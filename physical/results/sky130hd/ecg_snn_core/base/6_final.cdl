* CDL Netlist generated by OpenROAD

*.BUSDELIMITER [

.SUBCKT ecg_snn_core busy clk done inference_cycles[0] inference_cycles[10]
+ inference_cycles[11] inference_cycles[12] inference_cycles[13]
+ inference_cycles[14] inference_cycles[15] inference_cycles[1]
+ inference_cycles[2] inference_cycles[3] inference_cycles[4]
+ inference_cycles[5] inference_cycles[6] inference_cycles[7]
+ inference_cycles[8] inference_cycles[9] input_complete load_data[0]
+ load_data[1] load_data[2] load_data[3] load_ready load_valid
+ no_spike reset result_class[0] result_class[1] start VDD VSS
X_09401_ network.neuron_hid0.IF0.ref_counter\[0\] VSS VSS
+ VDD VDD _00910_ sky130_fd_sc_hd__inv_1
X_09402_ network.neuron_hid1.IF0.ref_counter\[0\] VSS VSS
+ VDD VDD _00710_ sky130_fd_sc_hd__inv_1
X_09403_ network.neuron_hid2.IF0.ref_counter\[0\] VSS VSS
+ VDD VDD _01018_ sky130_fd_sc_hd__inv_1
X_09404_ network.neuron_hid3.IF0.ref_counter\[0\] VSS VSS
+ VDD VDD _01027_ sky130_fd_sc_hd__inv_1
X_09405_ network.neuron_hid4.IF0.ref_counter\[0\] VSS VSS
+ VDD VDD _00706_ sky130_fd_sc_hd__inv_1
X_09406_ network.neuron_hid5.IF0.ref_counter\[0\] VSS VSS
+ VDD VDD _01143_ sky130_fd_sc_hd__inv_1
X_09407_ network.neuron_hid6.IF0.ref_counter\[0\] VSS VSS
+ VDD VDD _01155_ sky130_fd_sc_hd__inv_1
X_09408_ network.neuron_hid7.IF0.ref_counter\[0\] VSS VSS
+ VDD VDD _00730_ sky130_fd_sc_hd__inv_1
X_09409_ network.arbit.counter\[0\] VSS VSS VDD VDD _00117_
+ sky130_fd_sc_hd__inv_1
X_09410_ state\[0\] net430 state\[2\] VSS VSS VDD VDD _06355_
+ sky130_fd_sc_hd__nor3_1
Xclkbuf_leaf_223_clk clknet_5_19__leaf_clk VSS VSS VDD VDD
+ clknet_leaf_223_clk sky130_fd_sc_hd__clkbuf_16
Xclkbuf_leaf_222_clk clknet_5_17__leaf_clk VSS VSS VDD VDD
+ clknet_leaf_222_clk sky130_fd_sc_hd__clkbuf_16
Xclkbuf_leaf_221_clk clknet_5_16__leaf_clk VSS VSS VDD VDD
+ clknet_leaf_221_clk sky130_fd_sc_hd__clkbuf_16
Xclkbuf_leaf_220_clk clknet_5_16__leaf_clk VSS VSS VDD VDD
+ clknet_leaf_220_clk sky130_fd_sc_hd__clkbuf_16
X_09415_ network.neuron_in156.counter\[2\] _01065_ VSS VSS
+ VDD VDD _06360_ sky130_fd_sc_hd__xnor2_1
X_09416_ state\[0\] net430 state\[2\] VSS VSS VDD VDD _06361_
+ sky130_fd_sc_hd__or3_2
Xclkbuf_leaf_219_clk clknet_5_18__leaf_clk VSS VSS VDD VDD
+ clknet_leaf_219_clk sky130_fd_sc_hd__clkbuf_16
Xclkbuf_leaf_218_clk clknet_5_16__leaf_clk VSS VSS VDD VDD
+ clknet_leaf_218_clk sky130_fd_sc_hd__clkbuf_16
Xclkbuf_leaf_217_clk clknet_5_16__leaf_clk VSS VSS VDD VDD
+ clknet_leaf_217_clk sky130_fd_sc_hd__clkbuf_16
X_09420_ network.neuron_in156.counter\[2\] network.neuron_in156.counter\[3\]
+ VSS VSS VDD VDD _06365_ sky130_fd_sc_hd__nor2_1
X_09421_ net375 _06365_ VSS VSS VDD VDD _06366_ sky130_fd_sc_hd__nor2_1
X_09422_ network.in_period\[156\]\[2\] _06366_ VSS VSS VDD
+ VDD _06367_ sky130_fd_sc_hd__nor2_1
X_09423_ net394 _06360_ _06367_ VSS VSS VDD VDD _02690_ sky130_fd_sc_hd__a21oi_1
X_09424_ network.neuron_in157.counter\[2\] _00688_ VSS VSS
+ VDD VDD _06368_ sky130_fd_sc_hd__xnor2_1
Xclkbuf_leaf_216_clk clknet_5_16__leaf_clk VSS VSS VDD VDD
+ clknet_leaf_216_clk sky130_fd_sc_hd__clkbuf_16
Xclkbuf_leaf_215_clk clknet_5_16__leaf_clk VSS VSS VDD VDD
+ clknet_leaf_215_clk sky130_fd_sc_hd__clkbuf_16
X_09427_ network.neuron_in157.counter\[2\] network.neuron_in157.counter\[3\]
+ VSS VSS VDD VDD _06371_ sky130_fd_sc_hd__nor2_1
X_09428_ _00688_ _06371_ VSS VSS VDD VDD _06372_ sky130_fd_sc_hd__nand2_1
X_09429_ net401 _06372_ network.in_period\[157\]\[2\] VSS
+ VSS VDD VDD _06373_ sky130_fd_sc_hd__a21oi_1
X_09430_ net401 _06368_ _06373_ VSS VSS VDD VDD _02694_ sky130_fd_sc_hd__a21oi_1
X_09431_ network.neuron_in158.counter\[0\] VSS VSS VDD VDD
+ _00643_ sky130_fd_sc_hd__inv_1
Xclkbuf_leaf_214_clk clknet_5_16__leaf_clk VSS VSS VDD VDD
+ clknet_leaf_214_clk sky130_fd_sc_hd__clkbuf_16
Xclkbuf_leaf_213_clk clknet_5_16__leaf_clk VSS VSS VDD VDD
+ clknet_leaf_213_clk sky130_fd_sc_hd__clkbuf_16
X_09434_ network.neuron_in158.counter\[3\] _00645_ VSS VSS
+ VDD VDD _06376_ sky130_fd_sc_hd__nand2b_1
X_09435_ network.neuron_in158.counter\[2\] VSS VSS VDD VDD
+ _06377_ sky130_fd_sc_hd__inv_1
X_09436_ _06376_ _06377_ VSS VSS VDD VDD _06378_ sky130_fd_sc_hd__nand2b_1
X_09437_ net394 _06378_ VSS VSS VDD VDD _06379_ sky130_fd_sc_hd__nand2_1
X_09438_ network.in_period\[158\]\[0\] _06379_ VSS VSS VDD
+ VDD _06380_ sky130_fd_sc_hd__nand2_1
X_09439_ network.neuron_in158.counter\[0\] _06379_ _06380_
+ VSS VSS VDD VDD _02696_ sky130_fd_sc_hd__o21ai_0
X_09440_ network.neuron_in081.counter\[0\] VSS VSS VDD VDD
+ _00072_ sky130_fd_sc_hd__inv_1
X_09441_ network.neuron_in078.counter\[1\] VSS VSS VDD VDD
+ _00097_ sky130_fd_sc_hd__inv_1
X_09442_ network.neuron_in159.counter\[0\] VSS VSS VDD VDD
+ _00631_ sky130_fd_sc_hd__inv_1
Xclkbuf_leaf_212_clk clknet_5_16__leaf_clk VSS VSS VDD VDD
+ clknet_leaf_212_clk sky130_fd_sc_hd__clkbuf_16
X_09444_ network.neuron_in159.counter\[2\] network.neuron_in159.counter\[3\]
+ VSS VSS VDD VDD _06382_ sky130_fd_sc_hd__nor2_1
X_09445_ _00633_ _06382_ VSS VSS VDD VDD _06383_ sky130_fd_sc_hd__nand2_1
X_09446_ net401 _06383_ VSS VSS VDD VDD _06384_ sky130_fd_sc_hd__nand2_1
X_09447_ network.in_period\[159\]\[0\] _06384_ VSS VSS VDD
+ VDD _06385_ sky130_fd_sc_hd__nand2_1
X_09448_ network.neuron_in159.counter\[0\] _06384_ _06385_
+ VSS VSS VDD VDD _02700_ sky130_fd_sc_hd__o21ai_0
X_09449_ network.neuron_in077.counter\[1\] VSS VSS VDD VDD
+ _00102_ sky130_fd_sc_hd__inv_1
X_09450_ network.neuron_in161.counter\[2\] VSS VSS VDD VDD
+ _06386_ sky130_fd_sc_hd__inv_1
Xclkbuf_leaf_211_clk clknet_5_17__leaf_clk VSS VSS VDD VDD
+ clknet_leaf_211_clk sky130_fd_sc_hd__clkbuf_16
Xclkbuf_leaf_210_clk clknet_5_17__leaf_clk VSS VSS VDD VDD
+ clknet_leaf_210_clk sky130_fd_sc_hd__clkbuf_16
X_09453_ network.neuron_in161.counter\[3\] network.in_period\[161\]\[2\]
+ _00764_ net369 VSS VSS VDD VDD _06389_ sky130_fd_sc_hd__o22ai_1
Xclkbuf_leaf_209_clk clknet_5_17__leaf_clk VSS VSS VDD VDD
+ clknet_leaf_209_clk sky130_fd_sc_hd__clkbuf_16
Xclkbuf_leaf_208_clk clknet_5_17__leaf_clk VSS VSS VDD VDD
+ clknet_leaf_208_clk sky130_fd_sc_hd__clkbuf_16
Xclkbuf_leaf_207_clk clknet_5_17__leaf_clk VSS VSS VDD VDD
+ clknet_leaf_207_clk sky130_fd_sc_hd__clkbuf_16
X_09457_ network.neuron_in161.counter\[2\] _00764_ net404
+ VSS VSS VDD VDD _06393_ sky130_fd_sc_hd__nand3_1
X_09458_ network.in_period\[161\]\[2\] net404 _06393_ VSS
+ VSS VDD VDD _06394_ sky130_fd_sc_hd__o21ai_0
X_09459_ _06386_ _06389_ _06394_ VSS VSS VDD VDD _02710_ sky130_fd_sc_hd__a21oi_1
X_09460_ network.neuron_in121.counter\[0\] VSS VSS VDD VDD
+ _00123_ sky130_fd_sc_hd__inv_1
X_09461_ network.neuron_in177.counter\[2\] _00812_ VSS VSS
+ VDD VDD _06395_ sky130_fd_sc_hd__xnor2_1
X_09462_ network.neuron_in177.counter\[2\] network.neuron_in177.counter\[3\]
+ VSS VSS VDD VDD _06396_ sky130_fd_sc_hd__nor2_1
X_09463_ _06361_ _06396_ VSS VSS VDD VDD _06397_ sky130_fd_sc_hd__nor2_1
X_09464_ network.in_period\[177\]\[2\] _06397_ VSS VSS VDD
+ VDD _06398_ sky130_fd_sc_hd__nor2_1
X_09465_ net394 _06395_ _06398_ VSS VSS VDD VDD _02774_ sky130_fd_sc_hd__a21oi_1
X_09466_ network.neuron_in060.counter\[0\] VSS VSS VDD VDD
+ _00194_ sky130_fd_sc_hd__inv_1
X_09467_ network.neuron_in063.counter\[1\] VSS VSS VDD VDD
+ _00191_ sky130_fd_sc_hd__inv_1
X_09468_ network.neuron_in152.counter\[0\] VSS VSS VDD VDD
+ _00476_ sky130_fd_sc_hd__inv_1
X_09469_ network.neuron_in152.counter\[2\] _00478_ VSS VSS
+ VDD VDD _06399_ sky130_fd_sc_hd__nor2b_1
X_09470_ network.neuron_in152.counter\[3\] _06399_ VSS VSS
+ VDD VDD _06400_ sky130_fd_sc_hd__nand2b_1
X_09471_ net400 _06400_ VSS VSS VDD VDD _06401_ sky130_fd_sc_hd__nand2_1
X_09472_ network.in_period\[152\]\[0\] _06401_ VSS VSS VDD
+ VDD _06402_ sky130_fd_sc_hd__nand2_1
X_09473_ network.neuron_in152.counter\[0\] _06401_ _06402_
+ VSS VSS VDD VDD _02672_ sky130_fd_sc_hd__o21ai_0
X_09474_ network.neuron_in153.counter\[2\] network.neuron_in153.counter\[3\]
+ _00474_ VSS VSS VDD VDD _06403_ sky130_fd_sc_hd__or3b_2
X_09475_ net401 _06403_ VSS VSS VDD VDD _06404_ sky130_fd_sc_hd__nand2_1
X_09476_ network.in_period\[153\]\[1\] _06404_ VSS VSS VDD
+ VDD _06405_ sky130_fd_sc_hd__nand2_1
X_09477_ _00475_ _06404_ _06405_ VSS VSS VDD VDD _02677_ sky130_fd_sc_hd__o21ai_0
X_09478_ network.neuron_in154.counter\[2\] _00353_ VSS VSS
+ VDD VDD _06406_ sky130_fd_sc_hd__xnor2_1
X_09479_ network.neuron_in154.counter\[2\] network.neuron_in154.counter\[3\]
+ VSS VSS VDD VDD _06407_ sky130_fd_sc_hd__nor2_1
X_09480_ _00353_ _06407_ VSS VSS VDD VDD _06408_ sky130_fd_sc_hd__nand2_1
X_09481_ net394 _06408_ network.in_period\[154\]\[2\] VSS
+ VSS VDD VDD _06409_ sky130_fd_sc_hd__a21oi_1
X_09482_ net394 _06406_ _06409_ VSS VSS VDD VDD _02682_ sky130_fd_sc_hd__a21oi_1
X_09483_ network.neuron_in033.counter\[1\] VSS VSS VDD VDD
+ _01124_ sky130_fd_sc_hd__inv_1
X_09484_ net394 _06408_ VSS VSS VDD VDD _06410_ sky130_fd_sc_hd__nand2_1
X_09485_ network.in_period\[154\]\[1\] _06410_ VSS VSS VDD
+ VDD _06411_ sky130_fd_sc_hd__nand2_1
X_09486_ _00354_ _06410_ _06411_ VSS VSS VDD VDD _02681_ sky130_fd_sc_hd__o21ai_0
X_09487_ network.neuron_in155.counter\[2\] network.neuron_in155.counter\[3\]
+ VSS VSS VDD VDD _06412_ sky130_fd_sc_hd__nor2_1
X_09488_ _01205_ _06412_ VSS VSS VDD VDD _06413_ sky130_fd_sc_hd__nand2_1
X_09489_ net394 _06413_ VSS VSS VDD VDD _06414_ sky130_fd_sc_hd__nand2_1
X_09490_ network.in_period\[155\]\[1\] _06414_ VSS VSS VDD
+ VDD _06415_ sky130_fd_sc_hd__nand2_1
X_09491_ _01206_ _06414_ _06415_ VSS VSS VDD VDD _02685_ sky130_fd_sc_hd__o21ai_0
X_09492_ network.neuron_in140.counter\[1\] VSS VSS VDD VDD
+ _01088_ sky130_fd_sc_hd__inv_1
X_09493_ network.neuron_in155.counter\[0\] VSS VSS VDD VDD
+ _01203_ sky130_fd_sc_hd__inv_1
X_09494_ network.in_period\[155\]\[0\] _06414_ VSS VSS VDD
+ VDD _06416_ sky130_fd_sc_hd__nand2_1
X_09495_ network.neuron_in155.counter\[0\] _06414_ _06416_
+ VSS VSS VDD VDD _02684_ sky130_fd_sc_hd__o21ai_0
X_09496_ network.neuron_in156.counter\[3\] _01065_ VSS VSS
+ VDD VDD _06417_ sky130_fd_sc_hd__nand2b_1
X_09497_ network.neuron_in156.counter\[2\] _06417_ VSS VSS
+ VDD VDD _06418_ sky130_fd_sc_hd__or2_2
X_09498_ net394 _06418_ VSS VSS VDD VDD _06419_ sky130_fd_sc_hd__nand2_1
X_09499_ network.in_period\[156\]\[1\] _06419_ VSS VSS VDD
+ VDD _06420_ sky130_fd_sc_hd__nand2_1
X_09500_ _01066_ _06419_ _06420_ VSS VSS VDD VDD _02689_ sky130_fd_sc_hd__o21ai_0
X_09501_ network.neuron_in076.counter\[1\] VSS VSS VDD VDD
+ _00106_ sky130_fd_sc_hd__inv_1
X_09502_ network.neuron_in156.counter\[0\] VSS VSS VDD VDD
+ _01063_ sky130_fd_sc_hd__inv_1
X_09503_ network.in_period\[156\]\[0\] _06419_ VSS VSS VDD
+ VDD _06421_ sky130_fd_sc_hd__nand2_1
X_09504_ network.neuron_in156.counter\[0\] _06419_ _06421_
+ VSS VSS VDD VDD _02688_ sky130_fd_sc_hd__o21ai_0
X_09505_ network.neuron_in158.counter\[3\] network.in_period\[158\]\[2\]
+ _00645_ net375 VSS VSS VDD VDD _06422_ sky130_fd_sc_hd__o22ai_1
X_09506_ network.neuron_in158.counter\[2\] _00645_ net394
+ VSS VSS VDD VDD _06423_ sky130_fd_sc_hd__nand3_1
X_09507_ network.in_period\[158\]\[2\] net394 _06423_ VSS
+ VSS VDD VDD _06424_ sky130_fd_sc_hd__o21ai_0
X_09508_ _06377_ _06422_ _06424_ VSS VSS VDD VDD _02698_ sky130_fd_sc_hd__a21oi_1
X_09509_ network.in_period\[158\]\[1\] _06379_ VSS VSS VDD
+ VDD _06425_ sky130_fd_sc_hd__nand2_1
X_09510_ _00646_ _06379_ _06425_ VSS VSS VDD VDD _02697_ sky130_fd_sc_hd__o21ai_0
X_09511_ network.neuron_in159.counter\[2\] _00633_ VSS VSS
+ VDD VDD _06426_ sky130_fd_sc_hd__xnor2_1
X_09512_ net401 _06383_ network.in_period\[159\]\[2\] VSS
+ VSS VDD VDD _06427_ sky130_fd_sc_hd__a21oi_1
X_09513_ net401 _06426_ _06427_ VSS VSS VDD VDD _02702_ sky130_fd_sc_hd__a21oi_1
X_09514_ network.in_period\[159\]\[1\] _06384_ VSS VSS VDD
+ VDD _06428_ sky130_fd_sc_hd__nand2_1
X_09515_ _00634_ _06384_ _06428_ VSS VSS VDD VDD _02701_ sky130_fd_sc_hd__o21ai_0
X_09516_ _00515_ network.neuron_in132.counter\[2\] VSS VSS
+ VDD VDD _06429_ sky130_fd_sc_hd__xnor2_1
X_09517_ network.neuron_in132.counter\[3\] _00515_ VSS VSS
+ VDD VDD _06430_ sky130_fd_sc_hd__nand2b_1
X_09518_ net384 _06430_ network.in_period\[132\]\[2\] VSS
+ VSS VDD VDD _06431_ sky130_fd_sc_hd__a21oi_1
X_09519_ net384 _06429_ _06431_ VSS VSS VDD VDD _02594_ sky130_fd_sc_hd__a21oi_1
X_09520_ network.neuron_in160.counter\[2\] _01093_ VSS VSS
+ VDD VDD _06432_ sky130_fd_sc_hd__nor2b_1
X_09521_ network.neuron_in160.counter\[3\] _06432_ VSS VSS
+ VDD VDD _06433_ sky130_fd_sc_hd__nand2b_1
X_09522_ net404 _06433_ VSS VSS VDD VDD _06434_ sky130_fd_sc_hd__nand2_1
X_09523_ network.in_period\[160\]\[1\] _06434_ VSS VSS VDD
+ VDD _06435_ sky130_fd_sc_hd__nand2_1
X_09524_ _01094_ _06434_ _06435_ VSS VSS VDD VDD _02705_ sky130_fd_sc_hd__o21ai_0
X_09525_ network.neuron_in160.counter\[0\] VSS VSS VDD VDD
+ _01091_ sky130_fd_sc_hd__inv_1
X_09526_ network.in_period\[160\]\[0\] _06434_ VSS VSS VDD
+ VDD _06436_ sky130_fd_sc_hd__nand2_1
X_09527_ network.neuron_in160.counter\[0\] _06434_ _06436_
+ VSS VSS VDD VDD _02704_ sky130_fd_sc_hd__o21ai_0
X_09528_ network.neuron_in161.counter\[3\] _00764_ VSS VSS
+ VDD VDD _06437_ sky130_fd_sc_hd__nand2b_1
X_09529_ _06437_ _06386_ VSS VSS VDD VDD _06438_ sky130_fd_sc_hd__nand2b_1
X_09530_ net404 _06438_ VSS VSS VDD VDD _06439_ sky130_fd_sc_hd__nand2_1
X_09531_ network.in_period\[161\]\[1\] _06439_ VSS VSS VDD
+ VDD _06440_ sky130_fd_sc_hd__nand2_1
X_09532_ _00765_ _06439_ _06440_ VSS VSS VDD VDD _02709_ sky130_fd_sc_hd__o21ai_0
X_09533_ network.neuron_in054.counter\[1\] VSS VSS VDD VDD
+ _00247_ sky130_fd_sc_hd__inv_1
X_09534_ network.neuron_in133.counter\[1\] VSS VSS VDD VDD
+ _00564_ sky130_fd_sc_hd__inv_1
Xclkbuf_leaf_206_clk clknet_5_17__leaf_clk VSS VSS VDD VDD
+ clknet_leaf_206_clk sky130_fd_sc_hd__clkbuf_16
X_09536_ network.neuron_in188.counter\[2\] _00238_ VSS VSS
+ VDD VDD _06442_ sky130_fd_sc_hd__xnor2_1
X_09537_ network.neuron_in188.counter\[2\] network.neuron_in188.counter\[3\]
+ VSS VSS VDD VDD _06443_ sky130_fd_sc_hd__nor2_1
X_09538_ net367 _06443_ VSS VSS VDD VDD _06444_ sky130_fd_sc_hd__nor2_1
X_09539_ network.in_period\[188\]\[2\] _06444_ VSS VSS VDD
+ VDD _06445_ sky130_fd_sc_hd__nor2_1
X_09540_ net382 _06442_ _06445_ VSS VSS VDD VDD _02818_ sky130_fd_sc_hd__a21oi_1
X_09541_ network.neuron_in063.counter\[0\] VSS VSS VDD VDD
+ _00190_ sky130_fd_sc_hd__inv_1
X_09542_ network.neuron_in075.counter\[1\] VSS VSS VDD VDD
+ _00114_ sky130_fd_sc_hd__inv_1
X_09543_ network.neuron_in111.counter\[1\] VSS VSS VDD VDD
+ _00568_ sky130_fd_sc_hd__inv_1
X_09544_ network.neuron_in078.counter\[0\] VSS VSS VDD VDD
+ _00096_ sky130_fd_sc_hd__inv_1
X_09545_ network.neuron_in074.counter\[1\] VSS VSS VDD VDD
+ _00110_ sky130_fd_sc_hd__inv_1
X_09546_ network.neuron_in162.counter\[1\] VSS VSS VDD VDD
+ _00775_ sky130_fd_sc_hd__inv_1
X_09547_ network.neuron_in111.counter\[0\] VSS VSS VDD VDD
+ _00567_ sky130_fd_sc_hd__inv_1
X_09548_ network.neuron_in140.counter\[0\] VSS VSS VDD VDD
+ _01087_ sky130_fd_sc_hd__inv_1
X_09549_ network.neuron_in183.counter\[2\] _00984_ VSS VSS
+ VDD VDD _06446_ sky130_fd_sc_hd__xnor2_1
Xclkbuf_leaf_205_clk clknet_5_17__leaf_clk VSS VSS VDD VDD
+ clknet_leaf_205_clk sky130_fd_sc_hd__clkbuf_16
Xclkbuf_leaf_204_clk clknet_5_17__leaf_clk VSS VSS VDD VDD
+ clknet_leaf_204_clk sky130_fd_sc_hd__clkbuf_16
X_09552_ network.neuron_in183.counter\[2\] network.neuron_in183.counter\[3\]
+ VSS VSS VDD VDD _06449_ sky130_fd_sc_hd__nor2_1
X_09553_ _00984_ _06449_ VSS VSS VDD VDD _06450_ sky130_fd_sc_hd__nand2_1
X_09554_ net382 _06450_ network.in_period\[183\]\[2\] VSS
+ VSS VDD VDD _06451_ sky130_fd_sc_hd__a21oi_1
X_09555_ net382 _06446_ _06451_ VSS VSS VDD VDD _02798_ sky130_fd_sc_hd__a21oi_1
X_09556_ network.neuron_in187.counter\[0\] VSS VSS VDD VDD
+ _00208_ sky130_fd_sc_hd__inv_1
Xclkbuf_leaf_203_clk clknet_5_20__leaf_clk VSS VSS VDD VDD
+ clknet_leaf_203_clk sky130_fd_sc_hd__clkbuf_16
X_09558_ network.neuron_in187.counter\[3\] _00210_ VSS VSS
+ VDD VDD _06453_ sky130_fd_sc_hd__nand2b_1
X_09559_ network.neuron_in187.counter\[2\] _06453_ VSS VSS
+ VDD VDD _06454_ sky130_fd_sc_hd__or2_2
X_09560_ net382 _06454_ VSS VSS VDD VDD _06455_ sky130_fd_sc_hd__nand2_1
X_09561_ network.in_period\[187\]\[0\] _06455_ VSS VSS VDD
+ VDD _06456_ sky130_fd_sc_hd__nand2_1
X_09562_ network.neuron_in187.counter\[0\] _06455_ _06456_
+ VSS VSS VDD VDD _02812_ sky130_fd_sc_hd__o21ai_0
X_09563_ network.neuron_in180.counter\[3\] _00625_ VSS VSS
+ VDD VDD _06457_ sky130_fd_sc_hd__nand2b_1
X_09564_ network.neuron_in180.counter\[2\] _06457_ VSS VSS
+ VDD VDD _06458_ sky130_fd_sc_hd__or2_2
X_09565_ net382 _06458_ VSS VSS VDD VDD _06459_ sky130_fd_sc_hd__nand2_1
X_09566_ network.in_period\[180\]\[1\] _06459_ VSS VSS VDD
+ VDD _06460_ sky130_fd_sc_hd__nand2_1
X_09567_ _00626_ _06459_ _06460_ VSS VSS VDD VDD _02785_ sky130_fd_sc_hd__o21ai_0
X_09568_ network.neuron_hid7.IF0.ref_counter\[1\] VSS VSS
+ VDD VDD _00731_ sky130_fd_sc_hd__inv_1
X_09569_ network.neuron_in040.counter\[1\] VSS VSS VDD VDD
+ _00316_ sky130_fd_sc_hd__inv_1
X_09570_ network.neuron_in250.counter\[1\] VSS VSS VDD VDD
+ _01084_ sky130_fd_sc_hd__inv_1
X_09571_ network.neuron_in071.counter\[1\] VSS VSS VDD VDD
+ _00134_ sky130_fd_sc_hd__inv_1
X_09572_ network.neuron_hid1.IF0.ref_counter\[1\] VSS VSS
+ VDD VDD _00711_ sky130_fd_sc_hd__inv_1
X_09573_ network.neuron_in064.counter\[1\] VSS VSS VDD VDD
+ _00187_ sky130_fd_sc_hd__inv_1
X_09574_ network.neuron_in182.counter\[0\] VSS VSS VDD VDD
+ _00718_ sky130_fd_sc_hd__inv_1
X_09575_ network.neuron_in182.counter\[2\] network.neuron_in182.counter\[3\]
+ VSS VSS VDD VDD _06461_ sky130_fd_sc_hd__nor2_1
X_09576_ _00720_ _06461_ VSS VSS VDD VDD _06462_ sky130_fd_sc_hd__nand2_1
X_09577_ net382 _06462_ VSS VSS VDD VDD _06463_ sky130_fd_sc_hd__nand2_1
X_09578_ network.in_period\[182\]\[0\] _06463_ VSS VSS VDD
+ VDD _06464_ sky130_fd_sc_hd__nand2_1
X_09579_ network.neuron_in182.counter\[0\] _06463_ _06464_
+ VSS VSS VDD VDD _02792_ sky130_fd_sc_hd__o21ai_0
X_09580_ network.neuron_in081.counter\[1\] VSS VSS VDD VDD
+ _00073_ sky130_fd_sc_hd__inv_1
X_09581_ network.neuron_in070.counter\[1\] VSS VSS VDD VDD
+ _00138_ sky130_fd_sc_hd__inv_1
Xclkbuf_leaf_202_clk clknet_5_20__leaf_clk VSS VSS VDD VDD
+ clknet_leaf_202_clk sky130_fd_sc_hd__clkbuf_16
Xclkbuf_leaf_201_clk clknet_5_20__leaf_clk VSS VSS VDD VDD
+ clknet_leaf_201_clk sky130_fd_sc_hd__clkbuf_16
X_09584_ network.neuron_in131.counter\[2\] _00486_ VSS VSS
+ VDD VDD _06467_ sky130_fd_sc_hd__nor2b_1
X_09585_ _00486_ network.neuron_in131.counter\[2\] VSS VSS
+ VDD VDD _06468_ sky130_fd_sc_hd__nor2b_1
Xclkbuf_leaf_200_clk clknet_5_20__leaf_clk VSS VSS VDD VDD
+ clknet_leaf_200_clk sky130_fd_sc_hd__clkbuf_16
X_09587_ network.neuron_in131.counter\[2\] network.neuron_in131.counter\[3\]
+ VSS VSS VDD VDD _06470_ sky130_fd_sc_hd__nor2_1
X_09588_ _06361_ _06470_ VSS VSS VDD VDD _06471_ sky130_fd_sc_hd__nor2_1
X_09589_ _06361_ _06467_ _06468_ _06471_ network.in_period\[131\]\[2\]
+ VSS VSS VDD VDD _02590_ sky130_fd_sc_hd__o32a_1
Xclkbuf_leaf_199_clk clknet_5_20__leaf_clk VSS VSS VDD VDD
+ clknet_leaf_199_clk sky130_fd_sc_hd__clkbuf_16
X_09591_ network.neuron_in185.counter\[2\] network.neuron_in185.counter\[3\]
+ VSS VSS VDD VDD _06473_ sky130_fd_sc_hd__nor2_1
X_09592_ _00230_ _06473_ VSS VSS VDD VDD _06474_ sky130_fd_sc_hd__nand2_1
X_09593_ net382 _06474_ VSS VSS VDD VDD _06475_ sky130_fd_sc_hd__nand2_1
X_09594_ network.in_period\[185\]\[1\] _06475_ VSS VSS VDD
+ VDD _06476_ sky130_fd_sc_hd__nand2_1
X_09595_ _00231_ _06475_ _06476_ VSS VSS VDD VDD _02805_ sky130_fd_sc_hd__o21ai_0
X_09596_ network.neuron_in193.counter\[0\] VSS VSS VDD VDD
+ _00743_ sky130_fd_sc_hd__inv_1
X_09597_ network.neuron_in090.counter\[0\] VSS VSS VDD VDD
+ _00571_ sky130_fd_sc_hd__inv_1
X_09598_ network.neuron_in123.counter\[1\] VSS VSS VDD VDD
+ _00217_ sky130_fd_sc_hd__inv_1
X_09599_ network.neuron_in250.counter\[0\] VSS VSS VDD VDD
+ _01083_ sky130_fd_sc_hd__inv_1
X_09600_ network.neuron_in069.counter\[1\] VSS VSS VDD VDD
+ _00144_ sky130_fd_sc_hd__inv_1
X_09601_ network.in_period\[187\]\[1\] _06455_ VSS VSS VDD
+ VDD _06477_ sky130_fd_sc_hd__nand2_1
X_09602_ _00211_ _06455_ _06477_ VSS VSS VDD VDD _02813_ sky130_fd_sc_hd__o21ai_0
X_09603_ network.neuron_in179.counter\[2\] VSS VSS VDD VDD
+ _06478_ sky130_fd_sc_hd__inv_1
Xclkbuf_leaf_198_clk clknet_5_20__leaf_clk VSS VSS VDD VDD
+ clknet_leaf_198_clk sky130_fd_sc_hd__clkbuf_16
X_09605_ network.neuron_in179.counter\[3\] network.in_period\[179\]\[2\]
+ _00816_ _06361_ VSS VSS VDD VDD _06480_ sky130_fd_sc_hd__o22ai_1
X_09606_ network.neuron_in179.counter\[2\] _00816_ net394
+ VSS VSS VDD VDD _06481_ sky130_fd_sc_hd__nand3_1
X_09607_ network.in_period\[179\]\[2\] net394 _06481_ VSS
+ VSS VDD VDD _06482_ sky130_fd_sc_hd__o21ai_0
X_09608_ _06478_ _06480_ _06482_ VSS VSS VDD VDD _02782_ sky130_fd_sc_hd__a21oi_1
X_09609_ network.neuron_in180.counter\[2\] _00625_ VSS VSS
+ VDD VDD _06483_ sky130_fd_sc_hd__xnor2_1
X_09610_ network.neuron_in180.counter\[2\] network.neuron_in180.counter\[3\]
+ VSS VSS VDD VDD _06484_ sky130_fd_sc_hd__nor2_1
X_09611_ net367 _06484_ VSS VSS VDD VDD _06485_ sky130_fd_sc_hd__nor2_1
X_09612_ network.in_period\[180\]\[2\] _06485_ VSS VSS VDD
+ VDD _06486_ sky130_fd_sc_hd__nor2_1
X_09613_ net382 _06483_ _06486_ VSS VSS VDD VDD _02786_ sky130_fd_sc_hd__a21oi_1
X_09614_ network.neuron_in178.counter\[2\] _00992_ VSS VSS
+ VDD VDD _06487_ sky130_fd_sc_hd__xnor2_1
X_09615_ network.neuron_in178.counter\[2\] network.neuron_in178.counter\[3\]
+ VSS VSS VDD VDD _06488_ sky130_fd_sc_hd__nor2_1
X_09616_ _00992_ _06488_ VSS VSS VDD VDD _06489_ sky130_fd_sc_hd__nand2_1
X_09617_ net394 _06489_ network.in_period\[178\]\[2\] VSS
+ VSS VDD VDD _06490_ sky130_fd_sc_hd__a21oi_1
X_09618_ net394 _06487_ _06490_ VSS VSS VDD VDD _02778_ sky130_fd_sc_hd__a21oi_1
X_09619_ network.neuron_in181.counter\[2\] network.neuron_in181.counter\[3\]
+ VSS VSS VDD VDD _06491_ sky130_fd_sc_hd__nor2_1
X_09620_ _00629_ _06491_ VSS VSS VDD VDD _06492_ sky130_fd_sc_hd__nand2_1
X_09621_ net382 _06492_ VSS VSS VDD VDD _06493_ sky130_fd_sc_hd__nand2_1
X_09622_ network.in_period\[181\]\[1\] _06493_ VSS VSS VDD
+ VDD _06494_ sky130_fd_sc_hd__nand2_1
X_09623_ _00630_ _06493_ _06494_ VSS VSS VDD VDD _02789_ sky130_fd_sc_hd__o21ai_0
X_09624_ network.neuron_in100.counter\[1\] VSS VSS VDD VDD
+ _00703_ sky130_fd_sc_hd__inv_1
X_09625_ network.neuron_in068.counter\[1\] VSS VSS VDD VDD
+ _00150_ sky130_fd_sc_hd__inv_1
X_09626_ network.neuron_in056.counter\[0\] VSS VSS VDD VDD
+ _00224_ sky130_fd_sc_hd__inv_1
X_09627_ network.in_period\[182\]\[1\] _06463_ VSS VSS VDD
+ VDD _06495_ sky130_fd_sc_hd__nand2_1
X_09628_ _00721_ _06463_ _06495_ VSS VSS VDD VDD _02793_ sky130_fd_sc_hd__o21ai_0
X_09629_ network.neuron_in184.counter\[2\] _01113_ VSS VSS
+ VDD VDD _06496_ sky130_fd_sc_hd__xnor2_1
X_09630_ network.neuron_in184.counter\[2\] network.neuron_in184.counter\[3\]
+ VSS VSS VDD VDD _06497_ sky130_fd_sc_hd__nor2_1
X_09631_ net367 _06497_ VSS VSS VDD VDD _06498_ sky130_fd_sc_hd__nor2_1
X_09632_ network.in_period\[184\]\[2\] _06498_ VSS VSS VDD
+ VDD _06499_ sky130_fd_sc_hd__nor2_1
X_09633_ net382 _06496_ _06499_ VSS VSS VDD VDD _02802_ sky130_fd_sc_hd__a21oi_1
X_09634_ network.neuron_in185.counter\[2\] _00230_ VSS VSS
+ VDD VDD _06500_ sky130_fd_sc_hd__xnor2_1
X_09635_ net382 _06474_ network.in_period\[185\]\[2\] VSS
+ VSS VDD VDD _06501_ sky130_fd_sc_hd__a21oi_1
X_09636_ net382 _06500_ _06501_ VSS VSS VDD VDD _02806_ sky130_fd_sc_hd__a21oi_1
X_09637_ network.neuron_in064.counter\[0\] VSS VSS VDD VDD
+ _00186_ sky130_fd_sc_hd__inv_1
X_09638_ network.neuron_in186.counter\[2\] network.neuron_in186.counter\[3\]
+ VSS VSS VDD VDD _06502_ sky130_fd_sc_hd__nor2_1
X_09639_ _00832_ _06502_ VSS VSS VDD VDD _06503_ sky130_fd_sc_hd__nand2_1
X_09640_ net382 _06503_ VSS VSS VDD VDD _06504_ sky130_fd_sc_hd__nand2_1
X_09641_ network.in_period\[186\]\[1\] _06504_ VSS VSS VDD
+ VDD _06505_ sky130_fd_sc_hd__nand2_1
X_09642_ _00833_ _06504_ _06505_ VSS VSS VDD VDD _02809_ sky130_fd_sc_hd__o21ai_0
X_09643_ network.neuron_in202.counter\[1\] VSS VSS VDD VDD
+ _01080_ sky130_fd_sc_hd__inv_1
X_09644_ network.neuron_in187.counter\[2\] _00210_ VSS VSS
+ VDD VDD _06506_ sky130_fd_sc_hd__xnor2_1
X_09645_ network.neuron_in187.counter\[2\] network.neuron_in187.counter\[3\]
+ VSS VSS VDD VDD _06507_ sky130_fd_sc_hd__nor2_1
X_09646_ net367 _06507_ VSS VSS VDD VDD _06508_ sky130_fd_sc_hd__nor2_1
X_09647_ network.in_period\[187\]\[2\] _06508_ VSS VSS VDD
+ VDD _06509_ sky130_fd_sc_hd__nor2_1
X_09648_ net382 _06506_ _06509_ VSS VSS VDD VDD _02814_ sky130_fd_sc_hd__a21oi_1
X_09649_ network.neuron_in062.counter\[0\] VSS VSS VDD VDD
+ _00559_ sky130_fd_sc_hd__inv_1
X_09650_ net394 _06489_ VSS VSS VDD VDD _06510_ sky130_fd_sc_hd__nand2_1
X_09651_ network.in_period\[178\]\[1\] _06510_ VSS VSS VDD
+ VDD _06511_ sky130_fd_sc_hd__nand2_1
X_09652_ _00993_ _06510_ _06511_ VSS VSS VDD VDD _02777_ sky130_fd_sc_hd__o21ai_0
X_09653_ network.neuron_in178.counter\[0\] VSS VSS VDD VDD
+ _00990_ sky130_fd_sc_hd__inv_1
X_09654_ network.in_period\[178\]\[0\] _06510_ VSS VSS VDD
+ VDD _06512_ sky130_fd_sc_hd__nand2_1
X_09655_ network.neuron_in178.counter\[0\] _06510_ _06512_
+ VSS VSS VDD VDD _02776_ sky130_fd_sc_hd__o21ai_0
X_09656_ network.neuron_in245.counter\[0\] VSS VSS VDD VDD
+ _01195_ sky130_fd_sc_hd__inv_1
X_09657_ network.neuron_in240.counter\[1\] VSS VSS VDD VDD
+ _01192_ sky130_fd_sc_hd__inv_1
X_09658_ network.neuron_in157.counter\[0\] VSS VSS VDD VDD
+ _00686_ sky130_fd_sc_hd__inv_1
X_09659_ net401 _06372_ VSS VSS VDD VDD _06513_ sky130_fd_sc_hd__nand2_1
X_09660_ network.in_period\[157\]\[0\] _06513_ VSS VSS VDD
+ VDD _06514_ sky130_fd_sc_hd__nand2_1
X_09661_ network.neuron_in157.counter\[0\] _06513_ _06514_
+ VSS VSS VDD VDD _02692_ sky130_fd_sc_hd__o21ai_0
X_09662_ network.neuron_in179.counter\[3\] _00816_ VSS VSS
+ VDD VDD _06515_ sky130_fd_sc_hd__nand2b_1
X_09663_ _06515_ _06478_ VSS VSS VDD VDD _06516_ sky130_fd_sc_hd__nand2b_1
X_09664_ net394 _06516_ VSS VSS VDD VDD _06517_ sky130_fd_sc_hd__nand2_1
X_09665_ network.in_period\[179\]\[1\] _06517_ VSS VSS VDD
+ VDD _06518_ sky130_fd_sc_hd__nand2_1
X_09666_ _00817_ _06517_ _06518_ VSS VSS VDD VDD _02781_ sky130_fd_sc_hd__o21ai_0
X_09667_ network.neuron_in092.counter\[1\] VSS VSS VDD VDD
+ _01233_ sky130_fd_sc_hd__inv_1
X_09668_ network.neuron_in179.counter\[0\] VSS VSS VDD VDD
+ _00814_ sky130_fd_sc_hd__inv_1
X_09669_ network.in_period\[179\]\[0\] _06517_ VSS VSS VDD
+ VDD _06519_ sky130_fd_sc_hd__nand2_1
X_09670_ network.neuron_in179.counter\[0\] _06517_ _06519_
+ VSS VSS VDD VDD _02780_ sky130_fd_sc_hd__o21ai_0
X_09671_ network.neuron_in067.counter\[1\] VSS VSS VDD VDD
+ _00156_ sky130_fd_sc_hd__inv_1
X_09672_ network.neuron_in090.counter\[1\] VSS VSS VDD VDD
+ _00572_ sky130_fd_sc_hd__inv_1
X_09673_ network.neuron_in105.counter\[1\] VSS VSS VDD VDD
+ _01076_ sky130_fd_sc_hd__inv_1
X_09674_ network.neuron_in143.counter\[2\] network.neuron_in143.counter\[3\]
+ VSS VSS VDD VDD _06520_ sky130_fd_sc_hd__nor2_1
X_09675_ _00890_ _06520_ VSS VSS VDD VDD _06521_ sky130_fd_sc_hd__nand2_1
X_09676_ net393 _06521_ VSS VSS VDD VDD _06522_ sky130_fd_sc_hd__nand2_1
X_09677_ network.in_period\[143\]\[1\] _06522_ VSS VSS VDD
+ VDD _06523_ sky130_fd_sc_hd__nand2_1
X_09678_ _00891_ _06522_ _06523_ VSS VSS VDD VDD _02637_ sky130_fd_sc_hd__o21ai_0
X_09679_ network.neuron_in144.counter\[1\] VSS VSS VDD VDD
+ _00735_ sky130_fd_sc_hd__inv_1
X_09680_ network.neuron_in180.counter\[0\] VSS VSS VDD VDD
+ _00623_ sky130_fd_sc_hd__inv_1
X_09681_ network.in_period\[180\]\[0\] _06459_ VSS VSS VDD
+ VDD _06524_ sky130_fd_sc_hd__nand2_1
X_09682_ network.neuron_in180.counter\[0\] _06459_ _06524_
+ VSS VSS VDD VDD _02784_ sky130_fd_sc_hd__o21ai_0
X_09683_ network.neuron_in005.counter\[1\] VSS VSS VDD VDD
+ _00691_ sky130_fd_sc_hd__inv_1
X_09684_ network.neuron_in181.counter\[2\] _00629_ VSS VSS
+ VDD VDD _06525_ sky130_fd_sc_hd__xnor2_1
X_09685_ net382 _06492_ network.in_period\[181\]\[2\] VSS
+ VSS VDD VDD _06526_ sky130_fd_sc_hd__a21oi_1
X_09686_ net382 _06525_ _06526_ VSS VSS VDD VDD _02790_ sky130_fd_sc_hd__a21oi_1
X_09687_ network.neuron_in175.counter\[1\] VSS VSS VDD VDD
+ _00183_ sky130_fd_sc_hd__inv_1
X_09688_ network.neuron_in241.counter\[0\] VSS VSS VDD VDD
+ _00517_ sky130_fd_sc_hd__inv_1
X_09689_ network.neuron_in040.counter\[0\] VSS VSS VDD VDD
+ _00315_ sky130_fd_sc_hd__inv_1
X_09690_ network.neuron_in235.counter\[1\] VSS VSS VDD VDD
+ _00588_ sky130_fd_sc_hd__inv_1
X_09691_ network.neuron_in181.counter\[0\] VSS VSS VDD VDD
+ _00627_ sky130_fd_sc_hd__inv_1
X_09692_ network.in_period\[181\]\[0\] _06493_ VSS VSS VDD
+ VDD _06527_ sky130_fd_sc_hd__nand2_1
X_09693_ network.neuron_in181.counter\[0\] _06493_ _06527_
+ VSS VSS VDD VDD _02788_ sky130_fd_sc_hd__o21ai_0
X_09694_ network.neuron_in161.counter\[0\] VSS VSS VDD VDD
+ _00762_ sky130_fd_sc_hd__inv_1
X_09695_ network.neuron_in182.counter\[2\] _00720_ VSS VSS
+ VDD VDD _06528_ sky130_fd_sc_hd__xnor2_1
X_09696_ net382 _06462_ network.in_period\[182\]\[2\] VSS
+ VSS VDD VDD _06529_ sky130_fd_sc_hd__a21oi_1
X_09697_ net382 _06528_ _06529_ VSS VSS VDD VDD _02794_ sky130_fd_sc_hd__a21oi_1
X_09698_ net382 _06450_ VSS VSS VDD VDD _06530_ sky130_fd_sc_hd__nand2_1
X_09699_ network.in_period\[183\]\[1\] _06530_ VSS VSS VDD
+ VDD _06531_ sky130_fd_sc_hd__nand2_1
X_09700_ _00985_ _06530_ _06531_ VSS VSS VDD VDD _02797_ sky130_fd_sc_hd__o21ai_0
X_09701_ network.neuron_in144.counter\[0\] VSS VSS VDD VDD
+ _00734_ sky130_fd_sc_hd__inv_1
X_09702_ network.neuron_in066.counter\[1\] VSS VSS VDD VDD
+ _00169_ sky130_fd_sc_hd__inv_1
X_09703_ network.neuron_in113.counter\[0\] VSS VSS VDD VDD
+ _00575_ sky130_fd_sc_hd__inv_1
X_09704_ network.neuron_in183.counter\[0\] VSS VSS VDD VDD
+ _00982_ sky130_fd_sc_hd__inv_1
X_09705_ network.in_period\[183\]\[0\] _06530_ VSS VSS VDD
+ VDD _06532_ sky130_fd_sc_hd__nand2_1
X_09706_ network.neuron_in183.counter\[0\] _06530_ _06532_
+ VSS VSS VDD VDD _02796_ sky130_fd_sc_hd__o21ai_0
X_09707_ network.neuron_in093.counter\[0\] VSS VSS VDD VDD
+ _01236_ sky130_fd_sc_hd__inv_1
X_09708_ network.neuron_in202.counter\[0\] VSS VSS VDD VDD
+ _01079_ sky130_fd_sc_hd__inv_1
X_09709_ network.neuron_in184.counter\[3\] _01113_ VSS VSS
+ VDD VDD _06533_ sky130_fd_sc_hd__nand2b_1
X_09710_ network.neuron_in184.counter\[2\] _06533_ VSS VSS
+ VDD VDD _06534_ sky130_fd_sc_hd__or2_2
X_09711_ net382 _06534_ VSS VSS VDD VDD _06535_ sky130_fd_sc_hd__nand2_1
X_09712_ network.in_period\[184\]\[1\] _06535_ VSS VSS VDD
+ VDD _06536_ sky130_fd_sc_hd__nand2_1
X_09713_ _01114_ _06535_ _06536_ VSS VSS VDD VDD _02801_ sky130_fd_sc_hd__o21ai_0
X_09714_ network.neuron_in065.counter\[1\] VSS VSS VDD VDD
+ _00173_ sky130_fd_sc_hd__inv_1
X_09715_ network.neuron_in184.counter\[0\] VSS VSS VDD VDD
+ _01111_ sky130_fd_sc_hd__inv_1
X_09716_ network.in_period\[184\]\[0\] _06535_ VSS VSS VDD
+ VDD _06537_ sky130_fd_sc_hd__nand2_1
X_09717_ network.neuron_in184.counter\[0\] _06535_ _06537_
+ VSS VSS VDD VDD _02800_ sky130_fd_sc_hd__o21ai_0
X_09718_ net375 _06520_ VSS VSS VDD VDD _06538_ sky130_fd_sc_hd__nor2_1
X_09719_ network.neuron_in143.counter\[2\] _00890_ VSS VSS
+ VDD VDD _06539_ sky130_fd_sc_hd__xnor2_1
Xclkbuf_leaf_197_clk clknet_5_20__leaf_clk VSS VSS VDD VDD
+ clknet_leaf_197_clk sky130_fd_sc_hd__clkbuf_16
Xclkbuf_leaf_196_clk clknet_5_20__leaf_clk VSS VSS VDD VDD
+ clknet_leaf_196_clk sky130_fd_sc_hd__clkbuf_16
X_09722_ network.in_period\[143\]\[2\] _06538_ _06539_ net392
+ VSS VSS VDD VDD _02638_ sky130_fd_sc_hd__a2bb2oi_1
X_09723_ network.neuron_in160.counter\[1\] VSS VSS VDD VDD
+ _01092_ sky130_fd_sc_hd__inv_1
X_09724_ network.neuron_in185.counter\[0\] VSS VSS VDD VDD
+ _00228_ sky130_fd_sc_hd__inv_1
X_09725_ network.in_period\[185\]\[0\] _06475_ VSS VSS VDD
+ VDD _06542_ sky130_fd_sc_hd__nand2_1
X_09726_ network.neuron_in185.counter\[0\] _06475_ _06542_
+ VSS VSS VDD VDD _02804_ sky130_fd_sc_hd__o21ai_0
X_09727_ network.neuron_in024.counter\[0\] VSS VSS VDD VDD
+ _00375_ sky130_fd_sc_hd__inv_1
X_09728_ network.neuron_in186.counter\[2\] _00832_ VSS VSS
+ VDD VDD _06543_ sky130_fd_sc_hd__xnor2_1
X_09729_ net382 _06503_ network.in_period\[186\]\[2\] VSS
+ VSS VDD VDD _06544_ sky130_fd_sc_hd__a21oi_1
X_09730_ net382 _06543_ _06544_ VSS VSS VDD VDD _02810_ sky130_fd_sc_hd__a21oi_1
X_09731_ network.neuron_in175.counter\[0\] VSS VSS VDD VDD
+ _00182_ sky130_fd_sc_hd__inv_1
X_09732_ network.neuron_in186.counter\[0\] VSS VSS VDD VDD
+ _00830_ sky130_fd_sc_hd__inv_1
X_09733_ network.in_period\[186\]\[0\] _06504_ VSS VSS VDD
+ VDD _06545_ sky130_fd_sc_hd__nand2_1
X_09734_ network.neuron_in186.counter\[0\] _06504_ _06545_
+ VSS VSS VDD VDD _02808_ sky130_fd_sc_hd__o21ai_0
X_09735_ network.neuron_in215.counter\[1\] VSS VSS VDD VDD
+ _00868_ sky130_fd_sc_hd__inv_1
X_09736_ network.neuron_in037.counter\[1\] VSS VSS VDD VDD
+ _00344_ sky130_fd_sc_hd__inv_1
X_09737_ network.neuron_in142.counter\[0\] VSS VSS VDD VDD
+ _00539_ sky130_fd_sc_hd__inv_1
X_09738_ network.neuron_in142.counter\[2\] network.neuron_in142.counter\[3\]
+ _00541_ VSS VSS VDD VDD _06546_ sky130_fd_sc_hd__or3b_2
X_09739_ net393 _06546_ VSS VSS VDD VDD _06547_ sky130_fd_sc_hd__nand2_1
X_09740_ network.in_period\[142\]\[0\] _06547_ VSS VSS VDD
+ VDD _06548_ sky130_fd_sc_hd__nand2_1
X_09741_ network.neuron_in142.counter\[0\] _06547_ _06548_
+ VSS VSS VDD VDD _02632_ sky130_fd_sc_hd__o21ai_0
X_09742_ network.in_period\[142\]\[1\] _06547_ VSS VSS VDD
+ VDD _06549_ sky130_fd_sc_hd__nand2_1
X_09743_ _00542_ _06547_ _06549_ VSS VSS VDD VDD _02633_ sky130_fd_sc_hd__o21ai_0
X_09744_ network.neuron_in253.counter\[1\] VSS VSS VDD VDD
+ _01128_ sky130_fd_sc_hd__inv_1
X_09745_ network.neuron_in084.counter\[1\] VSS VSS VDD VDD
+ _00055_ sky130_fd_sc_hd__inv_1
X_09746_ network.neuron_in061.counter\[1\] VSS VSS VDD VDD
+ _00556_ sky130_fd_sc_hd__inv_1
X_09747_ network.neuron_in115.counter\[1\] VSS VSS VDD VDD
+ _01227_ sky130_fd_sc_hd__inv_1
X_09748_ network.neuron_in060.counter\[1\] VSS VSS VDD VDD
+ _00195_ sky130_fd_sc_hd__inv_1
X_09749_ network.neuron_in105.counter\[0\] VSS VSS VDD VDD
+ _01075_ sky130_fd_sc_hd__inv_1
X_09750_ network.neuron_in198.counter\[2\] network.neuron_in198.counter\[3\]
+ VSS VSS VDD VDD _06550_ sky130_fd_sc_hd__nor2_1
X_09751_ net369 _06550_ VSS VSS VDD VDD _06551_ sky130_fd_sc_hd__nor2_1
X_09752_ network.neuron_in198.counter\[2\] _01161_ VSS VSS
+ VDD VDD _06552_ sky130_fd_sc_hd__xnor2_1
X_09753_ network.in_period\[198\]\[2\] _06551_ _06552_ net406
+ VSS VSS VDD VDD _02858_ sky130_fd_sc_hd__a2bb2oi_1
X_09754_ network.neuron_in193.counter\[2\] _00745_ VSS VSS
+ VDD VDD _06553_ sky130_fd_sc_hd__nor2b_1
X_09755_ _00745_ network.neuron_in193.counter\[2\] VSS VSS
+ VDD VDD _06554_ sky130_fd_sc_hd__nor2b_1
X_09756_ network.neuron_in193.counter\[2\] network.neuron_in193.counter\[3\]
+ VSS VSS VDD VDD _06555_ sky130_fd_sc_hd__nor2_1
X_09757_ net368 _06555_ VSS VSS VDD VDD _06556_ sky130_fd_sc_hd__nor2_1
X_09758_ net368 _06553_ _06554_ _06556_ network.in_period\[193\]\[2\]
+ VSS VSS VDD VDD _02838_ sky130_fd_sc_hd__o32a_1
X_09759_ network.neuron_in197.counter\[0\] VSS VSS VDD VDD
+ _00822_ sky130_fd_sc_hd__inv_1
X_09760_ network.neuron_in197.counter\[3\] _00824_ VSS VSS
+ VDD VDD _06557_ sky130_fd_sc_hd__nand2b_1
X_09761_ network.neuron_in197.counter\[2\] _06557_ VSS VSS
+ VDD VDD _06558_ sky130_fd_sc_hd__or2_2
X_09762_ net404 _06558_ VSS VSS VDD VDD _06559_ sky130_fd_sc_hd__nand2_1
X_09763_ network.in_period\[197\]\[0\] _06559_ VSS VSS VDD
+ VDD _06560_ sky130_fd_sc_hd__nand2_1
X_09764_ network.neuron_in197.counter\[0\] _06559_ _06560_
+ VSS VSS VDD VDD _02852_ sky130_fd_sc_hd__o21ai_0
X_09765_ network.neuron_in190.counter\[3\] _00976_ VSS VSS
+ VDD VDD _06561_ sky130_fd_sc_hd__nand2b_1
X_09766_ network.neuron_in190.counter\[2\] VSS VSS VDD VDD
+ _06562_ sky130_fd_sc_hd__inv_1
X_09767_ _06561_ _06562_ VSS VSS VDD VDD _06563_ sky130_fd_sc_hd__nand2b_1
X_09768_ net382 _06563_ VSS VSS VDD VDD _06564_ sky130_fd_sc_hd__nand2_1
X_09769_ network.in_period\[190\]\[1\] _06564_ VSS VSS VDD
+ VDD _06565_ sky130_fd_sc_hd__nand2_1
X_09770_ _00977_ _06564_ _06565_ VSS VSS VDD VDD _02825_ sky130_fd_sc_hd__o21ai_0
X_09771_ network.neuron_in192.counter\[0\] VSS VSS VDD VDD
+ _00747_ sky130_fd_sc_hd__inv_1
X_09772_ network.neuron_in192.counter\[3\] _00749_ VSS VSS
+ VDD VDD _06566_ sky130_fd_sc_hd__nand2b_1
X_09773_ network.neuron_in192.counter\[2\] VSS VSS VDD VDD
+ _06567_ sky130_fd_sc_hd__inv_1
X_09774_ _06566_ _06567_ VSS VSS VDD VDD _06568_ sky130_fd_sc_hd__nand2b_1
X_09775_ net405 _06568_ VSS VSS VDD VDD _06569_ sky130_fd_sc_hd__nand2_1
X_09776_ network.in_period\[192\]\[0\] _06569_ VSS VSS VDD
+ VDD _06570_ sky130_fd_sc_hd__nand2_1
X_09777_ network.neuron_in192.counter\[0\] _06569_ _06570_
+ VSS VSS VDD VDD _02832_ sky130_fd_sc_hd__o21ai_0
X_09778_ network.neuron_in126.counter\[0\] VSS VSS VDD VDD
+ _00726_ sky130_fd_sc_hd__inv_1
X_09779_ network.neuron_in243.counter\[1\] VSS VSS VDD VDD
+ _00779_ sky130_fd_sc_hd__inv_1
X_09780_ network.neuron_in121.counter\[1\] VSS VSS VDD VDD
+ _00124_ sky130_fd_sc_hd__inv_1
X_09781_ network.neuron_in225.counter\[1\] VSS VSS VDD VDD
+ _00340_ sky130_fd_sc_hd__inv_1
X_09782_ network.neuron_in191.counter\[0\] VSS VSS VDD VDD
+ _01175_ sky130_fd_sc_hd__inv_1
X_09783_ network.neuron_in183.counter\[1\] VSS VSS VDD VDD
+ _00983_ sky130_fd_sc_hd__inv_1
X_09784_ network.neuron_in195.counter\[3\] _00828_ VSS VSS
+ VDD VDD _06571_ sky130_fd_sc_hd__nand2b_1
X_09785_ network.neuron_in195.counter\[2\] VSS VSS VDD VDD
+ _06572_ sky130_fd_sc_hd__inv_1
X_09786_ _06571_ _06572_ VSS VSS VDD VDD _06573_ sky130_fd_sc_hd__nand2b_1
X_09787_ net406 _06573_ VSS VSS VDD VDD _06574_ sky130_fd_sc_hd__nand2_1
X_09788_ network.in_period\[195\]\[1\] _06574_ VSS VSS VDD
+ VDD _06575_ sky130_fd_sc_hd__nand2_1
X_09789_ _00829_ _06574_ _06575_ VSS VSS VDD VDD _02845_ sky130_fd_sc_hd__o21ai_0
X_09790_ network.in_period\[197\]\[1\] _06559_ VSS VSS VDD
+ VDD _06576_ sky130_fd_sc_hd__nand2_1
X_09791_ _00825_ _06559_ _06576_ VSS VSS VDD VDD _02853_ sky130_fd_sc_hd__o21ai_0
X_09792_ network.neuron_in059.counter\[1\] VSS VSS VDD VDD
+ _00205_ sky130_fd_sc_hd__inv_1
X_09793_ network.neuron_in141.counter\[1\] VSS VSS VDD VDD
+ _01072_ sky130_fd_sc_hd__inv_1
X_09794_ network.neuron_in204.counter\[1\] VSS VSS VDD VDD
+ _00213_ sky130_fd_sc_hd__inv_1
X_09795_ network.neuron_in141.counter\[2\] network.neuron_in141.counter\[3\]
+ VSS VSS VDD VDD _06577_ sky130_fd_sc_hd__nor2_1
X_09796_ _01073_ _06577_ VSS VSS VDD VDD _06578_ sky130_fd_sc_hd__nand2_1
X_09797_ net393 _06578_ VSS VSS VDD VDD _06579_ sky130_fd_sc_hd__nand2_1
X_09798_ network.in_period\[141\]\[1\] _06579_ VSS VSS VDD
+ VDD _06580_ sky130_fd_sc_hd__nand2_1
X_09799_ _01074_ _06579_ _06580_ VSS VSS VDD VDD _02629_ sky130_fd_sc_hd__o21ai_0
Xclkbuf_leaf_195_clk clknet_5_20__leaf_clk VSS VSS VDD VDD
+ clknet_leaf_195_clk sky130_fd_sc_hd__clkbuf_16
X_09801_ network.neuron_in142.counter\[2\] _00541_ VSS VSS
+ VDD VDD _06582_ sky130_fd_sc_hd__xnor2_1
X_09802_ net393 _06546_ network.in_period\[142\]\[2\] VSS
+ VSS VDD VDD _06583_ sky130_fd_sc_hd__a21oi_1
X_09803_ net393 _06582_ _06583_ VSS VSS VDD VDD _02634_ sky130_fd_sc_hd__a21oi_1
X_09804_ network.neuron_in141.counter\[0\] VSS VSS VDD VDD
+ _01071_ sky130_fd_sc_hd__inv_1
X_09805_ network.in_period\[141\]\[0\] _06579_ VSS VSS VDD
+ VDD _06584_ sky130_fd_sc_hd__nand2_1
X_09806_ network.neuron_in141.counter\[0\] _06579_ _06584_
+ VSS VSS VDD VDD _02628_ sky130_fd_sc_hd__o21ai_0
X_09807_ _01117_ network.neuron_in189.counter\[2\] VSS VSS
+ VDD VDD _06585_ sky130_fd_sc_hd__xnor2_1
X_09808_ network.neuron_in189.counter\[2\] network.neuron_in189.counter\[3\]
+ VSS VSS VDD VDD _06586_ sky130_fd_sc_hd__nor2_1
X_09809_ _01117_ _06586_ VSS VSS VDD VDD _06587_ sky130_fd_sc_hd__nand2_1
X_09810_ net382 _06587_ network.in_period\[189\]\[2\] VSS
+ VSS VDD VDD _06588_ sky130_fd_sc_hd__a21oi_1
X_09811_ net382 _06585_ _06588_ VSS VSS VDD VDD _02822_ sky130_fd_sc_hd__a21oi_1
X_09812_ network.neuron_in190.counter\[3\] network.in_period\[190\]\[2\]
+ _00976_ net367 VSS VSS VDD VDD _06589_ sky130_fd_sc_hd__o22ai_1
X_09813_ network.neuron_in190.counter\[2\] _00976_ net382
+ VSS VSS VDD VDD _06590_ sky130_fd_sc_hd__nand3_1
X_09814_ network.in_period\[190\]\[2\] net382 _06590_ VSS
+ VSS VDD VDD _06591_ sky130_fd_sc_hd__o21ai_0
X_09815_ _06562_ _06589_ _06591_ VSS VSS VDD VDD _02826_ sky130_fd_sc_hd__a21oi_1
X_09816_ network.neuron_in203.counter\[1\] VSS VSS VDD VDD
+ _01050_ sky130_fd_sc_hd__inv_1
X_09817_ network.neuron_in119.counter\[1\] VSS VSS VDD VDD
+ _00580_ sky130_fd_sc_hd__inv_1
X_09818_ network.neuron_in101.counter\[1\] VSS VSS VDD VDD
+ _00835_ sky130_fd_sc_hd__inv_1
X_09819_ network.neuron_in242.counter\[0\] VSS VSS VDD VDD
+ _00583_ sky130_fd_sc_hd__inv_1
X_09820_ network.neuron_in110.counter\[0\] VSS VSS VDD VDD
+ _00078_ sky130_fd_sc_hd__inv_1
X_09821_ network.neuron_in058.counter\[1\] VSS VSS VDD VDD
+ _00221_ sky130_fd_sc_hd__inv_1
X_09822_ network.neuron_in041.counter\[0\] VSS VSS VDD VDD
+ _00310_ sky130_fd_sc_hd__inv_1
X_09823_ network.neuron_in191.counter\[3\] _01177_ VSS VSS
+ VDD VDD _06592_ sky130_fd_sc_hd__nand2b_1
X_09824_ network.neuron_in191.counter\[2\] VSS VSS VDD VDD
+ _06593_ sky130_fd_sc_hd__inv_1
X_09825_ _06592_ _06593_ VSS VSS VDD VDD _06594_ sky130_fd_sc_hd__nand2b_1
X_09826_ net382 _06594_ VSS VSS VDD VDD _06595_ sky130_fd_sc_hd__nand2_1
X_09827_ network.in_period\[191\]\[1\] _06595_ VSS VSS VDD
+ VDD _06596_ sky130_fd_sc_hd__nand2_1
X_09828_ _01178_ _06595_ _06596_ VSS VSS VDD VDD _02829_ sky130_fd_sc_hd__o21ai_0
X_09829_ network.in_period\[192\]\[1\] _06569_ VSS VSS VDD
+ VDD _06597_ sky130_fd_sc_hd__nand2_1
X_09830_ _00750_ _06569_ _06597_ VSS VSS VDD VDD _02833_ sky130_fd_sc_hd__o21ai_0
X_09831_ network.neuron_in194.counter\[2\] _00972_ VSS VSS
+ VDD VDD _06598_ sky130_fd_sc_hd__xnor2_1
X_09832_ network.neuron_in194.counter\[2\] network.neuron_in194.counter\[3\]
+ VSS VSS VDD VDD _06599_ sky130_fd_sc_hd__nor2_1
X_09833_ _00972_ _06599_ VSS VSS VDD VDD _06600_ sky130_fd_sc_hd__nand2_1
X_09834_ net405 _06600_ network.in_period\[194\]\[2\] VSS
+ VSS VDD VDD _06601_ sky130_fd_sc_hd__a21oi_1
X_09835_ net405 _06598_ _06601_ VSS VSS VDD VDD _02842_ sky130_fd_sc_hd__a21oi_1
X_09836_ network.neuron_in195.counter\[3\] network.in_period\[195\]\[2\]
+ _00828_ net369 VSS VSS VDD VDD _06602_ sky130_fd_sc_hd__o22ai_1
Xclkbuf_leaf_194_clk clknet_5_21__leaf_clk VSS VSS VDD VDD
+ clknet_leaf_194_clk sky130_fd_sc_hd__clkbuf_16
Xclkbuf_leaf_193_clk clknet_5_21__leaf_clk VSS VSS VDD VDD
+ clknet_leaf_193_clk sky130_fd_sc_hd__clkbuf_16
X_09839_ network.neuron_in195.counter\[2\] _00828_ net406
+ VSS VSS VDD VDD _06605_ sky130_fd_sc_hd__nand3_1
X_09840_ network.in_period\[195\]\[2\] net406 _06605_ VSS
+ VSS VDD VDD _06606_ sky130_fd_sc_hd__o21ai_0
X_09841_ _06572_ _06602_ _06606_ VSS VSS VDD VDD _02846_ sky130_fd_sc_hd__a21oi_1
X_09842_ network.neuron_in196.counter\[2\] VSS VSS VDD VDD
+ _06607_ sky130_fd_sc_hd__inv_1
X_09843_ network.neuron_in196.counter\[3\] network.in_period\[196\]\[2\]
+ _01181_ net369 VSS VSS VDD VDD _06608_ sky130_fd_sc_hd__o22ai_1
X_09844_ network.neuron_in196.counter\[2\] _01181_ net404
+ VSS VSS VDD VDD _06609_ sky130_fd_sc_hd__nand3_1
X_09845_ network.in_period\[196\]\[2\] net404 _06609_ VSS
+ VSS VDD VDD _06610_ sky130_fd_sc_hd__o21ai_0
X_09846_ _06607_ _06608_ _06610_ VSS VSS VDD VDD _02850_ sky130_fd_sc_hd__a21oi_1
X_09847_ network.neuron_in255.counter\[1\] VSS VSS VDD VDD
+ _00771_ sky130_fd_sc_hd__inv_1
X_09848_ network.neuron_in057.counter\[1\] VSS VSS VDD VDD
+ _00233_ sky130_fd_sc_hd__inv_1
X_09849_ network.neuron_in189.counter\[1\] VSS VSS VDD VDD
+ _01116_ sky130_fd_sc_hd__inv_1
X_09850_ network.neuron_in197.counter\[2\] _00824_ VSS VSS
+ VDD VDD _06611_ sky130_fd_sc_hd__xnor2_1
X_09851_ network.neuron_in197.counter\[2\] network.neuron_in197.counter\[3\]
+ VSS VSS VDD VDD _06612_ sky130_fd_sc_hd__nor2_1
X_09852_ net369 _06612_ VSS VSS VDD VDD _06613_ sky130_fd_sc_hd__nor2_1
X_09853_ network.in_period\[197\]\[2\] _06613_ VSS VSS VDD
+ VDD _06614_ sky130_fd_sc_hd__nor2_1
X_09854_ net404 _06611_ _06614_ VSS VSS VDD VDD _02854_ sky130_fd_sc_hd__a21oi_1
X_09855_ network.neuron_in189.counter\[0\] VSS VSS VDD VDD
+ _01115_ sky130_fd_sc_hd__inv_1
X_09856_ network.neuron_in056.counter\[1\] VSS VSS VDD VDD
+ _00225_ sky130_fd_sc_hd__inv_1
X_09857_ network.neuron_in188.counter\[3\] _00238_ VSS VSS
+ VDD VDD _06615_ sky130_fd_sc_hd__nand2b_1
X_09858_ network.neuron_in188.counter\[2\] _06615_ VSS VSS
+ VDD VDD _06616_ sky130_fd_sc_hd__or2_2
X_09859_ net382 _06616_ VSS VSS VDD VDD _06617_ sky130_fd_sc_hd__nand2_1
X_09860_ network.in_period\[188\]\[1\] _06617_ VSS VSS VDD
+ VDD _06618_ sky130_fd_sc_hd__nand2_1
X_09861_ _00239_ _06617_ _06618_ VSS VSS VDD VDD _02817_ sky130_fd_sc_hd__o21ai_0
X_09862_ _01073_ network.neuron_in141.counter\[2\] VSS VSS
+ VDD VDD _06619_ sky130_fd_sc_hd__xnor2_1
X_09863_ net393 _06578_ network.in_period\[141\]\[2\] VSS
+ VSS VDD VDD _06620_ sky130_fd_sc_hd__a21oi_1
X_09864_ net393 _06619_ _06620_ VSS VSS VDD VDD _02630_ sky130_fd_sc_hd__a21oi_1
X_09865_ network.neuron_in188.counter\[0\] VSS VSS VDD VDD
+ _00236_ sky130_fd_sc_hd__inv_1
X_09866_ network.in_period\[188\]\[0\] _06617_ VSS VSS VDD
+ VDD _06621_ sky130_fd_sc_hd__nand2_1
X_09867_ network.neuron_in188.counter\[0\] _06617_ _06621_
+ VSS VSS VDD VDD _02816_ sky130_fd_sc_hd__o21ai_0
X_09868_ net382 _06587_ VSS VSS VDD VDD _06622_ sky130_fd_sc_hd__nand2_1
X_09869_ network.in_period\[189\]\[1\] _06622_ VSS VSS VDD
+ VDD _06623_ sky130_fd_sc_hd__nand2_1
X_09870_ _01118_ _06622_ _06623_ VSS VSS VDD VDD _02821_ sky130_fd_sc_hd__o21ai_0
X_09871_ network.in_period\[189\]\[0\] _06622_ VSS VSS VDD
+ VDD _06624_ sky130_fd_sc_hd__nand2_1
X_09872_ network.neuron_in189.counter\[0\] _06622_ _06624_
+ VSS VSS VDD VDD _02820_ sky130_fd_sc_hd__o21ai_0
X_09873_ network.neuron_in190.counter\[0\] VSS VSS VDD VDD
+ _00974_ sky130_fd_sc_hd__inv_1
X_09874_ network.in_period\[190\]\[0\] _06564_ VSS VSS VDD
+ VDD _06625_ sky130_fd_sc_hd__nand2_1
X_09875_ network.neuron_in190.counter\[0\] _06564_ _06625_
+ VSS VSS VDD VDD _02824_ sky130_fd_sc_hd__o21ai_0
Xclkbuf_leaf_192_clk clknet_5_21__leaf_clk VSS VSS VDD VDD
+ clknet_leaf_192_clk sky130_fd_sc_hd__clkbuf_16
X_09877_ network.neuron_in140.counter\[2\] _01089_ VSS VSS
+ VDD VDD _06627_ sky130_fd_sc_hd__nor2b_1
X_09878_ network.neuron_in140.counter\[3\] _06627_ VSS VSS
+ VDD VDD _06628_ sky130_fd_sc_hd__nand2b_1
X_09879_ net393 _06628_ VSS VSS VDD VDD _06629_ sky130_fd_sc_hd__nand2_1
X_09880_ network.in_period\[140\]\[0\] _06629_ VSS VSS VDD
+ VDD _06630_ sky130_fd_sc_hd__nand2_1
X_09881_ network.neuron_in140.counter\[0\] _06629_ _06630_
+ VSS VSS VDD VDD _02624_ sky130_fd_sc_hd__o21ai_0
X_09882_ network.neuron_in107.counter\[1\] VSS VSS VDD VDD
+ _01068_ sky130_fd_sc_hd__inv_1
Xclkbuf_leaf_191_clk clknet_5_21__leaf_clk VSS VSS VDD VDD
+ clknet_leaf_191_clk sky130_fd_sc_hd__clkbuf_16
X_09884_ network.neuron_in191.counter\[3\] network.in_period\[191\]\[2\]
+ net367 _01177_ VSS VSS VDD VDD _06632_ sky130_fd_sc_hd__o22ai_1
X_09885_ network.neuron_in191.counter\[2\] _01177_ net382
+ VSS VSS VDD VDD _06633_ sky130_fd_sc_hd__nand3_1
X_09886_ network.in_period\[191\]\[2\] net382 _06633_ VSS
+ VSS VDD VDD _06634_ sky130_fd_sc_hd__o21ai_0
X_09887_ _06593_ _06632_ _06634_ VSS VSS VDD VDD _02830_ sky130_fd_sc_hd__a21oi_1
X_09888_ network.in_period\[191\]\[0\] _06595_ VSS VSS VDD
+ VDD _06635_ sky130_fd_sc_hd__nand2_1
X_09889_ network.neuron_in191.counter\[0\] _06595_ _06635_
+ VSS VSS VDD VDD _02828_ sky130_fd_sc_hd__o21ai_0
X_09890_ network.neuron_in005.counter\[0\] VSS VSS VDD VDD
+ _00690_ sky130_fd_sc_hd__inv_1
X_09891_ network.neuron_in192.counter\[3\] network.in_period\[192\]\[2\]
+ _00749_ net368 VSS VSS VDD VDD _06636_ sky130_fd_sc_hd__o22ai_1
X_09892_ network.neuron_in192.counter\[2\] _00749_ net405
+ VSS VSS VDD VDD _06637_ sky130_fd_sc_hd__nand3_1
X_09893_ network.in_period\[192\]\[2\] net405 _06637_ VSS
+ VSS VDD VDD _06638_ sky130_fd_sc_hd__o21ai_0
X_09894_ _06567_ _06636_ _06638_ VSS VSS VDD VDD _02834_ sky130_fd_sc_hd__a21oi_1
X_09895_ _00745_ _06555_ VSS VSS VDD VDD _06639_ sky130_fd_sc_hd__nand2_1
X_09896_ net405 _06639_ VSS VSS VDD VDD _06640_ sky130_fd_sc_hd__nand2_1
X_09897_ network.in_period\[193\]\[1\] _06640_ VSS VSS VDD
+ VDD _06641_ sky130_fd_sc_hd__nand2_1
X_09898_ _00746_ _06640_ _06641_ VSS VSS VDD VDD _02837_ sky130_fd_sc_hd__o21ai_0
X_09899_ network.neuron_in235.counter\[0\] VSS VSS VDD VDD
+ _00587_ sky130_fd_sc_hd__inv_1
X_09900_ network.neuron_in242.counter\[1\] VSS VSS VDD VDD
+ _00584_ sky130_fd_sc_hd__inv_1
X_09901_ network.in_period\[193\]\[0\] _06640_ VSS VSS VDD
+ VDD _06642_ sky130_fd_sc_hd__nand2_1
X_09902_ network.neuron_in193.counter\[0\] _06640_ _06642_
+ VSS VSS VDD VDD _02836_ sky130_fd_sc_hd__o21ai_0
X_09903_ net405 _06600_ VSS VSS VDD VDD _06643_ sky130_fd_sc_hd__nand2_1
X_09904_ network.in_period\[194\]\[1\] _06643_ VSS VSS VDD
+ VDD _06644_ sky130_fd_sc_hd__nand2_1
X_09905_ _00973_ _06643_ _06644_ VSS VSS VDD VDD _02841_ sky130_fd_sc_hd__o21ai_0
X_09906_ network.neuron_in065.counter\[0\] VSS VSS VDD VDD
+ _00172_ sky130_fd_sc_hd__inv_1
X_09907_ network.in_period\[140\]\[1\] _06629_ VSS VSS VDD
+ VDD _06645_ sky130_fd_sc_hd__nand2_1
X_09908_ _01090_ _06629_ _06645_ VSS VSS VDD VDD _02625_ sky130_fd_sc_hd__o21ai_0
X_09909_ network.neuron_in055.counter\[1\] VSS VSS VDD VDD
+ _00241_ sky130_fd_sc_hd__inv_1
X_09910_ network.neuron_in194.counter\[0\] VSS VSS VDD VDD
+ _00970_ sky130_fd_sc_hd__inv_1
X_09911_ network.in_period\[194\]\[0\] _06643_ VSS VSS VDD
+ VDD _06646_ sky130_fd_sc_hd__nand2_1
X_09912_ network.neuron_in194.counter\[0\] _06643_ _06646_
+ VSS VSS VDD VDD _02840_ sky130_fd_sc_hd__o21ai_0
X_09913_ network.neuron_in195.counter\[0\] VSS VSS VDD VDD
+ _00826_ sky130_fd_sc_hd__inv_1
X_09914_ network.in_period\[195\]\[0\] _06574_ VSS VSS VDD
+ VDD _06647_ sky130_fd_sc_hd__nand2_1
X_09915_ network.neuron_in195.counter\[0\] _06574_ _06647_
+ VSS VSS VDD VDD _02844_ sky130_fd_sc_hd__o21ai_0
X_09916_ network.neuron_in035.counter\[1\] VSS VSS VDD VDD
+ _00443_ sky130_fd_sc_hd__inv_1
X_09917_ network.neuron_in042.counter\[1\] VSS VSS VDD VDD
+ _00307_ sky130_fd_sc_hd__inv_1
X_09918_ network.neuron_in196.counter\[3\] _01181_ VSS VSS
+ VDD VDD _06648_ sky130_fd_sc_hd__nand2b_1
X_09919_ _06648_ _06607_ VSS VSS VDD VDD _06649_ sky130_fd_sc_hd__nand2b_1
X_09920_ net404 _06649_ VSS VSS VDD VDD _06650_ sky130_fd_sc_hd__nand2_1
X_09921_ network.in_period\[196\]\[1\] _06650_ VSS VSS VDD
+ VDD _06651_ sky130_fd_sc_hd__nand2_1
X_09922_ _01182_ _06650_ _06651_ VSS VSS VDD VDD _02849_ sky130_fd_sc_hd__o21ai_0
X_09923_ network.neuron_in196.counter\[0\] VSS VSS VDD VDD
+ _01179_ sky130_fd_sc_hd__inv_1
X_09924_ network.in_period\[196\]\[0\] _06650_ VSS VSS VDD
+ VDD _06652_ sky130_fd_sc_hd__nand2_1
X_09925_ network.neuron_in196.counter\[0\] _06650_ _06652_
+ VSS VSS VDD VDD _02848_ sky130_fd_sc_hd__o21ai_0
X_09926_ network.neuron_in208.counter\[2\] _00641_ VSS VSS
+ VDD VDD _06653_ sky130_fd_sc_hd__nand2b_1
X_09927_ _00641_ network.neuron_in208.counter\[2\] VSS VSS
+ VDD VDD _06654_ sky130_fd_sc_hd__nand2b_1
Xclkbuf_leaf_190_clk clknet_5_21__leaf_clk VSS VSS VDD VDD
+ clknet_leaf_190_clk sky130_fd_sc_hd__clkbuf_16
X_09929_ network.neuron_in208.counter\[2\] network.neuron_in208.counter\[3\]
+ VSS VSS VDD VDD _06656_ sky130_fd_sc_hd__nor2_1
X_09930_ net369 _06656_ VSS VSS VDD VDD _06657_ sky130_fd_sc_hd__nor2_1
X_09931_ network.in_period\[208\]\[2\] _06657_ VSS VSS VDD
+ VDD _06658_ sky130_fd_sc_hd__nor2_1
X_09932_ net403 _06653_ _06654_ _06658_ VSS VSS VDD VDD _02898_
+ sky130_fd_sc_hd__a31oi_1
X_09933_ network.neuron_in203.counter\[2\] VSS VSS VDD VDD
+ _06659_ sky130_fd_sc_hd__inv_1
X_09934_ network.neuron_in203.counter\[3\] network.in_period\[203\]\[2\]
+ _01051_ net369 VSS VSS VDD VDD _06660_ sky130_fd_sc_hd__o22ai_1
Xclkbuf_leaf_189_clk clknet_5_21__leaf_clk VSS VSS VDD VDD
+ clknet_leaf_189_clk sky130_fd_sc_hd__clkbuf_16
Xclkbuf_leaf_188_clk clknet_5_21__leaf_clk VSS VSS VDD VDD
+ clknet_leaf_188_clk sky130_fd_sc_hd__clkbuf_16
X_09937_ network.neuron_in203.counter\[2\] _01051_ net403
+ VSS VSS VDD VDD _06663_ sky130_fd_sc_hd__nand3_1
X_09938_ network.in_period\[203\]\[2\] net403 _06663_ VSS
+ VSS VDD VDD _06664_ sky130_fd_sc_hd__o21ai_0
X_09939_ _06659_ _06660_ _06664_ VSS VSS VDD VDD _02878_ sky130_fd_sc_hd__a21oi_1
Xclkbuf_leaf_187_clk clknet_5_21__leaf_clk VSS VSS VDD VDD
+ clknet_leaf_187_clk sky130_fd_sc_hd__clkbuf_16
X_09941_ network.neuron_in140.counter\[2\] net393 VSS VSS
+ VDD VDD _06666_ sky130_fd_sc_hd__nand2_1
X_09942_ network.in_period\[140\]\[2\] network.neuron_in140.counter\[3\]
+ _06666_ VSS VSS VDD VDD _06667_ sky130_fd_sc_hd__o21ai_0
X_09943_ _01089_ network.neuron_in140.counter\[2\] net374
+ VSS VSS VDD VDD _06668_ sky130_fd_sc_hd__or3_1
X_09944_ network.in_period\[140\]\[2\] net393 _06668_ VSS
+ VSS VDD VDD _06669_ sky130_fd_sc_hd__o21ai_0
X_09945_ _01089_ _06667_ _06669_ VSS VSS VDD VDD _02626_ sky130_fd_sc_hd__a21oi_1
X_09946_ network.neuron_in207.counter\[0\] VSS VSS VDD VDD
+ _01171_ sky130_fd_sc_hd__inv_1
X_09947_ network.neuron_in207.counter\[2\] network.neuron_in207.counter\[3\]
+ VSS VSS VDD VDD _06670_ sky130_fd_sc_hd__nor2_1
X_09948_ _01173_ _06670_ VSS VSS VDD VDD _06671_ sky130_fd_sc_hd__nand2_1
X_09949_ net403 _06671_ VSS VSS VDD VDD _06672_ sky130_fd_sc_hd__nand2_1
X_09950_ network.in_period\[207\]\[0\] _06672_ VSS VSS VDD
+ VDD _06673_ sky130_fd_sc_hd__nand2_1
X_09951_ network.neuron_in207.counter\[0\] _06672_ _06673_
+ VSS VSS VDD VDD _02892_ sky130_fd_sc_hd__o21ai_0
X_09952_ network.neuron_in200.counter\[2\] _00527_ VSS VSS
+ VDD VDD _06674_ sky130_fd_sc_hd__nor2b_1
X_09953_ network.neuron_in200.counter\[3\] _06674_ VSS VSS
+ VDD VDD _06675_ sky130_fd_sc_hd__nand2b_1
X_09954_ net404 _06675_ VSS VSS VDD VDD _06676_ sky130_fd_sc_hd__nand2_1
X_09955_ network.in_period\[200\]\[1\] _06676_ VSS VSS VDD
+ VDD _06677_ sky130_fd_sc_hd__nand2_1
X_09956_ _00528_ _06676_ _06677_ VSS VSS VDD VDD _02865_ sky130_fd_sc_hd__o21ai_0
Xclkbuf_leaf_186_clk clknet_5_21__leaf_clk VSS VSS VDD VDD
+ clknet_leaf_186_clk sky130_fd_sc_hd__clkbuf_16
X_09958_ network.neuron_in202.counter\[2\] network.neuron_in202.counter\[3\]
+ VSS VSS VDD VDD _06679_ sky130_fd_sc_hd__nor2_1
X_09959_ _01081_ _06679_ VSS VSS VDD VDD _06680_ sky130_fd_sc_hd__nand2_1
X_09960_ net406 _06680_ VSS VSS VDD VDD _06681_ sky130_fd_sc_hd__nand2_1
X_09961_ network.in_period\[202\]\[0\] _06681_ VSS VSS VDD
+ VDD _06682_ sky130_fd_sc_hd__nand2_1
X_09962_ network.neuron_in202.counter\[0\] _06681_ _06682_
+ VSS VSS VDD VDD _02872_ sky130_fd_sc_hd__o21ai_0
X_09963_ network.neuron_in139.counter\[0\] VSS VSS VDD VDD
+ _00649_ sky130_fd_sc_hd__inv_1
X_09964_ network.neuron_in139.counter\[3\] _00651_ VSS VSS
+ VDD VDD _06683_ sky130_fd_sc_hd__nand2b_1
X_09965_ network.neuron_in139.counter\[2\] VSS VSS VDD VDD
+ _06684_ sky130_fd_sc_hd__inv_1
X_09966_ _06683_ _06684_ VSS VSS VDD VDD _06685_ sky130_fd_sc_hd__nand2b_1
X_09967_ net383 _06685_ VSS VSS VDD VDD _06686_ sky130_fd_sc_hd__nand2_1
X_09968_ network.in_period\[139\]\[0\] _06686_ VSS VSS VDD
+ VDD _06687_ sky130_fd_sc_hd__nand2_1
X_09969_ network.neuron_in139.counter\[0\] _06686_ _06687_
+ VSS VSS VDD VDD _02620_ sky130_fd_sc_hd__o21ai_0
X_09970_ network.neuron_in107.counter\[0\] VSS VSS VDD VDD
+ _01067_ sky130_fd_sc_hd__inv_1
X_09971_ network.neuron_in053.counter\[1\] VSS VSS VDD VDD
+ _00251_ sky130_fd_sc_hd__inv_1
X_09972_ network.neuron_in191.counter\[1\] VSS VSS VDD VDD
+ _01176_ sky130_fd_sc_hd__inv_1
X_09973_ network.neuron_in148.counter\[0\] VSS VSS VDD VDD
+ _00591_ sky130_fd_sc_hd__inv_1
X_09974_ network.neuron_in052.counter\[1\] VSS VSS VDD VDD
+ _00255_ sky130_fd_sc_hd__inv_1
X_09975_ network.neuron_in035.counter\[0\] VSS VSS VDD VDD
+ _00442_ sky130_fd_sc_hd__inv_1
X_09976_ network.neuron_in156.counter\[1\] VSS VSS VDD VDD
+ _01064_ sky130_fd_sc_hd__inv_1
X_09977_ network.neuron_in042.counter\[0\] VSS VSS VDD VDD
+ _00306_ sky130_fd_sc_hd__inv_1
X_09978_ network.neuron_in120.counter\[0\] VSS VSS VDD VDD
+ _00790_ sky130_fd_sc_hd__inv_1
X_09979_ network.neuron_in048.counter\[1\] VSS VSS VDD VDD
+ _00263_ sky130_fd_sc_hd__inv_1
X_09980_ network.neuron_in205.counter\[1\] VSS VSS VDD VDD
+ _00967_ sky130_fd_sc_hd__inv_1
X_09981_ network.neuron_in049.counter\[1\] VSS VSS VDD VDD
+ _00259_ sky130_fd_sc_hd__inv_1
X_09982_ network.neuron_in148.counter\[1\] VSS VSS VDD VDD
+ _00592_ sky130_fd_sc_hd__inv_1
X_09983_ _00621_ network.neuron_in145.counter\[2\] VSS VSS
+ VDD VDD _06688_ sky130_fd_sc_hd__xnor2_1
Xclkbuf_leaf_185_clk clknet_5_20__leaf_clk VSS VSS VDD VDD
+ clknet_leaf_185_clk sky130_fd_sc_hd__clkbuf_16
X_09985_ network.neuron_in145.counter\[3\] _00621_ VSS VSS
+ VDD VDD _06690_ sky130_fd_sc_hd__nand2b_1
X_09986_ net400 _06690_ network.in_period\[145\]\[2\] VSS
+ VSS VDD VDD _06691_ sky130_fd_sc_hd__a21oi_1
X_09987_ net400 _06688_ _06691_ VSS VSS VDD VDD _02646_ sky130_fd_sc_hd__a21oi_1
X_09988_ network.neuron_in047.counter\[1\] VSS VSS VDD VDD
+ _00267_ sky130_fd_sc_hd__inv_1
X_09989_ network.neuron_in176.counter\[1\] VSS VSS VDD VDD
+ _01060_ sky130_fd_sc_hd__inv_1
X_09990_ network.neuron_in185.counter\[1\] VSS VSS VDD VDD
+ _00229_ sky130_fd_sc_hd__inv_1
X_09991_ network.neuron_in046.counter\[1\] VSS VSS VDD VDD
+ _00275_ sky130_fd_sc_hd__inv_1
X_09992_ network.neuron_in209.counter\[1\] VSS VSS VDD VDD
+ _00283_ sky130_fd_sc_hd__inv_1
X_09993_ network.neuron_in216.counter\[1\] VSS VSS VDD VDD
+ _00303_ sky130_fd_sc_hd__inv_1
X_09994_ network.neuron_in012.counter\[1\] VSS VSS VDD VDD
+ _00427_ sky130_fd_sc_hd__inv_1
X_09995_ network.neuron_in138.counter\[0\] VSS VSS VDD VDD
+ _00595_ sky130_fd_sc_hd__inv_1
X_09996_ network.neuron_in176.counter\[0\] VSS VSS VDD VDD
+ _01059_ sky130_fd_sc_hd__inv_1
X_09997_ network.neuron_in233.counter\[1\] VSS VSS VDD VDD
+ _01056_ sky130_fd_sc_hd__inv_1
X_09998_ network.neuron_in019.counter\[0\] VSS VSS VDD VDD
+ _00394_ sky130_fd_sc_hd__inv_1
X_09999_ network.neuron_in045.counter\[1\] VSS VSS VDD VDD
+ _00287_ sky130_fd_sc_hd__inv_1
Xclkbuf_leaf_184_clk clknet_5_22__leaf_clk VSS VSS VDD VDD
+ clknet_leaf_184_clk sky130_fd_sc_hd__clkbuf_16
Xclkbuf_leaf_183_clk clknet_5_22__leaf_clk VSS VSS VDD VDD
+ clknet_leaf_183_clk sky130_fd_sc_hd__clkbuf_16
X_10002_ network.neuron_in144.counter\[2\] _00736_ VSS VSS
+ VDD VDD _06694_ sky130_fd_sc_hd__nand2b_1
X_10003_ _00736_ network.neuron_in144.counter\[2\] VSS VSS
+ VDD VDD _06695_ sky130_fd_sc_hd__nand2b_1
X_10004_ network.neuron_in144.counter\[3\] network.neuron_in144.counter\[2\]
+ VSS VSS VDD VDD _06696_ sky130_fd_sc_hd__nor2_1
X_10005_ net376 _06696_ VSS VSS VDD VDD _06697_ sky130_fd_sc_hd__nor2_1
X_10006_ network.in_period\[144\]\[2\] _06697_ VSS VSS VDD
+ VDD _06698_ sky130_fd_sc_hd__nor2_1
X_10007_ net394 _06694_ _06695_ _06698_ VSS VSS VDD VDD _02642_
+ sky130_fd_sc_hd__a31oi_1
X_10008_ network.neuron_in143.counter\[0\] VSS VSS VDD VDD
+ _00888_ sky130_fd_sc_hd__inv_1
X_10009_ network.in_period\[143\]\[0\] _06522_ VSS VSS VDD
+ VDD _06699_ sky130_fd_sc_hd__nand2_1
X_10010_ network.neuron_in143.counter\[0\] _06522_ _06699_
+ VSS VSS VDD VDD _02636_ sky130_fd_sc_hd__o21ai_0
X_10011_ network.neuron_in115.counter\[0\] VSS VSS VDD VDD
+ _01226_ sky130_fd_sc_hd__inv_1
X_10012_ network.neuron_in233.counter\[0\] VSS VSS VDD VDD
+ _01055_ sky130_fd_sc_hd__inv_1
X_10013_ network.neuron_in208.counter\[1\] VSS VSS VDD VDD
+ _00640_ sky130_fd_sc_hd__inv_1
X_10014_ network.neuron_in044.counter\[1\] VSS VSS VDD VDD
+ _00271_ sky130_fd_sc_hd__inv_1
X_10015_ network.neuron_in205.counter\[3\] _00968_ VSS VSS
+ VDD VDD _06700_ sky130_fd_sc_hd__nand2b_1
X_10016_ network.neuron_in205.counter\[2\] VSS VSS VDD VDD
+ _06701_ sky130_fd_sc_hd__inv_1
X_10017_ _06700_ _06701_ VSS VSS VDD VDD _06702_ sky130_fd_sc_hd__nand2b_1
X_10018_ net403 _06702_ VSS VSS VDD VDD _06703_ sky130_fd_sc_hd__nand2_1
X_10019_ network.in_period\[205\]\[1\] _06703_ VSS VSS VDD
+ VDD _06704_ sky130_fd_sc_hd__nand2_1
X_10020_ _00969_ _06703_ _06704_ VSS VSS VDD VDD _02885_ sky130_fd_sc_hd__o21ai_0
X_10021_ network.neuron_in033.counter\[0\] VSS VSS VDD VDD
+ _01123_ sky130_fd_sc_hd__inv_1
X_10022_ network.in_period\[207\]\[1\] _06672_ VSS VSS VDD
+ VDD _06705_ sky130_fd_sc_hd__nand2_1
X_10023_ _01174_ _06672_ _06705_ VSS VSS VDD VDD _02893_ sky130_fd_sc_hd__o21ai_0
X_10024_ network.neuron_in066.counter\[0\] VSS VSS VDD VDD
+ _00168_ sky130_fd_sc_hd__inv_1
X_10025_ network.neuron_in199.counter\[2\] VSS VSS VDD VDD
+ _06706_ sky130_fd_sc_hd__inv_1
X_10026_ network.neuron_in199.counter\[3\] network.in_period\[199\]\[2\]
+ _01139_ net369 VSS VSS VDD VDD _06707_ sky130_fd_sc_hd__o22ai_1
X_10027_ network.neuron_in199.counter\[2\] _01139_ net406
+ VSS VSS VDD VDD _06708_ sky130_fd_sc_hd__nand3_1
X_10028_ network.in_period\[199\]\[2\] net406 _06708_ VSS
+ VSS VDD VDD _06709_ sky130_fd_sc_hd__o21ai_0
X_10029_ _06706_ _06707_ _06709_ VSS VSS VDD VDD _02862_ sky130_fd_sc_hd__a21oi_1
X_10030_ network.neuron_in113.counter\[1\] VSS VSS VDD VDD
+ _00576_ sky130_fd_sc_hd__inv_1
X_10031_ network.neuron_in036.counter\[1\] VSS VSS VDD VDD
+ _00348_ sky130_fd_sc_hd__inv_1
X_10032_ network.neuron_in138.counter\[1\] VSS VSS VDD VDD
+ _00596_ sky130_fd_sc_hd__inv_1
X_10033_ network.neuron_in008.counter\[0\] VSS VSS VDD VDD
+ _00464_ sky130_fd_sc_hd__inv_1
X_10034_ network.neuron_in200.counter\[2\] VSS VSS VDD VDD
+ _06710_ sky130_fd_sc_hd__inv_1
X_10035_ network.neuron_in200.counter\[3\] network.in_period\[200\]\[2\]
+ _00527_ net369 VSS VSS VDD VDD _06711_ sky130_fd_sc_hd__o22ai_1
X_10036_ network.neuron_in200.counter\[2\] _00527_ net404
+ VSS VSS VDD VDD _06712_ sky130_fd_sc_hd__nand3_1
X_10037_ network.in_period\[200\]\[2\] net404 _06712_ VSS
+ VSS VDD VDD _06713_ sky130_fd_sc_hd__o21ai_0
X_10038_ _06710_ _06711_ _06713_ VSS VSS VDD VDD _02866_ sky130_fd_sc_hd__a21oi_1
X_10039_ network.neuron_in201.counter\[2\] network.neuron_in201.counter\[3\]
+ VSS VSS VDD VDD _06714_ sky130_fd_sc_hd__nor2_1
X_10040_ _00796_ _06714_ VSS VSS VDD VDD _06715_ sky130_fd_sc_hd__nand2_1
X_10041_ net403 _06715_ VSS VSS VDD VDD _06716_ sky130_fd_sc_hd__nand2_1
X_10042_ network.in_period\[201\]\[1\] _06716_ VSS VSS VDD
+ VDD _06717_ sky130_fd_sc_hd__nand2_1
X_10043_ _00797_ _06716_ _06717_ VSS VSS VDD VDD _02869_ sky130_fd_sc_hd__o21ai_0
X_10044_ network.neuron_in043.counter\[1\] VSS VSS VDD VDD
+ _00295_ sky130_fd_sc_hd__inv_1
X_10045_ network.in_period\[202\]\[1\] _06681_ VSS VSS VDD
+ VDD _06718_ sky130_fd_sc_hd__nand2_1
X_10046_ _01082_ _06681_ _06718_ VSS VSS VDD VDD _02873_ sky130_fd_sc_hd__o21ai_0
X_10047_ network.neuron_in216.counter\[0\] VSS VSS VDD VDD
+ _00302_ sky130_fd_sc_hd__inv_1
X_10048_ network.neuron_in204.counter\[2\] VSS VSS VDD VDD
+ _06719_ sky130_fd_sc_hd__inv_1
X_10049_ network.neuron_in204.counter\[3\] network.in_period\[204\]\[2\]
+ _00214_ net369 VSS VSS VDD VDD _06720_ sky130_fd_sc_hd__o22ai_1
X_10050_ network.neuron_in204.counter\[2\] _00214_ net403
+ VSS VSS VDD VDD _06721_ sky130_fd_sc_hd__nand3_1
X_10051_ network.in_period\[204\]\[2\] net403 _06721_ VSS
+ VSS VDD VDD _06722_ sky130_fd_sc_hd__o21ai_0
X_10052_ _06719_ _06720_ _06722_ VSS VSS VDD VDD _02882_ sky130_fd_sc_hd__a21oi_1
X_10053_ network.neuron_in205.counter\[3\] network.in_period\[205\]\[2\]
+ _00968_ net381 VSS VSS VDD VDD _06723_ sky130_fd_sc_hd__o22ai_1
X_10054_ network.neuron_in205.counter\[2\] _00968_ net403
+ VSS VSS VDD VDD _06724_ sky130_fd_sc_hd__nand3_1
X_10055_ network.in_period\[205\]\[2\] net403 _06724_ VSS
+ VSS VDD VDD _06725_ sky130_fd_sc_hd__o21ai_0
X_10056_ _06701_ _06723_ _06725_ VSS VSS VDD VDD _02886_ sky130_fd_sc_hd__a21oi_1
X_10057_ network.neuron_in206.counter\[2\] VSS VSS VDD VDD
+ _06726_ sky130_fd_sc_hd__inv_1
Xclkbuf_leaf_182_clk clknet_5_22__leaf_clk VSS VSS VDD VDD
+ clknet_leaf_182_clk sky130_fd_sc_hd__clkbuf_16
X_10059_ network.neuron_in206.counter\[3\] network.in_period\[206\]\[2\]
+ _00840_ net369 VSS VSS VDD VDD _06728_ sky130_fd_sc_hd__o22ai_1
Xclkbuf_leaf_181_clk clknet_5_23__leaf_clk VSS VSS VDD VDD
+ clknet_leaf_181_clk sky130_fd_sc_hd__clkbuf_16
X_10061_ network.neuron_in206.counter\[2\] _00840_ net406
+ VSS VSS VDD VDD _06730_ sky130_fd_sc_hd__nand3_1
X_10062_ network.in_period\[206\]\[2\] net406 _06730_ VSS
+ VSS VDD VDD _06731_ sky130_fd_sc_hd__o21ai_0
X_10063_ _06726_ _06728_ _06731_ VSS VSS VDD VDD _02890_ sky130_fd_sc_hd__a21oi_1
X_10064_ network.neuron_in073.counter\[0\] VSS VSS VDD VDD
+ _00200_ sky130_fd_sc_hd__inv_1
X_10065_ network.neuron_in207.counter\[2\] VSS VSS VDD VDD
+ _06732_ sky130_fd_sc_hd__inv_1
X_10066_ network.neuron_in207.counter\[3\] network.in_period\[207\]\[2\]
+ _01173_ net369 VSS VSS VDD VDD _06733_ sky130_fd_sc_hd__o22ai_1
X_10067_ network.neuron_in207.counter\[2\] _01173_ net403
+ VSS VSS VDD VDD _06734_ sky130_fd_sc_hd__nand3_1
X_10068_ network.in_period\[207\]\[2\] net403 _06734_ VSS
+ VSS VDD VDD _06735_ sky130_fd_sc_hd__o21ai_0
X_10069_ _06732_ _06733_ _06735_ VSS VSS VDD VDD _02894_ sky130_fd_sc_hd__a21oi_1
X_10070_ network.neuron_in004.counter\[0\] VSS VSS VDD VDD
+ _00599_ sky130_fd_sc_hd__inv_1
X_10071_ network.neuron_in220.counter\[1\] VSS VSS VDD VDD
+ _00963_ sky130_fd_sc_hd__inv_1
X_10072_ network.neuron_in015.counter\[1\] VSS VSS VDD VDD
+ _00419_ sky130_fd_sc_hd__inv_1
X_10073_ network.neuron_in041.counter\[1\] VSS VSS VDD VDD
+ _00311_ sky130_fd_sc_hd__inv_1
X_10074_ network.neuron_in221.counter\[1\] VSS VSS VDD VDD
+ _00947_ sky130_fd_sc_hd__inv_1
X_10075_ _01161_ _06550_ VSS VSS VDD VDD _06736_ sky130_fd_sc_hd__nand2_1
X_10076_ net406 _06736_ VSS VSS VDD VDD _06737_ sky130_fd_sc_hd__nand2_1
X_10077_ network.in_period\[198\]\[1\] _06737_ VSS VSS VDD
+ VDD _06738_ sky130_fd_sc_hd__nand2_1
X_10078_ _01162_ _06737_ _06738_ VSS VSS VDD VDD _02857_ sky130_fd_sc_hd__o21ai_0
X_10079_ network.neuron_in203.counter\[0\] VSS VSS VDD VDD
+ _01049_ sky130_fd_sc_hd__inv_1
X_10080_ network.neuron_in198.counter\[0\] VSS VSS VDD VDD
+ _01159_ sky130_fd_sc_hd__inv_1
X_10081_ network.in_period\[198\]\[0\] _06737_ VSS VSS VDD
+ VDD _06739_ sky130_fd_sc_hd__nand2_1
X_10082_ network.neuron_in198.counter\[0\] _06737_ _06739_
+ VSS VSS VDD VDD _02856_ sky130_fd_sc_hd__o21ai_0
X_10083_ network.neuron_in199.counter\[2\] network.neuron_in199.counter\[3\]
+ VSS VSS VDD VDD _06740_ sky130_fd_sc_hd__nor2_1
X_10084_ _01139_ _06740_ VSS VSS VDD VDD _06741_ sky130_fd_sc_hd__nand2_1
X_10085_ net406 _06741_ VSS VSS VDD VDD _06742_ sky130_fd_sc_hd__nand2_1
X_10086_ network.in_period\[199\]\[1\] _06742_ VSS VSS VDD
+ VDD _06743_ sky130_fd_sc_hd__nand2_1
X_10087_ _01140_ _06742_ _06743_ VSS VSS VDD VDD _02861_ sky130_fd_sc_hd__o21ai_0
X_10088_ network.neuron_in039.counter\[1\] VSS VSS VDD VDD
+ _00328_ sky130_fd_sc_hd__inv_1
X_10089_ network.neuron_in135.counter\[2\] _00865_ VSS VSS
+ VDD VDD _06744_ sky130_fd_sc_hd__xnor2_1
X_10090_ network.neuron_in135.counter\[3\] network.neuron_in135.counter\[2\]
+ _00865_ VSS VSS VDD VDD _06745_ sky130_fd_sc_hd__or3b_2
X_10091_ net383 _06745_ network.in_period\[135\]\[2\] VSS
+ VSS VDD VDD _06746_ sky130_fd_sc_hd__a21oi_1
X_10092_ net383 _06744_ _06746_ VSS VSS VDD VDD _02606_ sky130_fd_sc_hd__a21oi_1
X_10093_ network.neuron_in199.counter\[0\] VSS VSS VDD VDD
+ _01137_ sky130_fd_sc_hd__inv_1
X_10094_ network.in_period\[199\]\[0\] _06742_ VSS VSS VDD
+ VDD _06747_ sky130_fd_sc_hd__nand2_1
X_10095_ network.neuron_in199.counter\[0\] _06742_ _06747_
+ VSS VSS VDD VDD _02860_ sky130_fd_sc_hd__o21ai_0
X_10096_ network.neuron_in174.counter\[0\] VSS VSS VDD VDD
+ _00658_ sky130_fd_sc_hd__inv_1
X_10097_ network.neuron_in200.counter\[0\] VSS VSS VDD VDD
+ _00525_ sky130_fd_sc_hd__inv_1
X_10098_ network.in_period\[200\]\[0\] _06676_ VSS VSS VDD
+ VDD _06748_ sky130_fd_sc_hd__nand2_1
X_10099_ network.neuron_in200.counter\[0\] _06676_ _06748_
+ VSS VSS VDD VDD _02864_ sky130_fd_sc_hd__o21ai_0
X_10100_ network.neuron_in224.counter\[1\] VSS VSS VDD VDD
+ _01168_ sky130_fd_sc_hd__inv_1
X_10101_ network.neuron_in004.counter\[1\] VSS VSS VDD VDD
+ _00600_ sky130_fd_sc_hd__inv_1
X_10102_ network.neuron_in057.counter\[0\] VSS VSS VDD VDD
+ _00232_ sky130_fd_sc_hd__inv_1
X_10103_ network.neuron_in201.counter\[2\] _00796_ VSS VSS
+ VDD VDD _06749_ sky130_fd_sc_hd__xnor2_1
X_10104_ net403 _06715_ network.in_period\[201\]\[2\] VSS
+ VSS VDD VDD _06750_ sky130_fd_sc_hd__a21oi_1
X_10105_ net403 _06749_ _06750_ VSS VSS VDD VDD _02870_ sky130_fd_sc_hd__a21oi_1
X_10106_ network.neuron_in126.counter\[2\] network.neuron_in126.counter\[3\]
+ VSS VSS VDD VDD _06751_ sky130_fd_sc_hd__nor2_1
X_10107_ _00728_ _06751_ VSS VSS VDD VDD _06752_ sky130_fd_sc_hd__nand2_1
X_10108_ net384 _06752_ VSS VSS VDD VDD _06753_ sky130_fd_sc_hd__nand2_1
X_10109_ network.in_period\[126\]\[0\] _06753_ VSS VSS VDD
+ VDD _06754_ sky130_fd_sc_hd__nand2_1
X_10110_ network.neuron_in126.counter\[0\] _06753_ _06754_
+ VSS VSS VDD VDD _02568_ sky130_fd_sc_hd__o21ai_0
X_10111_ network.neuron_in124.counter\[1\] VSS VSS VDD VDD
+ _00299_ sky130_fd_sc_hd__inv_1
X_10112_ network.neuron_in131.counter\[0\] VSS VSS VDD VDD
+ _00484_ sky130_fd_sc_hd__inv_1
X_10113_ network.neuron_in201.counter\[0\] VSS VSS VDD VDD
+ _00794_ sky130_fd_sc_hd__inv_1
X_10114_ network.in_period\[201\]\[0\] _06716_ VSS VSS VDD
+ VDD _06755_ sky130_fd_sc_hd__nand2_1
X_10115_ network.neuron_in201.counter\[0\] _06716_ _06755_
+ VSS VSS VDD VDD _02868_ sky130_fd_sc_hd__o21ai_0
X_10116_ network.neuron_in202.counter\[2\] net406 VSS VSS
+ VDD VDD _06756_ sky130_fd_sc_hd__nand2_1
X_10117_ network.neuron_in202.counter\[3\] network.in_period\[202\]\[2\]
+ _06756_ VSS VSS VDD VDD _06757_ sky130_fd_sc_hd__o21ai_0
X_10118_ _01081_ network.neuron_in202.counter\[2\] net368
+ VSS VSS VDD VDD _06758_ sky130_fd_sc_hd__or3_1
X_10119_ network.in_period\[202\]\[2\] net406 _06758_ VSS
+ VSS VDD VDD _06759_ sky130_fd_sc_hd__o21ai_0
X_10120_ _01081_ _06757_ _06759_ VSS VSS VDD VDD _02874_ sky130_fd_sc_hd__a21oi_1
X_10121_ network.neuron_in203.counter\[3\] _01051_ VSS VSS
+ VDD VDD _06760_ sky130_fd_sc_hd__nand2b_1
X_10122_ _06760_ _06659_ VSS VSS VDD VDD _06761_ sky130_fd_sc_hd__nand2b_1
X_10123_ net403 _06761_ VSS VSS VDD VDD _06762_ sky130_fd_sc_hd__nand2_1
X_10124_ network.in_period\[203\]\[1\] _06762_ VSS VSS VDD
+ VDD _06763_ sky130_fd_sc_hd__nand2_1
X_10125_ _01052_ _06762_ _06763_ VSS VSS VDD VDD _02877_ sky130_fd_sc_hd__o21ai_0
X_10126_ network.in_period\[203\]\[0\] _06762_ VSS VSS VDD
+ VDD _06764_ sky130_fd_sc_hd__nand2_1
X_10127_ network.neuron_in203.counter\[0\] _06762_ _06764_
+ VSS VSS VDD VDD _02876_ sky130_fd_sc_hd__o21ai_0
X_10128_ network.neuron_in204.counter\[3\] _00214_ VSS VSS
+ VDD VDD _06765_ sky130_fd_sc_hd__nand2b_1
X_10129_ _06765_ _06719_ VSS VSS VDD VDD _06766_ sky130_fd_sc_hd__nand2b_1
X_10130_ net403 _06766_ VSS VSS VDD VDD _06767_ sky130_fd_sc_hd__nand2_1
X_10131_ network.in_period\[204\]\[1\] _06767_ VSS VSS VDD
+ VDD _06768_ sky130_fd_sc_hd__nand2_1
X_10132_ _00215_ _06767_ _06768_ VSS VSS VDD VDD _02881_ sky130_fd_sc_hd__o21ai_0
X_10133_ network.neuron_in204.counter\[0\] VSS VSS VDD VDD
+ _00212_ sky130_fd_sc_hd__inv_1
X_10134_ network.in_period\[204\]\[0\] _06767_ VSS VSS VDD
+ VDD _06769_ sky130_fd_sc_hd__nand2_1
X_10135_ network.neuron_in204.counter\[0\] _06767_ _06769_
+ VSS VSS VDD VDD _02880_ sky130_fd_sc_hd__o21ai_0
X_10136_ network.neuron_in205.counter\[0\] VSS VSS VDD VDD
+ _00966_ sky130_fd_sc_hd__inv_1
X_10137_ network.in_period\[205\]\[0\] _06703_ VSS VSS VDD
+ VDD _06770_ sky130_fd_sc_hd__nand2_1
X_10138_ network.neuron_in205.counter\[0\] _06703_ _06770_
+ VSS VSS VDD VDD _02884_ sky130_fd_sc_hd__o21ai_0
X_10139_ network.neuron_in206.counter\[2\] network.neuron_in206.counter\[3\]
+ VSS VSS VDD VDD _06771_ sky130_fd_sc_hd__nor2_1
X_10140_ _00840_ _06771_ VSS VSS VDD VDD _06772_ sky130_fd_sc_hd__nand2_1
X_10141_ net406 _06772_ VSS VSS VDD VDD _06773_ sky130_fd_sc_hd__nand2_1
X_10142_ network.in_period\[206\]\[1\] _06773_ VSS VSS VDD
+ VDD _06774_ sky130_fd_sc_hd__nand2_1
X_10143_ _00841_ _06773_ _06774_ VSS VSS VDD VDD _02889_ sky130_fd_sc_hd__o21ai_0
X_10144_ network.neuron_in206.counter\[0\] VSS VSS VDD VDD
+ _00838_ sky130_fd_sc_hd__inv_1
X_10145_ network.in_period\[206\]\[0\] _06773_ VSS VSS VDD
+ VDD _06775_ sky130_fd_sc_hd__nand2_1
X_10146_ network.neuron_in206.counter\[0\] _06773_ _06775_
+ VSS VSS VDD VDD _02888_ sky130_fd_sc_hd__o21ai_0
X_10147_ network.neuron_in110.counter\[1\] VSS VSS VDD VDD
+ _00079_ sky130_fd_sc_hd__inv_1
X_10148_ network.neuron_in198.counter\[1\] VSS VSS VDD VDD
+ _01160_ sky130_fd_sc_hd__inv_1
X_10149_ network.neuron_in003.counter\[0\] VSS VSS VDD VDD
+ _00603_ sky130_fd_sc_hd__inv_1
X_10150_ network.neuron_in218.counter\[2\] _01185_ VSS VSS
+ VDD VDD _06776_ sky130_fd_sc_hd__xnor2_1
X_10151_ network.neuron_in218.counter\[2\] network.neuron_in218.counter\[3\]
+ VSS VSS VDD VDD _06777_ sky130_fd_sc_hd__nor2_1
X_10152_ _01185_ _06777_ VSS VSS VDD VDD _06778_ sky130_fd_sc_hd__nand2_1
X_10153_ net406 _06778_ network.in_period\[218\]\[2\] VSS
+ VSS VDD VDD _06779_ sky130_fd_sc_hd__a21oi_1
X_10154_ net406 _06776_ _06779_ VSS VSS VDD VDD _02938_ sky130_fd_sc_hd__a21oi_1
X_10155_ network.neuron_in213.counter\[2\] _00292_ VSS VSS
+ VDD VDD _06780_ sky130_fd_sc_hd__xnor2_1
X_10156_ network.neuron_in213.counter\[2\] network.neuron_in213.counter\[3\]
+ VSS VSS VDD VDD _06781_ sky130_fd_sc_hd__nor2_1
X_10157_ _00292_ _06781_ VSS VSS VDD VDD _06782_ sky130_fd_sc_hd__nand2_1
X_10158_ net405 _06782_ network.in_period\[213\]\[2\] VSS
+ VSS VDD VDD _06783_ sky130_fd_sc_hd__a21oi_1
X_10159_ net405 _06780_ _06783_ VSS VSS VDD VDD _02918_ sky130_fd_sc_hd__a21oi_1
X_10160_ network.neuron_in038.counter\[1\] VSS VSS VDD VDD
+ _00332_ sky130_fd_sc_hd__inv_1
X_10161_ network.neuron_in217.counter\[0\] VSS VSS VDD VDD
+ _00950_ sky130_fd_sc_hd__inv_1
X_10162_ network.neuron_in217.counter\[2\] network.neuron_in217.counter\[3\]
+ VSS VSS VDD VDD _06784_ sky130_fd_sc_hd__nor2_1
X_10163_ _00952_ _06784_ VSS VSS VDD VDD _06785_ sky130_fd_sc_hd__nand2_1
X_10164_ net400 _06785_ VSS VSS VDD VDD _06786_ sky130_fd_sc_hd__nand2_1
X_10165_ network.in_period\[217\]\[0\] _06786_ VSS VSS VDD
+ VDD _06787_ sky130_fd_sc_hd__nand2_1
X_10166_ network.neuron_in217.counter\[0\] _06786_ _06787_
+ VSS VSS VDD VDD _02932_ sky130_fd_sc_hd__o21ai_0
X_10167_ network.neuron_in067.counter\[0\] VSS VSS VDD VDD
+ _00155_ sky130_fd_sc_hd__inv_1
X_10168_ network.neuron_in249.counter\[0\] VSS VSS VDD VDD
+ _00402_ sky130_fd_sc_hd__inv_1
Xclkbuf_leaf_180_clk clknet_5_23__leaf_clk VSS VSS VDD VDD
+ clknet_leaf_180_clk sky130_fd_sc_hd__clkbuf_16
X_10170_ network.neuron_in210.counter\[2\] network.neuron_in210.counter\[3\]
+ VSS VSS VDD VDD _06789_ sky130_fd_sc_hd__nor2_1
X_10171_ _00960_ _06789_ VSS VSS VDD VDD _06790_ sky130_fd_sc_hd__nand2_1
X_10172_ net405 _06790_ VSS VSS VDD VDD _06791_ sky130_fd_sc_hd__nand2_1
X_10173_ network.in_period\[210\]\[1\] _06791_ VSS VSS VDD
+ VDD _06792_ sky130_fd_sc_hd__nand2_1
X_10174_ _00961_ _06791_ _06792_ VSS VSS VDD VDD _02905_ sky130_fd_sc_hd__o21ai_0
X_10175_ network.neuron_in212.counter\[0\] VSS VSS VDD VDD
+ _00751_ sky130_fd_sc_hd__inv_1
X_10176_ network.neuron_in212.counter\[2\] network.neuron_in212.counter\[3\]
+ VSS VSS VDD VDD _06793_ sky130_fd_sc_hd__nor2_1
X_10177_ _00753_ _06793_ VSS VSS VDD VDD _06794_ sky130_fd_sc_hd__nand2_1
X_10178_ net405 _06794_ VSS VSS VDD VDD _06795_ sky130_fd_sc_hd__nand2_1
X_10179_ network.in_period\[212\]\[0\] _06795_ VSS VSS VDD
+ VDD _06796_ sky130_fd_sc_hd__nand2_1
X_10180_ network.neuron_in212.counter\[0\] _06795_ _06796_
+ VSS VSS VDD VDD _02912_ sky130_fd_sc_hd__o21ai_0
Xclkbuf_leaf_179_clk clknet_5_23__leaf_clk VSS VSS VDD VDD
+ clknet_leaf_179_clk sky130_fd_sc_hd__clkbuf_16
X_10182_ network.neuron_in215.counter\[2\] _00869_ VSS VSS
+ VDD VDD _06798_ sky130_fd_sc_hd__xnor2_1
X_10183_ network.neuron_in215.counter\[2\] network.neuron_in215.counter\[3\]
+ VSS VSS VDD VDD _06799_ sky130_fd_sc_hd__nor2_1
X_10184_ _00869_ _06799_ VSS VSS VDD VDD _06800_ sky130_fd_sc_hd__nand2_1
X_10185_ net406 _06800_ network.in_period\[215\]\[2\] VSS
+ VSS VDD VDD _06801_ sky130_fd_sc_hd__a21oi_1
X_10186_ net406 _06798_ _06801_ VSS VSS VDD VDD _02926_ sky130_fd_sc_hd__a21oi_1
X_10187_ network.neuron_in226.counter\[1\] VSS VSS VDD VDD
+ _00783_ sky130_fd_sc_hd__inv_1
X_10188_ network.in_period\[217\]\[1\] _06786_ VSS VSS VDD
+ VDD _06802_ sky130_fd_sc_hd__nand2_1
X_10189_ _00953_ _06786_ _06802_ VSS VSS VDD VDD _02933_ sky130_fd_sc_hd__o21ai_0
X_10190_ network.neuron_in209.counter\[2\] VSS VSS VDD VDD
+ _06803_ sky130_fd_sc_hd__inv_1
X_10191_ network.neuron_in209.counter\[3\] network.in_period\[209\]\[2\]
+ _00284_ net368 VSS VSS VDD VDD _06804_ sky130_fd_sc_hd__o22ai_1
X_10192_ network.neuron_in209.counter\[2\] _00284_ net405
+ VSS VSS VDD VDD _06805_ sky130_fd_sc_hd__nand3_1
X_10193_ network.in_period\[209\]\[2\] net405 _06805_ VSS
+ VSS VDD VDD _06806_ sky130_fd_sc_hd__o21ai_0
X_10194_ _06803_ _06804_ _06806_ VSS VSS VDD VDD _02902_ sky130_fd_sc_hd__a21oi_1
X_10195_ network.neuron_in210.counter\[2\] _00960_ VSS VSS
+ VDD VDD _06807_ sky130_fd_sc_hd__xnor2_1
X_10196_ net405 _06790_ network.in_period\[210\]\[2\] VSS
+ VSS VDD VDD _06808_ sky130_fd_sc_hd__a21oi_1
X_10197_ net405 _06807_ _06808_ VSS VSS VDD VDD _02906_ sky130_fd_sc_hd__a21oi_1
X_10198_ network.neuron_in094.counter\[0\] VSS VSS VDD VDD
+ _01240_ sky130_fd_sc_hd__inv_1
X_10199_ network.neuron_in083.counter\[1\] VSS VSS VDD VDD
+ _00059_ sky130_fd_sc_hd__inv_1
X_10200_ network.neuron_in211.counter\[3\] _00280_ VSS VSS
+ VDD VDD _06809_ sky130_fd_sc_hd__nand2b_1
X_10201_ network.neuron_in211.counter\[2\] VSS VSS VDD VDD
+ _06810_ sky130_fd_sc_hd__inv_1
X_10202_ _06809_ _06810_ VSS VSS VDD VDD _06811_ sky130_fd_sc_hd__nand2b_1
X_10203_ net405 _06811_ VSS VSS VDD VDD _06812_ sky130_fd_sc_hd__nand2_1
X_10204_ network.in_period\[211\]\[1\] _06812_ VSS VSS VDD
+ VDD _06813_ sky130_fd_sc_hd__nand2_1
X_10205_ _00281_ _06812_ _06813_ VSS VSS VDD VDD _02909_ sky130_fd_sc_hd__o21ai_0
X_10206_ net380 _06412_ VSS VSS VDD VDD _06814_ sky130_fd_sc_hd__nor2_1
X_10207_ network.neuron_in155.counter\[2\] _01205_ VSS VSS
+ VDD VDD _06815_ sky130_fd_sc_hd__xnor2_1
X_10208_ network.in_period\[155\]\[2\] _06814_ _06815_ net394
+ VSS VSS VDD VDD _02686_ sky130_fd_sc_hd__a2bb2oi_1
X_10209_ network.neuron_in172.counter\[1\] VSS VSS VDD VDD
+ _01034_ sky130_fd_sc_hd__inv_1
X_10210_ network.in_period\[212\]\[1\] _06795_ VSS VSS VDD
+ VDD _06816_ sky130_fd_sc_hd__nand2_1
X_10211_ _00754_ _06795_ _06816_ VSS VSS VDD VDD _02913_ sky130_fd_sc_hd__o21ai_0
X_10212_ network.neuron_in079.counter\[1\] VSS VSS VDD VDD
+ _00090_ sky130_fd_sc_hd__inv_1
X_10213_ network.neuron_in134.counter\[1\] VSS VSS VDD VDD
+ _01120_ sky130_fd_sc_hd__inv_1
X_10214_ network.neuron_in214.counter\[2\] _01004_ VSS VSS
+ VDD VDD _06817_ sky130_fd_sc_hd__xnor2_1
X_10215_ network.neuron_in214.counter\[2\] network.neuron_in214.counter\[3\]
+ VSS VSS VDD VDD _06818_ sky130_fd_sc_hd__nor2_1
X_10216_ _01004_ _06818_ VSS VSS VDD VDD _06819_ sky130_fd_sc_hd__nand2_1
X_10217_ net406 _06819_ network.in_period\[214\]\[2\] VSS
+ VSS VDD VDD _06820_ sky130_fd_sc_hd__a21oi_1
X_10218_ net406 _06817_ _06820_ VSS VSS VDD VDD _02922_ sky130_fd_sc_hd__a21oi_1
X_10219_ network.neuron_in085.counter\[1\] VSS VSS VDD VDD
+ _00051_ sky130_fd_sc_hd__inv_1
X_10220_ network.neuron_in134.counter\[2\] _01121_ VSS VSS
+ VDD VDD _06821_ sky130_fd_sc_hd__nor2b_1
X_10221_ _01121_ network.neuron_in134.counter\[2\] VSS VSS
+ VDD VDD _06822_ sky130_fd_sc_hd__nor2b_1
X_10222_ network.neuron_in134.counter\[2\] network.neuron_in134.counter\[3\]
+ VSS VSS VDD VDD _06823_ sky130_fd_sc_hd__nor2_1
X_10223_ _06361_ _06823_ VSS VSS VDD VDD _06824_ sky130_fd_sc_hd__nor2_1
X_10224_ _06361_ _06821_ _06822_ _06824_ network.in_period\[134\]\[2\]
+ VSS VSS VDD VDD _02602_ sky130_fd_sc_hd__o32a_1
X_10225_ _01121_ _06823_ VSS VSS VDD VDD _06825_ sky130_fd_sc_hd__nand2_1
X_10226_ net384 _06825_ VSS VSS VDD VDD _06826_ sky130_fd_sc_hd__nand2_1
X_10227_ network.in_period\[134\]\[1\] _06826_ VSS VSS VDD
+ VDD _06827_ sky130_fd_sc_hd__nand2_1
X_10228_ _01122_ _06826_ _06827_ VSS VSS VDD VDD _02601_ sky130_fd_sc_hd__o21ai_0
X_10229_ network.neuron_in214.counter\[0\] VSS VSS VDD VDD
+ _01002_ sky130_fd_sc_hd__inv_1
X_10230_ net406 _06819_ VSS VSS VDD VDD _06828_ sky130_fd_sc_hd__nand2_1
X_10231_ network.in_period\[214\]\[0\] _06828_ VSS VSS VDD
+ VDD _06829_ sky130_fd_sc_hd__nand2_1
X_10232_ network.neuron_in214.counter\[0\] _06828_ _06829_
+ VSS VSS VDD VDD _02920_ sky130_fd_sc_hd__o21ai_0
Xclkbuf_leaf_178_clk clknet_5_23__leaf_clk VSS VSS VDD VDD
+ clknet_leaf_178_clk sky130_fd_sc_hd__clkbuf_16
X_10234_ network.neuron_in216.counter\[2\] net405 VSS VSS
+ VDD VDD _06831_ sky130_fd_sc_hd__nand2_1
X_10235_ network.neuron_in216.counter\[3\] network.in_period\[216\]\[2\]
+ _06831_ VSS VSS VDD VDD _06832_ sky130_fd_sc_hd__o21ai_0
Xclkbuf_leaf_177_clk clknet_5_23__leaf_clk VSS VSS VDD VDD
+ clknet_leaf_177_clk sky130_fd_sc_hd__clkbuf_16
X_10237_ _00304_ network.neuron_in216.counter\[2\] net368
+ VSS VSS VDD VDD _06834_ sky130_fd_sc_hd__or3_1
X_10238_ network.in_period\[216\]\[2\] net405 _06834_ VSS
+ VSS VDD VDD _06835_ sky130_fd_sc_hd__o21ai_0
X_10239_ _00304_ _06832_ _06835_ VSS VSS VDD VDD _02930_ sky130_fd_sc_hd__a21oi_1
X_10240_ network.neuron_in118.counter\[0\] VSS VSS VDD VDD
+ _00082_ sky130_fd_sc_hd__inv_1
X_10241_ network.neuron_in150.counter\[0\] VSS VSS VDD VDD
+ _00492_ sky130_fd_sc_hd__inv_1
X_10242_ network.neuron_in217.counter\[2\] _00952_ VSS VSS
+ VDD VDD _06836_ sky130_fd_sc_hd__xnor2_1
X_10243_ net400 _06785_ network.in_period\[217\]\[2\] VSS
+ VSS VDD VDD _06837_ sky130_fd_sc_hd__a21oi_1
X_10244_ net400 _06836_ _06837_ VSS VSS VDD VDD _02934_ sky130_fd_sc_hd__a21oi_1
X_10245_ network.neuron_in208.counter\[3\] _06653_ net403
+ VSS VSS VDD VDD _06838_ sky130_fd_sc_hd__o21ai_0
X_10246_ network.in_period\[208\]\[1\] _06838_ VSS VSS VDD
+ VDD _06839_ sky130_fd_sc_hd__nand2_1
X_10247_ _00642_ _06838_ _06839_ VSS VSS VDD VDD _02897_ sky130_fd_sc_hd__o21ai_0
X_10248_ network.neuron_in208.counter\[0\] VSS VSS VDD VDD
+ _00639_ sky130_fd_sc_hd__inv_1
X_10249_ network.in_period\[208\]\[0\] _06838_ VSS VSS VDD
+ VDD _06840_ sky130_fd_sc_hd__nand2_1
X_10250_ network.neuron_in208.counter\[0\] _06838_ _06840_
+ VSS VSS VDD VDD _02896_ sky130_fd_sc_hd__o21ai_0
X_10251_ network.neuron_in068.counter\[0\] VSS VSS VDD VDD
+ _00149_ sky130_fd_sc_hd__inv_1
Xclkbuf_leaf_176_clk clknet_5_23__leaf_clk VSS VSS VDD VDD
+ clknet_leaf_176_clk sky130_fd_sc_hd__clkbuf_16
X_10253_ network.neuron_in209.counter\[3\] _00284_ VSS VSS
+ VDD VDD _06842_ sky130_fd_sc_hd__nand2b_1
X_10254_ _06842_ _06803_ VSS VSS VDD VDD _06843_ sky130_fd_sc_hd__nand2b_1
X_10255_ net405 _06843_ VSS VSS VDD VDD _06844_ sky130_fd_sc_hd__nand2_1
X_10256_ network.in_period\[209\]\[1\] _06844_ VSS VSS VDD
+ VDD _06845_ sky130_fd_sc_hd__nand2_1
X_10257_ _00285_ _06844_ _06845_ VSS VSS VDD VDD _02901_ sky130_fd_sc_hd__o21ai_0
X_10258_ network.neuron_in209.counter\[0\] VSS VSS VDD VDD
+ _00282_ sky130_fd_sc_hd__inv_1
X_10259_ network.in_period\[209\]\[0\] _06844_ VSS VSS VDD
+ VDD _06846_ sky130_fd_sc_hd__nand2_1
X_10260_ network.neuron_in209.counter\[0\] _06844_ _06846_
+ VSS VSS VDD VDD _02900_ sky130_fd_sc_hd__o21ai_0
X_10261_ network.neuron_in210.counter\[0\] VSS VSS VDD VDD
+ _00958_ sky130_fd_sc_hd__inv_1
X_10262_ network.in_period\[210\]\[0\] _06791_ VSS VSS VDD
+ VDD _06847_ sky130_fd_sc_hd__nand2_1
X_10263_ network.neuron_in210.counter\[0\] _06791_ _06847_
+ VSS VSS VDD VDD _02904_ sky130_fd_sc_hd__o21ai_0
X_10264_ network.neuron_in211.counter\[3\] network.in_period\[211\]\[2\]
+ _00280_ net368 VSS VSS VDD VDD _06848_ sky130_fd_sc_hd__o22ai_1
X_10265_ network.neuron_in211.counter\[2\] _00280_ net405
+ VSS VSS VDD VDD _06849_ sky130_fd_sc_hd__nand3_1
X_10266_ network.in_period\[211\]\[2\] net405 _06849_ VSS
+ VSS VDD VDD _06850_ sky130_fd_sc_hd__o21ai_0
X_10267_ _06810_ _06848_ _06850_ VSS VSS VDD VDD _02910_ sky130_fd_sc_hd__a21oi_1
X_10268_ network.neuron_in211.counter\[0\] VSS VSS VDD VDD
+ _00278_ sky130_fd_sc_hd__inv_1
X_10269_ network.in_period\[211\]\[0\] _06812_ VSS VSS VDD
+ VDD _06851_ sky130_fd_sc_hd__nand2_1
X_10270_ network.neuron_in211.counter\[0\] _06812_ _06851_
+ VSS VSS VDD VDD _02908_ sky130_fd_sc_hd__o21ai_0
X_10271_ network.neuron_in212.counter\[2\] _00753_ VSS VSS
+ VDD VDD _06852_ sky130_fd_sc_hd__xnor2_1
X_10272_ net405 _06794_ network.in_period\[212\]\[2\] VSS
+ VSS VDD VDD _06853_ sky130_fd_sc_hd__a21oi_1
X_10273_ net405 _06852_ _06853_ VSS VSS VDD VDD _02914_ sky130_fd_sc_hd__a21oi_1
X_10274_ net405 _06782_ VSS VSS VDD VDD _06854_ sky130_fd_sc_hd__nand2_1
X_10275_ network.in_period\[213\]\[1\] _06854_ VSS VSS VDD
+ VDD _06855_ sky130_fd_sc_hd__nand2_1
X_10276_ _00293_ _06854_ _06855_ VSS VSS VDD VDD _02917_ sky130_fd_sc_hd__o21ai_0
X_10277_ network.neuron_in213.counter\[0\] VSS VSS VDD VDD
+ _00290_ sky130_fd_sc_hd__inv_1
X_10278_ network.in_period\[213\]\[0\] _06854_ VSS VSS VDD
+ VDD _06856_ sky130_fd_sc_hd__nand2_1
X_10279_ network.neuron_in213.counter\[0\] _06854_ _06856_
+ VSS VSS VDD VDD _02916_ sky130_fd_sc_hd__o21ai_0
X_10280_ network.in_period\[214\]\[1\] _06828_ VSS VSS VDD
+ VDD _06857_ sky130_fd_sc_hd__nand2_1
X_10281_ _01005_ _06828_ _06857_ VSS VSS VDD VDD _02921_ sky130_fd_sc_hd__o21ai_0
X_10282_ net406 _06800_ VSS VSS VDD VDD _06858_ sky130_fd_sc_hd__nand2_1
X_10283_ network.in_period\[215\]\[1\] _06858_ VSS VSS VDD
+ VDD _06859_ sky130_fd_sc_hd__nand2_1
X_10284_ _00870_ _06858_ _06859_ VSS VSS VDD VDD _02925_ sky130_fd_sc_hd__o21ai_0
X_10285_ network.neuron_in215.counter\[0\] VSS VSS VDD VDD
+ _00867_ sky130_fd_sc_hd__inv_1
X_10286_ network.in_period\[215\]\[0\] _06858_ VSS VSS VDD
+ VDD _06860_ sky130_fd_sc_hd__nand2_1
X_10287_ network.neuron_in215.counter\[0\] _06858_ _06860_
+ VSS VSS VDD VDD _02924_ sky130_fd_sc_hd__o21ai_0
X_10288_ network.neuron_in216.counter\[2\] _00304_ VSS VSS
+ VDD VDD _06861_ sky130_fd_sc_hd__nor2b_1
X_10289_ network.neuron_in216.counter\[3\] _06861_ VSS VSS
+ VDD VDD _06862_ sky130_fd_sc_hd__nand2b_1
X_10290_ net405 _06862_ VSS VSS VDD VDD _06863_ sky130_fd_sc_hd__nand2_1
X_10291_ network.in_period\[216\]\[1\] _06863_ VSS VSS VDD
+ VDD _06864_ sky130_fd_sc_hd__nand2_1
X_10292_ _00305_ _06863_ _06864_ VSS VSS VDD VDD _02929_ sky130_fd_sc_hd__o21ai_0
X_10293_ network.in_period\[216\]\[0\] _06863_ VSS VSS VDD
+ VDD _06865_ sky130_fd_sc_hd__nand2_1
X_10294_ network.neuron_in216.counter\[0\] _06863_ _06865_
+ VSS VSS VDD VDD _02928_ sky130_fd_sc_hd__o21ai_0
X_10295_ network.neuron_in047.counter\[0\] VSS VSS VDD VDD
+ _00266_ sky130_fd_sc_hd__inv_1
X_10296_ network.neuron_in228.counter\[2\] VSS VSS VDD VDD
+ _06866_ sky130_fd_sc_hd__inv_1
X_10297_ network.neuron_in228.counter\[3\] network.in_period\[228\]\[2\]
+ _00808_ net375 VSS VSS VDD VDD _06867_ sky130_fd_sc_hd__o22ai_1
X_10298_ network.neuron_in228.counter\[2\] _00808_ net392
+ VSS VSS VDD VDD _06868_ sky130_fd_sc_hd__nand3_1
X_10299_ network.in_period\[228\]\[2\] net392 _06868_ VSS
+ VSS VDD VDD _06869_ sky130_fd_sc_hd__o21ai_0
X_10300_ _06866_ _06867_ _06869_ VSS VSS VDD VDD _02978_ sky130_fd_sc_hd__a21oi_1
X_10301_ network.neuron_in223.counter\[2\] VSS VSS VDD VDD
+ _06870_ sky130_fd_sc_hd__inv_1
X_10302_ network.neuron_in223.counter\[3\] network.in_period\[223\]\[2\]
+ _00900_ net381 VSS VSS VDD VDD _06871_ sky130_fd_sc_hd__o22ai_1
Xclkbuf_leaf_175_clk clknet_5_29__leaf_clk VSS VSS VDD VDD
+ clknet_leaf_175_clk sky130_fd_sc_hd__clkbuf_16
X_10304_ network.neuron_in223.counter\[2\] _00900_ net400
+ VSS VSS VDD VDD _06873_ sky130_fd_sc_hd__nand3_1
X_10305_ network.in_period\[223\]\[2\] net400 _06873_ VSS
+ VSS VDD VDD _06874_ sky130_fd_sc_hd__o21ai_0
X_10306_ _06870_ _06871_ _06874_ VSS VSS VDD VDD _02958_ sky130_fd_sc_hd__a21oi_1
X_10307_ network.neuron_in227.counter\[0\] VSS VSS VDD VDD
+ _01187_ sky130_fd_sc_hd__inv_1
X_10308_ network.neuron_in227.counter\[3\] _01189_ VSS VSS
+ VDD VDD _06875_ sky130_fd_sc_hd__nand2b_1
X_10309_ network.neuron_in227.counter\[2\] _06875_ VSS VSS
+ VDD VDD _06876_ sky130_fd_sc_hd__or2_2
X_10310_ net385 _06876_ VSS VSS VDD VDD _06877_ sky130_fd_sc_hd__nand2_1
X_10311_ network.in_period\[227\]\[0\] _06877_ VSS VSS VDD
+ VDD _06878_ sky130_fd_sc_hd__nand2_1
X_10312_ network.neuron_in227.counter\[0\] _06877_ _06878_
+ VSS VSS VDD VDD _02972_ sky130_fd_sc_hd__o21ai_0
X_10313_ network.neuron_in231.counter\[1\] VSS VSS VDD VDD
+ _00663_ sky130_fd_sc_hd__inv_1
X_10314_ network.neuron_in220.counter\[3\] _00964_ VSS VSS
+ VDD VDD _06879_ sky130_fd_sc_hd__nand2b_1
X_10315_ network.neuron_in220.counter\[2\] VSS VSS VDD VDD
+ _06880_ sky130_fd_sc_hd__inv_1
X_10316_ _06879_ _06880_ VSS VSS VDD VDD _06881_ sky130_fd_sc_hd__nand2b_1
X_10317_ net397 _06881_ VSS VSS VDD VDD _06882_ sky130_fd_sc_hd__nand2_1
X_10318_ network.in_period\[220\]\[1\] _06882_ VSS VSS VDD
+ VDD _06883_ sky130_fd_sc_hd__nand2_1
X_10319_ _00965_ _06882_ _06883_ VSS VSS VDD VDD _02945_ sky130_fd_sc_hd__o21ai_0
X_10320_ network.neuron_in222.counter\[0\] VSS VSS VDD VDD
+ _00894_ sky130_fd_sc_hd__inv_1
X_10321_ network.neuron_in222.counter\[2\] _00896_ VSS VSS
+ VDD VDD _06884_ sky130_fd_sc_hd__nor2b_1
X_10322_ network.neuron_in222.counter\[3\] _06884_ VSS VSS
+ VDD VDD _06885_ sky130_fd_sc_hd__nand2b_1
X_10323_ net400 _06885_ VSS VSS VDD VDD _06886_ sky130_fd_sc_hd__nand2_1
X_10324_ network.in_period\[222\]\[0\] _06886_ VSS VSS VDD
+ VDD _06887_ sky130_fd_sc_hd__nand2_1
X_10325_ network.neuron_in222.counter\[0\] _06886_ _06887_
+ VSS VSS VDD VDD _02952_ sky130_fd_sc_hd__o21ai_0
X_10326_ network.neuron_in003.counter\[1\] VSS VSS VDD VDD
+ _00604_ sky130_fd_sc_hd__inv_1
X_10327_ network.neuron_in232.counter\[1\] VSS VSS VDD VDD
+ _00939_ sky130_fd_sc_hd__inv_1
X_10328_ network.neuron_in225.counter\[2\] VSS VSS VDD VDD
+ _06888_ sky130_fd_sc_hd__inv_1
X_10329_ network.neuron_in225.counter\[3\] network.in_period\[225\]\[2\]
+ _00341_ net375 VSS VSS VDD VDD _06889_ sky130_fd_sc_hd__o22ai_1
X_10330_ network.neuron_in225.counter\[2\] _00341_ net386
+ VSS VSS VDD VDD _06890_ sky130_fd_sc_hd__nand3_1
X_10331_ network.in_period\[225\]\[2\] net386 _06890_ VSS
+ VSS VDD VDD _06891_ sky130_fd_sc_hd__o21ai_0
X_10332_ _06888_ _06889_ _06891_ VSS VSS VDD VDD _02966_ sky130_fd_sc_hd__a21oi_1
X_10333_ network.in_period\[227\]\[1\] _06877_ VSS VSS VDD
+ VDD _06892_ sky130_fd_sc_hd__nand2_1
X_10334_ _01190_ _06877_ _06892_ VSS VSS VDD VDD _02973_ sky130_fd_sc_hd__o21ai_0
X_10335_ network.neuron_in177.counter\[0\] VSS VSS VDD VDD
+ _00810_ sky130_fd_sc_hd__inv_1
X_10336_ network.neuron_in177.counter\[3\] _00812_ VSS VSS
+ VDD VDD _06893_ sky130_fd_sc_hd__nand2b_1
X_10337_ network.neuron_in177.counter\[2\] _06893_ VSS VSS
+ VDD VDD _06894_ sky130_fd_sc_hd__or2_2
X_10338_ net384 _06894_ VSS VSS VDD VDD _06895_ sky130_fd_sc_hd__nand2_1
X_10339_ network.in_period\[177\]\[0\] _06895_ VSS VSS VDD
+ VDD _06896_ sky130_fd_sc_hd__nand2_1
X_10340_ network.neuron_in177.counter\[0\] _06895_ _06896_
+ VSS VSS VDD VDD _02772_ sky130_fd_sc_hd__o21ai_0
X_10341_ network.neuron_in172.counter\[0\] VSS VSS VDD VDD
+ _01033_ sky130_fd_sc_hd__inv_1
X_10342_ network.neuron_in199.counter\[1\] VSS VSS VDD VDD
+ _01138_ sky130_fd_sc_hd__inv_1
X_10343_ network.neuron_in219.counter\[2\] VSS VSS VDD VDD
+ _06897_ sky130_fd_sc_hd__inv_1
X_10344_ network.neuron_in219.counter\[3\] network.in_period\[219\]\[2\]
+ _01000_ net381 VSS VSS VDD VDD _06898_ sky130_fd_sc_hd__o22ai_1
X_10345_ network.neuron_in219.counter\[2\] _01000_ net399
+ VSS VSS VDD VDD _06899_ sky130_fd_sc_hd__nand3_1
X_10346_ network.in_period\[219\]\[2\] net399 _06899_ VSS
+ VSS VDD VDD _06900_ sky130_fd_sc_hd__o21ai_0
X_10347_ _06897_ _06898_ _06900_ VSS VSS VDD VDD _02942_ sky130_fd_sc_hd__a21oi_1
X_10348_ network.neuron_in220.counter\[3\] network.in_period\[220\]\[2\]
+ _00964_ net381 VSS VSS VDD VDD _06901_ sky130_fd_sc_hd__o22ai_1
Xclkbuf_leaf_174_clk clknet_5_29__leaf_clk VSS VSS VDD VDD
+ clknet_leaf_174_clk sky130_fd_sc_hd__clkbuf_16
X_10350_ network.neuron_in220.counter\[2\] _00964_ net397
+ VSS VSS VDD VDD _06903_ sky130_fd_sc_hd__nand3_1
X_10351_ network.in_period\[220\]\[2\] net397 _06903_ VSS
+ VSS VDD VDD _06904_ sky130_fd_sc_hd__o21ai_0
X_10352_ _06880_ _06901_ _06904_ VSS VSS VDD VDD _02946_ sky130_fd_sc_hd__a21oi_1
X_10353_ network.neuron_in221.counter\[2\] network.neuron_in221.counter\[3\]
+ VSS VSS VDD VDD _06905_ sky130_fd_sc_hd__nor2_1
X_10354_ _00948_ _06905_ VSS VSS VDD VDD _06906_ sky130_fd_sc_hd__nand2_1
X_10355_ net400 _06906_ VSS VSS VDD VDD _06907_ sky130_fd_sc_hd__nand2_1
X_10356_ network.in_period\[221\]\[1\] _06907_ VSS VSS VDD
+ VDD _06908_ sky130_fd_sc_hd__nand2_1
X_10357_ _00949_ _06907_ _06908_ VSS VSS VDD VDD _02949_ sky130_fd_sc_hd__o21ai_0
X_10358_ network.in_period\[222\]\[1\] _06886_ VSS VSS VDD
+ VDD _06909_ sky130_fd_sc_hd__nand2_1
X_10359_ _00897_ _06886_ _06909_ VSS VSS VDD VDD _02953_ sky130_fd_sc_hd__o21ai_0
X_10360_ network.in_period\[157\]\[1\] _06513_ VSS VSS VDD
+ VDD _06910_ sky130_fd_sc_hd__nand2_1
X_10361_ _00689_ _06513_ _06910_ VSS VSS VDD VDD _02693_ sky130_fd_sc_hd__o21ai_0
X_10362_ network.neuron_in224.counter\[2\] VSS VSS VDD VDD
+ _06911_ sky130_fd_sc_hd__inv_1
X_10363_ network.neuron_in224.counter\[3\] network.in_period\[224\]\[2\]
+ _01169_ net375 VSS VSS VDD VDD _06912_ sky130_fd_sc_hd__o22ai_1
X_10364_ network.neuron_in224.counter\[2\] _01169_ net386
+ VSS VSS VDD VDD _06913_ sky130_fd_sc_hd__nand3_1
X_10365_ network.in_period\[224\]\[2\] net386 _06913_ VSS
+ VSS VDD VDD _06914_ sky130_fd_sc_hd__o21ai_0
X_10366_ _06911_ _06912_ _06914_ VSS VSS VDD VDD _02962_ sky130_fd_sc_hd__a21oi_1
X_10367_ network.neuron_in224.counter\[0\] VSS VSS VDD VDD
+ _01167_ sky130_fd_sc_hd__inv_1
X_10368_ network.neuron_in224.counter\[2\] _01169_ VSS VSS
+ VDD VDD _06915_ sky130_fd_sc_hd__nor2b_1
X_10369_ network.neuron_in224.counter\[3\] _06915_ VSS VSS
+ VDD VDD _06916_ sky130_fd_sc_hd__nand2b_1
X_10370_ net386 _06916_ VSS VSS VDD VDD _06917_ sky130_fd_sc_hd__nand2_1
X_10371_ network.in_period\[224\]\[0\] _06917_ VSS VSS VDD
+ VDD _06918_ sky130_fd_sc_hd__nand2_1
X_10372_ network.neuron_in224.counter\[0\] _06917_ _06918_
+ VSS VSS VDD VDD _02960_ sky130_fd_sc_hd__o21ai_0
X_10373_ network.neuron_in226.counter\[2\] _00784_ VSS VSS
+ VDD VDD _06919_ sky130_fd_sc_hd__xnor2_1
Xclkbuf_leaf_173_clk clknet_5_23__leaf_clk VSS VSS VDD VDD
+ clknet_leaf_173_clk sky130_fd_sc_hd__clkbuf_16
X_10375_ network.neuron_in226.counter\[2\] network.neuron_in226.counter\[3\]
+ VSS VSS VDD VDD _06921_ sky130_fd_sc_hd__nor2_1
X_10376_ _00784_ _06921_ VSS VSS VDD VDD _06922_ sky130_fd_sc_hd__nand2_1
X_10377_ net386 _06922_ network.in_period\[226\]\[2\] VSS
+ VSS VDD VDD _06923_ sky130_fd_sc_hd__a21oi_1
X_10378_ net386 _06919_ _06923_ VSS VSS VDD VDD _02970_ sky130_fd_sc_hd__a21oi_1
X_10379_ network.neuron_in106.counter\[1\] VSS VSS VDD VDD
+ _00671_ sky130_fd_sc_hd__inv_1
X_10380_ network.neuron_in028.counter\[1\] VSS VSS VDD VDD
+ _00356_ sky130_fd_sc_hd__inv_1
X_10381_ network.neuron_in146.counter\[1\] VSS VSS VDD VDD
+ _00608_ sky130_fd_sc_hd__inv_1
X_10382_ network.neuron_in002.counter\[0\] VSS VSS VDD VDD
+ _00611_ sky130_fd_sc_hd__inv_1
X_10383_ network.neuron_in026.counter\[1\] VSS VSS VDD VDD
+ _00449_ sky130_fd_sc_hd__inv_1
X_10384_ network.neuron_in027.counter\[1\] VSS VSS VDD VDD
+ _00364_ sky130_fd_sc_hd__inv_1
X_10385_ network.neuron_hid3.IF0.ref_counter\[1\] VSS VSS
+ VDD VDD _01028_ sky130_fd_sc_hd__inv_1
X_10386_ network.neuron_in138.counter\[2\] network.neuron_in138.counter\[3\]
+ VSS VSS VDD VDD _06924_ sky130_fd_sc_hd__nor2_1
X_10387_ _00597_ _06924_ VSS VSS VDD VDD _06925_ sky130_fd_sc_hd__nand2_1
X_10388_ net392 _06925_ VSS VSS VDD VDD _06926_ sky130_fd_sc_hd__nand2_1
X_10389_ network.in_period\[138\]\[1\] _06926_ VSS VSS VDD
+ VDD _06927_ sky130_fd_sc_hd__nand2_1
X_10390_ _00598_ _06926_ _06927_ VSS VSS VDD VDD _02617_ sky130_fd_sc_hd__o21ai_0
X_10391_ network.neuron_in002.counter\[1\] VSS VSS VDD VDD
+ _00612_ sky130_fd_sc_hd__inv_1
X_10392_ network.neuron_in024.counter\[1\] VSS VSS VDD VDD
+ _00376_ sky130_fd_sc_hd__inv_1
X_10393_ network.neuron_in230.counter\[0\] VSS VSS VDD VDD
+ _00798_ sky130_fd_sc_hd__inv_1
X_10394_ network.neuron_in055.counter\[0\] VSS VSS VDD VDD
+ _00240_ sky130_fd_sc_hd__inv_1
X_10395_ network.neuron_in023.counter\[1\] VSS VSS VDD VDD
+ _00382_ sky130_fd_sc_hd__inv_1
X_10396_ network.neuron_in171.counter\[1\] VSS VSS VDD VDD
+ _01024_ sky130_fd_sc_hd__inv_1
X_10397_ network.neuron_in137.counter\[0\] VSS VSS VDD VDD
+ _01133_ sky130_fd_sc_hd__inv_1
X_10398_ network.neuron_in137.counter\[2\] network.neuron_in137.counter\[3\]
+ _01135_ VSS VSS VDD VDD _06928_ sky130_fd_sc_hd__or3b_2
X_10399_ net384 _06928_ VSS VSS VDD VDD _06929_ sky130_fd_sc_hd__nand2_1
X_10400_ network.in_period\[137\]\[0\] _06929_ VSS VSS VDD
+ VDD _06930_ sky130_fd_sc_hd__nand2_1
X_10401_ network.neuron_in137.counter\[0\] _06929_ _06930_
+ VSS VSS VDD VDD _02612_ sky130_fd_sc_hd__o21ai_0
X_10402_ network.neuron_in108.counter\[1\] VSS VSS VDD VDD
+ _00683_ sky130_fd_sc_hd__inv_1
X_10403_ network.cnt_main.counter\[0\] VSS VSS VDD VDD _00615_
+ sky130_fd_sc_hd__inv_1
X_10404_ network.neuron_in022.counter\[1\] VSS VSS VDD VDD
+ _00372_ sky130_fd_sc_hd__inv_1
X_10405_ network.neuron_in125.counter\[1\] VSS VSS VDD VDD
+ _00431_ sky130_fd_sc_hd__inv_1
X_10406_ network.neuron_in043.counter\[0\] VSS VSS VDD VDD
+ _00294_ sky130_fd_sc_hd__inv_1
X_10407_ network.neuron_in132.counter\[1\] VSS VSS VDD VDD
+ _00514_ sky130_fd_sc_hd__inv_1
X_10408_ network.neuron_in021.counter\[1\] VSS VSS VDD VDD
+ _00387_ sky130_fd_sc_hd__inv_1
X_10409_ network.in_period\[137\]\[1\] _06929_ VSS VSS VDD
+ VDD _06931_ sky130_fd_sc_hd__nand2_1
X_10410_ _01136_ _06929_ _06931_ VSS VSS VDD VDD _02613_ sky130_fd_sc_hd__o21ai_0
X_10411_ network.neuron_in171.counter\[0\] VSS VSS VDD VDD
+ _01023_ sky130_fd_sc_hd__inv_1
X_10412_ network.neuron_in020.counter\[1\] VSS VSS VDD VDD
+ _00391_ sky130_fd_sc_hd__inv_1
X_10413_ network.neuron_in099.counter\[1\] VSS VSS VDD VDD
+ _00723_ sky130_fd_sc_hd__inv_1
X_10414_ network.neuron_in019.counter\[1\] VSS VSS VDD VDD
+ _00395_ sky130_fd_sc_hd__inv_1
X_10415_ network.cnt_main.counter\[1\] VSS VSS VDD VDD _00616_
+ sky130_fd_sc_hd__inv_1
X_10416_ network.neuron_hid2.IF0.ref_counter\[1\] VSS VSS
+ VDD VDD _01019_ sky130_fd_sc_hd__inv_1
X_10417_ network.neuron_in145.counter\[0\] VSS VSS VDD VDD
+ _00619_ sky130_fd_sc_hd__inv_1
X_10418_ network.neuron_in018.counter\[1\] VSS VSS VDD VDD
+ _00399_ sky130_fd_sc_hd__inv_1
X_10419_ network.neuron_in137.counter\[2\] _01135_ VSS VSS
+ VDD VDD _06932_ sky130_fd_sc_hd__xnor2_1
X_10420_ net384 _06928_ network.in_period\[137\]\[2\] VSS
+ VSS VDD VDD _06933_ sky130_fd_sc_hd__a21oi_1
X_10421_ net384 _06932_ _06933_ VSS VSS VDD VDD _02614_ sky130_fd_sc_hd__a21oi_1
X_10422_ network.neuron_in213.counter\[1\] VSS VSS VDD VDD
+ _00291_ sky130_fd_sc_hd__inv_1
X_10423_ network.neuron_in014.counter\[0\] VSS VSS VDD VDD
+ _00414_ sky130_fd_sc_hd__inv_1
X_10424_ network.neuron_in170.counter\[1\] VSS VSS VDD VDD
+ _01015_ sky130_fd_sc_hd__inv_1
X_10425_ network.neuron_in154.counter\[1\] VSS VSS VDD VDD
+ _00352_ sky130_fd_sc_hd__inv_1
X_10426_ network.neuron_in196.counter\[1\] VSS VSS VDD VDD
+ _01180_ sky130_fd_sc_hd__inv_1
X_10427_ network.neuron_in017.counter\[1\] VSS VSS VDD VDD
+ _00411_ sky130_fd_sc_hd__inv_1
X_10428_ network.neuron_in160.counter\[2\] VSS VSS VDD VDD
+ _06934_ sky130_fd_sc_hd__inv_1
X_10429_ network.neuron_in160.counter\[3\] network.in_period\[160\]\[2\]
+ net369 _01093_ VSS VSS VDD VDD _06935_ sky130_fd_sc_hd__o22ai_1
X_10430_ network.neuron_in160.counter\[2\] _01093_ net404
+ VSS VSS VDD VDD _06936_ sky130_fd_sc_hd__nand3_1
X_10431_ network.in_period\[160\]\[2\] net404 _06936_ VSS
+ VSS VDD VDD _06937_ sky130_fd_sc_hd__o21ai_0
X_10432_ _06934_ _06935_ _06937_ VSS VSS VDD VDD _02706_ sky130_fd_sc_hd__a21oi_1
X_10433_ network.neuron_in016.counter\[1\] VSS VSS VDD VDD
+ _00407_ sky130_fd_sc_hd__inv_1
X_10434_ network.neuron_in170.counter\[0\] VSS VSS VDD VDD
+ _01014_ sky130_fd_sc_hd__inv_1
X_10435_ network.neuron_in136.counter\[0\] VSS VSS VDD VDD
+ _00873_ sky130_fd_sc_hd__inv_1
X_10436_ network.neuron_in136.counter\[3\] _00875_ VSS VSS
+ VDD VDD _06938_ sky130_fd_sc_hd__nand2b_1
X_10437_ network.neuron_in136.counter\[2\] VSS VSS VDD VDD
+ _06939_ sky130_fd_sc_hd__inv_1
X_10438_ _06938_ _06939_ VSS VSS VDD VDD _06940_ sky130_fd_sc_hd__nand2b_1
X_10439_ net384 _06940_ VSS VSS VDD VDD _06941_ sky130_fd_sc_hd__nand2_1
X_10440_ network.in_period\[136\]\[0\] _06941_ VSS VSS VDD
+ VDD _06942_ sky130_fd_sc_hd__nand2_1
X_10441_ network.neuron_in136.counter\[0\] _06941_ _06942_
+ VSS VSS VDD VDD _02608_ sky130_fd_sc_hd__o21ai_0
X_10442_ network.neuron_in251.counter\[1\] VSS VSS VDD VDD
+ _01011_ sky130_fd_sc_hd__inv_1
X_10443_ network.in_period\[177\]\[1\] _06895_ VSS VSS VDD
+ VDD _06943_ sky130_fd_sc_hd__nand2_1
X_10444_ _00813_ _06895_ _06943_ VSS VSS VDD VDD _02773_ sky130_fd_sc_hd__o21ai_0
X_10445_ network.neuron_in014.counter\[1\] VSS VSS VDD VDD
+ _00415_ sky130_fd_sc_hd__inv_1
Xclkbuf_leaf_172_clk clknet_5_22__leaf_clk VSS VSS VDD VDD
+ clknet_leaf_172_clk sky130_fd_sc_hd__clkbuf_16
X_10447_ network.in_period\[136\]\[2\] network.neuron_in136.counter\[3\]
+ _00875_ net374 VSS VSS VDD VDD _06945_ sky130_fd_sc_hd__o22ai_1
X_10448_ network.neuron_in136.counter\[2\] _00875_ net384
+ VSS VSS VDD VDD _06946_ sky130_fd_sc_hd__nand3_1
X_10449_ network.in_period\[136\]\[2\] net384 _06946_ VSS
+ VSS VDD VDD _06947_ sky130_fd_sc_hd__o21ai_0
X_10450_ _06939_ _06945_ _06947_ VSS VSS VDD VDD _02610_ sky130_fd_sc_hd__a21oi_1
X_10451_ network.neuron_in145.counter\[1\] VSS VSS VDD VDD
+ _00620_ sky130_fd_sc_hd__inv_1
X_10452_ network.in_period\[136\]\[1\] _06941_ VSS VSS VDD
+ VDD _06948_ sky130_fd_sc_hd__nand2_1
X_10453_ _00876_ _06941_ _06948_ VSS VSS VDD VDD _02609_ sky130_fd_sc_hd__o21ai_0
X_10454_ network.neuron_in089.counter\[1\] VSS VSS VDD VDD
+ _01222_ sky130_fd_sc_hd__inv_1
X_10455_ network.neuron_in251.counter\[0\] VSS VSS VDD VDD
+ _01010_ sky130_fd_sc_hd__inv_1
X_10456_ network.in_period\[139\]\[1\] _06686_ VSS VSS VDD
+ VDD _06949_ sky130_fd_sc_hd__nand2_1
X_10457_ _00652_ _06686_ _06949_ VSS VSS VDD VDD _02621_ sky130_fd_sc_hd__o21ai_0
X_10458_ network.neuron_in013.counter\[1\] VSS VSS VDD VDD
+ _00423_ sky130_fd_sc_hd__inv_1
X_10459_ _01189_ network.neuron_in227.counter\[2\] VSS VSS
+ VDD VDD _06950_ sky130_fd_sc_hd__xnor2_1
X_10460_ net385 _06875_ network.in_period\[227\]\[2\] VSS
+ VSS VDD VDD _06951_ sky130_fd_sc_hd__a21oi_1
X_10461_ net385 _06950_ _06951_ VSS VSS VDD VDD _02974_ sky130_fd_sc_hd__a21oi_1
X_10462_ network.neuron_in109.counter\[1\] VSS VSS VDD VDD
+ _01007_ sky130_fd_sc_hd__inv_1
X_10463_ network.neuron_in180.counter\[1\] VSS VSS VDD VDD
+ _00624_ sky130_fd_sc_hd__inv_1
X_10464_ network.neuron_in011.counter\[1\] VSS VSS VDD VDD
+ _00439_ sky130_fd_sc_hd__inv_1
X_10465_ network.in_period\[139\]\[2\] network.neuron_in139.counter\[3\]
+ _00651_ net374 VSS VSS VDD VDD _06952_ sky130_fd_sc_hd__o22ai_1
X_10466_ network.neuron_in139.counter\[2\] _00651_ net384
+ VSS VSS VDD VDD _06953_ sky130_fd_sc_hd__nand3_1
X_10467_ network.in_period\[139\]\[2\] net384 _06953_ VSS
+ VSS VDD VDD _06954_ sky130_fd_sc_hd__o21ai_0
X_10468_ _06684_ _06952_ _06954_ VSS VSS VDD VDD _02622_ sky130_fd_sc_hd__a21oi_1
X_10469_ network.neuron_in188.counter\[1\] VSS VSS VDD VDD
+ _00237_ sky130_fd_sc_hd__inv_1
X_10470_ network.neuron_in246.counter\[1\] VSS VSS VDD VDD
+ _00667_ sky130_fd_sc_hd__inv_1
X_10471_ net406 _06778_ VSS VSS VDD VDD _06955_ sky130_fd_sc_hd__nand2_1
X_10472_ network.in_period\[218\]\[1\] _06955_ VSS VSS VDD
+ VDD _06956_ sky130_fd_sc_hd__nand2_1
X_10473_ _01186_ _06955_ _06956_ VSS VSS VDD VDD _02937_ sky130_fd_sc_hd__o21ai_0
X_10474_ network.neuron_in218.counter\[0\] VSS VSS VDD VDD
+ _01183_ sky130_fd_sc_hd__inv_1
X_10475_ network.in_period\[218\]\[0\] _06955_ VSS VSS VDD
+ VDD _06957_ sky130_fd_sc_hd__nand2_1
X_10476_ network.neuron_in218.counter\[0\] _06955_ _06957_
+ VSS VSS VDD VDD _02936_ sky130_fd_sc_hd__o21ai_0
X_10477_ network.neuron_in219.counter\[3\] _01000_ VSS VSS
+ VDD VDD _06958_ sky130_fd_sc_hd__nand2b_1
X_10478_ _06958_ _06897_ VSS VSS VDD VDD _06959_ sky130_fd_sc_hd__nand2b_1
X_10479_ net399 _06959_ VSS VSS VDD VDD _06960_ sky130_fd_sc_hd__nand2_1
X_10480_ network.in_period\[219\]\[1\] _06960_ VSS VSS VDD
+ VDD _06961_ sky130_fd_sc_hd__nand2_1
X_10481_ _01001_ _06960_ _06961_ VSS VSS VDD VDD _02941_ sky130_fd_sc_hd__o21ai_0
X_10482_ network.neuron_in219.counter\[0\] VSS VSS VDD VDD
+ _00998_ sky130_fd_sc_hd__inv_1
X_10483_ network.in_period\[219\]\[0\] _06960_ VSS VSS VDD
+ VDD _06962_ sky130_fd_sc_hd__nand2_1
X_10484_ network.neuron_in219.counter\[0\] _06960_ _06962_
+ VSS VSS VDD VDD _02940_ sky130_fd_sc_hd__o21ai_0
X_10485_ network.neuron_in182.counter\[1\] VSS VSS VDD VDD
+ _00719_ sky130_fd_sc_hd__inv_1
X_10486_ network.neuron_in034.counter\[1\] VSS VSS VDD VDD
+ _00360_ sky130_fd_sc_hd__inv_1
X_10487_ network.neuron_in146.counter\[0\] VSS VSS VDD VDD
+ _00607_ sky130_fd_sc_hd__inv_1
X_10488_ network.neuron_in010.counter\[1\] VSS VSS VDD VDD
+ _00435_ sky130_fd_sc_hd__inv_1
X_10489_ network.neuron_in109.counter\[0\] VSS VSS VDD VDD
+ _01006_ sky130_fd_sc_hd__inv_1
X_10490_ network.neuron_in220.counter\[0\] VSS VSS VDD VDD
+ _00962_ sky130_fd_sc_hd__inv_1
X_10491_ network.in_period\[220\]\[0\] _06882_ VSS VSS VDD
+ VDD _06963_ sky130_fd_sc_hd__nand2_1
X_10492_ network.neuron_in220.counter\[0\] _06882_ _06963_
+ VSS VSS VDD VDD _02944_ sky130_fd_sc_hd__o21ai_0
X_10493_ network.neuron_in221.counter\[2\] _00948_ VSS VSS
+ VDD VDD _06964_ sky130_fd_sc_hd__xnor2_1
X_10494_ net400 _06906_ network.in_period\[221\]\[2\] VSS
+ VSS VDD VDD _06965_ sky130_fd_sc_hd__a21oi_1
X_10495_ net400 _06964_ _06965_ VSS VSS VDD VDD _02950_ sky130_fd_sc_hd__a21oi_1
X_10496_ network.neuron_in221.counter\[0\] VSS VSS VDD VDD
+ _00946_ sky130_fd_sc_hd__inv_1
X_10497_ network.in_period\[221\]\[0\] _06907_ VSS VSS VDD
+ VDD _06966_ sky130_fd_sc_hd__nand2_1
X_10498_ network.neuron_in221.counter\[0\] _06907_ _06966_
+ VSS VSS VDD VDD _02948_ sky130_fd_sc_hd__o21ai_0
X_10499_ network.neuron_in222.counter\[2\] VSS VSS VDD VDD
+ _06967_ sky130_fd_sc_hd__inv_1
X_10500_ network.neuron_in222.counter\[3\] network.in_period\[222\]\[2\]
+ _00896_ net381 VSS VSS VDD VDD _06968_ sky130_fd_sc_hd__o22ai_1
X_10501_ network.neuron_in222.counter\[2\] _00896_ net400
+ VSS VSS VDD VDD _06969_ sky130_fd_sc_hd__nand3_1
X_10502_ network.in_period\[222\]\[2\] net400 _06969_ VSS
+ VSS VDD VDD _06970_ sky130_fd_sc_hd__o21ai_0
X_10503_ _06967_ _06968_ _06970_ VSS VSS VDD VDD _02954_ sky130_fd_sc_hd__a21oi_1
X_10504_ network.neuron_in223.counter\[3\] _00900_ VSS VSS
+ VDD VDD _06971_ sky130_fd_sc_hd__nand2b_1
X_10505_ _06971_ _06870_ VSS VSS VDD VDD _06972_ sky130_fd_sc_hd__nand2b_1
X_10506_ net400 _06972_ VSS VSS VDD VDD _06973_ sky130_fd_sc_hd__nand2_1
X_10507_ network.in_period\[223\]\[1\] _06973_ VSS VSS VDD
+ VDD _06974_ sky130_fd_sc_hd__nand2_1
X_10508_ _00901_ _06973_ _06974_ VSS VSS VDD VDD _02957_ sky130_fd_sc_hd__o21ai_0
X_10509_ network.neuron_in214.counter\[1\] VSS VSS VDD VDD
+ _01003_ sky130_fd_sc_hd__inv_1
X_10510_ network.neuron_in088.counter\[0\] VSS VSS VDD VDD
+ _00034_ sky130_fd_sc_hd__inv_1
X_10511_ network.neuron_in223.counter\[0\] VSS VSS VDD VDD
+ _00898_ sky130_fd_sc_hd__inv_1
X_10512_ network.in_period\[223\]\[0\] _06973_ VSS VSS VDD
+ VDD _06975_ sky130_fd_sc_hd__nand2_1
X_10513_ network.neuron_in223.counter\[0\] _06973_ _06975_
+ VSS VSS VDD VDD _02956_ sky130_fd_sc_hd__o21ai_0
X_10514_ network.in_period\[224\]\[1\] _06917_ VSS VSS VDD
+ VDD _06976_ sky130_fd_sc_hd__nand2_1
X_10515_ _01170_ _06917_ _06976_ VSS VSS VDD VDD _02961_ sky130_fd_sc_hd__o21ai_0
X_10516_ network.neuron_in225.counter\[3\] _00341_ VSS VSS
+ VDD VDD _06977_ sky130_fd_sc_hd__nand2b_1
X_10517_ _06977_ _06888_ VSS VSS VDD VDD _06978_ sky130_fd_sc_hd__nand2b_1
X_10518_ net386 _06978_ VSS VSS VDD VDD _06979_ sky130_fd_sc_hd__nand2_1
X_10519_ network.in_period\[225\]\[1\] _06979_ VSS VSS VDD
+ VDD _06980_ sky130_fd_sc_hd__nand2_1
X_10520_ _00342_ _06979_ _06980_ VSS VSS VDD VDD _02965_ sky130_fd_sc_hd__o21ai_0
X_10521_ network.neuron_in147.counter\[0\] VSS VSS VDD VDD
+ _00456_ sky130_fd_sc_hd__inv_1
Xclkbuf_leaf_171_clk clknet_5_29__leaf_clk VSS VSS VDD VDD
+ clknet_leaf_171_clk sky130_fd_sc_hd__clkbuf_16
X_10523_ network.neuron_in147.counter\[2\] _00458_ VSS VSS
+ VDD VDD _06982_ sky130_fd_sc_hd__nor2b_1
X_10524_ network.neuron_in147.counter\[3\] _06982_ VSS VSS
+ VDD VDD _06983_ sky130_fd_sc_hd__nand2b_1
X_10525_ net403 _06983_ VSS VSS VDD VDD _06984_ sky130_fd_sc_hd__nand2_1
X_10526_ network.in_period\[147\]\[0\] _06984_ VSS VSS VDD
+ VDD _06985_ sky130_fd_sc_hd__nand2_1
X_10527_ network.neuron_in147.counter\[0\] _06984_ _06985_
+ VSS VSS VDD VDD _02652_ sky130_fd_sc_hd__o21ai_0
X_10528_ network.neuron_in225.counter\[0\] VSS VSS VDD VDD
+ _00339_ sky130_fd_sc_hd__inv_1
X_10529_ network.in_period\[225\]\[0\] _06979_ VSS VSS VDD
+ VDD _06986_ sky130_fd_sc_hd__nand2_1
X_10530_ network.neuron_in225.counter\[0\] _06979_ _06986_
+ VSS VSS VDD VDD _02964_ sky130_fd_sc_hd__o21ai_0
X_10531_ net386 _06922_ VSS VSS VDD VDD _06987_ sky130_fd_sc_hd__nand2_1
X_10532_ network.in_period\[226\]\[1\] _06987_ VSS VSS VDD
+ VDD _06988_ sky130_fd_sc_hd__nand2_1
X_10533_ _00785_ _06987_ _06988_ VSS VSS VDD VDD _02969_ sky130_fd_sc_hd__o21ai_0
X_10534_ network.neuron_in226.counter\[0\] VSS VSS VDD VDD
+ _00782_ sky130_fd_sc_hd__inv_1
X_10535_ network.in_period\[226\]\[0\] _06987_ VSS VSS VDD
+ VDD _06989_ sky130_fd_sc_hd__nand2_1
X_10536_ network.neuron_in226.counter\[0\] _06987_ _06989_
+ VSS VSS VDD VDD _02968_ sky130_fd_sc_hd__o21ai_0
X_10537_ network.neuron_in236.counter\[0\] VSS VSS VDD VDD
+ _00367_ sky130_fd_sc_hd__inv_1
X_10538_ network.neuron_in236.counter\[2\] network.neuron_in236.counter\[3\]
+ VSS VSS VDD VDD _06990_ sky130_fd_sc_hd__nor2_1
X_10539_ _00369_ _06990_ VSS VSS VDD VDD _06991_ sky130_fd_sc_hd__nand2_1
X_10540_ net393 _06991_ VSS VSS VDD VDD _06992_ sky130_fd_sc_hd__nand2_1
X_10541_ network.in_period\[236\]\[0\] _06992_ VSS VSS VDD
+ VDD _06993_ sky130_fd_sc_hd__nand2_1
X_10542_ network.neuron_in236.counter\[0\] _06992_ _06993_
+ VSS VSS VDD VDD _03008_ sky130_fd_sc_hd__o21ai_0
X_10543_ network.neuron_in009.counter\[1\] VSS VSS VDD VDD
+ _00461_ sky130_fd_sc_hd__inv_1
X_10544_ _01057_ network.neuron_in233.counter\[2\] VSS VSS
+ VDD VDD _06994_ sky130_fd_sc_hd__xnor2_1
X_10545_ network.neuron_in233.counter\[2\] network.neuron_in233.counter\[3\]
+ VSS VSS VDD VDD _06995_ sky130_fd_sc_hd__nor2_1
X_10546_ _01057_ _06995_ VSS VSS VDD VDD _06996_ sky130_fd_sc_hd__nand2_1
X_10547_ net392 _06996_ network.in_period\[233\]\[2\] VSS
+ VSS VDD VDD _06997_ sky130_fd_sc_hd__a21oi_1
X_10548_ net392 _06994_ _06997_ VSS VSS VDD VDD _02998_ sky130_fd_sc_hd__a21oi_1
X_10549_ network.in_period\[236\]\[1\] _06992_ VSS VSS VDD
+ VDD _06998_ sky130_fd_sc_hd__nand2_1
X_10550_ _00370_ _06992_ _06998_ VSS VSS VDD VDD _03009_ sky130_fd_sc_hd__o21ai_0
Xclkbuf_leaf_170_clk clknet_5_28__leaf_clk VSS VSS VDD VDD
+ clknet_leaf_170_clk sky130_fd_sc_hd__clkbuf_16
X_10552_ network.neuron_in230.counter\[2\] network.neuron_in230.counter\[3\]
+ VSS VSS VDD VDD _07000_ sky130_fd_sc_hd__nor2_1
X_10553_ _00800_ _07000_ VSS VSS VDD VDD _07001_ sky130_fd_sc_hd__nand2_1
X_10554_ net392 _07001_ VSS VSS VDD VDD _07002_ sky130_fd_sc_hd__nand2_1
X_10555_ network.in_period\[230\]\[1\] _07002_ VSS VSS VDD
+ VDD _07003_ sky130_fd_sc_hd__nand2_1
X_10556_ _00801_ _07002_ _07003_ VSS VSS VDD VDD _02985_ sky130_fd_sc_hd__o21ai_0
X_10557_ network.neuron_in008.counter\[1\] VSS VSS VDD VDD
+ _00465_ sky130_fd_sc_hd__inv_1
X_10558_ network.neuron_in219.counter\[1\] VSS VSS VDD VDD
+ _00999_ sky130_fd_sc_hd__inv_1
X_10559_ network.neuron_in232.counter\[0\] VSS VSS VDD VDD
+ _00938_ sky130_fd_sc_hd__inv_1
X_10560_ network.neuron_in232.counter\[3\] _00940_ VSS VSS
+ VDD VDD _07004_ sky130_fd_sc_hd__nand2b_1
X_10561_ network.neuron_in232.counter\[2\] VSS VSS VDD VDD
+ _07005_ sky130_fd_sc_hd__inv_1
X_10562_ _07004_ _07005_ VSS VSS VDD VDD _07006_ sky130_fd_sc_hd__nand2b_1
X_10563_ net393 _07006_ VSS VSS VDD VDD _07007_ sky130_fd_sc_hd__nand2_1
X_10564_ network.in_period\[232\]\[0\] _07007_ VSS VSS VDD
+ VDD _07008_ sky130_fd_sc_hd__nand2_1
X_10565_ network.neuron_in232.counter\[0\] _07007_ _07008_
+ VSS VSS VDD VDD _02992_ sky130_fd_sc_hd__o21ai_0
X_10566_ network.neuron_in235.counter\[2\] VSS VSS VDD VDD
+ _07009_ sky130_fd_sc_hd__inv_1
X_10567_ network.neuron_in235.counter\[3\] network.in_period\[235\]\[2\]
+ net374 _00589_ VSS VSS VDD VDD _07010_ sky130_fd_sc_hd__o22ai_1
X_10568_ network.neuron_in235.counter\[2\] _00589_ net393
+ VSS VSS VDD VDD _07011_ sky130_fd_sc_hd__nand3_1
X_10569_ network.in_period\[235\]\[2\] net393 _07011_ VSS
+ VSS VDD VDD _07012_ sky130_fd_sc_hd__o21ai_0
X_10570_ _07009_ _07010_ _07012_ VSS VSS VDD VDD _03006_ sky130_fd_sc_hd__a21oi_1
X_10571_ network.neuron_in236.counter\[2\] VSS VSS VDD VDD
+ _07013_ sky130_fd_sc_hd__inv_1
X_10572_ network.neuron_in236.counter\[3\] network.in_period\[236\]\[2\]
+ _00369_ net374 VSS VSS VDD VDD _07014_ sky130_fd_sc_hd__o22ai_1
Xclkbuf_leaf_169_clk clknet_5_22__leaf_clk VSS VSS VDD VDD
+ clknet_leaf_169_clk sky130_fd_sc_hd__clkbuf_16
X_10574_ network.neuron_in236.counter\[2\] _00369_ net393
+ VSS VSS VDD VDD _07016_ sky130_fd_sc_hd__nand3_1
X_10575_ network.in_period\[236\]\[2\] net393 _07016_ VSS
+ VSS VDD VDD _07017_ sky130_fd_sc_hd__o21ai_0
X_10576_ _07013_ _07014_ _07017_ VSS VSS VDD VDD _03010_ sky130_fd_sc_hd__a21oi_1
Xclkbuf_leaf_168_clk clknet_5_22__leaf_clk VSS VSS VDD VDD
+ clknet_leaf_168_clk sky130_fd_sc_hd__clkbuf_16
Xclkbuf_leaf_167_clk clknet_5_22__leaf_clk VSS VSS VDD VDD
+ clknet_leaf_167_clk sky130_fd_sc_hd__clkbuf_16
X_10579_ network.neuron_in229.counter\[2\] _00804_ VSS VSS
+ VDD VDD _07020_ sky130_fd_sc_hd__xnor2_1
X_10580_ network.neuron_in229.counter\[2\] network.neuron_in229.counter\[3\]
+ VSS VSS VDD VDD _07021_ sky130_fd_sc_hd__nor2_1
X_10581_ _00804_ _07021_ VSS VSS VDD VDD _07022_ sky130_fd_sc_hd__nand2_1
X_10582_ net386 _07022_ network.in_period\[229\]\[2\] VSS
+ VSS VDD VDD _07023_ sky130_fd_sc_hd__a21oi_1
X_10583_ net386 _07020_ _07023_ VSS VSS VDD VDD _02982_ sky130_fd_sc_hd__a21oi_1
X_10584_ network.neuron_in114.counter\[1\] VSS VSS VDD VDD
+ _00497_ sky130_fd_sc_hd__inv_1
X_10585_ network.neuron_in230.counter\[2\] _00800_ VSS VSS
+ VDD VDD _07024_ sky130_fd_sc_hd__xnor2_1
X_10586_ net392 _07001_ network.in_period\[230\]\[2\] VSS
+ VSS VDD VDD _07025_ sky130_fd_sc_hd__a21oi_1
X_10587_ net392 _07024_ _07025_ VSS VSS VDD VDD _02986_ sky130_fd_sc_hd__a21oi_1
X_10588_ network.neuron_in153.counter\[1\] VSS VSS VDD VDD
+ _00473_ sky130_fd_sc_hd__inv_1
X_10589_ network.neuron_in131.counter\[1\] VSS VSS VDD VDD
+ _00485_ sky130_fd_sc_hd__inv_1
X_10590_ network.neuron_in231.counter\[3\] _00664_ VSS VSS
+ VDD VDD _07026_ sky130_fd_sc_hd__nand2b_1
X_10591_ network.neuron_in231.counter\[2\] VSS VSS VDD VDD
+ _07027_ sky130_fd_sc_hd__inv_1
X_10592_ _07026_ _07027_ VSS VSS VDD VDD _07028_ sky130_fd_sc_hd__nand2b_1
X_10593_ net392 _07028_ VSS VSS VDD VDD _07029_ sky130_fd_sc_hd__nand2_1
X_10594_ network.in_period\[231\]\[1\] _07029_ VSS VSS VDD
+ VDD _07030_ sky130_fd_sc_hd__nand2_1
X_10595_ _00665_ _07029_ _07030_ VSS VSS VDD VDD _02989_ sky130_fd_sc_hd__o21ai_0
X_10596_ network.in_period\[232\]\[1\] _07007_ VSS VSS VDD
+ VDD _07031_ sky130_fd_sc_hd__nand2_1
X_10597_ _00941_ _07007_ _07031_ VSS VSS VDD VDD _02993_ sky130_fd_sc_hd__o21ai_0
X_10598_ network.neuron_in234.counter\[1\] VSS VSS VDD VDD
+ _01148_ sky130_fd_sc_hd__inv_1
X_10599_ net392 _06996_ VSS VSS VDD VDD _07032_ sky130_fd_sc_hd__nand2_1
X_10600_ network.in_period\[233\]\[0\] _07032_ VSS VSS VDD
+ VDD _07033_ sky130_fd_sc_hd__nand2_1
X_10601_ network.neuron_in233.counter\[0\] _07032_ _07033_
+ VSS VSS VDD VDD _02996_ sky130_fd_sc_hd__o21ai_0
X_10602_ network.neuron_in152.counter\[1\] VSS VSS VDD VDD
+ _00477_ sky130_fd_sc_hd__inv_1
X_10603_ network.neuron_in234.counter\[0\] VSS VSS VDD VDD
+ _01147_ sky130_fd_sc_hd__inv_1
X_10604_ network.neuron_in234.counter\[2\] network.neuron_in234.counter\[3\]
+ VSS VSS VDD VDD _07034_ sky130_fd_sc_hd__nor2_1
X_10605_ _01149_ _07034_ VSS VSS VDD VDD _07035_ sky130_fd_sc_hd__nand2_1
X_10606_ net391 _07035_ VSS VSS VDD VDD _07036_ sky130_fd_sc_hd__nand2_1
X_10607_ network.in_period\[234\]\[0\] _07036_ VSS VSS VDD
+ VDD _07037_ sky130_fd_sc_hd__nand2_1
X_10608_ network.neuron_in234.counter\[0\] _07036_ _07037_
+ VSS VSS VDD VDD _03000_ sky130_fd_sc_hd__o21ai_0
Xclkbuf_leaf_166_clk clknet_5_22__leaf_clk VSS VSS VDD VDD
+ clknet_leaf_166_clk sky130_fd_sc_hd__clkbuf_16
Xclkbuf_leaf_165_clk clknet_5_22__leaf_clk VSS VSS VDD VDD
+ clknet_leaf_165_clk sky130_fd_sc_hd__clkbuf_16
Xclkbuf_leaf_164_clk clknet_5_19__leaf_clk VSS VSS VDD VDD
+ clknet_leaf_164_clk sky130_fd_sc_hd__clkbuf_16
X_10612_ network.neuron_hid0.ROM0.address\[7\] VSS VSS VDD
+ VDD _07041_ sky130_fd_sc_hd__inv_1
X_10613_ network.neuron_hid0.ROM0.read_en net406 VSS VSS VDD
+ VDD _07042_ sky130_fd_sc_hd__nand2_1
X_10614_ net412 net409 _07041_ _07042_ VSS VSS VDD VDD _07043_
+ sky130_fd_sc_hd__nor4_2
Xclkbuf_leaf_163_clk clknet_5_19__leaf_clk VSS VSS VDD VDD
+ clknet_leaf_163_clk sky130_fd_sc_hd__clkbuf_16
X_10616_ network.neuron_hid0.ROM0.address\[4\] VSS VSS VDD
+ VDD _07045_ sky130_fd_sc_hd__inv_2
X_10617_ network.neuron_hid0.ROM0.address\[2\] VSS VSS VDD
+ VDD _07046_ sky130_fd_sc_hd__inv_2
X_10618_ net366 _07046_ VSS VSS VDD VDD _07047_ sky130_fd_sc_hd__nand2_1
Xclkbuf_leaf_162_clk clknet_5_19__leaf_clk VSS VSS VDD VDD
+ clknet_leaf_162_clk sky130_fd_sc_hd__clkbuf_16
Xclkbuf_leaf_161_clk clknet_5_19__leaf_clk VSS VSS VDD VDD
+ clknet_leaf_161_clk sky130_fd_sc_hd__clkbuf_16
X_10621_ net417 net423 VSS VSS VDD VDD _07050_ sky130_fd_sc_hd__nor2_2
Xclkbuf_leaf_160_clk clknet_5_28__leaf_clk VSS VSS VDD VDD
+ clknet_leaf_160_clk sky130_fd_sc_hd__clkbuf_16
Xclkbuf_leaf_159_clk clknet_5_25__leaf_clk VSS VSS VDD VDD
+ clknet_leaf_159_clk sky130_fd_sc_hd__clkbuf_16
X_10624_ network.neuron_hid0.ROM0.address\[0\] VSS VSS VDD
+ VDD _07053_ sky130_fd_sc_hd__inv_1
Xclkbuf_leaf_158_clk clknet_5_19__leaf_clk VSS VSS VDD VDD
+ clknet_leaf_158_clk sky130_fd_sc_hd__clkbuf_16
Xclkbuf_leaf_157_clk clknet_5_24__leaf_clk VSS VSS VDD VDD
+ clknet_leaf_157_clk sky130_fd_sc_hd__clkbuf_16
X_10627_ network.neuron_hid0.ROM0.address\[3\] VSS VSS VDD
+ VDD _07056_ sky130_fd_sc_hd__clkinv_1
X_10628_ net363 _07056_ VSS VSS VDD VDD _07057_ sky130_fd_sc_hd__nor2_2
Xclkbuf_leaf_156_clk clknet_5_24__leaf_clk VSS VSS VDD VDD
+ clknet_leaf_156_clk sky130_fd_sc_hd__clkbuf_16
Xclkbuf_leaf_155_clk clknet_5_24__leaf_clk VSS VSS VDD VDD
+ clknet_leaf_155_clk sky130_fd_sc_hd__clkbuf_16
Xclkbuf_leaf_154_clk clknet_5_24__leaf_clk VSS VSS VDD VDD
+ clknet_leaf_154_clk sky130_fd_sc_hd__clkbuf_16
Xclkbuf_leaf_153_clk clknet_5_24__leaf_clk VSS VSS VDD VDD
+ clknet_leaf_153_clk sky130_fd_sc_hd__clkbuf_16
Xclkbuf_leaf_152_clk clknet_5_25__leaf_clk VSS VSS VDD VDD
+ clknet_leaf_152_clk sky130_fd_sc_hd__clkbuf_16
Xclkbuf_leaf_151_clk clknet_5_25__leaf_clk VSS VSS VDD VDD
+ clknet_leaf_151_clk sky130_fd_sc_hd__clkbuf_16
Xclkbuf_leaf_150_clk clknet_5_28__leaf_clk VSS VSS VDD VDD
+ clknet_leaf_150_clk sky130_fd_sc_hd__clkbuf_16
Xclkbuf_leaf_149_clk clknet_5_28__leaf_clk VSS VSS VDD VDD
+ clknet_leaf_149_clk sky130_fd_sc_hd__clkbuf_16
Xclkbuf_leaf_148_clk clknet_5_25__leaf_clk VSS VSS VDD VDD
+ clknet_leaf_148_clk sky130_fd_sc_hd__clkbuf_16
X_10638_ network.neuron_hid0.ROM0.address\[0\] net417 VSS
+ VSS VDD VDD _07067_ sky130_fd_sc_hd__nor2b_2
Xclkbuf_leaf_147_clk clknet_5_25__leaf_clk VSS VSS VDD VDD
+ clknet_leaf_147_clk sky130_fd_sc_hd__clkbuf_16
X_10640_ net417 net425 VSS VSS VDD VDD _07069_ sky130_fd_sc_hd__nand2b_1
Xclkbuf_leaf_146_clk clknet_5_25__leaf_clk VSS VSS VDD VDD
+ clknet_leaf_146_clk sky130_fd_sc_hd__clkbuf_16
X_10642_ net414 net361 net360 VSS VSS VDD VDD _07071_ sky130_fd_sc_hd__o21ai_0
X_10643_ net420 net418 VSS VSS VDD VDD _07072_ sky130_fd_sc_hd__nand2b_1
Xclkbuf_leaf_145_clk clknet_5_25__leaf_clk VSS VSS VDD VDD
+ clknet_leaf_145_clk sky130_fd_sc_hd__clkbuf_16
X_10645_ net415 net359 VSS VSS VDD VDD _07074_ sky130_fd_sc_hd__nor2_1
X_10646_ net420 _07071_ _07074_ VSS VSS VDD VDD _07075_ sky130_fd_sc_hd__a21oi_1
Xclkbuf_leaf_144_clk clknet_5_30__leaf_clk VSS VSS VDD VDD
+ clknet_leaf_144_clk sky130_fd_sc_hd__clkbuf_16
Xclkbuf_leaf_143_clk clknet_5_30__leaf_clk VSS VSS VDD VDD
+ clknet_leaf_143_clk sky130_fd_sc_hd__clkbuf_16
Xclkbuf_leaf_142_clk clknet_5_28__leaf_clk VSS VSS VDD VDD
+ clknet_leaf_142_clk sky130_fd_sc_hd__clkbuf_16
Xclkbuf_leaf_141_clk clknet_5_28__leaf_clk VSS VSS VDD VDD
+ clknet_leaf_141_clk sky130_fd_sc_hd__clkbuf_16
Xclkbuf_leaf_140_clk clknet_5_28__leaf_clk VSS VSS VDD VDD
+ clknet_leaf_140_clk sky130_fd_sc_hd__clkbuf_16
X_10652_ _07047_ net364 net325 _07075_ net423 VSS VSS VDD
+ VDD _07081_ sky130_fd_sc_hd__o32ai_1
Xclkbuf_leaf_139_clk clknet_5_28__leaf_clk VSS VSS VDD VDD
+ clknet_leaf_139_clk sky130_fd_sc_hd__clkbuf_16
X_10654_ network.neuron_hid0.ROM0.address\[7\] _07042_ VSS
+ VSS VDD VDD _07083_ sky130_fd_sc_hd__nor2_2
Xclkbuf_leaf_138_clk clknet_5_29__leaf_clk VSS VSS VDD VDD
+ clknet_leaf_138_clk sky130_fd_sc_hd__clkbuf_16
Xclkbuf_leaf_137_clk clknet_5_30__leaf_clk VSS VSS VDD VDD
+ clknet_leaf_137_clk sky130_fd_sc_hd__clkbuf_16
Xclkbuf_leaf_136_clk clknet_5_29__leaf_clk VSS VSS VDD VDD
+ clknet_leaf_136_clk sky130_fd_sc_hd__clkbuf_16
Xclkbuf_leaf_135_clk clknet_5_29__leaf_clk VSS VSS VDD VDD
+ clknet_leaf_135_clk sky130_fd_sc_hd__clkbuf_16
X_10659_ net412 VSS VSS VDD VDD _07088_ sky130_fd_sc_hd__inv_1
Xclkbuf_leaf_134_clk clknet_5_29__leaf_clk VSS VSS VDD VDD
+ clknet_leaf_134_clk sky130_fd_sc_hd__clkbuf_16
Xclkbuf_leaf_133_clk clknet_5_29__leaf_clk VSS VSS VDD VDD
+ clknet_leaf_133_clk sky130_fd_sc_hd__clkbuf_16
Xclkbuf_leaf_132_clk clknet_5_31__leaf_clk VSS VSS VDD VDD
+ clknet_leaf_132_clk sky130_fd_sc_hd__clkbuf_16
Xclkbuf_leaf_131_clk clknet_5_31__leaf_clk VSS VSS VDD VDD
+ clknet_leaf_131_clk sky130_fd_sc_hd__clkbuf_16
Xclkbuf_leaf_130_clk clknet_5_31__leaf_clk VSS VSS VDD VDD
+ clknet_leaf_130_clk sky130_fd_sc_hd__clkbuf_16
Xclkbuf_leaf_129_clk clknet_5_31__leaf_clk VSS VSS VDD VDD
+ clknet_leaf_129_clk sky130_fd_sc_hd__clkbuf_16
Xclkbuf_leaf_128_clk clknet_5_30__leaf_clk VSS VSS VDD VDD
+ clknet_leaf_128_clk sky130_fd_sc_hd__clkbuf_16
X_10667_ net425 net423 VSS VSS VDD VDD _07096_ sky130_fd_sc_hd__and2_1
Xclkbuf_leaf_127_clk clknet_5_30__leaf_clk VSS VSS VDD VDD
+ clknet_leaf_127_clk sky130_fd_sc_hd__clkbuf_16
Xclkbuf_leaf_126_clk clknet_5_31__leaf_clk VSS VSS VDD VDD
+ clknet_leaf_126_clk sky130_fd_sc_hd__clkbuf_16
X_10670_ network.neuron_hid0.ROM0.address\[0\] net423 VSS
+ VSS VDD VDD _07099_ sky130_fd_sc_hd__or2_2
Xclkbuf_leaf_125_clk clknet_5_31__leaf_clk VSS VSS VDD VDD
+ clknet_leaf_125_clk sky130_fd_sc_hd__clkbuf_16
X_10672_ net414 _07099_ VSS VSS VDD VDD _07101_ sky130_fd_sc_hd__nor2_1
X_10673_ net420 net357 _07101_ VSS VSS VDD VDD _07102_ sky130_fd_sc_hd__a21oi_1
Xclkbuf_leaf_124_clk clknet_5_31__leaf_clk VSS VSS VDD VDD
+ clknet_leaf_124_clk sky130_fd_sc_hd__clkbuf_16
Xclkbuf_leaf_123_clk clknet_5_27__leaf_clk VSS VSS VDD VDD
+ clknet_leaf_123_clk sky130_fd_sc_hd__clkbuf_16
Xclkbuf_leaf_122_clk clknet_5_27__leaf_clk VSS VSS VDD VDD
+ clknet_leaf_122_clk sky130_fd_sc_hd__clkbuf_16
X_10677_ net411 net423 VSS VSS VDD VDD _07106_ sky130_fd_sc_hd__nor2_1
Xclkbuf_leaf_121_clk clknet_5_27__leaf_clk VSS VSS VDD VDD
+ clknet_leaf_121_clk sky130_fd_sc_hd__clkbuf_16
Xclkbuf_leaf_120_clk clknet_5_27__leaf_clk VSS VSS VDD VDD
+ clknet_leaf_120_clk sky130_fd_sc_hd__clkbuf_16
X_10680_ net365 net424 VSS VSS VDD VDD _07109_ sky130_fd_sc_hd__nor2_1
Xclkbuf_leaf_119_clk clknet_5_26__leaf_clk VSS VSS VDD VDD
+ clknet_leaf_119_clk sky130_fd_sc_hd__clkbuf_16
X_10682_ net417 _07106_ net324 VSS VSS VDD VDD _07111_ sky130_fd_sc_hd__o21ai_0
Xclkbuf_leaf_118_clk clknet_5_26__leaf_clk VSS VSS VDD VDD
+ clknet_leaf_118_clk sky130_fd_sc_hd__clkbuf_16
Xclkbuf_leaf_117_clk clknet_5_26__leaf_clk VSS VSS VDD VDD
+ clknet_leaf_117_clk sky130_fd_sc_hd__clkbuf_16
Xclkbuf_leaf_116_clk clknet_5_26__leaf_clk VSS VSS VDD VDD
+ clknet_leaf_116_clk sky130_fd_sc_hd__clkbuf_16
X_10686_ _07046_ net425 VSS VSS VDD VDD _07115_ sky130_fd_sc_hd__nand2_1
X_10687_ net417 _07115_ VSS VSS VDD VDD _07116_ sky130_fd_sc_hd__nand2_1
X_10688_ net423 net417 VSS VSS VDD VDD _07117_ sky130_fd_sc_hd__nand2b_1
X_10689_ net363 net356 VSS VSS VDD VDD _07118_ sky130_fd_sc_hd__nor2_1
Xclkbuf_leaf_115_clk clknet_5_26__leaf_clk VSS VSS VDD VDD
+ clknet_leaf_115_clk sky130_fd_sc_hd__clkbuf_16
X_10691_ network.neuron_hid0.ROM0.address\[0\] net423 VSS
+ VSS VDD VDD _07120_ sky130_fd_sc_hd__xnor2_1
X_10692_ net411 net355 VSS VSS VDD VDD _07121_ sky130_fd_sc_hd__nor2_1
Xclkbuf_leaf_114_clk clknet_5_26__leaf_clk VSS VSS VDD VDD
+ clknet_leaf_114_clk sky130_fd_sc_hd__clkbuf_16
X_10694_ _07118_ _07121_ net365 VSS VSS VDD VDD _07123_ sky130_fd_sc_hd__o21ai_0
X_10695_ net411 _07116_ _07123_ VSS VSS VDD VDD _07124_ sky130_fd_sc_hd__o21ai_0
Xclkbuf_leaf_113_clk clknet_5_26__leaf_clk VSS VSS VDD VDD
+ clknet_leaf_113_clk sky130_fd_sc_hd__clkbuf_16
Xclkbuf_leaf_112_clk clknet_5_27__leaf_clk VSS VSS VDD VDD
+ clknet_leaf_112_clk sky130_fd_sc_hd__clkbuf_16
X_10698_ net417 net423 VSS VSS VDD VDD _07127_ sky130_fd_sc_hd__nand2_1
X_10699_ net421 _07127_ VSS VSS VDD VDD _07128_ sky130_fd_sc_hd__nor2_1
X_10700_ _07046_ net417 VSS VSS VDD VDD _07129_ sky130_fd_sc_hd__nor2_1
Xclkbuf_leaf_111_clk clknet_5_27__leaf_clk VSS VSS VDD VDD
+ clknet_leaf_111_clk sky130_fd_sc_hd__clkbuf_16
X_10702_ _07128_ net323 network.neuron_hid0.ROM0.address\[0\]
+ VSS VSS VDD VDD _07131_ sky130_fd_sc_hd__o21ai_0
Xclkbuf_leaf_110_clk clknet_5_27__leaf_clk VSS VSS VDD VDD
+ clknet_leaf_110_clk sky130_fd_sc_hd__clkbuf_16
X_10704_ net418 net423 VSS VSS VDD VDD _07133_ sky130_fd_sc_hd__nor2b_2
X_10705_ net363 net353 VSS VSS VDD VDD _07134_ sky130_fd_sc_hd__nand2_1
Xclkbuf_leaf_109_clk clknet_5_27__leaf_clk VSS VSS VDD VDD
+ clknet_leaf_109_clk sky130_fd_sc_hd__clkbuf_16
X_10707_ net421 net417 VSS VSS VDD VDD _07136_ sky130_fd_sc_hd__nand2_1
X_10708_ _07134_ net352 net358 VSS VSS VDD VDD _07137_ sky130_fd_sc_hd__a21o_1
X_10709_ net422 net418 VSS VSS VDD VDD _07138_ sky130_fd_sc_hd__nor2b_2
Xclkbuf_leaf_108_clk clknet_5_27__leaf_clk VSS VSS VDD VDD
+ clknet_leaf_108_clk sky130_fd_sc_hd__clkbuf_16
X_10711_ net363 net351 VSS VSS VDD VDD _07140_ sky130_fd_sc_hd__nand2_1
X_10712_ net411 _07131_ _07137_ _07140_ net414 VSS VSS VDD
+ VDD _07141_ sky130_fd_sc_hd__o2111ai_1
X_10713_ net414 _07124_ _07141_ VSS VSS VDD VDD _07142_ sky130_fd_sc_hd__o21ai_0
X_10714_ net358 net417 _07102_ _07111_ _07142_ VSS VSS VDD
+ VDD _07143_ sky130_fd_sc_hd__o311ai_0
Xclkbuf_leaf_107_clk clknet_5_25__leaf_clk VSS VSS VDD VDD
+ clknet_leaf_107_clk sky130_fd_sc_hd__clkbuf_16
Xclkbuf_leaf_106_clk clknet_5_26__leaf_clk VSS VSS VDD VDD
+ clknet_leaf_106_clk sky130_fd_sc_hd__clkbuf_16
X_10717_ net366 net424 VSS VSS VDD VDD _07146_ sky130_fd_sc_hd__nand2_1
Xclkbuf_leaf_105_clk clknet_5_26__leaf_clk VSS VSS VDD VDD
+ clknet_leaf_105_clk sky130_fd_sc_hd__clkbuf_16
Xclkbuf_leaf_104_clk clknet_5_24__leaf_clk VSS VSS VDD VDD
+ clknet_leaf_104_clk sky130_fd_sc_hd__clkbuf_16
Xclkbuf_leaf_103_clk clknet_5_24__leaf_clk VSS VSS VDD VDD
+ clknet_leaf_103_clk sky130_fd_sc_hd__clkbuf_16
X_10721_ net411 net417 net423 VSS VSS VDD VDD _07150_ sky130_fd_sc_hd__a21oi_1
Xclkbuf_leaf_102_clk clknet_5_24__leaf_clk VSS VSS VDD VDD
+ clknet_leaf_102_clk sky130_fd_sc_hd__clkbuf_16
Xclkbuf_leaf_101_clk clknet_5_24__leaf_clk VSS VSS VDD VDD
+ clknet_leaf_101_clk sky130_fd_sc_hd__clkbuf_16
Xclkbuf_leaf_100_clk clknet_5_24__leaf_clk VSS VSS VDD VDD
+ clknet_leaf_100_clk sky130_fd_sc_hd__clkbuf_16
Xclkbuf_leaf_99_clk clknet_5_13__leaf_clk VSS VSS VDD VDD
+ clknet_leaf_99_clk sky130_fd_sc_hd__clkbuf_16
X_10726_ net423 net361 VSS VSS VDD VDD _07155_ sky130_fd_sc_hd__nor2_1
X_10727_ net416 net417 net423 VSS VSS VDD VDD _07156_ sky130_fd_sc_hd__a21oi_1
X_10728_ net416 _07155_ _07156_ net363 VSS VSS VDD VDD _07157_
+ sky130_fd_sc_hd__o22a_1
X_10729_ net425 net412 VSS VSS VDD VDD _07158_ sky130_fd_sc_hd__nand2b_1
Xclkbuf_leaf_98_clk clknet_5_13__leaf_clk VSS VSS VDD VDD
+ clknet_leaf_98_clk sky130_fd_sc_hd__clkbuf_16
Xclkbuf_leaf_97_clk clknet_5_13__leaf_clk VSS VSS VDD VDD
+ clknet_leaf_97_clk sky130_fd_sc_hd__clkbuf_16
X_10732_ net416 _07127_ net364 VSS VSS VDD VDD _07161_ sky130_fd_sc_hd__a21oi_1
X_10733_ net418 net422 VSS VSS VDD VDD _07162_ sky130_fd_sc_hd__and2_1
Xclkbuf_leaf_96_clk clknet_5_13__leaf_clk VSS VSS VDD VDD
+ clknet_leaf_96_clk sky130_fd_sc_hd__clkbuf_16
X_10735_ net425 _07162_ VSS VSS VDD VDD _07164_ sky130_fd_sc_hd__nand2_1
X_10736_ net412 _07157_ _07158_ _07161_ _07164_ VSS VSS VDD
+ VDD _07165_ sky130_fd_sc_hd__o221ai_1
X_10737_ net366 net362 VSS VSS VDD VDD _07166_ sky130_fd_sc_hd__nand2_1
X_10738_ network.neuron_hid0.ROM0.address\[0\] net416 VSS
+ VSS VDD VDD _07167_ sky130_fd_sc_hd__nand2b_1
X_10739_ _07166_ net350 net412 VSS VSS VDD VDD _07168_ sky130_fd_sc_hd__a21oi_1
X_10740_ net417 net423 VSS VSS VDD VDD _07169_ sky130_fd_sc_hd__nand2b_1
Xclkbuf_leaf_95_clk clknet_5_13__leaf_clk VSS VSS VDD VDD
+ clknet_leaf_95_clk sky130_fd_sc_hd__clkbuf_16
X_10742_ net416 net349 VSS VSS VDD VDD _07171_ sky130_fd_sc_hd__nor2_1
X_10743_ _07046_ net351 _07168_ _07171_ VSS VSS VDD VDD _07172_
+ sky130_fd_sc_hd__or4_1
X_10744_ net421 _07165_ _07172_ VSS VSS VDD VDD _07173_ sky130_fd_sc_hd__o21ai_0
X_10745_ _07146_ _07150_ _07173_ net408 VSS VSS VDD VDD _07174_
+ sky130_fd_sc_hd__o211ai_1
X_10746_ net408 _07143_ _07174_ VSS VSS VDD VDD _07175_ sky130_fd_sc_hd__o21ai_0
X_10747_ net307 _07081_ net306 _07175_ VSS VSS VDD VDD _01508_
+ sky130_fd_sc_hd__a22o_1
X_10748_ network.neuron_in238.counter\[1\] VSS VSS VDD VDD
+ _00787_ sky130_fd_sc_hd__inv_1
X_10749_ network.neuron_in130.counter\[1\] VSS VSS VDD VDD
+ _00501_ sky130_fd_sc_hd__inv_1
Xclkbuf_leaf_94_clk clknet_5_15__leaf_clk VSS VSS VDD VDD
+ clknet_leaf_94_clk sky130_fd_sc_hd__clkbuf_16
Xclkbuf_leaf_93_clk clknet_5_15__leaf_clk VSS VSS VDD VDD
+ clknet_leaf_93_clk sky130_fd_sc_hd__clkbuf_16
X_10752_ net425 net422 VSS VSS VDD VDD _07178_ sky130_fd_sc_hd__nand2b_1
Xclkbuf_leaf_92_clk clknet_5_12__leaf_clk VSS VSS VDD VDD
+ clknet_leaf_92_clk sky130_fd_sc_hd__clkbuf_16
X_10754_ net420 net417 VSS VSS VDD VDD _07180_ sky130_fd_sc_hd__nor2_1
X_10755_ net423 net425 VSS VSS VDD VDD _07181_ sky130_fd_sc_hd__nor2b_1
Xclkbuf_leaf_91_clk clknet_5_12__leaf_clk VSS VSS VDD VDD
+ clknet_leaf_91_clk sky130_fd_sc_hd__clkbuf_16
X_10757_ net417 _07181_ net420 VSS VSS VDD VDD _07183_ sky130_fd_sc_hd__o21ai_0
X_10758_ net348 _07180_ _07183_ VSS VSS VDD VDD _07184_ sky130_fd_sc_hd__o21ai_0
Xclkbuf_leaf_90_clk clknet_5_14__leaf_clk VSS VSS VDD VDD
+ clknet_leaf_90_clk sky130_fd_sc_hd__clkbuf_16
X_10760_ net422 VSS VSS VDD VDD _07186_ sky130_fd_sc_hd__inv_1
X_10761_ net420 _07186_ VSS VSS VDD VDD _07187_ sky130_fd_sc_hd__nor2_1
X_10762_ net365 _07099_ VSS VSS VDD VDD _07188_ sky130_fd_sc_hd__nor2_1
X_10763_ net322 _07188_ net414 VSS VSS VDD VDD _07189_ sky130_fd_sc_hd__o21ai_0
Xclkbuf_leaf_89_clk clknet_5_14__leaf_clk VSS VSS VDD VDD
+ clknet_leaf_89_clk sky130_fd_sc_hd__clkbuf_16
Xclkbuf_leaf_88_clk clknet_5_14__leaf_clk VSS VSS VDD VDD
+ clknet_leaf_88_clk sky130_fd_sc_hd__clkbuf_16
X_10766_ net366 _07184_ _07189_ net417 VSS VSS VDD VDD _07192_
+ sky130_fd_sc_hd__o2bb2ai_1
Xclkbuf_leaf_87_clk clknet_5_14__leaf_clk VSS VSS VDD VDD
+ clknet_leaf_87_clk sky130_fd_sc_hd__clkbuf_16
Xclkbuf_leaf_86_clk clknet_5_14__leaf_clk VSS VSS VDD VDD
+ clknet_leaf_86_clk sky130_fd_sc_hd__clkbuf_16
Xclkbuf_leaf_85_clk clknet_5_15__leaf_clk VSS VSS VDD VDD
+ clknet_leaf_85_clk sky130_fd_sc_hd__clkbuf_16
X_10770_ net425 _07050_ VSS VSS VDD VDD _07196_ sky130_fd_sc_hd__nand2_1
X_10771_ net348 net321 net420 VSS VSS VDD VDD _07197_ sky130_fd_sc_hd__a21oi_1
X_10772_ net420 net361 _07197_ VSS VSS VDD VDD _07198_ sky130_fd_sc_hd__a21oi_1
Xclkbuf_leaf_84_clk clknet_5_15__leaf_clk VSS VSS VDD VDD
+ clknet_leaf_84_clk sky130_fd_sc_hd__clkbuf_16
Xclkbuf_leaf_83_clk clknet_5_15__leaf_clk VSS VSS VDD VDD
+ clknet_leaf_83_clk sky130_fd_sc_hd__clkbuf_16
X_10775_ network.neuron_hid0.ROM0.address\[0\] net423 VSS
+ VSS VDD VDD _07201_ sky130_fd_sc_hd__nand2_1
Xclkbuf_leaf_82_clk clknet_5_15__leaf_clk VSS VSS VDD VDD
+ clknet_leaf_82_clk sky130_fd_sc_hd__clkbuf_16
Xclkbuf_leaf_81_clk clknet_5_15__leaf_clk VSS VSS VDD VDD
+ clknet_leaf_81_clk sky130_fd_sc_hd__clkbuf_16
X_10778_ net425 net423 VSS VSS VDD VDD _07204_ sky130_fd_sc_hd__nor2_2
X_10779_ net415 net347 VSS VSS VDD VDD _07205_ sky130_fd_sc_hd__nand2_1
X_10780_ _07201_ _07205_ VSS VSS VDD VDD _07206_ sky130_fd_sc_hd__nand2_1
X_10781_ net425 net353 VSS VSS VDD VDD _07207_ sky130_fd_sc_hd__nand2_1
X_10782_ _07140_ _07207_ VSS VSS VDD VDD _07208_ sky130_fd_sc_hd__nand2_1
Xclkbuf_leaf_80_clk clknet_5_15__leaf_clk VSS VSS VDD VDD
+ clknet_leaf_80_clk sky130_fd_sc_hd__clkbuf_16
X_10784_ net358 net409 VSS VSS VDD VDD _07210_ sky130_fd_sc_hd__nand2_1
X_10785_ net420 _07206_ _07208_ net414 _07210_ VSS VSS VDD
+ VDD _07211_ sky130_fd_sc_hd__a221oi_1
X_10786_ net414 _07198_ _07211_ VSS VSS VDD VDD _07212_ sky130_fd_sc_hd__o21ai_0
X_10787_ net418 net422 VSS VSS VDD VDD _07213_ sky130_fd_sc_hd__or2_2
Xclkbuf_leaf_79_clk clknet_5_14__leaf_clk VSS VSS VDD VDD
+ clknet_leaf_79_clk sky130_fd_sc_hd__clkbuf_16
X_10789_ network.neuron_hid0.ROM0.address\[0\] _07213_ VSS
+ VSS VDD VDD _07215_ sky130_fd_sc_hd__nor2_1
Xclkbuf_leaf_78_clk clknet_5_14__leaf_clk VSS VSS VDD VDD
+ clknet_leaf_78_clk sky130_fd_sc_hd__clkbuf_16
Xclkbuf_leaf_77_clk clknet_5_14__leaf_clk VSS VSS VDD VDD
+ clknet_leaf_77_clk sky130_fd_sc_hd__clkbuf_16
Xclkbuf_leaf_76_clk clknet_5_11__leaf_clk VSS VSS VDD VDD
+ clknet_leaf_76_clk sky130_fd_sc_hd__clkbuf_16
X_10793_ net366 net363 VSS VSS VDD VDD _07219_ sky130_fd_sc_hd__nor2_1
Xclkbuf_leaf_75_clk clknet_5_11__leaf_clk VSS VSS VDD VDD
+ clknet_leaf_75_clk sky130_fd_sc_hd__clkbuf_16
X_10795_ net416 net354 net425 VSS VSS VDD VDD _07221_ sky130_fd_sc_hd__a21oi_1
X_10796_ net351 net320 _07221_ VSS VSS VDD VDD _07222_ sky130_fd_sc_hd__a21oi_1
X_10797_ _07046_ _07222_ VSS VSS VDD VDD _07223_ sky130_fd_sc_hd__nor2_1
X_10798_ net425 net423 VSS VSS VDD VDD _07224_ sky130_fd_sc_hd__nor2b_2
Xclkbuf_leaf_74_clk clknet_5_10__leaf_clk VSS VSS VDD VDD
+ clknet_leaf_74_clk sky130_fd_sc_hd__clkbuf_16
X_10800_ net421 _07118_ net345 VSS VSS VDD VDD _07226_ sky130_fd_sc_hd__nor3_1
X_10801_ net412 net409 VSS VSS VDD VDD _07227_ sky130_fd_sc_hd__nor2_1
Xclkbuf_leaf_73_clk clknet_5_10__leaf_clk VSS VSS VDD VDD
+ clknet_leaf_73_clk sky130_fd_sc_hd__clkbuf_16
X_10803_ _07215_ _07223_ _07226_ net344 VSS VSS VDD VDD _07229_
+ sky130_fd_sc_hd__o31ai_1
X_10804_ net420 net348 _07166_ VSS VSS VDD VDD _07230_ sky130_fd_sc_hd__a21oi_1
X_10805_ net425 net351 VSS VSS VDD VDD _07231_ sky130_fd_sc_hd__nand2_1
Xclkbuf_leaf_72_clk clknet_5_11__leaf_clk VSS VSS VDD VDD
+ clknet_leaf_72_clk sky130_fd_sc_hd__clkbuf_16
X_10807_ network.neuron_hid0.ROM0.address\[0\] net351 net414
+ VSS VSS VDD VDD _07233_ sky130_fd_sc_hd__o21ai_0
Xclkbuf_leaf_71_clk clknet_5_11__leaf_clk VSS VSS VDD VDD
+ clknet_leaf_71_clk sky130_fd_sc_hd__clkbuf_16
X_10809_ net414 net361 net357 net420 VSS VSS VDD VDD _07235_
+ sky130_fd_sc_hd__a211oi_1
X_10810_ net420 _07231_ _07233_ _07235_ VSS VSS VDD VDD _07236_
+ sky130_fd_sc_hd__a31oi_1
Xclkbuf_leaf_70_clk clknet_5_11__leaf_clk VSS VSS VDD VDD
+ clknet_leaf_70_clk sky130_fd_sc_hd__clkbuf_16
X_10812_ net358 net409 VSS VSS VDD VDD _07238_ sky130_fd_sc_hd__nor2_1
X_10813_ _07230_ _07236_ _07238_ VSS VSS VDD VDD _07239_ sky130_fd_sc_hd__o21ai_0
Xclkbuf_leaf_69_clk clknet_5_11__leaf_clk VSS VSS VDD VDD
+ clknet_leaf_69_clk sky130_fd_sc_hd__clkbuf_16
X_10815_ _07046_ net423 VSS VSS VDD VDD _07241_ sky130_fd_sc_hd__nand2_1
Xclkbuf_leaf_68_clk clknet_5_11__leaf_clk VSS VSS VDD VDD
+ clknet_leaf_68_clk sky130_fd_sc_hd__clkbuf_16
X_10817_ net414 net352 _07241_ VSS VSS VDD VDD _07243_ sky130_fd_sc_hd__o21ai_0
Xclkbuf_leaf_67_clk clknet_5_10__leaf_clk VSS VSS VDD VDD
+ clknet_leaf_67_clk sky130_fd_sc_hd__clkbuf_16
X_10819_ net363 net346 VSS VSS VDD VDD _07245_ sky130_fd_sc_hd__nor2_1
X_10820_ net363 _07243_ _07245_ VSS VSS VDD VDD _07246_ sky130_fd_sc_hd__a21oi_1
X_10821_ net418 net425 VSS VSS VDD VDD _07247_ sky130_fd_sc_hd__nor2b_2
Xclkbuf_leaf_66_clk clknet_5_10__leaf_clk VSS VSS VDD VDD
+ clknet_leaf_66_clk sky130_fd_sc_hd__clkbuf_16
X_10823_ net423 network.neuron_hid0.ROM0.address\[0\] VSS
+ VSS VDD VDD _07249_ sky130_fd_sc_hd__nand2b_1
Xclkbuf_leaf_65_clk clknet_5_10__leaf_clk VSS VSS VDD VDD
+ clknet_leaf_65_clk sky130_fd_sc_hd__clkbuf_16
Xclkbuf_leaf_64_clk clknet_5_10__leaf_clk VSS VSS VDD VDD
+ clknet_leaf_64_clk sky130_fd_sc_hd__clkbuf_16
X_10826_ net417 net342 net414 VSS VSS VDD VDD _07252_ sky130_fd_sc_hd__a21oi_1
X_10827_ net343 _07252_ _07046_ VSS VSS VDD VDD _07253_ sky130_fd_sc_hd__o21ai_0
X_10828_ net410 net409 VSS VSS VDD VDD _07254_ sky130_fd_sc_hd__nand2_1
X_10829_ _07246_ _07253_ _07254_ VSS VSS VDD VDD _07255_ sky130_fd_sc_hd__a21o_1
X_10830_ _07212_ _07229_ _07239_ _07255_ VSS VSS VDD VDD _07256_
+ sky130_fd_sc_hd__nand4_1
X_10831_ net307 _07192_ _07256_ net306 VSS VSS VDD VDD _01509_
+ sky130_fd_sc_hd__a22o_1
X_10832_ network.neuron_in228.counter\[3\] _00808_ VSS VSS
+ VDD VDD _07257_ sky130_fd_sc_hd__nand2b_1
X_10833_ _07257_ _06866_ VSS VSS VDD VDD _07258_ sky130_fd_sc_hd__nand2b_1
X_10834_ net392 _07258_ VSS VSS VDD VDD _07259_ sky130_fd_sc_hd__nand2_1
X_10835_ network.in_period\[228\]\[1\] _07259_ VSS VSS VDD
+ VDD _07260_ sky130_fd_sc_hd__nand2_1
X_10836_ _00809_ _07259_ _07260_ VSS VSS VDD VDD _02977_ sky130_fd_sc_hd__o21ai_0
X_10837_ network.neuron_in027.counter\[0\] VSS VSS VDD VDD
+ _00363_ sky130_fd_sc_hd__inv_1
X_10838_ network.neuron_in228.counter\[0\] VSS VSS VDD VDD
+ _00806_ sky130_fd_sc_hd__inv_1
X_10839_ network.in_period\[228\]\[0\] _07259_ VSS VSS VDD
+ VDD _07261_ sky130_fd_sc_hd__nand2_1
X_10840_ network.neuron_in228.counter\[0\] _07259_ _07261_
+ VSS VSS VDD VDD _02976_ sky130_fd_sc_hd__o21ai_0
X_10841_ net386 _07022_ VSS VSS VDD VDD _07262_ sky130_fd_sc_hd__nand2_1
X_10842_ network.in_period\[229\]\[1\] _07262_ VSS VSS VDD
+ VDD _07263_ sky130_fd_sc_hd__nand2_1
X_10843_ _00805_ _07262_ _07263_ VSS VSS VDD VDD _02981_ sky130_fd_sc_hd__o21ai_0
X_10844_ network.neuron_in125.counter\[2\] network.neuron_in125.counter\[3\]
+ VSS VSS VDD VDD _07264_ sky130_fd_sc_hd__nor2_1
X_10845_ _00432_ _07264_ VSS VSS VDD VDD _07265_ sky130_fd_sc_hd__nand2_1
X_10846_ net383 _07265_ VSS VSS VDD VDD _07266_ sky130_fd_sc_hd__nand2_1
X_10847_ network.in_period\[125\]\[1\] _07266_ VSS VSS VDD
+ VDD _07267_ sky130_fd_sc_hd__nand2_1
X_10848_ _00433_ _07266_ _07267_ VSS VSS VDD VDD _02565_ sky130_fd_sc_hd__o21ai_0
X_10849_ network.neuron_in151.counter\[1\] VSS VSS VDD VDD
+ _00481_ sky130_fd_sc_hd__inv_1
X_10850_ network.neuron_in239.counter\[0\] VSS VSS VDD VDD
+ _00488_ sky130_fd_sc_hd__inv_1
X_10851_ network.neuron_in122.counter\[0\] VSS VSS VDD VDD
+ _00535_ sky130_fd_sc_hd__inv_1
X_10852_ network.neuron_in125.counter\[0\] VSS VSS VDD VDD
+ _00430_ sky130_fd_sc_hd__inv_1
X_10853_ network.in_period\[125\]\[0\] _07266_ VSS VSS VDD
+ VDD _07268_ sky130_fd_sc_hd__nand2_1
X_10854_ network.neuron_in125.counter\[0\] _07266_ _07268_
+ VSS VSS VDD VDD _02564_ sky130_fd_sc_hd__o21ai_0
X_10855_ network.neuron_in229.counter\[0\] VSS VSS VDD VDD
+ _00802_ sky130_fd_sc_hd__inv_1
X_10856_ network.in_period\[229\]\[0\] _07262_ VSS VSS VDD
+ VDD _07269_ sky130_fd_sc_hd__nand2_1
X_10857_ network.neuron_in229.counter\[0\] _07262_ _07269_
+ VSS VSS VDD VDD _02980_ sky130_fd_sc_hd__o21ai_0
X_10858_ network.in_period\[230\]\[0\] _07002_ VSS VSS VDD
+ VDD _07270_ sky130_fd_sc_hd__nand2_1
X_10859_ network.neuron_in230.counter\[0\] _07002_ _07270_
+ VSS VSS VDD VDD _02984_ sky130_fd_sc_hd__o21ai_0
X_10860_ network.neuron_in231.counter\[3\] network.in_period\[231\]\[2\]
+ _00664_ net375 VSS VSS VDD VDD _07271_ sky130_fd_sc_hd__o22ai_1
X_10861_ network.neuron_in231.counter\[2\] _00664_ net392
+ VSS VSS VDD VDD _07272_ sky130_fd_sc_hd__nand3_1
X_10862_ network.in_period\[231\]\[2\] net392 _07272_ VSS
+ VSS VDD VDD _07273_ sky130_fd_sc_hd__o21ai_0
X_10863_ _07027_ _07271_ _07273_ VSS VSS VDD VDD _02990_ sky130_fd_sc_hd__a21oi_1
X_10864_ network.neuron_in231.counter\[0\] VSS VSS VDD VDD
+ _00662_ sky130_fd_sc_hd__inv_1
X_10865_ network.in_period\[231\]\[0\] _07029_ VSS VSS VDD
+ VDD _07274_ sky130_fd_sc_hd__nand2_1
X_10866_ network.neuron_in231.counter\[0\] _07029_ _07274_
+ VSS VSS VDD VDD _02988_ sky130_fd_sc_hd__o21ai_0
X_10867_ network.neuron_in232.counter\[3\] network.in_period\[232\]\[2\]
+ _00940_ net374 VSS VSS VDD VDD _07275_ sky130_fd_sc_hd__o22ai_1
X_10868_ network.neuron_in232.counter\[2\] _00940_ net393
+ VSS VSS VDD VDD _07276_ sky130_fd_sc_hd__nand3_1
X_10869_ network.in_period\[232\]\[2\] net393 _07276_ VSS
+ VSS VDD VDD _07277_ sky130_fd_sc_hd__o21ai_0
X_10870_ _07005_ _07275_ _07277_ VSS VSS VDD VDD _02994_ sky130_fd_sc_hd__a21oi_1
X_10871_ network.in_period\[233\]\[1\] _07032_ VSS VSS VDD
+ VDD _07278_ sky130_fd_sc_hd__nand2_1
X_10872_ _01058_ _07032_ _07278_ VSS VSS VDD VDD _02997_ sky130_fd_sc_hd__o21ai_0
X_10873_ network.neuron_in150.counter\[1\] VSS VSS VDD VDD
+ _00493_ sky130_fd_sc_hd__inv_1
X_10874_ network.neuron_in234.counter\[2\] _01149_ VSS VSS
+ VDD VDD _07279_ sky130_fd_sc_hd__xnor2_1
X_10875_ net391 _07035_ network.in_period\[234\]\[2\] VSS
+ VSS VDD VDD _07280_ sky130_fd_sc_hd__a21oi_1
X_10876_ net391 _07279_ _07280_ VSS VSS VDD VDD _03002_ sky130_fd_sc_hd__a21oi_1
X_10877_ network.in_period\[234\]\[1\] _07036_ VSS VSS VDD
+ VDD _07281_ sky130_fd_sc_hd__nand2_1
X_10878_ _01150_ _07036_ _07281_ VSS VSS VDD VDD _03001_ sky130_fd_sc_hd__o21ai_0
X_10879_ network.neuron_in235.counter\[3\] _00589_ VSS VSS
+ VDD VDD _07282_ sky130_fd_sc_hd__nand2b_1
X_10880_ _07282_ _07009_ VSS VSS VDD VDD _07283_ sky130_fd_sc_hd__nand2b_1
X_10881_ net393 _07283_ VSS VSS VDD VDD _07284_ sky130_fd_sc_hd__nand2_1
X_10882_ network.in_period\[235\]\[1\] _07284_ VSS VSS VDD
+ VDD _07285_ sky130_fd_sc_hd__nand2_1
X_10883_ _00590_ _07284_ _07285_ VSS VSS VDD VDD _03005_ sky130_fd_sc_hd__o21ai_0
X_10884_ network.in_period\[235\]\[0\] _07284_ VSS VSS VDD
+ VDD _07286_ sky130_fd_sc_hd__nand2_1
X_10885_ network.neuron_in235.counter\[0\] _07284_ _07286_
+ VSS VSS VDD VDD _03004_ sky130_fd_sc_hd__o21ai_0
X_10886_ network.neuron_in137.counter\[1\] VSS VSS VDD VDD
+ _01134_ sky130_fd_sc_hd__inv_1
X_10887_ net422 net419 VSS VSS VDD VDD _07287_ sky130_fd_sc_hd__nand2b_1
Xclkbuf_leaf_63_clk clknet_5_10__leaf_clk VSS VSS VDD VDD
+ clknet_leaf_63_clk sky130_fd_sc_hd__clkbuf_16
X_10889_ net420 net423 VSS VSS VDD VDD _07289_ sky130_fd_sc_hd__or2_2
Xclkbuf_leaf_62_clk clknet_5_10__leaf_clk VSS VSS VDD VDD
+ clknet_leaf_62_clk sky130_fd_sc_hd__clkbuf_16
X_10891_ net420 _07162_ VSS VSS VDD VDD _07291_ sky130_fd_sc_hd__nand2_1
X_10892_ net411 _07289_ _07291_ VSS VSS VDD VDD _07292_ sky130_fd_sc_hd__o21ai_0
X_10893_ net411 net359 net341 _07292_ VSS VSS VDD VDD _07293_
+ sky130_fd_sc_hd__a31oi_1
X_10894_ net363 _07106_ net323 VSS VSS VDD VDD _07294_ sky130_fd_sc_hd__o21ai_0
X_10895_ net363 _07293_ _07294_ VSS VSS VDD VDD _07295_ sky130_fd_sc_hd__o21ai_0
Xclkbuf_leaf_61_clk clknet_5_8__leaf_clk VSS VSS VDD VDD clknet_leaf_61_clk
+ sky130_fd_sc_hd__clkbuf_16
X_10897_ net425 net418 VSS VSS VDD VDD _07297_ sky130_fd_sc_hd__nand2b_1
X_10898_ net360 net340 VSS VSS VDD VDD _07298_ sky130_fd_sc_hd__nand2_1
X_10899_ net366 net422 VSS VSS VDD VDD _07299_ sky130_fd_sc_hd__nand2_1
X_10900_ net325 _07101_ net420 VSS VSS VDD VDD _07300_ sky130_fd_sc_hd__o21ai_0
X_10901_ net346 _07115_ _07298_ _07299_ _07300_ VSS VSS VDD
+ VDD _07301_ sky130_fd_sc_hd__o221ai_1
Xclkbuf_leaf_60_clk clknet_5_8__leaf_clk VSS VSS VDD VDD clknet_leaf_60_clk
+ sky130_fd_sc_hd__clkbuf_16
X_10903_ net414 _07295_ _07301_ net411 VSS VSS VDD VDD _07303_
+ sky130_fd_sc_hd__a22oi_1
X_10904_ net365 net342 VSS VSS VDD VDD _07304_ sky130_fd_sc_hd__nor2_1
Xclkbuf_leaf_59_clk clknet_5_8__leaf_clk VSS VSS VDD VDD clknet_leaf_59_clk
+ sky130_fd_sc_hd__clkbuf_16
X_10906_ net345 _07304_ net362 VSS VSS VDD VDD _07306_ sky130_fd_sc_hd__o21ai_0
X_10907_ net358 net366 VSS VSS VDD VDD _07307_ sky130_fd_sc_hd__nand2_1
X_10908_ net408 _07307_ VSS VSS VDD VDD _07308_ sky130_fd_sc_hd__nor2_1
X_10909_ net420 _07155_ _07306_ net305 VSS VSS VDD VDD _07309_
+ sky130_fd_sc_hd__o211ai_1
X_10910_ net409 VSS VSS VDD VDD _07310_ sky130_fd_sc_hd__inv_1
Xclkbuf_leaf_58_clk clknet_5_8__leaf_clk VSS VSS VDD VDD clknet_leaf_58_clk
+ sky130_fd_sc_hd__clkbuf_16
X_10912_ net410 net339 VSS VSS VDD VDD _07312_ sky130_fd_sc_hd__nor2_1
X_10913_ net363 _07056_ VSS VSS VDD VDD _07313_ sky130_fd_sc_hd__nand2_1
X_10914_ net416 _07313_ VSS VSS VDD VDD _07314_ sky130_fd_sc_hd__nor2_1
Xclkbuf_leaf_57_clk clknet_5_8__leaf_clk VSS VSS VDD VDD clknet_leaf_57_clk
+ sky130_fd_sc_hd__clkbuf_16
X_10916_ net363 net353 VSS VSS VDD VDD _07316_ sky130_fd_sc_hd__nor2_1
Xclkbuf_leaf_56_clk clknet_5_8__leaf_clk VSS VSS VDD VDD clknet_leaf_56_clk
+ sky130_fd_sc_hd__clkbuf_16
X_10918_ net349 _07099_ net366 VSS VSS VDD VDD _07318_ sky130_fd_sc_hd__a21oi_1
X_10919_ net416 net348 _07046_ VSS VSS VDD VDD _07319_ sky130_fd_sc_hd__o21ai_0
X_10920_ _07046_ _07314_ _07316_ _07318_ _07319_ VSS VSS VDD
+ VDD _07320_ sky130_fd_sc_hd__o32ai_1
Xclkbuf_leaf_55_clk clknet_5_9__leaf_clk VSS VSS VDD VDD clknet_leaf_55_clk
+ sky130_fd_sc_hd__clkbuf_16
X_10922_ net420 net417 VSS VSS VDD VDD _07322_ sky130_fd_sc_hd__or2_2
X_10923_ net424 _07322_ VSS VSS VDD VDD _07323_ sky130_fd_sc_hd__nand2_1
X_10924_ net365 net363 VSS VSS VDD VDD _07324_ sky130_fd_sc_hd__nand2_1
Xclkbuf_leaf_54_clk clknet_5_9__leaf_clk VSS VSS VDD VDD clknet_leaf_54_clk
+ sky130_fd_sc_hd__clkbuf_16
X_10926_ net349 net319 net415 VSS VSS VDD VDD _07326_ sky130_fd_sc_hd__a21oi_1
X_10927_ net415 _07186_ _07323_ _07326_ VSS VSS VDD VDD _07327_
+ sky130_fd_sc_hd__a31oi_1
Xclkbuf_leaf_53_clk clknet_5_9__leaf_clk VSS VSS VDD VDD clknet_leaf_53_clk
+ sky130_fd_sc_hd__clkbuf_16
X_10929_ net420 net424 VSS VSS VDD VDD _07329_ sky130_fd_sc_hd__nand2_1
X_10930_ net422 _07329_ VSS VSS VDD VDD _07330_ sky130_fd_sc_hd__nand2_1
X_10931_ net424 net420 VSS VSS VDD VDD _07331_ sky130_fd_sc_hd__nand2b_1
X_10932_ net415 _07331_ VSS VSS VDD VDD _07332_ sky130_fd_sc_hd__nand2_1
X_10933_ net415 _07330_ _07332_ net418 VSS VSS VDD VDD _07333_
+ sky130_fd_sc_hd__o211ai_1
X_10934_ _07327_ _07333_ _07254_ VSS VSS VDD VDD _07334_ sky130_fd_sc_hd__a21oi_1
X_10935_ _07312_ _07320_ _07334_ VSS VSS VDD VDD _07335_ sky130_fd_sc_hd__a21oi_1
X_10936_ net408 _07303_ _07309_ _07335_ VSS VSS VDD VDD _07336_
+ sky130_fd_sc_hd__o211ai_1
X_10937_ _07178_ _07249_ VSS VSS VDD VDD _07337_ sky130_fd_sc_hd__nand2_1
Xclkbuf_leaf_52_clk clknet_5_9__leaf_clk VSS VSS VDD VDD clknet_leaf_52_clk
+ sky130_fd_sc_hd__clkbuf_16
Xclkbuf_leaf_51_clk clknet_5_9__leaf_clk VSS VSS VDD VDD clknet_leaf_51_clk
+ sky130_fd_sc_hd__clkbuf_16
Xclkbuf_leaf_50_clk clknet_5_9__leaf_clk VSS VSS VDD VDD clknet_leaf_50_clk
+ sky130_fd_sc_hd__clkbuf_16
Xclkbuf_leaf_49_clk clknet_5_11__leaf_clk VSS VSS VDD VDD
+ clknet_leaf_49_clk sky130_fd_sc_hd__clkbuf_16
X_10942_ net420 net346 _07201_ _07180_ VSS VSS VDD VDD _07342_
+ sky130_fd_sc_hd__a31oi_1
Xclkbuf_leaf_48_clk clknet_5_14__leaf_clk VSS VSS VDD VDD
+ clknet_leaf_48_clk sky130_fd_sc_hd__clkbuf_16
X_10944_ _07337_ _07322_ _07342_ net414 VSS VSS VDD VDD _07344_
+ sky130_fd_sc_hd__o22ai_1
Xclkbuf_leaf_47_clk clknet_5_12__leaf_clk VSS VSS VDD VDD
+ clknet_leaf_47_clk sky130_fd_sc_hd__clkbuf_16
X_10946_ net306 _07336_ _07344_ net307 VSS VSS VDD VDD _01510_
+ sky130_fd_sc_hd__a22o_1
X_10947_ network.neuron_in149.counter\[1\] VSS VSS VDD VDD
+ _00505_ sky130_fd_sc_hd__inv_1
X_10948_ network.neuron_hid0.ROM0.address\[7\] network.neuron_hid0.ROM0.read_en
+ net406 net344 VSS VSS VDD VDD _07346_ sky130_fd_sc_hd__nand4_1
Xclkbuf_leaf_46_clk clknet_5_12__leaf_clk VSS VSS VDD VDD
+ clknet_leaf_46_clk sky130_fd_sc_hd__clkbuf_16
Xclkbuf_leaf_45_clk clknet_5_12__leaf_clk VSS VSS VDD VDD
+ clknet_leaf_45_clk sky130_fd_sc_hd__clkbuf_16
Xclkbuf_leaf_44_clk clknet_5_12__leaf_clk VSS VSS VDD VDD
+ clknet_leaf_44_clk sky130_fd_sc_hd__clkbuf_16
X_10952_ net415 net422 VSS VSS VDD VDD _07350_ sky130_fd_sc_hd__nor2_1
X_10953_ net415 _07099_ net338 VSS VSS VDD VDD _07351_ sky130_fd_sc_hd__a21oi_1
X_10954_ _07127_ _07146_ _07351_ net417 VSS VSS VDD VDD _07352_
+ sky130_fd_sc_hd__o22ai_1
Xclkbuf_leaf_43_clk clknet_5_9__leaf_clk VSS VSS VDD VDD clknet_leaf_43_clk
+ sky130_fd_sc_hd__clkbuf_16
Xclkbuf_leaf_42_clk clknet_5_12__leaf_clk VSS VSS VDD VDD
+ clknet_leaf_42_clk sky130_fd_sc_hd__clkbuf_16
X_10957_ net415 net362 VSS VSS VDD VDD _07355_ sky130_fd_sc_hd__nor2_1
X_10958_ net415 net364 net317 VSS VSS VDD VDD _07356_ sky130_fd_sc_hd__a21oi_1
X_10959_ net422 net343 net351 VSS VSS VDD VDD _07357_ sky130_fd_sc_hd__a21oi_1
Xclkbuf_leaf_41_clk clknet_5_12__leaf_clk VSS VSS VDD VDD
+ clknet_leaf_41_clk sky130_fd_sc_hd__clkbuf_16
X_10961_ net424 _07356_ _07357_ net415 net420 VSS VSS VDD
+ VDD _07359_ sky130_fd_sc_hd__o221ai_1
X_10962_ net420 _07352_ _07359_ VSS VSS VDD VDD _07360_ sky130_fd_sc_hd__o21ai_0
X_10963_ net415 net420 VSS VSS VDD VDD _07361_ sky130_fd_sc_hd__nand2_1
X_10964_ net420 net422 net418 VSS VSS VDD VDD _07362_ sky130_fd_sc_hd__nor3b_1
X_10965_ net420 net363 _07127_ VSS VSS VDD VDD _07363_ sky130_fd_sc_hd__nand3_1
X_10966_ _07207_ _07363_ net415 VSS VSS VDD VDD _07364_ sky130_fd_sc_hd__a21oi_1
X_10967_ net420 net424 net418 VSS VSS VDD VDD _07365_ sky130_fd_sc_hd__or3_1
X_10968_ net420 net325 VSS VSS VDD VDD _07366_ sky130_fd_sc_hd__nand2_1
X_10969_ _07365_ _07366_ net366 VSS VSS VDD VDD _07367_ sky130_fd_sc_hd__a21oi_1
X_10970_ _07362_ _07364_ _07367_ VSS VSS VDD VDD _07368_ sky130_fd_sc_hd__nor3_1
X_10971_ net417 net421 VSS VSS VDD VDD _07369_ sky130_fd_sc_hd__nand2b_1
Xclkbuf_leaf_40_clk clknet_5_12__leaf_clk VSS VSS VDD VDD
+ clknet_leaf_40_clk sky130_fd_sc_hd__clkbuf_16
X_10973_ _07186_ net336 net366 VSS VSS VDD VDD _07371_ sky130_fd_sc_hd__a21oi_1
X_10974_ _07074_ _07371_ net363 VSS VSS VDD VDD _07372_ sky130_fd_sc_hd__o21ai_0
X_10975_ net343 net338 net365 VSS VSS VDD VDD _07373_ sky130_fd_sc_hd__o21ai_0
X_10976_ net342 _07372_ _07373_ net358 VSS VSS VDD VDD _07374_
+ sky130_fd_sc_hd__a31o_2
X_10977_ net355 _07361_ _07368_ net410 _07374_ VSS VSS VDD
+ VDD _07375_ sky130_fd_sc_hd__o221ai_1
X_10978_ net415 net422 VSS VSS VDD VDD _07376_ sky130_fd_sc_hd__nand2_1
X_10979_ net366 _07201_ net420 VSS VSS VDD VDD _07377_ sky130_fd_sc_hd__a21oi_1
X_10980_ _07304_ _07377_ net418 VSS VSS VDD VDD _07378_ sky130_fd_sc_hd__o21ai_0
X_10981_ net325 _07376_ _07378_ _07365_ VSS VSS VDD VDD _07379_
+ sky130_fd_sc_hd__o211ai_1
X_10982_ net418 net357 net413 VSS VSS VDD VDD _07380_ sky130_fd_sc_hd__o21ai_0
X_10983_ net413 _07313_ _07380_ net419 VSS VSS VDD VDD _07381_
+ sky130_fd_sc_hd__o211ai_1
X_10984_ net413 net319 VSS VSS VDD VDD _07382_ sky130_fd_sc_hd__nand2_1
X_10985_ net351 _07382_ VSS VSS VDD VDD _07383_ sky130_fd_sc_hd__nand2_1
X_10986_ _07381_ _07383_ net410 VSS VSS VDD VDD _07384_ sky130_fd_sc_hd__a21oi_1
X_10987_ net413 net365 VSS VSS VDD VDD _07385_ sky130_fd_sc_hd__nand2_1
X_10988_ _07164_ _07385_ VSS VSS VDD VDD _07386_ sky130_fd_sc_hd__nor2_1
X_10989_ net410 _07379_ _07384_ net409 _07386_ VSS VSS VDD
+ VDD _07387_ sky130_fd_sc_hd__a2111oi_0
X_10990_ _07041_ network.neuron_hid0.ROM0.read_en net406 VSS
+ VSS VDD VDD _07388_ sky130_fd_sc_hd__nand3_1
X_10991_ net409 _07375_ _07387_ net316 VSS VSS VDD VDD _07389_
+ sky130_fd_sc_hd__a211o_1
X_10992_ net318 _07360_ _07389_ VSS VSS VDD VDD _01511_ sky130_fd_sc_hd__o21ai_0
X_10993_ network.neuron_in030.counter\[1\] VSS VSS VDD VDD
+ _00675_ sky130_fd_sc_hd__inv_1
X_10994_ network.neuron_in181.counter\[1\] VSS VSS VDD VDD
+ _00628_ sky130_fd_sc_hd__inv_1
X_10995_ network.neuron_in237.counter\[0\] VSS VSS VDD VDD
+ _00934_ sky130_fd_sc_hd__inv_1
X_10996_ network.neuron_in237.counter\[2\] network.neuron_in237.counter\[3\]
+ VSS VSS VDD VDD _07390_ sky130_fd_sc_hd__nor2_1
X_10997_ _00936_ _07390_ VSS VSS VDD VDD _07391_ sky130_fd_sc_hd__nand2_1
X_10998_ net391 _07391_ VSS VSS VDD VDD _07392_ sky130_fd_sc_hd__nand2_1
X_10999_ network.in_period\[237\]\[0\] _07392_ VSS VSS VDD
+ VDD _07393_ sky130_fd_sc_hd__nand2_1
X_11000_ network.neuron_in237.counter\[0\] _07392_ _07393_
+ VSS VSS VDD VDD _03012_ sky130_fd_sc_hd__o21ai_0
X_11001_ network.neuron_in007.counter\[1\] VSS VSS VDD VDD
+ _00469_ sky130_fd_sc_hd__inv_1
X_11002_ network.neuron_in238.counter\[0\] VSS VSS VDD VDD
+ _00786_ sky130_fd_sc_hd__inv_1
X_11003_ network.neuron_in238.counter\[3\] _00788_ VSS VSS
+ VDD VDD _07394_ sky130_fd_sc_hd__nand2b_1
X_11004_ network.neuron_in238.counter\[2\] VSS VSS VDD VDD
+ _07395_ sky130_fd_sc_hd__inv_1
X_11005_ _07394_ _07395_ VSS VSS VDD VDD _07396_ sky130_fd_sc_hd__nand2b_1
X_11006_ net393 _07396_ VSS VSS VDD VDD _07397_ sky130_fd_sc_hd__nand2_1
X_11007_ network.in_period\[238\]\[0\] _07397_ VSS VSS VDD
+ VDD _07398_ sky130_fd_sc_hd__nand2_1
X_11008_ network.neuron_in238.counter\[0\] _07397_ _07398_
+ VSS VSS VDD VDD _03016_ sky130_fd_sc_hd__o21ai_0
X_11009_ network.neuron_in239.counter\[3\] _00490_ VSS VSS
+ VDD VDD _07399_ sky130_fd_sc_hd__nand2b_1
X_11010_ network.neuron_in239.counter\[2\] VSS VSS VDD VDD
+ _07400_ sky130_fd_sc_hd__inv_1
X_11011_ _07399_ _07400_ VSS VSS VDD VDD _07401_ sky130_fd_sc_hd__nand2b_1
X_11012_ net391 _07401_ VSS VSS VDD VDD _07402_ sky130_fd_sc_hd__nand2_1
X_11013_ network.in_period\[239\]\[0\] _07402_ VSS VSS VDD
+ VDD _07403_ sky130_fd_sc_hd__nand2_1
X_11014_ network.neuron_in239.counter\[0\] _07402_ _07403_
+ VSS VSS VDD VDD _03020_ sky130_fd_sc_hd__o21ai_0
X_11015_ network.neuron_in102.counter\[1\] VSS VSS VDD VDD
+ _00995_ sky130_fd_sc_hd__inv_1
X_11016_ network.neuron_in240.counter\[0\] VSS VSS VDD VDD
+ _01191_ sky130_fd_sc_hd__inv_1
X_11017_ network.neuron_in240.counter\[2\] network.neuron_in240.counter\[3\]
+ VSS VSS VDD VDD _07404_ sky130_fd_sc_hd__nor2_1
X_11018_ _01193_ _07404_ VSS VSS VDD VDD _07405_ sky130_fd_sc_hd__nand2_1
X_11019_ net400 _07405_ VSS VSS VDD VDD _07406_ sky130_fd_sc_hd__nand2_1
X_11020_ network.in_period\[240\]\[0\] _07406_ VSS VSS VDD
+ VDD _07407_ sky130_fd_sc_hd__nand2_1
X_11021_ network.neuron_in240.counter\[0\] _07406_ _07407_
+ VSS VSS VDD VDD _03024_ sky130_fd_sc_hd__o21ai_0
X_11022_ network.in_period\[237\]\[1\] _07392_ VSS VSS VDD
+ VDD _07408_ sky130_fd_sc_hd__nand2_1
X_11023_ _00937_ _07392_ _07408_ VSS VSS VDD VDD _03013_ sky130_fd_sc_hd__o21ai_0
X_11024_ network.in_period\[238\]\[1\] _07397_ VSS VSS VDD
+ VDD _07409_ sky130_fd_sc_hd__nand2_1
X_11025_ _00789_ _07397_ _07409_ VSS VSS VDD VDD _03017_ sky130_fd_sc_hd__o21ai_0
X_11026_ network.neuron_in006.counter\[1\] VSS VSS VDD VDD
+ _00510_ sky130_fd_sc_hd__inv_1
X_11027_ network.neuron_in102.counter\[0\] VSS VSS VDD VDD
+ _00994_ sky130_fd_sc_hd__inv_1
X_11028_ network.in_period\[239\]\[1\] _07402_ VSS VSS VDD
+ VDD _07410_ sky130_fd_sc_hd__nand2_1
X_11029_ _00491_ _07402_ _07410_ VSS VSS VDD VDD _03021_ sky130_fd_sc_hd__o21ai_0
X_11030_ network.neuron_in147.counter\[1\] VSS VSS VDD VDD
+ _00457_ sky130_fd_sc_hd__inv_1
X_11031_ network.in_period\[240\]\[1\] _07406_ VSS VSS VDD
+ VDD _07411_ sky130_fd_sc_hd__nand2_1
X_11032_ _01194_ _07406_ _07411_ VSS VSS VDD VDD _03025_ sky130_fd_sc_hd__o21ai_0
X_11033_ network.neuron_in142.counter\[1\] VSS VSS VDD VDD
+ _00540_ sky130_fd_sc_hd__inv_1
X_11034_ network.neuron_in153.counter\[0\] VSS VSS VDD VDD
+ _00472_ sky130_fd_sc_hd__inv_1
X_11035_ network.in_period\[153\]\[0\] _06404_ VSS VSS VDD
+ VDD _07412_ sky130_fd_sc_hd__nand2_1
X_11036_ network.neuron_in153.counter\[0\] _06404_ _07412_
+ VSS VSS VDD VDD _02676_ sky130_fd_sc_hd__o21ai_0
X_11037_ network.neuron_in237.counter\[2\] _00936_ VSS VSS
+ VDD VDD _07413_ sky130_fd_sc_hd__xnor2_1
X_11038_ net391 _07391_ network.in_period\[237\]\[2\] VSS
+ VSS VDD VDD _07414_ sky130_fd_sc_hd__a21oi_1
X_11039_ net391 _07413_ _07414_ VSS VSS VDD VDD _03014_ sky130_fd_sc_hd__a21oi_1
X_11040_ network.neuron_in238.counter\[3\] network.in_period\[238\]\[2\]
+ _00788_ net374 VSS VSS VDD VDD _07415_ sky130_fd_sc_hd__o22ai_1
Xclkbuf_leaf_39_clk clknet_5_13__leaf_clk VSS VSS VDD VDD
+ clknet_leaf_39_clk sky130_fd_sc_hd__clkbuf_16
X_11042_ network.neuron_in238.counter\[2\] _00788_ net393
+ VSS VSS VDD VDD _07417_ sky130_fd_sc_hd__nand3_1
X_11043_ network.in_period\[238\]\[2\] net393 _07417_ VSS
+ VSS VDD VDD _07418_ sky130_fd_sc_hd__o21ai_0
X_11044_ _07395_ _07415_ _07418_ VSS VSS VDD VDD _03018_ sky130_fd_sc_hd__a21oi_1
X_11045_ network.neuron_in178.counter\[1\] VSS VSS VDD VDD
+ _00991_ sky130_fd_sc_hd__inv_1
X_11046_ network.neuron_in145.counter\[2\] _06690_ VSS VSS
+ VDD VDD _07419_ sky130_fd_sc_hd__or2_2
X_11047_ net400 _07419_ VSS VSS VDD VDD _07420_ sky130_fd_sc_hd__nand2_1
X_11048_ network.in_period\[145\]\[1\] _07420_ VSS VSS VDD
+ VDD _07421_ sky130_fd_sc_hd__nand2_1
X_11049_ _00622_ _07420_ _07421_ VSS VSS VDD VDD _02645_ sky130_fd_sc_hd__o21ai_0
X_11050_ _00597_ network.neuron_in138.counter\[2\] VSS VSS
+ VDD VDD _07422_ sky130_fd_sc_hd__xnor2_1
X_11051_ net392 _06925_ network.in_period\[138\]\[2\] VSS
+ VSS VDD VDD _07423_ sky130_fd_sc_hd__a21oi_1
X_11052_ net392 _07422_ _07423_ VSS VSS VDD VDD _02618_ sky130_fd_sc_hd__a21oi_1
X_11053_ network.neuron_in089.counter\[0\] VSS VSS VDD VDD
+ _01221_ sky130_fd_sc_hd__inv_1
X_11054_ network.neuron_in017.counter\[0\] VSS VSS VDD VDD
+ _00410_ sky130_fd_sc_hd__inv_1
X_11055_ network.neuron_in025.counter\[1\] VSS VSS VDD VDD
+ _00453_ sky130_fd_sc_hd__inv_1
X_11056_ network.neuron_in051.counter\[1\] VSS VSS VDD VDD
+ _00522_ sky130_fd_sc_hd__inv_1
X_11057_ network.neuron_in050.counter\[1\] VSS VSS VDD VDD
+ _00336_ sky130_fd_sc_hd__inv_1
X_11058_ network.neuron_in184.counter\[1\] VSS VSS VDD VDD
+ _01112_ sky130_fd_sc_hd__inv_1
X_11059_ network.neuron_in129.counter\[1\] VSS VSS VDD VDD
+ _00987_ sky130_fd_sc_hd__inv_1
X_11060_ network.neuron_in073.counter\[1\] VSS VSS VDD VDD
+ _00201_ sky130_fd_sc_hd__inv_1
X_11061_ network.neuron_in239.counter\[3\] network.in_period\[239\]\[2\]
+ net373 _00490_ VSS VSS VDD VDD _07424_ sky130_fd_sc_hd__o22ai_1
X_11062_ network.neuron_in239.counter\[2\] _00490_ net391
+ VSS VSS VDD VDD _07425_ sky130_fd_sc_hd__nand3_1
X_11063_ network.in_period\[239\]\[2\] net391 _07425_ VSS
+ VSS VDD VDD _07426_ sky130_fd_sc_hd__o21ai_0
X_11064_ _07400_ _07424_ _07426_ VSS VSS VDD VDD _03022_ sky130_fd_sc_hd__a21oi_1
X_11065_ network.neuron_in072.counter\[1\] VSS VSS VDD VDD
+ _00530_ sky130_fd_sc_hd__inv_1
X_11066_ network.neuron_in240.counter\[2\] _01193_ VSS VSS
+ VDD VDD _07427_ sky130_fd_sc_hd__nor2b_1
X_11067_ _01193_ network.neuron_in240.counter\[2\] VSS VSS
+ VDD VDD _07428_ sky130_fd_sc_hd__nor2b_1
X_11068_ net368 _07404_ VSS VSS VDD VDD _07429_ sky130_fd_sc_hd__nor2_1
X_11069_ net368 _07427_ _07428_ _07429_ network.in_period\[240\]\[2\]
+ VSS VSS VDD VDD _03026_ sky130_fd_sc_hd__o32a_1
X_11070_ network.neuron_in097.counter\[1\] VSS VSS VDD VDD
+ _01214_ sky130_fd_sc_hd__inv_1
X_11071_ network.neuron_in243.counter\[2\] _00780_ VSS VSS
+ VDD VDD _07430_ sky130_fd_sc_hd__nor2b_1
X_11072_ network.neuron_in243.counter\[3\] _07430_ VSS VSS
+ VDD VDD _07431_ sky130_fd_sc_hd__nand2b_1
X_11073_ net399 _07431_ VSS VSS VDD VDD _07432_ sky130_fd_sc_hd__nand2_1
X_11074_ network.in_period\[243\]\[1\] _07432_ VSS VSS VDD
+ VDD _07433_ sky130_fd_sc_hd__nand2_1
X_11075_ _00781_ _07432_ _07433_ VSS VSS VDD VDD _03037_ sky130_fd_sc_hd__o21ai_0
X_11076_ network.neuron_in245.counter\[2\] network.neuron_in245.counter\[3\]
+ VSS VSS VDD VDD _07434_ sky130_fd_sc_hd__nor2_1
X_11077_ _01197_ _07434_ VSS VSS VDD VDD _07435_ sky130_fd_sc_hd__nand2_1
X_11078_ net399 _07435_ VSS VSS VDD VDD _07436_ sky130_fd_sc_hd__nand2_1
X_11079_ network.in_period\[245\]\[0\] _07436_ VSS VSS VDD
+ VDD _07437_ sky130_fd_sc_hd__nand2_1
X_11080_ network.neuron_in245.counter\[0\] _07436_ _07437_
+ VSS VSS VDD VDD _03044_ sky130_fd_sc_hd__o21ai_0
X_11081_ network.neuron_in039.counter\[0\] VSS VSS VDD VDD
+ _00327_ sky130_fd_sc_hd__inv_1
X_11082_ network.neuron_in243.counter\[2\] VSS VSS VDD VDD
+ _07438_ sky130_fd_sc_hd__inv_1
X_11083_ network.in_period\[243\]\[2\] network.neuron_in243.counter\[3\]
+ _00780_ net368 VSS VSS VDD VDD _07439_ sky130_fd_sc_hd__o22ai_1
X_11084_ network.neuron_in243.counter\[2\] _00780_ net399
+ VSS VSS VDD VDD _07440_ sky130_fd_sc_hd__nand3_1
X_11085_ network.in_period\[243\]\[2\] net399 _07440_ VSS
+ VSS VDD VDD _07441_ sky130_fd_sc_hd__o21ai_0
X_11086_ _07438_ _07439_ _07441_ VSS VSS VDD VDD _03038_ sky130_fd_sc_hd__a21oi_1
Xclkbuf_leaf_38_clk clknet_5_13__leaf_clk VSS VSS VDD VDD
+ clknet_leaf_38_clk sky130_fd_sc_hd__clkbuf_16
X_11088_ network.neuron_in244.counter\[2\] _00924_ VSS VSS
+ VDD VDD _07443_ sky130_fd_sc_hd__nor2b_1
X_11089_ network.neuron_in244.counter\[3\] _07443_ VSS VSS
+ VDD VDD _07444_ sky130_fd_sc_hd__nand2b_1
X_11090_ net400 _07444_ VSS VSS VDD VDD _07445_ sky130_fd_sc_hd__nand2_1
X_11091_ network.in_period\[244\]\[1\] _07445_ VSS VSS VDD
+ VDD _07446_ sky130_fd_sc_hd__nand2_1
X_11092_ _00925_ _07445_ _07446_ VSS VSS VDD VDD _03041_ sky130_fd_sc_hd__o21ai_0
X_11093_ network.in_period\[245\]\[1\] _07436_ VSS VSS VDD
+ VDD _07447_ sky130_fd_sc_hd__nand2_1
X_11094_ _01198_ _07436_ _07447_ VSS VSS VDD VDD _03045_ sky130_fd_sc_hd__o21ai_0
X_11095_ network.neuron_in122.counter\[1\] VSS VSS VDD VDD
+ _00536_ sky130_fd_sc_hd__inv_1
X_11096_ network.neuron_in149.counter\[0\] VSS VSS VDD VDD
+ _00504_ sky130_fd_sc_hd__inv_1
X_11097_ network.neuron_in249.counter\[1\] VSS VSS VDD VDD
+ _00403_ sky130_fd_sc_hd__inv_1
X_11098_ network.neuron_in129.counter\[0\] VSS VSS VDD VDD
+ _00986_ sky130_fd_sc_hd__inv_1
X_11099_ network.neuron_in176.counter\[3\] _01061_ VSS VSS
+ VDD VDD _07448_ sky130_fd_sc_hd__nand2b_1
X_11100_ network.neuron_in176.counter\[2\] VSS VSS VDD VDD
+ _07449_ sky130_fd_sc_hd__inv_1
X_11101_ _07448_ _07449_ VSS VSS VDD VDD _07450_ sky130_fd_sc_hd__nand2b_1
X_11102_ net382 _07450_ VSS VSS VDD VDD _07451_ sky130_fd_sc_hd__nand2_1
X_11103_ network.in_period\[176\]\[0\] _07451_ VSS VSS VDD
+ VDD _07452_ sky130_fd_sc_hd__nand2_1
X_11104_ network.neuron_in176.counter\[0\] _07451_ _07452_
+ VSS VSS VDD VDD _02768_ sky130_fd_sc_hd__o21ai_0
X_11105_ network.neuron_in171.counter\[3\] _01025_ VSS VSS
+ VDD VDD _07453_ sky130_fd_sc_hd__nand2b_1
X_11106_ network.neuron_in171.counter\[2\] VSS VSS VDD VDD
+ _07454_ sky130_fd_sc_hd__inv_1
X_11107_ _07453_ _07454_ VSS VSS VDD VDD _07455_ sky130_fd_sc_hd__nand2b_1
X_11108_ net401 _07455_ VSS VSS VDD VDD _07456_ sky130_fd_sc_hd__nand2_1
X_11109_ network.in_period\[171\]\[1\] _07456_ VSS VSS VDD
+ VDD _07457_ sky130_fd_sc_hd__nand2_1
X_11110_ _01026_ _07456_ _07457_ VSS VSS VDD VDD _02749_ sky130_fd_sc_hd__o21ai_0
X_11111_ network.in_period\[176\]\[1\] _07451_ VSS VSS VDD
+ VDD _07458_ sky130_fd_sc_hd__nand2_1
X_11112_ _01062_ _07451_ _07458_ VSS VSS VDD VDD _02769_ sky130_fd_sc_hd__o21ai_0
X_11113_ network.neuron_in168.counter\[0\] VSS VSS VDD VDD
+ _00954_ sky130_fd_sc_hd__inv_1
X_11114_ network.neuron_in168.counter\[3\] _00956_ VSS VSS
+ VDD VDD _07459_ sky130_fd_sc_hd__nand2b_1
X_11115_ network.neuron_in168.counter\[2\] VSS VSS VDD VDD
+ _07460_ sky130_fd_sc_hd__inv_1
X_11116_ _07459_ _07460_ VSS VSS VDD VDD _07461_ sky130_fd_sc_hd__nand2b_1
X_11117_ net401 _07461_ VSS VSS VDD VDD _07462_ sky130_fd_sc_hd__nand2_1
X_11118_ network.in_period\[168\]\[0\] _07462_ VSS VSS VDD
+ VDD _07463_ sky130_fd_sc_hd__nand2_1
X_11119_ network.neuron_in168.counter\[0\] _07462_ _07463_
+ VSS VSS VDD VDD _02736_ sky130_fd_sc_hd__o21ai_0
X_11120_ network.neuron_in171.counter\[3\] network.in_period\[171\]\[2\]
+ _06361_ _01025_ VSS VSS VDD VDD _07464_ sky130_fd_sc_hd__o22ai_1
X_11121_ network.neuron_in171.counter\[2\] _01025_ net401
+ VSS VSS VDD VDD _07465_ sky130_fd_sc_hd__nand3_1
X_11122_ network.in_period\[171\]\[2\] net401 _07465_ VSS
+ VSS VDD VDD _07466_ sky130_fd_sc_hd__o21ai_0
X_11123_ _07454_ _07464_ _07466_ VSS VSS VDD VDD _02750_ sky130_fd_sc_hd__a21oi_1
X_11124_ network.neuron_in173.counter\[0\] VSS VSS VDD VDD
+ _00842_ sky130_fd_sc_hd__inv_1
X_11125_ network.neuron_in173.counter\[2\] network.neuron_in173.counter\[3\]
+ VSS VSS VDD VDD _07467_ sky130_fd_sc_hd__nor2_1
X_11126_ _00844_ _07467_ VSS VSS VDD VDD _07468_ sky130_fd_sc_hd__nand2_1
X_11127_ net394 _07468_ VSS VSS VDD VDD _07469_ sky130_fd_sc_hd__nand2_1
X_11128_ network.in_period\[173\]\[0\] _07469_ VSS VSS VDD
+ VDD _07470_ sky130_fd_sc_hd__nand2_1
X_11129_ network.neuron_in173.counter\[0\] _07469_ _07470_
+ VSS VSS VDD VDD _02756_ sky130_fd_sc_hd__o21ai_0
X_11130_ network.neuron_in176.counter\[3\] network.in_period\[176\]\[2\]
+ net367 _01061_ VSS VSS VDD VDD _07471_ sky130_fd_sc_hd__o22ai_1
X_11131_ network.neuron_in176.counter\[2\] _01061_ net407
+ VSS VSS VDD VDD _07472_ sky130_fd_sc_hd__nand3_1
X_11132_ network.in_period\[176\]\[2\] net407 _07472_ VSS
+ VSS VDD VDD _07473_ sky130_fd_sc_hd__o21ai_0
X_11133_ _07449_ _07471_ _07473_ VSS VSS VDD VDD _02770_ sky130_fd_sc_hd__a21oi_1
X_11134_ network.neuron_in167.counter\[2\] network.neuron_in167.counter\[3\]
+ VSS VSS VDD VDD _07474_ sky130_fd_sc_hd__nor2_1
X_11135_ _00928_ _07474_ VSS VSS VDD VDD _07475_ sky130_fd_sc_hd__nand2_1
X_11136_ net402 _07475_ VSS VSS VDD VDD _07476_ sky130_fd_sc_hd__nand2_1
X_11137_ network.in_period\[167\]\[1\] _07476_ VSS VSS VDD
+ VDD _07477_ sky130_fd_sc_hd__nand2_1
X_11138_ _00929_ _07476_ _07477_ VSS VSS VDD VDD _02733_ sky130_fd_sc_hd__o21ai_0
X_11139_ network.in_period\[168\]\[1\] _07462_ VSS VSS VDD
+ VDD _07478_ sky130_fd_sc_hd__nand2_1
X_11140_ _00957_ _07462_ _07478_ VSS VSS VDD VDD _02737_ sky130_fd_sc_hd__o21ai_0
X_11141_ network.neuron_in169.counter\[0\] VSS VSS VDD VDD
+ _00978_ sky130_fd_sc_hd__inv_1
X_11142_ network.neuron_in169.counter\[2\] network.neuron_in169.counter\[3\]
+ VSS VSS VDD VDD _07479_ sky130_fd_sc_hd__nor2_1
X_11143_ _00980_ _07479_ VSS VSS VDD VDD _07480_ sky130_fd_sc_hd__nand2_1
X_11144_ net401 _07480_ VSS VSS VDD VDD _07481_ sky130_fd_sc_hd__nand2_1
X_11145_ network.in_period\[169\]\[0\] _07481_ VSS VSS VDD
+ VDD _07482_ sky130_fd_sc_hd__nand2_1
X_11146_ network.neuron_in169.counter\[0\] _07481_ _07482_
+ VSS VSS VDD VDD _02740_ sky130_fd_sc_hd__o21ai_0
X_11147_ network.neuron_in170.counter\[2\] network.neuron_in170.counter\[3\]
+ VSS VSS VDD VDD _07483_ sky130_fd_sc_hd__nor2_1
X_11148_ _01016_ _07483_ VSS VSS VDD VDD _07484_ sky130_fd_sc_hd__nand2_1
X_11149_ net401 _07484_ VSS VSS VDD VDD _07485_ sky130_fd_sc_hd__nand2_1
X_11150_ network.in_period\[170\]\[0\] _07485_ VSS VSS VDD
+ VDD _07486_ sky130_fd_sc_hd__nand2_1
X_11151_ network.neuron_in170.counter\[0\] _07485_ _07486_
+ VSS VSS VDD VDD _02744_ sky130_fd_sc_hd__o21ai_0
X_11152_ network.neuron_in172.counter\[3\] _01035_ VSS VSS
+ VDD VDD _07487_ sky130_fd_sc_hd__nand2b_1
X_11153_ network.neuron_in172.counter\[2\] VSS VSS VDD VDD
+ _07488_ sky130_fd_sc_hd__inv_1
X_11154_ _07487_ _07488_ VSS VSS VDD VDD _07489_ sky130_fd_sc_hd__nand2b_1
X_11155_ net401 _07489_ VSS VSS VDD VDD _07490_ sky130_fd_sc_hd__nand2_1
X_11156_ network.in_period\[172\]\[1\] _07490_ VSS VSS VDD
+ VDD _07491_ sky130_fd_sc_hd__nand2_1
X_11157_ _01036_ _07490_ _07491_ VSS VSS VDD VDD _02753_ sky130_fd_sc_hd__o21ai_0
X_11158_ network.in_period\[173\]\[1\] _07469_ VSS VSS VDD
+ VDD _07492_ sky130_fd_sc_hd__nand2_1
X_11159_ _00845_ _07469_ _07492_ VSS VSS VDD VDD _02757_ sky130_fd_sc_hd__o21ai_0
Xclkbuf_leaf_37_clk clknet_5_13__leaf_clk VSS VSS VDD VDD
+ clknet_leaf_37_clk sky130_fd_sc_hd__clkbuf_16
X_11161_ network.neuron_in174.counter\[2\] network.neuron_in174.counter\[3\]
+ VSS VSS VDD VDD _07494_ sky130_fd_sc_hd__nor2_1
X_11162_ _00660_ _07494_ VSS VSS VDD VDD _07495_ sky130_fd_sc_hd__nand2_1
X_11163_ net407 _07495_ VSS VSS VDD VDD _07496_ sky130_fd_sc_hd__nand2_1
X_11164_ network.in_period\[174\]\[0\] _07496_ VSS VSS VDD
+ VDD _07497_ sky130_fd_sc_hd__nand2_1
X_11165_ network.neuron_in174.counter\[0\] _07496_ _07497_
+ VSS VSS VDD VDD _02760_ sky130_fd_sc_hd__o21ai_0
X_11166_ network.neuron_in175.counter\[2\] network.neuron_in175.counter\[3\]
+ VSS VSS VDD VDD _07498_ sky130_fd_sc_hd__nor2_1
X_11167_ _00184_ _07498_ VSS VSS VDD VDD _07499_ sky130_fd_sc_hd__nand2_1
X_11168_ net407 _07499_ VSS VSS VDD VDD _07500_ sky130_fd_sc_hd__nand2_1
X_11169_ network.in_period\[175\]\[0\] _07500_ VSS VSS VDD
+ VDD _07501_ sky130_fd_sc_hd__nand2_1
X_11170_ network.neuron_in175.counter\[0\] _07500_ _07501_
+ VSS VSS VDD VDD _02764_ sky130_fd_sc_hd__o21ai_0
X_11171_ network.neuron_in166.counter\[0\] VSS VSS VDD VDD
+ _00906_ sky130_fd_sc_hd__inv_1
X_11172_ network.neuron_in166.counter\[2\] network.neuron_in166.counter\[3\]
+ VSS VSS VDD VDD _07502_ sky130_fd_sc_hd__nor2_1
X_11173_ _00908_ _07502_ VSS VSS VDD VDD _07503_ sky130_fd_sc_hd__nand2_1
X_11174_ net402 _07503_ VSS VSS VDD VDD _07504_ sky130_fd_sc_hd__nand2_1
X_11175_ network.in_period\[166\]\[0\] _07504_ VSS VSS VDD
+ VDD _07505_ sky130_fd_sc_hd__nand2_1
X_11176_ network.neuron_in166.counter\[0\] _07504_ _07505_
+ VSS VSS VDD VDD _02728_ sky130_fd_sc_hd__o21ai_0
X_11177_ network.neuron_in167.counter\[2\] _00928_ VSS VSS
+ VDD VDD _07506_ sky130_fd_sc_hd__xnor2_1
Xclkbuf_leaf_36_clk clknet_5_7__leaf_clk VSS VSS VDD VDD clknet_leaf_36_clk
+ sky130_fd_sc_hd__clkbuf_16
X_11179_ net402 _07475_ network.in_period\[167\]\[2\] VSS
+ VSS VDD VDD _07508_ sky130_fd_sc_hd__a21oi_1
X_11180_ net402 _07506_ _07508_ VSS VSS VDD VDD _02734_ sky130_fd_sc_hd__a21oi_1
X_11181_ network.neuron_in167.counter\[0\] VSS VSS VDD VDD
+ _00926_ sky130_fd_sc_hd__inv_1
X_11182_ network.in_period\[167\]\[0\] _07476_ VSS VSS VDD
+ VDD _07509_ sky130_fd_sc_hd__nand2_1
X_11183_ network.neuron_in167.counter\[0\] _07476_ _07509_
+ VSS VSS VDD VDD _02732_ sky130_fd_sc_hd__o21ai_0
X_11184_ network.neuron_in168.counter\[3\] network.in_period\[168\]\[2\]
+ _00956_ net370 VSS VSS VDD VDD _07510_ sky130_fd_sc_hd__o22ai_1
X_11185_ network.neuron_in168.counter\[2\] _00956_ net402
+ VSS VSS VDD VDD _07511_ sky130_fd_sc_hd__nand3_1
X_11186_ network.in_period\[168\]\[2\] net402 _07511_ VSS
+ VSS VDD VDD _07512_ sky130_fd_sc_hd__o21ai_0
X_11187_ _07460_ _07510_ _07512_ VSS VSS VDD VDD _02738_ sky130_fd_sc_hd__a21oi_1
X_11188_ network.neuron_in169.counter\[2\] _00980_ VSS VSS
+ VDD VDD _07513_ sky130_fd_sc_hd__xnor2_1
X_11189_ net401 _07480_ network.in_period\[169\]\[2\] VSS
+ VSS VDD VDD _07514_ sky130_fd_sc_hd__a21oi_1
X_11190_ net401 _07513_ _07514_ VSS VSS VDD VDD _02742_ sky130_fd_sc_hd__a21oi_1
X_11191_ network.in_period\[169\]\[1\] _07481_ VSS VSS VDD
+ VDD _07515_ sky130_fd_sc_hd__nand2_1
X_11192_ _00981_ _07481_ _07515_ VSS VSS VDD VDD _02741_ sky130_fd_sc_hd__o21ai_0
X_11193_ network.neuron_in170.counter\[2\] _01016_ VSS VSS
+ VDD VDD _07516_ sky130_fd_sc_hd__xnor2_1
X_11194_ net401 _07484_ network.in_period\[170\]\[2\] VSS
+ VSS VDD VDD _07517_ sky130_fd_sc_hd__a21oi_1
X_11195_ net401 _07516_ _07517_ VSS VSS VDD VDD _02746_ sky130_fd_sc_hd__a21oi_1
X_11196_ network.in_period\[170\]\[1\] _07485_ VSS VSS VDD
+ VDD _07518_ sky130_fd_sc_hd__nand2_1
X_11197_ _01017_ _07485_ _07518_ VSS VSS VDD VDD _02745_ sky130_fd_sc_hd__o21ai_0
X_11198_ network.in_period\[171\]\[0\] _07456_ VSS VSS VDD
+ VDD _07519_ sky130_fd_sc_hd__nand2_1
X_11199_ network.neuron_in171.counter\[0\] _07456_ _07519_
+ VSS VSS VDD VDD _02748_ sky130_fd_sc_hd__o21ai_0
Xclkbuf_leaf_35_clk clknet_5_7__leaf_clk VSS VSS VDD VDD clknet_leaf_35_clk
+ sky130_fd_sc_hd__clkbuf_16
X_11201_ network.neuron_in172.counter\[3\] network.in_period\[172\]\[2\]
+ net370 _01035_ VSS VSS VDD VDD _07521_ sky130_fd_sc_hd__o22ai_1
X_11202_ network.neuron_in172.counter\[2\] _01035_ net401
+ VSS VSS VDD VDD _07522_ sky130_fd_sc_hd__nand3_1
X_11203_ network.in_period\[172\]\[2\] net401 _07522_ VSS
+ VSS VDD VDD _07523_ sky130_fd_sc_hd__o21ai_0
X_11204_ _07488_ _07521_ _07523_ VSS VSS VDD VDD _02754_ sky130_fd_sc_hd__a21oi_1
X_11205_ network.in_period\[172\]\[0\] _07490_ VSS VSS VDD
+ VDD _07524_ sky130_fd_sc_hd__nand2_1
X_11206_ network.neuron_in172.counter\[0\] _07490_ _07524_
+ VSS VSS VDD VDD _02752_ sky130_fd_sc_hd__o21ai_0
X_11207_ network.neuron_in173.counter\[2\] _00844_ VSS VSS
+ VDD VDD _07525_ sky130_fd_sc_hd__xnor2_1
X_11208_ net394 _07468_ network.in_period\[173\]\[2\] VSS
+ VSS VDD VDD _07526_ sky130_fd_sc_hd__a21oi_1
X_11209_ net407 _07525_ _07526_ VSS VSS VDD VDD _02758_ sky130_fd_sc_hd__a21oi_1
X_11210_ network.neuron_in174.counter\[2\] _00660_ VSS VSS
+ VDD VDD _07527_ sky130_fd_sc_hd__xnor2_1
X_11211_ net407 _07495_ network.in_period\[174\]\[2\] VSS
+ VSS VDD VDD _07528_ sky130_fd_sc_hd__a21oi_1
X_11212_ net407 _07527_ _07528_ VSS VSS VDD VDD _02762_ sky130_fd_sc_hd__a21oi_1
X_11213_ network.in_period\[174\]\[1\] _07496_ VSS VSS VDD
+ VDD _07529_ sky130_fd_sc_hd__nand2_1
X_11214_ _00661_ _07496_ _07529_ VSS VSS VDD VDD _02761_ sky130_fd_sc_hd__o21ai_0
Xclkbuf_leaf_34_clk clknet_5_6__leaf_clk VSS VSS VDD VDD clknet_leaf_34_clk
+ sky130_fd_sc_hd__clkbuf_16
X_11216_ network.neuron_in175.counter\[2\] _00184_ VSS VSS
+ VDD VDD _07531_ sky130_fd_sc_hd__xnor2_1
X_11217_ net407 _07499_ network.in_period\[175\]\[2\] VSS
+ VSS VDD VDD _07532_ sky130_fd_sc_hd__a21oi_1
X_11218_ net407 _07531_ _07532_ VSS VSS VDD VDD _02766_ sky130_fd_sc_hd__a21oi_1
X_11219_ network.in_period\[175\]\[1\] _07500_ VSS VSS VDD
+ VDD _07533_ sky130_fd_sc_hd__nand2_1
X_11220_ _00185_ _07500_ _07533_ VSS VSS VDD VDD _02765_ sky130_fd_sc_hd__o21ai_0
X_11221_ network.neuron_in029.counter\[2\] network.neuron_in029.counter\[3\]
+ VSS VSS VDD VDD _07534_ sky130_fd_sc_hd__nor2_1
X_11222_ _00553_ _07534_ VSS VSS VDD VDD _07535_ sky130_fd_sc_hd__nand2_1
X_11223_ net391 _07535_ VSS VSS VDD VDD _07536_ sky130_fd_sc_hd__nand2_1
X_11224_ network.in_period\[29\]\[1\] _07536_ VSS VSS VDD
+ VDD _07537_ sky130_fd_sc_hd__nand2_1
X_11225_ _00554_ _07536_ _07537_ VSS VSS VDD VDD _02181_ sky130_fd_sc_hd__o21ai_0
X_11226_ network.neuron_in030.counter\[2\] VSS VSS VDD VDD
+ _07538_ sky130_fd_sc_hd__inv_1
X_11227_ network.neuron_in030.counter\[3\] network.in_period\[30\]\[2\]
+ _00676_ net373 VSS VSS VDD VDD _07539_ sky130_fd_sc_hd__o22ai_1
Xclkbuf_leaf_33_clk clknet_5_12__leaf_clk VSS VSS VDD VDD
+ clknet_leaf_33_clk sky130_fd_sc_hd__clkbuf_16
X_11229_ network.neuron_in030.counter\[2\] _00676_ net391
+ VSS VSS VDD VDD _07541_ sky130_fd_sc_hd__nand3_1
X_11230_ network.in_period\[30\]\[2\] net391 _07541_ VSS VSS
+ VDD VDD _07542_ sky130_fd_sc_hd__o21ai_0
X_11231_ _07538_ _07539_ _07542_ VSS VSS VDD VDD _02186_ sky130_fd_sc_hd__a21oi_1
X_11232_ network.neuron_in029.counter\[2\] _00553_ VSS VSS
+ VDD VDD _07543_ sky130_fd_sc_hd__xnor2_1
X_11233_ net391 _07535_ network.in_period\[29\]\[2\] VSS VSS
+ VDD VDD _07544_ sky130_fd_sc_hd__a21oi_1
X_11234_ net391 _07543_ _07544_ VSS VSS VDD VDD _02182_ sky130_fd_sc_hd__a21oi_1
X_11235_ network.neuron_in029.counter\[0\] VSS VSS VDD VDD
+ _00551_ sky130_fd_sc_hd__inv_1
X_11236_ network.in_period\[29\]\[0\] _07536_ VSS VSS VDD
+ VDD _07545_ sky130_fd_sc_hd__nand2_1
X_11237_ network.neuron_in029.counter\[0\] _07536_ _07545_
+ VSS VSS VDD VDD _02180_ sky130_fd_sc_hd__o21ai_0
X_11238_ network.neuron_in030.counter\[3\] _00676_ VSS VSS
+ VDD VDD _07546_ sky130_fd_sc_hd__nand2b_1
X_11239_ _07546_ _07538_ VSS VSS VDD VDD _07547_ sky130_fd_sc_hd__nand2b_1
X_11240_ net391 _07547_ VSS VSS VDD VDD _07548_ sky130_fd_sc_hd__nand2_1
X_11241_ network.in_period\[30\]\[1\] _07548_ VSS VSS VDD
+ VDD _07549_ sky130_fd_sc_hd__nand2_1
X_11242_ _00677_ _07548_ _07549_ VSS VSS VDD VDD _02185_ sky130_fd_sc_hd__o21ai_0
X_11243_ network.neuron_in030.counter\[0\] VSS VSS VDD VDD
+ _00674_ sky130_fd_sc_hd__inv_1
X_11244_ network.in_period\[30\]\[0\] _07548_ VSS VSS VDD
+ VDD _07550_ sky130_fd_sc_hd__nand2_1
X_11245_ network.neuron_in030.counter\[0\] _07548_ _07550_
+ VSS VSS VDD VDD _02184_ sky130_fd_sc_hd__o21ai_0
X_11246_ network.neuron_in070.counter\[0\] VSS VSS VDD VDD
+ _00137_ sky130_fd_sc_hd__inv_1
X_11247_ _00519_ network.neuron_in241.counter\[2\] VSS VSS
+ VDD VDD _07551_ sky130_fd_sc_hd__xnor2_1
X_11248_ network.neuron_in241.counter\[2\] network.neuron_in241.counter\[3\]
+ VSS VSS VDD VDD _07552_ sky130_fd_sc_hd__nor2_1
X_11249_ _00519_ _07552_ VSS VSS VDD VDD _07553_ sky130_fd_sc_hd__nand2_1
X_11250_ net400 _07553_ network.in_period\[241\]\[2\] VSS
+ VSS VDD VDD _07554_ sky130_fd_sc_hd__a21oi_1
X_11251_ net400 _07551_ _07554_ VSS VSS VDD VDD _03030_ sky130_fd_sc_hd__a21oi_1
X_11252_ network.neuron_in118.counter\[1\] VSS VSS VDD VDD
+ _00083_ sky130_fd_sc_hd__inv_1
X_11253_ network.neuron_in242.counter\[2\] net399 VSS VSS
+ VDD VDD _07555_ sky130_fd_sc_hd__nand2_1
X_11254_ network.in_period\[242\]\[2\] network.neuron_in242.counter\[3\]
+ _07555_ VSS VSS VDD VDD _07556_ sky130_fd_sc_hd__o21ai_0
X_11255_ _00585_ network.neuron_in242.counter\[2\] net368
+ VSS VSS VDD VDD _07557_ sky130_fd_sc_hd__or3_1
X_11256_ network.in_period\[242\]\[2\] net399 _07557_ VSS
+ VSS VDD VDD _07558_ sky130_fd_sc_hd__o21ai_0
X_11257_ _00585_ _07556_ _07558_ VSS VSS VDD VDD _03034_ sky130_fd_sc_hd__a21oi_1
X_11258_ network.neuron_in242.counter\[2\] network.neuron_in242.counter\[3\]
+ VSS VSS VDD VDD _07559_ sky130_fd_sc_hd__nor2_1
X_11259_ _00585_ _07559_ VSS VSS VDD VDD _07560_ sky130_fd_sc_hd__nand2_1
X_11260_ net399 _07560_ VSS VSS VDD VDD _07561_ sky130_fd_sc_hd__nand2_1
X_11261_ network.in_period\[242\]\[0\] _07561_ VSS VSS VDD
+ VDD _07562_ sky130_fd_sc_hd__nand2_1
X_11262_ network.neuron_in242.counter\[0\] _07561_ _07562_
+ VSS VSS VDD VDD _03032_ sky130_fd_sc_hd__o21ai_0
X_11263_ network.neuron_in133.counter\[0\] VSS VSS VDD VDD
+ _00563_ sky130_fd_sc_hd__inv_1
X_11264_ network.neuron_in053.counter\[0\] VSS VSS VDD VDD
+ _00250_ sky130_fd_sc_hd__inv_1
X_11265_ network.in_period\[138\]\[0\] _06926_ VSS VSS VDD
+ VDD _07563_ sky130_fd_sc_hd__nand2_1
X_11266_ network.neuron_in138.counter\[0\] _06926_ _07563_
+ VSS VSS VDD VDD _02616_ sky130_fd_sc_hd__o21ai_0
X_11267_ network.neuron_in000.counter\[1\] VSS VSS VDD VDD
+ _00548_ sky130_fd_sc_hd__inv_1
X_11268_ network.neuron_hid5.IF0.ref_counter\[1\] VSS VSS
+ VDD VDD _01144_ sky130_fd_sc_hd__inv_1
X_11269_ network.neuron_in106.counter\[0\] VSS VSS VDD VDD
+ _00670_ sky130_fd_sc_hd__inv_1
X_11270_ network.neuron_in124.counter\[0\] VSS VSS VDD VDD
+ _00298_ sky130_fd_sc_hd__inv_1
X_11271_ network.neuron_in029.counter\[1\] VSS VSS VDD VDD
+ _00552_ sky130_fd_sc_hd__inv_1
X_11272_ network.neuron_in119.counter\[0\] VSS VSS VDD VDD
+ _00579_ sky130_fd_sc_hd__inv_1
X_11273_ network.neuron_in062.counter\[1\] VSS VSS VDD VDD
+ _00560_ sky130_fd_sc_hd__inv_1
X_11274_ network.neuron_in061.counter\[0\] VSS VSS VDD VDD
+ _00555_ sky130_fd_sc_hd__inv_1
X_11275_ network.neuron_in037.counter\[0\] VSS VSS VDD VDD
+ _00343_ sky130_fd_sc_hd__inv_1
X_11276_ network.neuron_in091.counter\[1\] VSS VSS VDD VDD
+ _00130_ sky130_fd_sc_hd__inv_1
X_11277_ network.neuron_in001.counter\[0\] VSS VSS VDD VDD
+ _00738_ sky130_fd_sc_hd__inv_1
X_11278_ network.neuron_in169.counter\[1\] VSS VSS VDD VDD
+ _00979_ sky130_fd_sc_hd__inv_1
X_11279_ network.neuron_in200.counter\[1\] VSS VSS VDD VDD
+ _00526_ sky130_fd_sc_hd__inv_1
X_11280_ network.neuron_in241.counter\[1\] VSS VSS VDD VDD
+ _00518_ sky130_fd_sc_hd__inv_1
X_11281_ network.neuron_in036.counter\[0\] VSS VSS VDD VDD
+ _00347_ sky130_fd_sc_hd__inv_1
X_11282_ network.neuron_in051.counter\[0\] VSS VSS VDD VDD
+ _00521_ sky130_fd_sc_hd__inv_1
X_11283_ network.neuron_in239.counter\[1\] VSS VSS VDD VDD
+ _00489_ sky130_fd_sc_hd__inv_1
X_11284_ network.neuron_in117.counter\[1\] VSS VSS VDD VDD
+ _01218_ sky130_fd_sc_hd__inv_1
X_11285_ network.neuron_in244.counter\[2\] VSS VSS VDD VDD
+ _07564_ sky130_fd_sc_hd__inv_1
Xclkbuf_leaf_32_clk clknet_5_6__leaf_clk VSS VSS VDD VDD clknet_leaf_32_clk
+ sky130_fd_sc_hd__clkbuf_16
X_11287_ network.in_period\[244\]\[2\] network.neuron_in244.counter\[3\]
+ _00924_ net368 VSS VSS VDD VDD _07566_ sky130_fd_sc_hd__o22ai_1
X_11288_ network.neuron_in244.counter\[2\] _00924_ net400
+ VSS VSS VDD VDD _07567_ sky130_fd_sc_hd__nand3_1
X_11289_ network.in_period\[244\]\[2\] net400 _07567_ VSS
+ VSS VDD VDD _07568_ sky130_fd_sc_hd__o21ai_0
X_11290_ _07564_ _07566_ _07568_ VSS VSS VDD VDD _03042_ sky130_fd_sc_hd__a21oi_1
X_11291_ network.in_period\[245\]\[2\] VSS VSS VDD VDD _07569_
+ sky130_fd_sc_hd__inv_1
X_11292_ _01197_ network.neuron_in245.counter\[2\] VSS VSS
+ VDD VDD _07570_ sky130_fd_sc_hd__xnor2_1
X_11293_ _07569_ _07436_ _07570_ net399 VSS VSS VDD VDD _03046_
+ sky130_fd_sc_hd__a22oi_1
X_11294_ net419 net346 VSS VSS VDD VDD _07571_ sky130_fd_sc_hd__nor2_1
X_11295_ net421 net360 VSS VSS VDD VDD _07572_ sky130_fd_sc_hd__nor2_1
X_11296_ net420 net360 VSS VSS VDD VDD _07573_ sky130_fd_sc_hd__nand2_1
X_11297_ net423 _07573_ _07188_ VSS VSS VDD VDD _07574_ sky130_fd_sc_hd__a21oi_1
X_11298_ _07572_ _07574_ VSS VSS VDD VDD _07575_ sky130_fd_sc_hd__nor2_1
X_11299_ net360 _07140_ VSS VSS VDD VDD _07576_ sky130_fd_sc_hd__nand2_1
X_11300_ net360 net322 _07576_ net421 net416 VSS VSS VDD VDD
+ _07577_ sky130_fd_sc_hd__a221oi_1
X_11301_ net416 _07575_ _07577_ VSS VSS VDD VDD _07578_ sky130_fd_sc_hd__a21oi_1
X_11302_ _07571_ _07578_ net358 VSS VSS VDD VDD _07579_ sky130_fd_sc_hd__o21ai_0
X_11303_ net358 net339 VSS VSS VDD VDD _07580_ sky130_fd_sc_hd__nor2_1
X_11304_ network.neuron_hid0.ROM0.address\[4\] net418 VSS
+ VSS VDD VDD _07581_ sky130_fd_sc_hd__nor2_1
X_11305_ net419 _07050_ VSS VSS VDD VDD _07582_ sky130_fd_sc_hd__nor2_1
X_11306_ _07581_ _07241_ _07582_ network.neuron_hid0.ROM0.address\[4\]
+ net363 VSS VSS VDD VDD _07583_ sky130_fd_sc_hd__a221o_1
X_11307_ net419 net349 VSS VSS VDD VDD _07584_ sky130_fd_sc_hd__nor2_1
X_11308_ net424 net414 VSS VSS VDD VDD _07585_ sky130_fd_sc_hd__nor2b_1
X_11309_ net351 _07584_ net335 VSS VSS VDD VDD _07586_ sky130_fd_sc_hd__o21ai_0
X_11310_ network.neuron_hid0.ROM0.address\[2\] net343 VSS
+ VSS VDD VDD _07587_ sky130_fd_sc_hd__nand2_1
X_11311_ network.neuron_hid0.ROM0.address\[4\] net418 VSS
+ VSS VDD VDD _07588_ sky130_fd_sc_hd__nand2_1
X_11312_ net425 _07588_ net419 VSS VSS VDD VDD _07589_ sky130_fd_sc_hd__a21oi_1
X_11313_ net419 net418 VSS VSS VDD VDD _07590_ sky130_fd_sc_hd__nor2b_1
Xclkbuf_leaf_31_clk clknet_5_6__leaf_clk VSS VSS VDD VDD clknet_leaf_31_clk
+ sky130_fd_sc_hd__clkbuf_16
X_11315_ net359 _07369_ VSS VSS VDD VDD _07592_ sky130_fd_sc_hd__nand2_1
X_11316_ _07590_ net350 _07592_ net413 net422 VSS VSS VDD
+ VDD _07593_ sky130_fd_sc_hd__o221ai_1
X_11317_ net422 net361 _07589_ _07593_ VSS VSS VDD VDD _07594_
+ sky130_fd_sc_hd__o31ai_1
X_11318_ net410 _07587_ _07594_ net409 VSS VSS VDD VDD _07595_
+ sky130_fd_sc_hd__a31oi_1
X_11319_ net352 _07580_ _07583_ _07586_ _07595_ VSS VSS VDD
+ VDD _07596_ sky130_fd_sc_hd__a41oi_1
X_11320_ net419 net422 VSS VSS VDD VDD _07597_ sky130_fd_sc_hd__nor2_1
X_11321_ _07166_ net334 net344 VSS VSS VDD VDD _07598_ sky130_fd_sc_hd__o21ai_0
X_11322_ net366 net363 VSS VSS VDD VDD _07599_ sky130_fd_sc_hd__nand2_1
X_11323_ _07599_ _07289_ net362 VSS VSS VDD VDD _07600_ sky130_fd_sc_hd__a21oi_1
X_11324_ _07598_ _07600_ VSS VSS VDD VDD _07601_ sky130_fd_sc_hd__nor2_1
Xclkbuf_leaf_30_clk clknet_5_6__leaf_clk VSS VSS VDD VDD clknet_leaf_30_clk
+ sky130_fd_sc_hd__clkbuf_16
X_11326_ net419 _07201_ VSS VSS VDD VDD _07603_ sky130_fd_sc_hd__nor2_1
X_11327_ net347 _07603_ network.neuron_hid0.ROM0.address\[4\]
+ VSS VSS VDD VDD _07604_ sky130_fd_sc_hd__o21ai_0
X_11328_ _07579_ _07596_ _07601_ _07604_ network.neuron_hid0.ROM0.address\[7\]
+ VSS VSS VDD VDD _07605_ sky130_fd_sc_hd__a221o_1
Xclkbuf_leaf_29_clk clknet_5_6__leaf_clk VSS VSS VDD VDD clknet_leaf_29_clk
+ sky130_fd_sc_hd__clkbuf_16
X_11330_ net417 net423 VSS VSS VDD VDD _07607_ sky130_fd_sc_hd__xnor2_1
X_11331_ net425 net349 VSS VSS VDD VDD _07608_ sky130_fd_sc_hd__nor2_1
X_11332_ net315 net338 VSS VSS VDD VDD _07609_ sky130_fd_sc_hd__nor2_1
X_11333_ _07599_ net333 _07609_ net419 net321 VSS VSS VDD
+ VDD _07610_ sky130_fd_sc_hd__o221ai_1
X_11334_ network.neuron_hid0.ROM0.address\[7\] net344 _07610_
+ VSS VSS VDD VDD _07611_ sky130_fd_sc_hd__nand3_1
X_11335_ _07605_ _07611_ _07042_ VSS VSS VDD VDD _01512_ sky130_fd_sc_hd__a21oi_1
X_11336_ net410 net366 VSS VSS VDD VDD _07612_ sky130_fd_sc_hd__nor2_1
X_11337_ net343 net361 VSS VSS VDD VDD _07613_ sky130_fd_sc_hd__nor2_1
X_11338_ net421 net423 VSS VSS VDD VDD _07614_ sky130_fd_sc_hd__nand2_1
X_11339_ net334 _07613_ net319 net346 _07614_ VSS VSS VDD
+ VDD _07615_ sky130_fd_sc_hd__o221ai_1
X_11340_ net412 net366 VSS VSS VDD VDD _07616_ sky130_fd_sc_hd__nand2_1
Xclkbuf_leaf_28_clk clknet_5_3__leaf_clk VSS VSS VDD VDD clknet_leaf_28_clk
+ sky130_fd_sc_hd__clkbuf_16
X_11342_ net418 _07337_ VSS VSS VDD VDD _07618_ sky130_fd_sc_hd__nand2_1
Xclkbuf_leaf_27_clk clknet_5_3__leaf_clk VSS VSS VDD VDD clknet_leaf_27_clk
+ sky130_fd_sc_hd__clkbuf_16
X_11344_ net356 net348 net419 VSS VSS VDD VDD _07620_ sky130_fd_sc_hd__a21oi_1
X_11345_ net419 _07618_ _07620_ VSS VSS VDD VDD _07621_ sky130_fd_sc_hd__a21oi_1
Xclkbuf_leaf_26_clk clknet_5_3__leaf_clk VSS VSS VDD VDD clknet_leaf_26_clk
+ sky130_fd_sc_hd__clkbuf_16
X_11347_ net419 _07099_ VSS VSS VDD VDD _07623_ sky130_fd_sc_hd__nor2_1
X_11348_ net412 net416 VSS VSS VDD VDD _07624_ sky130_fd_sc_hd__nand2_1
X_11349_ net419 net346 _07201_ _07623_ _07624_ VSS VSS VDD
+ VDD _07625_ sky130_fd_sc_hd__a311oi_1
X_11350_ net424 net418 _07614_ _07307_ net315 VSS VSS VDD
+ VDD _07626_ sky130_fd_sc_hd__a311oi_1
X_11351_ net409 _07625_ _07626_ VSS VSS VDD VDD _07627_ sky130_fd_sc_hd__nor3_1
X_11352_ _07616_ _07621_ _07627_ VSS VSS VDD VDD _07628_ sky130_fd_sc_hd__o21ai_0
X_11353_ _07612_ _07615_ _07628_ VSS VSS VDD VDD _07629_ sky130_fd_sc_hd__a21oi_1
Xclkbuf_leaf_25_clk clknet_5_3__leaf_clk VSS VSS VDD VDD clknet_leaf_25_clk
+ sky130_fd_sc_hd__clkbuf_16
X_11355_ net346 _07614_ net424 VSS VSS VDD VDD _07631_ sky130_fd_sc_hd__a21oi_1
X_11356_ net358 net366 VSS VSS VDD VDD _07632_ sky130_fd_sc_hd__nor2_1
X_11357_ _07207_ _07632_ VSS VSS VDD VDD _07633_ sky130_fd_sc_hd__nand2_1
X_11358_ _07631_ _07633_ net409 VSS VSS VDD VDD _07634_ sky130_fd_sc_hd__o21ai_0
Xclkbuf_leaf_24_clk clknet_5_3__leaf_clk VSS VSS VDD VDD clknet_leaf_24_clk
+ sky130_fd_sc_hd__clkbuf_16
X_11360_ net422 net419 VSS VSS VDD VDD _07636_ sky130_fd_sc_hd__nor2b_1
Xclkbuf_leaf_23_clk clknet_5_9__leaf_clk VSS VSS VDD VDD clknet_leaf_23_clk
+ sky130_fd_sc_hd__clkbuf_16
X_11362_ net322 net332 VSS VSS VDD VDD _07638_ sky130_fd_sc_hd__nor2_1
X_11363_ net424 net351 VSS VSS VDD VDD _07639_ sky130_fd_sc_hd__nor2_1
X_11364_ net424 _07638_ _07616_ _07639_ VSS VSS VDD VDD _07640_
+ sky130_fd_sc_hd__a211oi_1
X_11365_ net425 net417 VSS VSS VDD VDD _07641_ sky130_fd_sc_hd__nor2_1
Xclkbuf_leaf_22_clk clknet_5_9__leaf_clk VSS VSS VDD VDD clknet_leaf_22_clk
+ sky130_fd_sc_hd__clkbuf_16
X_11367_ net421 _07641_ VSS VSS VDD VDD _07643_ sky130_fd_sc_hd__nand2_1
X_11368_ net365 net325 VSS VSS VDD VDD _07644_ sky130_fd_sc_hd__nand2_1
X_11369_ net420 net345 VSS VSS VDD VDD _07645_ sky130_fd_sc_hd__nand2_1
X_11370_ _07644_ _07645_ VSS VSS VDD VDD _07646_ sky130_fd_sc_hd__nand2_1
X_11371_ net322 _07298_ VSS VSS VDD VDD _07647_ sky130_fd_sc_hd__nand2_1
X_11372_ net325 net341 _07647_ net415 VSS VSS VDD VDD _07648_
+ sky130_fd_sc_hd__o211ai_1
X_11373_ net415 _07646_ _07648_ VSS VSS VDD VDD _07649_ sky130_fd_sc_hd__o21ai_0
X_11374_ _07643_ _07649_ net411 VSS VSS VDD VDD _07650_ sky130_fd_sc_hd__a21oi_1
X_11375_ _07634_ _07640_ _07650_ net306 VSS VSS VDD VDD _07651_
+ sky130_fd_sc_hd__o31ai_1
X_11376_ net420 net363 VSS VSS VDD VDD _07652_ sky130_fd_sc_hd__nor2_1
Xclkbuf_leaf_21_clk clknet_5_3__leaf_clk VSS VSS VDD VDD clknet_leaf_21_clk
+ sky130_fd_sc_hd__clkbuf_16
X_11378_ _07109_ net314 VSS VSS VDD VDD _07654_ sky130_fd_sc_hd__nor2_1
X_11379_ net366 _07654_ _07304_ _07382_ VSS VSS VDD VDD _07655_
+ sky130_fd_sc_hd__o2bb2ai_1
X_11380_ net422 net325 _07623_ VSS VSS VDD VDD _07656_ sky130_fd_sc_hd__a21oi_1
X_11381_ net418 _07655_ _07656_ net413 VSS VSS VDD VDD _07657_
+ sky130_fd_sc_hd__o22ai_1
X_11382_ net307 _07657_ VSS VSS VDD VDD _07658_ sky130_fd_sc_hd__nand2_1
X_11383_ _07629_ _07651_ _07658_ VSS VSS VDD VDD _01513_ sky130_fd_sc_hd__o21ai_0
X_11384_ net425 net418 net422 VSS VSS VDD VDD _07659_ sky130_fd_sc_hd__or3_1
X_11385_ net413 _07659_ net365 VSS VSS VDD VDD _07660_ sky130_fd_sc_hd__a21oi_1
X_11386_ _07201_ _07659_ net413 VSS VSS VDD VDD _07661_ sky130_fd_sc_hd__a21oi_1
X_11387_ net353 net314 _07660_ _07661_ VSS VSS VDD VDD _07662_
+ sky130_fd_sc_hd__a211oi_1
X_11388_ net415 net359 net341 _07210_ VSS VSS VDD VDD _07663_
+ sky130_fd_sc_hd__a31oi_1
X_11389_ net415 net323 net314 _07329_ _07186_ VSS VSS VDD
+ VDD _07664_ sky130_fd_sc_hd__o311ai_0
X_11390_ net419 net331 net314 VSS VSS VDD VDD _07665_ sky130_fd_sc_hd__a21oi_1
X_11391_ net422 _07665_ VSS VSS VDD VDD _07666_ sky130_fd_sc_hd__nand2_1
X_11392_ _07664_ _07666_ VSS VSS VDD VDD _07667_ sky130_fd_sc_hd__nand2_1
X_11393_ net421 net425 net353 VSS VSS VDD VDD _07668_ sky130_fd_sc_hd__nor3_1
X_11394_ _07134_ _07231_ net365 VSS VSS VDD VDD _07669_ sky130_fd_sc_hd__a21oi_1
X_11395_ net362 net345 net365 VSS VSS VDD VDD _07670_ sky130_fd_sc_hd__o21ai_0
X_11396_ net420 net355 VSS VSS VDD VDD _07671_ sky130_fd_sc_hd__nand2_1
X_11397_ net414 net360 _07670_ _07671_ VSS VSS VDD VDD _07672_
+ sky130_fd_sc_hd__nand4_1
X_11398_ net414 _07668_ _07669_ _07672_ VSS VSS VDD VDD _07673_
+ sky130_fd_sc_hd__o31ai_1
X_11399_ net349 _07115_ _07673_ VSS VSS VDD VDD _07674_ sky130_fd_sc_hd__o21ai_0
X_11400_ net410 net339 VSS VSS VDD VDD _07675_ sky130_fd_sc_hd__nand2_1
X_11401_ net413 net424 VSS VSS VDD VDD _07676_ sky130_fd_sc_hd__nand2_1
X_11402_ net346 _07676_ net365 VSS VSS VDD VDD _07677_ sky130_fd_sc_hd__a21oi_1
X_11403_ _07641_ _07162_ net421 VSS VSS VDD VDD _07678_ sky130_fd_sc_hd__o21ai_0
X_11404_ net346 _07644_ _07678_ net414 VSS VSS VDD VDD _07679_
+ sky130_fd_sc_hd__a31oi_1
X_11405_ net415 net424 net356 _07677_ _07679_ VSS VSS VDD
+ VDD _07680_ sky130_fd_sc_hd__a311oi_1
X_11406_ net322 net332 net415 VSS VSS VDD VDD _07681_ sky130_fd_sc_hd__o21ai_0
X_11407_ net366 net334 VSS VSS VDD VDD _07682_ sky130_fd_sc_hd__nand2_1
X_11408_ net424 _07681_ _07682_ net417 VSS VSS VDD VDD _07683_
+ sky130_fd_sc_hd__a31oi_1
X_11409_ _07047_ net354 VSS VSS VDD VDD _07684_ sky130_fd_sc_hd__nor2_1
X_11410_ _07188_ _07683_ _07684_ VSS VSS VDD VDD _07685_ sky130_fd_sc_hd__nor3_1
X_11411_ _07675_ _07680_ _07685_ _07254_ VSS VSS VDD VDD _07686_
+ sky130_fd_sc_hd__o22ai_1
X_11412_ _07663_ _07667_ _07674_ net344 _07686_ VSS VSS VDD
+ VDD _07687_ sky130_fd_sc_hd__a221oi_1
Xclkbuf_leaf_20_clk clknet_5_2__leaf_clk VSS VSS VDD VDD clknet_leaf_20_clk
+ sky130_fd_sc_hd__clkbuf_16
X_11414_ net318 _07662_ _07687_ net316 VSS VSS VDD VDD _01514_
+ sky130_fd_sc_hd__o22ai_1
X_11415_ net415 net354 net346 VSS VSS VDD VDD _07689_ sky130_fd_sc_hd__o21ai_0
X_11416_ _07313_ _07289_ net415 VSS VSS VDD VDD _07690_ sky130_fd_sc_hd__a21oi_1
X_11417_ net425 _07689_ _07690_ VSS VSS VDD VDD _07691_ sky130_fd_sc_hd__a21oi_1
X_11418_ net421 net425 VSS VSS VDD VDD _07692_ sky130_fd_sc_hd__nor2_1
X_11419_ net421 net348 net330 VSS VSS VDD VDD _07693_ sky130_fd_sc_hd__a21oi_1
X_11420_ net346 _07115_ _07693_ net362 VSS VSS VDD VDD _07694_
+ sky130_fd_sc_hd__o22ai_1
X_11421_ net421 net353 VSS VSS VDD VDD _07695_ sky130_fd_sc_hd__nand2_1
X_11422_ net414 _07644_ _07695_ VSS VSS VDD VDD _07696_ sky130_fd_sc_hd__nand3_1
X_11423_ net414 _07694_ _07696_ net339 VSS VSS VDD VDD _07697_
+ sky130_fd_sc_hd__o211ai_1
X_11424_ net339 _07046_ _07164_ net319 net346 VSS VSS VDD
+ VDD _07698_ sky130_fd_sc_hd__o32ai_1
Xclkbuf_leaf_19_clk clknet_5_8__leaf_clk VSS VSS VDD VDD clknet_leaf_19_clk
+ sky130_fd_sc_hd__clkbuf_16
X_11426_ net416 net360 net340 VSS VSS VDD VDD _07700_ sky130_fd_sc_hd__o21ai_0
X_11427_ net332 _07700_ VSS VSS VDD VDD _07701_ sky130_fd_sc_hd__nand2_1
X_11428_ _07047_ _07576_ _07701_ VSS VSS VDD VDD _07702_ sky130_fd_sc_hd__o21ai_0
X_11429_ net353 net324 _07698_ net416 net408 _07702_ VSS VSS
+ VDD VDD _07703_ sky130_fd_sc_hd__a222oi_1
X_11430_ net422 net352 _07592_ net413 VSS VSS VDD VDD _07704_
+ sky130_fd_sc_hd__a22oi_1
X_11431_ net409 net413 net338 VSS VSS VDD VDD _07705_ sky130_fd_sc_hd__a21oi_1
X_11432_ net409 _07704_ _07705_ net352 VSS VSS VDD VDD _07706_
+ sky130_fd_sc_hd__o22ai_1
X_11433_ net419 net422 VSS VSS VDD VDD _07707_ sky130_fd_sc_hd__and2_1
Xplace408 _06355_ VSS VSS VDD VDD net407 sky130_fd_sc_hd__buf_4
X_11435_ net415 net342 VSS VSS VDD VDD _07709_ sky130_fd_sc_hd__nor2_1
X_11436_ net413 net419 net425 VSS VSS VDD VDD _07710_ sky130_fd_sc_hd__nand3_1
X_11437_ _07682_ _07710_ net339 VSS VSS VDD VDD _07711_ sky130_fd_sc_hd__a21oi_1
X_11438_ net339 net415 _07707_ _07709_ _07711_ VSS VSS VDD
+ VDD _07712_ sky130_fd_sc_hd__a311oi_1
Xplace407 net407 VSS VSS VDD VDD net406 sky130_fd_sc_hd__buf_4
X_11440_ net415 net363 VSS VSS VDD VDD _07714_ sky130_fd_sc_hd__nor2_1
X_11441_ net323 _07146_ _07385_ net356 VSS VSS VDD VDD _07715_
+ sky130_fd_sc_hd__o22ai_1
X_11442_ _07162_ _07714_ _07715_ net409 VSS VSS VDD VDD _07716_
+ sky130_fd_sc_hd__a22oi_1
X_11443_ net418 _07712_ _07716_ VSS VSS VDD VDD _07717_ sky130_fd_sc_hd__o21ai_0
X_11444_ net363 _07706_ _07717_ net358 VSS VSS VDD VDD _07718_
+ sky130_fd_sc_hd__a211oi_1
X_11445_ net358 _07697_ _07703_ _07718_ VSS VSS VDD VDD _07719_
+ sky130_fd_sc_hd__a31o_2
X_11446_ net318 _07691_ _07719_ net316 VSS VSS VDD VDD _01515_
+ sky130_fd_sc_hd__o22ai_1
X_11447_ net425 net418 VSS VSS VDD VDD _07720_ sky130_fd_sc_hd__nand2_1
Xplace406 net406 VSS VSS VDD VDD net405 sky130_fd_sc_hd__buf_4
X_11449_ net413 _07720_ net348 VSS VSS VDD VDD _07722_ sky130_fd_sc_hd__o21ai_0
X_11450_ net413 _07162_ VSS VSS VDD VDD _07723_ sky130_fd_sc_hd__nand2_1
X_11451_ net419 net346 _07723_ VSS VSS VDD VDD _07724_ sky130_fd_sc_hd__o21ai_0
X_11452_ net413 net361 _07181_ VSS VSS VDD VDD _07725_ sky130_fd_sc_hd__nor3_1
X_11453_ net419 _07722_ _07724_ net363 _07725_ VSS VSS VDD
+ VDD _07726_ sky130_fd_sc_hd__a221oi_1
X_11454_ net365 net357 _07115_ VSS VSS VDD VDD _07727_ sky130_fd_sc_hd__o21ai_0
X_11455_ net419 net342 VSS VSS VDD VDD _07728_ sky130_fd_sc_hd__nor2_1
X_11456_ net411 _07727_ _07728_ VSS VSS VDD VDD _07729_ sky130_fd_sc_hd__a21oi_1
X_11457_ net410 _07726_ _07729_ _07588_ VSS VSS VDD VDD _07730_
+ sky130_fd_sc_hd__o22ai_1
X_11458_ _07164_ _07643_ net416 VSS VSS VDD VDD _07731_ sky130_fd_sc_hd__a21oi_1
X_11459_ net363 net364 net416 VSS VSS VDD VDD _07732_ sky130_fd_sc_hd__o21ai_0
X_11460_ _07140_ _07732_ net421 VSS VSS VDD VDD _07733_ sky130_fd_sc_hd__a21oi_1
X_11461_ _07731_ _07733_ VSS VSS VDD VDD _07734_ sky130_fd_sc_hd__nor2_1
X_11462_ net408 _07734_ VSS VSS VDD VDD _07735_ sky130_fd_sc_hd__nor2_1
X_11463_ net339 net425 _07588_ VSS VSS VDD VDD _07736_ sky130_fd_sc_hd__a21oi_1
X_11464_ net416 _07337_ VSS VSS VDD VDD _07737_ sky130_fd_sc_hd__nand2_1
X_11465_ net425 net354 VSS VSS VDD VDD _07738_ sky130_fd_sc_hd__nor2_1
X_11466_ _07181_ _07738_ net408 VSS VSS VDD VDD _07739_ sky130_fd_sc_hd__o21ai_0
X_11467_ net320 _07314_ net408 VSS VSS VDD VDD _07740_ sky130_fd_sc_hd__o21ai_0
X_11468_ net421 _07171_ VSS VSS VDD VDD _07741_ sky130_fd_sc_hd__nor2_1
X_11469_ net421 _07737_ _07739_ _07740_ _07741_ VSS VSS VDD
+ VDD _07742_ sky130_fd_sc_hd__a32oi_1
X_11470_ net358 _07735_ _07736_ _07742_ VSS VSS VDD VDD _07743_
+ sky130_fd_sc_hd__nor4_1
X_11471_ net421 net357 _07099_ VSS VSS VDD VDD _07744_ sky130_fd_sc_hd__o21ai_0
X_11472_ net417 _07744_ net356 VSS VSS VDD VDD _07745_ sky130_fd_sc_hd__o21ai_0
X_11473_ net416 _07745_ VSS VSS VDD VDD _07746_ sky130_fd_sc_hd__nor2_1
X_11474_ net414 net321 _07291_ _07746_ VSS VSS VDD VDD _07747_
+ sky130_fd_sc_hd__a31oi_1
X_11475_ _07588_ _07682_ net425 VSS VSS VDD VDD _07748_ sky130_fd_sc_hd__a21oi_1
X_11476_ _07747_ _07748_ net344 VSS VSS VDD VDD _07749_ sky130_fd_sc_hd__o21a_1
X_11477_ net409 _07730_ _07743_ _07749_ VSS VSS VDD VDD _07750_
+ sky130_fd_sc_hd__a211oi_1
X_11478_ net422 net343 VSS VSS VDD VDD _07751_ sky130_fd_sc_hd__nor2_1
X_11479_ net413 net365 VSS VSS VDD VDD _07752_ sky130_fd_sc_hd__nor2_1
X_11480_ net422 _07115_ VSS VSS VDD VDD _07753_ sky130_fd_sc_hd__nand2_1
X_11481_ net413 _07201_ VSS VSS VDD VDD _07754_ sky130_fd_sc_hd__nor2_1
X_11482_ net413 _07753_ _07754_ VSS VSS VDD VDD _07755_ sky130_fd_sc_hd__a21oi_1
X_11483_ net418 _07755_ VSS VSS VDD VDD _07756_ sky130_fd_sc_hd__nor2_1
X_11484_ _07751_ _07752_ _07756_ VSS VSS VDD VDD _07757_ sky130_fd_sc_hd__a21oi_1
X_11485_ net316 _07750_ _07757_ net318 VSS VSS VDD VDD _01516_
+ sky130_fd_sc_hd__o22ai_1
X_11486_ net425 net356 VSS VSS VDD VDD _07758_ sky130_fd_sc_hd__nor2_1
X_11487_ _07758_ _07572_ VSS VSS VDD VDD _07759_ sky130_fd_sc_hd__nor2_1
X_11488_ net347 _07355_ net420 VSS VSS VDD VDD _07760_ sky130_fd_sc_hd__o21ai_0
X_11489_ _07109_ _07376_ _07759_ net415 _07760_ VSS VSS VDD
+ VDD _07761_ sky130_fd_sc_hd__o221ai_1
X_11490_ net415 net336 VSS VSS VDD VDD _07762_ sky130_fd_sc_hd__nor2_1
X_11491_ net415 net322 _07762_ VSS VSS VDD VDD _07763_ sky130_fd_sc_hd__a21oi_1
X_11492_ net409 _07652_ VSS VSS VDD VDD _07764_ sky130_fd_sc_hd__nand2_1
X_11493_ net409 net366 _07287_ VSS VSS VDD VDD _07765_ sky130_fd_sc_hd__nor3_1
X_11494_ net409 net332 _07603_ VSS VSS VDD VDD _07766_ sky130_fd_sc_hd__a21oi_1
X_11495_ net413 _07099_ _07187_ VSS VSS VDD VDD _07767_ sky130_fd_sc_hd__a21oi_1
X_11496_ net413 _07766_ _07767_ net339 VSS VSS VDD VDD _07768_
+ sky130_fd_sc_hd__o22ai_1
X_11497_ net330 _07709_ VSS VSS VDD VDD _07769_ sky130_fd_sc_hd__nor2_1
X_11498_ net409 net366 _07707_ VSS VSS VDD VDD _07770_ sky130_fd_sc_hd__nand3_1
X_11499_ net409 _07769_ _07770_ net418 _07205_ VSS VSS VDD
+ VDD _07771_ sky130_fd_sc_hd__o2111ai_1
X_11500_ net418 _07765_ _07768_ _07771_ VSS VSS VDD VDD _07772_
+ sky130_fd_sc_hd__o31ai_1
X_11501_ net424 _07763_ _07764_ net338 _07772_ VSS VSS VDD
+ VDD _07773_ sky130_fd_sc_hd__o221ai_1
X_11502_ net420 net340 _07207_ VSS VSS VDD VDD _07774_ sky130_fd_sc_hd__o21ai_0
X_11503_ net420 net418 _07120_ VSS VSS VDD VDD _07775_ sky130_fd_sc_hd__nor3_1
X_11504_ net410 net409 _07188_ _07775_ VSS VSS VDD VDD _07776_
+ sky130_fd_sc_hd__or4_1
X_11505_ net366 _07774_ _07776_ VSS VSS VDD VDD _07777_ sky130_fd_sc_hd__a21oi_1
X_11506_ _07312_ _07761_ _07773_ net410 _07777_ VSS VSS VDD
+ VDD _07778_ sky130_fd_sc_hd__a221oi_1
X_11507_ _07056_ net330 _07186_ VSS VSS VDD VDD _07779_ sky130_fd_sc_hd__o21ai_0
X_11508_ _07164_ _07779_ net415 VSS VSS VDD VDD _07780_ sky130_fd_sc_hd__a21oi_1
X_11509_ net321 _07299_ net365 VSS VSS VDD VDD _07781_ sky130_fd_sc_hd__a21oi_1
X_11510_ _07780_ _07781_ net307 VSS VSS VDD VDD _07782_ sky130_fd_sc_hd__o21ai_0
X_11511_ net316 _07778_ _07782_ VSS VSS VDD VDD _01517_ sky130_fd_sc_hd__o21ai_0
X_11512_ net332 _07603_ net362 VSS VSS VDD VDD _07783_ sky130_fd_sc_hd__o21ai_0
X_11513_ _07599_ _07582_ _07783_ VSS VSS VDD VDD _07784_ sky130_fd_sc_hd__o21a_1
X_11514_ net419 _07166_ _07099_ VSS VSS VDD VDD _07785_ sky130_fd_sc_hd__a21oi_1
X_11515_ net413 _07590_ _07581_ VSS VSS VDD VDD _07786_ sky130_fd_sc_hd__a21oi_1
X_11516_ net366 net417 VSS VSS VDD VDD _07787_ sky130_fd_sc_hd__nor2_1
X_11517_ net422 net317 net313 net424 VSS VSS VDD VDD _07788_
+ sky130_fd_sc_hd__o31ai_1
X_11518_ net422 _07786_ _07788_ VSS VSS VDD VDD _07789_ sky130_fd_sc_hd__a21oi_1
X_11519_ _07162_ _07752_ _07785_ _07789_ net411 VSS VSS VDD
+ VDD _07790_ sky130_fd_sc_hd__a2111oi_0
X_11520_ net347 net336 VSS VSS VDD VDD _07791_ sky130_fd_sc_hd__nand2_1
X_11521_ net359 _07695_ _07791_ _07616_ VSS VSS VDD VDD _07792_
+ sky130_fd_sc_hd__a31oi_1
X_11522_ net423 net331 VSS VSS VDD VDD _07793_ sky130_fd_sc_hd__xnor2_1
X_11523_ net421 _07793_ _07226_ VSS VSS VDD VDD _07794_ sky130_fd_sc_hd__a21oi_1
X_11524_ _07624_ _07794_ VSS VSS VDD VDD _07795_ sky130_fd_sc_hd__nor2_1
X_11525_ _07313_ _07249_ VSS VSS VDD VDD _07796_ sky130_fd_sc_hd__nand2_1
X_11526_ net363 net333 VSS VSS VDD VDD _07797_ sky130_fd_sc_hd__nand2_1
X_11527_ net349 _07115_ _07797_ VSS VSS VDD VDD _07798_ sky130_fd_sc_hd__o21ai_0
X_11528_ net421 _07796_ _07798_ VSS VSS VDD VDD _07799_ sky130_fd_sc_hd__a21oi_1
X_11529_ net412 net416 VSS VSS VDD VDD _07800_ sky130_fd_sc_hd__nor2_1
X_11530_ net417 net355 net421 VSS VSS VDD VDD _07801_ sky130_fd_sc_hd__o21ai_0
X_11531_ net421 net325 net347 _07801_ VSS VSS VDD VDD _07802_
+ sky130_fd_sc_hd__o31ai_1
X_11532_ _07313_ _07164_ net421 VSS VSS VDD VDD _07803_ sky130_fd_sc_hd__a21oi_1
X_11533_ _07587_ _07632_ VSS VSS VDD VDD _07804_ sky130_fd_sc_hd__nand2_1
X_11534_ net358 net416 VSS VSS VDD VDD _07805_ sky130_fd_sc_hd__nand2_1
X_11535_ _07803_ _07804_ _07793_ _07805_ net408 VSS VSS VDD
+ VDD _07806_ sky130_fd_sc_hd__o221ai_1
X_11536_ _07800_ _07802_ _07806_ VSS VSS VDD VDD _07807_ sky130_fd_sc_hd__a21oi_1
X_11537_ _07616_ _07799_ _07807_ VSS VSS VDD VDD _07808_ sky130_fd_sc_hd__o21ai_0
X_11538_ net408 _07790_ _07792_ _07795_ _07808_ VSS VSS VDD
+ VDD _07809_ sky130_fd_sc_hd__o41ai_1
X_11539_ net318 _07784_ _07809_ net316 VSS VSS VDD VDD _01518_
+ sky130_fd_sc_hd__o22ai_1
X_11540_ net361 _07241_ _07587_ net344 network.neuron_hid0.ROM0.address\[4\]
+ VSS VSS VDD VDD _07810_ sky130_fd_sc_hd__o2111ai_1
X_11541_ _07162_ net314 _07241_ _07298_ net332 VSS VSS VDD
+ VDD _07811_ sky130_fd_sc_hd__a221oi_1
Xplace405 net406 VSS VSS VDD VDD net404 sky130_fd_sc_hd__buf_4
X_11543_ _07115_ net333 _07678_ VSS VSS VDD VDD _07813_ sky130_fd_sc_hd__o21ai_0
X_11544_ _07590_ _07249_ VSS VSS VDD VDD _07814_ sky130_fd_sc_hd__nand2_1
X_11545_ _07695_ _07814_ net412 VSS VSS VDD VDD _07815_ sky130_fd_sc_hd__a21oi_1
X_11546_ net412 _07813_ _07815_ _07738_ VSS VSS VDD VDD _07816_
+ sky130_fd_sc_hd__a211oi_1
X_11547_ _07624_ _07811_ _07816_ net415 VSS VSS VDD VDD _07817_
+ sky130_fd_sc_hd__o22ai_1
X_11548_ _07162_ _07571_ VSS VSS VDD VDD _07818_ sky130_fd_sc_hd__nor2_1
X_11549_ net356 _07158_ _07307_ net325 VSS VSS VDD VDD _07819_
+ sky130_fd_sc_hd__o22ai_1
X_11550_ net358 net417 VSS VSS VDD VDD _07820_ sky130_fd_sc_hd__nand2_1
X_11551_ net349 _07820_ _07676_ VSS VSS VDD VDD _07821_ sky130_fd_sc_hd__a21oi_1
X_11552_ _07819_ _07821_ net421 VSS VSS VDD VDD _07822_ sky130_fd_sc_hd__o21ai_0
X_11553_ net354 net319 _07818_ net411 _07822_ VSS VSS VDD
+ VDD _07823_ sky130_fd_sc_hd__o221ai_1
X_11554_ net351 net315 net411 VSS VSS VDD VDD _07824_ sky130_fd_sc_hd__o21ai_0
X_11555_ _07644_ _07824_ net415 VSS VSS VDD VDD _07825_ sky130_fd_sc_hd__a21oi_1
X_11556_ _07823_ _07825_ net408 VSS VSS VDD VDD _07826_ sky130_fd_sc_hd__o21ai_0
X_11557_ net408 _07817_ _07826_ VSS VSS VDD VDD _07827_ sky130_fd_sc_hd__o21ai_0
X_11558_ net419 net348 net341 VSS VSS VDD VDD _07828_ sky130_fd_sc_hd__o21ai_0
X_11559_ net413 net348 _07249_ VSS VSS VDD VDD _07829_ sky130_fd_sc_hd__o21ai_0
X_11560_ net413 _07828_ _07829_ net419 VSS VSS VDD VDD _07830_
+ sky130_fd_sc_hd__a22oi_1
X_11561_ net325 _07707_ _07668_ VSS VSS VDD VDD _07831_ sky130_fd_sc_hd__a21oi_1
X_11562_ net418 _07830_ _07831_ net413 VSS VSS VDD VDD _07832_
+ sky130_fd_sc_hd__o22ai_1
X_11563_ net306 _07810_ _07827_ _07832_ net307 VSS VSS VDD
+ VDD _01519_ sky130_fd_sc_hd__a32o_1
X_11564_ net400 _07553_ VSS VSS VDD VDD _07833_ sky130_fd_sc_hd__nand2_1
X_11565_ network.in_period\[241\]\[1\] _07833_ VSS VSS VDD
+ VDD _07834_ sky130_fd_sc_hd__nand2_1
X_11566_ _00520_ _07833_ _07834_ VSS VSS VDD VDD _03029_ sky130_fd_sc_hd__o21ai_0
X_11567_ network.in_period\[241\]\[0\] _07833_ VSS VSS VDD
+ VDD _07835_ sky130_fd_sc_hd__nand2_1
X_11568_ network.neuron_in241.counter\[0\] _07833_ _07835_
+ VSS VSS VDD VDD _03028_ sky130_fd_sc_hd__o21ai_0
X_11569_ network.neuron_in190.counter\[1\] VSS VSS VDD VDD
+ _00975_ sky130_fd_sc_hd__inv_1
X_11570_ network.in_period\[242\]\[1\] _07561_ VSS VSS VDD
+ VDD _07836_ sky130_fd_sc_hd__nand2_1
X_11571_ _00586_ _07561_ _07836_ VSS VSS VDD VDD _03033_ sky130_fd_sc_hd__o21ai_0
X_11572_ network.neuron_in243.counter\[0\] VSS VSS VDD VDD
+ _00778_ sky130_fd_sc_hd__inv_1
X_11573_ network.in_period\[243\]\[0\] _07432_ VSS VSS VDD
+ VDD _07837_ sky130_fd_sc_hd__nand2_1
X_11574_ network.neuron_in243.counter\[0\] _07432_ _07837_
+ VSS VSS VDD VDD _03036_ sky130_fd_sc_hd__o21ai_0
X_11575_ network.neuron_in244.counter\[0\] VSS VSS VDD VDD
+ _00922_ sky130_fd_sc_hd__inv_1
X_11576_ network.in_period\[244\]\[0\] _07445_ VSS VSS VDD
+ VDD _07838_ sky130_fd_sc_hd__nand2_1
X_11577_ network.neuron_in244.counter\[0\] _07445_ _07838_
+ VSS VSS VDD VDD _03040_ sky130_fd_sc_hd__o21ai_0
X_11578_ network.neuron_in085.counter\[0\] VSS VSS VDD VDD
+ _00050_ sky130_fd_sc_hd__inv_1
X_11579_ network.neuron_in159.counter\[1\] VSS VSS VDD VDD
+ _00632_ sky130_fd_sc_hd__inv_1
X_11580_ network.neuron_in128.counter\[0\] VSS VSS VDD VDD
+ _00635_ sky130_fd_sc_hd__inv_1
X_11581_ network.neuron_in194.counter\[1\] VSS VSS VDD VDD
+ _00971_ sky130_fd_sc_hd__inv_1
X_11582_ network.neuron_in126.counter\[1\] VSS VSS VDD VDD
+ _00727_ sky130_fd_sc_hd__inv_1
X_11583_ network.neuron_in128.counter\[1\] VSS VSS VDD VDD
+ _00636_ sky130_fd_sc_hd__inv_1
X_11584_ network.neuron_in048.counter\[0\] VSS VSS VDD VDD
+ _00262_ sky130_fd_sc_hd__inv_1
X_11585_ net335 _07355_ _07186_ VSS VSS VDD VDD _07839_ sky130_fd_sc_hd__o21ai_0
X_11586_ net420 _07207_ _07839_ VSS VSS VDD VDD _07840_ sky130_fd_sc_hd__nand3_1
X_11587_ net331 _07299_ net365 _07720_ VSS VSS VDD VDD _07841_
+ sky130_fd_sc_hd__o211ai_1
X_11588_ _07840_ _07841_ net410 VSS VSS VDD VDD _07842_ sky130_fd_sc_hd__a21oi_1
Xplace404 net404 VSS VSS VDD VDD net403 sky130_fd_sc_hd__buf_4
X_11590_ net417 _07181_ _07241_ VSS VSS VDD VDD _07844_ sky130_fd_sc_hd__o21ai_0
X_11591_ net422 net340 _07115_ _07616_ VSS VSS VDD VDD _07845_
+ sky130_fd_sc_hd__a31oi_1
X_11592_ _07632_ _07844_ _07845_ VSS VSS VDD VDD _07846_ sky130_fd_sc_hd__a21oi_1
X_11593_ net339 _07846_ VSS VSS VDD VDD _07847_ sky130_fd_sc_hd__nand2_1
X_11594_ net418 _07287_ net424 VSS VSS VDD VDD _07848_ sky130_fd_sc_hd__a21oi_1
X_11595_ net349 _07331_ net410 VSS VSS VDD VDD _07849_ sky130_fd_sc_hd__a21oi_1
X_11596_ net410 net325 _07289_ _07848_ _07849_ VSS VSS VDD
+ VDD _07850_ sky130_fd_sc_hd__a311o_1
X_11597_ net415 _07115_ VSS VSS VDD VDD _07851_ sky130_fd_sc_hd__nor2_1
X_11598_ _07047_ _07099_ net410 VSS VSS VDD VDD _07852_ sky130_fd_sc_hd__a21oi_1
X_11599_ _07851_ _07852_ VSS VSS VDD VDD _07853_ sky130_fd_sc_hd__nor2_1
X_11600_ net418 net422 _07115_ _07728_ net410 VSS VSS VDD
+ VDD _07854_ sky130_fd_sc_hd__a32oi_1
X_11601_ net418 _07853_ _07854_ net415 VSS VSS VDD VDD _07855_
+ sky130_fd_sc_hd__o22ai_1
X_11602_ net415 _07850_ _07855_ VSS VSS VDD VDD _07856_ sky130_fd_sc_hd__a21oi_1
X_11603_ _07842_ _07847_ _07856_ net339 net306 VSS VSS VDD
+ VDD _07857_ sky130_fd_sc_hd__o221ai_1
X_11604_ net422 _07581_ net425 VSS VSS VDD VDD _07858_ sky130_fd_sc_hd__o21ai_0
X_11605_ net349 _07858_ VSS VSS VDD VDD _07859_ sky130_fd_sc_hd__nand2_1
X_11606_ net419 _07859_ VSS VSS VDD VDD _07860_ sky130_fd_sc_hd__nand2_1
X_11607_ net419 _07618_ _07860_ net307 _07380_ VSS VSS VDD
+ VDD _07861_ sky130_fd_sc_hd__o2111ai_1
X_11608_ _07857_ _07861_ VSS VSS VDD VDD _01520_ sky130_fd_sc_hd__nand2_1
X_11609_ net419 net342 net345 VSS VSS VDD VDD _07862_ sky130_fd_sc_hd__a21oi_1
X_11610_ _07676_ _07638_ _07862_ net413 VSS VSS VDD VDD _07863_
+ sky130_fd_sc_hd__o22ai_1
X_11611_ net351 net314 VSS VSS VDD VDD _07864_ sky130_fd_sc_hd__nand2_1
X_11612_ _07645_ _07864_ net413 VSS VSS VDD VDD _07865_ sky130_fd_sc_hd__a21oi_1
X_11613_ _07056_ _07863_ _07865_ VSS VSS VDD VDD _07866_ sky130_fd_sc_hd__a21oi_1
X_11614_ net418 _07329_ VSS VSS VDD VDD _07867_ sky130_fd_sc_hd__nand2_1
X_11615_ net413 _07867_ VSS VSS VDD VDD _07868_ sky130_fd_sc_hd__nand2_1
X_11616_ _07599_ net336 _07868_ VSS VSS VDD VDD _07869_ sky130_fd_sc_hd__nand3_1
X_11617_ net351 _07714_ net331 VSS VSS VDD VDD _07870_ sky130_fd_sc_hd__a21oi_1
X_11618_ net364 _07714_ net335 net419 VSS VSS VDD VDD _07871_
+ sky130_fd_sc_hd__a211oi_1
X_11619_ net419 _07870_ _07871_ VSS VSS VDD VDD _07872_ sky130_fd_sc_hd__a21oi_1
X_11620_ net422 _07869_ _07872_ VSS VSS VDD VDD _07873_ sky130_fd_sc_hd__a21oi_1
X_11621_ net415 net324 _07180_ _07587_ VSS VSS VDD VDD _07874_
+ sky130_fd_sc_hd__o31ai_1
X_11622_ net421 _07720_ VSS VSS VDD VDD _07875_ sky130_fd_sc_hd__nor2_1
X_11623_ _07046_ net425 net353 VSS VSS VDD VDD _07876_ sky130_fd_sc_hd__nor3_1
X_11624_ _07875_ _07876_ net416 VSS VSS VDD VDD _07877_ sky130_fd_sc_hd__o21ai_0
X_11625_ _07140_ _07877_ VSS VSS VDD VDD _07878_ sky130_fd_sc_hd__nand2_1
X_11626_ net422 _07874_ _07878_ VSS VSS VDD VDD _07879_ sky130_fd_sc_hd__a21oi_1
X_11627_ net366 net420 VSS VSS VDD VDD _07880_ sky130_fd_sc_hd__nand2_1
X_11628_ net413 _07707_ _07289_ VSS VSS VDD VDD _07881_ sky130_fd_sc_hd__o21ai_0
X_11629_ _07056_ _07881_ VSS VSS VDD VDD _07882_ sky130_fd_sc_hd__nand2_1
X_11630_ _07127_ _07880_ _07882_ VSS VSS VDD VDD _07883_ sky130_fd_sc_hd__o21ai_0
X_11631_ network.neuron_hid0.ROM0.address\[4\] net419 VSS
+ VSS VDD VDD _07884_ sky130_fd_sc_hd__nor2_1
X_11632_ net413 net359 net346 net351 _07884_ VSS VSS VDD VDD
+ _07885_ sky130_fd_sc_hd__a32oi_1
X_11633_ net425 _07885_ VSS VSS VDD VDD _07886_ sky130_fd_sc_hd__nor2_1
X_11634_ net425 _07883_ _07886_ VSS VSS VDD VDD _07887_ sky130_fd_sc_hd__a21oi_1
X_11635_ _07675_ _07879_ _07887_ _07254_ VSS VSS VDD VDD _07888_
+ sky130_fd_sc_hd__o22ai_1
X_11636_ _07127_ _07361_ _07312_ VSS VSS VDD VDD _07889_ sky130_fd_sc_hd__o21ai_0
X_11637_ net424 net351 net349 VSS VSS VDD VDD _07890_ sky130_fd_sc_hd__o21ai_0
X_11638_ net365 _07890_ _07608_ VSS VSS VDD VDD _07891_ sky130_fd_sc_hd__a21oi_1
X_11639_ net413 _07891_ VSS VSS VDD VDD _07892_ sky130_fd_sc_hd__nor2_1
X_11640_ net424 _07299_ _07592_ _07889_ _07892_ VSS VSS VDD
+ VDD _07893_ sky130_fd_sc_hd__a311oi_1
X_11641_ net344 _07873_ _07888_ _07893_ VSS VSS VDD VDD _07894_
+ sky130_fd_sc_hd__a211oi_1
X_11642_ net318 _07866_ _07894_ net316 VSS VSS VDD VDD _01521_
+ sky130_fd_sc_hd__o22ai_1
X_11643_ net353 _07118_ net421 VSS VSS VDD VDD _07895_ sky130_fd_sc_hd__o21ai_0
X_11644_ _07814_ _07895_ net416 VSS VSS VDD VDD _07896_ sky130_fd_sc_hd__a21oi_1
X_11645_ net353 net330 _07896_ VSS VSS VDD VDD _07897_ sky130_fd_sc_hd__a21o_1
X_11646_ net421 _07751_ _07876_ VSS VSS VDD VDD _07898_ sky130_fd_sc_hd__o21bai_1
X_11647_ net363 net349 net365 VSS VSS VDD VDD _07899_ sky130_fd_sc_hd__a21oi_1
X_11648_ net418 _07828_ _07899_ VSS VSS VDD VDD _07900_ sky130_fd_sc_hd__a21oi_1
X_11649_ net419 net361 VSS VSS VDD VDD _07901_ sky130_fd_sc_hd__nand2_1
X_11650_ _07590_ net364 net424 VSS VSS VDD VDD _07902_ sky130_fd_sc_hd__o21ai_0
X_11651_ _07901_ _07612_ _07902_ VSS VSS VDD VDD _07903_ sky130_fd_sc_hd__nand3_1
X_11652_ _07046_ net356 VSS VSS VDD VDD _07904_ sky130_fd_sc_hd__nor2_1
X_11653_ _07323_ _07904_ _07632_ VSS VSS VDD VDD _07905_ sky130_fd_sc_hd__o21ai_0
X_11654_ _07616_ _07900_ _07903_ _07905_ net408 VSS VSS VDD
+ VDD _07906_ sky130_fd_sc_hd__o2111ai_1
X_11655_ _07800_ _07898_ _07906_ VSS VSS VDD VDD _07907_ sky130_fd_sc_hd__a21oi_1
X_11656_ net417 net334 net425 VSS VSS VDD VDD _07908_ sky130_fd_sc_hd__o21ai_0
X_11657_ net421 net354 _07659_ VSS VSS VDD VDD _07909_ sky130_fd_sc_hd__nand3_1
X_11658_ net421 net351 net315 _07909_ VSS VSS VDD VDD _07910_
+ sky130_fd_sc_hd__o31ai_1
X_11659_ _07908_ _07910_ _07624_ VSS VSS VDD VDD _07911_ sky130_fd_sc_hd__a21oi_1
X_11660_ net363 _07162_ VSS VSS VDD VDD _07912_ sky130_fd_sc_hd__nand2_1
X_11661_ net353 net334 net424 VSS VSS VDD VDD _07913_ sky130_fd_sc_hd__o21ai_0
X_11662_ _07912_ _07913_ _07805_ VSS VSS VDD VDD _07914_ sky130_fd_sc_hd__a21oi_1
X_11663_ net421 net347 net352 net423 _07207_ VSS VSS VDD VDD
+ _07915_ sky130_fd_sc_hd__o221ai_1
X_11664_ net423 _07323_ _07616_ net351 VSS VSS VDD VDD _07916_
+ sky130_fd_sc_hd__a211oi_1
X_11665_ _07800_ _07915_ _07916_ net408 VSS VSS VDD VDD _07917_
+ sky130_fd_sc_hd__a211o_1
X_11666_ _07911_ _07914_ _07917_ VSS VSS VDD VDD _07918_ sky130_fd_sc_hd__nor3_1
X_11667_ network.neuron_hid0.ROM0.address\[7\] _07907_ _07918_
+ VSS VSS VDD VDD _07919_ sky130_fd_sc_hd__nor3_1
X_11668_ network.neuron_hid0.ROM0.address\[7\] net344 _07897_
+ _07919_ VSS VSS VDD VDD _07920_ sky130_fd_sc_hd__a31oi_1
X_11669_ _07042_ _07920_ VSS VSS VDD VDD _01522_ sky130_fd_sc_hd__nor2_1
X_11670_ net418 net330 VSS VSS VDD VDD _07921_ sky130_fd_sc_hd__nor2_1
X_11671_ net418 _07652_ _07332_ VSS VSS VDD VDD _07922_ sky130_fd_sc_hd__o21ai_0
X_11672_ net410 _07922_ VSS VSS VDD VDD _07923_ sky130_fd_sc_hd__nand2_1
X_11673_ net415 _07331_ _07921_ net410 _07923_ VSS VSS VDD
+ VDD _07924_ sky130_fd_sc_hd__o221ai_1
X_11674_ net410 net365 net346 net359 VSS VSS VDD VDD _07925_
+ sky130_fd_sc_hd__o31ai_1
X_11675_ _07313_ net338 net325 VSS VSS VDD VDD _07926_ sky130_fd_sc_hd__a21oi_1
X_11676_ net415 _07848_ VSS VSS VDD VDD _07927_ sky130_fd_sc_hd__nand2_1
X_11677_ net419 _07926_ _07927_ VSS VSS VDD VDD _07928_ sky130_fd_sc_hd__o21ai_0
X_11678_ net422 _07924_ _07925_ _07714_ _07928_ net410 VSS
+ VSS VDD VDD _07929_ sky130_fd_sc_hd__a222oi_1
X_11679_ _07046_ _07127_ VSS VSS VDD VDD _07930_ sky130_fd_sc_hd__nor2_1
X_11680_ _07180_ _07930_ net414 VSS VSS VDD VDD _07931_ sky130_fd_sc_hd__o21ai_0
X_11681_ net414 _07241_ _07931_ VSS VSS VDD VDD _07932_ sky130_fd_sc_hd__o21ai_0
X_11682_ net346 _07820_ _07880_ VSS VSS VDD VDD _07933_ sky130_fd_sc_hd__a21oi_1
X_11683_ net411 _07932_ _07933_ net337 VSS VSS VDD VDD _07934_
+ sky130_fd_sc_hd__a211o_1
X_11684_ net411 _07162_ _07215_ VSS VSS VDD VDD _07935_ sky130_fd_sc_hd__a21oi_1
X_11685_ net349 _07331_ _07935_ _07047_ VSS VSS VDD VDD _07936_
+ sky130_fd_sc_hd__o22ai_1
X_11686_ _07109_ _07584_ net413 VSS VSS VDD VDD _07937_ sky130_fd_sc_hd__o21ai_0
X_11687_ net424 _07287_ net418 VSS VSS VDD VDD _07938_ sky130_fd_sc_hd__a21oi_1
X_11688_ net348 _07289_ net413 VSS VSS VDD VDD _07939_ sky130_fd_sc_hd__a21oi_1
X_11689_ _07938_ _07939_ VSS VSS VDD VDD _07940_ sky130_fd_sc_hd__nor2_1
X_11690_ _07937_ _07940_ net410 VSS VSS VDD VDD _07941_ sky130_fd_sc_hd__a21oi_1
X_11691_ net424 _07934_ _07936_ _07941_ net409 VSS VSS VDD
+ VDD _07942_ sky130_fd_sc_hd__a2111o_1
X_11692_ net339 _07929_ _07942_ VSS VSS VDD VDD _07943_ sky130_fd_sc_hd__o21ai_0
X_11693_ net413 _07654_ _07851_ VSS VSS VDD VDD _07944_ sky130_fd_sc_hd__a21oi_1
X_11694_ net422 _07944_ VSS VSS VDD VDD _07945_ sky130_fd_sc_hd__nor2_1
X_11695_ net357 _07752_ _07945_ VSS VSS VDD VDD _07946_ sky130_fd_sc_hd__a21oi_1
X_11696_ net413 net340 _07638_ _07946_ net418 VSS VSS VDD
+ VDD _07947_ sky130_fd_sc_hd__o32ai_1
X_11697_ net306 _07943_ _07947_ net307 VSS VSS VDD VDD _01523_
+ sky130_fd_sc_hd__a22o_1
X_11698_ network.neuron_in251.counter\[2\] VSS VSS VDD VDD
+ _07948_ sky130_fd_sc_hd__inv_1
X_11699_ network.neuron_in251.counter\[3\] VSS VSS VDD VDD
+ _07949_ sky130_fd_sc_hd__inv_1
X_11700_ _07948_ _01012_ _07949_ VSS VSS VDD VDD _07950_ sky130_fd_sc_hd__nand3_1
X_11701_ net398 _07950_ VSS VSS VDD VDD _07951_ sky130_fd_sc_hd__nand2_1
X_11702_ network.in_period\[251\]\[0\] _07951_ VSS VSS VDD
+ VDD _07952_ sky130_fd_sc_hd__nand2_1
X_11703_ network.neuron_in251.counter\[0\] _07951_ _07952_
+ VSS VSS VDD VDD _03068_ sky130_fd_sc_hd__o21ai_0
X_11704_ network.neuron_in247.counter\[0\] VSS VSS VDD VDD
+ _00756_ sky130_fd_sc_hd__inv_1
X_11705_ network.neuron_in247.counter\[3\] _00758_ VSS VSS
+ VDD VDD _07953_ sky130_fd_sc_hd__nand2b_1
X_11706_ network.neuron_in247.counter\[2\] _07953_ VSS VSS
+ VDD VDD _07954_ sky130_fd_sc_hd__or2_2
X_11707_ net399 _07954_ VSS VSS VDD VDD _07955_ sky130_fd_sc_hd__nand2_1
X_11708_ network.in_period\[247\]\[0\] _07955_ VSS VSS VDD
+ VDD _07956_ sky130_fd_sc_hd__nand2_1
X_11709_ network.neuron_in247.counter\[0\] _07955_ _07956_
+ VSS VSS VDD VDD _03052_ sky130_fd_sc_hd__o21ai_0
X_11710_ network.neuron_in249.counter\[2\] _00404_ VSS VSS
+ VDD VDD _07957_ sky130_fd_sc_hd__xnor2_1
X_11711_ network.neuron_in249.counter\[2\] network.neuron_in249.counter\[3\]
+ VSS VSS VDD VDD _07958_ sky130_fd_sc_hd__nor2_1
X_11712_ _00404_ _07958_ VSS VSS VDD VDD _07959_ sky130_fd_sc_hd__nand2_1
X_11713_ net399 _07959_ network.in_period\[249\]\[2\] VSS
+ VSS VDD VDD _07960_ sky130_fd_sc_hd__a21oi_1
X_11714_ net399 _07957_ _07960_ VSS VSS VDD VDD _03062_ sky130_fd_sc_hd__a21oi_1
X_11715_ network.in_period\[251\]\[1\] _07951_ VSS VSS VDD
+ VDD _07961_ sky130_fd_sc_hd__nand2_1
X_11716_ _01013_ _07951_ _07961_ VSS VSS VDD VDD _03069_ sky130_fd_sc_hd__o21ai_0
X_11717_ network.neuron_in246.counter\[0\] VSS VSS VDD VDD
+ _00666_ sky130_fd_sc_hd__inv_1
X_11718_ network.neuron_in246.counter\[3\] _00668_ VSS VSS
+ VDD VDD _07962_ sky130_fd_sc_hd__nand2b_1
X_11719_ network.neuron_in246.counter\[2\] VSS VSS VDD VDD
+ _07963_ sky130_fd_sc_hd__inv_1
X_11720_ _07962_ _07963_ VSS VSS VDD VDD _07964_ sky130_fd_sc_hd__nand2b_1
X_11721_ net399 _07964_ VSS VSS VDD VDD _07965_ sky130_fd_sc_hd__nand2_1
X_11722_ network.in_period\[246\]\[0\] _07965_ VSS VSS VDD
+ VDD _07966_ sky130_fd_sc_hd__nand2_1
X_11723_ network.neuron_in246.counter\[0\] _07965_ _07966_
+ VSS VSS VDD VDD _03048_ sky130_fd_sc_hd__o21ai_0
X_11724_ network.in_period\[247\]\[1\] _07955_ VSS VSS VDD
+ VDD _07967_ sky130_fd_sc_hd__nand2_1
X_11725_ _00759_ _07955_ _07967_ VSS VSS VDD VDD _03053_ sky130_fd_sc_hd__o21ai_0
X_11726_ network.neuron_in248.counter\[0\] VSS VSS VDD VDD
+ _00918_ sky130_fd_sc_hd__inv_1
X_11727_ network.neuron_in248.counter\[2\] _00920_ VSS VSS
+ VDD VDD _07968_ sky130_fd_sc_hd__nor2b_1
X_11728_ network.neuron_in248.counter\[3\] _07968_ VSS VSS
+ VDD VDD _07969_ sky130_fd_sc_hd__nand2b_1
X_11729_ net399 _07969_ VSS VSS VDD VDD _07970_ sky130_fd_sc_hd__nand2_1
X_11730_ network.in_period\[248\]\[0\] _07970_ VSS VSS VDD
+ VDD _07971_ sky130_fd_sc_hd__nand2_1
X_11731_ network.neuron_in248.counter\[0\] _07970_ _07971_
+ VSS VSS VDD VDD _03056_ sky130_fd_sc_hd__o21ai_0
X_11732_ _01085_ network.neuron_in250.counter\[2\] VSS VSS
+ VDD VDD _07972_ sky130_fd_sc_hd__xnor2_1
X_11733_ network.neuron_in250.counter\[2\] network.neuron_in250.counter\[3\]
+ VSS VSS VDD VDD _07973_ sky130_fd_sc_hd__nor2_1
X_11734_ _01085_ _07973_ VSS VSS VDD VDD _07974_ sky130_fd_sc_hd__nand2_1
X_11735_ net398 _07974_ network.in_period\[250\]\[2\] VSS
+ VSS VDD VDD _07975_ sky130_fd_sc_hd__a21oi_1
X_11736_ net398 _07972_ _07975_ VSS VSS VDD VDD _03066_ sky130_fd_sc_hd__a21oi_1
X_11737_ network.neuron_in251.counter\[3\] network.in_period\[251\]\[2\]
+ net380 _01012_ VSS VSS VDD VDD _07976_ sky130_fd_sc_hd__o22ai_1
Xplace403 net406 VSS VSS VDD VDD net402 sky130_fd_sc_hd__buf_4
X_11739_ network.neuron_in251.counter\[2\] _01012_ net399
+ VSS VSS VDD VDD _07978_ sky130_fd_sc_hd__nand3_1
X_11740_ network.in_period\[251\]\[2\] net398 _07978_ VSS
+ VSS VDD VDD _07979_ sky130_fd_sc_hd__o21ai_0
X_11741_ _07948_ _07976_ _07979_ VSS VSS VDD VDD _03070_ sky130_fd_sc_hd__a21oi_1
X_11742_ network.in_period\[246\]\[2\] network.neuron_in246.counter\[3\]
+ _00668_ net368 VSS VSS VDD VDD _07980_ sky130_fd_sc_hd__o22ai_1
X_11743_ network.neuron_in246.counter\[2\] _00668_ net399
+ VSS VSS VDD VDD _07981_ sky130_fd_sc_hd__nand3_1
X_11744_ network.in_period\[246\]\[2\] net399 _07981_ VSS
+ VSS VDD VDD _07982_ sky130_fd_sc_hd__o21ai_0
X_11745_ _07963_ _07980_ _07982_ VSS VSS VDD VDD _03050_ sky130_fd_sc_hd__a21oi_1
X_11746_ network.in_period\[246\]\[1\] _07965_ VSS VSS VDD
+ VDD _07983_ sky130_fd_sc_hd__nand2_1
X_11747_ _00669_ _07965_ _07983_ VSS VSS VDD VDD _03049_ sky130_fd_sc_hd__o21ai_0
X_11748_ network.neuron_in247.counter\[2\] _00758_ VSS VSS
+ VDD VDD _07984_ sky130_fd_sc_hd__xnor2_1
X_11749_ network.neuron_in247.counter\[2\] network.neuron_in247.counter\[3\]
+ VSS VSS VDD VDD _07985_ sky130_fd_sc_hd__nor2_1
X_11750_ net368 _07985_ VSS VSS VDD VDD _07986_ sky130_fd_sc_hd__nor2_1
X_11751_ network.in_period\[247\]\[2\] _07986_ VSS VSS VDD
+ VDD _07987_ sky130_fd_sc_hd__nor2_1
X_11752_ net399 _07984_ _07987_ VSS VSS VDD VDD _03054_ sky130_fd_sc_hd__a21oi_1
X_11753_ network.neuron_in248.counter\[2\] VSS VSS VDD VDD
+ _07988_ sky130_fd_sc_hd__inv_1
X_11754_ network.neuron_in248.counter\[3\] network.in_period\[248\]\[2\]
+ _00920_ net368 VSS VSS VDD VDD _07989_ sky130_fd_sc_hd__o22ai_1
X_11755_ network.neuron_in248.counter\[2\] _00920_ net399
+ VSS VSS VDD VDD _07990_ sky130_fd_sc_hd__nand3_1
X_11756_ network.in_period\[248\]\[2\] net399 _07990_ VSS
+ VSS VDD VDD _07991_ sky130_fd_sc_hd__o21ai_0
X_11757_ _07988_ _07989_ _07991_ VSS VSS VDD VDD _03058_ sky130_fd_sc_hd__a21oi_1
X_11758_ network.in_period\[248\]\[1\] _07970_ VSS VSS VDD
+ VDD _07992_ sky130_fd_sc_hd__nand2_1
X_11759_ _00921_ _07970_ _07992_ VSS VSS VDD VDD _03057_ sky130_fd_sc_hd__o21ai_0
X_11760_ net399 _07959_ VSS VSS VDD VDD _07993_ sky130_fd_sc_hd__nand2_1
X_11761_ network.in_period\[249\]\[1\] _07993_ VSS VSS VDD
+ VDD _07994_ sky130_fd_sc_hd__nand2_1
X_11762_ _00405_ _07993_ _07994_ VSS VSS VDD VDD _03061_ sky130_fd_sc_hd__o21ai_0
X_11763_ network.in_period\[249\]\[0\] _07993_ VSS VSS VDD
+ VDD _07995_ sky130_fd_sc_hd__nand2_1
X_11764_ network.neuron_in249.counter\[0\] _07993_ _07995_
+ VSS VSS VDD VDD _03060_ sky130_fd_sc_hd__o21ai_0
X_11765_ net398 _07974_ VSS VSS VDD VDD _07996_ sky130_fd_sc_hd__nand2_1
X_11766_ network.in_period\[250\]\[1\] _07996_ VSS VSS VDD
+ VDD _07997_ sky130_fd_sc_hd__nand2_1
X_11767_ _01086_ _07996_ _07997_ VSS VSS VDD VDD _03065_ sky130_fd_sc_hd__o21ai_0
X_11768_ network.in_period\[250\]\[0\] _07996_ VSS VSS VDD
+ VDD _07998_ sky130_fd_sc_hd__nand2_1
X_11769_ network.neuron_in250.counter\[0\] _07996_ _07998_
+ VSS VSS VDD VDD _03064_ sky130_fd_sc_hd__o21ai_0
X_11770_ network.neuron_in253.counter\[0\] VSS VSS VDD VDD
+ _01127_ sky130_fd_sc_hd__inv_1
X_11771_ network.neuron_in253.counter\[2\] network.neuron_in253.counter\[3\]
+ VSS VSS VDD VDD _07999_ sky130_fd_sc_hd__nor2_1
X_11772_ _01129_ _07999_ VSS VSS VDD VDD _08000_ sky130_fd_sc_hd__nand2_1
X_11773_ net399 _08000_ VSS VSS VDD VDD _08001_ sky130_fd_sc_hd__nand2_1
X_11774_ network.in_period\[253\]\[0\] _08001_ VSS VSS VDD
+ VDD _08002_ sky130_fd_sc_hd__nand2_1
X_11775_ network.neuron_in253.counter\[0\] _08001_ _08002_
+ VSS VSS VDD VDD _03076_ sky130_fd_sc_hd__o21ai_0
X_11776_ network.neuron_in252.counter\[0\] VSS VSS VDD VDD
+ _00930_ sky130_fd_sc_hd__inv_1
X_11777_ network.neuron_in252.counter\[3\] _00932_ VSS VSS
+ VDD VDD _08003_ sky130_fd_sc_hd__nand2b_1
X_11778_ network.neuron_in252.counter\[2\] VSS VSS VDD VDD
+ _08004_ sky130_fd_sc_hd__inv_1
X_11779_ _08003_ _08004_ VSS VSS VDD VDD _08005_ sky130_fd_sc_hd__nand2b_1
X_11780_ net399 _08005_ VSS VSS VDD VDD _08006_ sky130_fd_sc_hd__nand2_1
X_11781_ network.in_period\[252\]\[0\] _08006_ VSS VSS VDD
+ VDD _08007_ sky130_fd_sc_hd__nand2_1
X_11782_ network.neuron_in252.counter\[0\] _08006_ _08007_
+ VSS VSS VDD VDD _03072_ sky130_fd_sc_hd__o21ai_0
X_11783_ network.in_period\[253\]\[1\] _08001_ VSS VSS VDD
+ VDD _08008_ sky130_fd_sc_hd__nand2_1
X_11784_ _01130_ _08001_ _08008_ VSS VSS VDD VDD _03077_ sky130_fd_sc_hd__o21ai_0
X_11785_ network.neuron_in254.counter\[0\] VSS VSS VDD VDD
+ _00914_ sky130_fd_sc_hd__inv_1
Xplace402 net407 VSS VSS VDD VDD net401 sky130_fd_sc_hd__buf_4
X_11787_ network.neuron_in254.counter\[2\] network.neuron_in254.counter\[3\]
+ VSS VSS VDD VDD _08010_ sky130_fd_sc_hd__nor2_1
X_11788_ _00916_ _08010_ VSS VSS VDD VDD _08011_ sky130_fd_sc_hd__nand2_1
X_11789_ net398 _08011_ VSS VSS VDD VDD _08012_ sky130_fd_sc_hd__nand2_1
X_11790_ network.in_period\[254\]\[0\] _08012_ VSS VSS VDD
+ VDD _08013_ sky130_fd_sc_hd__nand2_1
X_11791_ network.neuron_in254.counter\[0\] _08012_ _08013_
+ VSS VSS VDD VDD _03080_ sky130_fd_sc_hd__o21ai_0
X_11792_ network.neuron_in255.counter\[0\] VSS VSS VDD VDD
+ _00770_ sky130_fd_sc_hd__inv_1
X_11793_ network.neuron_in255.counter\[2\] network.neuron_in255.counter\[3\]
+ VSS VSS VDD VDD _08014_ sky130_fd_sc_hd__nor2_1
X_11794_ _00772_ _08014_ VSS VSS VDD VDD _08015_ sky130_fd_sc_hd__nand2_1
X_11795_ net399 _08015_ VSS VSS VDD VDD _08016_ sky130_fd_sc_hd__nand2_1
X_11796_ network.in_period\[255\]\[0\] _08016_ VSS VSS VDD
+ VDD _08017_ sky130_fd_sc_hd__nand2_1
X_11797_ network.neuron_in255.counter\[0\] _08016_ _08017_
+ VSS VSS VDD VDD _03084_ sky130_fd_sc_hd__o21ai_0
X_11798_ network.neuron_in252.counter\[3\] network.in_period\[252\]\[2\]
+ _00932_ net381 VSS VSS VDD VDD _08018_ sky130_fd_sc_hd__o22ai_1
X_11799_ network.neuron_in252.counter\[2\] _00932_ net399
+ VSS VSS VDD VDD _08019_ sky130_fd_sc_hd__nand3_1
X_11800_ network.in_period\[252\]\[2\] net399 _08019_ VSS
+ VSS VDD VDD _08020_ sky130_fd_sc_hd__o21ai_0
X_11801_ _08004_ _08018_ _08020_ VSS VSS VDD VDD _03074_ sky130_fd_sc_hd__a21oi_1
X_11802_ network.in_period\[252\]\[1\] _08006_ VSS VSS VDD
+ VDD _08021_ sky130_fd_sc_hd__nand2_1
X_11803_ _00933_ _08006_ _08021_ VSS VSS VDD VDD _03073_ sky130_fd_sc_hd__o21ai_0
X_11804_ _01129_ network.neuron_in253.counter\[2\] VSS VSS
+ VDD VDD _08022_ sky130_fd_sc_hd__xnor2_1
Xplace401 net401 VSS VSS VDD VDD net400 sky130_fd_sc_hd__buf_4
X_11806_ net399 _08000_ network.in_period\[253\]\[2\] VSS
+ VSS VDD VDD _08024_ sky130_fd_sc_hd__a21oi_1
X_11807_ net399 _08022_ _08024_ VSS VSS VDD VDD _03078_ sky130_fd_sc_hd__a21oi_1
X_11808_ network.neuron_in254.counter\[2\] VSS VSS VDD VDD
+ _08025_ sky130_fd_sc_hd__inv_1
X_11809_ network.neuron_in254.counter\[3\] network.in_period\[254\]\[2\]
+ _00916_ net380 VSS VSS VDD VDD _08026_ sky130_fd_sc_hd__o22ai_1
X_11810_ network.neuron_in254.counter\[2\] _00916_ net398
+ VSS VSS VDD VDD _08027_ sky130_fd_sc_hd__nand3_1
X_11811_ network.in_period\[254\]\[2\] net398 _08027_ VSS
+ VSS VDD VDD _08028_ sky130_fd_sc_hd__o21ai_0
X_11812_ _08025_ _08026_ _08028_ VSS VSS VDD VDD _03082_ sky130_fd_sc_hd__a21oi_1
X_11813_ network.in_period\[254\]\[1\] _08012_ VSS VSS VDD
+ VDD _08029_ sky130_fd_sc_hd__nand2_1
X_11814_ _00917_ _08012_ _08029_ VSS VSS VDD VDD _03081_ sky130_fd_sc_hd__o21ai_0
X_11815_ network.neuron_in255.counter\[2\] VSS VSS VDD VDD
+ _08030_ sky130_fd_sc_hd__inv_1
X_11816_ network.neuron_in255.counter\[3\] network.in_period\[255\]\[2\]
+ _00772_ net381 VSS VSS VDD VDD _08031_ sky130_fd_sc_hd__o22ai_1
X_11817_ network.neuron_in255.counter\[2\] _00772_ net399
+ VSS VSS VDD VDD _08032_ sky130_fd_sc_hd__nand3_1
X_11818_ network.in_period\[255\]\[2\] net399 _08032_ VSS
+ VSS VDD VDD _08033_ sky130_fd_sc_hd__o21ai_0
X_11819_ _08030_ _08031_ _08033_ VSS VSS VDD VDD _03086_ sky130_fd_sc_hd__a21oi_1
X_11820_ network.in_period\[255\]\[1\] _08016_ VSS VSS VDD
+ VDD _08034_ sky130_fd_sc_hd__nand2_1
X_11821_ _00773_ _08016_ _08034_ VSS VSS VDD VDD _03085_ sky130_fd_sc_hd__o21ai_0
X_11822_ network.neuron_in151.counter\[0\] VSS VSS VDD VDD
+ _00480_ sky130_fd_sc_hd__inv_1
X_11823_ network.neuron_in143.counter\[1\] VSS VSS VDD VDD
+ _00889_ sky130_fd_sc_hd__inv_1
X_11824_ network.neuron_in230.counter\[1\] VSS VSS VDD VDD
+ _00799_ sky130_fd_sc_hd__inv_1
X_11825_ network.neuron_in120.counter\[1\] VSS VSS VDD VDD
+ _00791_ sky130_fd_sc_hd__inv_1
X_11826_ network.in_period\[126\]\[1\] _06753_ VSS VSS VDD
+ VDD _08035_ sky130_fd_sc_hd__nand2_1
X_11827_ _00729_ _06753_ _08035_ VSS VSS VDD VDD _02569_ sky130_fd_sc_hd__o21ai_0
X_11828_ network.neuron_in126.counter\[2\] VSS VSS VDD VDD
+ _08036_ sky130_fd_sc_hd__inv_1
X_11829_ network.neuron_in126.counter\[3\] network.in_period\[126\]\[2\]
+ _00728_ net374 VSS VSS VDD VDD _08037_ sky130_fd_sc_hd__o22ai_1
X_11830_ network.neuron_in126.counter\[2\] _00728_ net384
+ VSS VSS VDD VDD _08038_ sky130_fd_sc_hd__nand3_1
X_11831_ network.in_period\[126\]\[2\] net384 _08038_ VSS
+ VSS VDD VDD _08039_ sky130_fd_sc_hd__o21ai_0
X_11832_ _08036_ _08037_ _08039_ VSS VSS VDD VDD _02570_ sky130_fd_sc_hd__a21oi_1
X_11833_ net383 _06745_ VSS VSS VDD VDD _08040_ sky130_fd_sc_hd__nand2_1
X_11834_ network.in_period\[135\]\[1\] _08040_ VSS VSS VDD
+ VDD _08041_ sky130_fd_sc_hd__nand2_1
X_11835_ _00866_ _08040_ _08041_ VSS VSS VDD VDD _02605_ sky130_fd_sc_hd__o21ai_0
X_11836_ network.neuron_in187.counter\[1\] VSS VSS VDD VDD
+ _00209_ sky130_fd_sc_hd__inv_1
X_11837_ network.neuron_in135.counter\[0\] VSS VSS VDD VDD
+ _00863_ sky130_fd_sc_hd__inv_1
X_11838_ network.in_period\[135\]\[0\] _08040_ VSS VSS VDD
+ VDD _08042_ sky130_fd_sc_hd__nand2_1
X_11839_ network.neuron_in135.counter\[0\] _08040_ _08042_
+ VSS VSS VDD VDD _02604_ sky130_fd_sc_hd__o21ai_0
X_11840_ network.neuron_in132.counter\[0\] VSS VSS VDD VDD
+ _00513_ sky130_fd_sc_hd__inv_1
Xplace400 net400 VSS VSS VDD VDD net399 sky130_fd_sc_hd__buf_4
X_11842_ network.neuron_in132.counter\[2\] _06430_ VSS VSS
+ VDD VDD _08044_ sky130_fd_sc_hd__or2_2
X_11843_ net384 _08044_ VSS VSS VDD VDD _08045_ sky130_fd_sc_hd__nand2_1
X_11844_ network.in_period\[132\]\[0\] _08045_ VSS VSS VDD
+ VDD _08046_ sky130_fd_sc_hd__nand2_1
X_11845_ network.neuron_in132.counter\[0\] _08045_ _08046_
+ VSS VSS VDD VDD _02592_ sky130_fd_sc_hd__o21ai_0
X_11846_ network.neuron_in127.counter\[2\] _01153_ VSS VSS
+ VDD VDD _08047_ sky130_fd_sc_hd__xnor2_1
X_11847_ network.neuron_in127.counter\[2\] network.neuron_in127.counter\[3\]
+ VSS VSS VDD VDD _08048_ sky130_fd_sc_hd__nor2_1
X_11848_ net374 _08048_ VSS VSS VDD VDD _08049_ sky130_fd_sc_hd__nor2_1
X_11849_ network.in_period\[127\]\[2\] _08049_ VSS VSS VDD
+ VDD _08050_ sky130_fd_sc_hd__nor2_1
X_11850_ net384 _08047_ _08050_ VSS VSS VDD VDD _02574_ sky130_fd_sc_hd__a21oi_1
X_11851_ network.neuron_in069.counter\[0\] VSS VSS VDD VDD
+ _00143_ sky130_fd_sc_hd__inv_1
Xplace399 net399 VSS VSS VDD VDD net398 sky130_fd_sc_hd__buf_4
X_11853_ network.neuron_out0.ROM0.address\[1\] network.neuron_out0.ROM0.read_en
+ net402 VSS VSS VDD VDD _08052_ sky130_fd_sc_hd__nand3_1
X_11854_ _08052_ VSS VSS VDD VDD _01524_ sky130_fd_sc_hd__inv_1
Xplace398 net400 VSS VSS VDD VDD net397 sky130_fd_sc_hd__buf_4
Xplace397 net397 VSS VSS VDD VDD net396 sky130_fd_sc_hd__buf_4
Xplace382 _06361_ VSS VSS VDD VDD net381 sky130_fd_sc_hd__buf_4
X_11858_ network.neuron_out0.ROM0.address\[2\] network.neuron_out0.ROM0.address\[0\]
+ VSS VSS VDD VDD _08056_ sky130_fd_sc_hd__nand2_1
X_11859_ network.neuron_out0.ROM0.read_en net402 _08056_ VSS
+ VSS VDD VDD _08057_ sky130_fd_sc_hd__nand3_1
X_11860_ network.neuron_out0.ROM0.address\[1\] _08057_ VSS
+ VSS VDD VDD _01525_ sky130_fd_sc_hd__nor2_1
X_11861_ network.neuron_out0.ROM0.address\[0\] VSS VSS VDD
+ VDD _08058_ sky130_fd_sc_hd__inv_1
X_11862_ network.neuron_out0.ROM0.address\[2\] _08058_ VSS
+ VSS VDD VDD _08059_ sky130_fd_sc_hd__nor2_1
X_11863_ network.neuron_out0.ROM0.address\[0\] network.neuron_out0.ROM0.address\[2\]
+ VSS VSS VDD VDD _08060_ sky130_fd_sc_hd__nor2b_1
X_11864_ network.neuron_out0.ROM0.address\[1\] _08059_ _08060_
+ VSS VSS VDD VDD _08061_ sky130_fd_sc_hd__nor3_1
X_11865_ network.neuron_out0.ROM0.read_en net406 VSS VSS VDD
+ VDD _08062_ sky130_fd_sc_hd__nand2_1
Xplace381 net381 VSS VSS VDD VDD net380 sky130_fd_sc_hd__buf_4
X_11867_ network.neuron_out0.ROM0.address\[1\] _08059_ _08061_
+ _08062_ VSS VSS VDD VDD _01526_ sky130_fd_sc_hd__a211oi_1
Xplace380 net380 VSS VSS VDD VDD net379 sky130_fd_sc_hd__buf_4
X_11869_ network.neuron_out0.ROM0.address\[1\] _08058_ VSS
+ VSS VDD VDD _08065_ sky130_fd_sc_hd__nor2_1
X_11870_ _08065_ network.neuron_out0.ROM0.address\[2\] VSS
+ VSS VDD VDD _08066_ sky130_fd_sc_hd__nor2b_1
X_11871_ _08062_ _08066_ VSS VSS VDD VDD _01527_ sky130_fd_sc_hd__nor2_1
X_11872_ network.neuron_out0.ROM0.address\[2\] network.neuron_out0.ROM0.address\[1\]
+ VSS VSS VDD VDD _08067_ sky130_fd_sc_hd__nand2b_1
X_11873_ network.neuron_out0.ROM0.address\[2\] network.neuron_out0.ROM0.address\[0\]
+ VSS VSS VDD VDD _08068_ sky130_fd_sc_hd__nor2_1
X_11874_ network.neuron_out0.ROM0.address\[1\] _08068_ VSS
+ VSS VDD VDD _08069_ sky130_fd_sc_hd__or2_2
X_11875_ _08067_ _08069_ _08062_ VSS VSS VDD VDD _01528_ sky130_fd_sc_hd__a21oi_1
X_11876_ network.neuron_out0.ROM0.address\[2\] _08058_ VSS
+ VSS VDD VDD _08070_ sky130_fd_sc_hd__nand2_1
X_11877_ network.neuron_out0.ROM0.address\[1\] _08070_ _08067_
+ VSS VSS VDD VDD _08071_ sky130_fd_sc_hd__o21ai_0
X_11878_ _08062_ _08071_ VSS VSS VDD VDD _01529_ sky130_fd_sc_hd__nor2b_1
X_11879_ network.neuron_out0.ROM0.address\[1\] _08070_ _08059_
+ VSS VSS VDD VDD _08072_ sky130_fd_sc_hd__a21oi_1
X_11880_ _08062_ _08072_ VSS VSS VDD VDD _01530_ sky130_fd_sc_hd__nor2_1
X_11881_ network.neuron_out0.ROM0.address\[2\] network.neuron_out0.ROM0.address\[0\]
+ VSS VSS VDD VDD _08073_ sky130_fd_sc_hd__nand2b_1
X_11882_ network.neuron_out0.ROM0.address\[1\] _08060_ VSS
+ VSS VDD VDD _08074_ sky130_fd_sc_hd__nand2_1
X_11883_ network.neuron_out0.ROM0.address\[1\] _08073_ _08074_
+ VSS VSS VDD VDD _08075_ sky130_fd_sc_hd__o21ai_0
X_11884_ _08062_ _08075_ VSS VSS VDD VDD _01531_ sky130_fd_sc_hd__nor2_1
X_11885_ network.neuron_out0.ROM0.address\[1\] _08056_ _08068_
+ VSS VSS VDD VDD _08076_ sky130_fd_sc_hd__a21oi_1
X_11886_ _08062_ _08076_ VSS VSS VDD VDD _01532_ sky130_fd_sc_hd__nor2_1
X_11887_ network.neuron_out0.ROM0.address\[1\] _08073_ _08062_
+ VSS VSS VDD VDD _01533_ sky130_fd_sc_hd__a21oi_1
X_11888_ network.neuron_out0.ROM0.address\[1\] network.neuron_out0.ROM0.address\[2\]
+ VSS VSS VDD VDD _08077_ sky130_fd_sc_hd__nor2_1
X_11889_ network.neuron_out0.ROM0.address\[1\] _08060_ _08077_
+ VSS VSS VDD VDD _08078_ sky130_fd_sc_hd__a21oi_1
X_11890_ _08062_ _08078_ VSS VSS VDD VDD _01534_ sky130_fd_sc_hd__nor2_1
X_11891_ _08062_ _08075_ VSS VSS VDD VDD _01535_ sky130_fd_sc_hd__nor2b_1
X_11892_ network.neuron_out0.ROM0.address\[1\] _08068_ _08065_
+ _08062_ VSS VSS VDD VDD _01536_ sky130_fd_sc_hd__a211oi_1
X_11893_ network.neuron_in127.counter\[3\] _01153_ VSS VSS
+ VDD VDD _08079_ sky130_fd_sc_hd__nand2b_1
X_11894_ network.neuron_in127.counter\[2\] _08079_ VSS VSS
+ VDD VDD _08080_ sky130_fd_sc_hd__or2_2
X_11895_ net384 _08080_ VSS VSS VDD VDD _08081_ sky130_fd_sc_hd__nand2_1
X_11896_ network.in_period\[127\]\[1\] _08081_ VSS VSS VDD
+ VDD _08082_ sky130_fd_sc_hd__nand2_1
X_11897_ _01154_ _08081_ _08082_ VSS VSS VDD VDD _02573_ sky130_fd_sc_hd__o21ai_0
X_11898_ network.neuron_in162.counter\[0\] VSS VSS VDD VDD
+ _00774_ sky130_fd_sc_hd__inv_1
X_11899_ network.neuron_out0.ROM0.address\[0\] _08052_ VSS
+ VSS VDD VDD _01537_ sky130_fd_sc_hd__nor2_1
X_11900_ _08059_ _08060_ VSS VSS VDD VDD _08083_ sky130_fd_sc_hd__nor2_1
X_11901_ network.neuron_out0.ROM0.address\[1\] network.neuron_out0.ROM0.address\[2\]
+ network.neuron_out0.ROM0.address\[0\] VSS VSS VDD VDD _08084_
+ sky130_fd_sc_hd__nand3_1
X_11902_ network.neuron_out0.ROM0.address\[1\] _08083_ _08084_
+ VSS VSS VDD VDD _08085_ sky130_fd_sc_hd__o21a_1
X_11903_ _08062_ _08085_ VSS VSS VDD VDD _01538_ sky130_fd_sc_hd__nor2_1
X_11904_ _08056_ _08067_ _08062_ VSS VSS VDD VDD _01539_ sky130_fd_sc_hd__a21oi_1
X_11905_ _08057_ _08077_ VSS VSS VDD VDD _01540_ sky130_fd_sc_hd__nor2_1
X_11906_ network.neuron_in049.counter\[0\] VSS VSS VDD VDD
+ _00258_ sky130_fd_sc_hd__inv_1
X_11907_ network.neuron_out0.ROM0.address\[1\] network.neuron_out0.ROM0.address\[0\]
+ VSS VSS VDD VDD _08086_ sky130_fd_sc_hd__nor2_1
X_11908_ _08057_ _08086_ VSS VSS VDD VDD _01541_ sky130_fd_sc_hd__nor2_1
X_11909_ network.neuron_out0.ROM0.address\[2\] network.neuron_out0.ROM0.address\[0\]
+ network.neuron_out0.ROM0.address\[1\] VSS VSS VDD VDD _08087_
+ sky130_fd_sc_hd__a21oi_1
X_11910_ network.neuron_out0.ROM0.address\[1\] _08083_ _08087_
+ _08062_ VSS VSS VDD VDD _01542_ sky130_fd_sc_hd__a211oi_1
X_11911_ network.neuron_in158.counter\[1\] VSS VSS VDD VDD
+ _00644_ sky130_fd_sc_hd__inv_1
X_11912_ network.neuron_out0.ROM0.address\[1\] _08060_ _08061_
+ VSS VSS VDD VDD _08088_ sky130_fd_sc_hd__a21oi_1
X_11913_ _08062_ _08088_ VSS VSS VDD VDD _01543_ sky130_fd_sc_hd__nor2_1
X_11914_ _08062_ _08069_ VSS VSS VDD VDD _01544_ sky130_fd_sc_hd__nor2_1
X_11915_ _08062_ _08077_ _08084_ VSS VSS VDD VDD _01545_ sky130_fd_sc_hd__nor3b_1
X_11916_ _08058_ _08062_ VSS VSS VDD VDD _01546_ sky130_fd_sc_hd__nor2_1
X_11917_ network.neuron_out0.ROM0.address\[1\] network.neuron_out0.ROM0.address\[2\]
+ VSS VSS VDD VDD _08089_ sky130_fd_sc_hd__nand2b_1
X_11918_ _08058_ _08089_ _08062_ VSS VSS VDD VDD _01547_ sky130_fd_sc_hd__a21oi_1
X_11919_ network.neuron_in127.counter\[0\] VSS VSS VDD VDD
+ _01151_ sky130_fd_sc_hd__inv_1
X_11920_ network.in_period\[127\]\[0\] _08081_ VSS VSS VDD
+ VDD _08090_ sky130_fd_sc_hd__nand2_1
X_11921_ network.neuron_in127.counter\[0\] _08081_ _08090_
+ VSS VSS VDD VDD _02572_ sky130_fd_sc_hd__o21ai_0
X_11922_ net417 _07099_ net416 VSS VSS VDD VDD _08091_ sky130_fd_sc_hd__a21oi_1
X_11923_ net416 net325 _07215_ _08091_ VSS VSS VDD VDD _08092_
+ sky130_fd_sc_hd__a211oi_1
X_11924_ net412 net349 net356 VSS VSS VDD VDD _08093_ sky130_fd_sc_hd__o21ai_0
X_11925_ net320 _08093_ VSS VSS VDD VDD _08094_ sky130_fd_sc_hd__nand2_1
X_11926_ net358 _08092_ _08094_ VSS VSS VDD VDD _08095_ sky130_fd_sc_hd__o21ai_0
X_11927_ net412 net346 _07241_ VSS VSS VDD VDD _08096_ sky130_fd_sc_hd__o21ai_0
X_11928_ _07047_ _07127_ net412 VSS VSS VDD VDD _08097_ sky130_fd_sc_hd__a21oi_1
X_11929_ net416 _08096_ _08097_ _07128_ VSS VSS VDD VDD _08098_
+ sky130_fd_sc_hd__a211oi_1
X_11930_ net412 net421 net360 VSS VSS VDD VDD _08099_ sky130_fd_sc_hd__o21ai_0
X_11931_ net366 _08099_ _07572_ VSS VSS VDD VDD _08100_ sky130_fd_sc_hd__a21oi_1
X_11932_ network.neuron_hid0.ROM0.address\[0\] _08098_ _08100_
+ net423 net408 VSS VSS VDD VDD _08101_ sky130_fd_sc_hd__o221ai_1
X_11933_ net421 _08095_ _08101_ VSS VSS VDD VDD _08102_ sky130_fd_sc_hd__a21oi_1
X_11934_ _07299_ net330 _07329_ VSS VSS VDD VDD _08103_ sky130_fd_sc_hd__o21ai_0
X_11935_ net414 _07329_ VSS VSS VDD VDD _08104_ sky130_fd_sc_hd__nor2_1
X_11936_ net414 net352 net319 _08104_ VSS VSS VDD VDD _08105_
+ sky130_fd_sc_hd__a31oi_1
X_11937_ net422 _08105_ VSS VSS VDD VDD _08106_ sky130_fd_sc_hd__nor2_1
X_11938_ net417 _07350_ net365 VSS VSS VDD VDD _08107_ sky130_fd_sc_hd__o21ai_0
X_11939_ _07723_ _08107_ net424 VSS VSS VDD VDD _08108_ sky130_fd_sc_hd__a21oi_1
X_11940_ net362 _08103_ _08106_ _07675_ _08108_ VSS VSS VDD
+ VDD _08109_ sky130_fd_sc_hd__a2111oi_0
X_11941_ net417 _07614_ VSS VSS VDD VDD _08110_ sky130_fd_sc_hd__nand2_1
X_11942_ net417 _07289_ net416 VSS VSS VDD VDD _08111_ sky130_fd_sc_hd__a21oi_1
X_11943_ _07180_ _08111_ net424 VSS VSS VDD VDD _08112_ sky130_fd_sc_hd__o21ai_0
X_11944_ net424 _08110_ _08112_ VSS VSS VDD VDD _08113_ sky130_fd_sc_hd__o21ai_0
X_11945_ _07714_ net335 _07614_ net344 VSS VSS VDD VDD _08114_
+ sky130_fd_sc_hd__o31ai_1
X_11946_ _08113_ _08114_ VSS VSS VDD VDD _08115_ sky130_fd_sc_hd__nor2_1
X_11947_ network.neuron_hid0.ROM0.address\[7\] _08102_ _08109_
+ _08115_ VSS VSS VDD VDD _08116_ sky130_fd_sc_hd__nor4_1
X_11948_ _07180_ _07930_ network.neuron_hid0.ROM0.address\[0\]
+ VSS VSS VDD VDD _08117_ sky130_fd_sc_hd__o21ai_0
X_11949_ net420 network.neuron_hid0.ROM0.address\[0\] net364
+ _08117_ VSS VSS VDD VDD _08118_ sky130_fd_sc_hd__o31ai_1
X_11950_ _07308_ _08118_ _07041_ VSS VSS VDD VDD _08119_ sky130_fd_sc_hd__a21oi_1
X_11951_ net307 _07201_ _07331_ net313 VSS VSS VDD VDD _08120_
+ sky130_fd_sc_hd__nand4_1
X_11952_ _07042_ _08116_ _08119_ _08120_ VSS VSS VDD VDD _01548_
+ sky130_fd_sc_hd__o31ai_1
X_11953_ net414 _07329_ _07189_ VSS VSS VDD VDD _08121_ sky130_fd_sc_hd__o21ai_0
X_11954_ net365 net348 net321 VSS VSS VDD VDD _08122_ sky130_fd_sc_hd__nand3_1
X_11955_ _07645_ _08122_ net414 VSS VSS VDD VDD _08123_ sky130_fd_sc_hd__a21oi_1
X_11956_ net362 _08121_ _08123_ VSS VSS VDD VDD _08124_ sky130_fd_sc_hd__a21oi_1
X_11957_ net314 _07188_ net414 VSS VSS VDD VDD _08125_ sky130_fd_sc_hd__o21ai_0
X_11958_ net414 _07116_ _07913_ _08125_ VSS VSS VDD VDD _08126_
+ sky130_fd_sc_hd__o211ai_1
X_11959_ _07146_ net350 net420 VSS VSS VDD VDD _08127_ sky130_fd_sc_hd__a21oi_1
X_11960_ _07304_ _08127_ VSS VSS VDD VDD _08128_ sky130_fd_sc_hd__nor2_1
X_11961_ _07047_ _07366_ VSS VSS VDD VDD _08129_ sky130_fd_sc_hd__nand2_1
X_11962_ net414 _07573_ _07580_ _07140_ VSS VSS VDD VDD _08130_
+ sky130_fd_sc_hd__o211ai_1
X_11963_ net423 _08129_ _08130_ VSS VSS VDD VDD _08131_ sky130_fd_sc_hd__a21oi_1
X_11964_ net417 _08128_ _08131_ VSS VSS VDD VDD _08132_ sky130_fd_sc_hd__o21a_1
X_11965_ net331 _07118_ net414 VSS VSS VDD VDD _08133_ sky130_fd_sc_hd__o21ai_0
X_11966_ net415 _07720_ _07714_ VSS VSS VDD VDD _08134_ sky130_fd_sc_hd__a21oi_1
X_11967_ net415 _07322_ _08134_ net365 VSS VSS VDD VDD _08135_
+ sky130_fd_sc_hd__o22ai_1
X_11968_ net422 _08135_ VSS VSS VDD VDD _08136_ sky130_fd_sc_hd__nand2_1
X_11969_ _07864_ _08133_ _08136_ _07210_ VSS VSS VDD VDD _08137_
+ sky130_fd_sc_hd__a31oi_1
X_11970_ net335 _07851_ net418 VSS VSS VDD VDD _08138_ sky130_fd_sc_hd__o21ai_0
X_11971_ _07166_ net332 _07241_ VSS VSS VDD VDD _08139_ sky130_fd_sc_hd__o21ai_0
X_11972_ net364 _07707_ net415 VSS VSS VDD VDD _08140_ sky130_fd_sc_hd__o21ai_0
X_11973_ net424 _07682_ _08140_ VSS VSS VDD VDD _08141_ sky130_fd_sc_hd__nand3_1
X_11974_ net424 _08139_ _08141_ VSS VSS VDD VDD _08142_ sky130_fd_sc_hd__o21ai_0
X_11975_ _08138_ _08142_ _07675_ VSS VSS VDD VDD _08143_ sky130_fd_sc_hd__a21oi_1
X_11976_ net344 _08126_ _08132_ _08137_ _08143_ VSS VSS VDD
+ VDD _08144_ sky130_fd_sc_hd__a2111oi_0
X_11977_ net318 _08124_ _08144_ net316 VSS VSS VDD VDD _01549_
+ sky130_fd_sc_hd__o22ai_1
X_11978_ net417 net347 VSS VSS VDD VDD _08145_ sky130_fd_sc_hd__nor2_1
X_11979_ net420 _08145_ _07207_ VSS VSS VDD VDD _08146_ sky130_fd_sc_hd__o21ai_0
X_11980_ net331 _07728_ VSS VSS VDD VDD _08147_ sky130_fd_sc_hd__nor2_1
X_11981_ _07671_ _08147_ net414 VSS VSS VDD VDD _08148_ sky130_fd_sc_hd__a21oi_1
X_11982_ net414 _08146_ _08148_ _07118_ _07675_ VSS VSS VDD
+ VDD _08149_ sky130_fd_sc_hd__a2111oi_0
X_11983_ net423 net343 net420 VSS VSS VDD VDD _08150_ sky130_fd_sc_hd__o21ai_0
X_11984_ net414 net351 VSS VSS VDD VDD _08151_ sky130_fd_sc_hd__nor2_1
X_11985_ net414 _07201_ _08150_ _08151_ _07183_ VSS VSS VDD
+ VDD _08152_ sky130_fd_sc_hd__a32oi_1
X_11986_ _07047_ net356 network.neuron_hid0.ROM0.address\[0\]
+ VSS VSS VDD VDD _08153_ sky130_fd_sc_hd__a21oi_1
X_11987_ _07254_ _08152_ _08153_ VSS VSS VDD VDD _08154_ sky130_fd_sc_hd__nor3_1
X_11988_ net420 net340 _07695_ VSS VSS VDD VDD _08155_ sky130_fd_sc_hd__o21ai_0
X_11989_ net414 _08155_ VSS VSS VDD VDD _08156_ sky130_fd_sc_hd__nand2_1
X_11990_ net420 _07162_ VSS VSS VDD VDD _08157_ sky130_fd_sc_hd__nor2_1
X_11991_ net415 net424 VSS VSS VDD VDD _08158_ sky130_fd_sc_hd__nor2_1
X_11992_ _07930_ _08157_ _08158_ VSS VSS VDD VDD _08159_ sky130_fd_sc_hd__o21ai_0
X_11993_ net416 net323 VSS VSS VDD VDD _08160_ sky130_fd_sc_hd__nand2_1
X_11994_ net416 _07241_ _08160_ VSS VSS VDD VDD _08161_ sky130_fd_sc_hd__o21ai_0
X_11995_ net424 _08161_ VSS VSS VDD VDD _08162_ sky130_fd_sc_hd__nand2_1
X_11996_ net344 _08156_ _08159_ _08162_ VSS VSS VDD VDD _08163_
+ sky130_fd_sc_hd__and4_1
X_11997_ _07046_ net351 net363 VSS VSS VDD VDD _08164_ sky130_fd_sc_hd__o21ai_0
X_11998_ net420 net333 _08164_ VSS VSS VDD VDD _08165_ sky130_fd_sc_hd__o21ai_0
X_11999_ net416 net423 VSS VSS VDD VDD _08166_ sky130_fd_sc_hd__xnor2_1
X_12000_ net416 _08110_ _08166_ net336 VSS VSS VDD VDD _08167_
+ sky130_fd_sc_hd__o22ai_1
X_12001_ net346 _07599_ _07312_ VSS VSS VDD VDD _08168_ sky130_fd_sc_hd__o21ai_0
X_12002_ net414 _08165_ _08167_ net424 _08168_ VSS VSS VDD
+ VDD _08169_ sky130_fd_sc_hd__a221oi_1
X_12003_ _08149_ _08154_ _08163_ _08169_ VSS VSS VDD VDD _08170_
+ sky130_fd_sc_hd__nor4_1
X_12004_ net341 _07613_ net414 VSS VSS VDD VDD _08171_ sky130_fd_sc_hd__a21oi_1
X_12005_ net349 _07146_ net420 VSS VSS VDD VDD _08172_ sky130_fd_sc_hd__a21oi_1
X_12006_ _08171_ _08172_ net307 VSS VSS VDD VDD _08173_ sky130_fd_sc_hd__o21ai_0
X_12007_ net316 _08170_ _08173_ VSS VSS VDD VDD _01550_ sky130_fd_sc_hd__o21ai_0
X_12008_ _07707_ net337 VSS VSS VDD VDD _08174_ sky130_fd_sc_hd__nor2_1
X_12009_ net416 net330 net323 VSS VSS VDD VDD _08175_ sky130_fd_sc_hd__a21oi_1
X_12010_ net416 net330 _08175_ VSS VSS VDD VDD _08176_ sky130_fd_sc_hd__o21ai_0
X_12011_ net357 net331 _07385_ _07643_ _07231_ VSS VSS VDD
+ VDD _08177_ sky130_fd_sc_hd__o311ai_0
X_12012_ net423 _08176_ _08177_ VSS VSS VDD VDD _08178_ sky130_fd_sc_hd__a21oi_1
X_12013_ net354 net319 net336 VSS VSS VDD VDD _08179_ sky130_fd_sc_hd__o21ai_0
X_12014_ _07181_ _07738_ net421 VSS VSS VDD VDD _08180_ sky130_fd_sc_hd__o21ai_0
X_12015_ net416 _07207_ _08180_ VSS VSS VDD VDD _08181_ sky130_fd_sc_hd__nand3_1
X_12016_ net416 _08179_ _08181_ net412 VSS VSS VDD VDD _08182_
+ sky130_fd_sc_hd__o211ai_1
X_12017_ _07146_ _08174_ _08178_ net412 _08182_ VSS VSS VDD
+ VDD _08183_ sky130_fd_sc_hd__o221ai_1
X_12018_ net366 _07576_ _07245_ VSS VSS VDD VDD _08184_ sky130_fd_sc_hd__a21oi_1
X_12019_ net423 _07720_ VSS VSS VDD VDD _08185_ sky130_fd_sc_hd__nand2_1
X_12020_ _07231_ _08185_ VSS VSS VDD VDD _08186_ sky130_fd_sc_hd__nand2_1
X_12021_ net416 _08186_ _07737_ net421 VSS VSS VDD VDD _08187_
+ sky130_fd_sc_hd__o211ai_1
X_12022_ net354 net350 _08184_ net421 _08187_ VSS VSS VDD
+ VDD _08188_ sky130_fd_sc_hd__o221ai_1
X_12023_ net347 net352 _07201_ VSS VSS VDD VDD _08189_ sky130_fd_sc_hd__o21ai_0
X_12024_ _07201_ net323 VSS VSS VDD VDD _08190_ sky130_fd_sc_hd__nor2_1
X_12025_ net366 net419 VSS VSS VDD VDD _08191_ sky130_fd_sc_hd__nor2_1
X_12026_ net359 _07331_ net415 VSS VSS VDD VDD _08192_ sky130_fd_sc_hd__a21oi_1
X_12027_ _07641_ _08191_ _08192_ VSS VSS VDD VDD _08193_ sky130_fd_sc_hd__a21oi_1
X_12028_ net422 _08193_ VSS VSS VDD VDD _08194_ sky130_fd_sc_hd__nor2_1
X_12029_ net414 _08189_ _08190_ _07675_ _08194_ VSS VSS VDD
+ VDD _08195_ sky130_fd_sc_hd__a2111oi_0
X_12030_ net408 _08183_ _08188_ net344 _08195_ VSS VSS VDD
+ VDD _08196_ sky130_fd_sc_hd__a221oi_1
X_12031_ network.neuron_hid0.ROM0.address\[0\] _07322_ _07614_
+ net345 VSS VSS VDD VDD _08197_ sky130_fd_sc_hd__a31oi_1
X_12032_ net417 _07189_ _08197_ net414 VSS VSS VDD VDD _08198_
+ sky130_fd_sc_hd__o22ai_1
X_12033_ net344 _08198_ _07041_ VSS VSS VDD VDD _08199_ sky130_fd_sc_hd__a21oi_1
X_12034_ _07041_ _08196_ _08199_ _07042_ VSS VSS VDD VDD _01551_
+ sky130_fd_sc_hd__a211oi_1
X_12035_ network.neuron_in128.counter\[2\] VSS VSS VDD VDD
+ _08200_ sky130_fd_sc_hd__inv_1
X_12036_ network.neuron_in128.counter\[3\] network.in_period\[128\]\[2\]
+ net375 _00637_ VSS VSS VDD VDD _08201_ sky130_fd_sc_hd__o22ai_1
X_12037_ network.neuron_in128.counter\[2\] _00637_ net394
+ VSS VSS VDD VDD _08202_ sky130_fd_sc_hd__nand3_1
X_12038_ network.in_period\[128\]\[2\] net394 _08202_ VSS
+ VSS VDD VDD _08203_ sky130_fd_sc_hd__o21ai_0
X_12039_ _08200_ _08201_ _08203_ VSS VSS VDD VDD _02578_ sky130_fd_sc_hd__a21oi_1
X_12040_ network.neuron_in072.counter\[0\] VSS VSS VDD VDD
+ _00529_ sky130_fd_sc_hd__inv_1
X_12041_ network.neuron_in000.counter\[2\] _00549_ VSS VSS
+ VDD VDD _08204_ sky130_fd_sc_hd__nor2b_1
X_12042_ network.neuron_in000.counter\[3\] _08204_ VSS VSS
+ VDD VDD _08205_ sky130_fd_sc_hd__nand2b_1
X_12043_ net395 _08205_ VSS VSS VDD VDD _08206_ sky130_fd_sc_hd__nand2_1
X_12044_ network.in_period\[0\]\[1\] _08206_ VSS VSS VDD VDD
+ _08207_ sky130_fd_sc_hd__nand2_1
X_12045_ _00550_ _08206_ _08207_ VSS VSS VDD VDD _02065_ sky130_fd_sc_hd__o21ai_0
X_12046_ network.neuron_in001.counter\[2\] net398 VSS VSS
+ VDD VDD _08208_ sky130_fd_sc_hd__nand2_1
X_12047_ network.in_period\[1\]\[2\] network.neuron_in001.counter\[3\]
+ _08208_ VSS VSS VDD VDD _08209_ sky130_fd_sc_hd__o21ai_0
X_12048_ _00740_ network.neuron_in001.counter\[2\] net379
+ VSS VSS VDD VDD _08210_ sky130_fd_sc_hd__or3_1
X_12049_ network.in_period\[1\]\[2\] net398 _08210_ VSS VSS
+ VDD VDD _08211_ sky130_fd_sc_hd__o21ai_0
X_12050_ _00740_ _08209_ _08211_ VSS VSS VDD VDD _02070_ sky130_fd_sc_hd__a21oi_1
X_12051_ _00565_ network.neuron_in133.counter\[2\] VSS VSS
+ VDD VDD _08212_ sky130_fd_sc_hd__xnor2_1
X_12052_ network.neuron_in133.counter\[2\] network.neuron_in133.counter\[3\]
+ VSS VSS VDD VDD _08213_ sky130_fd_sc_hd__nor2_1
X_12053_ _00565_ _08213_ VSS VSS VDD VDD _08214_ sky130_fd_sc_hd__nand2_1
X_12054_ net384 _08214_ network.in_period\[133\]\[2\] VSS
+ VSS VDD VDD _08215_ sky130_fd_sc_hd__a21oi_1
X_12055_ net384 _08212_ _08215_ VSS VSS VDD VDD _02598_ sky130_fd_sc_hd__a21oi_1
X_12056_ net384 _08214_ VSS VSS VDD VDD _08216_ sky130_fd_sc_hd__nand2_1
X_12057_ network.in_period\[133\]\[1\] _08216_ VSS VSS VDD
+ VDD _08217_ sky130_fd_sc_hd__nand2_1
X_12058_ _00566_ _08216_ _08217_ VSS VSS VDD VDD _02597_ sky130_fd_sc_hd__o21ai_0
X_12059_ network.in_period\[133\]\[0\] _08216_ VSS VSS VDD
+ VDD _08218_ sky130_fd_sc_hd__nand2_1
X_12060_ network.neuron_in133.counter\[0\] _08216_ _08218_
+ VSS VSS VDD VDD _02596_ sky130_fd_sc_hd__o21ai_0
X_12061_ network.neuron_in088.counter\[1\] VSS VSS VDD VDD
+ _00035_ sky130_fd_sc_hd__inv_1
X_12062_ network.neuron_in002.counter\[2\] _00613_ VSS VSS
+ VDD VDD _08219_ sky130_fd_sc_hd__nor2b_1
X_12063_ network.neuron_in002.counter\[3\] _08219_ VSS VSS
+ VDD VDD _08220_ sky130_fd_sc_hd__nand2b_1
X_12064_ net395 _08220_ VSS VSS VDD VDD _08221_ sky130_fd_sc_hd__nand2_1
X_12065_ network.in_period\[2\]\[1\] _08221_ VSS VSS VDD VDD
+ _08222_ sky130_fd_sc_hd__nand2_1
X_12066_ _00614_ _08221_ _08222_ VSS VSS VDD VDD _02073_ sky130_fd_sc_hd__o21ai_0
X_12067_ network.neuron_in087.counter\[1\] VSS VSS VDD VDD
+ _00043_ sky130_fd_sc_hd__inv_1
X_12068_ network.neuron_in193.counter\[1\] VSS VSS VDD VDD
+ _00744_ sky130_fd_sc_hd__inv_1
X_12069_ network.neuron_in000.counter\[2\] VSS VSS VDD VDD
+ _08223_ sky130_fd_sc_hd__inv_1
X_12070_ network.neuron_in000.counter\[3\] network.in_period\[0\]\[2\]
+ _00549_ net379 VSS VSS VDD VDD _08224_ sky130_fd_sc_hd__o22ai_1
Xplace379 net379 VSS VSS VDD VDD net378 sky130_fd_sc_hd__buf_4
X_12072_ network.neuron_in000.counter\[2\] _00549_ net395
+ VSS VSS VDD VDD _08226_ sky130_fd_sc_hd__nand3_1
X_12073_ network.in_period\[0\]\[2\] net395 _08226_ VSS VSS
+ VDD VDD _08227_ sky130_fd_sc_hd__o21ai_0
X_12074_ _08223_ _08224_ _08227_ VSS VSS VDD VDD _02066_ sky130_fd_sc_hd__a21oi_1
X_12075_ network.neuron_in000.counter\[0\] VSS VSS VDD VDD
+ _00547_ sky130_fd_sc_hd__inv_1
X_12076_ network.in_period\[0\]\[0\] _08206_ VSS VSS VDD VDD
+ _08228_ sky130_fd_sc_hd__nand2_1
X_12077_ network.neuron_in000.counter\[0\] _08206_ _08228_
+ VSS VSS VDD VDD _02064_ sky130_fd_sc_hd__o21ai_0
X_12078_ network.neuron_in045.counter\[0\] VSS VSS VDD VDD
+ _00286_ sky130_fd_sc_hd__inv_1
X_12079_ network.neuron_in001.counter\[2\] _00740_ VSS VSS
+ VDD VDD _08229_ sky130_fd_sc_hd__nor2b_1
X_12080_ network.neuron_in001.counter\[3\] _08229_ VSS VSS
+ VDD VDD _08230_ sky130_fd_sc_hd__nand2b_1
X_12081_ net398 _08230_ VSS VSS VDD VDD _08231_ sky130_fd_sc_hd__nand2_1
X_12082_ network.in_period\[1\]\[1\] _08231_ VSS VSS VDD VDD
+ _08232_ sky130_fd_sc_hd__nand2_1
X_12083_ _00741_ _08231_ _08232_ VSS VSS VDD VDD _02069_ sky130_fd_sc_hd__o21ai_0
X_12084_ network.in_period\[1\]\[0\] _08231_ VSS VSS VDD VDD
+ _08233_ sky130_fd_sc_hd__nand2_1
X_12085_ network.neuron_in001.counter\[0\] _08231_ _08233_
+ VSS VSS VDD VDD _02068_ sky130_fd_sc_hd__o21ai_0
X_12086_ network.neuron_in002.counter\[2\] net395 VSS VSS
+ VDD VDD _08234_ sky130_fd_sc_hd__nand2_1
X_12087_ network.neuron_in002.counter\[3\] network.in_period\[2\]\[2\]
+ _08234_ VSS VSS VDD VDD _08235_ sky130_fd_sc_hd__o21ai_0
Xplace378 net379 VSS VSS VDD VDD net377 sky130_fd_sc_hd__buf_4
X_12089_ _00613_ network.neuron_in002.counter\[2\] net379
+ VSS VSS VDD VDD _08237_ sky130_fd_sc_hd__or3_1
X_12090_ network.in_period\[2\]\[2\] net395 _08237_ VSS VSS
+ VDD VDD _08238_ sky130_fd_sc_hd__o21ai_0
X_12091_ _00613_ _08235_ _08238_ VSS VSS VDD VDD _02074_ sky130_fd_sc_hd__a21oi_1
X_12092_ network.neuron_in003.counter\[2\] network.neuron_in003.counter\[3\]
+ VSS VSS VDD VDD _08239_ sky130_fd_sc_hd__nor2_1
X_12093_ _00605_ _08239_ VSS VSS VDD VDD _08240_ sky130_fd_sc_hd__nand2_1
X_12094_ net395 _08240_ VSS VSS VDD VDD _08241_ sky130_fd_sc_hd__nand2_1
X_12095_ network.in_period\[3\]\[1\] _08241_ VSS VSS VDD VDD
+ _08242_ sky130_fd_sc_hd__nand2_1
X_12096_ _00606_ _08241_ _08242_ VSS VSS VDD VDD _02077_ sky130_fd_sc_hd__o21ai_0
X_12097_ network.neuron_in004.counter\[2\] _00601_ VSS VSS
+ VDD VDD _08243_ sky130_fd_sc_hd__nor2b_1
X_12098_ network.neuron_in004.counter\[3\] _08243_ VSS VSS
+ VDD VDD _08244_ sky130_fd_sc_hd__nand2b_1
X_12099_ net395 _08244_ VSS VSS VDD VDD _08245_ sky130_fd_sc_hd__nand2_1
X_12100_ network.in_period\[4\]\[1\] _08245_ VSS VSS VDD VDD
+ _08246_ sky130_fd_sc_hd__nand2_1
X_12101_ _00602_ _08245_ _08246_ VSS VSS VDD VDD _02081_ sky130_fd_sc_hd__o21ai_0
X_12102_ network.neuron_in005.counter\[2\] _00692_ VSS VSS
+ VDD VDD _08247_ sky130_fd_sc_hd__xnor2_1
X_12103_ network.neuron_in005.counter\[2\] network.neuron_in005.counter\[3\]
+ VSS VSS VDD VDD _08248_ sky130_fd_sc_hd__nor2_1
X_12104_ _00692_ _08248_ VSS VSS VDD VDD _08249_ sky130_fd_sc_hd__nand2_1
X_12105_ net395 _08249_ network.in_period\[5\]\[2\] VSS VSS
+ VDD VDD _08250_ sky130_fd_sc_hd__a21oi_1
X_12106_ net395 _08247_ _08250_ VSS VSS VDD VDD _02086_ sky130_fd_sc_hd__a21oi_1
X_12107_ network.in_period\[3\]\[0\] _08241_ VSS VSS VDD VDD
+ _08251_ sky130_fd_sc_hd__nand2_1
X_12108_ network.neuron_in003.counter\[0\] _08241_ _08251_
+ VSS VSS VDD VDD _02076_ sky130_fd_sc_hd__o21ai_0
X_12109_ network.in_period\[2\]\[0\] _08221_ VSS VSS VDD VDD
+ _08252_ sky130_fd_sc_hd__nand2_1
X_12110_ network.neuron_in002.counter\[0\] _08221_ _08252_
+ VSS VSS VDD VDD _02072_ sky130_fd_sc_hd__o21ai_0
X_12111_ network.neuron_in003.counter\[2\] net395 VSS VSS
+ VDD VDD _08253_ sky130_fd_sc_hd__nand2_1
X_12112_ network.in_period\[3\]\[2\] network.neuron_in003.counter\[3\]
+ _08253_ VSS VSS VDD VDD _08254_ sky130_fd_sc_hd__o21ai_0
X_12113_ _00605_ network.neuron_in003.counter\[2\] net379
+ VSS VSS VDD VDD _08255_ sky130_fd_sc_hd__or3_1
X_12114_ network.in_period\[3\]\[2\] net395 _08255_ VSS VSS
+ VDD VDD _08256_ sky130_fd_sc_hd__o21ai_0
X_12115_ _00605_ _08254_ _08256_ VSS VSS VDD VDD _02078_ sky130_fd_sc_hd__a21oi_1
X_12116_ network.neuron_in004.counter\[2\] net395 VSS VSS
+ VDD VDD _08257_ sky130_fd_sc_hd__nand2_1
X_12117_ network.in_period\[4\]\[2\] network.neuron_in004.counter\[3\]
+ _08257_ VSS VSS VDD VDD _08258_ sky130_fd_sc_hd__o21ai_0
X_12118_ _00601_ network.neuron_in004.counter\[2\] net379
+ VSS VSS VDD VDD _08259_ sky130_fd_sc_hd__or3_1
X_12119_ network.in_period\[4\]\[2\] net395 _08259_ VSS VSS
+ VDD VDD _08260_ sky130_fd_sc_hd__o21ai_0
X_12120_ _00601_ _08258_ _08260_ VSS VSS VDD VDD _02082_ sky130_fd_sc_hd__a21oi_1
X_12121_ network.in_period\[4\]\[0\] _08245_ VSS VSS VDD VDD
+ _08261_ sky130_fd_sc_hd__nand2_1
X_12122_ network.neuron_in004.counter\[0\] _08245_ _08261_
+ VSS VSS VDD VDD _02080_ sky130_fd_sc_hd__o21ai_0
X_12123_ net395 _08249_ VSS VSS VDD VDD _08262_ sky130_fd_sc_hd__nand2_1
X_12124_ network.in_period\[5\]\[1\] _08262_ VSS VSS VDD VDD
+ _08263_ sky130_fd_sc_hd__nand2_1
X_12125_ _00693_ _08262_ _08263_ VSS VSS VDD VDD _02085_ sky130_fd_sc_hd__o21ai_0
X_12126_ network.in_period\[5\]\[0\] _08262_ VSS VSS VDD VDD
+ _08264_ sky130_fd_sc_hd__nand2_1
X_12127_ network.neuron_in005.counter\[0\] _08262_ _08264_
+ VSS VSS VDD VDD _02084_ sky130_fd_sc_hd__o21ai_0
X_12128_ network.neuron_in128.counter\[3\] _00637_ VSS VSS
+ VDD VDD _08265_ sky130_fd_sc_hd__nand2b_1
X_12129_ _08265_ _08200_ VSS VSS VDD VDD _08266_ sky130_fd_sc_hd__nand2b_1
X_12130_ net394 _08266_ VSS VSS VDD VDD _08267_ sky130_fd_sc_hd__nand2_1
X_12131_ network.in_period\[128\]\[1\] _08267_ VSS VSS VDD
+ VDD _08268_ sky130_fd_sc_hd__nand2_1
X_12132_ _00638_ _08267_ _08268_ VSS VSS VDD VDD _02577_ sky130_fd_sc_hd__o21ai_0
X_12133_ network.neuron_in006.counter\[2\] VSS VSS VDD VDD
+ _08269_ sky130_fd_sc_hd__inv_1
X_12134_ network.in_period\[6\]\[2\] network.neuron_in006.counter\[3\]
+ _00511_ net379 VSS VSS VDD VDD _08270_ sky130_fd_sc_hd__o22ai_1
X_12135_ network.neuron_in006.counter\[2\] _00511_ net395
+ VSS VSS VDD VDD _08271_ sky130_fd_sc_hd__nand3_1
X_12136_ network.in_period\[6\]\[2\] net395 _08271_ VSS VSS
+ VDD VDD _08272_ sky130_fd_sc_hd__o21ai_0
X_12137_ _08269_ _08270_ _08272_ VSS VSS VDD VDD _02090_ sky130_fd_sc_hd__a21oi_1
X_12138_ network.neuron_in006.counter\[2\] _00511_ VSS VSS
+ VDD VDD _08273_ sky130_fd_sc_hd__nor2b_1
X_12139_ network.neuron_in006.counter\[3\] _08273_ VSS VSS
+ VDD VDD _08274_ sky130_fd_sc_hd__nand2b_1
X_12140_ net395 _08274_ VSS VSS VDD VDD _08275_ sky130_fd_sc_hd__nand2_1
X_12141_ network.in_period\[6\]\[1\] _08275_ VSS VSS VDD VDD
+ _08276_ sky130_fd_sc_hd__nand2_1
X_12142_ _00512_ _08275_ _08276_ VSS VSS VDD VDD _02089_ sky130_fd_sc_hd__o21ai_0
X_12143_ network.neuron_in006.counter\[0\] VSS VSS VDD VDD
+ _00509_ sky130_fd_sc_hd__inv_1
X_12144_ network.in_period\[6\]\[0\] _08275_ VSS VSS VDD VDD
+ _08277_ sky130_fd_sc_hd__nand2_1
X_12145_ network.neuron_in006.counter\[0\] _08275_ _08277_
+ VSS VSS VDD VDD _02088_ sky130_fd_sc_hd__o21ai_0
X_12146_ network.in_period\[128\]\[0\] _08267_ VSS VSS VDD
+ VDD _08278_ sky130_fd_sc_hd__nand2_1
X_12147_ network.neuron_in128.counter\[0\] _08267_ _08278_
+ VSS VSS VDD VDD _02576_ sky130_fd_sc_hd__o21ai_0
Xplace377 net381 VSS VSS VDD VDD net376 sky130_fd_sc_hd__buf_4
X_12149_ network.neuron_in007.counter\[2\] _00470_ VSS VSS
+ VDD VDD _08280_ sky130_fd_sc_hd__xnor2_1
X_12150_ network.neuron_in007.counter\[2\] network.neuron_in007.counter\[3\]
+ VSS VSS VDD VDD _08281_ sky130_fd_sc_hd__nor2_1
X_12151_ _00470_ _08281_ VSS VSS VDD VDD _08282_ sky130_fd_sc_hd__nand2_1
X_12152_ net395 _08282_ network.in_period\[7\]\[2\] VSS VSS
+ VDD VDD _08283_ sky130_fd_sc_hd__a21oi_1
X_12153_ net395 _08280_ _08283_ VSS VSS VDD VDD _02094_ sky130_fd_sc_hd__a21oi_1
X_12154_ net395 _08282_ VSS VSS VDD VDD _08284_ sky130_fd_sc_hd__nand2_1
X_12155_ network.in_period\[7\]\[1\] _08284_ VSS VSS VDD VDD
+ _08285_ sky130_fd_sc_hd__nand2_1
X_12156_ _00471_ _08284_ _08285_ VSS VSS VDD VDD _02093_ sky130_fd_sc_hd__o21ai_0
X_12157_ network.neuron_in007.counter\[0\] VSS VSS VDD VDD
+ _00468_ sky130_fd_sc_hd__inv_1
X_12158_ network.in_period\[7\]\[0\] _08284_ VSS VSS VDD VDD
+ _08286_ sky130_fd_sc_hd__nand2_1
X_12159_ network.neuron_in007.counter\[0\] _08284_ _08286_
+ VSS VSS VDD VDD _02092_ sky130_fd_sc_hd__o21ai_0
X_12160_ loaded\[0\] VSS VSS VDD VDD _01102_ sky130_fd_sc_hd__inv_1
Xplace376 _06361_ VSS VSS VDD VDD net375 sky130_fd_sc_hd__buf_4
X_12162_ network.neuron_out3.IF0.membrane_potential\[1\] network.neuron_out3.IF0.membrane_potential\[2\]
+ network.neuron_out3.IF0.membrane_potential\[3\] network.neuron_out3.IF0.membrane_potential\[0\]
+ VSS VSS VDD VDD _08288_ sky130_fd_sc_hd__nor4_1
X_12163_ network.neuron_out3.IF0.membrane_potential\[5\] network.neuron_out3.IF0.membrane_potential\[6\]
+ network.neuron_out3.IF0.membrane_potential\[4\] VSS VSS VDD
+ VDD _08289_ sky130_fd_sc_hd__nand3_1
X_12164_ network.neuron_out3.IF0.membrane_potential\[8\] network.neuron_out3.IF0.membrane_potential\[9\]
+ network.neuron_out3.IF0.membrane_potential\[10\] network.neuron_out3.IF0.membrane_potential\[7\]
+ VSS VSS VDD VDD _08290_ sky130_fd_sc_hd__nor4_1
X_12165_ _08288_ _08289_ _08290_ VSS VSS VDD VDD _08291_ sky130_fd_sc_hd__o21ai_0
X_12166_ network.neuron_out2.IF0.membrane_potential\[2\] network.neuron_out2.IF0.membrane_potential\[1\]
+ network.neuron_out2.IF0.membrane_potential\[3\] network.neuron_out2.IF0.membrane_potential\[0\]
+ VSS VSS VDD VDD _08292_ sky130_fd_sc_hd__nor4_1
X_12167_ network.neuron_out2.IF0.membrane_potential\[5\] network.neuron_out2.IF0.membrane_potential\[6\]
+ network.neuron_out2.IF0.membrane_potential\[4\] VSS VSS VDD
+ VDD _08293_ sky130_fd_sc_hd__nand3_1
X_12168_ network.neuron_out2.IF0.membrane_potential\[10\]
+ network.neuron_out2.IF0.membrane_potential\[9\] network.neuron_out2.IF0.membrane_potential\[8\]
+ network.neuron_out2.IF0.membrane_potential\[7\] VSS VSS VDD
+ VDD _08294_ sky130_fd_sc_hd__nor4_1
X_12169_ _08292_ _08293_ _08294_ VSS VSS VDD VDD _08295_ sky130_fd_sc_hd__o21ai_0
X_12170_ network.neuron_out0.IF0.membrane_potential\[3\] network.neuron_out0.IF0.membrane_potential\[1\]
+ network.neuron_out0.IF0.membrane_potential\[2\] network.neuron_out0.IF0.membrane_potential\[0\]
+ VSS VSS VDD VDD _08296_ sky130_fd_sc_hd__nor4_1
X_12171_ network.neuron_out0.IF0.membrane_potential\[6\] network.neuron_out0.IF0.membrane_potential\[5\]
+ network.neuron_out0.IF0.membrane_potential\[4\] VSS VSS VDD
+ VDD _08297_ sky130_fd_sc_hd__nand3_1
X_12172_ network.neuron_out0.IF0.membrane_potential\[9\] network.neuron_out0.IF0.membrane_potential\[8\]
+ network.neuron_out0.IF0.membrane_potential\[7\] network.neuron_out0.IF0.membrane_potential\[10\]
+ VSS VSS VDD VDD _08298_ sky130_fd_sc_hd__nor4_1
X_12173_ _08296_ _08297_ _08298_ VSS VSS VDD VDD _08299_ sky130_fd_sc_hd__o21ai_0
X_12174_ network.neuron_out1.IF0.membrane_potential\[3\] network.neuron_out1.IF0.membrane_potential\[0\]
+ network.neuron_out1.IF0.membrane_potential\[1\] network.neuron_out1.IF0.membrane_potential\[2\]
+ VSS VSS VDD VDD _08300_ sky130_fd_sc_hd__nor4_1
X_12175_ network.neuron_out1.IF0.membrane_potential\[6\] network.neuron_out1.IF0.membrane_potential\[4\]
+ network.neuron_out1.IF0.membrane_potential\[5\] VSS VSS VDD
+ VDD _08301_ sky130_fd_sc_hd__nand3_1
X_12176_ network.neuron_out1.IF0.membrane_potential\[7\] network.neuron_out1.IF0.membrane_potential\[9\]
+ network.neuron_out1.IF0.membrane_potential\[8\] network.neuron_out1.IF0.membrane_potential\[10\]
+ VSS VSS VDD VDD _08302_ sky130_fd_sc_hd__nor4_1
X_12177_ _08300_ _08301_ _08302_ VSS VSS VDD VDD _08303_ sky130_fd_sc_hd__o21ai_0
X_12178_ _08291_ _08295_ net312 net311 VSS VSS VDD VDD _08304_
+ sky130_fd_sc_hd__nor4_1
X_12179_ network.neuron_out5.IF0.membrane_potential\[0\] network.neuron_out5.IF0.membrane_potential\[3\]
+ network.neuron_out5.IF0.membrane_potential\[2\] network.neuron_out5.IF0.membrane_potential\[1\]
+ VSS VSS VDD VDD _08305_ sky130_fd_sc_hd__nor4_1
X_12180_ network.neuron_out5.IF0.membrane_potential\[4\] network.neuron_out5.IF0.membrane_potential\[6\]
+ network.neuron_out5.IF0.membrane_potential\[5\] VSS VSS VDD
+ VDD _08306_ sky130_fd_sc_hd__nand3_1
X_12181_ network.neuron_out5.IF0.membrane_potential\[8\] network.neuron_out5.IF0.membrane_potential\[7\]
+ network.neuron_out5.IF0.membrane_potential\[10\] network.neuron_out5.IF0.membrane_potential\[9\]
+ VSS VSS VDD VDD _08307_ sky130_fd_sc_hd__nor4_1
X_12182_ _08305_ _08306_ _08307_ VSS VSS VDD VDD _08308_ sky130_fd_sc_hd__o21ai_0
X_12183_ network.neuron_out4.IF0.membrane_potential\[3\] network.neuron_out4.IF0.membrane_potential\[1\]
+ network.neuron_out4.IF0.membrane_potential\[2\] network.neuron_out4.IF0.membrane_potential\[0\]
+ VSS VSS VDD VDD _08309_ sky130_fd_sc_hd__nor4_1
X_12184_ network.neuron_out4.IF0.membrane_potential\[5\] network.neuron_out4.IF0.membrane_potential\[4\]
+ network.neuron_out4.IF0.membrane_potential\[6\] VSS VSS VDD
+ VDD _08310_ sky130_fd_sc_hd__nand3_1
X_12185_ network.neuron_out4.IF0.membrane_potential\[9\] network.neuron_out4.IF0.membrane_potential\[8\]
+ network.neuron_out4.IF0.membrane_potential\[7\] network.neuron_out4.IF0.membrane_potential\[10\]
+ VSS VSS VDD VDD _08311_ sky130_fd_sc_hd__nor4_1
X_12186_ _08309_ _08310_ _08311_ VSS VSS VDD VDD _08312_ sky130_fd_sc_hd__o21ai_0
X_12187_ _00119_ VSS VSS VDD VDD _08313_ sky130_fd_sc_hd__inv_1
X_12188_ network.arbit.counter\[3\] network.arbit.counter\[2\]
+ _08313_ VSS VSS VDD VDD _08314_ sky130_fd_sc_hd__nor3_1
X_12189_ _08308_ net310 _08314_ VSS VSS VDD VDD _08315_ sky130_fd_sc_hd__nor3_1
Xplace375 net375 VSS VSS VDD VDD net374 sky130_fd_sc_hd__buf_4
X_12191_ _08304_ _08315_ state\[1\] VSS VSS VDD VDD _08317_
+ sky130_fd_sc_hd__a21boi_1
X_12192_ _08291_ _08295_ VSS VSS VDD VDD _08318_ sky130_fd_sc_hd__nor2_1
X_12193_ net310 _08308_ VSS VSS VDD VDD _08319_ sky130_fd_sc_hd__nand2b_1
X_12194_ _08318_ _08319_ net311 VSS VSS VDD VDD _08320_ sky130_fd_sc_hd__a21oi_1
X_12195_ net312 _08320_ _08317_ VSS VSS VDD VDD _08321_ sky130_fd_sc_hd__o21ai_0
X_12196_ net46 _08317_ _08321_ VSS VSS VDD VDD _08322_ sky130_fd_sc_hd__o21ai_0
X_12197_ net430 _08322_ VSS VSS VDD VDD _01552_ sky130_fd_sc_hd__nand2b_1
X_12198_ loaded\[2\] loaded\[3\] _01104_ VSS VSS VDD VDD _08323_
+ sky130_fd_sc_hd__nor3b_1
Xplace374 net374 VSS VSS VDD VDD net373 sky130_fd_sc_hd__buf_4
Xplace373 net375 VSS VSS VDD VDD net372 sky130_fd_sc_hd__buf_4
Xplace372 net372 VSS VSS VDD VDD net371 sky130_fd_sc_hd__buf_4
X_12202_ net429 net428 loaded\[6\] loaded\[7\] VSS VSS VDD
+ VDD _08327_ sky130_fd_sc_hd__nor4_1
X_12203_ state\[0\] VSS VSS VDD VDD _08328_ sky130_fd_sc_hd__inv_1
X_12204_ loaded\[8\] net24 _08323_ _08327_ _08328_ VSS VSS
+ VDD VDD _08329_ sky130_fd_sc_hd__a41o_1
X_12205_ state\[0\] state\[1\] _08329_ VSS VSS VDD VDD _08330_
+ sky130_fd_sc_hd__o21ai_0
X_12206_ state\[1\] _08330_ net430 VSS VSS VDD VDD _08331_
+ sky130_fd_sc_hd__o21bai_1
Xplace371 _06361_ VSS VSS VDD VDD net370 sky130_fd_sc_hd__buf_4
X_12208_ state\[0\] state\[1\] _08329_ VSS VSS VDD VDD _08333_
+ sky130_fd_sc_hd__o21a_1
X_12209_ net39 VSS VSS VDD VDD _08334_ sky130_fd_sc_hd__inv_1
X_12210_ net36 net37 net38 VSS VSS VDD VDD _08335_ sky130_fd_sc_hd__nand3_1
X_12211_ _08334_ _08335_ VSS VSS VDD VDD _08336_ sky130_fd_sc_hd__nor2_1
X_12212_ net35 _01131_ _08333_ _08336_ VSS VSS VDD VDD _08337_
+ sky130_fd_sc_hd__nand4_1
X_12213_ net40 net41 net42 net28 VSS VSS VDD VDD _08338_ sky130_fd_sc_hd__nand4_1
X_12214_ _08337_ _08338_ VSS VSS VDD VDD _08339_ sky130_fd_sc_hd__nor2_1
X_12215_ net29 net30 net31 VSS VSS VDD VDD _08340_ sky130_fd_sc_hd__and3_1
X_12216_ _08339_ _08340_ VSS VSS VDD VDD _08341_ sky130_fd_sc_hd__nand2_1
X_12217_ net32 _08341_ VSS VSS VDD VDD _08342_ sky130_fd_sc_hd__xor2_1
X_12218_ _08331_ _08342_ VSS VSS VDD VDD _01553_ sky130_fd_sc_hd__nor2_1
X_12219_ net27 net34 VSS VSS VDD VDD _08343_ sky130_fd_sc_hd__and2_1
X_12220_ state\[0\] state\[1\] _08329_ _08343_ net35 VSS VSS
+ VDD VDD _08344_ sky130_fd_sc_hd__o2111a_1
X_12221_ _08336_ _08344_ VSS VSS VDD VDD _08345_ sky130_fd_sc_hd__nand2_1
X_12222_ _08338_ _08345_ VSS VSS VDD VDD _08346_ sky130_fd_sc_hd__nor2_1
X_12223_ net29 net30 _08346_ VSS VSS VDD VDD _08347_ sky130_fd_sc_hd__nand3_1
X_12224_ net31 _08347_ VSS VSS VDD VDD _08348_ sky130_fd_sc_hd__xor2_1
X_12225_ _08331_ _08348_ VSS VSS VDD VDD _01554_ sky130_fd_sc_hd__nor2_1
X_12226_ net29 _08339_ VSS VSS VDD VDD _08349_ sky130_fd_sc_hd__nand2_1
X_12227_ net30 _08349_ VSS VSS VDD VDD _08350_ sky130_fd_sc_hd__xor2_1
X_12228_ _08331_ _08350_ VSS VSS VDD VDD _01555_ sky130_fd_sc_hd__nor2_1
X_12229_ net29 _08346_ VSS VSS VDD VDD _08351_ sky130_fd_sc_hd__xnor2_1
X_12230_ _08331_ _08351_ VSS VSS VDD VDD _01556_ sky130_fd_sc_hd__nor2_1
X_12231_ net40 net41 net42 VSS VSS VDD VDD _08352_ sky130_fd_sc_hd__nand3_1
X_12232_ _08337_ _08352_ net28 VSS VSS VDD VDD _08353_ sky130_fd_sc_hd__o21ai_0
X_12233_ net28 _08337_ _08352_ VSS VSS VDD VDD _08354_ sky130_fd_sc_hd__or3_1
X_12234_ _08353_ _08354_ _08331_ VSS VSS VDD VDD _01557_ sky130_fd_sc_hd__a21oi_1
X_12235_ net40 net41 VSS VSS VDD VDD _08355_ sky130_fd_sc_hd__nand2_1
X_12236_ _08355_ _08345_ net42 VSS VSS VDD VDD _08356_ sky130_fd_sc_hd__o21ai_0
X_12237_ net42 _08355_ _08345_ VSS VSS VDD VDD _08357_ sky130_fd_sc_hd__or3_1
X_12238_ _08356_ _08357_ _08331_ VSS VSS VDD VDD _01558_ sky130_fd_sc_hd__a21oi_1
X_12239_ net40 VSS VSS VDD VDD _08358_ sky130_fd_sc_hd__inv_1
X_12240_ _08358_ _08337_ VSS VSS VDD VDD _08359_ sky130_fd_sc_hd__nor2_1
X_12241_ net41 _08359_ VSS VSS VDD VDD _08360_ sky130_fd_sc_hd__xnor2_1
X_12242_ _08331_ _08360_ VSS VSS VDD VDD _01559_ sky130_fd_sc_hd__nor2_1
X_12243_ _08358_ _08345_ VSS VSS VDD VDD _08361_ sky130_fd_sc_hd__xnor2_1
X_12244_ _08331_ _08361_ VSS VSS VDD VDD _01560_ sky130_fd_sc_hd__nor2_1
X_12245_ net35 _01131_ _08333_ VSS VSS VDD VDD _08362_ sky130_fd_sc_hd__nand3_1
X_12246_ _08362_ _08335_ net39 VSS VSS VDD VDD _08363_ sky130_fd_sc_hd__o21ai_0
X_12247_ net39 _08362_ _08335_ VSS VSS VDD VDD _08364_ sky130_fd_sc_hd__or3_1
X_12248_ _08363_ _08364_ _08331_ VSS VSS VDD VDD _01561_ sky130_fd_sc_hd__a21oi_1
X_12249_ net36 net37 _08344_ VSS VSS VDD VDD _08365_ sky130_fd_sc_hd__nand3_1
X_12250_ net38 _08365_ VSS VSS VDD VDD _08366_ sky130_fd_sc_hd__xor2_1
X_12251_ _08331_ _08366_ VSS VSS VDD VDD _01562_ sky130_fd_sc_hd__nor2_1
X_12252_ net35 net36 _01131_ _08333_ VSS VSS VDD VDD _08367_
+ sky130_fd_sc_hd__nand4_1
X_12253_ net37 _08367_ VSS VSS VDD VDD _08368_ sky130_fd_sc_hd__xor2_1
X_12254_ _08331_ _08368_ VSS VSS VDD VDD _01563_ sky130_fd_sc_hd__nor2_1
X_12255_ net36 _08344_ VSS VSS VDD VDD _08369_ sky130_fd_sc_hd__xnor2_1
X_12256_ _08331_ _08369_ VSS VSS VDD VDD _01564_ sky130_fd_sc_hd__nor2_1
X_12257_ _01131_ _08333_ VSS VSS VDD VDD _08370_ sky130_fd_sc_hd__nand2_1
X_12258_ net35 _08370_ VSS VSS VDD VDD _08371_ sky130_fd_sc_hd__xor2_1
X_12259_ _08331_ _08371_ VSS VSS VDD VDD _01565_ sky130_fd_sc_hd__nor2_1
X_12260_ state\[1\] _01132_ _08329_ _08330_ net34 VSS VSS
+ VDD VDD _08372_ sky130_fd_sc_hd__a32oi_1
X_12261_ net430 _08372_ VSS VSS VDD VDD _01566_ sky130_fd_sc_hd__nor2_1
X_12262_ state\[1\] _08329_ VSS VSS VDD VDD _08373_ sky130_fd_sc_hd__nand2_1
X_12263_ net27 _08373_ VSS VSS VDD VDD _08374_ sky130_fd_sc_hd__nor2_1
X_12264_ net27 _08330_ _08374_ VSS VSS VDD VDD _08375_ sky130_fd_sc_hd__a21oi_1
X_12265_ net430 _08375_ VSS VSS VDD VDD _01567_ sky130_fd_sc_hd__nor2_1
X_12266_ state\[1\] _08304_ _08315_ state\[2\] VSS VSS VDD
+ VDD _08376_ sky130_fd_sc_hd__a31oi_1
X_12267_ _08328_ net283 net430 VSS VSS VDD VDD _08377_ sky130_fd_sc_hd__a21oi_1
Xplace370 net370 VSS VSS VDD VDD net369 sky130_fd_sc_hd__buf_4
X_12269_ _08328_ loaded\[8\] net430 VSS VSS VDD VDD net44
+ sky130_fd_sc_hd__nor3_1
X_12270_ net22 net44 _08328_ VSS VSS VDD VDD _08379_ sky130_fd_sc_hd__a21oi_1
X_12271_ state\[1\] _08304_ _08315_ _08379_ state\[2\] VSS
+ VSS VDD VDD _08380_ sky130_fd_sc_hd__a311oi_2
X_12272_ net429 net428 _08380_ VSS VSS VDD VDD _08381_ sky130_fd_sc_hd__and3_1
X_12273_ loaded\[1\] VSS VSS VDD VDD _01103_ sky130_fd_sc_hd__inv_1
Xplace369 net369 VSS VSS VDD VDD net368 sky130_fd_sc_hd__buf_4
Xplace368 _06361_ VSS VSS VDD VDD net367 sky130_fd_sc_hd__buf_4
X_12276_ loaded\[2\] loaded\[3\] VSS VSS VDD VDD _08384_ sky130_fd_sc_hd__nand2_1
X_12277_ _01102_ _01103_ _08384_ VSS VSS VDD VDD _08385_ sky130_fd_sc_hd__nor3_1
X_12278_ net427 _08381_ _08385_ VSS VSS VDD VDD _08386_ sky130_fd_sc_hd__nand3_1
X_12279_ net426 _08386_ VSS VSS VDD VDD _08387_ sky130_fd_sc_hd__xnor2_1
X_12280_ _08377_ _08387_ VSS VSS VDD VDD _01568_ sky130_fd_sc_hd__and2_1
X_12281_ loaded\[2\] loaded\[3\] _01108_ VSS VSS VDD VDD _08388_
+ sky130_fd_sc_hd__and3_1
X_12282_ _08381_ _08388_ VSS VSS VDD VDD _08389_ sky130_fd_sc_hd__nand2_1
X_12283_ net427 _08389_ VSS VSS VDD VDD _08390_ sky130_fd_sc_hd__xnor2_1
X_12284_ _08377_ _08390_ VSS VSS VDD VDD _01569_ sky130_fd_sc_hd__and2_1
X_12285_ net429 _08380_ _08385_ VSS VSS VDD VDD _08391_ sky130_fd_sc_hd__nand3_1
X_12286_ net428 _08391_ VSS VSS VDD VDD _08392_ sky130_fd_sc_hd__xnor2_1
X_12287_ _08377_ _08392_ VSS VSS VDD VDD _01570_ sky130_fd_sc_hd__and2_1
X_12288_ _08380_ _08388_ VSS VSS VDD VDD _08393_ sky130_fd_sc_hd__nand2_1
X_12289_ net429 _08393_ VSS VSS VDD VDD _08394_ sky130_fd_sc_hd__xnor2_1
X_12290_ _08377_ _08394_ VSS VSS VDD VDD _01571_ sky130_fd_sc_hd__and2_1
X_12291_ loaded\[0\] loaded\[1\] loaded\[2\] _08380_ VSS VSS
+ VDD VDD _08395_ sky130_fd_sc_hd__nand4_1
X_12292_ loaded\[3\] _08395_ VSS VSS VDD VDD _08396_ sky130_fd_sc_hd__xnor2_1
X_12293_ _08377_ _08396_ VSS VSS VDD VDD _01572_ sky130_fd_sc_hd__and2_1
X_12294_ _01108_ _08380_ VSS VSS VDD VDD _08397_ sky130_fd_sc_hd__nand2_1
X_12295_ loaded\[2\] _08397_ VSS VSS VDD VDD _08398_ sky130_fd_sc_hd__xnor2_1
X_12296_ _08377_ _08398_ VSS VSS VDD VDD _01573_ sky130_fd_sc_hd__and2_1
X_12297_ state\[0\] _01105_ _08380_ VSS VSS VDD VDD _08399_
+ sky130_fd_sc_hd__nand3_1
X_12298_ _01103_ _08380_ _08399_ VSS VSS VDD VDD _08400_ sky130_fd_sc_hd__o21ai_0
X_12299_ net430 _08400_ VSS VSS VDD VDD _01574_ sky130_fd_sc_hd__nor2b_1
X_12300_ _08328_ loaded\[0\] VSS VSS VDD VDD _08401_ sky130_fd_sc_hd__nor2_1
X_12301_ _01102_ _08380_ VSS VSS VDD VDD _08402_ sky130_fd_sc_hd__nor2_1
X_12302_ _08380_ _08401_ _08402_ VSS VSS VDD VDD _08403_ sky130_fd_sc_hd__a21oi_1
X_12303_ net430 _08403_ VSS VSS VDD VDD _01575_ sky130_fd_sc_hd__nor2_1
X_12304_ network.cnt_main.counter\[3\] network.cnt_main.counter\[2\]
+ network.cnt_main.counter\[5\] network.cnt_main.counter\[4\]
+ VSS VSS VDD VDD _08404_ sky130_fd_sc_hd__nor4_1
X_12305_ _00617_ _08404_ VSS VSS VDD VDD _08405_ sky130_fd_sc_hd__nand2_1
X_12306_ network.cnt_main.counter\[8\] network.cnt_main.counter\[6\]
+ network.cnt_main.counter\[7\] _08405_ VSS VSS VDD VDD _08406_
+ sky130_fd_sc_hd__or4_1
X_12307_ network.cnt_main.counter\[10\] network.cnt_main.counter\[11\]
+ network.cnt_main.counter\[9\] network.cnt_main.counter\[12\]
+ VSS VSS VDD VDD _08407_ sky130_fd_sc_hd__or4_1
X_12308_ network.cnt_main.counter\[13\] _08406_ _08407_ VSS
+ VSS VDD VDD _08408_ sky130_fd_sc_hd__or3_1
Xplace365 _07050_ VSS VSS VDD VDD net364 sky130_fd_sc_hd__buf_4
Xplace364 _07053_ VSS VSS VDD VDD net363 sky130_fd_sc_hd__buf_4
X_12311_ _08313_ net293 VSS VSS VDD VDD _08411_ sky130_fd_sc_hd__nor2_1
X_12312_ network.arbit.counter\[2\] _08411_ VSS VSS VDD VDD
+ _08412_ sky130_fd_sc_hd__xnor2_1
X_12313_ net402 _08412_ VSS VSS VDD VDD _01576_ sky130_fd_sc_hd__nand2_1
Xplace363 _07056_ VSS VSS VDD VDD net362 sky130_fd_sc_hd__buf_4
Xplace362 _07067_ VSS VSS VDD VDD net361 sky130_fd_sc_hd__buf_4
X_12316_ _00120_ net293 VSS VSS VDD VDD _08415_ sky130_fd_sc_hd__nor2_1
X_12317_ network.arbit.counter\[1\] net293 _08415_ VSS VSS
+ VDD VDD _08416_ sky130_fd_sc_hd__a21oi_1
X_12318_ net370 _08416_ VSS VSS VDD VDD _01577_ sky130_fd_sc_hd__nor2_1
X_12319_ _00117_ net293 VSS VSS VDD VDD _08417_ sky130_fd_sc_hd__xnor2_1
X_12320_ net370 _08417_ VSS VSS VDD VDD _01578_ sky130_fd_sc_hd__nor2_1
X_12321_ _00166_ VSS VSS VDD VDD _08418_ sky130_fd_sc_hd__inv_1
X_12322_ _00148_ VSS VSS VDD VDD _08419_ sky130_fd_sc_hd__inv_1
X_12323_ _00128_ _00028_ _00127_ VSS VSS VDD VDD _08420_ sky130_fd_sc_hd__a21o_1
X_12324_ _00181_ _08420_ _00180_ VSS VSS VDD VDD _08421_ sky130_fd_sc_hd__a21oi_1
X_12325_ _08419_ _08421_ _00147_ VSS VSS VDD VDD _08422_ sky130_fd_sc_hd__o21bai_1
X_12326_ _01048_ _08422_ _01047_ VSS VSS VDD VDD _08423_ sky130_fd_sc_hd__a21oi_1
X_12327_ _08423_ _00154_ VSS VSS VDD VDD _08424_ sky130_fd_sc_hd__nor2b_1
X_12328_ _00153_ _08424_ _00167_ VSS VSS VDD VDD _08425_ sky130_fd_sc_hd__o21ai_0
X_12329_ net370 _08308_ VSS VSS VDD VDD _08426_ sky130_fd_sc_hd__or2_2
Xplace361 _07069_ VSS VSS VDD VDD net360 sky130_fd_sc_hd__buf_4
X_12331_ _08418_ _08425_ _08426_ VSS VSS VDD VDD _01579_ sky130_fd_sc_hd__a21oi_1
X_12332_ _00029_ _00181_ _00180_ VSS VSS VDD VDD _08428_ sky130_fd_sc_hd__a21oi_1
X_12333_ _08419_ _08428_ _00147_ VSS VSS VDD VDD _08429_ sky130_fd_sc_hd__o21bai_1
X_12334_ _01048_ _08429_ _01047_ VSS VSS VDD VDD _08430_ sky130_fd_sc_hd__a21o_1
X_12335_ _00154_ _08430_ _00153_ VSS VSS VDD VDD _08431_ sky130_fd_sc_hd__a21oi_1
X_12336_ _00167_ _08431_ VSS VSS VDD VDD _08432_ sky130_fd_sc_hd__xor2_1
X_12337_ _08426_ _08432_ VSS VSS VDD VDD _01580_ sky130_fd_sc_hd__nor2_1
X_12338_ _00154_ _08423_ VSS VSS VDD VDD _08433_ sky130_fd_sc_hd__nor2b_1
X_12339_ _08426_ _08424_ _08433_ VSS VSS VDD VDD _01581_ sky130_fd_sc_hd__nor3_1
X_12340_ _01048_ _08429_ VSS VSS VDD VDD _08434_ sky130_fd_sc_hd__xnor2_1
X_12341_ _08426_ _08434_ VSS VSS VDD VDD _01582_ sky130_fd_sc_hd__nor2_1
X_12342_ _08419_ _08421_ VSS VSS VDD VDD _08435_ sky130_fd_sc_hd__xnor2_1
X_12343_ _08426_ _08435_ VSS VSS VDD VDD _01583_ sky130_fd_sc_hd__nor2_1
X_12344_ _00029_ _00181_ VSS VSS VDD VDD _08436_ sky130_fd_sc_hd__xnor2_1
X_12345_ _08426_ _08436_ VSS VSS VDD VDD _01584_ sky130_fd_sc_hd__nor2_1
X_12346_ _00030_ VSS VSS VDD VDD _08437_ sky130_fd_sc_hd__inv_1
X_12347_ _08437_ _08426_ VSS VSS VDD VDD _01585_ sky130_fd_sc_hd__nor2_1
X_12348_ _00742_ VSS VSS VDD VDD _08438_ sky130_fd_sc_hd__inv_1
X_12349_ _08438_ _08426_ VSS VSS VDD VDD _01586_ sky130_fd_sc_hd__nor2_1
X_12350_ net367 net310 VSS VSS VDD VDD _08439_ sky130_fd_sc_hd__or2_2
Xplace360 _07072_ VSS VSS VDD VDD net359 sky130_fd_sc_hd__buf_4
X_12352_ _00031_ _00179_ _00178_ VSS VSS VDD VDD _08441_ sky130_fd_sc_hd__a21o_1
X_12353_ _00849_ _08441_ _00848_ VSS VSS VDD VDD _08442_ sky130_fd_sc_hd__a21oi_1
X_12354_ _08442_ _00094_ VSS VSS VDD VDD _08443_ sky130_fd_sc_hd__nor2b_1
X_12355_ _00093_ _08443_ _00323_ VSS VSS VDD VDD _08444_ sky130_fd_sc_hd__o21ai_0
X_12356_ _00322_ _08444_ VSS VSS VDD VDD _08445_ sky130_fd_sc_hd__nand2b_1
X_12357_ network.neuron_out4.IF0.membrane_potential\[5\] network.neuron_out4.IF0.membrane_potential\[6\]
+ _08445_ network.neuron_out4.IF0.membrane_potential\[7\] VSS
+ VSS VDD VDD _08446_ sky130_fd_sc_hd__a31oi_1
X_12358_ _08439_ _08446_ VSS VSS VDD VDD _01587_ sky130_fd_sc_hd__nor2_1
X_12359_ _00849_ _00032_ _00848_ VSS VSS VDD VDD _08447_ sky130_fd_sc_hd__a21o_1
X_12360_ _00094_ _08447_ _00093_ VSS VSS VDD VDD _08448_ sky130_fd_sc_hd__a21oi_1
X_12361_ _08448_ _00323_ VSS VSS VDD VDD _08449_ sky130_fd_sc_hd__nor2b_1
X_12362_ _00322_ _08449_ network.neuron_out4.IF0.membrane_potential\[5\]
+ VSS VSS VDD VDD _08450_ sky130_fd_sc_hd__o21ai_0
X_12363_ network.neuron_out4.IF0.membrane_potential\[6\] _08450_
+ VSS VSS VDD VDD _08451_ sky130_fd_sc_hd__xor2_1
X_12364_ _08439_ _08451_ VSS VSS VDD VDD _01588_ sky130_fd_sc_hd__nor2_1
X_12365_ network.neuron_out4.IF0.membrane_potential\[5\] _08445_
+ VSS VSS VDD VDD _08452_ sky130_fd_sc_hd__xnor2_1
X_12366_ _08439_ _08452_ VSS VSS VDD VDD _01589_ sky130_fd_sc_hd__nor2_1
X_12367_ _00323_ _08448_ VSS VSS VDD VDD _08453_ sky130_fd_sc_hd__nor2b_1
X_12368_ _08439_ _08449_ _08453_ VSS VSS VDD VDD _01590_ sky130_fd_sc_hd__nor3_1
X_12369_ _00094_ _08442_ VSS VSS VDD VDD _08454_ sky130_fd_sc_hd__nor2b_1
X_12370_ _08439_ _08443_ _08454_ VSS VSS VDD VDD _01591_ sky130_fd_sc_hd__nor3_1
X_12371_ _00849_ _00032_ VSS VSS VDD VDD _08455_ sky130_fd_sc_hd__xnor2_1
X_12372_ _08439_ _08455_ VSS VSS VDD VDD _01592_ sky130_fd_sc_hd__nor2_1
X_12373_ _00033_ VSS VSS VDD VDD _08456_ sky130_fd_sc_hd__inv_1
X_12374_ _08456_ _08439_ VSS VSS VDD VDD _01593_ sky130_fd_sc_hd__nor2_1
X_12375_ _00324_ VSS VSS VDD VDD _08457_ sky130_fd_sc_hd__inv_1
X_12376_ _08457_ _08439_ VSS VSS VDD VDD _01594_ sky130_fd_sc_hd__nor2_1
X_12377_ network.neuron_out3.IF0.membrane_potential\[5\] network.neuron_out3.IF0.membrane_potential\[6\]
+ VSS VSS VDD VDD _08458_ sky130_fd_sc_hd__nand2_1
X_12378_ _00025_ _00326_ _00325_ VSS VSS VDD VDD _08459_ sky130_fd_sc_hd__a21o_1
X_12379_ _00177_ _08459_ _00176_ VSS VSS VDD VDD _08460_ sky130_fd_sc_hd__a21o_1
X_12380_ _00160_ _08460_ _00159_ VSS VSS VDD VDD _08461_ sky130_fd_sc_hd__a21o_1
X_12381_ _01042_ _08461_ _01041_ VSS VSS VDD VDD _08462_ sky130_fd_sc_hd__a21oi_1
X_12382_ _08458_ _08462_ network.neuron_out3.IF0.membrane_potential\[7\]
+ VSS VSS VDD VDD _08463_ sky130_fd_sc_hd__o21ai_0
X_12383_ network.neuron_out3.IF0.membrane_potential\[7\] _08458_
+ _08462_ VSS VSS VDD VDD _08464_ sky130_fd_sc_hd__or3_1
X_12384_ net367 _08291_ VSS VSS VDD VDD _08465_ sky130_fd_sc_hd__or2_2
Xplace359 _07088_ VSS VSS VDD VDD net358 sky130_fd_sc_hd__buf_4
X_12386_ _08463_ _08464_ _08465_ VSS VSS VDD VDD _01595_ sky130_fd_sc_hd__a21oi_1
X_12387_ _00026_ _00177_ _00176_ VSS VSS VDD VDD _08467_ sky130_fd_sc_hd__a21o_1
X_12388_ _00160_ _08467_ _00159_ VSS VSS VDD VDD _08468_ sky130_fd_sc_hd__a21oi_1
X_12389_ _08468_ _01042_ VSS VSS VDD VDD _08469_ sky130_fd_sc_hd__nor2b_1
X_12390_ _01041_ _08469_ network.neuron_out3.IF0.membrane_potential\[5\]
+ VSS VSS VDD VDD _08470_ sky130_fd_sc_hd__o21ai_0
X_12391_ network.neuron_out3.IF0.membrane_potential\[6\] _08470_
+ VSS VSS VDD VDD _08471_ sky130_fd_sc_hd__xor2_1
X_12392_ _08465_ _08471_ VSS VSS VDD VDD _01596_ sky130_fd_sc_hd__nor2_1
X_12393_ network.neuron_out3.IF0.membrane_potential\[5\] _08462_
+ VSS VSS VDD VDD _08472_ sky130_fd_sc_hd__xor2_1
X_12394_ _08465_ _08472_ VSS VSS VDD VDD _01597_ sky130_fd_sc_hd__nor2_1
X_12395_ _01042_ _08468_ VSS VSS VDD VDD _08473_ sky130_fd_sc_hd__nor2b_1
X_12396_ _08465_ _08469_ _08473_ VSS VSS VDD VDD _01598_ sky130_fd_sc_hd__nor3_1
X_12397_ _00160_ _08460_ VSS VSS VDD VDD _08474_ sky130_fd_sc_hd__xnor2_1
X_12398_ _08465_ _08474_ VSS VSS VDD VDD _01599_ sky130_fd_sc_hd__nor2_1
X_12399_ _00026_ _00177_ VSS VSS VDD VDD _08475_ sky130_fd_sc_hd__xnor2_1
X_12400_ _08465_ _08475_ VSS VSS VDD VDD _01600_ sky130_fd_sc_hd__nor2_1
X_12401_ _00027_ VSS VSS VDD VDD _08476_ sky130_fd_sc_hd__inv_1
X_12402_ _08476_ _08465_ VSS VSS VDD VDD _01601_ sky130_fd_sc_hd__nor2_1
X_12403_ _00319_ VSS VSS VDD VDD _08477_ sky130_fd_sc_hd__inv_1
X_12404_ _08477_ _08465_ VSS VSS VDD VDD _01602_ sky130_fd_sc_hd__nor2_1
X_12405_ network.neuron_out2.IF0.membrane_potential\[5\] network.neuron_out2.IF0.membrane_potential\[6\]
+ VSS VSS VDD VDD _08478_ sky130_fd_sc_hd__nand2_1
X_12406_ _00006_ _00314_ _01225_ VSS VSS VDD VDD _08479_ sky130_fd_sc_hd__a21o_1
X_12407_ _01110_ _08479_ _01109_ VSS VSS VDD VDD _08480_ sky130_fd_sc_hd__a21o_1
X_12408_ _00715_ _08480_ _00714_ VSS VSS VDD VDD _08481_ sky130_fd_sc_hd__a21o_1
X_12409_ _00872_ _08481_ _00871_ VSS VSS VDD VDD _08482_ sky130_fd_sc_hd__a21oi_1
X_12410_ _08478_ _08482_ network.neuron_out2.IF0.membrane_potential\[7\]
+ VSS VSS VDD VDD _08483_ sky130_fd_sc_hd__o21ai_0
X_12411_ network.neuron_out2.IF0.membrane_potential\[7\] _08478_
+ _08482_ VSS VSS VDD VDD _08484_ sky130_fd_sc_hd__or3_1
X_12412_ net367 _08295_ VSS VSS VDD VDD _08485_ sky130_fd_sc_hd__or2_2
Xplace358 _07096_ VSS VSS VDD VDD net357 sky130_fd_sc_hd__buf_4
X_12414_ _08483_ _08484_ _08485_ VSS VSS VDD VDD _01603_ sky130_fd_sc_hd__a21oi_1
X_12415_ _00007_ _01110_ _01109_ VSS VSS VDD VDD _08487_ sky130_fd_sc_hd__a21o_1
X_12416_ _00715_ _08487_ _00714_ VSS VSS VDD VDD _08488_ sky130_fd_sc_hd__a21oi_1
X_12417_ _08488_ _00872_ VSS VSS VDD VDD _08489_ sky130_fd_sc_hd__nor2b_1
X_12418_ _00871_ _08489_ network.neuron_out2.IF0.membrane_potential\[5\]
+ VSS VSS VDD VDD _08490_ sky130_fd_sc_hd__o21ai_0
X_12419_ network.neuron_out2.IF0.membrane_potential\[6\] _08490_
+ VSS VSS VDD VDD _08491_ sky130_fd_sc_hd__xor2_1
X_12420_ _08485_ _08491_ VSS VSS VDD VDD _01604_ sky130_fd_sc_hd__nor2_1
X_12421_ network.neuron_out2.IF0.membrane_potential\[5\] _08482_
+ VSS VSS VDD VDD _08492_ sky130_fd_sc_hd__xor2_1
X_12422_ _08485_ _08492_ VSS VSS VDD VDD _01605_ sky130_fd_sc_hd__nor2_1
X_12423_ _00872_ _08488_ VSS VSS VDD VDD _08493_ sky130_fd_sc_hd__nor2b_1
X_12424_ _08485_ _08489_ _08493_ VSS VSS VDD VDD _01606_ sky130_fd_sc_hd__nor3_1
X_12425_ _00715_ _08480_ VSS VSS VDD VDD _08494_ sky130_fd_sc_hd__xnor2_1
X_12426_ _08485_ _08494_ VSS VSS VDD VDD _01607_ sky130_fd_sc_hd__nor2_1
X_12427_ _00007_ _01110_ VSS VSS VDD VDD _08495_ sky130_fd_sc_hd__xnor2_1
X_12428_ _08485_ _08495_ VSS VSS VDD VDD _01608_ sky130_fd_sc_hd__nor2_1
X_12429_ _00008_ VSS VSS VDD VDD _08496_ sky130_fd_sc_hd__inv_1
X_12430_ _08496_ _08485_ VSS VSS VDD VDD _01609_ sky130_fd_sc_hd__nor2_1
X_12431_ _00161_ VSS VSS VDD VDD _08497_ sky130_fd_sc_hd__inv_1
X_12432_ _08497_ _08485_ VSS VSS VDD VDD _01610_ sky130_fd_sc_hd__nor2_1
X_12433_ network.neuron_out1.IF0.membrane_potential\[6\] network.neuron_out1.IF0.membrane_potential\[5\]
+ VSS VSS VDD VDD _08498_ sky130_fd_sc_hd__nand2_1
X_12434_ _00014_ _00653_ _00850_ VSS VSS VDD VDD _08499_ sky130_fd_sc_hd__a21o_1
X_12435_ _01040_ _08499_ _01039_ VSS VSS VDD VDD _08500_ sky130_fd_sc_hd__a21o_1
X_12436_ _00142_ _08500_ _00141_ VSS VSS VDD VDD _08501_ sky130_fd_sc_hd__a21o_1
X_12437_ _00767_ _08501_ _00766_ VSS VSS VDD VDD _08502_ sky130_fd_sc_hd__a21oi_1
X_12438_ _08498_ _08502_ network.neuron_out1.IF0.membrane_potential\[7\]
+ VSS VSS VDD VDD _08503_ sky130_fd_sc_hd__o21ai_0
X_12439_ network.neuron_out1.IF0.membrane_potential\[7\] _08498_
+ _08502_ VSS VSS VDD VDD _08504_ sky130_fd_sc_hd__or3_1
X_12440_ net367 net311 VSS VSS VDD VDD _08505_ sky130_fd_sc_hd__or2_2
Xplace357 _07117_ VSS VSS VDD VDD net356 sky130_fd_sc_hd__buf_4
X_12442_ _08503_ _08504_ _08505_ VSS VSS VDD VDD _01611_ sky130_fd_sc_hd__a21oi_1
X_12443_ _01040_ _00015_ _01039_ VSS VSS VDD VDD _08507_ sky130_fd_sc_hd__a21o_1
X_12444_ _00142_ _08507_ _00141_ VSS VSS VDD VDD _08508_ sky130_fd_sc_hd__a21oi_1
X_12445_ _08508_ _00767_ VSS VSS VDD VDD _08509_ sky130_fd_sc_hd__nor2b_1
X_12446_ _00766_ _08509_ network.neuron_out1.IF0.membrane_potential\[5\]
+ VSS VSS VDD VDD _08510_ sky130_fd_sc_hd__o21ai_0
X_12447_ network.neuron_out1.IF0.membrane_potential\[6\] _08510_
+ VSS VSS VDD VDD _08511_ sky130_fd_sc_hd__xor2_1
X_12448_ _08505_ _08511_ VSS VSS VDD VDD _01612_ sky130_fd_sc_hd__nor2_1
X_12449_ network.neuron_out1.IF0.membrane_potential\[5\] _08502_
+ VSS VSS VDD VDD _08512_ sky130_fd_sc_hd__xor2_1
X_12450_ _08505_ _08512_ VSS VSS VDD VDD _01613_ sky130_fd_sc_hd__nor2_1
X_12451_ _00767_ _08508_ VSS VSS VDD VDD _08513_ sky130_fd_sc_hd__nor2b_1
X_12452_ _08505_ _08509_ _08513_ VSS VSS VDD VDD _01614_ sky130_fd_sc_hd__nor3_1
X_12453_ _00142_ _08500_ VSS VSS VDD VDD _08514_ sky130_fd_sc_hd__xnor2_1
X_12454_ _08505_ _08514_ VSS VSS VDD VDD _01615_ sky130_fd_sc_hd__nor2_1
X_12455_ _01040_ _00015_ VSS VSS VDD VDD _08515_ sky130_fd_sc_hd__xnor2_1
X_12456_ _08505_ _08515_ VSS VSS VDD VDD _01616_ sky130_fd_sc_hd__nor2_1
X_12457_ _00016_ VSS VSS VDD VDD _08516_ sky130_fd_sc_hd__inv_1
X_12458_ _08516_ _08505_ VSS VSS VDD VDD _01617_ sky130_fd_sc_hd__nor2_1
X_12459_ _01022_ VSS VSS VDD VDD _08517_ sky130_fd_sc_hd__inv_1
X_12460_ _08517_ _08505_ VSS VSS VDD VDD _01618_ sky130_fd_sc_hd__nor2_1
X_12461_ net370 net312 VSS VSS VDD VDD _08518_ sky130_fd_sc_hd__or2_2
Xplace356 _07120_ VSS VSS VDD VDD net355 sky130_fd_sc_hd__buf_4
X_12463_ _00657_ VSS VSS VDD VDD _08520_ sky130_fd_sc_hd__inv_1
X_12464_ _00011_ _00508_ _00877_ VSS VSS VDD VDD _08521_ sky130_fd_sc_hd__a21o_1
X_12465_ _01046_ _08521_ _01045_ VSS VSS VDD VDD _08522_ sky130_fd_sc_hd__a21oi_1
X_12466_ _08520_ _08522_ _00656_ VSS VSS VDD VDD _08523_ sky130_fd_sc_hd__o21bai_1
X_12467_ _00163_ _08523_ _00162_ VSS VSS VDD VDD _08524_ sky130_fd_sc_hd__a21oi_1
X_12468_ _08524_ _01231_ VSS VSS VDD VDD _08525_ sky130_fd_sc_hd__nor2b_1
X_12469_ _01230_ _08525_ network.neuron_out0.IF0.membrane_potential\[6\]
+ VSS VSS VDD VDD _08526_ sky130_fd_sc_hd__o21ai_0
X_12470_ network.neuron_out0.IF0.membrane_potential\[7\] _08526_
+ VSS VSS VDD VDD _08527_ sky130_fd_sc_hd__xor2_1
X_12471_ _08518_ _08527_ VSS VSS VDD VDD _01619_ sky130_fd_sc_hd__nor2_1
X_12472_ _01046_ _00012_ _01045_ VSS VSS VDD VDD _08528_ sky130_fd_sc_hd__a21oi_1
X_12473_ _08520_ _08528_ _00656_ VSS VSS VDD VDD _08529_ sky130_fd_sc_hd__o21bai_1
X_12474_ _00163_ _08529_ _00162_ VSS VSS VDD VDD _08530_ sky130_fd_sc_hd__a21o_1
X_12475_ _01231_ _08530_ _01230_ VSS VSS VDD VDD _08531_ sky130_fd_sc_hd__a21oi_1
X_12476_ network.neuron_out0.IF0.membrane_potential\[6\] _08531_
+ VSS VSS VDD VDD _08532_ sky130_fd_sc_hd__xor2_1
X_12477_ _08518_ _08532_ VSS VSS VDD VDD _01620_ sky130_fd_sc_hd__nor2_1
X_12478_ _01231_ _08524_ VSS VSS VDD VDD _08533_ sky130_fd_sc_hd__nor2b_1
X_12479_ _08518_ _08525_ _08533_ VSS VSS VDD VDD _01621_ sky130_fd_sc_hd__nor3_1
X_12480_ _00163_ _08529_ VSS VSS VDD VDD _08534_ sky130_fd_sc_hd__xnor2_1
X_12481_ _08518_ _08534_ VSS VSS VDD VDD _01622_ sky130_fd_sc_hd__nor2_1
X_12482_ _08520_ _08522_ VSS VSS VDD VDD _08535_ sky130_fd_sc_hd__xnor2_1
X_12483_ _08518_ _08535_ VSS VSS VDD VDD _01623_ sky130_fd_sc_hd__nor2_1
X_12484_ _01046_ _00012_ VSS VSS VDD VDD _08536_ sky130_fd_sc_hd__xnor2_1
X_12485_ _08518_ _08536_ VSS VSS VDD VDD _01624_ sky130_fd_sc_hd__nor2_1
X_12486_ _00013_ VSS VSS VDD VDD _08537_ sky130_fd_sc_hd__inv_1
X_12487_ _08537_ _08518_ VSS VSS VDD VDD _01625_ sky130_fd_sc_hd__nor2_1
X_12488_ _00648_ VSS VSS VDD VDD _08538_ sky130_fd_sc_hd__inv_1
X_12489_ _08538_ _08518_ VSS VSS VDD VDD _01626_ sky130_fd_sc_hd__nor2_1
X_12490_ network.hid_spk3 network.hid_spk2 VSS VSS VDD VDD
+ _08539_ sky130_fd_sc_hd__nor2_1
X_12491_ network.hid_spk5 network.hid_spk4 VSS VSS VDD VDD
+ _08540_ sky130_fd_sc_hd__nor2_1
X_12492_ network.hid_spk7 network.hid_spk6 _08540_ VSS VSS
+ VDD VDD _08541_ sky130_fd_sc_hd__o21ai_0
X_12493_ network.hid_spk7 network.hid_spk6 network.hid_spk5
+ network.hid_spk4 VSS VSS VDD VDD _08542_ sky130_fd_sc_hd__nor4_1
Xplace354 _07133_ VSS VSS VDD VDD net353 sky130_fd_sc_hd__buf_4
X_12495_ network.hid_spk3 network.hid_spk2 network.hid_spk1
+ VSS VSS VDD VDD _08544_ sky130_fd_sc_hd__nor3_1
Xplace352 _07138_ VSS VSS VDD VDD net351 sky130_fd_sc_hd__buf_4
X_12497_ _08542_ _08544_ network.hid_spk0 net370 VSS VSS VDD
+ VDD _08546_ sky130_fd_sc_hd__a211o_1
X_12498_ _08539_ _08541_ _08546_ network.hid_spk1 network.hid_spk0
+ VSS VSS VDD VDD _01627_ sky130_fd_sc_hd__a2111oi_0
X_12499_ network.hid_spk3 network.hid_spk2 network.hid_spk1
+ network.hid_spk0 VSS VSS VDD VDD _08547_ sky130_fd_sc_hd__nor4_1
X_12500_ _08540_ _08547_ VSS VSS VDD VDD _08548_ sky130_fd_sc_hd__nand2_1
X_12501_ network.hid_spk6 _08548_ VSS VSS VDD VDD _08549_
+ sky130_fd_sc_hd__nor2_1
X_12502_ network.hid_spk4 VSS VSS VDD VDD _08550_ sky130_fd_sc_hd__inv_1
X_12503_ network.hid_spk5 _08550_ network.hid_spk3 VSS VSS
+ VDD VDD _08551_ sky130_fd_sc_hd__a21oi_1
X_12504_ network.hid_spk2 _08551_ VSS VSS VDD VDD _08552_
+ sky130_fd_sc_hd__nor2_1
X_12505_ network.hid_spk1 _08552_ VSS VSS VDD VDD _08553_
+ sky130_fd_sc_hd__nor2_1
X_12506_ network.hid_spk0 _08553_ VSS VSS VDD VDD _08554_
+ sky130_fd_sc_hd__nor2_1
X_12507_ network.hid_spk7 _08549_ _08554_ VSS VSS VDD VDD
+ _08555_ sky130_fd_sc_hd__a21oi_1
X_12508_ _08546_ _08555_ VSS VSS VDD VDD _01628_ sky130_fd_sc_hd__nor2_1
X_12509_ network.neuron_hid7.IF0.membrane_potential\[5\] network.neuron_hid7.IF0.membrane_potential\[2\]
+ network.neuron_hid7.IF0.membrane_potential\[3\] network.neuron_hid7.IF0.membrane_potential\[0\]
+ VSS VSS VDD VDD _08556_ sky130_fd_sc_hd__or4_1
X_12510_ network.neuron_hid7.IF0.membrane_potential\[1\] network.neuron_hid7.IF0.membrane_potential\[4\]
+ _08556_ network.neuron_hid7.IF0.membrane_potential\[6\] VSS
+ VSS VDD VDD _08557_ sky130_fd_sc_hd__o31a_1
X_12511_ network.neuron_hid7.IF0.membrane_potential\[7\] _08557_
+ network.neuron_hid7.IF0.membrane_potential\[8\] VSS VSS VDD
+ VDD _08558_ sky130_fd_sc_hd__o21a_1
X_12512_ network.neuron_hid7.IF0.membrane_potential\[10\]
+ network.neuron_hid7.IF0.membrane_potential\[9\] _08558_ _00732_
+ VSS VSS VDD VDD _08559_ sky130_fd_sc_hd__o31ai_1
X_12513_ net402 _08559_ VSS VSS VDD VDD _08560_ sky130_fd_sc_hd__nand2_1
Xplace351 _07167_ VSS VSS VDD VDD net350 sky130_fd_sc_hd__buf_4
X_12515_ _00732_ net293 VSS VSS VDD VDD _08562_ sky130_fd_sc_hd__nor2_1
X_12516_ network.neuron_hid7.IF0.ref_counter\[0\] _08562_
+ VSS VSS VDD VDD _08563_ sky130_fd_sc_hd__xnor2_1
X_12517_ _08560_ _08563_ VSS VSS VDD VDD _01629_ sky130_fd_sc_hd__nor2_1
X_12518_ _00321_ VSS VSS VDD VDD _08564_ sky130_fd_sc_hd__inv_1
X_12519_ _00858_ VSS VSS VDD VDD _08565_ sky130_fd_sc_hd__inv_1
X_12520_ _00100_ _00004_ _00647_ VSS VSS VDD VDD _08566_ sky130_fd_sc_hd__a21o_1
X_12521_ _00122_ _08566_ _00121_ VSS VSS VDD VDD _08567_ sky130_fd_sc_hd__a21oi_1
X_12522_ _08565_ _08567_ _00857_ VSS VSS VDD VDD _08568_ sky130_fd_sc_hd__o21bai_1
X_12523_ _00852_ _08568_ _00851_ VSS VSS VDD VDD _08569_ sky130_fd_sc_hd__a21oi_1
X_12524_ _08564_ _08569_ _00320_ VSS VSS VDD VDD _08570_ sky130_fd_sc_hd__o21bai_1
X_12525_ _00846_ network.neuron_hid7.IF0.membrane_potential\[8\]
+ VSS VSS VDD VDD _08571_ sky130_fd_sc_hd__nand2_1
X_12526_ _00847_ _00379_ network.neuron_hid7.IF0.membrane_potential\[8\]
+ VSS VSS VDD VDD _08572_ sky130_fd_sc_hd__nand3_1
X_12527_ _08571_ _08572_ VSS VSS VDD VDD _08573_ sky130_fd_sc_hd__nand2_1
X_12528_ _00847_ _00380_ network.neuron_hid7.IF0.membrane_potential\[8\]
+ _08570_ _08573_ VSS VSS VDD VDD _08574_ sky130_fd_sc_hd__a41oi_1
X_12529_ network.neuron_hid7.IF0.membrane_potential\[9\] _08574_
+ VSS VSS VDD VDD _08575_ sky130_fd_sc_hd__xor2_1
X_12530_ _08560_ _08575_ VSS VSS VDD VDD _01630_ sky130_fd_sc_hd__nor2_1
X_12531_ _00847_ _00380_ VSS VSS VDD VDD _08576_ sky130_fd_sc_hd__nand2_1
X_12532_ _00852_ VSS VSS VDD VDD _08577_ sky130_fd_sc_hd__inv_1
X_12533_ _00122_ _00005_ _00121_ VSS VSS VDD VDD _08578_ sky130_fd_sc_hd__a21o_1
X_12534_ _00858_ _08578_ _00857_ VSS VSS VDD VDD _08579_ sky130_fd_sc_hd__a21oi_1
X_12535_ _08577_ _08579_ _00851_ VSS VSS VDD VDD _08580_ sky130_fd_sc_hd__o21bai_1
X_12536_ _00321_ _08580_ _00320_ VSS VSS VDD VDD _08581_ sky130_fd_sc_hd__a21oi_1
X_12537_ _00847_ _00379_ _00846_ VSS VSS VDD VDD _08582_ sky130_fd_sc_hd__a21oi_1
X_12538_ _08576_ _08581_ _08582_ VSS VSS VDD VDD _08583_ sky130_fd_sc_hd__o21ai_0
X_12539_ network.neuron_hid7.IF0.membrane_potential\[8\] _08583_
+ VSS VSS VDD VDD _08584_ sky130_fd_sc_hd__xnor2_1
X_12540_ _08560_ _08584_ VSS VSS VDD VDD _01631_ sky130_fd_sc_hd__nor2_1
X_12541_ _00380_ _08570_ _00379_ VSS VSS VDD VDD _08585_ sky130_fd_sc_hd__a21oi_1
X_12542_ _00847_ _08585_ VSS VSS VDD VDD _08586_ sky130_fd_sc_hd__xor2_1
X_12543_ _08560_ _08586_ VSS VSS VDD VDD _01632_ sky130_fd_sc_hd__nor2_1
X_12544_ _00380_ _08581_ VSS VSS VDD VDD _08587_ sky130_fd_sc_hd__xor2_1
X_12545_ _08560_ _08587_ VSS VSS VDD VDD _01633_ sky130_fd_sc_hd__nor2_1
X_12546_ _08564_ _08569_ VSS VSS VDD VDD _08588_ sky130_fd_sc_hd__xnor2_1
X_12547_ _08560_ _08588_ VSS VSS VDD VDD _01634_ sky130_fd_sc_hd__nor2_1
X_12548_ _08577_ _08579_ VSS VSS VDD VDD _08589_ sky130_fd_sc_hd__xnor2_1
X_12549_ _08560_ _08589_ VSS VSS VDD VDD _01635_ sky130_fd_sc_hd__nor2_1
X_12550_ _08565_ _08567_ VSS VSS VDD VDD _08590_ sky130_fd_sc_hd__xnor2_1
X_12551_ _08560_ _08590_ VSS VSS VDD VDD _01636_ sky130_fd_sc_hd__nor2_1
X_12552_ _00122_ _00005_ VSS VSS VDD VDD _08591_ sky130_fd_sc_hd__xnor2_1
X_12553_ _08560_ _08591_ VSS VSS VDD VDD _01637_ sky130_fd_sc_hd__nor2_1
Xplace350 _07169_ VSS VSS VDD VDD net349 sky130_fd_sc_hd__buf_4
Xplace348 _07204_ VSS VSS VDD VDD net347 sky130_fd_sc_hd__buf_4
X_12556_ network.neuron_hid7.IF0.add_out\[1\] net402 _08559_
+ VSS VSS VDD VDD _01638_ sky130_fd_sc_hd__and3_1
Xplace344 _07247_ VSS VSS VDD VDD net343 sky130_fd_sc_hd__buf_4
X_12558_ network.neuron_hid7.IF0.add_out\[0\] net402 _08559_
+ VSS VSS VDD VDD _01639_ sky130_fd_sc_hd__and3_1
X_12559_ network.neuron_hid6.IF0.membrane_potential\[0\] network.neuron_hid6.IF0.membrane_potential\[4\]
+ network.neuron_hid6.IF0.membrane_potential\[1\] network.neuron_hid6.IF0.membrane_potential\[5\]
+ VSS VSS VDD VDD _08595_ sky130_fd_sc_hd__or4_1
X_12560_ network.neuron_hid6.IF0.membrane_potential\[3\] network.neuron_hid6.IF0.membrane_potential\[2\]
+ _08595_ network.neuron_hid6.IF0.membrane_potential\[6\] VSS
+ VSS VDD VDD _08596_ sky130_fd_sc_hd__o31a_1
X_12561_ network.neuron_hid6.IF0.membrane_potential\[7\] _08596_
+ network.neuron_hid6.IF0.membrane_potential\[8\] VSS VSS VDD
+ VDD _08597_ sky130_fd_sc_hd__o21a_1
X_12562_ network.neuron_hid6.IF0.membrane_potential\[10\]
+ network.neuron_hid6.IF0.membrane_potential\[9\] _08597_ _01157_
+ VSS VSS VDD VDD _08598_ sky130_fd_sc_hd__o31ai_1
X_12563_ net402 _08598_ VSS VSS VDD VDD _08599_ sky130_fd_sc_hd__nand2_1
Xplace343 _07249_ VSS VSS VDD VDD net342 sky130_fd_sc_hd__buf_4
X_12565_ _01157_ net293 VSS VSS VDD VDD _08601_ sky130_fd_sc_hd__nor2_1
X_12566_ network.neuron_hid6.IF0.ref_counter\[0\] _08601_
+ VSS VSS VDD VDD _08602_ sky130_fd_sc_hd__xnor2_1
X_12567_ _08599_ _08602_ VSS VSS VDD VDD _01640_ sky130_fd_sc_hd__nor2_1
X_12568_ _00000_ _00086_ _00755_ VSS VSS VDD VDD _08603_ sky130_fd_sc_hd__a21o_1
X_12569_ _01054_ _08603_ _01053_ VSS VSS VDD VDD _08604_ sky130_fd_sc_hd__a21o_1
X_12570_ _00447_ _08604_ _00446_ VSS VSS VDD VDD _08605_ sky130_fd_sc_hd__a21o_1
X_12571_ _00088_ _08605_ _00087_ VSS VSS VDD VDD _08606_ sky130_fd_sc_hd__a21oi_1
X_12572_ network.neuron_hid6.IF0.membrane_potential\[6\] network.neuron_hid6.IF0.membrane_potential\[5\]
+ network.neuron_hid6.IF0.membrane_potential\[8\] network.neuron_hid6.IF0.membrane_potential\[7\]
+ VSS VSS VDD VDD _08607_ sky130_fd_sc_hd__nand4_1
X_12573_ _08606_ _08607_ network.neuron_hid6.IF0.membrane_potential\[9\]
+ VSS VSS VDD VDD _08608_ sky130_fd_sc_hd__o21ai_0
X_12574_ network.neuron_hid6.IF0.membrane_potential\[9\] _08606_
+ _08607_ VSS VSS VDD VDD _08609_ sky130_fd_sc_hd__or3_1
X_12575_ _08608_ _08609_ _08599_ VSS VSS VDD VDD _01641_ sky130_fd_sc_hd__a21oi_1
X_12576_ _01054_ _00001_ _01053_ VSS VSS VDD VDD _08610_ sky130_fd_sc_hd__a21o_1
X_12577_ _00447_ _08610_ _00446_ VSS VSS VDD VDD _08611_ sky130_fd_sc_hd__a21oi_1
X_12578_ _08611_ VSS VSS VDD VDD _08612_ sky130_fd_sc_hd__inv_1
X_12579_ _00088_ _08612_ _00087_ VSS VSS VDD VDD _08613_ sky130_fd_sc_hd__a21oi_1
X_12580_ network.neuron_hid6.IF0.membrane_potential\[6\] network.neuron_hid6.IF0.membrane_potential\[5\]
+ VSS VSS VDD VDD _08614_ sky130_fd_sc_hd__nand2_1
X_12581_ _08613_ _08614_ network.neuron_hid6.IF0.membrane_potential\[7\]
+ VSS VSS VDD VDD _08615_ sky130_fd_sc_hd__nor3b_1
X_12582_ network.neuron_hid6.IF0.membrane_potential\[8\] _08615_
+ VSS VSS VDD VDD _08616_ sky130_fd_sc_hd__xnor2_1
X_12583_ _08599_ _08616_ VSS VSS VDD VDD _01642_ sky130_fd_sc_hd__nor2_1
X_12584_ _08606_ _08614_ network.neuron_hid6.IF0.membrane_potential\[7\]
+ VSS VSS VDD VDD _08617_ sky130_fd_sc_hd__o21ai_0
X_12585_ network.neuron_hid6.IF0.membrane_potential\[7\] _08606_
+ _08614_ VSS VSS VDD VDD _08618_ sky130_fd_sc_hd__or3_1
X_12586_ _08617_ _08618_ _08599_ VSS VSS VDD VDD _01643_ sky130_fd_sc_hd__a21oi_1
X_12587_ _08613_ network.neuron_hid6.IF0.membrane_potential\[5\]
+ VSS VSS VDD VDD _08619_ sky130_fd_sc_hd__nor2b_1
X_12588_ network.neuron_hid6.IF0.membrane_potential\[6\] _08619_
+ VSS VSS VDD VDD _08620_ sky130_fd_sc_hd__xnor2_1
X_12589_ _08599_ _08620_ VSS VSS VDD VDD _01644_ sky130_fd_sc_hd__nor2_1
X_12590_ network.neuron_hid6.IF0.membrane_potential\[5\] _08606_
+ VSS VSS VDD VDD _08621_ sky130_fd_sc_hd__xor2_1
X_12591_ _08599_ _08621_ VSS VSS VDD VDD _01645_ sky130_fd_sc_hd__nor2_1
X_12592_ _00088_ _08611_ VSS VSS VDD VDD _08622_ sky130_fd_sc_hd__xor2_1
X_12593_ _08599_ _08622_ VSS VSS VDD VDD _01646_ sky130_fd_sc_hd__nor2_1
X_12594_ _00447_ _08604_ VSS VSS VDD VDD _08623_ sky130_fd_sc_hd__xnor2_1
X_12595_ _08599_ _08623_ VSS VSS VDD VDD _01647_ sky130_fd_sc_hd__nor2_1
X_12596_ _01054_ _00001_ VSS VSS VDD VDD _08624_ sky130_fd_sc_hd__xnor2_1
X_12597_ _08599_ _08624_ VSS VSS VDD VDD _01648_ sky130_fd_sc_hd__nor2_1
X_12598_ network.neuron_hid6.IF0.add_out\[1\] net402 net298
+ VSS VSS VDD VDD _01649_ sky130_fd_sc_hd__and3_1
X_12599_ network.neuron_hid6.IF0.add_out\[0\] net402 net298
+ VSS VSS VDD VDD _01650_ sky130_fd_sc_hd__and3_1
X_12600_ network.neuron_hid5.IF0.membrane_potential\[5\] network.neuron_hid5.IF0.membrane_potential\[2\]
+ network.neuron_hid5.IF0.membrane_potential\[3\] network.neuron_hid5.IF0.membrane_potential\[1\]
+ VSS VSS VDD VDD _08625_ sky130_fd_sc_hd__or4_1
X_12601_ network.neuron_hid5.IF0.membrane_potential\[4\] network.neuron_hid5.IF0.membrane_potential\[0\]
+ _08625_ network.neuron_hid5.IF0.membrane_potential\[6\] VSS
+ VSS VDD VDD _08626_ sky130_fd_sc_hd__o31a_1
X_12602_ network.neuron_hid5.IF0.membrane_potential\[7\] _08626_
+ network.neuron_hid5.IF0.membrane_potential\[8\] VSS VSS VDD
+ VDD _08627_ sky130_fd_sc_hd__o21a_1
X_12603_ network.neuron_hid5.IF0.membrane_potential\[9\] network.neuron_hid5.IF0.membrane_potential\[10\]
+ _08627_ _01145_ VSS VSS VDD VDD _08628_ sky130_fd_sc_hd__o31ai_1
X_12604_ net402 _08628_ VSS VSS VDD VDD _08629_ sky130_fd_sc_hd__nand2_1
Xplace342 _07287_ VSS VSS VDD VDD net341 sky130_fd_sc_hd__buf_4
X_12606_ _01145_ net293 VSS VSS VDD VDD _08631_ sky130_fd_sc_hd__nor2_1
X_12607_ network.neuron_hid5.IF0.ref_counter\[0\] _08631_
+ VSS VSS VDD VDD _08632_ sky130_fd_sc_hd__xnor2_1
X_12608_ _08629_ _08632_ VSS VSS VDD VDD _01651_ sky130_fd_sc_hd__nor2_1
X_12609_ _00023_ _00534_ _00533_ VSS VSS VDD VDD _08633_ sky130_fd_sc_hd__a21o_1
X_12610_ _00856_ _08633_ _00855_ VSS VSS VDD VDD _08634_ sky130_fd_sc_hd__a21o_1
X_12611_ _01101_ _08634_ _01100_ VSS VSS VDD VDD _08635_ sky130_fd_sc_hd__a21o_1
X_12612_ _00854_ _08635_ _00853_ VSS VSS VDD VDD _08636_ sky130_fd_sc_hd__a21oi_1
X_12613_ network.neuron_hid5.IF0.membrane_potential\[5\] network.neuron_hid5.IF0.membrane_potential\[7\]
+ network.neuron_hid5.IF0.membrane_potential\[6\] network.neuron_hid5.IF0.membrane_potential\[8\]
+ VSS VSS VDD VDD _08637_ sky130_fd_sc_hd__nand4_1
X_12614_ _08636_ _08637_ network.neuron_hid5.IF0.membrane_potential\[9\]
+ VSS VSS VDD VDD _08638_ sky130_fd_sc_hd__o21ai_0
X_12615_ network.neuron_hid5.IF0.membrane_potential\[9\] _08636_
+ _08637_ VSS VSS VDD VDD _08639_ sky130_fd_sc_hd__or3_1
X_12616_ _08638_ _08639_ _08629_ VSS VSS VDD VDD _01652_ sky130_fd_sc_hd__a21oi_1
X_12617_ _00856_ _00024_ _00855_ VSS VSS VDD VDD _08640_ sky130_fd_sc_hd__a21o_1
X_12618_ _01101_ _08640_ _01100_ VSS VSS VDD VDD _08641_ sky130_fd_sc_hd__a21oi_1
X_12619_ _08641_ VSS VSS VDD VDD _08642_ sky130_fd_sc_hd__inv_1
X_12620_ _00854_ _08642_ _00853_ VSS VSS VDD VDD _08643_ sky130_fd_sc_hd__a21oi_1
X_12621_ network.neuron_hid5.IF0.membrane_potential\[5\] network.neuron_hid5.IF0.membrane_potential\[6\]
+ VSS VSS VDD VDD _08644_ sky130_fd_sc_hd__nand2_1
X_12622_ _08643_ _08644_ network.neuron_hid5.IF0.membrane_potential\[7\]
+ VSS VSS VDD VDD _08645_ sky130_fd_sc_hd__nor3b_1
X_12623_ network.neuron_hid5.IF0.membrane_potential\[8\] _08645_
+ VSS VSS VDD VDD _08646_ sky130_fd_sc_hd__xnor2_1
X_12624_ _08629_ _08646_ VSS VSS VDD VDD _01653_ sky130_fd_sc_hd__nor2_1
X_12625_ _08636_ _08644_ network.neuron_hid5.IF0.membrane_potential\[7\]
+ VSS VSS VDD VDD _08647_ sky130_fd_sc_hd__o21ai_0
X_12626_ network.neuron_hid5.IF0.membrane_potential\[7\] _08636_
+ _08644_ VSS VSS VDD VDD _08648_ sky130_fd_sc_hd__or3_1
X_12627_ _08647_ _08648_ _08629_ VSS VSS VDD VDD _01654_ sky130_fd_sc_hd__a21oi_1
X_12628_ _08643_ network.neuron_hid5.IF0.membrane_potential\[5\]
+ VSS VSS VDD VDD _08649_ sky130_fd_sc_hd__nor2b_1
X_12629_ network.neuron_hid5.IF0.membrane_potential\[6\] _08649_
+ VSS VSS VDD VDD _08650_ sky130_fd_sc_hd__xnor2_1
X_12630_ _08629_ _08650_ VSS VSS VDD VDD _01655_ sky130_fd_sc_hd__nor2_1
X_12631_ network.neuron_hid5.IF0.membrane_potential\[5\] _08636_
+ VSS VSS VDD VDD _08651_ sky130_fd_sc_hd__xor2_1
X_12632_ _08629_ _08651_ VSS VSS VDD VDD _01656_ sky130_fd_sc_hd__nor2_1
X_12633_ _00854_ _08641_ VSS VSS VDD VDD _08652_ sky130_fd_sc_hd__xor2_1
X_12634_ _08629_ _08652_ VSS VSS VDD VDD _01657_ sky130_fd_sc_hd__nor2_1
X_12635_ _01101_ _08634_ VSS VSS VDD VDD _08653_ sky130_fd_sc_hd__xnor2_1
X_12636_ _08629_ _08653_ VSS VSS VDD VDD _01658_ sky130_fd_sc_hd__nor2_1
X_12637_ _00856_ _00024_ VSS VSS VDD VDD _08654_ sky130_fd_sc_hd__xnor2_1
X_12638_ _08629_ _08654_ VSS VSS VDD VDD _01659_ sky130_fd_sc_hd__nor2_1
X_12639_ network.neuron_hid5.IF0.add_out\[1\] net402 _08628_
+ VSS VSS VDD VDD _01660_ sky130_fd_sc_hd__and3_1
X_12640_ network.neuron_hid5.IF0.add_out\[0\] net402 _08628_
+ VSS VSS VDD VDD _01661_ sky130_fd_sc_hd__and3_1
X_12641_ network.neuron_hid4.IF0.membrane_potential\[5\] network.neuron_hid4.IF0.membrane_potential\[4\]
+ network.neuron_hid4.IF0.membrane_potential\[2\] network.neuron_hid4.IF0.membrane_potential\[3\]
+ VSS VSS VDD VDD _08655_ sky130_fd_sc_hd__or4_1
X_12642_ network.neuron_hid4.IF0.membrane_potential\[0\] network.neuron_hid4.IF0.membrane_potential\[1\]
+ _08655_ network.neuron_hid4.IF0.membrane_potential\[6\] VSS
+ VSS VDD VDD _08656_ sky130_fd_sc_hd__o31a_1
X_12643_ network.neuron_hid4.IF0.membrane_potential\[7\] _08656_
+ network.neuron_hid4.IF0.membrane_potential\[8\] VSS VSS VDD
+ VDD _08657_ sky130_fd_sc_hd__o21a_1
X_12644_ network.neuron_hid4.IF0.membrane_potential\[9\] network.neuron_hid4.IF0.membrane_potential\[10\]
+ _08657_ _00708_ VSS VSS VDD VDD _08658_ sky130_fd_sc_hd__o31ai_1
X_12645_ net402 _08658_ VSS VSS VDD VDD _08659_ sky130_fd_sc_hd__nand2_1
Xplace341 _07297_ VSS VSS VDD VDD net340 sky130_fd_sc_hd__buf_4
X_12647_ _00708_ net293 VSS VSS VDD VDD _08661_ sky130_fd_sc_hd__nor2_1
X_12648_ network.neuron_hid4.IF0.ref_counter\[0\] _08661_
+ VSS VSS VDD VDD _08662_ sky130_fd_sc_hd__xnor2_1
X_12649_ _08659_ _08662_ VSS VSS VDD VDD _01662_ sky130_fd_sc_hd__nor2_1
X_12650_ _00019_ _00717_ _00716_ VSS VSS VDD VDD _08663_ sky130_fd_sc_hd__a21o_1
X_12651_ _01142_ _08663_ _01141_ VSS VSS VDD VDD _08664_ sky130_fd_sc_hd__a21o_1
X_12652_ _00761_ _08664_ _00760_ VSS VSS VDD VDD _08665_ sky130_fd_sc_hd__a21o_1
X_12653_ _00245_ _08665_ _00244_ VSS VSS VDD VDD _08666_ sky130_fd_sc_hd__a21oi_1
X_12654_ network.neuron_hid4.IF0.membrane_potential\[5\] network.neuron_hid4.IF0.membrane_potential\[6\]
+ network.neuron_hid4.IF0.membrane_potential\[8\] network.neuron_hid4.IF0.membrane_potential\[7\]
+ VSS VSS VDD VDD _08667_ sky130_fd_sc_hd__nand4_1
X_12655_ _08666_ _08667_ network.neuron_hid4.IF0.membrane_potential\[9\]
+ VSS VSS VDD VDD _08668_ sky130_fd_sc_hd__o21ai_0
X_12656_ network.neuron_hid4.IF0.membrane_potential\[9\] _08666_
+ _08667_ VSS VSS VDD VDD _08669_ sky130_fd_sc_hd__or3_1
X_12657_ _08668_ _08669_ _08659_ VSS VSS VDD VDD _01663_ sky130_fd_sc_hd__a21oi_1
X_12658_ _00020_ _01142_ _01141_ VSS VSS VDD VDD _08670_ sky130_fd_sc_hd__a21o_1
X_12659_ _00761_ _08670_ _00760_ VSS VSS VDD VDD _08671_ sky130_fd_sc_hd__a21oi_1
X_12660_ _08671_ VSS VSS VDD VDD _08672_ sky130_fd_sc_hd__inv_1
X_12661_ _00245_ _08672_ _00244_ VSS VSS VDD VDD _08673_ sky130_fd_sc_hd__a21oi_1
X_12662_ network.neuron_hid4.IF0.membrane_potential\[5\] network.neuron_hid4.IF0.membrane_potential\[6\]
+ VSS VSS VDD VDD _08674_ sky130_fd_sc_hd__nand2_1
X_12663_ _08673_ _08674_ network.neuron_hid4.IF0.membrane_potential\[7\]
+ VSS VSS VDD VDD _08675_ sky130_fd_sc_hd__nor3b_1
X_12664_ network.neuron_hid4.IF0.membrane_potential\[8\] _08675_
+ VSS VSS VDD VDD _08676_ sky130_fd_sc_hd__xnor2_1
X_12665_ _08659_ _08676_ VSS VSS VDD VDD _01664_ sky130_fd_sc_hd__nor2_1
X_12666_ _08666_ _08674_ network.neuron_hid4.IF0.membrane_potential\[7\]
+ VSS VSS VDD VDD _08677_ sky130_fd_sc_hd__o21ai_0
X_12667_ network.neuron_hid4.IF0.membrane_potential\[7\] _08666_
+ _08674_ VSS VSS VDD VDD _08678_ sky130_fd_sc_hd__or3_1
X_12668_ _08677_ _08678_ _08659_ VSS VSS VDD VDD _01665_ sky130_fd_sc_hd__a21oi_1
X_12669_ _08673_ network.neuron_hid4.IF0.membrane_potential\[5\]
+ VSS VSS VDD VDD _08679_ sky130_fd_sc_hd__nor2b_1
X_12670_ network.neuron_hid4.IF0.membrane_potential\[6\] _08679_
+ VSS VSS VDD VDD _08680_ sky130_fd_sc_hd__xnor2_1
X_12671_ _08659_ _08680_ VSS VSS VDD VDD _01666_ sky130_fd_sc_hd__nor2_1
X_12672_ network.neuron_hid4.IF0.membrane_potential\[5\] _08666_
+ VSS VSS VDD VDD _08681_ sky130_fd_sc_hd__xor2_1
X_12673_ _08659_ _08681_ VSS VSS VDD VDD _01667_ sky130_fd_sc_hd__nor2_1
X_12674_ _00245_ _08671_ VSS VSS VDD VDD _08682_ sky130_fd_sc_hd__xor2_1
X_12675_ _08659_ _08682_ VSS VSS VDD VDD _01668_ sky130_fd_sc_hd__nor2_1
X_12676_ _00761_ _08664_ VSS VSS VDD VDD _08683_ sky130_fd_sc_hd__xnor2_1
X_12677_ _08659_ _08683_ VSS VSS VDD VDD _01669_ sky130_fd_sc_hd__nor2_1
X_12678_ _00020_ _01142_ VSS VSS VDD VDD _08684_ sky130_fd_sc_hd__xnor2_1
X_12679_ _08659_ _08684_ VSS VSS VDD VDD _01670_ sky130_fd_sc_hd__nor2_1
X_12680_ network.neuron_hid4.IF0.add_out\[1\] net402 _08658_
+ VSS VSS VDD VDD _01671_ sky130_fd_sc_hd__and3_1
X_12681_ network.neuron_hid4.IF0.add_out\[0\] net402 _08658_
+ VSS VSS VDD VDD _01672_ sky130_fd_sc_hd__and3_1
X_12682_ network.neuron_hid3.IF0.membrane_potential\[3\] network.neuron_hid3.IF0.membrane_potential\[4\]
+ network.neuron_hid3.IF0.membrane_potential\[5\] network.neuron_hid3.IF0.membrane_potential\[0\]
+ VSS VSS VDD VDD _08685_ sky130_fd_sc_hd__or4_1
X_12683_ network.neuron_hid3.IF0.membrane_potential\[1\] network.neuron_hid3.IF0.membrane_potential\[2\]
+ _08685_ network.neuron_hid3.IF0.membrane_potential\[6\] VSS
+ VSS VDD VDD _08686_ sky130_fd_sc_hd__o31a_1
X_12684_ network.neuron_hid3.IF0.membrane_potential\[7\] _08686_
+ network.neuron_hid3.IF0.membrane_potential\[8\] VSS VSS VDD
+ VDD _08687_ sky130_fd_sc_hd__o21a_1
X_12685_ network.neuron_hid3.IF0.membrane_potential\[9\] network.neuron_hid3.IF0.membrane_potential\[10\]
+ _08687_ _01029_ VSS VSS VDD VDD _08688_ sky130_fd_sc_hd__o31ai_1
X_12686_ net402 _08688_ VSS VSS VDD VDD _08689_ sky130_fd_sc_hd__nand2_1
Xplace340 _07310_ VSS VSS VDD VDD net339 sky130_fd_sc_hd__buf_4
X_12688_ _01029_ net293 VSS VSS VDD VDD _08691_ sky130_fd_sc_hd__nor2_1
X_12689_ network.neuron_hid3.IF0.ref_counter\[0\] _08691_
+ VSS VSS VDD VDD _08692_ sky130_fd_sc_hd__xnor2_1
X_12690_ _08689_ _08692_ VSS VSS VDD VDD _01673_ sky130_fd_sc_hd__nor2_1
X_12691_ _00701_ VSS VSS VDD VDD _08693_ sky130_fd_sc_hd__inv_1
X_12692_ _01038_ VSS VSS VDD VDD _08694_ sky130_fd_sc_hd__inv_1
X_12693_ _00002_ _00095_ _00385_ VSS VSS VDD VDD _08695_ sky130_fd_sc_hd__a21o_1
X_12694_ _00199_ _08695_ _00198_ VSS VSS VDD VDD _08696_ sky130_fd_sc_hd__a21oi_1
X_12695_ _08694_ _08696_ _01037_ VSS VSS VDD VDD _08697_ sky130_fd_sc_hd__o21bai_1
X_12696_ _01044_ _08697_ _01043_ VSS VSS VDD VDD _08698_ sky130_fd_sc_hd__a21oi_1
X_12697_ _08693_ _08698_ _00700_ VSS VSS VDD VDD _08699_ sky130_fd_sc_hd__o21bai_1
X_12698_ network.neuron_hid3.IF0.membrane_potential\[8\] _01207_
+ VSS VSS VDD VDD _08700_ sky130_fd_sc_hd__nand2_1
X_12699_ network.neuron_hid3.IF0.membrane_potential\[8\] _01031_
+ _01208_ VSS VSS VDD VDD _08701_ sky130_fd_sc_hd__nand3_1
X_12700_ _08700_ _08701_ VSS VSS VDD VDD _08702_ sky130_fd_sc_hd__nand2_1
X_12701_ network.neuron_hid3.IF0.membrane_potential\[8\] _01032_
+ _01208_ _08699_ _08702_ VSS VSS VDD VDD _08703_ sky130_fd_sc_hd__a41oi_1
X_12702_ network.neuron_hid3.IF0.membrane_potential\[9\] _08703_
+ VSS VSS VDD VDD _08704_ sky130_fd_sc_hd__xor2_1
X_12703_ _08689_ _08704_ VSS VSS VDD VDD _01674_ sky130_fd_sc_hd__nor2_1
X_12704_ _01044_ VSS VSS VDD VDD _08705_ sky130_fd_sc_hd__inv_1
X_12705_ _00003_ _00199_ _00198_ VSS VSS VDD VDD _08706_ sky130_fd_sc_hd__a21o_1
X_12706_ _01038_ _08706_ _01037_ VSS VSS VDD VDD _08707_ sky130_fd_sc_hd__a21oi_1
X_12707_ _08705_ _08707_ _01043_ VSS VSS VDD VDD _08708_ sky130_fd_sc_hd__o21bai_1
X_12708_ _00701_ _08708_ _00700_ VSS VSS VDD VDD _08709_ sky130_fd_sc_hd__a21oi_1
X_12709_ _01032_ _01208_ VSS VSS VDD VDD _08710_ sky130_fd_sc_hd__nand2_1
X_12710_ _01031_ _01208_ _01207_ VSS VSS VDD VDD _08711_ sky130_fd_sc_hd__a21oi_1
X_12711_ _08709_ _08710_ _08711_ VSS VSS VDD VDD _08712_ sky130_fd_sc_hd__o21ai_0
X_12712_ network.neuron_hid3.IF0.membrane_potential\[8\] _08712_
+ VSS VSS VDD VDD _08713_ sky130_fd_sc_hd__xnor2_1
X_12713_ _08689_ _08713_ VSS VSS VDD VDD _01675_ sky130_fd_sc_hd__nor2_1
X_12714_ _01032_ _08699_ _01031_ VSS VSS VDD VDD _08714_ sky130_fd_sc_hd__a21oi_1
X_12715_ _01208_ _08714_ VSS VSS VDD VDD _08715_ sky130_fd_sc_hd__xor2_1
X_12716_ _08689_ _08715_ VSS VSS VDD VDD _01676_ sky130_fd_sc_hd__nor2_1
X_12717_ _01032_ _08709_ VSS VSS VDD VDD _08716_ sky130_fd_sc_hd__xor2_1
X_12718_ _08689_ _08716_ VSS VSS VDD VDD _01677_ sky130_fd_sc_hd__nor2_1
X_12719_ _08693_ _08698_ VSS VSS VDD VDD _08717_ sky130_fd_sc_hd__xnor2_1
X_12720_ _08689_ _08717_ VSS VSS VDD VDD _01678_ sky130_fd_sc_hd__nor2_1
X_12721_ _08705_ _08707_ VSS VSS VDD VDD _08718_ sky130_fd_sc_hd__xnor2_1
X_12722_ _08689_ _08718_ VSS VSS VDD VDD _01679_ sky130_fd_sc_hd__nor2_1
X_12723_ _08694_ _08696_ VSS VSS VDD VDD _08719_ sky130_fd_sc_hd__xnor2_1
X_12724_ _08689_ _08719_ VSS VSS VDD VDD _01680_ sky130_fd_sc_hd__nor2_1
X_12725_ _00003_ _00199_ VSS VSS VDD VDD _08720_ sky130_fd_sc_hd__xnor2_1
X_12726_ _08689_ _08720_ VSS VSS VDD VDD _01681_ sky130_fd_sc_hd__nor2_1
X_12727_ network.neuron_hid3.IF0.add_out\[1\] net402 _08688_
+ VSS VSS VDD VDD _01682_ sky130_fd_sc_hd__and3_1
X_12728_ network.neuron_hid3.IF0.add_out\[0\] net402 _08688_
+ VSS VSS VDD VDD _01683_ sky130_fd_sc_hd__and3_1
X_12729_ network.neuron_hid2.IF0.membrane_potential\[1\] network.neuron_hid2.IF0.membrane_potential\[4\]
+ network.neuron_hid2.IF0.membrane_potential\[5\] network.neuron_hid2.IF0.membrane_potential\[0\]
+ VSS VSS VDD VDD _08721_ sky130_fd_sc_hd__or4_1
X_12730_ network.neuron_hid2.IF0.membrane_potential\[2\] network.neuron_hid2.IF0.membrane_potential\[3\]
+ _08721_ network.neuron_hid2.IF0.membrane_potential\[6\] VSS
+ VSS VDD VDD _08722_ sky130_fd_sc_hd__o31a_1
X_12731_ network.neuron_hid2.IF0.membrane_potential\[7\] _08722_
+ network.neuron_hid2.IF0.membrane_potential\[8\] VSS VSS VDD
+ VDD _08723_ sky130_fd_sc_hd__o21a_1
X_12732_ network.neuron_hid2.IF0.membrane_potential\[9\] network.neuron_hid2.IF0.membrane_potential\[10\]
+ _08723_ _01020_ VSS VSS VDD VDD _08724_ sky130_fd_sc_hd__o31ai_1
X_12733_ net402 _08724_ VSS VSS VDD VDD _08725_ sky130_fd_sc_hd__nand2_1
Xplace339 _07350_ VSS VSS VDD VDD net338 sky130_fd_sc_hd__buf_4
X_12735_ _01020_ net293 VSS VSS VDD VDD _08727_ sky130_fd_sc_hd__nor2_1
X_12736_ network.neuron_hid2.IF0.ref_counter\[0\] _08727_
+ VSS VSS VDD VDD _08728_ sky130_fd_sc_hd__xnor2_1
X_12737_ _08725_ _08728_ VSS VSS VDD VDD _01684_ sky130_fd_sc_hd__nor2_1
X_12738_ _00769_ VSS VSS VDD VDD _08729_ sky130_fd_sc_hd__inv_1
X_12739_ _01099_ VSS VSS VDD VDD _08730_ sky130_fd_sc_hd__inv_1
X_12740_ _00021_ _01095_ _01244_ VSS VSS VDD VDD _08731_ sky130_fd_sc_hd__a21o_1
X_12741_ _00881_ _08731_ _00880_ VSS VSS VDD VDD _08732_ sky130_fd_sc_hd__a21oi_1
X_12742_ _08730_ _08732_ _01098_ VSS VSS VDD VDD _08733_ sky130_fd_sc_hd__o21bai_1
X_12743_ _00879_ _08733_ _00878_ VSS VSS VDD VDD _08734_ sky130_fd_sc_hd__a21oi_1
X_12744_ _08729_ _08734_ _00768_ VSS VSS VDD VDD _08735_ sky130_fd_sc_hd__o21bai_1
X_12745_ network.neuron_hid2.IF0.membrane_potential\[8\] _00696_
+ VSS VSS VDD VDD _08736_ sky130_fd_sc_hd__nand2_1
X_12746_ network.neuron_hid2.IF0.membrane_potential\[8\] _00697_
+ _00694_ VSS VSS VDD VDD _08737_ sky130_fd_sc_hd__nand3_1
X_12747_ _08736_ _08737_ VSS VSS VDD VDD _08738_ sky130_fd_sc_hd__nand2_1
X_12748_ network.neuron_hid2.IF0.membrane_potential\[8\] _00697_
+ _00695_ _08735_ _08738_ VSS VSS VDD VDD _08739_ sky130_fd_sc_hd__a41oi_1
X_12749_ network.neuron_hid2.IF0.membrane_potential\[9\] _08739_
+ VSS VSS VDD VDD _08740_ sky130_fd_sc_hd__xor2_1
X_12750_ _08725_ _08740_ VSS VSS VDD VDD _01685_ sky130_fd_sc_hd__nor2_1
X_12751_ _00879_ VSS VSS VDD VDD _08741_ sky130_fd_sc_hd__inv_1
X_12752_ _00881_ _00022_ _00880_ VSS VSS VDD VDD _08742_ sky130_fd_sc_hd__a21o_1
X_12753_ _01099_ _08742_ _01098_ VSS VSS VDD VDD _08743_ sky130_fd_sc_hd__a21oi_1
X_12754_ _08741_ _08743_ _00878_ VSS VSS VDD VDD _08744_ sky130_fd_sc_hd__o21bai_1
X_12755_ _00769_ _08744_ _00768_ VSS VSS VDD VDD _08745_ sky130_fd_sc_hd__a21oi_1
X_12756_ _00697_ _00695_ VSS VSS VDD VDD _08746_ sky130_fd_sc_hd__nand2_1
X_12757_ _00697_ _00694_ _00696_ VSS VSS VDD VDD _08747_ sky130_fd_sc_hd__a21oi_1
X_12758_ _08745_ _08746_ _08747_ VSS VSS VDD VDD _08748_ sky130_fd_sc_hd__o21ai_0
X_12759_ network.neuron_hid2.IF0.membrane_potential\[8\] _08748_
+ VSS VSS VDD VDD _08749_ sky130_fd_sc_hd__xnor2_1
X_12760_ _08725_ _08749_ VSS VSS VDD VDD _01686_ sky130_fd_sc_hd__nor2_1
X_12761_ _00695_ _08735_ _00694_ VSS VSS VDD VDD _08750_ sky130_fd_sc_hd__a21oi_1
X_12762_ _00697_ _08750_ VSS VSS VDD VDD _08751_ sky130_fd_sc_hd__xor2_1
X_12763_ _08725_ _08751_ VSS VSS VDD VDD _01687_ sky130_fd_sc_hd__nor2_1
X_12764_ _00695_ _08745_ VSS VSS VDD VDD _08752_ sky130_fd_sc_hd__xor2_1
X_12765_ _08725_ _08752_ VSS VSS VDD VDD _01688_ sky130_fd_sc_hd__nor2_1
X_12766_ _08729_ _08734_ VSS VSS VDD VDD _08753_ sky130_fd_sc_hd__xnor2_1
X_12767_ _08725_ _08753_ VSS VSS VDD VDD _01689_ sky130_fd_sc_hd__nor2_1
X_12768_ _08741_ _08743_ VSS VSS VDD VDD _08754_ sky130_fd_sc_hd__xnor2_1
X_12769_ _08725_ _08754_ VSS VSS VDD VDD _01690_ sky130_fd_sc_hd__nor2_1
X_12770_ _08730_ _08732_ VSS VSS VDD VDD _08755_ sky130_fd_sc_hd__xnor2_1
X_12771_ _08725_ _08755_ VSS VSS VDD VDD _01691_ sky130_fd_sc_hd__nor2_1
X_12772_ _00881_ _00022_ VSS VSS VDD VDD _08756_ sky130_fd_sc_hd__xnor2_1
X_12773_ _08725_ _08756_ VSS VSS VDD VDD _01692_ sky130_fd_sc_hd__nor2_1
X_12774_ network.neuron_hid2.IF0.add_out\[1\] net402 _08724_
+ VSS VSS VDD VDD _01693_ sky130_fd_sc_hd__and3_1
X_12775_ network.neuron_hid2.IF0.add_out\[0\] net402 _08724_
+ VSS VSS VDD VDD _01694_ sky130_fd_sc_hd__and3_1
X_12776_ network.neuron_hid1.IF0.membrane_potential\[5\] network.neuron_hid1.IF0.membrane_potential\[0\]
+ network.neuron_hid1.IF0.membrane_potential\[3\] network.neuron_hid1.IF0.membrane_potential\[2\]
+ VSS VSS VDD VDD _08757_ sky130_fd_sc_hd__or4_1
X_12777_ network.neuron_hid1.IF0.membrane_potential\[4\] network.neuron_hid1.IF0.membrane_potential\[1\]
+ _08757_ network.neuron_hid1.IF0.membrane_potential\[6\] VSS
+ VSS VDD VDD _08758_ sky130_fd_sc_hd__o31a_1
X_12778_ network.neuron_hid1.IF0.membrane_potential\[7\] _08758_
+ network.neuron_hid1.IF0.membrane_potential\[8\] VSS VSS VDD
+ VDD _08759_ sky130_fd_sc_hd__o21a_1
X_12779_ network.neuron_hid1.IF0.membrane_potential\[9\] network.neuron_hid1.IF0.membrane_potential\[10\]
+ _08759_ _00712_ VSS VSS VDD VDD _08760_ sky130_fd_sc_hd__o31ai_2
X_12780_ net402 _08760_ VSS VSS VDD VDD _08761_ sky130_fd_sc_hd__nand2_1
Xplace338 _07362_ VSS VSS VDD VDD net337 sky130_fd_sc_hd__buf_4
X_12782_ _00712_ net293 VSS VSS VDD VDD _08763_ sky130_fd_sc_hd__nor2_1
X_12783_ network.neuron_hid1.IF0.ref_counter\[0\] _08763_
+ VSS VSS VDD VDD _08764_ sky130_fd_sc_hd__xnor2_1
X_12784_ _08761_ _08764_ VSS VSS VDD VDD _01695_ sky130_fd_sc_hd__nor2_1
X_12785_ _00009_ _00077_ _00076_ VSS VSS VDD VDD _08765_ sky130_fd_sc_hd__a21o_1
X_12786_ _00067_ _08765_ _00066_ VSS VSS VDD VDD _08766_ sky130_fd_sc_hd__a21o_1
X_12787_ _00699_ _08766_ _00698_ VSS VSS VDD VDD _08767_ sky130_fd_sc_hd__a21o_1
X_12788_ _00883_ _08767_ _00882_ VSS VSS VDD VDD _08768_ sky130_fd_sc_hd__a21oi_1
X_12789_ network.neuron_hid1.IF0.membrane_potential\[6\] network.neuron_hid1.IF0.membrane_potential\[5\]
+ network.neuron_hid1.IF0.membrane_potential\[8\] network.neuron_hid1.IF0.membrane_potential\[7\]
+ VSS VSS VDD VDD _08769_ sky130_fd_sc_hd__nand4_1
X_12790_ _08768_ _08769_ network.neuron_hid1.IF0.membrane_potential\[9\]
+ VSS VSS VDD VDD _08770_ sky130_fd_sc_hd__o21ai_0
X_12791_ network.neuron_hid1.IF0.membrane_potential\[9\] _08768_
+ _08769_ VSS VSS VDD VDD _08771_ sky130_fd_sc_hd__or3_1
X_12792_ _08770_ _08771_ _08761_ VSS VSS VDD VDD _01696_ sky130_fd_sc_hd__a21oi_1
X_12793_ _00067_ _00010_ _00066_ VSS VSS VDD VDD _08772_ sky130_fd_sc_hd__a21o_1
X_12794_ _00699_ _08772_ _00698_ VSS VSS VDD VDD _08773_ sky130_fd_sc_hd__a21oi_1
X_12795_ _08773_ VSS VSS VDD VDD _08774_ sky130_fd_sc_hd__inv_1
X_12796_ _00883_ _08774_ _00882_ VSS VSS VDD VDD _08775_ sky130_fd_sc_hd__a21oi_1
X_12797_ network.neuron_hid1.IF0.membrane_potential\[6\] network.neuron_hid1.IF0.membrane_potential\[5\]
+ VSS VSS VDD VDD _08776_ sky130_fd_sc_hd__nand2_1
X_12798_ _08775_ _08776_ network.neuron_hid1.IF0.membrane_potential\[7\]
+ VSS VSS VDD VDD _08777_ sky130_fd_sc_hd__nor3b_1
X_12799_ network.neuron_hid1.IF0.membrane_potential\[8\] _08777_
+ VSS VSS VDD VDD _08778_ sky130_fd_sc_hd__xnor2_1
X_12800_ _08761_ _08778_ VSS VSS VDD VDD _01697_ sky130_fd_sc_hd__nor2_1
X_12801_ _08768_ _08776_ network.neuron_hid1.IF0.membrane_potential\[7\]
+ VSS VSS VDD VDD _08779_ sky130_fd_sc_hd__o21ai_0
X_12802_ network.neuron_hid1.IF0.membrane_potential\[7\] _08768_
+ _08776_ VSS VSS VDD VDD _08780_ sky130_fd_sc_hd__or3_1
X_12803_ _08779_ _08780_ _08761_ VSS VSS VDD VDD _01698_ sky130_fd_sc_hd__a21oi_1
X_12804_ _08775_ network.neuron_hid1.IF0.membrane_potential\[5\]
+ VSS VSS VDD VDD _08781_ sky130_fd_sc_hd__nor2b_1
X_12805_ network.neuron_hid1.IF0.membrane_potential\[6\] _08781_
+ VSS VSS VDD VDD _08782_ sky130_fd_sc_hd__xnor2_1
X_12806_ _08761_ _08782_ VSS VSS VDD VDD _01699_ sky130_fd_sc_hd__nor2_1
X_12807_ network.neuron_hid1.IF0.membrane_potential\[5\] _08768_
+ VSS VSS VDD VDD _08783_ sky130_fd_sc_hd__xor2_1
X_12808_ _08761_ _08783_ VSS VSS VDD VDD _01700_ sky130_fd_sc_hd__nor2_1
X_12809_ _00883_ _08773_ VSS VSS VDD VDD _08784_ sky130_fd_sc_hd__xor2_1
X_12810_ _08761_ _08784_ VSS VSS VDD VDD _01701_ sky130_fd_sc_hd__nor2_1
X_12811_ _00699_ _08766_ VSS VSS VDD VDD _08785_ sky130_fd_sc_hd__xnor2_1
X_12812_ _08761_ _08785_ VSS VSS VDD VDD _01702_ sky130_fd_sc_hd__nor2_1
X_12813_ _00067_ _00010_ VSS VSS VDD VDD _08786_ sky130_fd_sc_hd__xnor2_1
X_12814_ _08761_ _08786_ VSS VSS VDD VDD _01703_ sky130_fd_sc_hd__nor2_1
X_12815_ network.neuron_hid1.IF0.add_out\[1\] net402 _08760_
+ VSS VSS VDD VDD _01704_ sky130_fd_sc_hd__and3_1
X_12816_ network.neuron_hid1.IF0.add_out\[0\] net402 _08760_
+ VSS VSS VDD VDD _01705_ sky130_fd_sc_hd__and3_1
X_12817_ network.ctrl_addr\[6\] net403 VSS VSS VDD VDD _01706_
+ sky130_fd_sc_hd__and2_1
X_12818_ network.ctrl_addr\[5\] net403 VSS VSS VDD VDD _01707_
+ sky130_fd_sc_hd__and2_1
X_12819_ network.ctrl_addr\[4\] net403 VSS VSS VDD VDD _01708_
+ sky130_fd_sc_hd__and2_1
X_12820_ network.ctrl_addr\[3\] net406 VSS VSS VDD VDD _01709_
+ sky130_fd_sc_hd__and2_1
X_12821_ network.ctrl_addr\[2\] net406 VSS VSS VDD VDD _01710_
+ sky130_fd_sc_hd__and2_1
X_12822_ network.ctrl_addr\[1\] net403 VSS VSS VDD VDD _01711_
+ sky130_fd_sc_hd__and2_1
X_12823_ network.ctrl_addr\[0\] net403 VSS VSS VDD VDD _01712_
+ sky130_fd_sc_hd__and2_1
X_12824_ network.neuron_hid0.IF0.membrane_potential\[5\] network.neuron_hid0.IF0.membrane_potential\[1\]
+ network.neuron_hid0.IF0.membrane_potential\[0\] network.neuron_hid0.IF0.membrane_potential\[4\]
+ VSS VSS VDD VDD _08787_ sky130_fd_sc_hd__or4_1
X_12825_ network.neuron_hid0.IF0.membrane_potential\[2\] network.neuron_hid0.IF0.membrane_potential\[3\]
+ _08787_ network.neuron_hid0.IF0.membrane_potential\[6\] VSS
+ VSS VDD VDD _08788_ sky130_fd_sc_hd__o31a_1
X_12826_ network.neuron_hid0.IF0.membrane_potential\[7\] _08788_
+ network.neuron_hid0.IF0.membrane_potential\[8\] VSS VSS VDD
+ VDD _08789_ sky130_fd_sc_hd__o21a_1
X_12827_ network.neuron_hid0.IF0.membrane_potential\[10\]
+ network.neuron_hid0.IF0.membrane_potential\[9\] _08789_ _00912_
+ VSS VSS VDD VDD _08790_ sky130_fd_sc_hd__o31ai_2
X_12828_ net405 net297 VSS VSS VDD VDD _08791_ sky130_fd_sc_hd__nand2_1
Xplace337 _07369_ VSS VSS VDD VDD net336 sky130_fd_sc_hd__buf_4
X_12830_ _00912_ net293 VSS VSS VDD VDD _08793_ sky130_fd_sc_hd__nor2_1
X_12831_ network.neuron_hid0.IF0.ref_counter\[0\] _08793_
+ VSS VSS VDD VDD _08794_ sky130_fd_sc_hd__xnor2_1
X_12832_ _08791_ _08794_ VSS VSS VDD VDD _01713_ sky130_fd_sc_hd__nor2_1
X_12833_ _00017_ _00165_ _00164_ VSS VSS VDD VDD _08795_ sky130_fd_sc_hd__a21o_1
X_12834_ _00893_ _08795_ _00892_ VSS VSS VDD VDD _08796_ sky130_fd_sc_hd__a21o_1
X_12835_ _01097_ _08796_ _01096_ VSS VSS VDD VDD _08797_ sky130_fd_sc_hd__a21o_1
X_12836_ _00655_ _08797_ _00654_ VSS VSS VDD VDD _08798_ sky130_fd_sc_hd__a21oi_1
X_12837_ network.neuron_hid0.IF0.membrane_potential\[5\] network.neuron_hid0.IF0.membrane_potential\[8\]
+ network.neuron_hid0.IF0.membrane_potential\[7\] network.neuron_hid0.IF0.membrane_potential\[6\]
+ VSS VSS VDD VDD _08799_ sky130_fd_sc_hd__nand4_1
X_12838_ _08798_ _08799_ network.neuron_hid0.IF0.membrane_potential\[9\]
+ VSS VSS VDD VDD _08800_ sky130_fd_sc_hd__o21ai_0
X_12839_ network.neuron_hid0.IF0.membrane_potential\[9\] _08798_
+ _08799_ VSS VSS VDD VDD _08801_ sky130_fd_sc_hd__or3_1
X_12840_ _08800_ _08801_ _08791_ VSS VSS VDD VDD _01714_ sky130_fd_sc_hd__a21oi_1
X_12841_ _00018_ _00893_ _00892_ VSS VSS VDD VDD _08802_ sky130_fd_sc_hd__a21o_1
X_12842_ _01097_ _08802_ _01096_ VSS VSS VDD VDD _08803_ sky130_fd_sc_hd__a21oi_1
X_12843_ _08803_ VSS VSS VDD VDD _08804_ sky130_fd_sc_hd__inv_1
X_12844_ _00655_ _08804_ _00654_ VSS VSS VDD VDD _08805_ sky130_fd_sc_hd__a21oi_1
X_12845_ network.neuron_hid0.IF0.membrane_potential\[5\] network.neuron_hid0.IF0.membrane_potential\[6\]
+ VSS VSS VDD VDD _08806_ sky130_fd_sc_hd__nand2_1
X_12846_ _08805_ _08806_ network.neuron_hid0.IF0.membrane_potential\[7\]
+ VSS VSS VDD VDD _08807_ sky130_fd_sc_hd__nor3b_1
X_12847_ network.neuron_hid0.IF0.membrane_potential\[8\] _08807_
+ VSS VSS VDD VDD _08808_ sky130_fd_sc_hd__xnor2_1
X_12848_ _08791_ _08808_ VSS VSS VDD VDD _01715_ sky130_fd_sc_hd__nor2_1
X_12849_ _08798_ _08806_ network.neuron_hid0.IF0.membrane_potential\[7\]
+ VSS VSS VDD VDD _08809_ sky130_fd_sc_hd__o21ai_0
X_12850_ network.neuron_hid0.IF0.membrane_potential\[7\] _08798_
+ _08806_ VSS VSS VDD VDD _08810_ sky130_fd_sc_hd__or3_1
X_12851_ _08809_ _08810_ _08791_ VSS VSS VDD VDD _01716_ sky130_fd_sc_hd__a21oi_1
X_12852_ _08805_ network.neuron_hid0.IF0.membrane_potential\[5\]
+ VSS VSS VDD VDD _08811_ sky130_fd_sc_hd__nor2b_1
X_12853_ network.neuron_hid0.IF0.membrane_potential\[6\] _08811_
+ VSS VSS VDD VDD _08812_ sky130_fd_sc_hd__xnor2_1
X_12854_ _08791_ _08812_ VSS VSS VDD VDD _01717_ sky130_fd_sc_hd__nor2_1
X_12855_ network.neuron_hid0.IF0.membrane_potential\[5\] _08798_
+ VSS VSS VDD VDD _08813_ sky130_fd_sc_hd__xor2_1
X_12856_ _08791_ _08813_ VSS VSS VDD VDD _01718_ sky130_fd_sc_hd__nor2_1
X_12857_ _00655_ _08803_ VSS VSS VDD VDD _08814_ sky130_fd_sc_hd__xor2_1
X_12858_ _08791_ _08814_ VSS VSS VDD VDD _01719_ sky130_fd_sc_hd__nor2_1
X_12859_ _01097_ _08796_ VSS VSS VDD VDD _08815_ sky130_fd_sc_hd__xnor2_1
X_12860_ _08791_ _08815_ VSS VSS VDD VDD _01720_ sky130_fd_sc_hd__nor2_1
X_12861_ _00018_ _00893_ VSS VSS VDD VDD _08816_ sky130_fd_sc_hd__xnor2_1
X_12862_ _08791_ _08816_ VSS VSS VDD VDD _01721_ sky130_fd_sc_hd__nor2_1
X_12863_ network.neuron_hid0.IF0.add_out\[1\] net405 net297
+ VSS VSS VDD VDD _01722_ sky130_fd_sc_hd__and3_1
X_12864_ network.neuron_hid0.IF0.add_out\[0\] net405 net297
+ VSS VSS VDD VDD _01723_ sky130_fd_sc_hd__and3_1
Xplace336 _07585_ VSS VSS VDD VDD net335 sky130_fd_sc_hd__buf_4
X_12866_ network.in_spk11_14 network.in_spk10_14 network.in_spk09_14
+ network.in_spk08_14 VSS VSS VDD VDD _08818_ sky130_fd_sc_hd__or4_1
X_12867_ network.in_spk14_14 network.in_spk13_14 network.in_spk12_14
+ VSS VSS VDD VDD _08819_ sky130_fd_sc_hd__or3_1
X_12868_ network.in_spk15_14 _08818_ _08819_ VSS VSS VDD VDD
+ _08820_ sky130_fd_sc_hd__nor3_1
X_12869_ network.in_spk02_14 network.in_spk03_14 network.in_spk00_14
+ network.in_spk01_14 VSS VSS VDD VDD _08821_ sky130_fd_sc_hd__nor4_1
Xplace335 _07597_ VSS VSS VDD VDD net334 sky130_fd_sc_hd__buf_4
X_12871_ network.in_spk04_14 network.in_spk05_14 network.in_spk06_14
+ network.in_spk07_14 VSS VSS VDD VDD _08823_ sky130_fd_sc_hd__nor4_1
X_12872_ _08820_ _08821_ _08823_ VSS VSS VDD VDD _08824_ sky130_fd_sc_hd__and3_1
X_12873_ network.in_spk00_12 network.in_spk01_12 network.in_spk02_12
+ VSS VSS VDD VDD _08825_ sky130_fd_sc_hd__nor3_1
X_12874_ network.in_spk03_12 network.in_spk04_12 network.in_spk05_12
+ VSS VSS VDD VDD _08826_ sky130_fd_sc_hd__nor3_1
X_12875_ network.in_spk06_12 network.in_spk07_12 VSS VSS VDD
+ VDD _08827_ sky130_fd_sc_hd__nor2_1
X_12876_ network.in_spk08_12 network.in_spk09_12 network.in_spk10_12
+ VSS VSS VDD VDD _08828_ sky130_fd_sc_hd__nor3_1
X_12877_ _08825_ _08826_ _08827_ _08828_ VSS VSS VDD VDD _08829_
+ sky130_fd_sc_hd__nand4_1
X_12878_ network.in_spk11_12 network.in_spk12_12 network.in_spk13_12
+ VSS VSS VDD VDD _08830_ sky130_fd_sc_hd__nor3_1
X_12879_ network.in_spk14_12 _08830_ VSS VSS VDD VDD _08831_
+ sky130_fd_sc_hd__nand2b_1
X_12880_ network.in_spk12_13 network.in_spk13_13 network.in_spk14_13
+ network.in_spk15_13 VSS VSS VDD VDD _08832_ sky130_fd_sc_hd__nor4_1
X_12881_ network.in_spk00_13 network.in_spk01_13 network.in_spk02_13
+ network.in_spk03_13 VSS VSS VDD VDD _08833_ sky130_fd_sc_hd__nor4_1
X_12882_ network.in_spk04_13 network.in_spk05_13 network.in_spk06_13
+ network.in_spk07_13 VSS VSS VDD VDD _08834_ sky130_fd_sc_hd__nor4_1
X_12883_ network.in_spk08_13 network.in_spk09_13 network.in_spk10_13
+ network.in_spk11_13 VSS VSS VDD VDD _08835_ sky130_fd_sc_hd__nor4_1
X_12884_ _08832_ net329 _08834_ _08835_ VSS VSS VDD VDD _08836_
+ sky130_fd_sc_hd__nand4_1
X_12885_ network.in_spk15_12 _08829_ _08831_ _08836_ VSS VSS
+ VDD VDD _08837_ sky130_fd_sc_hd__nor4_2
X_12886_ network.in_spk03_15 network.in_spk02_15 VSS VSS VDD
+ VDD _08838_ sky130_fd_sc_hd__nor2_1
X_12887_ network.in_spk05_15 network.in_spk04_15 VSS VSS VDD
+ VDD _08839_ sky130_fd_sc_hd__nor2_1
X_12888_ network.in_spk07_15 network.in_spk06_15 network.in_spk01_15
+ network.in_spk00_15 VSS VSS VDD VDD _08840_ sky130_fd_sc_hd__nor4_1
X_12889_ network.in_spk11_15 network.in_spk10_15 network.in_spk09_15
+ network.in_spk08_15 VSS VSS VDD VDD _08841_ sky130_fd_sc_hd__nor4_1
X_12890_ _08838_ _08839_ _08840_ _08841_ VSS VSS VDD VDD _08842_
+ sky130_fd_sc_hd__and4_1
Xplace334 _07607_ VSS VSS VDD VDD net333 sky130_fd_sc_hd__buf_4
X_12892_ network.in_spk15_15 network.in_spk14_15 network.in_spk13_15
+ network.in_spk12_15 VSS VSS VDD VDD _08844_ sky130_fd_sc_hd__nor4_1
X_12893_ network.in_spk00_00 network.in_spk01_00 network.in_spk02_00
+ network.in_spk03_00 VSS VSS VDD VDD _08845_ sky130_fd_sc_hd__nor4_1
X_12894_ network.in_spk04_00 network.in_spk05_00 network.in_spk06_00
+ network.in_spk07_00 VSS VSS VDD VDD _08846_ sky130_fd_sc_hd__nor4_1
X_12895_ network.in_spk08_00 network.in_spk09_00 network.in_spk10_00
+ network.in_spk11_00 VSS VSS VDD VDD _08847_ sky130_fd_sc_hd__nor4_1
X_12896_ network.in_spk12_00 net327 _08846_ _08847_ VSS VSS
+ VDD VDD _08848_ sky130_fd_sc_hd__nand4b_1
X_12897_ network.in_spk00_01 network.in_spk01_01 network.in_spk02_01
+ network.in_spk03_01 VSS VSS VDD VDD _08849_ sky130_fd_sc_hd__or4_1
X_12898_ network.in_spk04_01 network.in_spk05_01 network.in_spk06_01
+ network.in_spk07_01 VSS VSS VDD VDD _08850_ sky130_fd_sc_hd__nor4_1
X_12899_ network.in_spk13_00 network.in_spk14_00 network.in_spk15_00
+ VSS VSS VDD VDD _08851_ sky130_fd_sc_hd__nor3_1
X_12900_ _08849_ _08850_ _08851_ VSS VSS VDD VDD _08852_ sky130_fd_sc_hd__nand3b_1
Xplace332 _07641_ VSS VSS VDD VDD net331 sky130_fd_sc_hd__buf_4
X_12902_ network.in_spk08_01 network.in_spk09_01 network.in_spk10_01
+ network.in_spk11_01 VSS VSS VDD VDD _08854_ sky130_fd_sc_hd__or4_1
X_12903_ network.in_spk12_01 network.in_spk13_01 network.in_spk14_01
+ network.in_spk15_01 VSS VSS VDD VDD _08855_ sky130_fd_sc_hd__or4_1
X_12904_ _08854_ _08855_ VSS VSS VDD VDD _08856_ sky130_fd_sc_hd__or2_2
X_12905_ _08848_ _08852_ _08856_ VSS VSS VDD VDD _08857_ sky130_fd_sc_hd__or3_1
Xplace330 _08833_ VSS VSS VDD VDD net329 sky130_fd_sc_hd__buf_4
X_12907_ network.in_spk00_04 network.in_spk01_04 network.in_spk02_04
+ network.in_spk03_04 VSS VSS VDD VDD _08859_ sky130_fd_sc_hd__nor4_1
X_12908_ network.in_spk04_04 network.in_spk05_04 network.in_spk06_04
+ network.in_spk07_04 VSS VSS VDD VDD _08860_ sky130_fd_sc_hd__nor4_1
X_12909_ network.in_spk12_04 network.in_spk13_04 network.in_spk14_04
+ network.in_spk15_04 VSS VSS VDD VDD _08861_ sky130_fd_sc_hd__nor4_1
X_12910_ network.in_spk08_04 network.in_spk09_04 network.in_spk10_04
+ network.in_spk11_04 VSS VSS VDD VDD _08862_ sky130_fd_sc_hd__nor4_1
X_12911_ _08859_ _08860_ _08861_ _08862_ VSS VSS VDD VDD _08863_
+ sky130_fd_sc_hd__nand4_1
Xplace326 _07057_ VSS VSS VDD VDD net325 sky130_fd_sc_hd__buf_4
Xplace325 _07109_ VSS VSS VDD VDD net324 sky130_fd_sc_hd__buf_4
X_12914_ network.in_spk12_05 network.in_spk13_05 network.in_spk14_05
+ network.in_spk15_05 VSS VSS VDD VDD _08866_ sky130_fd_sc_hd__or4_4
X_12915_ network.in_spk08_05 network.in_spk09_05 network.in_spk10_05
+ network.in_spk11_05 VSS VSS VDD VDD _08867_ sky130_fd_sc_hd__or4_1
X_12916_ network.in_spk00_05 network.in_spk01_05 network.in_spk02_05
+ network.in_spk03_05 VSS VSS VDD VDD _08868_ sky130_fd_sc_hd__or4_1
X_12917_ network.in_spk04_05 network.in_spk05_05 network.in_spk06_05
+ network.in_spk07_05 VSS VSS VDD VDD _08869_ sky130_fd_sc_hd__or4_1
X_12918_ _08866_ _08867_ _08868_ _08869_ VSS VSS VDD VDD _08870_
+ sky130_fd_sc_hd__or4_4
X_12919_ network.in_spk12_02 network.in_spk13_02 network.in_spk14_02
+ network.in_spk15_02 VSS VSS VDD VDD _08871_ sky130_fd_sc_hd__nor4_1
X_12920_ network.in_spk08_02 network.in_spk09_02 network.in_spk10_02
+ network.in_spk11_02 VSS VSS VDD VDD _08872_ sky130_fd_sc_hd__nor4_1
X_12921_ network.in_spk00_02 network.in_spk01_02 network.in_spk02_02
+ network.in_spk03_02 VSS VSS VDD VDD _08873_ sky130_fd_sc_hd__nor4_1
X_12922_ network.in_spk04_02 network.in_spk05_02 network.in_spk06_02
+ network.in_spk07_02 VSS VSS VDD VDD _08874_ sky130_fd_sc_hd__nor4_1
X_12923_ _08871_ _08872_ _08873_ _08874_ VSS VSS VDD VDD _08875_
+ sky130_fd_sc_hd__nand4_1
X_12924_ network.in_spk00_03 network.in_spk01_03 network.in_spk02_03
+ network.in_spk03_03 VSS VSS VDD VDD _08876_ sky130_fd_sc_hd__or4_1
Xplace324 _07129_ VSS VSS VDD VDD net323 sky130_fd_sc_hd__buf_4
X_12926_ network.in_spk04_03 network.in_spk05_03 network.in_spk06_03
+ network.in_spk07_03 VSS VSS VDD VDD _08878_ sky130_fd_sc_hd__or4_1
Xplace323 _07187_ VSS VSS VDD VDD net322 sky130_fd_sc_hd__buf_4
X_12928_ network.in_spk08_03 network.in_spk09_03 network.in_spk10_03
+ network.in_spk11_03 VSS VSS VDD VDD _08880_ sky130_fd_sc_hd__or4_1
X_12929_ network.in_spk12_03 network.in_spk13_03 network.in_spk14_03
+ network.in_spk15_03 VSS VSS VDD VDD _08881_ sky130_fd_sc_hd__or4_1
X_12930_ _08876_ _08878_ _08880_ _08881_ VSS VSS VDD VDD _08882_
+ sky130_fd_sc_hd__or4_4
X_12931_ net309 _08870_ net308 _08882_ VSS VSS VDD VDD _08883_
+ sky130_fd_sc_hd__or4_4
Xplace322 _07196_ VSS VSS VDD VDD net321 sky130_fd_sc_hd__buf_4
X_12933_ network.in_spk04_11 network.in_spk05_11 network.in_spk06_11
+ network.in_spk07_11 VSS VSS VDD VDD _08885_ sky130_fd_sc_hd__or4_1
X_12934_ network.in_spk00_11 network.in_spk01_11 network.in_spk02_11
+ network.in_spk03_11 VSS VSS VDD VDD _08886_ sky130_fd_sc_hd__or4_1
Xplace298 _08790_ VSS VSS VDD VDD net297 sky130_fd_sc_hd__buf_4
Xplace296 _08988_ VSS VSS VDD VDD net295 sky130_fd_sc_hd__buf_4
X_12937_ network.in_spk12_11 network.in_spk13_11 network.in_spk14_11
+ network.in_spk15_11 VSS VSS VDD VDD _08889_ sky130_fd_sc_hd__or4_1
Xplace295 _04006_ VSS VSS VDD VDD net294 sky130_fd_sc_hd__buf_4
Xplace294 _08408_ VSS VSS VDD VDD net293 sky130_fd_sc_hd__buf_4
X_12940_ network.in_spk08_11 network.in_spk09_11 network.in_spk10_11
+ network.in_spk11_11 VSS VSS VDD VDD _08892_ sky130_fd_sc_hd__or4_1
X_12941_ _08885_ _08886_ _08889_ _08892_ VSS VSS VDD VDD _08893_
+ sky130_fd_sc_hd__nor4_2
X_12942_ network.in_spk08_08 network.in_spk09_08 network.in_spk10_08
+ network.in_spk11_08 VSS VSS VDD VDD _08894_ sky130_fd_sc_hd__nor4_1
X_12943_ network.in_spk12_08 network.in_spk13_08 network.in_spk14_08
+ network.in_spk15_08 VSS VSS VDD VDD _08895_ sky130_fd_sc_hd__nor4_1
X_12944_ network.in_spk00_08 network.in_spk01_08 network.in_spk02_08
+ network.in_spk03_08 VSS VSS VDD VDD _08896_ sky130_fd_sc_hd__nor4_1
X_12945_ network.in_spk04_08 network.in_spk05_08 network.in_spk06_08
+ network.in_spk07_08 VSS VSS VDD VDD _08897_ sky130_fd_sc_hd__nor4_1
X_12946_ _08894_ _08895_ _08896_ _08897_ VSS VSS VDD VDD _08898_
+ sky130_fd_sc_hd__and4_1
Xplace293 _08927_ VSS VSS VDD VDD net292 sky130_fd_sc_hd__buf_4
Xplace292 _09173_ VSS VSS VDD VDD net291 sky130_fd_sc_hd__buf_4
X_12949_ network.in_spk08_09 network.in_spk09_09 network.in_spk10_09
+ network.in_spk11_09 VSS VSS VDD VDD _08901_ sky130_fd_sc_hd__nor4_1
X_12950_ network.in_spk12_09 network.in_spk13_09 network.in_spk14_09
+ network.in_spk15_09 VSS VSS VDD VDD _08902_ sky130_fd_sc_hd__nor4_1
X_12951_ network.in_spk00_09 network.in_spk01_09 network.in_spk02_09
+ network.in_spk03_09 VSS VSS VDD VDD _08903_ sky130_fd_sc_hd__nor4_1
X_12952_ network.in_spk04_09 network.in_spk05_09 network.in_spk06_09
+ network.in_spk07_09 VSS VSS VDD VDD _08904_ sky130_fd_sc_hd__nor4_1
X_12953_ _08901_ _08902_ _08903_ _08904_ VSS VSS VDD VDD _08905_
+ sky130_fd_sc_hd__and4_1
X_12954_ network.in_spk04_10 network.in_spk05_10 network.in_spk06_10
+ network.in_spk07_10 VSS VSS VDD VDD _08906_ sky130_fd_sc_hd__nor4_1
X_12955_ network.in_spk00_10 network.in_spk01_10 network.in_spk02_10
+ network.in_spk03_10 VSS VSS VDD VDD _08907_ sky130_fd_sc_hd__nor4_1
X_12956_ network.in_spk08_10 network.in_spk09_10 network.in_spk10_10
+ network.in_spk11_10 VSS VSS VDD VDD _08908_ sky130_fd_sc_hd__nor4_1
Xplace291 _04002_ VSS VSS VDD VDD net290 sky130_fd_sc_hd__buf_4
X_12958_ network.in_spk12_10 network.in_spk13_10 network.in_spk14_10
+ network.in_spk15_10 VSS VSS VDD VDD _08910_ sky130_fd_sc_hd__nor4_1
X_12959_ _08906_ _08907_ _08908_ _08910_ VSS VSS VDD VDD _08911_
+ sky130_fd_sc_hd__and4_1
X_12960_ _08893_ _08898_ _08905_ _08911_ VSS VSS VDD VDD _08912_
+ sky130_fd_sc_hd__nand4_1
X_12961_ network.in_spk00_07 network.in_spk01_07 network.in_spk02_07
+ network.in_spk03_07 VSS VSS VDD VDD _08913_ sky130_fd_sc_hd__or4_1
X_12962_ network.in_spk04_07 network.in_spk05_07 network.in_spk06_07
+ network.in_spk07_07 VSS VSS VDD VDD _08914_ sky130_fd_sc_hd__nor4_1
X_12963_ network.in_spk12_07 network.in_spk13_07 network.in_spk14_07
+ network.in_spk15_07 VSS VSS VDD VDD _08915_ sky130_fd_sc_hd__nor4_1
X_12964_ network.in_spk08_07 network.in_spk09_07 network.in_spk10_07
+ network.in_spk11_07 VSS VSS VDD VDD _08916_ sky130_fd_sc_hd__nor4_1
X_12965_ _08913_ _08914_ _08915_ _08916_ VSS VSS VDD VDD _08917_
+ sky130_fd_sc_hd__nand4b_1
X_12966_ network.in_spk12_06 network.in_spk13_06 network.in_spk14_06
+ network.in_spk15_06 VSS VSS VDD VDD _08918_ sky130_fd_sc_hd__or4_1
X_12967_ network.in_spk02_06 network.in_spk03_06 network.in_spk00_06
+ network.in_spk01_06 VSS VSS VDD VDD _08919_ sky130_fd_sc_hd__nor4_1
Xplace283 _03685_ VSS VSS VDD VDD net282 sky130_fd_sc_hd__buf_4
X_12969_ network.in_spk04_06 network.in_spk05_06 network.in_spk06_06
+ network.in_spk07_06 VSS VSS VDD VDD _08921_ sky130_fd_sc_hd__nor4_1
X_12970_ network.in_spk08_06 network.in_spk09_06 network.in_spk10_06
+ network.in_spk11_06 VSS VSS VDD VDD _08922_ sky130_fd_sc_hd__nor4_1
X_12971_ _08918_ _08919_ _08921_ _08922_ VSS VSS VDD VDD _08923_
+ sky130_fd_sc_hd__and4b_1
X_12972_ _08917_ _08923_ VSS VSS VDD VDD _08924_ sky130_fd_sc_hd__nand2b_1
X_12973_ net303 _08883_ _08912_ _08924_ VSS VSS VDD VDD _08925_
+ sky130_fd_sc_hd__or4_4
Xplace282 net282 VSS VSS VDD VDD net281 sky130_fd_sc_hd__buf_4
X_12975_ _08824_ net304 _08842_ net328 _08925_ VSS VSS VDD
+ VDD _08927_ sky130_fd_sc_hd__a41oi_1
X_12976_ net292 VSS VSS VDD VDD _08928_ sky130_fd_sc_hd__inv_1
X_12977_ net309 _08870_ VSS VSS VDD VDD _08929_ sky130_fd_sc_hd__or2_2
Xplace281 net282 VSS VSS VDD VDD net280 sky130_fd_sc_hd__buf_4
X_12979_ net303 net308 _08882_ VSS VSS VDD VDD _08931_ sky130_fd_sc_hd__nor3_1
X_12980_ _08929_ _08924_ net296 VSS VSS VDD VDD _08932_ sky130_fd_sc_hd__o21ai_0
X_12981_ _08928_ _08932_ net380 VSS VSS VDD VDD _01724_ sky130_fd_sc_hd__a21oi_1
X_12982_ _08842_ net328 VSS VSS VDD VDD _08933_ sky130_fd_sc_hd__nand2_1
X_12983_ _08824_ net304 _08933_ VSS VSS VDD VDD _08934_ sky130_fd_sc_hd__nand3_1
X_12984_ _08925_ _08934_ VSS VSS VDD VDD _08935_ sky130_fd_sc_hd__or2_1
X_12985_ _08894_ _08895_ _08896_ _08897_ VSS VSS VDD VDD _08936_
+ sky130_fd_sc_hd__nand4_1
X_12986_ _08901_ _08902_ _08903_ _08904_ VSS VSS VDD VDD _08937_
+ sky130_fd_sc_hd__nand4_1
X_12987_ _08936_ _08937_ VSS VSS VDD VDD _08938_ sky130_fd_sc_hd__nor2_1
X_12988_ _08938_ _08911_ VSS VSS VDD VDD _08939_ sky130_fd_sc_hd__nand2_1
X_12989_ net303 _08883_ _08924_ VSS VSS VDD VDD _08940_ sky130_fd_sc_hd__or3_1
X_12990_ _08893_ _08939_ _08940_ VSS VSS VDD VDD _08941_ sky130_fd_sc_hd__or3_1
Xplace280 net282 VSS VSS VDD VDD net279 sky130_fd_sc_hd__buf_4
X_12992_ _08935_ _08941_ VSS VSS VDD VDD _08943_ sky130_fd_sc_hd__and2_1
X_12993_ net303 _08883_ _08912_ _08924_ VSS VSS VDD VDD _08944_
+ sky130_fd_sc_hd__nor4_4
X_12994_ _08824_ net304 VSS VSS VDD VDD _08945_ sky130_fd_sc_hd__nor2b_1
X_12995_ _08944_ _08945_ VSS VSS VDD VDD _08946_ sky130_fd_sc_hd__nand2_1
X_12996_ _08848_ _08852_ _08856_ VSS VSS VDD VDD _08947_ sky130_fd_sc_hd__nor3_2
Xplace279 net279 VSS VSS VDD VDD net278 sky130_fd_sc_hd__buf_4
X_12998_ _08919_ _08921_ _08922_ VSS VSS VDD VDD _08949_ sky130_fd_sc_hd__nand3_1
X_12999_ _08917_ _08918_ _08949_ VSS VSS VDD VDD _08950_ sky130_fd_sc_hd__nor3_1
X_13000_ net308 _08882_ VSS VSS VDD VDD _08951_ sky130_fd_sc_hd__nor2_1
X_13001_ _08929_ _08950_ _08951_ VSS VSS VDD VDD _08952_ sky130_fd_sc_hd__o21ai_0
X_13002_ _08898_ _08905_ VSS VSS VDD VDD _08953_ sky130_fd_sc_hd__nand2_1
Xplace278 net282 VSS VSS VDD VDD net277 sky130_fd_sc_hd__buf_4
X_13004_ _08953_ _08911_ _08940_ VSS VSS VDD VDD _08955_ sky130_fd_sc_hd__nor3_2
X_13005_ net302 _08952_ _08955_ VSS VSS VDD VDD _08956_ sky130_fd_sc_hd__a21oi_1
X_13006_ _08925_ net292 net404 VSS VSS VDD VDD _08957_ sky130_fd_sc_hd__o21ai_1
X_13007_ _08943_ _08946_ _08956_ _08957_ VSS VSS VDD VDD _01725_
+ sky130_fd_sc_hd__a31oi_1
X_13008_ _08917_ _08923_ VSS VSS VDD VDD _08958_ sky130_fd_sc_hd__nand2_1
X_13009_ net303 _08883_ _08958_ VSS VSS VDD VDD _08959_ sky130_fd_sc_hd__or3_1
Xplace277 net282 VSS VSS VDD VDD net276 sky130_fd_sc_hd__buf_4
X_13011_ _08849_ _08850_ VSS VSS VDD VDD _08961_ sky130_fd_sc_hd__nor2b_1
X_13012_ _08854_ _08855_ VSS VSS VDD VDD _08962_ sky130_fd_sc_hd__nor2_1
X_13013_ network.in_spk12_00 network.in_spk13_00 network.in_spk14_00
+ network.in_spk15_00 VSS VSS VDD VDD _08963_ sky130_fd_sc_hd__nor4_1
X_13014_ net327 _08846_ _08847_ _08963_ VSS VSS VDD VDD _08964_
+ sky130_fd_sc_hd__nand4_1
X_13015_ _08961_ _08962_ _08964_ VSS VSS VDD VDD _08965_ sky130_fd_sc_hd__a21o_1
X_13016_ _08871_ _08872_ _08873_ _08874_ VSS VSS VDD VDD _08966_
+ sky130_fd_sc_hd__and4_1
X_13017_ _08947_ _08966_ _08882_ VSS VSS VDD VDD _08967_ sky130_fd_sc_hd__nand3_1
X_13018_ _08859_ _08860_ _08861_ _08862_ VSS VSS VDD VDD _08968_
+ sky130_fd_sc_hd__and4_1
X_13019_ _08968_ _08870_ net302 _08951_ VSS VSS VDD VDD _08969_
+ sky130_fd_sc_hd__nand4_1
X_13020_ _08959_ _08965_ _08967_ _08969_ VSS VSS VDD VDD _08970_
+ sky130_fd_sc_hd__nand4_1
X_13021_ network.in_spk15_12 _08829_ _08831_ VSS VSS VDD VDD
+ _08971_ sky130_fd_sc_hd__nor3_1
X_13022_ _08971_ _08836_ VSS VSS VDD VDD _08972_ sky130_fd_sc_hd__nand2_1
X_13023_ _08925_ _08972_ VSS VSS VDD VDD _08973_ sky130_fd_sc_hd__nor2_1
X_13024_ _08936_ _08905_ _08940_ VSS VSS VDD VDD _08974_ sky130_fd_sc_hd__nor3_2
X_13025_ _08970_ _08973_ _08974_ VSS VSS VDD VDD _08975_ sky130_fd_sc_hd__nor3_1
X_13026_ _08943_ _08975_ _08957_ VSS VSS VDD VDD _01726_ sky130_fd_sc_hd__a21oi_1
X_13027_ network.in_spk04_11 network.in_spk05_11 network.in_spk06_11
+ network.in_spk07_11 VSS VSS VDD VDD _08976_ sky130_fd_sc_hd__nor4_1
X_13028_ _08886_ VSS VSS VDD VDD _08977_ sky130_fd_sc_hd__inv_1
X_13029_ _08976_ _08977_ VSS VSS VDD VDD _08978_ sky130_fd_sc_hd__nand2_1
X_13030_ _08978_ _08939_ _08940_ VSS VSS VDD VDD _08979_ sky130_fd_sc_hd__nor3_1
X_13031_ _08889_ _08892_ _08979_ VSS VSS VDD VDD _08980_ sky130_fd_sc_hd__o21ai_2
X_13032_ _08901_ _08902_ VSS VSS VDD VDD _08981_ sky130_fd_sc_hd__nand2_1
X_13033_ _08903_ _08904_ VSS VSS VDD VDD _08982_ sky130_fd_sc_hd__and2_1
X_13034_ _08894_ _08895_ VSS VSS VDD VDD _08983_ sky130_fd_sc_hd__nand2_1
X_13035_ _08981_ _08982_ _08983_ VSS VSS VDD VDD _08984_ sky130_fd_sc_hd__a21oi_1
X_13036_ network.in_spk04_08 network.in_spk05_08 VSS VSS VDD
+ VDD _08985_ sky130_fd_sc_hd__nor2_1
X_13037_ network.in_spk06_08 _08896_ _08985_ VSS VSS VDD VDD
+ _08986_ sky130_fd_sc_hd__nand3b_1
X_13038_ network.in_spk07_08 _08986_ VSS VSS VDD VDD _08987_
+ sky130_fd_sc_hd__nor2_1
X_13039_ net303 _08883_ _08924_ VSS VSS VDD VDD _08988_ sky130_fd_sc_hd__nor3_1
X_13040_ _08987_ net295 VSS VSS VDD VDD _08989_ sky130_fd_sc_hd__nand2_1
X_13041_ _08821_ _08823_ VSS VSS VDD VDD _08990_ sky130_fd_sc_hd__nand2_1
X_13042_ _08820_ _08990_ VSS VSS VDD VDD _08991_ sky130_fd_sc_hd__nor2_1
X_13043_ _08944_ _08945_ _08991_ VSS VSS VDD VDD _08992_ sky130_fd_sc_hd__nand3_1
X_13044_ _08984_ _08989_ _08992_ VSS VSS VDD VDD _08993_ sky130_fd_sc_hd__o21ai_0
X_13045_ network.in_spk04_07 network.in_spk05_07 network.in_spk06_07
+ VSS VSS VDD VDD _08994_ sky130_fd_sc_hd__or3_1
X_13046_ network.in_spk07_07 _08913_ _08994_ VSS VSS VDD VDD
+ _08995_ sky130_fd_sc_hd__nor3_1
X_13047_ _08995_ VSS VSS VDD VDD _08996_ sky130_fd_sc_hd__inv_1
X_13048_ _08996_ _08959_ VSS VSS VDD VDD _08997_ sky130_fd_sc_hd__nor2_1
X_13049_ net327 _08846_ VSS VSS VDD VDD _08998_ sky130_fd_sc_hd__nand2_1
X_13050_ _08847_ _08963_ VSS VSS VDD VDD _08999_ sky130_fd_sc_hd__nand2_1
X_13051_ _08961_ _08856_ _08999_ VSS VSS VDD VDD _09000_ sky130_fd_sc_hd__a21oi_1
X_13052_ _08871_ _08872_ VSS VSS VDD VDD _09001_ sky130_fd_sc_hd__and2_1
X_13053_ _08873_ _08874_ VSS VSS VDD VDD _09002_ sky130_fd_sc_hd__nand2_1
X_13054_ _09001_ _09002_ VSS VSS VDD VDD _09003_ sky130_fd_sc_hd__nor2_1
X_13055_ net302 _09003_ VSS VSS VDD VDD _09004_ sky130_fd_sc_hd__nand2_1
X_13056_ network.in_spk00_04 network.in_spk01_04 network.in_spk02_04
+ network.in_spk03_04 VSS VSS VDD VDD _09005_ sky130_fd_sc_hd__or4_1
X_13057_ network.in_spk04_04 network.in_spk05_04 network.in_spk06_04
+ network.in_spk07_04 VSS VSS VDD VDD _09006_ sky130_fd_sc_hd__or4_1
X_13058_ _09005_ _09006_ VSS VSS VDD VDD _09007_ sky130_fd_sc_hd__nor2_1
X_13059_ _08861_ _08862_ VSS VSS VDD VDD _09008_ sky130_fd_sc_hd__nand2_1
X_13060_ _09007_ _09008_ net302 _08951_ VSS VSS VDD VDD _09009_
+ sky130_fd_sc_hd__nand4_1
X_13061_ _08998_ _09000_ _09004_ _09009_ VSS VSS VDD VDD _09010_
+ sky130_fd_sc_hd__o211a_1
X_13062_ _08919_ _08921_ VSS VSS VDD VDD _09011_ sky130_fd_sc_hd__nand2_1
X_13063_ net309 _08870_ _08923_ VSS VSS VDD VDD _09012_ sky130_fd_sc_hd__nor3_1
X_13064_ net302 _08951_ _09012_ VSS VSS VDD VDD _09013_ sky130_fd_sc_hd__nand3_1
X_13065_ _09011_ _09013_ VSS VSS VDD VDD _09014_ sky130_fd_sc_hd__or2_2
X_13066_ _08876_ _08878_ _08967_ VSS VSS VDD VDD _09015_ sky130_fd_sc_hd__or3_1
X_13067_ _08868_ _08869_ VSS VSS VDD VDD _09016_ sky130_fd_sc_hd__nor2_1
X_13068_ _08866_ _08867_ _09016_ VSS VSS VDD VDD _09017_ sky130_fd_sc_hd__o21ai_0
X_13069_ _08969_ _09017_ VSS VSS VDD VDD _09018_ sky130_fd_sc_hd__or2_2
X_13070_ _09010_ _09014_ _09015_ _09018_ VSS VSS VDD VDD _09019_
+ sky130_fd_sc_hd__nand4_1
X_13071_ _08906_ _08907_ VSS VSS VDD VDD _09020_ sky130_fd_sc_hd__and2_1
X_13072_ _08908_ _08910_ VSS VSS VDD VDD _09021_ sky130_fd_sc_hd__nand2_1
X_13073_ _08953_ _08940_ VSS VSS VDD VDD _09022_ sky130_fd_sc_hd__nor2_1
X_13074_ _09020_ _09021_ _09022_ VSS VSS VDD VDD _09023_ sky130_fd_sc_hd__nand3_1
X_13075_ _08993_ _08997_ _09019_ _09023_ VSS VSS VDD VDD _09024_
+ sky130_fd_sc_hd__nor4b_1
X_13076_ _08971_ _08836_ VSS VSS VDD VDD _09025_ sky130_fd_sc_hd__and2_1
X_13077_ _08832_ _08835_ _08834_ VSS VSS VDD VDD _09026_ sky130_fd_sc_hd__a21boi_0
X_13078_ _08944_ net329 _09025_ _09026_ VSS VSS VDD VDD _09027_
+ sky130_fd_sc_hd__nand4_1
X_13079_ network.in_spk01_15 network.in_spk00_15 VSS VSS VDD
+ VDD _09028_ sky130_fd_sc_hd__nor2_1
X_13080_ network.in_spk06_15 network.in_spk05_15 network.in_spk04_15
+ VSS VSS VDD VDD _09029_ sky130_fd_sc_hd__nor3_1
X_13081_ _09028_ _08838_ _09029_ VSS VSS VDD VDD _09030_ sky130_fd_sc_hd__nand3_1
X_13082_ network.in_spk07_15 _09030_ VSS VSS VDD VDD _09031_
+ sky130_fd_sc_hd__nor2_1
X_13083_ _08925_ _08934_ VSS VSS VDD VDD _09032_ sky130_fd_sc_hd__nor2_1
X_13084_ _09031_ _09032_ VSS VSS VDD VDD _09033_ sky130_fd_sc_hd__nand2_1
X_13085_ _08825_ _08826_ VSS VSS VDD VDD _09034_ sky130_fd_sc_hd__and2_1
X_13086_ _08925_ _08971_ VSS VSS VDD VDD _09035_ sky130_fd_sc_hd__nor2_1
X_13087_ _09034_ _08827_ _09035_ VSS VSS VDD VDD _09036_ sky130_fd_sc_hd__nand3_1
X_13088_ _09027_ _09033_ _09036_ VSS VSS VDD VDD _09037_ sky130_fd_sc_hd__and3_1
X_13089_ _08980_ net275 _09037_ _08957_ VSS VSS VDD VDD _01727_
+ sky130_fd_sc_hd__a31oi_1
X_13090_ network.in_spk10_15 network.in_spk09_15 network.in_spk08_15
+ VSS VSS VDD VDD _09038_ sky130_fd_sc_hd__or3_1
X_13091_ network.in_spk11_15 _09038_ net328 VSS VSS VDD VDD
+ _09039_ sky130_fd_sc_hd__nor3_1
X_13092_ network.in_spk07_15 _09039_ _09029_ VSS VSS VDD VDD
+ _09040_ sky130_fd_sc_hd__nor3b_1
X_13093_ _09028_ _08838_ _09032_ VSS VSS VDD VDD _09041_ sky130_fd_sc_hd__nand3_1
X_13094_ network.in_spk04_06 network.in_spk05_06 network.in_spk06_06
+ network.in_spk07_06 VSS VSS VDD VDD _09042_ sky130_fd_sc_hd__or4_1
X_13095_ _08918_ _08922_ _09042_ VSS VSS VDD VDD _09043_ sky130_fd_sc_hd__a21oi_1
X_13096_ _08931_ _08919_ _09012_ VSS VSS VDD VDD _09044_ sky130_fd_sc_hd__nand3_1
X_13097_ _08832_ _08835_ VSS VSS VDD VDD _09045_ sky130_fd_sc_hd__nand2b_1
X_13098_ net329 VSS VSS VDD VDD _09046_ sky130_fd_sc_hd__inv_1
X_13099_ _08834_ _09045_ _09046_ VSS VSS VDD VDD _09047_ sky130_fd_sc_hd__a21o_1
X_13100_ _08944_ _09025_ VSS VSS VDD VDD _09048_ sky130_fd_sc_hd__nand2_1
X_13101_ network.in_spk08_05 network.in_spk09_05 network.in_spk10_05
+ network.in_spk11_05 VSS VSS VDD VDD _09049_ sky130_fd_sc_hd__nor4_1
X_13102_ _08866_ _09049_ _08869_ VSS VSS VDD VDD _09050_ sky130_fd_sc_hd__a21oi_1
X_13103_ network.in_spk12_11 network.in_spk13_11 network.in_spk14_11
+ network.in_spk15_11 VSS VSS VDD VDD _09051_ sky130_fd_sc_hd__nor4_1
X_13104_ _09051_ _08892_ _08976_ VSS VSS VDD VDD _09052_ sky130_fd_sc_hd__o21ai_0
X_13105_ _08895_ _08894_ VSS VSS VDD VDD _09053_ sky130_fd_sc_hd__nand2b_1
X_13106_ network.in_spk00_08 network.in_spk01_08 network.in_spk02_08
+ network.in_spk03_08 VSS VSS VDD VDD _09054_ sky130_fd_sc_hd__or4_1
X_13107_ _08897_ _09053_ _09054_ VSS VSS VDD VDD _09055_ sky130_fd_sc_hd__a21oi_1
X_13108_ _08977_ _08938_ _08911_ _09052_ _09055_ VSS VSS VDD
+ VDD _09056_ sky130_fd_sc_hd__a41oi_1
X_13109_ _08868_ _08969_ _09050_ _09056_ _08940_ VSS VSS VDD
+ VDD _09057_ sky130_fd_sc_hd__o32a_1
X_13110_ _09043_ _09044_ _09047_ _09048_ _09057_ VSS VSS VDD
+ VDD _09058_ sky130_fd_sc_hd__o221a_2
X_13111_ _08910_ _08908_ VSS VSS VDD VDD _09059_ sky130_fd_sc_hd__nand2b_1
X_13112_ _08906_ _09059_ _08907_ VSS VSS VDD VDD _09060_ sky130_fd_sc_hd__a21boi_0
X_13113_ _08913_ _08959_ VSS VSS VDD VDD _09061_ sky130_fd_sc_hd__nor2_1
X_13114_ _08916_ VSS VSS VDD VDD _09062_ sky130_fd_sc_hd__inv_1
X_13115_ _08915_ _09062_ _08914_ VSS VSS VDD VDD _09063_ sky130_fd_sc_hd__o21ai_0
X_13116_ network.in_spk08_03 network.in_spk09_03 network.in_spk10_03
+ network.in_spk11_03 VSS VSS VDD VDD _09064_ sky130_fd_sc_hd__nor4_1
X_13117_ _09064_ _08881_ _08878_ VSS VSS VDD VDD _09065_ sky130_fd_sc_hd__a21oi_1
X_13118_ _08876_ _08878_ _08880_ _08881_ VSS VSS VDD VDD _09066_
+ sky130_fd_sc_hd__nor4_1
X_13119_ _08857_ net308 _08876_ _09066_ VSS VSS VDD VDD _09067_
+ sky130_fd_sc_hd__or4_1
X_13120_ network.in_spk04_00 network.in_spk05_00 network.in_spk06_00
+ network.in_spk07_00 VSS VSS VDD VDD _09068_ sky130_fd_sc_hd__or4_1
X_13121_ network.in_spk08_01 network.in_spk09_01 network.in_spk10_01
+ network.in_spk11_01 VSS VSS VDD VDD _09069_ sky130_fd_sc_hd__nor4_1
X_13122_ _09069_ _08855_ VSS VSS VDD VDD _09070_ sky130_fd_sc_hd__nand2_1
X_13123_ _08850_ _09070_ _08849_ VSS VSS VDD VDD _09071_ sky130_fd_sc_hd__a21oi_1
X_13124_ _09068_ _08847_ _08964_ _09071_ net327 VSS VSS VDD
+ VDD _09072_ sky130_fd_sc_hd__o221ai_1
X_13125_ network.in_spk08_04 network.in_spk09_04 network.in_spk10_04
+ network.in_spk11_04 VSS VSS VDD VDD _09073_ sky130_fd_sc_hd__or4_1
X_13126_ _08861_ _09073_ _08860_ VSS VSS VDD VDD _09074_ sky130_fd_sc_hd__o21ai_0
X_13127_ _08859_ net302 _08951_ _09074_ VSS VSS VDD VDD _09075_
+ sky130_fd_sc_hd__nand4_1
X_13128_ network.in_spk08_02 network.in_spk09_02 VSS VSS VDD
+ VDD _09076_ sky130_fd_sc_hd__nor2_1
X_13129_ network.in_spk10_02 network.in_spk11_02 VSS VSS VDD
+ VDD _09077_ sky130_fd_sc_hd__nor2_1
X_13130_ _09076_ _09077_ VSS VSS VDD VDD _09078_ sky130_fd_sc_hd__nand2_1
X_13131_ _08871_ _09078_ _08874_ VSS VSS VDD VDD _09079_ sky130_fd_sc_hd__o21ai_0
X_13132_ net302 _08873_ net308 _09079_ VSS VSS VDD VDD _09080_
+ sky130_fd_sc_hd__nand4_1
X_13133_ _09065_ _09067_ _09072_ _09075_ _09080_ VSS VSS VDD
+ VDD _09081_ sky130_fd_sc_hd__o2111ai_1
X_13134_ _09022_ _09060_ _09061_ _09063_ _09081_ VSS VSS VDD
+ VDD _09082_ sky130_fd_sc_hd__a221oi_1
X_13135_ _09040_ _09041_ _09058_ _09082_ VSS VSS VDD VDD _09083_
+ sky130_fd_sc_hd__o211a_1
X_13136_ network.in_spk04_12 network.in_spk05_12 network.in_spk06_12
+ network.in_spk07_12 VSS VSS VDD VDD _09084_ sky130_fd_sc_hd__nor4_1
X_13137_ network.in_spk00_12 network.in_spk01_12 network.in_spk02_12
+ VSS VSS VDD VDD _09085_ sky130_fd_sc_hd__or3_1
X_13138_ _08971_ _08944_ VSS VSS VDD VDD _09086_ sky130_fd_sc_hd__nand2b_1
X_13139_ network.in_spk03_12 _09085_ _09086_ VSS VSS VDD VDD
+ _09087_ sky130_fd_sc_hd__or3_1
X_13140_ _08925_ _08829_ _08971_ VSS VSS VDD VDD _09088_ sky130_fd_sc_hd__or3_1
X_13141_ _09084_ _09087_ _09088_ network.in_spk11_12 VSS VSS
+ VDD VDD _09089_ sky130_fd_sc_hd__o22a_1
X_13142_ network.in_spk08_09 network.in_spk09_09 VSS VSS VDD
+ VDD _09090_ sky130_fd_sc_hd__nor2_1
X_13143_ network.in_spk10_09 network.in_spk11_09 VSS VSS VDD
+ VDD _09091_ sky130_fd_sc_hd__nor2_1
X_13144_ _09090_ _09091_ VSS VSS VDD VDD _09092_ sky130_fd_sc_hd__nand2_1
X_13145_ _09092_ _08902_ _08904_ VSS VSS VDD VDD _09093_ sky130_fd_sc_hd__o21ai_0
X_13146_ network.in_spk00_09 network.in_spk01_09 network.in_spk02_09
+ network.in_spk03_09 VSS VSS VDD VDD _09094_ sky130_fd_sc_hd__or4_1
X_13147_ _08898_ _08937_ net295 VSS VSS VDD VDD _09095_ sky130_fd_sc_hd__nand3_1
X_13148_ _09094_ _09095_ VSS VSS VDD VDD _09096_ sky130_fd_sc_hd__nor2_1
X_13149_ network.in_spk11_14 network.in_spk10_14 network.in_spk09_14
+ network.in_spk08_14 VSS VSS VDD VDD _09097_ sky130_fd_sc_hd__nor4_1
X_13150_ network.in_spk15_14 _08819_ _09097_ VSS VSS VDD VDD
+ _09098_ sky130_fd_sc_hd__o21ai_0
X_13151_ _08944_ _08821_ _08945_ VSS VSS VDD VDD _09099_ sky130_fd_sc_hd__nand3_1
X_13152_ _08823_ _09098_ _09099_ VSS VSS VDD VDD _09100_ sky130_fd_sc_hd__a21oi_1
X_13153_ _09093_ _09096_ _09100_ VSS VSS VDD VDD _09101_ sky130_fd_sc_hd__a21oi_1
X_13154_ _09083_ _09089_ _09101_ _08957_ VSS VSS VDD VDD _01728_
+ sky130_fd_sc_hd__a31oi_1
X_13155_ network.in_spk04_14 network.in_spk05_14 VSS VSS VDD
+ VDD _09102_ sky130_fd_sc_hd__nor2_1
X_13156_ network.in_spk06_14 _09102_ network.in_spk02_14 network.in_spk03_14
+ VSS VSS VDD VDD _09103_ sky130_fd_sc_hd__a211oi_1
X_13157_ network.in_spk13_14 network.in_spk11_14 network.in_spk12_14
+ network.in_spk14_14 VSS VSS VDD VDD _09104_ sky130_fd_sc_hd__nor4b_1
X_13158_ network.in_spk10_14 _09104_ VSS VSS VDD VDD _09105_
+ sky130_fd_sc_hd__nor2_1
X_13159_ network.in_spk09_14 network.in_spk08_14 _08990_ _09105_
+ VSS VSS VDD VDD _09106_ sky130_fd_sc_hd__or4_1
X_13160_ network.in_spk14_14 network.in_spk13_14 network.in_spk12_14
+ VSS VSS VDD VDD _09107_ sky130_fd_sc_hd__nor3_1
X_13161_ network.in_spk15_14 _09107_ network.in_spk11_14 VSS
+ VSS VDD VDD _09108_ sky130_fd_sc_hd__a21oi_1
X_13162_ network.in_spk10_14 network.in_spk09_14 network.in_spk08_14
+ _09108_ VSS VSS VDD VDD _09109_ sky130_fd_sc_hd__nor4_1
X_13163_ network.in_spk04_14 network.in_spk05_14 network.in_spk06_14
+ VSS VSS VDD VDD _09110_ sky130_fd_sc_hd__nor3_1
X_13164_ network.in_spk07_14 _09109_ _09110_ _08821_ VSS VSS
+ VDD VDD _09111_ sky130_fd_sc_hd__o211ai_1
X_13165_ network.in_spk00_14 network.in_spk01_14 _09103_ _09106_
+ _09111_ VSS VSS VDD VDD _09112_ sky130_fd_sc_hd__o311ai_0
X_13166_ network.in_spk02_14 network.in_spk03_14 network.in_spk01_14
+ VSS VSS VDD VDD _09113_ sky130_fd_sc_hd__nor3_1
X_13167_ _08820_ _08823_ _09113_ network.in_spk00_14 VSS VSS
+ VDD VDD _09114_ sky130_fd_sc_hd__a31oi_1
X_13168_ _08944_ _08945_ _09114_ VSS VSS VDD VDD _09115_ sky130_fd_sc_hd__and3_1
X_13169_ network.in_spk04_02 network.in_spk05_02 network.in_spk06_02
+ VSS VSS VDD VDD _09116_ sky130_fd_sc_hd__nor3_1
X_13170_ _08873_ _09116_ VSS VSS VDD VDD _09117_ sky130_fd_sc_hd__nand2_1
X_13171_ network.in_spk07_02 _09117_ VSS VSS VDD VDD _09118_
+ sky130_fd_sc_hd__nor2_1
X_13172_ network.in_spk14_02 network.in_spk15_02 VSS VSS VDD
+ VDD _09119_ sky130_fd_sc_hd__nor2_1
X_13173_ network.in_spk12_02 network.in_spk13_02 _09119_ _09077_
+ VSS VSS VDD VDD _09120_ sky130_fd_sc_hd__o31ai_1
X_13174_ network.in_spk02_02 network.in_spk03_02 VSS VSS VDD
+ VDD _09121_ sky130_fd_sc_hd__nor2_1
X_13175_ network.in_spk04_02 network.in_spk05_02 VSS VSS VDD
+ VDD _09122_ sky130_fd_sc_hd__nor2_1
X_13176_ network.in_spk06_02 network.in_spk07_02 _09122_ VSS
+ VSS VDD VDD _09123_ sky130_fd_sc_hd__o21ai_0
X_13177_ _09121_ _09123_ network.in_spk01_02 VSS VSS VDD VDD
+ _09124_ sky130_fd_sc_hd__a21oi_1
X_13178_ _09076_ _09118_ _09120_ _09124_ VSS VSS VDD VDD _09125_
+ sky130_fd_sc_hd__a31oi_1
X_13179_ network.in_spk00_02 net303 _08966_ VSS VSS VDD VDD
+ _09126_ sky130_fd_sc_hd__or3_1
Xplace276 _09024_ VSS VSS VDD VDD net275 sky130_fd_sc_hd__buf_4
X_13181_ network.in_spk08_10 network.in_spk09_10 VSS VSS VDD
+ VDD _09128_ sky130_fd_sc_hd__nor2_1
X_13182_ _09020_ _09128_ VSS VSS VDD VDD _09129_ sky130_fd_sc_hd__nand2_1
X_13183_ network.in_spk12_10 network.in_spk13_10 network.in_spk14_10
+ VSS VSS VDD VDD _09130_ sky130_fd_sc_hd__nor3_1
X_13184_ network.in_spk15_10 _09130_ network.in_spk10_10 network.in_spk11_10
+ VSS VSS VDD VDD _09131_ sky130_fd_sc_hd__a211oi_1
X_13185_ network.in_spk12_10 network.in_spk13_10 network.in_spk14_10
+ VSS VSS VDD VDD _09132_ sky130_fd_sc_hd__nor3b_1
X_13186_ network.in_spk06_10 network.in_spk07_10 VSS VSS VDD
+ VDD _09133_ sky130_fd_sc_hd__nor2_1
X_13187_ network.in_spk02_10 network.in_spk03_10 VSS VSS VDD
+ VDD _09134_ sky130_fd_sc_hd__nor2_1
X_13188_ network.in_spk04_10 network.in_spk05_10 _09133_ _09134_
+ VSS VSS VDD VDD _09135_ sky130_fd_sc_hd__o31ai_1
X_13189_ network.in_spk00_10 network.in_spk01_10 VSS VSS VDD
+ VDD _09136_ sky130_fd_sc_hd__nor2_1
X_13190_ _09020_ _08908_ _09132_ _09135_ _09136_ VSS VSS VDD
+ VDD _09137_ sky130_fd_sc_hd__a32oi_1
X_13191_ _09129_ _09131_ _09137_ VSS VSS VDD VDD _09138_ sky130_fd_sc_hd__o21a_1
X_13192_ network.in_spk01_10 network.in_spk02_10 network.in_spk03_10
+ VSS VSS VDD VDD _09139_ sky130_fd_sc_hd__nor3_1
X_13193_ _08906_ _08908_ _08910_ _09139_ network.in_spk00_10
+ VSS VSS VDD VDD _09140_ sky130_fd_sc_hd__a41oi_1
X_13194_ _08938_ net295 _09140_ VSS VSS VDD VDD _09141_ sky130_fd_sc_hd__nand3_1
X_13195_ network.in_spk02_03 network.in_spk03_03 VSS VSS VDD
+ VDD _09142_ sky130_fd_sc_hd__nor2_1
X_13196_ network.in_spk00_03 network.in_spk01_03 network.in_spk04_03
+ network.in_spk05_03 VSS VSS VDD VDD _09143_ sky130_fd_sc_hd__or4_1
X_13197_ network.in_spk08_03 network.in_spk09_03 VSS VSS VDD
+ VDD _09144_ sky130_fd_sc_hd__nor2_1
X_13198_ network.in_spk14_03 network.in_spk15_03 VSS VSS VDD
+ VDD _09145_ sky130_fd_sc_hd__nor2_1
X_13199_ network.in_spk10_03 network.in_spk11_03 VSS VSS VDD
+ VDD _09146_ sky130_fd_sc_hd__nor2_1
X_13200_ network.in_spk12_03 network.in_spk13_03 _09145_ _09146_
+ VSS VSS VDD VDD _09147_ sky130_fd_sc_hd__o31ai_1
X_13201_ _09144_ _09147_ network.in_spk06_03 network.in_spk07_03
+ VSS VSS VDD VDD _09148_ sky130_fd_sc_hd__a211oi_1
X_13202_ network.in_spk00_03 network.in_spk01_03 _09142_ _09143_
+ _09148_ VSS VSS VDD VDD _09149_ sky130_fd_sc_hd__o32ai_1
X_13203_ _08880_ _08881_ VSS VSS VDD VDD _09150_ sky130_fd_sc_hd__nor2_1
X_13204_ network.in_spk01_03 network.in_spk02_03 network.in_spk03_03
+ _08878_ VSS VSS VDD VDD _09151_ sky130_fd_sc_hd__nor4_1
X_13205_ _09150_ _09151_ network.in_spk00_03 _08857_ net308
+ VSS VSS VDD VDD _09152_ sky130_fd_sc_hd__a2111oi_0
X_13206_ network.in_spk00_00 network.in_spk01_00 network.in_spk02_00
+ network.in_spk03_00 VSS VSS VDD VDD _09153_ sky130_fd_sc_hd__or4_1
X_13207_ network.in_spk12_00 _09153_ _09068_ _08847_ VSS VSS
+ VDD VDD _09154_ sky130_fd_sc_hd__nor4b_1
X_13208_ network.in_spk13_00 _09154_ VSS VSS VDD VDD _09155_
+ sky130_fd_sc_hd__nand2b_1
X_13209_ network.in_spk14_00 network.in_spk15_00 VSS VSS VDD
+ VDD _09156_ sky130_fd_sc_hd__nor2_1
X_13210_ network.in_spk04_00 network.in_spk05_00 _09153_ VSS
+ VSS VDD VDD _09157_ sky130_fd_sc_hd__or3_1
X_13211_ network.in_spk10_00 network.in_spk11_00 VSS VSS VDD
+ VDD _09158_ sky130_fd_sc_hd__nor2_1
X_13212_ network.in_spk08_00 network.in_spk09_00 _09158_ VSS
+ VSS VDD VDD _09159_ sky130_fd_sc_hd__nor3_1
X_13213_ network.in_spk06_00 network.in_spk07_00 _09159_ VSS
+ VSS VDD VDD _09160_ sky130_fd_sc_hd__nor3_1
X_13214_ network.in_spk00_00 network.in_spk01_00 VSS VSS VDD
+ VDD _09161_ sky130_fd_sc_hd__nor2_1
X_13215_ network.in_spk02_00 network.in_spk03_00 _09161_ VSS
+ VSS VDD VDD _09162_ sky130_fd_sc_hd__o21ai_0
X_13216_ _09155_ _09156_ _09157_ _09160_ _09162_ VSS VSS VDD
+ VDD _09163_ sky130_fd_sc_hd__o221ai_1
X_13217_ network.in_spk02_01 network.in_spk03_01 VSS VSS VDD
+ VDD _09164_ sky130_fd_sc_hd__nor2_1
X_13218_ network.in_spk14_01 network.in_spk15_01 VSS VSS VDD
+ VDD _09165_ sky130_fd_sc_hd__nor2_1
X_13219_ network.in_spk12_01 network.in_spk13_01 _09165_ VSS
+ VSS VDD VDD _09166_ sky130_fd_sc_hd__nor3_1
X_13220_ network.in_spk04_01 network.in_spk05_01 VSS VSS VDD
+ VDD _09167_ sky130_fd_sc_hd__or2_2
X_13221_ network.in_spk08_01 network.in_spk09_01 _09167_ VSS
+ VSS VDD VDD _09168_ sky130_fd_sc_hd__nor3_1
X_13222_ network.in_spk10_01 network.in_spk11_01 _09166_ _09168_
+ VSS VSS VDD VDD _09169_ sky130_fd_sc_hd__o31ai_1
X_13223_ network.in_spk06_01 network.in_spk07_01 _09167_ VSS
+ VSS VDD VDD _09170_ sky130_fd_sc_hd__o21bai_1
X_13224_ network.in_spk00_01 network.in_spk01_01 _08964_ VSS
+ VSS VDD VDD _09171_ sky130_fd_sc_hd__or3_1
X_13225_ _09164_ _09169_ _09170_ _09171_ VSS VSS VDD VDD _09172_
+ sky130_fd_sc_hd__a31oi_1
X_13226_ _09149_ _09152_ _09163_ _09172_ VSS VSS VDD VDD _09173_
+ sky130_fd_sc_hd__a211oi_1
X_13227_ _09125_ _09126_ _09138_ _09141_ net291 VSS VSS VDD
+ VDD _09174_ sky130_fd_sc_hd__o221ai_1
X_13228_ network.in_spk08_07 network.in_spk09_07 VSS VSS VDD
+ VDD _09175_ sky130_fd_sc_hd__nor2_1
X_13229_ network.in_spk12_07 network.in_spk13_07 VSS VSS VDD
+ VDD _09176_ sky130_fd_sc_hd__nor2_1
X_13230_ network.in_spk14_07 _09176_ network.in_spk10_07 network.in_spk11_07
+ VSS VSS VDD VDD _09177_ sky130_fd_sc_hd__a211o_1
X_13231_ network.in_spk04_07 network.in_spk05_07 VSS VSS VDD
+ VDD _09178_ sky130_fd_sc_hd__nor2_1
X_13232_ network.in_spk06_07 _09178_ network.in_spk02_07 network.in_spk03_07
+ VSS VSS VDD VDD _09179_ sky130_fd_sc_hd__a211oi_1
X_13233_ network.in_spk00_07 network.in_spk01_07 _09179_ VSS
+ VSS VDD VDD _09180_ sky130_fd_sc_hd__nor3_1
X_13234_ network.in_spk14_07 VSS VSS VDD VDD _09181_ sky130_fd_sc_hd__inv_1
X_13235_ _09181_ network.in_spk15_07 _09176_ _08916_ network.in_spk07_07
+ VSS VSS VDD VDD _09182_ sky130_fd_sc_hd__a41oi_1
X_13236_ _08913_ _08994_ _09182_ VSS VSS VDD VDD _09183_ sky130_fd_sc_hd__nor3_1
X_13237_ _08995_ _09175_ _09177_ _09180_ _09183_ VSS VSS VDD
+ VDD _09184_ sky130_fd_sc_hd__a311oi_1
X_13238_ network.in_spk12_11 network.in_spk13_11 VSS VSS VDD
+ VDD _09185_ sky130_fd_sc_hd__nor2_1
X_13239_ network.in_spk14_11 _09185_ VSS VSS VDD VDD _09186_
+ sky130_fd_sc_hd__nand2_1
X_13240_ network.in_spk02_11 network.in_spk03_11 VSS VSS VDD
+ VDD _09187_ sky130_fd_sc_hd__nor2_1
X_13241_ network.in_spk04_11 network.in_spk05_11 _08886_ VSS
+ VSS VDD VDD _09188_ sky130_fd_sc_hd__or3_1
X_13242_ network.in_spk07_11 VSS VSS VDD VDD _09189_ sky130_fd_sc_hd__inv_1
X_13243_ network.in_spk08_11 network.in_spk09_11 VSS VSS VDD
+ VDD _09190_ sky130_fd_sc_hd__nor2_1
X_13244_ _09189_ network.in_spk10_11 _09190_ network.in_spk06_11
+ VSS VSS VDD VDD _09191_ sky130_fd_sc_hd__a31oi_1
X_13245_ network.in_spk00_11 network.in_spk01_11 _09187_ _09188_
+ _09191_ VSS VSS VDD VDD _09192_ sky130_fd_sc_hd__o32a_1
X_13246_ network.in_spk12_11 network.in_spk13_11 network.in_spk14_11
+ network.in_spk15_11 VSS VSS VDD VDD _09193_ sky130_fd_sc_hd__nor4b_1
X_13247_ network.in_spk08_11 network.in_spk09_11 network.in_spk10_11
+ VSS VSS VDD VDD _09194_ sky130_fd_sc_hd__nor3_1
X_13248_ network.in_spk11_11 _09193_ _09194_ VSS VSS VDD VDD
+ _09195_ sky130_fd_sc_hd__o21ai_0
X_13249_ _09189_ _09195_ _09188_ network.in_spk06_11 VSS VSS
+ VDD VDD _09196_ sky130_fd_sc_hd__a211o_1
X_13250_ _08978_ _08892_ _09186_ _09192_ _09196_ VSS VSS VDD
+ VDD _09197_ sky130_fd_sc_hd__o311a_1
X_13251_ network.in_spk08_11 network.in_spk09_11 network.in_spk10_11
+ network.in_spk11_11 VSS VSS VDD VDD _09198_ sky130_fd_sc_hd__nor4_1
X_13252_ network.in_spk01_11 network.in_spk02_11 network.in_spk03_11
+ VSS VSS VDD VDD _09199_ sky130_fd_sc_hd__nor3_1
X_13253_ _08976_ _09051_ _09198_ _09199_ network.in_spk00_11
+ VSS VSS VDD VDD _09200_ sky130_fd_sc_hd__a41oi_1
X_13254_ _08898_ _08905_ _08911_ _09200_ VSS VSS VDD VDD _09201_
+ sky130_fd_sc_hd__nand4_1
X_13255_ net303 _08883_ _08924_ _09201_ VSS VSS VDD VDD _09202_
+ sky130_fd_sc_hd__or4_1
X_13256_ network.in_spk00_07 _08959_ _09184_ _09197_ _09202_
+ VSS VSS VDD VDD _09203_ sky130_fd_sc_hd__o32ai_1
X_13257_ _09112_ _09115_ _09174_ _09203_ VSS VSS VDD VDD _09204_
+ sky130_fd_sc_hd__a211oi_1
X_13258_ _08903_ _08904_ VSS VSS VDD VDD _09205_ sky130_fd_sc_hd__nand2_1
X_13259_ network.in_spk12_09 _08901_ VSS VSS VDD VDD _09206_
+ sky130_fd_sc_hd__nand2b_1
X_13260_ network.in_spk14_09 network.in_spk15_09 VSS VSS VDD
+ VDD _09207_ sky130_fd_sc_hd__nor2_1
X_13261_ network.in_spk13_09 _09206_ _09207_ VSS VSS VDD VDD
+ _09208_ sky130_fd_sc_hd__nor3_1
X_13262_ network.in_spk10_09 _09090_ _09208_ VSS VSS VDD VDD
+ _09209_ sky130_fd_sc_hd__a21oi_1
X_13263_ network.in_spk00_09 network.in_spk01_09 VSS VSS VDD
+ VDD _09210_ sky130_fd_sc_hd__nor2_1
X_13264_ network.in_spk04_09 network.in_spk05_09 VSS VSS VDD
+ VDD _09211_ sky130_fd_sc_hd__nor2_1
X_13265_ network.in_spk06_09 _09211_ network.in_spk02_09 network.in_spk03_09
+ VSS VSS VDD VDD _09212_ sky130_fd_sc_hd__a211o_1
X_13266_ network.in_spk08_09 network.in_spk09_09 network.in_spk10_09
+ network.in_spk11_09 VSS VSS VDD VDD _09213_ sky130_fd_sc_hd__nor4b_1
X_13267_ network.in_spk04_09 network.in_spk05_09 network.in_spk06_09
+ _09094_ VSS VSS VDD VDD _09214_ sky130_fd_sc_hd__nor4_1
X_13268_ network.in_spk07_09 _09213_ _09214_ VSS VSS VDD VDD
+ _09215_ sky130_fd_sc_hd__o21ai_0
X_13269_ _09210_ _09212_ _09215_ VSS VSS VDD VDD _09216_ sky130_fd_sc_hd__a21boi_0
X_13270_ _09205_ _09209_ _09216_ VSS VSS VDD VDD _09217_ sky130_fd_sc_hd__o21ai_0
X_13271_ network.in_spk01_09 network.in_spk02_09 network.in_spk03_09
+ VSS VSS VDD VDD _09218_ sky130_fd_sc_hd__nor3_1
X_13272_ _08901_ _08902_ _08904_ _09218_ network.in_spk00_09
+ VSS VSS VDD VDD _09219_ sky130_fd_sc_hd__a41oi_1
X_13273_ _08898_ _09219_ VSS VSS VDD VDD _09220_ sky130_fd_sc_hd__nand2_1
X_13274_ net303 _08883_ _08924_ _09220_ VSS VSS VDD VDD _09221_
+ sky130_fd_sc_hd__nor4_1
X_13275_ network.in_spk02_13 network.in_spk03_13 VSS VSS VDD
+ VDD _09222_ sky130_fd_sc_hd__nor2_1
X_13276_ network.in_spk08_13 network.in_spk09_13 VSS VSS VDD
+ VDD _09223_ sky130_fd_sc_hd__nor2_1
X_13277_ network.in_spk10_13 network.in_spk11_13 _08834_ _09223_
+ VSS VSS VDD VDD _09224_ sky130_fd_sc_hd__o211ai_1
X_13278_ _09222_ _09224_ network.in_spk00_13 network.in_spk01_13
+ VSS VSS VDD VDD _09225_ sky130_fd_sc_hd__a211oi_1
X_13279_ network.in_spk06_13 network.in_spk07_13 VSS VSS VDD
+ VDD _09226_ sky130_fd_sc_hd__nor2_1
X_13280_ network.in_spk04_13 network.in_spk05_13 VSS VSS VDD
+ VDD _09227_ sky130_fd_sc_hd__nor2_1
X_13281_ net329 _09227_ VSS VSS VDD VDD _09228_ sky130_fd_sc_hd__nand2_1
X_13282_ network.in_spk12_13 network.in_spk13_13 VSS VSS VDD
+ VDD _09229_ sky130_fd_sc_hd__nor2_1
X_13283_ network.in_spk14_13 network.in_spk15_13 _09229_ VSS
+ VSS VDD VDD _09230_ sky130_fd_sc_hd__o21ai_0
X_13284_ net329 _08834_ _08835_ VSS VSS VDD VDD _09231_ sky130_fd_sc_hd__nand3_1
X_13285_ _09226_ _09228_ _09230_ _09231_ VSS VSS VDD VDD _09232_
+ sky130_fd_sc_hd__o22ai_1
X_13286_ _09225_ _09232_ VSS VSS VDD VDD _09233_ sky130_fd_sc_hd__nor2_1
X_13287_ network.in_spk00_12 network.in_spk01_12 VSS VSS VDD
+ VDD _09234_ sky130_fd_sc_hd__nor2_1
X_13288_ network.in_spk14_12 _08830_ network.in_spk10_12 VSS
+ VSS VDD VDD _09235_ sky130_fd_sc_hd__a21oi_1
X_13289_ network.in_spk08_12 network.in_spk09_12 _09235_ _08827_
+ VSS VSS VDD VDD _09236_ sky130_fd_sc_hd__o31ai_1
X_13290_ network.in_spk11_12 network.in_spk12_12 network.in_spk13_12
+ VSS VSS VDD VDD _09237_ sky130_fd_sc_hd__or3_1
X_13291_ network.in_spk14_12 _09237_ VSS VSS VDD VDD _09238_
+ sky130_fd_sc_hd__nor2_1
X_13292_ network.in_spk15_12 _09238_ network.in_spk11_12 VSS
+ VSS VDD VDD _09239_ sky130_fd_sc_hd__a21oi_1
X_13293_ network.in_spk03_12 _08825_ VSS VSS VDD VDD _09240_
+ sky130_fd_sc_hd__nand2_1
X_13294_ _08829_ _09239_ _09240_ VSS VSS VDD VDD _09241_ sky130_fd_sc_hd__o21ai_0
X_13295_ network.in_spk02_12 _09234_ _09034_ _09236_ _09241_
+ VSS VSS VDD VDD _09242_ sky130_fd_sc_hd__a221oi_1
X_13296_ _09048_ _09233_ _09242_ _09086_ VSS VSS VDD VDD _09243_
+ sky130_fd_sc_hd__o22ai_1
X_13297_ network.in_spk13_15 network.in_spk12_15 VSS VSS VDD
+ VDD _09244_ sky130_fd_sc_hd__nor2_1
X_13298_ network.in_spk09_15 network.in_spk08_15 VSS VSS VDD
+ VDD _09245_ sky130_fd_sc_hd__nor2_1
X_13299_ network.in_spk14_15 network.in_spk13_15 network.in_spk12_15
+ VSS VSS VDD VDD _09246_ sky130_fd_sc_hd__nor3_1
X_13300_ network.in_spk15_15 _09246_ network.in_spk07_15 network.in_spk11_15
+ VSS VSS VDD VDD _09247_ sky130_fd_sc_hd__a211oi_1
X_13301_ network.in_spk07_15 _09038_ VSS VSS VDD VDD _09248_
+ sky130_fd_sc_hd__nor2b_1
X_13302_ _09030_ _09247_ _09248_ VSS VSS VDD VDD _09249_ sky130_fd_sc_hd__nor3_1
X_13303_ network.in_spk06_15 _08839_ VSS VSS VDD VDD _09250_
+ sky130_fd_sc_hd__nand2_1
X_13304_ _08838_ _09250_ _09028_ VSS VSS VDD VDD _09251_ sky130_fd_sc_hd__a21boi_0
X_13305_ network.in_spk10_15 _09031_ _09245_ _09249_ _09251_
+ VSS VSS VDD VDD _09252_ sky130_fd_sc_hd__a311o_1
X_13306_ network.in_spk14_15 _08842_ _09244_ _09252_ VSS VSS
+ VDD VDD _09253_ sky130_fd_sc_hd__a31oi_1
X_13307_ _08935_ _09253_ VSS VSS VDD VDD _09254_ sky130_fd_sc_hd__nor2_1
X_13308_ network.in_spk06_08 _08985_ network.in_spk02_08 network.in_spk03_08
+ VSS VSS VDD VDD _09255_ sky130_fd_sc_hd__a211oi_1
X_13309_ network.in_spk08_08 network.in_spk09_08 VSS VSS VDD
+ VDD _09256_ sky130_fd_sc_hd__nor2_1
X_13310_ network.in_spk14_08 network.in_spk15_08 VSS VSS VDD
+ VDD _09257_ sky130_fd_sc_hd__nor2_1
X_13311_ network.in_spk10_08 network.in_spk11_08 VSS VSS VDD
+ VDD _09258_ sky130_fd_sc_hd__nor2_1
X_13312_ network.in_spk12_08 network.in_spk13_08 _09257_ _09258_
+ VSS VSS VDD VDD _09259_ sky130_fd_sc_hd__o31ai_1
X_13313_ _09256_ _09259_ network.in_spk07_08 VSS VSS VDD VDD
+ _09260_ sky130_fd_sc_hd__a21oi_1
X_13314_ network.in_spk01_08 _09255_ _09260_ _08986_ VSS VSS
+ VDD VDD _09261_ sky130_fd_sc_hd__o22a_1
X_13315_ network.in_spk00_08 _08898_ _08940_ VSS VSS VDD VDD
+ _09262_ sky130_fd_sc_hd__or3_1
X_13316_ network.in_spk02_05 network.in_spk03_05 VSS VSS VDD
+ VDD _09263_ sky130_fd_sc_hd__nor2_1
X_13317_ network.in_spk08_05 network.in_spk09_05 network.in_spk10_05
+ VSS VSS VDD VDD _09264_ sky130_fd_sc_hd__nor3b_1
X_13318_ network.in_spk07_05 _09264_ VSS VSS VDD VDD _09265_
+ sky130_fd_sc_hd__nor2b_1
X_13319_ network.in_spk04_05 network.in_spk05_05 VSS VSS VDD
+ VDD _09266_ sky130_fd_sc_hd__nor2_1
X_13320_ network.in_spk06_05 _09265_ _09266_ VSS VSS VDD VDD
+ _09267_ sky130_fd_sc_hd__o21ai_0
X_13321_ _09263_ _09267_ network.in_spk00_05 network.in_spk01_05
+ VSS VSS VDD VDD _09268_ sky130_fd_sc_hd__a211oi_1
X_13322_ network.in_spk12_05 network.in_spk13_05 VSS VSS VDD
+ VDD _09269_ sky130_fd_sc_hd__nor2_1
X_13323_ _08867_ _08868_ _08869_ VSS VSS VDD VDD _09270_ sky130_fd_sc_hd__nor3_1
X_13324_ network.in_spk14_05 _09269_ _09270_ VSS VSS VDD VDD
+ _09271_ sky130_fd_sc_hd__nand3_1
X_13325_ network.in_spk12_05 network.in_spk13_05 network.in_spk14_05
+ network.in_spk15_05 VSS VSS VDD VDD _09272_ sky130_fd_sc_hd__nor4b_1
X_13326_ network.in_spk08_05 network.in_spk09_05 network.in_spk10_05
+ VSS VSS VDD VDD _09273_ sky130_fd_sc_hd__nor3_1
X_13327_ network.in_spk11_05 _09272_ _09273_ VSS VSS VDD VDD
+ _09274_ sky130_fd_sc_hd__o21a_1
X_13328_ network.in_spk00_05 network.in_spk01_05 network.in_spk02_05
+ network.in_spk03_05 VSS VSS VDD VDD _09275_ sky130_fd_sc_hd__nor4_1
X_13329_ network.in_spk06_05 _09275_ _09266_ VSS VSS VDD VDD
+ _09276_ sky130_fd_sc_hd__nand3b_1
X_13330_ network.in_spk07_05 _09274_ _09276_ VSS VSS VDD VDD
+ _09277_ sky130_fd_sc_hd__o21bai_1
X_13331_ _09271_ _09277_ VSS VSS VDD VDD _09278_ sky130_fd_sc_hd__nand2_1
X_13332_ network.in_spk12_05 _09272_ _09049_ VSS VSS VDD VDD
+ _09279_ sky130_fd_sc_hd__o21a_1
X_13333_ _09264_ _09279_ _09016_ VSS VSS VDD VDD _09280_ sky130_fd_sc_hd__o21ai_0
X_13334_ network.in_spk08_05 network.in_spk09_05 VSS VSS VDD
+ VDD _09281_ sky130_fd_sc_hd__nor2_1
X_13335_ network.in_spk04_05 network.in_spk05_05 network.in_spk06_05
+ network.in_spk07_05 VSS VSS VDD VDD _09282_ sky130_fd_sc_hd__nor4_1
X_13336_ network.in_spk10_05 VSS VSS VDD VDD _09283_ sky130_fd_sc_hd__inv_1
X_13337_ _09283_ network.in_spk11_05 network.in_spk01_05 VSS
+ VSS VDD VDD _09284_ sky130_fd_sc_hd__a21oi_1
X_13338_ _09281_ _09263_ _09282_ _09284_ network.in_spk00_05
+ VSS VSS VDD VDD _09285_ sky130_fd_sc_hd__a41o_1
X_13339_ network.in_spk13_05 network.in_spk14_05 VSS VSS VDD
+ VDD _09286_ sky130_fd_sc_hd__nor2_1
X_13340_ network.in_spk12_05 _09286_ VSS VSS VDD VDD _09287_
+ sky130_fd_sc_hd__nor2_1
X_13341_ _09270_ _09287_ VSS VSS VDD VDD _09288_ sky130_fd_sc_hd__nand2_1
X_13342_ _08968_ _08870_ _08966_ _09066_ VSS VSS VDD VDD _09289_
+ sky130_fd_sc_hd__nand4_1
X_13343_ _09280_ _09285_ _09288_ _09289_ _08857_ VSS VSS VDD
+ VDD _09290_ sky130_fd_sc_hd__a311oi_1
X_13344_ _09268_ _09278_ _09290_ VSS VSS VDD VDD _09291_ sky130_fd_sc_hd__o21ai_0
X_13345_ network.in_spk06_06 network.in_spk07_06 VSS VSS VDD
+ VDD _09292_ sky130_fd_sc_hd__nor2_1
X_13346_ network.in_spk04_06 network.in_spk05_06 _09292_ VSS
+ VSS VDD VDD _09293_ sky130_fd_sc_hd__nor3_1
X_13347_ network.in_spk02_06 network.in_spk03_06 _09293_ VSS
+ VSS VDD VDD _09294_ sky130_fd_sc_hd__nor3_1
X_13348_ network.in_spk00_06 network.in_spk01_06 _09294_ VSS
+ VSS VDD VDD _09295_ sky130_fd_sc_hd__nor3_1
X_13349_ network.in_spk14_06 network.in_spk15_06 VSS VSS VDD
+ VDD _09296_ sky130_fd_sc_hd__nor2_1
X_13350_ network.in_spk12_06 network.in_spk13_06 _09296_ VSS
+ VSS VDD VDD _09297_ sky130_fd_sc_hd__nor3_1
X_13351_ network.in_spk10_06 network.in_spk11_06 _09297_ VSS
+ VSS VDD VDD _09298_ sky130_fd_sc_hd__nor3_1
X_13352_ network.in_spk08_06 network.in_spk09_06 _09011_ _09298_
+ VSS VSS VDD VDD _09299_ sky130_fd_sc_hd__nor4_1
X_13353_ network.in_spk02_06 network.in_spk03_06 network.in_spk01_06
+ VSS VSS VDD VDD _09300_ sky130_fd_sc_hd__nor3_1
X_13354_ _08918_ _09042_ VSS VSS VDD VDD _09301_ sky130_fd_sc_hd__nor2_1
X_13355_ _08922_ _09300_ _09301_ network.in_spk00_06 VSS VSS
+ VDD VDD _09302_ sky130_fd_sc_hd__a31o_2
X_13356_ net303 _08883_ _09302_ VSS VSS VDD VDD _09303_ sky130_fd_sc_hd__or3_1
X_13357_ _09295_ _09299_ _09303_ VSS VSS VDD VDD _09304_ sky130_fd_sc_hd__o21bai_1
X_13358_ network.in_spk12_04 network.in_spk13_04 VSS VSS VDD
+ VDD _09305_ sky130_fd_sc_hd__nor2_1
X_13359_ _09005_ _09006_ _09073_ VSS VSS VDD VDD _09306_ sky130_fd_sc_hd__nor3_1
X_13360_ network.in_spk14_04 network.in_spk15_04 VSS VSS VDD
+ VDD _09307_ sky130_fd_sc_hd__nor2b_1
X_13361_ _09305_ _09307_ network.in_spk10_04 network.in_spk11_04
+ VSS VSS VDD VDD _09308_ sky130_fd_sc_hd__a211oi_1
X_13362_ network.in_spk08_04 network.in_spk09_04 _09308_ _09007_
+ VSS VSS VDD VDD _09309_ sky130_fd_sc_hd__nor4b_1
X_13363_ network.in_spk02_04 network.in_spk03_04 VSS VSS VDD
+ VDD _09310_ sky130_fd_sc_hd__nor2_1
X_13364_ network.in_spk04_04 network.in_spk05_04 VSS VSS VDD
+ VDD _09311_ sky130_fd_sc_hd__nor2_1
X_13365_ network.in_spk06_04 network.in_spk07_04 _09311_ VSS
+ VSS VDD VDD _09312_ sky130_fd_sc_hd__o21ai_0
X_13366_ _09310_ _09312_ network.in_spk01_04 VSS VSS VDD VDD
+ _09313_ sky130_fd_sc_hd__a21oi_1
X_13367_ network.in_spk14_04 _09305_ _09306_ _09309_ _09313_
+ VSS VSS VDD VDD _09314_ sky130_fd_sc_hd__a311oi_1
X_13368_ net309 net302 _08951_ VSS VSS VDD VDD _09315_ sky130_fd_sc_hd__nand3_1
X_13369_ network.in_spk00_04 _09314_ _09315_ VSS VSS VDD VDD
+ _09316_ sky130_fd_sc_hd__or3_1
X_13370_ _09261_ _09262_ _09291_ _09304_ _09316_ VSS VSS VDD
+ VDD _09317_ sky130_fd_sc_hd__o2111ai_1
X_13371_ _09217_ _09221_ _09243_ _09254_ _09317_ VSS VSS VDD
+ VDD _09318_ sky130_fd_sc_hd__a2111oi_0
X_13372_ _09204_ _09318_ _08957_ VSS VSS VDD VDD _01729_ sky130_fd_sc_hd__a21oi_1
X_13373_ network.in_spk04_14 VSS VSS VDD VDD _09319_ sky130_fd_sc_hd__inv_1
X_13374_ _09319_ network.in_spk05_14 network.in_spk03_14 VSS
+ VSS VDD VDD _09320_ sky130_fd_sc_hd__a21oi_1
X_13375_ network.in_spk02_14 _09320_ VSS VSS VDD VDD _09321_
+ sky130_fd_sc_hd__nor2_1
X_13376_ network.in_spk01_14 _09321_ VSS VSS VDD VDD _09322_
+ sky130_fd_sc_hd__nor2_1
X_13377_ network.in_spk12_14 VSS VSS VDD VDD _09323_ sky130_fd_sc_hd__inv_1
X_13378_ network.in_spk08_14 VSS VSS VDD VDD _09324_ sky130_fd_sc_hd__inv_1
X_13379_ network.in_spk13_14 _09323_ _09097_ network.in_spk09_14
+ _09324_ VSS VSS VDD VDD _09325_ sky130_fd_sc_hd__a32oi_1
X_13380_ network.in_spk00_14 _09322_ _09325_ _08990_ _09111_
+ VSS VSS VDD VDD _09326_ sky130_fd_sc_hd__o221ai_1
X_13381_ network.in_spk12_15 network.in_spk11_15 network.in_spk10_15
+ network.in_spk13_15 VSS VSS VDD VDD _09327_ sky130_fd_sc_hd__nor4b_1
X_13382_ network.in_spk09_15 _09327_ VSS VSS VDD VDD _09328_
+ sky130_fd_sc_hd__nor2_1
X_13383_ network.in_spk08_15 _09328_ VSS VSS VDD VDD _09329_
+ sky130_fd_sc_hd__nor2_1
X_13384_ network.in_spk04_15 VSS VSS VDD VDD _09330_ sky130_fd_sc_hd__inv_1
X_13385_ network.in_spk05_15 _09330_ network.in_spk03_15 VSS
+ VSS VDD VDD _09331_ sky130_fd_sc_hd__a21oi_1
X_13386_ network.in_spk02_15 _09331_ network.in_spk01_15 VSS
+ VSS VDD VDD _09332_ sky130_fd_sc_hd__o21bai_1
X_13387_ _09031_ _09329_ _09332_ _09249_ VSS VSS VDD VDD _09333_
+ sky130_fd_sc_hd__a211oi_1
X_13388_ network.in_spk00_15 _08935_ _09333_ VSS VSS VDD VDD
+ _09334_ sky130_fd_sc_hd__nor3_1
X_13389_ network.in_spk07_12 VSS VSS VDD VDD _09335_ sky130_fd_sc_hd__inv_1
X_13390_ network.in_spk10_12 network.in_spk11_12 network.in_spk12_12
+ network.in_spk13_12 VSS VSS VDD VDD _09336_ sky130_fd_sc_hd__nor4b_1
X_13391_ network.in_spk09_12 _09336_ network.in_spk08_12 VSS
+ VSS VDD VDD _09337_ sky130_fd_sc_hd__o21bai_1
X_13392_ _09335_ _09337_ network.in_spk06_12 VSS VSS VDD VDD
+ _09338_ sky130_fd_sc_hd__a21oi_1
X_13393_ network.in_spk05_12 _09338_ VSS VSS VDD VDD _09339_
+ sky130_fd_sc_hd__nor2_1
X_13394_ network.in_spk03_12 network.in_spk04_12 _09085_ _09339_
+ VSS VSS VDD VDD _09340_ sky130_fd_sc_hd__nor4_1
X_13395_ network.in_spk00_12 _08925_ _08971_ VSS VSS VDD VDD
+ _09341_ sky130_fd_sc_hd__nor3_1
X_13396_ network.in_spk01_12 _09241_ _09340_ _09341_ VSS VSS
+ VDD VDD _09342_ sky130_fd_sc_hd__o31a_1
X_13397_ _09115_ _09326_ _09334_ _09342_ VSS VSS VDD VDD _09343_
+ sky130_fd_sc_hd__a211oi_1
X_13398_ network.in_spk13_04 _09307_ VSS VSS VDD VDD _09344_
+ sky130_fd_sc_hd__nor2_1
X_13399_ network.in_spk12_04 _09344_ VSS VSS VDD VDD _09345_
+ sky130_fd_sc_hd__nor2_1
X_13400_ _09306_ _09345_ VSS VSS VDD VDD _09346_ sky130_fd_sc_hd__nand2_1
X_13401_ network.in_spk02_04 VSS VSS VDD VDD _09347_ sky130_fd_sc_hd__inv_1
X_13402_ _09347_ network.in_spk03_04 network.in_spk01_04 VSS
+ VSS VDD VDD _09348_ sky130_fd_sc_hd__a21oi_1
X_13403_ network.in_spk10_04 VSS VSS VDD VDD _09349_ sky130_fd_sc_hd__inv_1
X_13404_ _09349_ network.in_spk11_04 network.in_spk09_04 VSS
+ VSS VDD VDD _09350_ sky130_fd_sc_hd__a21oi_1
X_13405_ network.in_spk08_04 _09350_ network.in_spk07_04 VSS
+ VSS VDD VDD _09351_ sky130_fd_sc_hd__o21ba_2
X_13406_ network.in_spk06_04 _09351_ VSS VSS VDD VDD _09352_
+ sky130_fd_sc_hd__nor2_1
X_13407_ network.in_spk04_04 _09005_ VSS VSS VDD VDD _09353_
+ sky130_fd_sc_hd__nor2_1
X_13408_ network.in_spk05_04 _09352_ _09353_ VSS VSS VDD VDD
+ _09354_ sky130_fd_sc_hd__o21ai_0
X_13409_ _09346_ _09348_ _09354_ _09315_ network.in_spk00_04
+ VSS VSS VDD VDD _09355_ sky130_fd_sc_hd__a311oi_2
X_13410_ network.in_spk08_05 network.in_spk09_05 _09016_ VSS
+ VSS VDD VDD _09356_ sky130_fd_sc_hd__nand3b_1
X_13411_ network.in_spk03_05 VSS VSS VDD VDD _09357_ sky130_fd_sc_hd__inv_1
X_13412_ network.in_spk04_05 network.in_spk05_05 VSS VSS VDD
+ VDD _09358_ sky130_fd_sc_hd__nand2b_1
X_13413_ _09357_ _09358_ network.in_spk02_05 VSS VSS VDD VDD
+ _09359_ sky130_fd_sc_hd__a21oi_1
X_13414_ network.in_spk01_05 _09359_ network.in_spk00_05 VSS
+ VSS VDD VDD _09360_ sky130_fd_sc_hd__o21bai_1
X_13415_ network.in_spk12_05 network.in_spk13_05 _09270_ VSS
+ VSS VDD VDD _09361_ sky130_fd_sc_hd__nand3b_1
X_13416_ _09277_ _09356_ _09360_ _09361_ VSS VSS VDD VDD _09362_
+ sky130_fd_sc_hd__nand4_1
X_13417_ _09290_ _09362_ VSS VSS VDD VDD _09363_ sky130_fd_sc_hd__nand2_1
X_13418_ network.in_spk01_01 network.in_spk02_01 network.in_spk03_01
+ VSS VSS VDD VDD _09364_ sky130_fd_sc_hd__nor3_1
X_13419_ _08850_ _08962_ _09364_ _08964_ network.in_spk00_01
+ VSS VSS VDD VDD _09365_ sky130_fd_sc_hd__a311oi_1
X_13420_ network.in_spk06_01 _08849_ _09167_ VSS VSS VDD VDD
+ _09366_ sky130_fd_sc_hd__nor3_1
X_13421_ network.in_spk14_01 network.in_spk15_01 VSS VSS VDD
+ VDD _09367_ sky130_fd_sc_hd__nor2b_1
X_13422_ network.in_spk13_01 _09367_ _09069_ VSS VSS VDD VDD
+ _09368_ sky130_fd_sc_hd__o21ai_0
X_13423_ network.in_spk08_01 VSS VSS VDD VDD _09369_ sky130_fd_sc_hd__inv_1
X_13424_ network.in_spk08_01 network.in_spk10_01 VSS VSS VDD
+ VDD _09370_ sky130_fd_sc_hd__nor2_1
X_13425_ _09369_ network.in_spk09_01 network.in_spk11_01 _09370_
+ network.in_spk07_01 VSS VSS VDD VDD _09371_ sky130_fd_sc_hd__a221oi_1
X_13426_ network.in_spk12_01 _09368_ _09371_ VSS VSS VDD VDD
+ _09372_ sky130_fd_sc_hd__o21ai_0
X_13427_ network.in_spk04_01 VSS VSS VDD VDD _09373_ sky130_fd_sc_hd__inv_1
X_13428_ _09373_ network.in_spk05_01 network.in_spk03_01 VSS
+ VSS VDD VDD _09374_ sky130_fd_sc_hd__a21oi_1
X_13429_ network.in_spk02_01 _09374_ VSS VSS VDD VDD _09375_
+ sky130_fd_sc_hd__nor2_1
X_13430_ _09366_ _09372_ network.in_spk01_01 _09375_ VSS VSS
+ VDD VDD _09376_ sky130_fd_sc_hd__a211o_1
X_13431_ network.in_spk09_00 VSS VSS VDD VDD _09377_ sky130_fd_sc_hd__inv_1
X_13432_ network.in_spk10_00 network.in_spk11_00 VSS VSS VDD
+ VDD _09378_ sky130_fd_sc_hd__nand2b_1
X_13433_ _09377_ _09378_ network.in_spk08_00 VSS VSS VDD VDD
+ _09379_ sky130_fd_sc_hd__a21oi_1
X_13434_ network.in_spk07_00 _09379_ VSS VSS VDD VDD _09380_
+ sky130_fd_sc_hd__nor2_1
X_13435_ network.in_spk03_00 VSS VSS VDD VDD _09381_ sky130_fd_sc_hd__inv_1
X_13436_ network.in_spk04_00 network.in_spk05_00 VSS VSS VDD
+ VDD _09382_ sky130_fd_sc_hd__nand2b_1
X_13437_ _09381_ _09382_ network.in_spk02_00 VSS VSS VDD VDD
+ _09383_ sky130_fd_sc_hd__a21oi_1
X_13438_ network.in_spk01_00 _09383_ network.in_spk00_00 VSS
+ VSS VDD VDD _09384_ sky130_fd_sc_hd__o21bai_1
X_13439_ network.in_spk14_00 network.in_spk15_00 VSS VSS VDD
+ VDD _09385_ sky130_fd_sc_hd__nor2b_1
X_13440_ network.in_spk13_00 _09385_ _09154_ VSS VSS VDD VDD
+ _09386_ sky130_fd_sc_hd__o21ai_0
X_13441_ network.in_spk06_00 _09157_ _09380_ _09384_ _09386_
+ VSS VSS VDD VDD _09387_ sky130_fd_sc_hd__o311ai_0
X_13442_ _09365_ _09376_ _09387_ VSS VSS VDD VDD _09388_ sky130_fd_sc_hd__a21oi_1
X_13443_ network.in_spk14_03 VSS VSS VDD VDD _09389_ sky130_fd_sc_hd__inv_1
X_13444_ _09389_ network.in_spk15_03 network.in_spk13_03 VSS
+ VSS VDD VDD _09390_ sky130_fd_sc_hd__a21o_1
X_13445_ network.in_spk10_03 network.in_spk11_03 network.in_spk12_03
+ VSS VSS VDD VDD _09391_ sky130_fd_sc_hd__nor3_1
X_13446_ _09390_ _09391_ network.in_spk09_03 VSS VSS VDD VDD
+ _09392_ sky130_fd_sc_hd__a21oi_1
X_13447_ network.in_spk08_03 _08876_ _08878_ _09392_ VSS VSS
+ VDD VDD _09393_ sky130_fd_sc_hd__nor4_1
X_13448_ network.in_spk03_03 VSS VSS VDD VDD _09394_ sky130_fd_sc_hd__inv_1
X_13449_ network.in_spk04_03 network.in_spk05_03 VSS VSS VDD
+ VDD _09395_ sky130_fd_sc_hd__nand2b_1
X_13450_ _09394_ _09395_ network.in_spk02_03 VSS VSS VDD VDD
+ _09396_ sky130_fd_sc_hd__a21oi_1
X_13451_ network.in_spk01_03 _09396_ VSS VSS VDD VDD _03344_
+ sky130_fd_sc_hd__nor2_1
X_13452_ network.in_spk08_03 network.in_spk09_03 network.in_spk10_03
+ network.in_spk11_03 VSS VSS VDD VDD _03345_ sky130_fd_sc_hd__nor4b_1
X_13453_ network.in_spk04_03 network.in_spk05_03 network.in_spk06_03
+ _08876_ VSS VSS VDD VDD _03346_ sky130_fd_sc_hd__nor4_1
X_13454_ network.in_spk07_03 _03345_ _03346_ VSS VSS VDD VDD
+ _03347_ sky130_fd_sc_hd__o21ai_0
X_13455_ network.in_spk00_03 _03344_ _03347_ VSS VSS VDD VDD
+ _03348_ sky130_fd_sc_hd__o21ai_0
X_13456_ _09393_ _03348_ _09152_ VSS VSS VDD VDD _03349_ sky130_fd_sc_hd__o21ai_0
X_13457_ network.in_spk14_02 network.in_spk15_02 VSS VSS VDD
+ VDD _03350_ sky130_fd_sc_hd__nor2b_1
X_13458_ network.in_spk13_02 _03350_ _08872_ VSS VSS VDD VDD
+ _03351_ sky130_fd_sc_hd__o21ai_0
X_13459_ network.in_spk10_02 VSS VSS VDD VDD _03352_ sky130_fd_sc_hd__inv_1
X_13460_ _03352_ network.in_spk11_02 network.in_spk09_02 VSS
+ VSS VDD VDD _03353_ sky130_fd_sc_hd__a21oi_1
X_13461_ network.in_spk07_02 VSS VSS VDD VDD _03354_ sky130_fd_sc_hd__inv_1
X_13462_ network.in_spk12_02 _03351_ _03353_ network.in_spk08_02
+ _03354_ VSS VSS VDD VDD _03355_ sky130_fd_sc_hd__o221ai_1
X_13463_ network.in_spk04_02 VSS VSS VDD VDD _03356_ sky130_fd_sc_hd__inv_1
X_13464_ _03356_ network.in_spk05_02 network.in_spk03_02 VSS
+ VSS VDD VDD _03357_ sky130_fd_sc_hd__a21oi_1
X_13465_ network.in_spk02_02 _03357_ VSS VSS VDD VDD _03358_
+ sky130_fd_sc_hd__nor2_1
X_13466_ _08873_ _09116_ _03355_ _03358_ network.in_spk01_02
+ VSS VSS VDD VDD _03359_ sky130_fd_sc_hd__a311oi_1
X_13467_ network.in_spk04_06 network.in_spk05_06 network.in_spk06_06
+ VSS VSS VDD VDD _03360_ sky130_fd_sc_hd__nor3_1
X_13468_ network.in_spk10_06 VSS VSS VDD VDD _03361_ sky130_fd_sc_hd__inv_1
X_13469_ _03361_ network.in_spk11_06 network.in_spk09_06 VSS
+ VSS VDD VDD _03362_ sky130_fd_sc_hd__a21oi_1
X_13470_ network.in_spk08_06 _03362_ network.in_spk07_06 VSS
+ VSS VDD VDD _03363_ sky130_fd_sc_hd__o21bai_1
X_13471_ network.in_spk01_06 VSS VSS VDD VDD _03364_ sky130_fd_sc_hd__inv_1
X_13472_ network.in_spk04_06 network.in_spk05_06 VSS VSS VDD
+ VDD _03365_ sky130_fd_sc_hd__nor2b_1
X_13473_ network.in_spk03_06 _03365_ network.in_spk02_06 VSS
+ VSS VDD VDD _03366_ sky130_fd_sc_hd__o21bai_1
X_13474_ _03364_ _03366_ network.in_spk00_06 VSS VSS VDD VDD
+ _03367_ sky130_fd_sc_hd__a21oi_1
X_13475_ network.in_spk14_06 VSS VSS VDD VDD _03368_ sky130_fd_sc_hd__inv_1
X_13476_ _03368_ network.in_spk15_06 network.in_spk13_06 VSS
+ VSS VDD VDD _03369_ sky130_fd_sc_hd__a21oi_1
X_13477_ network.in_spk12_06 _08949_ _03369_ VSS VSS VDD VDD
+ _03370_ sky130_fd_sc_hd__nor3_1
X_13478_ _08919_ _03360_ _03363_ _03367_ _03370_ VSS VSS VDD
+ VDD _03371_ sky130_fd_sc_hd__a311oi_1
X_13479_ _09126_ _03359_ _03371_ _09303_ VSS VSS VDD VDD _03372_
+ sky130_fd_sc_hd__o22a_1
X_13480_ _09363_ _09388_ _03349_ _03372_ VSS VSS VDD VDD _03373_
+ sky130_fd_sc_hd__nand4_1
X_13481_ network.in_spk13_08 VSS VSS VDD VDD _03374_ sky130_fd_sc_hd__inv_1
X_13482_ network.in_spk14_08 network.in_spk15_08 VSS VSS VDD
+ VDD _03375_ sky130_fd_sc_hd__nand2b_1
X_13483_ _03374_ _03375_ network.in_spk12_08 VSS VSS VDD VDD
+ _03376_ sky130_fd_sc_hd__a21oi_1
X_13484_ network.in_spk11_08 _03376_ VSS VSS VDD VDD _03377_
+ sky130_fd_sc_hd__nor2_1
X_13485_ network.in_spk07_08 network.in_spk09_08 VSS VSS VDD
+ VDD _03378_ sky130_fd_sc_hd__nor2_1
X_13486_ network.in_spk10_08 _03377_ _03378_ VSS VSS VDD VDD
+ _03379_ sky130_fd_sc_hd__o21ai_0
X_13487_ network.in_spk07_08 VSS VSS VDD VDD _03380_ sky130_fd_sc_hd__inv_1
X_13488_ _03380_ network.in_spk08_08 _08986_ VSS VSS VDD VDD
+ _03381_ sky130_fd_sc_hd__a21oi_1
X_13489_ network.in_spk04_08 VSS VSS VDD VDD _03382_ sky130_fd_sc_hd__inv_1
X_13490_ _03382_ network.in_spk05_08 network.in_spk03_08 VSS
+ VSS VDD VDD _03383_ sky130_fd_sc_hd__a21oi_1
X_13491_ network.in_spk02_08 _03383_ VSS VSS VDD VDD _03384_
+ sky130_fd_sc_hd__nor2_1
X_13492_ _03379_ _03381_ network.in_spk01_08 _03384_ VSS VSS
+ VDD VDD _03385_ sky130_fd_sc_hd__a211oi_1
X_13493_ network.in_spk00_13 VSS VSS VDD VDD _03386_ sky130_fd_sc_hd__inv_1
X_13494_ network.in_spk04_13 VSS VSS VDD VDD _03387_ sky130_fd_sc_hd__inv_1
X_13495_ _03387_ network.in_spk05_13 network.in_spk03_13 VSS
+ VSS VDD VDD _03388_ sky130_fd_sc_hd__a21oi_1
X_13496_ network.in_spk01_13 VSS VSS VDD VDD _03389_ sky130_fd_sc_hd__inv_1
X_13497_ network.in_spk02_13 _03388_ _03389_ VSS VSS VDD VDD
+ _03390_ sky130_fd_sc_hd__o21ai_0
X_13498_ network.in_spk06_13 _09228_ VSS VSS VDD VDD _03391_
+ sky130_fd_sc_hd__nor2_1
X_13499_ network.in_spk10_13 VSS VSS VDD VDD _03392_ sky130_fd_sc_hd__inv_1
X_13500_ _03392_ network.in_spk11_13 network.in_spk09_13 VSS
+ VSS VDD VDD _03393_ sky130_fd_sc_hd__a21oi_1
X_13501_ network.in_spk08_13 _03393_ network.in_spk07_13 VSS
+ VSS VDD VDD _03394_ sky130_fd_sc_hd__o21bai_1
X_13502_ network.in_spk14_13 VSS VSS VDD VDD _03395_ sky130_fd_sc_hd__inv_1
X_13503_ _03395_ network.in_spk15_13 network.in_spk13_13 VSS
+ VSS VDD VDD _03396_ sky130_fd_sc_hd__a21oi_1
X_13504_ network.in_spk12_13 _09231_ _03396_ VSS VSS VDD VDD
+ _03397_ sky130_fd_sc_hd__nor3_1
X_13505_ _03386_ _03390_ _03391_ _03394_ _03397_ VSS VSS VDD
+ VDD _03398_ sky130_fd_sc_hd__a221o_1
X_13506_ network.in_spk14_09 VSS VSS VDD VDD _03399_ sky130_fd_sc_hd__inv_1
X_13507_ _03399_ network.in_spk15_09 network.in_spk13_09 VSS
+ VSS VDD VDD _03400_ sky130_fd_sc_hd__a21oi_1
X_13508_ network.in_spk08_09 VSS VSS VDD VDD _03401_ sky130_fd_sc_hd__inv_1
X_13509_ _09206_ _03400_ _03401_ network.in_spk09_09 VSS VSS
+ VDD VDD _03402_ sky130_fd_sc_hd__a2bb2oi_1
X_13510_ network.in_spk03_09 VSS VSS VDD VDD _03403_ sky130_fd_sc_hd__inv_1
X_13511_ network.in_spk04_09 network.in_spk05_09 VSS VSS VDD
+ VDD _03404_ sky130_fd_sc_hd__nand2b_1
X_13512_ _03403_ _03404_ network.in_spk02_09 VSS VSS VDD VDD
+ _03405_ sky130_fd_sc_hd__a21oi_1
X_13513_ network.in_spk01_09 _03405_ VSS VSS VDD VDD _03406_
+ sky130_fd_sc_hd__nor2_1
X_13514_ _09205_ _03402_ _03406_ network.in_spk00_09 _09215_
+ VSS VSS VDD VDD _03407_ sky130_fd_sc_hd__o221ai_1
X_13515_ _08944_ _09025_ _03398_ _03407_ _09221_ VSS VSS VDD
+ VDD _03408_ sky130_fd_sc_hd__a32oi_1
X_13516_ network.in_spk08_07 VSS VSS VDD VDD _03409_ sky130_fd_sc_hd__inv_1
X_13517_ network.in_spk12_07 VSS VSS VDD VDD _03410_ sky130_fd_sc_hd__inv_1
X_13518_ _03410_ network.in_spk13_07 network.in_spk11_07 VSS
+ VSS VDD VDD _03411_ sky130_fd_sc_hd__a21oi_1
X_13519_ network.in_spk10_07 _03411_ network.in_spk09_07 VSS
+ VSS VDD VDD _03412_ sky130_fd_sc_hd__o21bai_1
X_13520_ network.in_spk04_07 VSS VSS VDD VDD _03413_ sky130_fd_sc_hd__inv_1
X_13521_ _03413_ network.in_spk05_07 network.in_spk03_07 VSS
+ VSS VDD VDD _03414_ sky130_fd_sc_hd__a21oi_1
X_13522_ network.in_spk02_07 _03414_ network.in_spk01_07 VSS
+ VSS VDD VDD _03415_ sky130_fd_sc_hd__o21bai_1
X_13523_ _03409_ _08995_ _03412_ _03415_ _09183_ VSS VSS VDD
+ VDD _03416_ sky130_fd_sc_hd__a311oi_1
X_13524_ network.in_spk03_11 VSS VSS VDD VDD _03417_ sky130_fd_sc_hd__inv_1
X_13525_ network.in_spk04_11 network.in_spk05_11 VSS VSS VDD
+ VDD _03418_ sky130_fd_sc_hd__nand2b_1
X_13526_ _03417_ _03418_ network.in_spk02_11 VSS VSS VDD VDD
+ _03419_ sky130_fd_sc_hd__a21oi_1
X_13527_ network.in_spk01_11 _03419_ VSS VSS VDD VDD _03420_
+ sky130_fd_sc_hd__nor2_1
X_13528_ network.in_spk12_11 VSS VSS VDD VDD _03421_ sky130_fd_sc_hd__inv_1
X_13529_ network.in_spk08_11 VSS VSS VDD VDD _03422_ sky130_fd_sc_hd__inv_1
X_13530_ _03421_ network.in_spk13_11 _09198_ network.in_spk09_11
+ _03422_ VSS VSS VDD VDD _03423_ sky130_fd_sc_hd__a32oi_1
X_13531_ network.in_spk00_11 _03420_ _03423_ _08978_ _09196_
+ VSS VSS VDD VDD _03424_ sky130_fd_sc_hd__o221a_2
X_13532_ network.in_spk00_07 _08959_ _03416_ _03424_ _09202_
+ VSS VSS VDD VDD _03425_ sky130_fd_sc_hd__o32a_1
X_13533_ network.in_spk01_10 VSS VSS VDD VDD _03426_ sky130_fd_sc_hd__inv_1
X_13534_ network.in_spk07_10 VSS VSS VDD VDD _03427_ sky130_fd_sc_hd__inv_1
X_13535_ network.in_spk08_10 network.in_spk09_10 VSS VSS VDD
+ VDD _03428_ sky130_fd_sc_hd__nand2b_1
X_13536_ _03427_ _03428_ network.in_spk06_10 VSS VSS VDD VDD
+ _03429_ sky130_fd_sc_hd__a21oi_1
X_13537_ network.in_spk05_10 _03429_ network.in_spk04_10 VSS
+ VSS VDD VDD _03430_ sky130_fd_sc_hd__o21bai_1
X_13538_ network.in_spk01_10 network.in_spk03_10 VSS VSS VDD
+ VDD _03431_ sky130_fd_sc_hd__nor2_1
X_13539_ _03426_ network.in_spk02_10 _03430_ _03431_ network.in_spk00_10
+ VSS VSS VDD VDD _03432_ sky130_fd_sc_hd__a221oi_1
X_13540_ network.in_spk12_10 VSS VSS VDD VDD _03433_ sky130_fd_sc_hd__inv_1
X_13541_ _03433_ network.in_spk13_10 network.in_spk15_10 _09130_
+ network.in_spk11_10 VSS VSS VDD VDD _03434_ sky130_fd_sc_hd__a221oi_1
X_13542_ network.in_spk10_10 _09129_ _03434_ VSS VSS VDD VDD
+ _03435_ sky130_fd_sc_hd__nor3_1
X_13543_ _03432_ _03435_ _08938_ net295 _09140_ VSS VSS VDD
+ VDD _03436_ sky130_fd_sc_hd__o2111ai_1
X_13544_ _09262_ _03385_ _03408_ _03425_ _03436_ VSS VSS VDD
+ VDD _03437_ sky130_fd_sc_hd__o2111ai_1
X_13545_ _09355_ _03373_ _03437_ VSS VSS VDD VDD _03438_ sky130_fd_sc_hd__nor3_1
X_13546_ _09343_ _03438_ _08957_ VSS VSS VDD VDD _01730_ sky130_fd_sc_hd__a21oi_1
X_13547_ network.neuron_in008.counter\[2\] VSS VSS VDD VDD
+ _03439_ sky130_fd_sc_hd__inv_1
X_13548_ network.in_period\[8\]\[2\] network.neuron_in008.counter\[3\]
+ net377 _00466_ VSS VSS VDD VDD _03440_ sky130_fd_sc_hd__o22ai_1
X_13549_ network.neuron_in008.counter\[2\] _00466_ net396
+ VSS VSS VDD VDD _03441_ sky130_fd_sc_hd__nand3_1
X_13550_ network.in_period\[8\]\[2\] net396 _03441_ VSS VSS
+ VDD VDD _03442_ sky130_fd_sc_hd__o21ai_0
X_13551_ _03439_ _03440_ _03442_ VSS VSS VDD VDD _02098_ sky130_fd_sc_hd__a21oi_1
X_13552_ network.neuron_in008.counter\[2\] _00466_ VSS VSS
+ VDD VDD _03443_ sky130_fd_sc_hd__nor2b_1
X_13553_ network.neuron_in008.counter\[3\] _03443_ VSS VSS
+ VDD VDD _03444_ sky130_fd_sc_hd__nand2b_1
X_13554_ net396 _03444_ VSS VSS VDD VDD _03445_ sky130_fd_sc_hd__nand2_1
X_13555_ network.in_period\[8\]\[1\] _03445_ VSS VSS VDD VDD
+ _03446_ sky130_fd_sc_hd__nand2_1
X_13556_ _00467_ _03445_ _03446_ VSS VSS VDD VDD _02097_ sky130_fd_sc_hd__o21ai_0
X_13557_ network.in_period\[8\]\[0\] _03445_ VSS VSS VDD VDD
+ _03447_ sky130_fd_sc_hd__nand2_1
X_13558_ network.neuron_in008.counter\[0\] _03445_ _03447_
+ VSS VSS VDD VDD _02096_ sky130_fd_sc_hd__o21ai_0
X_13559_ network.neuron_in009.counter\[2\] _00462_ VSS VSS
+ VDD VDD _03448_ sky130_fd_sc_hd__xnor2_1
X_13560_ network.neuron_in009.counter\[2\] network.neuron_in009.counter\[3\]
+ VSS VSS VDD VDD _03449_ sky130_fd_sc_hd__nor2_1
X_13561_ _00462_ _03449_ VSS VSS VDD VDD _03450_ sky130_fd_sc_hd__nand2_1
X_13562_ net396 _03450_ network.in_period\[9\]\[2\] VSS VSS
+ VDD VDD _03451_ sky130_fd_sc_hd__a21oi_1
X_13563_ net396 _03448_ _03451_ VSS VSS VDD VDD _02102_ sky130_fd_sc_hd__a21oi_1
X_13564_ net396 _03450_ VSS VSS VDD VDD _03452_ sky130_fd_sc_hd__nand2_1
X_13565_ network.in_period\[9\]\[1\] _03452_ VSS VSS VDD VDD
+ _03453_ sky130_fd_sc_hd__nand2_1
X_13566_ _00463_ _03452_ _03453_ VSS VSS VDD VDD _02101_ sky130_fd_sc_hd__o21ai_0
X_13567_ network.neuron_in009.counter\[0\] VSS VSS VDD VDD
+ _00460_ sky130_fd_sc_hd__inv_1
X_13568_ network.in_period\[9\]\[0\] _03452_ VSS VSS VDD VDD
+ _03454_ sky130_fd_sc_hd__nand2_1
X_13569_ network.neuron_in009.counter\[0\] _03452_ _03454_
+ VSS VSS VDD VDD _02100_ sky130_fd_sc_hd__o21ai_0
X_13570_ network.neuron_in010.counter\[2\] VSS VSS VDD VDD
+ _03455_ sky130_fd_sc_hd__inv_1
X_13571_ network.neuron_in010.counter\[3\] network.in_period\[10\]\[2\]
+ _00436_ net377 VSS VSS VDD VDD _03456_ sky130_fd_sc_hd__o22ai_1
X_13572_ network.neuron_in010.counter\[2\] _00436_ net396
+ VSS VSS VDD VDD _03457_ sky130_fd_sc_hd__nand3_1
X_13573_ network.in_period\[10\]\[2\] net396 _03457_ VSS VSS
+ VDD VDD _03458_ sky130_fd_sc_hd__o21ai_0
X_13574_ _03455_ _03456_ _03458_ VSS VSS VDD VDD _02106_ sky130_fd_sc_hd__a21oi_1
X_13575_ network.neuron_in010.counter\[2\] _00436_ VSS VSS
+ VDD VDD _03459_ sky130_fd_sc_hd__nor2b_1
X_13576_ network.neuron_in010.counter\[3\] _03459_ VSS VSS
+ VDD VDD _03460_ sky130_fd_sc_hd__nand2b_1
X_13577_ net396 _03460_ VSS VSS VDD VDD _03461_ sky130_fd_sc_hd__nand2_1
X_13578_ network.in_period\[10\]\[1\] _03461_ VSS VSS VDD
+ VDD _03462_ sky130_fd_sc_hd__nand2_1
X_13579_ _00437_ _03461_ _03462_ VSS VSS VDD VDD _02105_ sky130_fd_sc_hd__o21ai_0
X_13580_ network.neuron_in010.counter\[0\] VSS VSS VDD VDD
+ _00434_ sky130_fd_sc_hd__inv_1
X_13581_ network.in_period\[10\]\[0\] _03461_ VSS VSS VDD
+ VDD _03463_ sky130_fd_sc_hd__nand2_1
X_13582_ network.neuron_in010.counter\[0\] _03461_ _03463_
+ VSS VSS VDD VDD _02104_ sky130_fd_sc_hd__o21ai_0
X_13583_ network.neuron_in011.counter\[2\] VSS VSS VDD VDD
+ _03464_ sky130_fd_sc_hd__inv_1
X_13584_ network.in_period\[11\]\[2\] network.neuron_in011.counter\[3\]
+ net377 _00440_ VSS VSS VDD VDD _03465_ sky130_fd_sc_hd__o22ai_1
X_13585_ network.neuron_in011.counter\[2\] _00440_ net396
+ VSS VSS VDD VDD _03466_ sky130_fd_sc_hd__nand3_1
X_13586_ network.in_period\[11\]\[2\] net396 _03466_ VSS VSS
+ VDD VDD _03467_ sky130_fd_sc_hd__o21ai_0
X_13587_ _03464_ _03465_ _03467_ VSS VSS VDD VDD _02110_ sky130_fd_sc_hd__a21oi_1
Xplace367 _07045_ VSS VSS VDD VDD net366 sky130_fd_sc_hd__buf_4
X_13589_ network.neuron_in011.counter\[3\] _00440_ VSS VSS
+ VDD VDD _03469_ sky130_fd_sc_hd__nand2b_1
X_13590_ _03469_ _03464_ VSS VSS VDD VDD _03470_ sky130_fd_sc_hd__nand2b_1
X_13591_ net396 _03470_ VSS VSS VDD VDD _03471_ sky130_fd_sc_hd__nand2_1
X_13592_ network.in_period\[11\]\[1\] _03471_ VSS VSS VDD
+ VDD _03472_ sky130_fd_sc_hd__nand2_1
X_13593_ _00441_ _03471_ _03472_ VSS VSS VDD VDD _02109_ sky130_fd_sc_hd__o21ai_0
X_13594_ network.neuron_in080.counter\[1\] VSS VSS VDD VDD
+ _00069_ sky130_fd_sc_hd__inv_1
X_13595_ network.neuron_in011.counter\[0\] VSS VSS VDD VDD
+ _00438_ sky130_fd_sc_hd__inv_1
X_13596_ network.in_period\[11\]\[0\] _03471_ VSS VSS VDD
+ VDD _03473_ sky130_fd_sc_hd__nand2_1
X_13597_ network.neuron_in011.counter\[0\] _03471_ _03473_
+ VSS VSS VDD VDD _02108_ sky130_fd_sc_hd__o21ai_0
X_13598_ network.neuron_in095.counter\[0\] VSS VSS VDD VDD
+ _01245_ sky130_fd_sc_hd__inv_1
X_13599_ _00428_ network.neuron_in012.counter\[2\] VSS VSS
+ VDD VDD _03474_ sky130_fd_sc_hd__xnor2_1
X_13600_ network.neuron_in012.counter\[2\] network.neuron_in012.counter\[3\]
+ VSS VSS VDD VDD _03475_ sky130_fd_sc_hd__nor2_1
X_13601_ _00428_ _03475_ VSS VSS VDD VDD _03476_ sky130_fd_sc_hd__nand2_1
X_13602_ net387 _03476_ network.in_period\[12\]\[2\] VSS VSS
+ VDD VDD _03477_ sky130_fd_sc_hd__a21oi_1
X_13603_ net387 _03474_ _03477_ VSS VSS VDD VDD _02114_ sky130_fd_sc_hd__a21oi_1
X_13604_ net387 _03476_ VSS VSS VDD VDD _03478_ sky130_fd_sc_hd__nand2_1
X_13605_ network.in_period\[12\]\[1\] _03478_ VSS VSS VDD
+ VDD _03479_ sky130_fd_sc_hd__nand2_1
X_13606_ _00429_ _03478_ _03479_ VSS VSS VDD VDD _02113_ sky130_fd_sc_hd__o21ai_0
X_13607_ network.neuron_in012.counter\[0\] VSS VSS VDD VDD
+ _00426_ sky130_fd_sc_hd__inv_1
X_13608_ network.in_period\[12\]\[0\] _03478_ VSS VSS VDD
+ VDD _03480_ sky130_fd_sc_hd__nand2_1
X_13609_ network.neuron_in012.counter\[0\] _03478_ _03480_
+ VSS VSS VDD VDD _02112_ sky130_fd_sc_hd__o21ai_0
X_13610_ network.neuron_in013.counter\[2\] VSS VSS VDD VDD
+ _03481_ sky130_fd_sc_hd__inv_1
X_13611_ network.in_period\[13\]\[2\] network.neuron_in013.counter\[3\]
+ net371 _00424_ VSS VSS VDD VDD _03482_ sky130_fd_sc_hd__o22ai_1
X_13612_ network.neuron_in013.counter\[2\] _00424_ net387
+ VSS VSS VDD VDD _03483_ sky130_fd_sc_hd__nand3_1
X_13613_ network.in_period\[13\]\[2\] net387 _03483_ VSS VSS
+ VDD VDD _03484_ sky130_fd_sc_hd__o21ai_0
X_13614_ _03481_ _03482_ _03484_ VSS VSS VDD VDD _02118_ sky130_fd_sc_hd__a21oi_1
X_13615_ network.neuron_in013.counter\[2\] _00424_ VSS VSS
+ VDD VDD _03485_ sky130_fd_sc_hd__nor2b_1
X_13616_ network.neuron_in013.counter\[3\] _03485_ VSS VSS
+ VDD VDD _03486_ sky130_fd_sc_hd__nand2b_1
X_13617_ net387 _03486_ VSS VSS VDD VDD _03487_ sky130_fd_sc_hd__nand2_1
X_13618_ network.in_period\[13\]\[1\] _03487_ VSS VSS VDD
+ VDD _03488_ sky130_fd_sc_hd__nand2_1
X_13619_ _00425_ _03487_ _03488_ VSS VSS VDD VDD _02117_ sky130_fd_sc_hd__o21ai_0
X_13620_ network.neuron_in013.counter\[0\] VSS VSS VDD VDD
+ _00422_ sky130_fd_sc_hd__inv_1
X_13621_ network.in_period\[13\]\[0\] _03487_ VSS VSS VDD
+ VDD _03489_ sky130_fd_sc_hd__nand2_1
X_13622_ network.neuron_in013.counter\[0\] _03487_ _03489_
+ VSS VSS VDD VDD _02116_ sky130_fd_sc_hd__o21ai_0
X_13623_ network.neuron_in015.counter\[2\] network.neuron_in015.counter\[3\]
+ _00420_ VSS VSS VDD VDD _03490_ sky130_fd_sc_hd__or3b_2
X_13624_ net387 _03490_ VSS VSS VDD VDD _03491_ sky130_fd_sc_hd__nand2_1
X_13625_ network.in_period\[15\]\[1\] _03491_ VSS VSS VDD
+ VDD _03492_ sky130_fd_sc_hd__nand2_1
X_13626_ _00421_ _03491_ _03492_ VSS VSS VDD VDD _02125_ sky130_fd_sc_hd__o21ai_0
X_13627_ network.neuron_in015.counter\[0\] VSS VSS VDD VDD
+ _00418_ sky130_fd_sc_hd__inv_1
X_13628_ network.in_period\[15\]\[0\] _03491_ VSS VSS VDD
+ VDD _03493_ sky130_fd_sc_hd__nand2_1
X_13629_ network.neuron_in015.counter\[0\] _03491_ _03493_
+ VSS VSS VDD VDD _02124_ sky130_fd_sc_hd__o21ai_0
X_13630_ network.neuron_in014.counter\[2\] VSS VSS VDD VDD
+ _03494_ sky130_fd_sc_hd__inv_1
Xplace366 _07046_ VSS VSS VDD VDD net365 sky130_fd_sc_hd__buf_4
X_13632_ network.in_period\[14\]\[2\] network.neuron_in014.counter\[3\]
+ _00416_ net377 VSS VSS VDD VDD _03496_ sky130_fd_sc_hd__o22ai_1
X_13633_ network.neuron_in014.counter\[2\] _00416_ net385
+ VSS VSS VDD VDD _03497_ sky130_fd_sc_hd__nand3_1
X_13634_ network.in_period\[14\]\[2\] net385 _03497_ VSS VSS
+ VDD VDD _03498_ sky130_fd_sc_hd__o21ai_0
X_13635_ _03494_ _03496_ _03498_ VSS VSS VDD VDD _02122_ sky130_fd_sc_hd__a21oi_1
X_13636_ network.neuron_in014.counter\[2\] network.neuron_in014.counter\[3\]
+ VSS VSS VDD VDD _03499_ sky130_fd_sc_hd__nor2_1
X_13637_ _00416_ _03499_ VSS VSS VDD VDD _03500_ sky130_fd_sc_hd__nand2_1
X_13638_ net385 _03500_ VSS VSS VDD VDD _03501_ sky130_fd_sc_hd__nand2_1
X_13639_ network.in_period\[14\]\[1\] _03501_ VSS VSS VDD
+ VDD _03502_ sky130_fd_sc_hd__nand2_1
X_13640_ _00417_ _03501_ _03502_ VSS VSS VDD VDD _02121_ sky130_fd_sc_hd__o21ai_0
X_13641_ network.neuron_in210.counter\[1\] VSS VSS VDD VDD
+ _00959_ sky130_fd_sc_hd__inv_1
X_13642_ network.in_period\[14\]\[0\] _03501_ VSS VSS VDD
+ VDD _03503_ sky130_fd_sc_hd__nand2_1
X_13643_ network.neuron_in014.counter\[0\] _03501_ _03503_
+ VSS VSS VDD VDD _02120_ sky130_fd_sc_hd__o21ai_0
X_13644_ network.neuron_in015.counter\[2\] _00420_ VSS VSS
+ VDD VDD _03504_ sky130_fd_sc_hd__xnor2_1
X_13645_ net387 _03490_ network.in_period\[15\]\[2\] VSS VSS
+ VDD VDD _03505_ sky130_fd_sc_hd__a21oi_1
X_13646_ net387 _03504_ _03505_ VSS VSS VDD VDD _02126_ sky130_fd_sc_hd__a21oi_1
X_13647_ network.neuron_in082.counter\[1\] VSS VSS VDD VDD
+ _00063_ sky130_fd_sc_hd__inv_1
X_13648_ network.neuron_in146.counter\[2\] network.neuron_in146.counter\[3\]
+ VSS VSS VDD VDD _03506_ sky130_fd_sc_hd__nor2_1
X_13649_ _00609_ _03506_ VSS VSS VDD VDD _03507_ sky130_fd_sc_hd__nand2_1
X_13650_ net400 _03507_ VSS VSS VDD VDD _03508_ sky130_fd_sc_hd__nand2_1
X_13651_ network.in_period\[146\]\[1\] _03508_ VSS VSS VDD
+ VDD _03509_ sky130_fd_sc_hd__nand2_1
X_13652_ _00610_ _03508_ _03509_ VSS VSS VDD VDD _02649_ sky130_fd_sc_hd__o21ai_0
X_13653_ network.in_period\[146\]\[0\] _03508_ VSS VSS VDD
+ VDD _03510_ sky130_fd_sc_hd__nand2_1
X_13654_ network.neuron_in146.counter\[0\] _03508_ _03510_
+ VSS VSS VDD VDD _02648_ sky130_fd_sc_hd__o21ai_0
X_13655_ network.neuron_in016.counter\[2\] net387 VSS VSS
+ VDD VDD _03511_ sky130_fd_sc_hd__nand2_1
X_13656_ network.in_period\[16\]\[2\] network.neuron_in016.counter\[3\]
+ _03511_ VSS VSS VDD VDD _03512_ sky130_fd_sc_hd__o21ai_0
X_13657_ _00408_ network.neuron_in016.counter\[2\] net371
+ VSS VSS VDD VDD _03513_ sky130_fd_sc_hd__or3_1
X_13658_ network.in_period\[16\]\[2\] net387 _03513_ VSS VSS
+ VDD VDD _03514_ sky130_fd_sc_hd__o21ai_0
X_13659_ _00408_ _03512_ _03514_ VSS VSS VDD VDD _02130_ sky130_fd_sc_hd__a21oi_1
X_13660_ network.neuron_in016.counter\[2\] _00408_ VSS VSS
+ VDD VDD _03515_ sky130_fd_sc_hd__nor2b_1
X_13661_ network.neuron_in016.counter\[3\] _03515_ VSS VSS
+ VDD VDD _03516_ sky130_fd_sc_hd__nand2b_1
X_13662_ net387 _03516_ VSS VSS VDD VDD _03517_ sky130_fd_sc_hd__nand2_1
X_13663_ network.in_period\[16\]\[1\] _03517_ VSS VSS VDD
+ VDD _03518_ sky130_fd_sc_hd__nand2_1
X_13664_ _00409_ _03517_ _03518_ VSS VSS VDD VDD _02129_ sky130_fd_sc_hd__o21ai_0
X_13665_ network.neuron_in016.counter\[0\] VSS VSS VDD VDD
+ _00406_ sky130_fd_sc_hd__inv_1
X_13666_ network.in_period\[16\]\[0\] _03517_ VSS VSS VDD
+ VDD _03519_ sky130_fd_sc_hd__nand2_1
X_13667_ network.neuron_in016.counter\[0\] _03517_ _03519_
+ VSS VSS VDD VDD _02128_ sky130_fd_sc_hd__o21ai_0
X_13668_ network.neuron_in117.counter\[0\] VSS VSS VDD VDD
+ _01217_ sky130_fd_sc_hd__inv_1
X_13669_ network.neuron_in092.counter\[0\] VSS VSS VDD VDD
+ _01232_ sky130_fd_sc_hd__inv_1
X_13670_ network.neuron_in017.counter\[2\] VSS VSS VDD VDD
+ _03520_ sky130_fd_sc_hd__inv_1
X_13671_ network.in_period\[17\]\[2\] network.neuron_in017.counter\[3\]
+ _00412_ net371 VSS VSS VDD VDD _03521_ sky130_fd_sc_hd__o22ai_1
Xplace355 _07127_ VSS VSS VDD VDD net354 sky130_fd_sc_hd__buf_4
X_13673_ network.neuron_in017.counter\[2\] _00412_ net387
+ VSS VSS VDD VDD _03523_ sky130_fd_sc_hd__nand3_1
X_13674_ network.in_period\[17\]\[2\] net387 _03523_ VSS VSS
+ VDD VDD _03524_ sky130_fd_sc_hd__o21ai_0
X_13675_ _03520_ _03521_ _03524_ VSS VSS VDD VDD _02134_ sky130_fd_sc_hd__a21oi_1
X_13676_ network.neuron_in017.counter\[3\] _00412_ VSS VSS
+ VDD VDD _03525_ sky130_fd_sc_hd__nand2b_1
X_13677_ _03525_ _03520_ VSS VSS VDD VDD _03526_ sky130_fd_sc_hd__nand2b_1
X_13678_ net387 _03526_ VSS VSS VDD VDD _03527_ sky130_fd_sc_hd__nand2_1
X_13679_ network.in_period\[17\]\[1\] _03527_ VSS VSS VDD
+ VDD _03528_ sky130_fd_sc_hd__nand2_1
X_13680_ _00413_ _03527_ _03528_ VSS VSS VDD VDD _02133_ sky130_fd_sc_hd__o21ai_0
X_13681_ network.in_period\[17\]\[0\] _03527_ VSS VSS VDD
+ VDD _03529_ sky130_fd_sc_hd__nand2_1
X_13682_ network.neuron_in017.counter\[0\] _03527_ _03529_
+ VSS VSS VDD VDD _02132_ sky130_fd_sc_hd__o21ai_0
X_13683_ network.neuron_in018.counter\[2\] VSS VSS VDD VDD
+ _03530_ sky130_fd_sc_hd__inv_1
X_13684_ network.in_period\[18\]\[2\] network.neuron_in018.counter\[3\]
+ _00400_ net372 VSS VSS VDD VDD _03531_ sky130_fd_sc_hd__o22ai_1
X_13685_ network.neuron_in018.counter\[2\] _00400_ net390
+ VSS VSS VDD VDD _03532_ sky130_fd_sc_hd__nand3_1
X_13686_ network.in_period\[18\]\[2\] net390 _03532_ VSS VSS
+ VDD VDD _03533_ sky130_fd_sc_hd__o21ai_0
X_13687_ _03530_ _03531_ _03533_ VSS VSS VDD VDD _02138_ sky130_fd_sc_hd__a21oi_1
X_13688_ network.neuron_in018.counter\[3\] _00400_ VSS VSS
+ VDD VDD _03534_ sky130_fd_sc_hd__nand2b_1
X_13689_ _03534_ _03530_ VSS VSS VDD VDD _03535_ sky130_fd_sc_hd__nand2b_1
X_13690_ net387 _03535_ VSS VSS VDD VDD _03536_ sky130_fd_sc_hd__nand2_1
X_13691_ network.in_period\[18\]\[1\] _03536_ VSS VSS VDD
+ VDD _03537_ sky130_fd_sc_hd__nand2_1
X_13692_ _00401_ _03536_ _03537_ VSS VSS VDD VDD _02137_ sky130_fd_sc_hd__o21ai_0
X_13693_ network.neuron_in168.counter\[1\] VSS VSS VDD VDD
+ _00955_ sky130_fd_sc_hd__inv_1
X_13694_ network.neuron_in018.counter\[0\] VSS VSS VDD VDD
+ _00398_ sky130_fd_sc_hd__inv_1
X_13695_ network.in_period\[18\]\[0\] _03536_ VSS VSS VDD
+ VDD _03538_ sky130_fd_sc_hd__nand2_1
X_13696_ network.neuron_in018.counter\[0\] _03536_ _03538_
+ VSS VSS VDD VDD _02136_ sky130_fd_sc_hd__o21ai_0
X_13697_ network.neuron_in129.counter\[2\] net394 VSS VSS
+ VDD VDD _03539_ sky130_fd_sc_hd__nand2_1
X_13698_ network.in_period\[129\]\[2\] network.neuron_in129.counter\[3\]
+ _03539_ VSS VSS VDD VDD _03540_ sky130_fd_sc_hd__o21ai_0
X_13699_ _00988_ network.neuron_in129.counter\[2\] net375
+ VSS VSS VDD VDD _03541_ sky130_fd_sc_hd__or3_1
X_13700_ network.in_period\[129\]\[2\] net394 _03541_ VSS
+ VSS VDD VDD _03542_ sky130_fd_sc_hd__o21ai_0
X_13701_ _00988_ _03540_ _03542_ VSS VSS VDD VDD _02582_ sky130_fd_sc_hd__a21oi_1
X_13702_ network.neuron_in054.counter\[0\] VSS VSS VDD VDD
+ _00246_ sky130_fd_sc_hd__inv_1
X_13703_ network.neuron_in019.counter\[2\] _00396_ VSS VSS
+ VDD VDD _03543_ sky130_fd_sc_hd__nor2b_1
X_13704_ network.neuron_in019.counter\[3\] _03543_ VSS VSS
+ VDD VDD _03544_ sky130_fd_sc_hd__nand2b_1
X_13705_ net387 _03544_ VSS VSS VDD VDD _03545_ sky130_fd_sc_hd__nand2_1
X_13706_ network.in_period\[19\]\[0\] _03545_ VSS VSS VDD
+ VDD _03546_ sky130_fd_sc_hd__nand2_1
X_13707_ network.neuron_in019.counter\[0\] _03545_ _03546_
+ VSS VSS VDD VDD _02140_ sky130_fd_sc_hd__o21ai_0
X_13708_ network.neuron_in019.counter\[2\] VSS VSS VDD VDD
+ _03547_ sky130_fd_sc_hd__inv_1
X_13709_ network.in_period\[19\]\[2\] network.neuron_in019.counter\[3\]
+ net371 _00396_ VSS VSS VDD VDD _03548_ sky130_fd_sc_hd__o22ai_1
X_13710_ network.neuron_in019.counter\[2\] _00396_ net387
+ VSS VSS VDD VDD _03549_ sky130_fd_sc_hd__nand3_1
X_13711_ network.in_period\[19\]\[2\] net387 _03549_ VSS VSS
+ VDD VDD _03550_ sky130_fd_sc_hd__o21ai_0
X_13712_ _03547_ _03548_ _03550_ VSS VSS VDD VDD _02142_ sky130_fd_sc_hd__a21oi_1
X_13713_ network.in_period\[19\]\[1\] _03545_ VSS VSS VDD
+ VDD _03551_ sky130_fd_sc_hd__nand2_1
X_13714_ _00397_ _03545_ _03551_ VSS VSS VDD VDD _02141_ sky130_fd_sc_hd__o21ai_0
X_13715_ network.neuron_in020.counter\[2\] net390 VSS VSS
+ VDD VDD _03552_ sky130_fd_sc_hd__nand2_1
X_13716_ network.in_period\[20\]\[2\] network.neuron_in020.counter\[3\]
+ _03552_ VSS VSS VDD VDD _03553_ sky130_fd_sc_hd__o21ai_0
X_13717_ _00392_ network.neuron_in020.counter\[2\] net373
+ VSS VSS VDD VDD _03554_ sky130_fd_sc_hd__or3_1
X_13718_ network.in_period\[20\]\[2\] net390 _03554_ VSS VSS
+ VDD VDD _03555_ sky130_fd_sc_hd__o21ai_0
X_13719_ _00392_ _03553_ _03555_ VSS VSS VDD VDD _02146_ sky130_fd_sc_hd__a21oi_1
X_13720_ network.neuron_in020.counter\[2\] _00392_ VSS VSS
+ VDD VDD _03556_ sky130_fd_sc_hd__nor2b_1
X_13721_ network.neuron_in020.counter\[3\] _03556_ VSS VSS
+ VDD VDD _03557_ sky130_fd_sc_hd__nand2b_1
X_13722_ net390 _03557_ VSS VSS VDD VDD _03558_ sky130_fd_sc_hd__nand2_1
X_13723_ network.in_period\[20\]\[1\] _03558_ VSS VSS VDD
+ VDD _03559_ sky130_fd_sc_hd__nand2_1
X_13724_ _00393_ _03558_ _03559_ VSS VSS VDD VDD _02145_ sky130_fd_sc_hd__o21ai_0
X_13725_ network.neuron_in020.counter\[0\] VSS VSS VDD VDD
+ _00390_ sky130_fd_sc_hd__inv_1
X_13726_ network.in_period\[20\]\[0\] _03558_ VSS VSS VDD
+ VDD _03560_ sky130_fd_sc_hd__nand2_1
X_13727_ network.neuron_in020.counter\[0\] _03558_ _03560_
+ VSS VSS VDD VDD _02144_ sky130_fd_sc_hd__o21ai_0
X_13728_ network.neuron_in212.counter\[1\] VSS VSS VDD VDD
+ _00752_ sky130_fd_sc_hd__inv_1
X_13729_ network.neuron_in161.counter\[1\] VSS VSS VDD VDD
+ _00763_ sky130_fd_sc_hd__inv_1
X_13730_ network.neuron_in021.counter\[2\] _00388_ VSS VSS
+ VDD VDD _03561_ sky130_fd_sc_hd__xnor2_1
X_13731_ network.neuron_in021.counter\[2\] network.neuron_in021.counter\[3\]
+ VSS VSS VDD VDD _03562_ sky130_fd_sc_hd__nor2_1
X_13732_ _00388_ _03562_ VSS VSS VDD VDD _03563_ sky130_fd_sc_hd__nand2_1
X_13733_ net390 _03563_ network.in_period\[21\]\[2\] VSS VSS
+ VDD VDD _03564_ sky130_fd_sc_hd__a21oi_1
X_13734_ net390 _03561_ _03564_ VSS VSS VDD VDD _02150_ sky130_fd_sc_hd__a21oi_1
X_13735_ network.neuron_in217.counter\[1\] VSS VSS VDD VDD
+ _00951_ sky130_fd_sc_hd__inv_1
Xplace353 _07136_ VSS VSS VDD VDD net352 sky130_fd_sc_hd__buf_4
X_13737_ net390 _03563_ VSS VSS VDD VDD _03566_ sky130_fd_sc_hd__nand2_1
X_13738_ network.in_period\[21\]\[1\] _03566_ VSS VSS VDD
+ VDD _03567_ sky130_fd_sc_hd__nand2_1
X_13739_ _00389_ _03566_ _03567_ VSS VSS VDD VDD _02149_ sky130_fd_sc_hd__o21ai_0
X_13740_ network.neuron_in021.counter\[0\] VSS VSS VDD VDD
+ _00386_ sky130_fd_sc_hd__inv_1
X_13741_ network.in_period\[21\]\[0\] _03566_ VSS VSS VDD
+ VDD _03568_ sky130_fd_sc_hd__nand2_1
X_13742_ network.neuron_in021.counter\[0\] _03566_ _03568_
+ VSS VSS VDD VDD _02148_ sky130_fd_sc_hd__o21ai_0
X_13743_ network.neuron_in022.counter\[2\] VSS VSS VDD VDD
+ _03569_ sky130_fd_sc_hd__inv_1
X_13744_ network.in_period\[22\]\[2\] network.neuron_in022.counter\[3\]
+ _00373_ net373 VSS VSS VDD VDD _03570_ sky130_fd_sc_hd__o22ai_1
Xplace349 _07178_ VSS VSS VDD VDD net348 sky130_fd_sc_hd__buf_4
X_13746_ network.neuron_in022.counter\[2\] _00373_ net390
+ VSS VSS VDD VDD _03572_ sky130_fd_sc_hd__nand3_1
X_13747_ network.in_period\[22\]\[2\] net390 _03572_ VSS VSS
+ VDD VDD _03573_ sky130_fd_sc_hd__o21ai_0
X_13748_ _03569_ _03570_ _03573_ VSS VSS VDD VDD _02154_ sky130_fd_sc_hd__a21oi_1
X_13749_ network.neuron_in022.counter\[3\] _00373_ VSS VSS
+ VDD VDD _03574_ sky130_fd_sc_hd__nand2b_1
X_13750_ _03574_ _03569_ VSS VSS VDD VDD _03575_ sky130_fd_sc_hd__nand2b_1
X_13751_ net390 _03575_ VSS VSS VDD VDD _03576_ sky130_fd_sc_hd__nand2_1
X_13752_ network.in_period\[22\]\[1\] _03576_ VSS VSS VDD
+ VDD _03577_ sky130_fd_sc_hd__nand2_1
X_13753_ _00374_ _03576_ _03577_ VSS VSS VDD VDD _02153_ sky130_fd_sc_hd__o21ai_0
X_13754_ network.neuron_in022.counter\[0\] VSS VSS VDD VDD
+ _00371_ sky130_fd_sc_hd__inv_1
X_13755_ network.in_period\[22\]\[0\] _03576_ VSS VSS VDD
+ VDD _03578_ sky130_fd_sc_hd__nand2_1
X_13756_ network.neuron_in022.counter\[0\] _03576_ _03578_
+ VSS VSS VDD VDD _02152_ sky130_fd_sc_hd__o21ai_0
X_13757_ network.neuron_in023.counter\[2\] VSS VSS VDD VDD
+ _03579_ sky130_fd_sc_hd__inv_1
X_13758_ network.neuron_in023.counter\[3\] network.in_period\[23\]\[2\]
+ net372 _00383_ VSS VSS VDD VDD _03580_ sky130_fd_sc_hd__o22ai_1
X_13759_ network.neuron_in023.counter\[2\] _00383_ net389
+ VSS VSS VDD VDD _03581_ sky130_fd_sc_hd__nand3_1
X_13760_ network.in_period\[23\]\[2\] net389 _03581_ VSS VSS
+ VDD VDD _03582_ sky130_fd_sc_hd__o21ai_0
X_13761_ _03579_ _03580_ _03582_ VSS VSS VDD VDD _02158_ sky130_fd_sc_hd__a21oi_1
X_13762_ network.neuron_in023.counter\[3\] _00383_ VSS VSS
+ VDD VDD _03583_ sky130_fd_sc_hd__nand2b_1
X_13763_ _03583_ _03579_ VSS VSS VDD VDD _03584_ sky130_fd_sc_hd__nand2b_1
X_13764_ net389 _03584_ VSS VSS VDD VDD _03585_ sky130_fd_sc_hd__nand2_1
X_13765_ network.in_period\[23\]\[1\] _03585_ VSS VSS VDD
+ VDD _03586_ sky130_fd_sc_hd__nand2_1
X_13766_ _00384_ _03585_ _03586_ VSS VSS VDD VDD _02157_ sky130_fd_sc_hd__o21ai_0
X_13767_ network.neuron_in023.counter\[0\] VSS VSS VDD VDD
+ _00381_ sky130_fd_sc_hd__inv_1
X_13768_ network.in_period\[23\]\[0\] _03585_ VSS VSS VDD
+ VDD _03587_ sky130_fd_sc_hd__nand2_1
X_13769_ network.neuron_in023.counter\[0\] _03585_ _03587_
+ VSS VSS VDD VDD _02156_ sky130_fd_sc_hd__o21ai_0
X_13770_ network.neuron_in024.counter\[2\] VSS VSS VDD VDD
+ _03588_ sky130_fd_sc_hd__inv_1
X_13771_ network.in_period\[24\]\[2\] network.neuron_in024.counter\[3\]
+ _00377_ net374 VSS VSS VDD VDD _03589_ sky130_fd_sc_hd__o22ai_1
X_13772_ network.neuron_in024.counter\[2\] _00377_ net391
+ VSS VSS VDD VDD _03590_ sky130_fd_sc_hd__nand3_1
X_13773_ network.in_period\[24\]\[2\] net391 _03590_ VSS VSS
+ VDD VDD _03591_ sky130_fd_sc_hd__o21ai_0
X_13774_ _03588_ _03589_ _03591_ VSS VSS VDD VDD _02162_ sky130_fd_sc_hd__a21oi_1
X_13775_ network.neuron_in024.counter\[2\] _00377_ VSS VSS
+ VDD VDD _03592_ sky130_fd_sc_hd__nor2b_1
X_13776_ network.neuron_in024.counter\[3\] _03592_ VSS VSS
+ VDD VDD _03593_ sky130_fd_sc_hd__nand2b_1
X_13777_ net391 _03593_ VSS VSS VDD VDD _03594_ sky130_fd_sc_hd__nand2_1
X_13778_ network.in_period\[24\]\[1\] _03594_ VSS VSS VDD
+ VDD _03595_ sky130_fd_sc_hd__nand2_1
X_13779_ _00378_ _03594_ _03595_ VSS VSS VDD VDD _02161_ sky130_fd_sc_hd__o21ai_0
X_13780_ network.in_period\[24\]\[0\] _03594_ VSS VSS VDD
+ VDD _03596_ sky130_fd_sc_hd__nand2_1
X_13781_ network.neuron_in024.counter\[0\] _03594_ _03596_
+ VSS VSS VDD VDD _02160_ sky130_fd_sc_hd__o21ai_0
X_13782_ network.neuron_in211.counter\[1\] VSS VSS VDD VDD
+ _00279_ sky130_fd_sc_hd__inv_1
X_13783_ network.neuron_in026.counter\[2\] net388 VSS VSS
+ VDD VDD _03597_ sky130_fd_sc_hd__nand2_1
X_13784_ network.neuron_in026.counter\[3\] network.in_period\[26\]\[2\]
+ _03597_ VSS VSS VDD VDD _03598_ sky130_fd_sc_hd__o21ai_0
X_13785_ _00450_ network.neuron_in026.counter\[2\] net373
+ VSS VSS VDD VDD _03599_ sky130_fd_sc_hd__or3_1
X_13786_ network.in_period\[26\]\[2\] net388 _03599_ VSS VSS
+ VDD VDD _03600_ sky130_fd_sc_hd__o21ai_0
X_13787_ _00450_ _03598_ _03600_ VSS VSS VDD VDD _02170_ sky130_fd_sc_hd__a21oi_1
X_13788_ network.in_period\[147\]\[1\] _06984_ VSS VSS VDD
+ VDD _03601_ sky130_fd_sc_hd__nand2_1
X_13789_ _00459_ _06984_ _03601_ VSS VSS VDD VDD _02653_ sky130_fd_sc_hd__o21ai_0
Xplace347 _07213_ VSS VSS VDD VDD net346 sky130_fd_sc_hd__buf_4
X_13791_ network.neuron_in129.counter\[2\] _00988_ VSS VSS
+ VDD VDD _03603_ sky130_fd_sc_hd__nor2b_1
X_13792_ network.neuron_in129.counter\[3\] _03603_ VSS VSS
+ VDD VDD _03604_ sky130_fd_sc_hd__nand2b_1
X_13793_ net394 _03604_ VSS VSS VDD VDD _03605_ sky130_fd_sc_hd__nand2_1
X_13794_ network.in_period\[129\]\[1\] _03605_ VSS VSS VDD
+ VDD _03606_ sky130_fd_sc_hd__nand2_1
X_13795_ _00989_ _03605_ _03606_ VSS VSS VDD VDD _02581_ sky130_fd_sc_hd__o21ai_0
Xplace345 _07227_ VSS VSS VDD VDD net344 sky130_fd_sc_hd__buf_4
X_13797_ network.neuron_in147.counter\[2\] net403 VSS VSS
+ VDD VDD _03608_ sky130_fd_sc_hd__nand2_1
X_13798_ network.in_period\[147\]\[2\] network.neuron_in147.counter\[3\]
+ _03608_ VSS VSS VDD VDD _03609_ sky130_fd_sc_hd__o21ai_0
Xplace333 _07636_ VSS VSS VDD VDD net332 sky130_fd_sc_hd__buf_4
X_13800_ _00458_ network.neuron_in147.counter\[2\] net369
+ VSS VSS VDD VDD _03611_ sky130_fd_sc_hd__or3_1
X_13801_ network.in_period\[147\]\[2\] net403 _03611_ VSS
+ VSS VDD VDD _03612_ sky130_fd_sc_hd__o21ai_0
X_13802_ _00458_ _03609_ _03612_ VSS VSS VDD VDD _02654_ sky130_fd_sc_hd__a21oi_1
X_13803_ network.neuron_in027.counter\[2\] net391 VSS VSS
+ VDD VDD _03613_ sky130_fd_sc_hd__nand2_1
X_13804_ network.neuron_in027.counter\[3\] network.in_period\[27\]\[2\]
+ _03613_ VSS VSS VDD VDD _03614_ sky130_fd_sc_hd__o21ai_0
Xclkbuf_leaf_18_clk clknet_5_8__leaf_clk VSS VSS VDD VDD clknet_leaf_18_clk
+ sky130_fd_sc_hd__clkbuf_16
X_13806_ _00365_ network.neuron_in027.counter\[2\] net373
+ VSS VSS VDD VDD _03616_ sky130_fd_sc_hd__or3_1
X_13807_ network.in_period\[27\]\[2\] net391 _03616_ VSS VSS
+ VDD VDD _03617_ sky130_fd_sc_hd__o21ai_0
X_13808_ _00365_ _03614_ _03617_ VSS VSS VDD VDD _02174_ sky130_fd_sc_hd__a21oi_1
X_13809_ network.neuron_in025.counter\[2\] _00454_ VSS VSS
+ VDD VDD _03618_ sky130_fd_sc_hd__xnor2_1
X_13810_ network.neuron_in025.counter\[2\] network.neuron_in025.counter\[3\]
+ VSS VSS VDD VDD _03619_ sky130_fd_sc_hd__nor2_1
X_13811_ _00454_ _03619_ VSS VSS VDD VDD _03620_ sky130_fd_sc_hd__nand2_1
X_13812_ net391 _03620_ network.in_period\[25\]\[2\] VSS VSS
+ VDD VDD _03621_ sky130_fd_sc_hd__a21oi_1
X_13813_ net391 _03618_ _03621_ VSS VSS VDD VDD _02166_ sky130_fd_sc_hd__a21oi_1
X_13814_ network.neuron_in025.counter\[0\] VSS VSS VDD VDD
+ _00452_ sky130_fd_sc_hd__inv_1
X_13815_ net391 _03620_ VSS VSS VDD VDD _03622_ sky130_fd_sc_hd__nand2_1
X_13816_ network.in_period\[25\]\[0\] _03622_ VSS VSS VDD
+ VDD _03623_ sky130_fd_sc_hd__nand2_1
X_13817_ network.neuron_in025.counter\[0\] _03622_ _03623_
+ VSS VSS VDD VDD _02164_ sky130_fd_sc_hd__o21ai_0
X_13818_ network.neuron_in026.counter\[3\] _00450_ VSS VSS
+ VDD VDD _03624_ sky130_fd_sc_hd__nand2b_1
X_13819_ network.neuron_in026.counter\[2\] _03624_ VSS VSS
+ VDD VDD _03625_ sky130_fd_sc_hd__or2_2
X_13820_ net388 _03625_ VSS VSS VDD VDD _03626_ sky130_fd_sc_hd__nand2_1
X_13821_ network.in_period\[26\]\[1\] _03626_ VSS VSS VDD
+ VDD _03627_ sky130_fd_sc_hd__nand2_1
X_13822_ _00451_ _03626_ _03627_ VSS VSS VDD VDD _02169_ sky130_fd_sc_hd__o21ai_0
X_13823_ network.neuron_in026.counter\[0\] VSS VSS VDD VDD
+ _00448_ sky130_fd_sc_hd__inv_1
X_13824_ network.in_period\[26\]\[0\] _03626_ VSS VSS VDD
+ VDD _03628_ sky130_fd_sc_hd__nand2_1
X_13825_ network.neuron_in026.counter\[0\] _03626_ _03628_
+ VSS VSS VDD VDD _02168_ sky130_fd_sc_hd__o21ai_0
X_13826_ network.neuron_in027.counter\[2\] _00365_ VSS VSS
+ VDD VDD _03629_ sky130_fd_sc_hd__nor2b_1
X_13827_ network.neuron_in027.counter\[3\] _03629_ VSS VSS
+ VDD VDD _03630_ sky130_fd_sc_hd__nand2b_1
X_13828_ net391 _03630_ VSS VSS VDD VDD _03631_ sky130_fd_sc_hd__nand2_1
X_13829_ network.in_period\[27\]\[1\] _03631_ VSS VSS VDD
+ VDD _03632_ sky130_fd_sc_hd__nand2_1
X_13830_ _00366_ _03631_ _03632_ VSS VSS VDD VDD _02173_ sky130_fd_sc_hd__o21ai_0
X_13831_ network.neuron_in157.counter\[1\] VSS VSS VDD VDD
+ _00687_ sky130_fd_sc_hd__inv_1
X_13832_ network.neuron_in032.counter\[0\] VSS VSS VDD VDD
+ _01163_ sky130_fd_sc_hd__inv_1
X_13833_ network.neuron_in032.counter\[3\] _01165_ VSS VSS
+ VDD VDD _03633_ sky130_fd_sc_hd__nand2b_1
X_13834_ network.neuron_in032.counter\[2\] VSS VSS VDD VDD
+ _03634_ sky130_fd_sc_hd__inv_1
X_13835_ _03633_ _03634_ VSS VSS VDD VDD _03635_ sky130_fd_sc_hd__nand2b_1
X_13836_ net396 _03635_ VSS VSS VDD VDD _03636_ sky130_fd_sc_hd__nand2_1
X_13837_ network.in_period\[32\]\[0\] _03636_ VSS VSS VDD
+ VDD _03637_ sky130_fd_sc_hd__nand2_1
X_13838_ network.neuron_in032.counter\[0\] _03636_ _03637_
+ VSS VSS VDD VDD _02192_ sky130_fd_sc_hd__o21ai_0
X_13839_ network.in_period\[32\]\[1\] _03636_ VSS VSS VDD
+ VDD _03638_ sky130_fd_sc_hd__nand2_1
X_13840_ _01166_ _03636_ _03638_ VSS VSS VDD VDD _02193_ sky130_fd_sc_hd__o21ai_0
X_13841_ network.neuron_in031.counter\[2\] VSS VSS VDD VDD
+ _03639_ sky130_fd_sc_hd__inv_1
X_13842_ network.neuron_in031.counter\[3\] network.in_period\[31\]\[2\]
+ _01201_ net373 VSS VSS VDD VDD _03640_ sky130_fd_sc_hd__o22ai_1
X_13843_ network.neuron_in031.counter\[2\] _01201_ net391
+ VSS VSS VDD VDD _03641_ sky130_fd_sc_hd__nand3_1
X_13844_ network.in_period\[31\]\[2\] net391 _03641_ VSS VSS
+ VDD VDD _03642_ sky130_fd_sc_hd__o21ai_0
X_13845_ _03639_ _03640_ _03642_ VSS VSS VDD VDD _02190_ sky130_fd_sc_hd__a21oi_1
X_13846_ network.neuron_in032.counter\[3\] network.in_period\[32\]\[2\]
+ _01165_ net379 VSS VSS VDD VDD _03643_ sky130_fd_sc_hd__o22ai_1
X_13847_ network.neuron_in032.counter\[2\] _01165_ net396
+ VSS VSS VDD VDD _03644_ sky130_fd_sc_hd__nand3_1
X_13848_ network.in_period\[32\]\[2\] net396 _03644_ VSS VSS
+ VDD VDD _03645_ sky130_fd_sc_hd__o21ai_0
X_13849_ _03634_ _03643_ _03645_ VSS VSS VDD VDD _02194_ sky130_fd_sc_hd__a21oi_1
X_13850_ network.neuron_in033.counter\[2\] _01125_ VSS VSS
+ VDD VDD _03646_ sky130_fd_sc_hd__nor2b_1
X_13851_ network.neuron_in033.counter\[3\] _03646_ VSS VSS
+ VDD VDD _03647_ sky130_fd_sc_hd__nand2b_1
X_13852_ net397 _03647_ VSS VSS VDD VDD _03648_ sky130_fd_sc_hd__nand2_1
X_13853_ network.in_period\[33\]\[1\] _03648_ VSS VSS VDD
+ VDD _03649_ sky130_fd_sc_hd__nand2_1
X_13854_ _01126_ _03648_ _03649_ VSS VSS VDD VDD _02197_ sky130_fd_sc_hd__o21ai_0
X_13855_ network.neuron_in001.counter\[1\] VSS VSS VDD VDD
+ _00739_ sky130_fd_sc_hd__inv_1
X_13856_ network.neuron_in031.counter\[3\] _01201_ VSS VSS
+ VDD VDD _03650_ sky130_fd_sc_hd__nand2b_1
X_13857_ _03650_ _03639_ VSS VSS VDD VDD _03651_ sky130_fd_sc_hd__nand2b_1
X_13858_ net391 _03651_ VSS VSS VDD VDD _03652_ sky130_fd_sc_hd__nand2_1
X_13859_ network.in_period\[31\]\[1\] _03652_ VSS VSS VDD
+ VDD _03653_ sky130_fd_sc_hd__nand2_1
X_13860_ _01202_ _03652_ _03653_ VSS VSS VDD VDD _02189_ sky130_fd_sc_hd__o21ai_0
X_13861_ network.neuron_in095.counter\[1\] VSS VSS VDD VDD
+ _01246_ sky130_fd_sc_hd__inv_1
X_13862_ network.neuron_in031.counter\[0\] VSS VSS VDD VDD
+ _01199_ sky130_fd_sc_hd__inv_1
X_13863_ network.in_period\[31\]\[0\] _03652_ VSS VSS VDD
+ VDD _03654_ sky130_fd_sc_hd__nand2_1
X_13864_ network.neuron_in031.counter\[0\] _03652_ _03654_
+ VSS VSS VDD VDD _02188_ sky130_fd_sc_hd__o21ai_0
X_13865_ network.neuron_in033.counter\[2\] net397 VSS VSS
+ VDD VDD _03655_ sky130_fd_sc_hd__nand2_1
X_13866_ network.neuron_in033.counter\[3\] network.in_period\[33\]\[2\]
+ _03655_ VSS VSS VDD VDD _03656_ sky130_fd_sc_hd__o21ai_0
X_13867_ _01125_ network.neuron_in033.counter\[2\] net381
+ VSS VSS VDD VDD _03657_ sky130_fd_sc_hd__or3_1
X_13868_ network.in_period\[33\]\[2\] net397 _03657_ VSS VSS
+ VDD VDD _03658_ sky130_fd_sc_hd__o21ai_0
X_13869_ _01125_ _03656_ _03658_ VSS VSS VDD VDD _02198_ sky130_fd_sc_hd__a21oi_1
X_13870_ network.in_period\[33\]\[0\] _03648_ VSS VSS VDD
+ VDD _03659_ sky130_fd_sc_hd__nand2_1
X_13871_ network.neuron_in033.counter\[0\] _03648_ _03659_
+ VSS VSS VDD VDD _02196_ sky130_fd_sc_hd__o21ai_0
X_13872_ network.neuron_in036.counter\[2\] VSS VSS VDD VDD
+ _03660_ sky130_fd_sc_hd__inv_1
X_13873_ network.neuron_in036.counter\[3\] network.in_period\[36\]\[2\]
+ net380 _00349_ VSS VSS VDD VDD _03661_ sky130_fd_sc_hd__o22ai_1
X_13874_ network.neuron_in036.counter\[2\] _00349_ net397
+ VSS VSS VDD VDD _03662_ sky130_fd_sc_hd__nand3_1
X_13875_ network.in_period\[36\]\[2\] net397 _03662_ VSS VSS
+ VDD VDD _03663_ sky130_fd_sc_hd__o21ai_0
X_13876_ _03660_ _03661_ _03663_ VSS VSS VDD VDD _02210_ sky130_fd_sc_hd__a21oi_1
X_13877_ network.neuron_in034.counter\[2\] VSS VSS VDD VDD
+ _03664_ sky130_fd_sc_hd__inv_1
X_13878_ network.neuron_in034.counter\[3\] network.in_period\[34\]\[2\]
+ net380 _00361_ VSS VSS VDD VDD _03665_ sky130_fd_sc_hd__o22ai_1
X_13879_ network.neuron_in034.counter\[2\] _00361_ net397
+ VSS VSS VDD VDD _03666_ sky130_fd_sc_hd__nand3_1
X_13880_ network.in_period\[34\]\[2\] net397 _03666_ VSS VSS
+ VDD VDD _03667_ sky130_fd_sc_hd__o21ai_0
X_13881_ _03664_ _03665_ _03667_ VSS VSS VDD VDD _02202_ sky130_fd_sc_hd__a21oi_1
X_13882_ network.neuron_in035.counter\[2\] net397 VSS VSS
+ VDD VDD _03668_ sky130_fd_sc_hd__nand2_1
X_13883_ network.neuron_in035.counter\[3\] network.in_period\[35\]\[2\]
+ _03668_ VSS VSS VDD VDD _03669_ sky130_fd_sc_hd__o21ai_0
X_13884_ _00444_ network.neuron_in035.counter\[2\] net380
+ VSS VSS VDD VDD _03670_ sky130_fd_sc_hd__or3_1
X_13885_ network.in_period\[35\]\[2\] net397 _03670_ VSS VSS
+ VDD VDD _03671_ sky130_fd_sc_hd__o21ai_0
X_13886_ _00444_ _03669_ _03671_ VSS VSS VDD VDD _02206_ sky130_fd_sc_hd__a21oi_1
X_13887_ network.neuron_in034.counter\[3\] _00361_ VSS VSS
+ VDD VDD _03672_ sky130_fd_sc_hd__nand2b_1
X_13888_ _03672_ _03664_ VSS VSS VDD VDD _03673_ sky130_fd_sc_hd__nand2b_1
X_13889_ net397 _03673_ VSS VSS VDD VDD _03674_ sky130_fd_sc_hd__nand2_1
X_13890_ network.in_period\[34\]\[1\] _03674_ VSS VSS VDD
+ VDD _03675_ sky130_fd_sc_hd__nand2_1
X_13891_ _00362_ _03674_ _03675_ VSS VSS VDD VDD _02201_ sky130_fd_sc_hd__o21ai_0
X_13892_ network.neuron_in134.counter\[0\] VSS VSS VDD VDD
+ _01119_ sky130_fd_sc_hd__inv_1
X_13893_ network.neuron_in034.counter\[0\] VSS VSS VDD VDD
+ _00359_ sky130_fd_sc_hd__inv_1
X_13894_ network.in_period\[34\]\[0\] _03674_ VSS VSS VDD
+ VDD _03676_ sky130_fd_sc_hd__nand2_1
X_13895_ network.neuron_in034.counter\[0\] _03674_ _03676_
+ VSS VSS VDD VDD _02200_ sky130_fd_sc_hd__o21ai_0
X_13896_ network.neuron_in035.counter\[2\] network.neuron_in035.counter\[3\]
+ VSS VSS VDD VDD _03677_ sky130_fd_sc_hd__nor2_1
X_13897_ _00444_ _03677_ VSS VSS VDD VDD _03678_ sky130_fd_sc_hd__nand2_1
X_13898_ net397 _03678_ VSS VSS VDD VDD _03679_ sky130_fd_sc_hd__nand2_1
X_13899_ network.in_period\[35\]\[1\] _03679_ VSS VSS VDD
+ VDD _03680_ sky130_fd_sc_hd__nand2_1
X_13900_ _00445_ _03679_ _03680_ VSS VSS VDD VDD _02205_ sky130_fd_sc_hd__o21ai_0
X_13901_ network.in_period\[35\]\[0\] _03679_ VSS VSS VDD
+ VDD _03681_ sky130_fd_sc_hd__nand2_1
X_13902_ network.neuron_in035.counter\[0\] _03679_ _03681_
+ VSS VSS VDD VDD _02204_ sky130_fd_sc_hd__o21ai_0
X_13903_ net402 net293 VSS VSS VDD VDD _03682_ sky130_fd_sc_hd__nand2_1
X_13904_ network.cnt_main.counter\[10\] network.cnt_main.counter\[11\]
+ network.cnt_main.counter\[9\] _08406_ VSS VSS VDD VDD _03683_
+ sky130_fd_sc_hd__nor4_1
X_13905_ network.cnt_main.counter\[12\] _03683_ VSS VSS VDD
+ VDD _03684_ sky130_fd_sc_hd__xnor2_1
X_13906_ _03682_ _03684_ VSS VSS VDD VDD _01731_ sky130_fd_sc_hd__nor2_1
X_13907_ net407 net293 VSS VSS VDD VDD _03685_ sky130_fd_sc_hd__and2_1
Xclkbuf_leaf_15_clk clknet_5_2__leaf_clk VSS VSS VDD VDD clknet_leaf_15_clk
+ sky130_fd_sc_hd__clkbuf_16
Xplace445 net20 VSS VSS VDD VDD net444 sky130_fd_sc_hd__buf_4
Xplace412 net412 VSS VSS VDD VDD net411 sky130_fd_sc_hd__buf_4
X_13911_ network.cnt_main.counter\[10\] network.cnt_main.counter\[9\]
+ VSS VSS VDD VDD _03689_ sky130_fd_sc_hd__nor2_1
X_13912_ network.cnt_main.counter\[0\] network.cnt_main.counter\[1\]
+ VSS VSS VDD VDD _03690_ sky130_fd_sc_hd__nor2_1
X_13913_ _08404_ _03690_ VSS VSS VDD VDD _03691_ sky130_fd_sc_hd__nand2_1
X_13914_ network.cnt_main.counter\[8\] network.cnt_main.counter\[6\]
+ network.cnt_main.counter\[7\] _03691_ VSS VSS VDD VDD _03692_
+ sky130_fd_sc_hd__nor4_1
X_13915_ _03689_ _03692_ VSS VSS VDD VDD _03693_ sky130_fd_sc_hd__nand2_1
X_13916_ network.cnt_main.counter\[11\] _03693_ VSS VSS VDD
+ VDD _03694_ sky130_fd_sc_hd__xor2_1
X_13917_ _03685_ _03694_ VSS VSS VDD VDD _01732_ sky130_fd_sc_hd__nand2_1
X_13918_ network.cnt_main.counter\[9\] _08406_ VSS VSS VDD
+ VDD _03695_ sky130_fd_sc_hd__nor2_1
X_13919_ network.cnt_main.counter\[10\] _03695_ VSS VSS VDD
+ VDD _03696_ sky130_fd_sc_hd__xnor2_1
X_13920_ _03682_ _03696_ VSS VSS VDD VDD _01733_ sky130_fd_sc_hd__nor2_1
X_13921_ network.cnt_main.counter\[9\] _03692_ VSS VSS VDD
+ VDD _03697_ sky130_fd_sc_hd__xnor2_1
X_13922_ _03682_ _03697_ VSS VSS VDD VDD _01734_ sky130_fd_sc_hd__nor2_1
X_13923_ network.cnt_main.counter\[6\] network.cnt_main.counter\[7\]
+ _08405_ network.cnt_main.counter\[8\] VSS VSS VDD VDD _03698_
+ sky130_fd_sc_hd__o31ai_1
X_13924_ net402 _08406_ _03698_ VSS VSS VDD VDD _01735_ sky130_fd_sc_hd__nand3_1
X_13925_ network.cnt_main.counter\[6\] _03691_ VSS VSS VDD
+ VDD _03699_ sky130_fd_sc_hd__nor2_1
X_13926_ network.cnt_main.counter\[7\] _03699_ VSS VSS VDD
+ VDD _03700_ sky130_fd_sc_hd__xnor2_1
X_13927_ _03685_ _03700_ VSS VSS VDD VDD _01736_ sky130_fd_sc_hd__nand2_1
X_13928_ network.cnt_main.counter\[6\] _08405_ VSS VSS VDD
+ VDD _03701_ sky130_fd_sc_hd__xor2_1
X_13929_ net402 _03701_ VSS VSS VDD VDD _01737_ sky130_fd_sc_hd__nand2_1
X_13930_ network.cnt_main.counter\[3\] network.cnt_main.counter\[2\]
+ VSS VSS VDD VDD _03702_ sky130_fd_sc_hd__nor2_1
X_13931_ _03702_ _03690_ VSS VSS VDD VDD _03703_ sky130_fd_sc_hd__nand2_1
X_13932_ network.cnt_main.counter\[4\] _03703_ network.cnt_main.counter\[5\]
+ VSS VSS VDD VDD _03704_ sky130_fd_sc_hd__o21ai_0
X_13933_ _03691_ _03704_ _03682_ VSS VSS VDD VDD _01738_ sky130_fd_sc_hd__a21oi_1
X_13934_ _00617_ _03702_ VSS VSS VDD VDD _03705_ sky130_fd_sc_hd__nand2_1
X_13935_ network.cnt_main.counter\[4\] _03705_ VSS VSS VDD
+ VDD _03706_ sky130_fd_sc_hd__xor2_1
X_13936_ _03682_ _03706_ VSS VSS VDD VDD _01739_ sky130_fd_sc_hd__nor2_1
X_13937_ network.cnt_main.counter\[2\] network.cnt_main.counter\[0\]
+ network.cnt_main.counter\[1\] network.cnt_main.counter\[3\]
+ VSS VSS VDD VDD _03707_ sky130_fd_sc_hd__o31ai_1
X_13938_ _03703_ _03707_ _03682_ VSS VSS VDD VDD _01740_ sky130_fd_sc_hd__a21oi_1
X_13939_ network.cnt_main.counter\[2\] _00617_ VSS VSS VDD
+ VDD _03708_ sky130_fd_sc_hd__xnor2_1
X_13940_ _03685_ _03708_ VSS VSS VDD VDD _01741_ sky130_fd_sc_hd__nand2_1
X_13941_ _00618_ _03682_ VSS VSS VDD VDD _01742_ sky130_fd_sc_hd__nor2_1
X_13942_ network.cnt_main.counter\[0\] _03682_ VSS VSS VDD
+ VDD _01743_ sky130_fd_sc_hd__nor2_1
X_13943_ network.neuron_in037.counter\[2\] network.neuron_in037.counter\[3\]
+ VSS VSS VDD VDD _03709_ sky130_fd_sc_hd__nor2_1
X_13944_ _00345_ _03709_ VSS VSS VDD VDD _03710_ sky130_fd_sc_hd__nand2_1
X_13945_ net397 _03710_ VSS VSS VDD VDD _03711_ sky130_fd_sc_hd__nand2_1
X_13946_ network.in_period\[37\]\[0\] _03711_ VSS VSS VDD
+ VDD _03712_ sky130_fd_sc_hd__nand2_1
X_13947_ network.neuron_in037.counter\[0\] _03711_ _03712_
+ VSS VSS VDD VDD _02212_ sky130_fd_sc_hd__o21ai_0
X_13948_ network.in_period\[37\]\[1\] _03711_ VSS VSS VDD
+ VDD _03713_ sky130_fd_sc_hd__nand2_1
X_13949_ _00346_ _03711_ _03713_ VSS VSS VDD VDD _02213_ sky130_fd_sc_hd__o21ai_0
X_13950_ network.neuron_in124.counter\[2\] network.neuron_in124.counter\[3\]
+ VSS VSS VDD VDD _03714_ sky130_fd_sc_hd__nor2_1
X_13951_ _00300_ _03714_ VSS VSS VDD VDD _03715_ sky130_fd_sc_hd__nand2_1
X_13952_ net383 _03715_ VSS VSS VDD VDD _03716_ sky130_fd_sc_hd__nand2_1
X_13953_ network.in_period\[124\]\[0\] _03716_ VSS VSS VDD
+ VDD _03717_ sky130_fd_sc_hd__nand2_1
X_13954_ network.neuron_in124.counter\[0\] _03716_ _03717_
+ VSS VSS VDD VDD _02560_ sky130_fd_sc_hd__o21ai_0
X_13955_ network.neuron_in125.counter\[2\] net383 VSS VSS
+ VDD VDD _03718_ sky130_fd_sc_hd__nand2_1
X_13956_ network.in_period\[125\]\[2\] network.neuron_in125.counter\[3\]
+ _03718_ VSS VSS VDD VDD _03719_ sky130_fd_sc_hd__o21ai_0
X_13957_ _00432_ network.neuron_in125.counter\[2\] net374
+ VSS VSS VDD VDD _03720_ sky130_fd_sc_hd__or3_1
X_13958_ network.in_period\[125\]\[2\] net383 _03720_ VSS
+ VSS VDD VDD _03721_ sky130_fd_sc_hd__o21ai_0
X_13959_ _00432_ _03719_ _03721_ VSS VSS VDD VDD _02566_ sky130_fd_sc_hd__a21oi_1
X_13960_ network.neuron_in037.counter\[2\] _00345_ VSS VSS
+ VDD VDD _03722_ sky130_fd_sc_hd__xnor2_1
X_13961_ net397 _03710_ network.in_period\[37\]\[2\] VSS VSS
+ VDD VDD _03723_ sky130_fd_sc_hd__a21oi_1
X_13962_ net397 _03722_ _03723_ VSS VSS VDD VDD _02214_ sky130_fd_sc_hd__a21oi_1
X_13963_ network.neuron_in038.counter\[2\] VSS VSS VDD VDD
+ _03724_ sky130_fd_sc_hd__inv_1
Xplace410 network.neuron_hid0.ROM0.address\[6\] VSS VSS VDD
+ VDD net409 sky130_fd_sc_hd__buf_4
X_13965_ network.neuron_in038.counter\[3\] network.in_period\[38\]\[2\]
+ net380 _00333_ VSS VSS VDD VDD _03726_ sky130_fd_sc_hd__o22ai_1
X_13966_ network.neuron_in038.counter\[2\] _00333_ net397
+ VSS VSS VDD VDD _03727_ sky130_fd_sc_hd__nand3_1
X_13967_ network.in_period\[38\]\[2\] net397 _03727_ VSS VSS
+ VDD VDD _03728_ sky130_fd_sc_hd__o21ai_0
X_13968_ _03724_ _03726_ _03728_ VSS VSS VDD VDD _02218_ sky130_fd_sc_hd__a21oi_1
X_13969_ network.neuron_in036.counter\[2\] _00349_ VSS VSS
+ VDD VDD _03729_ sky130_fd_sc_hd__nor2b_1
X_13970_ network.neuron_in036.counter\[3\] _03729_ VSS VSS
+ VDD VDD _03730_ sky130_fd_sc_hd__nand2b_1
X_13971_ net397 _03730_ VSS VSS VDD VDD _03731_ sky130_fd_sc_hd__nand2_1
X_13972_ network.in_period\[36\]\[1\] _03731_ VSS VSS VDD
+ VDD _03732_ sky130_fd_sc_hd__nand2_1
X_13973_ _00350_ _03731_ _03732_ VSS VSS VDD VDD _02209_ sky130_fd_sc_hd__o21ai_0
X_13974_ network.in_period\[36\]\[0\] _03731_ VSS VSS VDD
+ VDD _03733_ sky130_fd_sc_hd__nand2_1
X_13975_ network.neuron_in036.counter\[0\] _03731_ _03733_
+ VSS VSS VDD VDD _02208_ sky130_fd_sc_hd__o21ai_0
X_13976_ network.neuron_in116.counter\[0\] VSS VSS VDD VDD
+ _00038_ sky130_fd_sc_hd__inv_1
X_13977_ network.neuron_in098.counter\[1\] VSS VSS VDD VDD
+ _00943_ sky130_fd_sc_hd__inv_1
X_13978_ network.neuron_in038.counter\[3\] VSS VSS VDD VDD
+ _03734_ sky130_fd_sc_hd__inv_1
X_13979_ _03724_ _00333_ _03734_ VSS VSS VDD VDD _03735_ sky130_fd_sc_hd__nand3_1
X_13980_ net397 _03735_ VSS VSS VDD VDD _03736_ sky130_fd_sc_hd__nand2_1
X_13981_ network.in_period\[38\]\[1\] _03736_ VSS VSS VDD
+ VDD _03737_ sky130_fd_sc_hd__nand2_1
X_13982_ _00334_ _03736_ _03737_ VSS VSS VDD VDD _02217_ sky130_fd_sc_hd__o21ai_0
X_13983_ network.neuron_in038.counter\[0\] VSS VSS VDD VDD
+ _00331_ sky130_fd_sc_hd__inv_1
X_13984_ network.in_period\[38\]\[0\] _03736_ VSS VSS VDD
+ VDD _03738_ sky130_fd_sc_hd__nand2_1
X_13985_ network.neuron_in038.counter\[0\] _03736_ _03738_
+ VSS VSS VDD VDD _02216_ sky130_fd_sc_hd__o21ai_0
X_13986_ network.neuron_in043.counter\[2\] _00296_ VSS VSS
+ VDD VDD _03739_ sky130_fd_sc_hd__xnor2_1
Xplace409 net409 VSS VSS VDD VDD net408 sky130_fd_sc_hd__buf_4
Xplace438 net21 VSS VSS VDD VDD net437 sky130_fd_sc_hd__buf_4
X_13989_ network.neuron_in043.counter\[2\] network.neuron_in043.counter\[3\]
+ _00296_ VSS VSS VDD VDD _03742_ sky130_fd_sc_hd__or3b_2
X_13990_ net397 _03742_ network.in_period\[43\]\[2\] VSS VSS
+ VDD VDD _03743_ sky130_fd_sc_hd__a21oi_1
X_13991_ net397 _03739_ _03743_ VSS VSS VDD VDD _02238_ sky130_fd_sc_hd__a21oi_1
X_13992_ network.neuron_in041.counter\[2\] network.neuron_in041.counter\[3\]
+ VSS VSS VDD VDD _03744_ sky130_fd_sc_hd__nor2_1
X_13993_ _00312_ _03744_ VSS VSS VDD VDD _03745_ sky130_fd_sc_hd__nand2_1
X_13994_ net397 _03745_ VSS VSS VDD VDD _03746_ sky130_fd_sc_hd__nand2_1
X_13995_ network.in_period\[41\]\[1\] _03746_ VSS VSS VDD
+ VDD _03747_ sky130_fd_sc_hd__nand2_1
X_13996_ _00313_ _03746_ _03747_ VSS VSS VDD VDD _02229_ sky130_fd_sc_hd__o21ai_0
X_13997_ network.neuron_in098.counter\[0\] VSS VSS VDD VDD
+ _00942_ sky130_fd_sc_hd__inv_1
X_13998_ network.neuron_in135.counter\[1\] VSS VSS VDD VDD
+ _00864_ sky130_fd_sc_hd__inv_1
X_13999_ network.neuron_in086.counter\[1\] VSS VSS VDD VDD
+ _00047_ sky130_fd_sc_hd__inv_1
X_14000_ network.neuron_in227.counter\[1\] VSS VSS VDD VDD
+ _01188_ sky130_fd_sc_hd__inv_1
X_14001_ network.neuron_in237.counter\[1\] VSS VSS VDD VDD
+ _00935_ sky130_fd_sc_hd__inv_1
X_14002_ network.neuron_in144.counter\[3\] _06694_ net394
+ VSS VSS VDD VDD _03748_ sky130_fd_sc_hd__o21ai_0
X_14003_ network.in_period\[144\]\[1\] _03748_ VSS VSS VDD
+ VDD _03749_ sky130_fd_sc_hd__nand2_1
X_14004_ _00737_ _03748_ _03749_ VSS VSS VDD VDD _02641_ sky130_fd_sc_hd__o21ai_0
X_14005_ network.neuron_in104.counter\[0\] VSS VSS VDD VDD
+ _00678_ sky130_fd_sc_hd__inv_1
X_14006_ network.neuron_in207.counter\[1\] VSS VSS VDD VDD
+ _01172_ sky130_fd_sc_hd__inv_1
X_14007_ network.neuron_in229.counter\[1\] VSS VSS VDD VDD
+ _00803_ sky130_fd_sc_hd__inv_1
X_14008_ network.neuron_in252.counter\[1\] VSS VSS VDD VDD
+ _00931_ sky130_fd_sc_hd__inv_1
X_14009_ network.in_period\[134\]\[0\] _06826_ VSS VSS VDD
+ VDD _03750_ sky130_fd_sc_hd__nand2_1
X_14010_ network.neuron_in134.counter\[0\] _06826_ _03750_
+ VSS VSS VDD VDD _02600_ sky130_fd_sc_hd__o21ai_0
X_14011_ network.neuron_in223.counter\[1\] VSS VSS VDD VDD
+ _00899_ sky130_fd_sc_hd__inv_1
X_14012_ network.neuron_in163.counter\[1\] VSS VSS VDD VDD
+ _00819_ sky130_fd_sc_hd__inv_1
X_14013_ network.neuron_in167.counter\[1\] VSS VSS VDD VDD
+ _00927_ sky130_fd_sc_hd__inv_1
X_14014_ network.neuron_in097.counter\[0\] VSS VSS VDD VDD
+ _01213_ sky130_fd_sc_hd__inv_1
X_14015_ network.neuron_in197.counter\[1\] VSS VSS VDD VDD
+ _00823_ sky130_fd_sc_hd__inv_1
X_14016_ network.neuron_in244.counter\[1\] VSS VSS VDD VDD
+ _00923_ sky130_fd_sc_hd__inv_1
X_14017_ network.neuron_in104.counter\[1\] VSS VSS VDD VDD
+ _00679_ sky130_fd_sc_hd__inv_1
X_14018_ network.neuron_in164.counter\[1\] VSS VSS VDD VDD
+ _00860_ sky130_fd_sc_hd__inv_1
X_14019_ network.neuron_in245.counter\[1\] VSS VSS VDD VDD
+ _01196_ sky130_fd_sc_hd__inv_1
X_14020_ network.neuron_in247.counter\[1\] VSS VSS VDD VDD
+ _00757_ sky130_fd_sc_hd__inv_1
X_14021_ network.neuron_in201.counter\[1\] VSS VSS VDD VDD
+ _00795_ sky130_fd_sc_hd__inv_1
X_14022_ network.neuron_in236.counter\[1\] VSS VSS VDD VDD
+ _00368_ sky130_fd_sc_hd__inv_1
X_14023_ network.neuron_in248.counter\[1\] VSS VSS VDD VDD
+ _00919_ sky130_fd_sc_hd__inv_1
X_14024_ network.in_period\[144\]\[0\] _03748_ VSS VSS VDD
+ VDD _03751_ sky130_fd_sc_hd__nand2_1
X_14025_ network.neuron_in144.counter\[0\] _03748_ _03751_
+ VSS VSS VDD VDD _02640_ sky130_fd_sc_hd__o21ai_0
X_14026_ network.neuron_in028.counter\[0\] VSS VSS VDD VDD
+ _00355_ sky130_fd_sc_hd__inv_1
X_14027_ network.neuron_in100.counter\[0\] VSS VSS VDD VDD
+ _00702_ sky130_fd_sc_hd__inv_1
X_14028_ network.neuron_in218.counter\[1\] VSS VSS VDD VDD
+ _01184_ sky130_fd_sc_hd__inv_1
X_14029_ network.neuron_in192.counter\[1\] VSS VSS VDD VDD
+ _00748_ sky130_fd_sc_hd__inv_1
X_14030_ _00312_ network.neuron_in041.counter\[2\] VSS VSS
+ VDD VDD _03752_ sky130_fd_sc_hd__xnor2_1
X_14031_ net397 _03745_ network.in_period\[41\]\[2\] VSS VSS
+ VDD VDD _03753_ sky130_fd_sc_hd__a21oi_1
X_14032_ net397 _03752_ _03753_ VSS VSS VDD VDD _02230_ sky130_fd_sc_hd__a21oi_1
X_14033_ network.neuron_in165.counter\[1\] VSS VSS VDD VDD
+ _00885_ sky130_fd_sc_hd__inv_1
X_14034_ network.neuron_in254.counter\[1\] VSS VSS VDD VDD
+ _00915_ sky130_fd_sc_hd__inv_1
X_14035_ network.neuron_in096.counter\[1\] VSS VSS VDD VDD
+ _01210_ sky130_fd_sc_hd__inv_1
X_14036_ network.neuron_hid0.IF0.ref_counter\[1\] VSS VSS
+ VDD VDD _00911_ sky130_fd_sc_hd__inv_1
X_14037_ network.neuron_in039.counter\[3\] _00329_ VSS VSS
+ VDD VDD _03754_ sky130_fd_sc_hd__nand2b_1
X_14038_ network.neuron_in039.counter\[2\] VSS VSS VDD VDD
+ _03755_ sky130_fd_sc_hd__inv_1
X_14039_ _03754_ _03755_ VSS VSS VDD VDD _03756_ sky130_fd_sc_hd__nand2b_1
X_14040_ net397 _03756_ VSS VSS VDD VDD _03757_ sky130_fd_sc_hd__nand2_1
X_14041_ network.in_period\[39\]\[0\] _03757_ VSS VSS VDD
+ VDD _03758_ sky130_fd_sc_hd__nand2_1
X_14042_ network.neuron_in039.counter\[0\] _03757_ _03758_
+ VSS VSS VDD VDD _02220_ sky130_fd_sc_hd__o21ai_0
X_14043_ network.neuron_in166.counter\[1\] VSS VSS VDD VDD
+ _00907_ sky130_fd_sc_hd__inv_1
X_14044_ network.neuron_in040.counter\[2\] _00317_ VSS VSS
+ VDD VDD _03759_ sky130_fd_sc_hd__nor2b_1
X_14045_ network.neuron_in040.counter\[3\] _03759_ VSS VSS
+ VDD VDD _03760_ sky130_fd_sc_hd__nand2b_1
X_14046_ net397 _03760_ VSS VSS VDD VDD _03761_ sky130_fd_sc_hd__nand2_1
X_14047_ network.in_period\[40\]\[0\] _03761_ VSS VSS VDD
+ VDD _03762_ sky130_fd_sc_hd__nand2_1
X_14048_ network.neuron_in040.counter\[0\] _03761_ _03762_
+ VSS VSS VDD VDD _02224_ sky130_fd_sc_hd__o21ai_0
X_14049_ network.in_period\[161\]\[0\] _06439_ VSS VSS VDD
+ VDD _03763_ sky130_fd_sc_hd__nand2_1
X_14050_ network.neuron_in161.counter\[0\] _06439_ _03763_
+ VSS VSS VDD VDD _02708_ sky130_fd_sc_hd__o21ai_0
X_14051_ network.neuron_in162.counter\[2\] VSS VSS VDD VDD
+ _03764_ sky130_fd_sc_hd__inv_1
X_14052_ network.neuron_in162.counter\[3\] network.in_period\[162\]\[2\]
+ net370 _00776_ VSS VSS VDD VDD _03765_ sky130_fd_sc_hd__o22ai_1
X_14053_ network.neuron_in162.counter\[2\] _00776_ net402
+ VSS VSS VDD VDD _03766_ sky130_fd_sc_hd__nand3_1
X_14054_ network.in_period\[162\]\[2\] net402 _03766_ VSS
+ VSS VDD VDD _03767_ sky130_fd_sc_hd__o21ai_0
X_14055_ _03764_ _03765_ _03767_ VSS VSS VDD VDD _02714_ sky130_fd_sc_hd__a21oi_1
X_14056_ network.neuron_in222.counter\[1\] VSS VSS VDD VDD
+ _00895_ sky130_fd_sc_hd__inv_1
Xplace413 network.neuron_hid0.ROM0.address\[5\] VSS VSS VDD
+ VDD net412 sky130_fd_sc_hd__buf_4
X_14058_ network.neuron_in162.counter\[3\] _00776_ VSS VSS
+ VDD VDD _03769_ sky130_fd_sc_hd__nand2b_1
X_14059_ _03769_ _03764_ VSS VSS VDD VDD _03770_ sky130_fd_sc_hd__nand2b_1
X_14060_ net402 _03770_ VSS VSS VDD VDD _03771_ sky130_fd_sc_hd__nand2_1
X_14061_ network.in_period\[162\]\[1\] _03771_ VSS VSS VDD
+ VDD _03772_ sky130_fd_sc_hd__nand2_1
X_14062_ _00777_ _03771_ _03772_ VSS VSS VDD VDD _02713_ sky130_fd_sc_hd__o21ai_0
X_14063_ network.neuron_in042.counter\[2\] _00308_ VSS VSS
+ VDD VDD _03773_ sky130_fd_sc_hd__nor2b_1
X_14064_ network.neuron_in042.counter\[3\] _03773_ VSS VSS
+ VDD VDD _03774_ sky130_fd_sc_hd__nand2b_1
X_14065_ net396 _03774_ VSS VSS VDD VDD _03775_ sky130_fd_sc_hd__nand2_1
X_14066_ network.in_period\[42\]\[0\] _03775_ VSS VSS VDD
+ VDD _03776_ sky130_fd_sc_hd__nand2_1
X_14067_ network.neuron_in042.counter\[0\] _03775_ _03776_
+ VSS VSS VDD VDD _02232_ sky130_fd_sc_hd__o21ai_0
X_14068_ network.neuron_in103.counter\[1\] VSS VSS VDD VDD
+ _00903_ sky130_fd_sc_hd__inv_1
X_14069_ network.neuron_in039.counter\[3\] network.in_period\[39\]\[2\]
+ net377 _00329_ VSS VSS VDD VDD _03777_ sky130_fd_sc_hd__o22ai_1
Xplace437 net437 VSS VSS VDD VDD net436 sky130_fd_sc_hd__buf_4
X_14071_ network.neuron_in039.counter\[2\] _00329_ net397
+ VSS VSS VDD VDD _03779_ sky130_fd_sc_hd__nand3_1
X_14072_ network.in_period\[39\]\[2\] net397 _03779_ VSS VSS
+ VDD VDD _03780_ sky130_fd_sc_hd__o21ai_0
X_14073_ _03755_ _03777_ _03780_ VSS VSS VDD VDD _02222_ sky130_fd_sc_hd__a21oi_1
X_14074_ network.neuron_in103.counter\[0\] VSS VSS VDD VDD
+ _00902_ sky130_fd_sc_hd__inv_1
X_14075_ network.in_period\[39\]\[1\] _03757_ VSS VSS VDD
+ VDD _03781_ sky130_fd_sc_hd__nand2_1
X_14076_ _00330_ _03757_ _03781_ VSS VSS VDD VDD _02221_ sky130_fd_sc_hd__o21ai_0
X_14077_ network.neuron_in139.counter\[1\] VSS VSS VDD VDD
+ _00650_ sky130_fd_sc_hd__inv_1
X_14078_ network.neuron_in228.counter\[1\] VSS VSS VDD VDD
+ _00807_ sky130_fd_sc_hd__inv_1
X_14079_ network.neuron_in154.counter\[0\] VSS VSS VDD VDD
+ _00351_ sky130_fd_sc_hd__inv_1
X_14080_ network.in_period\[154\]\[0\] _06410_ VSS VSS VDD
+ VDD _03782_ sky130_fd_sc_hd__nand2_1
X_14081_ network.neuron_in154.counter\[0\] _06410_ _03782_
+ VSS VSS VDD VDD _02680_ sky130_fd_sc_hd__o21ai_0
X_14082_ network.neuron_in174.counter\[1\] VSS VSS VDD VDD
+ _00659_ sky130_fd_sc_hd__inv_1
X_14083_ network.neuron_in052.counter\[0\] VSS VSS VDD VDD
+ _00254_ sky130_fd_sc_hd__inv_1
X_14084_ network.neuron_in206.counter\[1\] VSS VSS VDD VDD
+ _00839_ sky130_fd_sc_hd__inv_1
X_14085_ network.neuron_in116.counter\[1\] VSS VSS VDD VDD
+ _00039_ sky130_fd_sc_hd__inv_1
X_14086_ network.neuron_hid4.IF0.ref_counter\[1\] VSS VSS
+ VDD VDD _00707_ sky130_fd_sc_hd__inv_1
X_14087_ network.neuron_in195.counter\[1\] VSS VSS VDD VDD
+ _00827_ sky130_fd_sc_hd__inv_1
X_14088_ network.neuron_in186.counter\[1\] VSS VSS VDD VDD
+ _00831_ sky130_fd_sc_hd__inv_1
X_14089_ network.neuron_in179.counter\[1\] VSS VSS VDD VDD
+ _00815_ sky130_fd_sc_hd__inv_1
X_14090_ _00486_ _06470_ VSS VSS VDD VDD _03783_ sky130_fd_sc_hd__nand2_1
X_14091_ net384 _03783_ VSS VSS VDD VDD _03784_ sky130_fd_sc_hd__nand2_1
X_14092_ network.in_period\[131\]\[1\] _03784_ VSS VSS VDD
+ VDD _03785_ sky130_fd_sc_hd__nand2_1
X_14093_ _00487_ _03784_ _03785_ VSS VSS VDD VDD _02589_ sky130_fd_sc_hd__o21ai_0
X_14094_ network.neuron_in096.counter\[0\] VSS VSS VDD VDD
+ _01209_ sky130_fd_sc_hd__inv_1
X_14095_ network.neuron_in165.counter\[0\] VSS VSS VDD VDD
+ _00884_ sky130_fd_sc_hd__inv_1
X_14096_ network.in_period\[131\]\[0\] _03784_ VSS VSS VDD
+ VDD _03786_ sky130_fd_sc_hd__nand2_1
X_14097_ network.neuron_in131.counter\[0\] _03784_ _03786_
+ VSS VSS VDD VDD _02588_ sky130_fd_sc_hd__o21ai_0
X_14098_ network.neuron_in136.counter\[1\] VSS VSS VDD VDD
+ _00874_ sky130_fd_sc_hd__inv_1
X_14099_ network.neuron_in087.counter\[0\] VSS VSS VDD VDD
+ _00042_ sky130_fd_sc_hd__inv_1
X_14100_ network.neuron_in093.counter\[1\] VSS VSS VDD VDD
+ _01237_ sky130_fd_sc_hd__inv_1
X_14101_ network.in_period\[162\]\[0\] _03771_ VSS VSS VDD
+ VDD _03787_ sky130_fd_sc_hd__nand2_1
X_14102_ network.neuron_in162.counter\[0\] _03771_ _03787_
+ VSS VSS VDD VDD _02712_ sky130_fd_sc_hd__o21ai_0
X_14103_ network.in_period\[145\]\[0\] _07420_ VSS VSS VDD
+ VDD _03788_ sky130_fd_sc_hd__nand2_1
X_14104_ network.neuron_in145.counter\[0\] _07420_ _03788_
+ VSS VSS VDD VDD _02644_ sky130_fd_sc_hd__o21ai_0
X_14105_ network.neuron_in040.counter\[2\] net397 VSS VSS
+ VDD VDD _03789_ sky130_fd_sc_hd__nand2_1
X_14106_ network.neuron_in040.counter\[3\] network.in_period\[40\]\[2\]
+ _03789_ VSS VSS VDD VDD _03790_ sky130_fd_sc_hd__o21ai_0
X_14107_ _00317_ network.neuron_in040.counter\[2\] net379
+ VSS VSS VDD VDD _03791_ sky130_fd_sc_hd__or3_1
X_14108_ network.in_period\[40\]\[2\] net397 _03791_ VSS VSS
+ VDD VDD _03792_ sky130_fd_sc_hd__o21ai_0
X_14109_ _00317_ _03790_ _03792_ VSS VSS VDD VDD _02226_ sky130_fd_sc_hd__a21oi_1
X_14110_ network.arbit.counter\[1\] VSS VSS VDD VDD _00118_
+ sky130_fd_sc_hd__inv_1
X_14111_ network.in_period\[40\]\[1\] _03761_ VSS VSS VDD
+ VDD _03793_ sky130_fd_sc_hd__nand2_1
X_14112_ _00318_ _03761_ _03793_ VSS VSS VDD VDD _02225_ sky130_fd_sc_hd__o21ai_0
X_14113_ network.neuron_in086.counter\[0\] VSS VSS VDD VDD
+ _00046_ sky130_fd_sc_hd__inv_1
X_14114_ network.neuron_in155.counter\[1\] VSS VSS VDD VDD
+ _01204_ sky130_fd_sc_hd__inv_1
X_14115_ network.neuron_in164.counter\[0\] VSS VSS VDD VDD
+ _00859_ sky130_fd_sc_hd__inv_1
X_14116_ network.in_period\[41\]\[0\] _03746_ VSS VSS VDD
+ VDD _03794_ sky130_fd_sc_hd__nand2_1
X_14117_ network.neuron_in041.counter\[0\] _03746_ _03794_
+ VSS VSS VDD VDD _02228_ sky130_fd_sc_hd__o21ai_0
X_14118_ network.neuron_in173.counter\[1\] VSS VSS VDD VDD
+ _00843_ sky130_fd_sc_hd__inv_1
X_14119_ network.neuron_in163.counter\[2\] VSS VSS VDD VDD
+ _03795_ sky130_fd_sc_hd__inv_1
X_14120_ network.neuron_in163.counter\[3\] network.in_period\[163\]\[2\]
+ _00820_ net370 VSS VSS VDD VDD _03796_ sky130_fd_sc_hd__o22ai_1
Xplace436 net436 VSS VSS VDD VDD net435 sky130_fd_sc_hd__buf_4
X_14122_ network.neuron_in163.counter\[2\] _00820_ net401
+ VSS VSS VDD VDD _03798_ sky130_fd_sc_hd__nand3_1
X_14123_ network.in_period\[163\]\[2\] net401 _03798_ VSS
+ VSS VDD VDD _03799_ sky130_fd_sc_hd__o21ai_0
X_14124_ _03795_ _03796_ _03799_ VSS VSS VDD VDD _02718_ sky130_fd_sc_hd__a21oi_1
X_14125_ network.neuron_in084.counter\[0\] VSS VSS VDD VDD
+ _00054_ sky130_fd_sc_hd__inv_1
X_14126_ network.neuron_in099.counter\[0\] VSS VSS VDD VDD
+ _00722_ sky130_fd_sc_hd__inv_1
X_14127_ network.neuron_in163.counter\[2\] network.neuron_in163.counter\[3\]
+ VSS VSS VDD VDD _03800_ sky130_fd_sc_hd__nor2_1
X_14128_ _00820_ _03800_ VSS VSS VDD VDD _03801_ sky130_fd_sc_hd__nand2_1
X_14129_ net401 _03801_ VSS VSS VDD VDD _03802_ sky130_fd_sc_hd__nand2_1
X_14130_ network.in_period\[163\]\[1\] _03802_ VSS VSS VDD
+ VDD _03803_ sky130_fd_sc_hd__nand2_1
X_14131_ _00821_ _03802_ _03803_ VSS VSS VDD VDD _02717_ sky130_fd_sc_hd__o21ai_0
X_14132_ network.neuron_in112.counter\[1\] VSS VSS VDD VDD
+ _00544_ sky130_fd_sc_hd__inv_1
X_14133_ network.neuron_in123.counter\[0\] VSS VSS VDD VDD
+ _00216_ sky130_fd_sc_hd__inv_1
X_14134_ _07186_ _08158_ _07676_ VSS VSS VDD VDD _03804_ sky130_fd_sc_hd__o21ai_0
X_14135_ _07313_ _07299_ VSS VSS VDD VDD _03805_ sky130_fd_sc_hd__nor2_1
X_14136_ net418 _03804_ _03805_ VSS VSS VDD VDD _03806_ sky130_fd_sc_hd__a21oi_1
X_14137_ net415 net343 _08158_ net418 VSS VSS VDD VDD _03807_
+ sky130_fd_sc_hd__a22oi_1
X_14138_ net419 _03806_ _03807_ net341 VSS VSS VDD VDD _03808_
+ sky130_fd_sc_hd__o22a_1
X_14139_ _07109_ _07162_ _07632_ net339 VSS VSS VDD VDD _03809_
+ sky130_fd_sc_hd__a31oi_1
X_14140_ net411 _03808_ _03809_ VSS VSS VDD VDD _03810_ sky130_fd_sc_hd__o21ai_0
X_14141_ net306 _03810_ VSS VSS VDD VDD _03811_ sky130_fd_sc_hd__nand2_1
X_14142_ net419 net340 _07587_ VSS VSS VDD VDD _03812_ sky130_fd_sc_hd__o21ai_0
X_14143_ _07616_ _07805_ _03812_ VSS VSS VDD VDD _03813_ sky130_fd_sc_hd__nand3_1
X_14144_ _07366_ _07805_ _03813_ VSS VSS VDD VDD _03814_ sky130_fd_sc_hd__o21ai_0
X_14145_ net366 net325 net313 VSS VSS VDD VDD _03815_ sky130_fd_sc_hd__a21oi_1
X_14146_ net411 _03815_ VSS VSS VDD VDD _03816_ sky130_fd_sc_hd__nor2_1
X_14147_ net418 _07167_ VSS VSS VDD VDD _03817_ sky130_fd_sc_hd__nor2_1
X_14148_ _03816_ _03817_ net322 VSS VSS VDD VDD _03818_ sky130_fd_sc_hd__o21ai_0
X_14149_ net339 _03818_ VSS VSS VDD VDD _03819_ sky130_fd_sc_hd__nand2_1
X_14150_ _07186_ _03814_ _03819_ VSS VSS VDD VDD _03820_ sky130_fd_sc_hd__a21oi_1
X_14151_ net418 _07654_ _07921_ net318 _07299_ VSS VSS VDD
+ VDD _03821_ sky130_fd_sc_hd__a2111o_1
X_14152_ _03811_ _03820_ _03821_ VSS VSS VDD VDD _01744_ sky130_fd_sc_hd__o21ai_0
X_14153_ net419 net348 VSS VSS VDD VDD _03822_ sky130_fd_sc_hd__nor2_1
X_14154_ net410 net409 _07588_ VSS VSS VDD VDD _03823_ sky130_fd_sc_hd__nor3_1
X_14155_ net414 net332 VSS VSS VDD VDD _03824_ sky130_fd_sc_hd__nor2_1
X_14156_ net414 net356 _07695_ _03824_ VSS VSS VDD VDD _03825_
+ sky130_fd_sc_hd__a31oi_1
X_14157_ net414 _08174_ _07291_ net424 VSS VSS VDD VDD _03826_
+ sky130_fd_sc_hd__o211ai_1
X_14158_ net424 _03825_ _03826_ net411 VSS VSS VDD VDD _03827_
+ sky130_fd_sc_hd__o211ai_1
X_14159_ _07201_ _07307_ _07205_ VSS VSS VDD VDD _03828_ sky130_fd_sc_hd__o21ai_0
X_14160_ _07590_ _03828_ VSS VSS VDD VDD _03829_ sky130_fd_sc_hd__nand2_1
X_14161_ _07046_ net345 _07181_ VSS VSS VDD VDD _03830_ sky130_fd_sc_hd__a21oi_1
X_14162_ net412 network.neuron_hid0.ROM0.address\[2\] VSS
+ VSS VDD VDD _03831_ sky130_fd_sc_hd__nand2_1
X_14163_ net412 net417 _03830_ _03831_ _07164_ VSS VSS VDD
+ VDD _03832_ sky130_fd_sc_hd__o32ai_1
X_14164_ net411 net359 net336 VSS VSS VDD VDD _03833_ sky130_fd_sc_hd__nand3_1
X_14165_ net358 _07590_ VSS VSS VDD VDD _03834_ sky130_fd_sc_hd__nand2_1
X_14166_ _03833_ _03834_ _07101_ VSS VSS VDD VDD _03835_ sky130_fd_sc_hd__a21boi_0
X_14167_ net411 _07587_ VSS VSS VDD VDD _03836_ sky130_fd_sc_hd__nor2_1
X_14168_ net415 _03832_ _03835_ _03836_ net409 VSS VSS VDD
+ VDD _03837_ sky130_fd_sc_hd__a2111oi_0
X_14169_ net409 _03827_ _03829_ _03837_ VSS VSS VDD VDD _03838_
+ sky130_fd_sc_hd__a31o_2
X_14170_ net366 net418 _07675_ VSS VSS VDD VDD _03839_ sky130_fd_sc_hd__nor3_1
X_14171_ _07304_ _03839_ VSS VSS VDD VDD _03840_ sky130_fd_sc_hd__nand2_1
X_14172_ _03838_ _03840_ VSS VSS VDD VDD _03841_ sky130_fd_sc_hd__nand2_1
X_14173_ _03822_ _03823_ _03841_ VSS VSS VDD VDD _03842_ sky130_fd_sc_hd__a21oi_1
X_14174_ net362 net307 _07884_ _07337_ VSS VSS VDD VDD _03843_
+ sky130_fd_sc_hd__nand4_1
X_14175_ net316 _03842_ _03843_ VSS VSS VDD VDD _01745_ sky130_fd_sc_hd__o21ai_0
X_14176_ net423 net412 VSS VSS VDD VDD _03844_ sky130_fd_sc_hd__nor2b_1
X_14177_ _07158_ net333 _03844_ _07720_ VSS VSS VDD VDD _03845_
+ sky130_fd_sc_hd__o22a_1
X_14178_ _07912_ _03831_ _03845_ net421 VSS VSS VDD VDD _03846_
+ sky130_fd_sc_hd__o22ai_1
X_14179_ net416 _03846_ VSS VSS VDD VDD _03847_ sky130_fd_sc_hd__nand2_1
X_14180_ net419 _07050_ net358 VSS VSS VDD VDD _03848_ sky130_fd_sc_hd__o21ai_0
X_14181_ net411 net337 VSS VSS VDD VDD _03849_ sky130_fd_sc_hd__nand2_1
X_14182_ _07695_ _03848_ _03849_ net414 VSS VSS VDD VDD _03850_
+ sky130_fd_sc_hd__a31oi_1
X_14183_ net411 net354 VSS VSS VDD VDD _03851_ sky130_fd_sc_hd__nor2_1
X_14184_ _03850_ _03851_ net425 VSS VSS VDD VDD _03852_ sky130_fd_sc_hd__o21ai_0
X_14185_ net365 net346 _07307_ _03847_ _03852_ VSS VSS VDD
+ VDD _03853_ sky130_fd_sc_hd__o311ai_0
X_14186_ _07181_ _07585_ net365 VSS VSS VDD VDD _03854_ sky130_fd_sc_hd__o21ai_0
X_14187_ net414 _07671_ _03854_ VSS VSS VDD VDD _03855_ sky130_fd_sc_hd__o21ai_0
X_14188_ net417 _03855_ VSS VSS VDD VDD _03856_ sky130_fd_sc_hd__nand2_1
X_14189_ _07134_ _07880_ _03856_ VSS VSS VDD VDD _03857_ sky130_fd_sc_hd__o21ai_0
X_14190_ _07181_ _08191_ _07752_ net345 VSS VSS VDD VDD _03858_
+ sky130_fd_sc_hd__a22oi_1
X_14191_ net418 net318 _03858_ VSS VSS VDD VDD _03859_ sky130_fd_sc_hd__nor3_1
X_14192_ net409 _03853_ _03857_ _07238_ _03859_ VSS VSS VDD
+ VDD _03860_ sky130_fd_sc_hd__a221oi_1
X_14193_ _03822_ _03839_ VSS VSS VDD VDD _03861_ sky130_fd_sc_hd__nand2_1
X_14194_ _03860_ _03861_ VSS VSS VDD VDD _03862_ sky130_fd_sc_hd__nand2_1
X_14195_ _07074_ _07787_ net422 VSS VSS VDD VDD _03863_ sky130_fd_sc_hd__o21ai_0
X_14196_ net424 net344 VSS VSS VDD VDD _03864_ sky130_fd_sc_hd__nand2_1
X_14197_ net336 _03863_ _03864_ VSS VSS VDD VDD _03865_ sky130_fd_sc_hd__a21oi_1
X_14198_ _07083_ _03859_ VSS VSS VDD VDD _03866_ sky130_fd_sc_hd__or2_2
X_14199_ _03862_ _03865_ _03866_ VSS VSS VDD VDD _01746_ sky130_fd_sc_hd__o21a_1
X_14200_ net356 _07324_ VSS VSS VDD VDD _03867_ sky130_fd_sc_hd__nor2_1
X_14201_ _07707_ _07298_ _03867_ VSS VSS VDD VDD _03868_ sky130_fd_sc_hd__a21oi_1
X_14202_ net321 _07385_ _03868_ network.neuron_hid0.ROM0.address\[4\]
+ VSS VSS VDD VDD _03869_ sky130_fd_sc_hd__o22ai_1
X_14203_ net307 _03869_ VSS VSS VDD VDD _03870_ sky130_fd_sc_hd__nand2_1
X_14204_ net422 _07599_ net418 VSS VSS VDD VDD _03871_ sky130_fd_sc_hd__a21oi_1
X_14205_ net347 net320 _03831_ _03871_ VSS VSS VDD VDD _03872_
+ sky130_fd_sc_hd__nor4_1
X_14206_ _07720_ _07365_ net413 VSS VSS VDD VDD _03873_ sky130_fd_sc_hd__a21o_1
X_14207_ _07710_ _03873_ VSS VSS VDD VDD _03874_ sky130_fd_sc_hd__nand2_1
X_14208_ net422 _03874_ VSS VSS VDD VDD _03875_ sky130_fd_sc_hd__nand2_1
X_14209_ net419 _07641_ _07590_ VSS VSS VDD VDD _03876_ sky130_fd_sc_hd__a21oi_1
X_14210_ net340 _07880_ _03876_ net366 VSS VSS VDD VDD _03877_
+ sky130_fd_sc_hd__o22ai_1
X_14211_ net361 _08191_ _03877_ _07186_ VSS VSS VDD VDD _03878_
+ sky130_fd_sc_hd__a22oi_1
X_14212_ _03875_ _03878_ net410 VSS VSS VDD VDD _03879_ sky130_fd_sc_hd__a21oi_1
X_14213_ net412 net419 VSS VSS VDD VDD _03880_ sky130_fd_sc_hd__nor2_1
X_14214_ net410 net363 net346 VSS VSS VDD VDD _03881_ sky130_fd_sc_hd__nand3_1
X_14215_ net321 _03881_ VSS VSS VDD VDD _03882_ sky130_fd_sc_hd__nand2_1
X_14216_ _07208_ _03880_ _03882_ net419 VSS VSS VDD VDD _03883_
+ sky130_fd_sc_hd__a22oi_1
X_14217_ net410 _07329_ _07324_ VSS VSS VDD VDD _03884_ sky130_fd_sc_hd__o21ai_0
X_14218_ net360 net341 _07385_ net348 VSS VSS VDD VDD _03885_
+ sky130_fd_sc_hd__o22ai_1
X_14219_ net422 net313 _03884_ _03885_ net410 VSS VSS VDD
+ VDD _03886_ sky130_fd_sc_hd__a32oi_1
X_14220_ network.neuron_hid0.ROM0.address\[4\] _03883_ _03886_
+ net339 VSS VSS VDD VDD _03887_ sky130_fd_sc_hd__o211ai_1
X_14221_ net339 _03872_ _03879_ _03887_ _07083_ VSS VSS VDD
+ VDD _03888_ sky130_fd_sc_hd__o311ai_0
X_14222_ _03870_ _03888_ VSS VSS VDD VDD _01747_ sky130_fd_sc_hd__nand2_1
X_14223_ net422 _03813_ VSS VSS VDD VDD _03889_ sky130_fd_sc_hd__nor2_1
X_14224_ _03819_ _03889_ VSS VSS VDD VDD _03890_ sky130_fd_sc_hd__nor2_1
X_14225_ _03811_ _03890_ _03821_ VSS VSS VDD VDD _01748_ sky130_fd_sc_hd__o21ai_0
X_14226_ _07304_ _03822_ _03823_ VSS VSS VDD VDD _03891_ sky130_fd_sc_hd__o21ai_0
X_14227_ _03838_ _03840_ _03891_ VSS VSS VDD VDD _03892_ sky130_fd_sc_hd__and3_1
X_14228_ net316 _03892_ _03843_ VSS VSS VDD VDD _01749_ sky130_fd_sc_hd__o21ai_0
X_14229_ network.neuron_hid0.ROM0.address\[4\] _07592_ _07723_
+ net425 net344 VSS VSS VDD VDD _03893_ sky130_fd_sc_hd__o2111ai_1
X_14230_ net334 _03893_ VSS VSS VDD VDD _03894_ sky130_fd_sc_hd__nor2_1
X_14231_ _03862_ _03894_ _03866_ VSS VSS VDD VDD _01750_ sky130_fd_sc_hd__o21a_1
X_14232_ net413 net333 VSS VSS VDD VDD _03895_ sky130_fd_sc_hd__nand2_1
X_14233_ net413 _07050_ _03895_ VSS VSS VDD VDD _03896_ sky130_fd_sc_hd__o21ai_0
X_14234_ net353 net335 _07208_ net366 VSS VSS VDD VDD _03897_
+ sky130_fd_sc_hd__a22oi_1
X_14235_ _07329_ _03896_ _03897_ net419 VSS VSS VDD VDD _03898_
+ sky130_fd_sc_hd__o22ai_1
X_14236_ network.neuron_hid0.ROM0.address\[4\] net425 _07050_
+ VSS VSS VDD VDD _03899_ sky130_fd_sc_hd__nor3_1
X_14237_ _07245_ _03899_ net419 VSS VSS VDD VDD _03900_ sky130_fd_sc_hd__o21ai_0
X_14238_ net348 _07385_ _03900_ VSS VSS VDD VDD _03901_ sky130_fd_sc_hd__o21ai_0
X_14239_ net422 _07613_ net419 VSS VSS VDD VDD _03902_ sky130_fd_sc_hd__o21ai_0
X_14240_ network.neuron_hid0.ROM0.address\[4\] net348 _03805_
+ _03902_ net358 VSS VSS VDD VDD _03903_ sky130_fd_sc_hd__a2111oi_0
X_14241_ _03879_ _03903_ net409 VSS VSS VDD VDD _03904_ sky130_fd_sc_hd__o21a_1
X_14242_ net344 _03898_ _03901_ _07238_ _03904_ VSS VSS VDD
+ VDD _03905_ sky130_fd_sc_hd__a221oi_1
X_14243_ net316 _03905_ _03870_ VSS VSS VDD VDD _01751_ sky130_fd_sc_hd__o21ai_0
X_14244_ _07304_ _03822_ _03839_ _03823_ VSS VSS VDD VDD _03906_
+ sky130_fd_sc_hd__o22ai_1
X_14245_ _03838_ _03906_ VSS VSS VDD VDD _03907_ sky130_fd_sc_hd__nand2_1
X_14246_ _07083_ _03907_ VSS VSS VDD VDD _03908_ sky130_fd_sc_hd__nand2_1
X_14247_ _03843_ _03908_ VSS VSS VDD VDD _01752_ sky130_fd_sc_hd__nand2_1
X_14248_ _07304_ _07584_ network.neuron_hid0.ROM0.address\[4\]
+ VSS VSS VDD VDD _03909_ sky130_fd_sc_hd__o21ai_0
X_14249_ net323 _07684_ net424 VSS VSS VDD VDD _03910_ sky130_fd_sc_hd__o21ai_0
X_14250_ _03909_ _03910_ VSS VSS VDD VDD _03911_ sky130_fd_sc_hd__nand2_1
X_14251_ net344 _03911_ VSS VSS VDD VDD _03912_ sky130_fd_sc_hd__nand2_1
X_14252_ _03860_ _03912_ _03866_ VSS VSS VDD VDD _01753_ sky130_fd_sc_hd__a21boi_0
X_14253_ net413 net334 _07614_ VSS VSS VDD VDD _03913_ sky130_fd_sc_hd__o21ai_0
X_14254_ net413 _07324_ _07710_ VSS VSS VDD VDD _03914_ sky130_fd_sc_hd__o21ai_0
X_14255_ net343 _03913_ _03914_ net351 VSS VSS VDD VDD _03915_
+ sky130_fd_sc_hd__a22o_1
X_14256_ _07385_ _07912_ _03900_ VSS VSS VDD VDD _03916_ sky130_fd_sc_hd__o21ai_0
X_14257_ net344 _03915_ _03916_ _07238_ _03904_ VSS VSS VDD
+ VDD _03917_ sky130_fd_sc_hd__a221oi_1
X_14258_ net419 _07298_ VSS VSS VDD VDD _03918_ sky130_fd_sc_hd__nand2_1
X_14259_ _07365_ _03918_ VSS VSS VDD VDD _03919_ sky130_fd_sc_hd__nand2_1
X_14260_ net422 _03919_ _03867_ VSS VSS VDD VDD _03920_ sky130_fd_sc_hd__a21oi_1
X_14261_ net321 _07385_ _03920_ network.neuron_hid0.ROM0.address\[4\]
+ VSS VSS VDD VDD _03921_ sky130_fd_sc_hd__o22ai_1
X_14262_ net307 _03921_ VSS VSS VDD VDD _03922_ sky130_fd_sc_hd__nand2_1
X_14263_ net316 _03917_ _03922_ VSS VSS VDD VDD _01754_ sky130_fd_sc_hd__o21ai_0
X_14264_ network.neuron_in163.counter\[0\] VSS VSS VDD VDD
+ _00818_ sky130_fd_sc_hd__inv_1
X_14265_ network.in_period\[163\]\[0\] _03802_ VSS VSS VDD
+ VDD _03923_ sky130_fd_sc_hd__nand2_1
X_14266_ network.neuron_in163.counter\[0\] _03802_ _03923_
+ VSS VSS VDD VDD _02716_ sky130_fd_sc_hd__o21ai_0
X_14267_ network.neuron_in164.counter\[2\] VSS VSS VDD VDD
+ _03924_ sky130_fd_sc_hd__inv_1
X_14268_ network.neuron_in164.counter\[3\] network.in_period\[164\]\[2\]
+ net370 _00861_ VSS VSS VDD VDD _03925_ sky130_fd_sc_hd__o22ai_1
X_14269_ network.neuron_in164.counter\[2\] _00861_ net407
+ VSS VSS VDD VDD _03926_ sky130_fd_sc_hd__nand3_1
X_14270_ network.in_period\[164\]\[2\] net401 _03926_ VSS
+ VSS VDD VDD _03927_ sky130_fd_sc_hd__o21ai_0
X_14271_ _03924_ _03925_ _03927_ VSS VSS VDD VDD _02722_ sky130_fd_sc_hd__a21oi_1
X_14272_ network.neuron_in164.counter\[3\] _00861_ VSS VSS
+ VDD VDD _03928_ sky130_fd_sc_hd__nand2b_1
X_14273_ _03928_ _03924_ VSS VSS VDD VDD _03929_ sky130_fd_sc_hd__nand2b_1
X_14274_ net401 _03929_ VSS VSS VDD VDD _03930_ sky130_fd_sc_hd__nand2_1
X_14275_ network.in_period\[164\]\[1\] _03930_ VSS VSS VDD
+ VDD _03931_ sky130_fd_sc_hd__nand2_1
X_14276_ _00862_ _03930_ _03931_ VSS VSS VDD VDD _02721_ sky130_fd_sc_hd__o21ai_0
X_14277_ network.in_period\[164\]\[0\] _03930_ VSS VSS VDD
+ VDD _03932_ sky130_fd_sc_hd__nand2_1
X_14278_ network.neuron_in164.counter\[0\] _03930_ _03932_
+ VSS VSS VDD VDD _02720_ sky130_fd_sc_hd__o21ai_0
X_14279_ network.in_period\[165\]\[2\] VSS VSS VDD VDD _03933_
+ sky130_fd_sc_hd__inv_1
X_14280_ network.neuron_in165.counter\[2\] network.neuron_in165.counter\[3\]
+ VSS VSS VDD VDD _03934_ sky130_fd_sc_hd__nor2_1
X_14281_ _00886_ _03934_ VSS VSS VDD VDD _03935_ sky130_fd_sc_hd__nand2_1
X_14282_ net402 _03935_ VSS VSS VDD VDD _03936_ sky130_fd_sc_hd__nand2_1
X_14283_ network.neuron_in165.counter\[2\] _00886_ VSS VSS
+ VDD VDD _03937_ sky130_fd_sc_hd__xnor2_1
X_14284_ _03933_ _03936_ _03937_ net402 VSS VSS VDD VDD _02726_
+ sky130_fd_sc_hd__a22oi_1
X_14285_ network.in_period\[165\]\[1\] _03936_ VSS VSS VDD
+ VDD _03938_ sky130_fd_sc_hd__nand2_1
X_14286_ _00887_ _03936_ _03938_ VSS VSS VDD VDD _02725_ sky130_fd_sc_hd__o21ai_0
X_14287_ network.in_period\[165\]\[0\] _03936_ VSS VSS VDD
+ VDD _03939_ sky130_fd_sc_hd__nand2_1
X_14288_ network.neuron_in165.counter\[0\] _03936_ _03939_
+ VSS VSS VDD VDD _02724_ sky130_fd_sc_hd__o21ai_0
X_14289_ network.neuron_in166.counter\[2\] VSS VSS VDD VDD
+ _03940_ sky130_fd_sc_hd__inv_1
X_14290_ network.neuron_in166.counter\[3\] network.in_period\[166\]\[2\]
+ net370 _00908_ VSS VSS VDD VDD _03941_ sky130_fd_sc_hd__o22ai_1
X_14291_ network.neuron_in166.counter\[2\] _00908_ net402
+ VSS VSS VDD VDD _03942_ sky130_fd_sc_hd__nand3_1
X_14292_ network.in_period\[166\]\[2\] net402 _03942_ VSS
+ VSS VDD VDD _03943_ sky130_fd_sc_hd__o21ai_0
X_14293_ _03940_ _03941_ _03943_ VSS VSS VDD VDD _02730_ sky130_fd_sc_hd__a21oi_1
X_14294_ network.in_period\[166\]\[1\] _07504_ VSS VSS VDD
+ VDD _03944_ sky130_fd_sc_hd__nand2_1
X_14295_ _00909_ _07504_ _03944_ VSS VSS VDD VDD _02729_ sky130_fd_sc_hd__o21ai_0
X_14296_ loaded\[2\] loaded\[3\] _01108_ VSS VSS VDD VDD _03945_
+ sky130_fd_sc_hd__nand3_4
Xplace435 net437 VSS VSS VDD VDD net434 sky130_fd_sc_hd__buf_4
X_14298_ net22 net44 VSS VSS VDD VDD _03947_ sky130_fd_sc_hd__nand2_1
X_14299_ _03947_ net427 net426 VSS VSS VDD VDD _03948_ sky130_fd_sc_hd__nor3b_1
X_14300_ net429 net428 VSS VSS VDD VDD _03949_ sky130_fd_sc_hd__nor2b_1
X_14301_ _03948_ _03949_ VSS VSS VDD VDD _03950_ sky130_fd_sc_hd__nand2_1
Xplace416 net416 VSS VSS VDD VDD net415 sky130_fd_sc_hd__buf_4
X_14303_ _03945_ _03950_ VSS VSS VDD VDD _03171_ sky130_fd_sc_hd__nor2_1
X_14304_ loaded\[2\] loaded\[3\] _01106_ VSS VSS VDD VDD _03952_
+ sky130_fd_sc_hd__nand3_2
Xplace434 net437 VSS VSS VDD VDD net433 sky130_fd_sc_hd__buf_4
X_14306_ _03950_ _03952_ VSS VSS VDD VDD _03170_ sky130_fd_sc_hd__nor2_1
X_14307_ loaded\[2\] loaded\[3\] _01107_ VSS VSS VDD VDD _03954_
+ sky130_fd_sc_hd__nand3_4
Xplace417 network.neuron_hid0.ROM0.address\[4\] VSS VSS VDD
+ VDD net416 sky130_fd_sc_hd__buf_4
X_14309_ _03950_ _03954_ VSS VSS VDD VDD _03169_ sky130_fd_sc_hd__nor2_1
X_14310_ network.neuron_in042.counter\[2\] net396 VSS VSS
+ VDD VDD _03956_ sky130_fd_sc_hd__nand2_1
X_14311_ network.neuron_in042.counter\[3\] network.in_period\[42\]\[2\]
+ _03956_ VSS VSS VDD VDD _03957_ sky130_fd_sc_hd__o21ai_0
X_14312_ _00308_ network.neuron_in042.counter\[2\] net380
+ VSS VSS VDD VDD _03958_ sky130_fd_sc_hd__or3_1
X_14313_ network.in_period\[42\]\[2\] net396 _03958_ VSS VSS
+ VDD VDD _03959_ sky130_fd_sc_hd__o21ai_0
X_14314_ _00308_ _03957_ _03959_ VSS VSS VDD VDD _02234_ sky130_fd_sc_hd__a21oi_1
X_14315_ net315 net320 net421 VSS VSS VDD VDD _03960_ sky130_fd_sc_hd__o21ai_0
X_14316_ net343 net330 net338 VSS VSS VDD VDD _03961_ sky130_fd_sc_hd__o21ai_0
X_14317_ net417 net345 net414 VSS VSS VDD VDD _03962_ sky130_fd_sc_hd__o21ai_0
X_14318_ _03961_ _03962_ VSS VSS VDD VDD _03963_ sky130_fd_sc_hd__nand2_1
X_14319_ _07162_ net314 _03963_ VSS VSS VDD VDD _03964_ sky130_fd_sc_hd__a21oi_1
X_14320_ net422 _07329_ _07820_ VSS VSS VDD VDD _03965_ sky130_fd_sc_hd__a21oi_1
X_14321_ net412 net356 net343 VSS VSS VDD VDD _03966_ sky130_fd_sc_hd__a21oi_1
X_14322_ net315 _03844_ net421 VSS VSS VDD VDD _03967_ sky130_fd_sc_hd__o21ai_0
X_14323_ net421 _03966_ _03967_ VSS VSS VDD VDD _03968_ sky130_fd_sc_hd__o21ai_0
X_14324_ _07181_ _03965_ _03968_ net416 VSS VSS VDD VDD _03969_
+ sky130_fd_sc_hd__o31ai_1
X_14325_ net412 net347 VSS VSS VDD VDD _03970_ sky130_fd_sc_hd__nand2_1
X_14326_ net412 _07241_ _03970_ VSS VSS VDD VDD _03971_ sky130_fd_sc_hd__o21ai_0
X_14327_ net423 _07880_ net358 net363 VSS VSS VDD VDD _03972_
+ sky130_fd_sc_hd__a211oi_1
X_14328_ _07800_ _07744_ _03972_ VSS VSS VDD VDD _03973_ sky130_fd_sc_hd__a21oi_1
X_14329_ net417 _03973_ VSS VSS VDD VDD _03974_ sky130_fd_sc_hd__nor2_1
X_14330_ net317 _03971_ _03974_ VSS VSS VDD VDD _03975_ sky130_fd_sc_hd__a21oi_1
X_14331_ net417 _07385_ net352 VSS VSS VDD VDD _03976_ sky130_fd_sc_hd__o21ai_0
X_14332_ _03969_ _03975_ _03976_ _07181_ net339 VSS VSS VDD
+ VDD _03977_ sky130_fd_sc_hd__a221o_1
X_14333_ net417 _07289_ VSS VSS VDD VDD _03978_ sky130_fd_sc_hd__nand2_1
X_14334_ net421 net346 _03978_ VSS VSS VDD VDD _03979_ sky130_fd_sc_hd__o21ai_0
X_14335_ net425 _07800_ _03979_ VSS VSS VDD VDD _03980_ sky130_fd_sc_hd__nand3_1
X_14336_ _07046_ net333 VSS VSS VDD VDD _03981_ sky130_fd_sc_hd__nand2_1
X_14337_ _07231_ _07643_ _03981_ _07616_ VSS VSS VDD VDD _03982_
+ sky130_fd_sc_hd__a31oi_1
X_14338_ _07590_ net347 _07805_ _08190_ VSS VSS VDD VDD _03983_
+ sky130_fd_sc_hd__nor4_1
X_14339_ net408 _03982_ _03983_ VSS VSS VDD VDD _03984_ sky130_fd_sc_hd__nor3_1
X_14340_ _07798_ _07904_ _07632_ VSS VSS VDD VDD _03985_ sky130_fd_sc_hd__o21ai_0
X_14341_ _03980_ _03984_ _03985_ net316 VSS VSS VDD VDD _03986_
+ sky130_fd_sc_hd__a31oi_1
X_14342_ net307 _03960_ _03964_ _03977_ _03986_ VSS VSS VDD
+ VDD _01755_ sky130_fd_sc_hd__a32o_1
X_14343_ loaded\[2\] loaded\[3\] _01104_ VSS VSS VDD VDD _03987_
+ sky130_fd_sc_hd__nand3_2
Xplace290 _04012_ VSS VSS VDD VDD net289 sky130_fd_sc_hd__buf_4
X_14345_ net427 net426 VSS VSS VDD VDD _03989_ sky130_fd_sc_hd__nand2_1
X_14346_ _03947_ _03989_ VSS VSS VDD VDD _03990_ sky130_fd_sc_hd__nor2_1
X_14347_ _03949_ _03990_ VSS VSS VDD VDD _03991_ sky130_fd_sc_hd__nand2_1
Xplace289 _04022_ VSS VSS VDD VDD net288 sky130_fd_sc_hd__buf_4
X_14349_ net300 _03991_ VSS VSS VDD VDD _03239_ sky130_fd_sc_hd__nor2_1
X_14350_ _07083_ _07304_ _03823_ VSS VSS VDD VDD _01756_ sky130_fd_sc_hd__and3_1
X_14351_ loaded\[2\] loaded\[3\] VSS VSS VDD VDD _03993_ sky130_fd_sc_hd__nor2b_1
X_14352_ _01104_ _03993_ VSS VSS VDD VDD _03994_ sky130_fd_sc_hd__nand2_4
Xplace285 _04289_ VSS VSS VDD VDD net284 sky130_fd_sc_hd__buf_4
X_14354_ _03991_ _03994_ VSS VSS VDD VDD _03235_ sky130_fd_sc_hd__nor2_1
X_14355_ loaded\[3\] loaded\[2\] VSS VSS VDD VDD _03996_ sky130_fd_sc_hd__nor2b_1
X_14356_ _01106_ _03996_ VSS VSS VDD VDD _03997_ sky130_fd_sc_hd__nand2_4
Xplace284 _08376_ VSS VSS VDD VDD net283 sky130_fd_sc_hd__buf_4
X_14358_ _03991_ _03997_ VSS VSS VDD VDD _03233_ sky130_fd_sc_hd__nor2_1
X_14359_ _01104_ _03996_ VSS VSS VDD VDD _03999_ sky130_fd_sc_hd__nand2_4
Xplace288 _04033_ VSS VSS VDD VDD net287 sky130_fd_sc_hd__buf_4
X_14361_ _03991_ _03999_ VSS VSS VDD VDD _03230_ sky130_fd_sc_hd__nor2_1
X_14362_ network.neuron_in108.counter\[0\] VSS VSS VDD VDD
+ _00682_ sky130_fd_sc_hd__inv_1
X_14363_ net428 net429 VSS VSS VDD VDD _04001_ sky130_fd_sc_hd__nor2b_1
X_14364_ _03990_ _04001_ VSS VSS VDD VDD _04002_ sky130_fd_sc_hd__nand2_1
Xplace287 _04141_ VSS VSS VDD VDD net286 sky130_fd_sc_hd__buf_4
X_14366_ net301 net290 VSS VSS VDD VDD _03224_ sky130_fd_sc_hd__nor2_1
X_14367_ _01108_ _03996_ VSS VSS VDD VDD _04004_ sky130_fd_sc_hd__nand2_4
Xplace286 _04212_ VSS VSS VDD VDD net285 sky130_fd_sc_hd__buf_4
X_14369_ net427 net426 _03947_ VSS VSS VDD VDD _04006_ sky130_fd_sc_hd__nor3_1
X_14370_ _03949_ net294 VSS VSS VDD VDD _04007_ sky130_fd_sc_hd__nand2_1
Xplace300 _04009_ VSS VSS VDD VDD net299 sky130_fd_sc_hd__buf_4
X_14372_ _04004_ _04007_ VSS VSS VDD VDD _03276_ sky130_fd_sc_hd__nor2_1
X_14373_ _01106_ _03993_ VSS VSS VDD VDD _04009_ sky130_fd_sc_hd__nand2_4
Xplace299 _08598_ VSS VSS VDD VDD net298 sky130_fd_sc_hd__buf_4
X_14375_ net290 net299 VSS VSS VDD VDD _03219_ sky130_fd_sc_hd__nor2_1
X_14376_ _03997_ net290 VSS VSS VDD VDD _03215_ sky130_fd_sc_hd__nor2_1
X_14377_ net429 net428 VSS VSS VDD VDD _04011_ sky130_fd_sc_hd__nor2_1
X_14378_ net326 _03990_ VSS VSS VDD VDD _04012_ sky130_fd_sc_hd__nand2_1
Xplace321 _07219_ VSS VSS VDD VDD net320 sky130_fd_sc_hd__buf_4
X_14380_ _03945_ net289 VSS VSS VDD VDD _03207_ sky130_fd_sc_hd__nor2_1
X_14381_ _03954_ net289 VSS VSS VDD VDD _03205_ sky130_fd_sc_hd__nor2_1
X_14382_ _03999_ net289 VSS VSS VDD VDD _03194_ sky130_fd_sc_hd__nor2_1
X_14383_ loaded\[2\] loaded\[3\] VSS VSS VDD VDD _04014_ sky130_fd_sc_hd__nor2_1
X_14384_ _01108_ _04014_ VSS VSS VDD VDD _04015_ sky130_fd_sc_hd__nand2_4
Xplace318 _07355_ VSS VSS VDD VDD net317 sky130_fd_sc_hd__buf_4
X_14386_ net289 _04015_ VSS VSS VDD VDD _03193_ sky130_fd_sc_hd__nor2_1
X_14387_ _01106_ _04014_ VSS VSS VDD VDD _04017_ sky130_fd_sc_hd__nand2_4
Xplace319 _07346_ VSS VSS VDD VDD net318 sky130_fd_sc_hd__buf_4
X_14389_ net289 _04017_ VSS VSS VDD VDD _03192_ sky130_fd_sc_hd__nor2_1
X_14390_ _01104_ _04014_ VSS VSS VDD VDD _04019_ sky130_fd_sc_hd__nand2_4
Xplace320 _07324_ VSS VSS VDD VDD net319 sky130_fd_sc_hd__buf_4
X_14392_ _04019_ net289 VSS VSS VDD VDD _03190_ sky130_fd_sc_hd__nor2_1
X_14393_ network.in_period\[42\]\[1\] _03775_ VSS VSS VDD
+ VDD _04021_ sky130_fd_sc_hd__nand2_1
X_14394_ _00309_ _03775_ _04021_ VSS VSS VDD VDD _02233_ sky130_fd_sc_hd__o21ai_0
X_14395_ net429 net428 _03948_ VSS VSS VDD VDD _04022_ sky130_fd_sc_hd__nand3_1
Xclkbuf_leaf_5_clk clknet_5_0__leaf_clk VSS VSS VDD VDD clknet_leaf_5_clk
+ sky130_fd_sc_hd__clkbuf_16
X_14397_ _03994_ net288 VSS VSS VDD VDD _03181_ sky130_fd_sc_hd__nor2_1
X_14398_ net299 net288 VSS VSS VDD VDD _03183_ sky130_fd_sc_hd__nor2_1
X_14399_ net429 net428 _03990_ VSS VSS VDD VDD _04024_ sky130_fd_sc_hd__nand3_2
Xclkbuf_leaf_4_clk clknet_5_0__leaf_clk VSS VSS VDD VDD clknet_leaf_4_clk
+ sky130_fd_sc_hd__clkbuf_16
X_14401_ _04004_ _04024_ VSS VSS VDD VDD _03251_ sky130_fd_sc_hd__nor2_1
X_14402_ _04019_ _04024_ VSS VSS VDD VDD _03244_ sky130_fd_sc_hd__nor2_1
X_14403_ _03954_ _03991_ VSS VSS VDD VDD _03240_ sky130_fd_sc_hd__nor2_1
X_14404_ _03948_ _04001_ VSS VSS VDD VDD _04026_ sky130_fd_sc_hd__nand2_1
Xclkbuf_leaf_3_clk clknet_5_0__leaf_clk VSS VSS VDD VDD clknet_leaf_3_clk
+ sky130_fd_sc_hd__clkbuf_16
X_14406_ _03994_ _04026_ VSS VSS VDD VDD _03146_ sky130_fd_sc_hd__nor2_1
X_14407_ net326 _03948_ VSS VSS VDD VDD _04028_ sky130_fd_sc_hd__nand2_1
Xclkbuf_leaf_2_clk clknet_5_0__leaf_clk VSS VSS VDD VDD clknet_leaf_2_clk
+ sky130_fd_sc_hd__clkbuf_16
X_14409_ _04015_ _04028_ VSS VSS VDD VDD _03123_ sky130_fd_sc_hd__nor2_1
X_14410_ _04017_ _04028_ VSS VSS VDD VDD _03122_ sky130_fd_sc_hd__nor2_1
X_14411_ _01107_ _04014_ VSS VSS VDD VDD _04030_ sky130_fd_sc_hd__nand2_4
Xclkbuf_leaf_1_clk clknet_5_0__leaf_clk VSS VSS VDD VDD clknet_leaf_1_clk
+ sky130_fd_sc_hd__clkbuf_16
X_14413_ _04028_ _04030_ VSS VSS VDD VDD _03120_ sky130_fd_sc_hd__nor2_1
X_14414_ _03945_ _04024_ VSS VSS VDD VDD _03260_ sky130_fd_sc_hd__nor2_1
X_14415_ net426 _03947_ net427 VSS VSS VDD VDD _04032_ sky130_fd_sc_hd__nor3b_1
X_14416_ net429 net428 _04032_ VSS VSS VDD VDD _04033_ sky130_fd_sc_hd__nand3_1
Xclkbuf_leaf_0_clk clknet_5_0__leaf_clk VSS VSS VDD VDD clknet_leaf_0_clk
+ sky130_fd_sc_hd__clkbuf_16
X_14418_ _03945_ net287 VSS VSS VDD VDD _03118_ sky130_fd_sc_hd__nor2_1
X_14419_ _03954_ net287 VSS VSS VDD VDD _03116_ sky130_fd_sc_hd__nor2_1
X_14420_ net300 net287 VSS VSS VDD VDD _03115_ sky130_fd_sc_hd__nor2_1
X_14421_ _01108_ _03993_ VSS VSS VDD VDD _04035_ sky130_fd_sc_hd__nand2_4
Xplace458 net458 VSS VSS VDD VDD net457 sky130_fd_sc_hd__buf_4
X_14423_ net287 _04035_ VSS VSS VDD VDD _03114_ sky130_fd_sc_hd__nor2_1
X_14424_ _04004_ net288 VSS VSS VDD VDD _03180_ sky130_fd_sc_hd__nor2_1
X_14425_ net299 net287 VSS VSS VDD VDD _03113_ sky130_fd_sc_hd__nor2_1
X_14426_ _01107_ _03993_ VSS VSS VDD VDD _04037_ sky130_fd_sc_hd__nand2_4
Xplace457 net457 VSS VSS VDD VDD net456 sky130_fd_sc_hd__buf_4
X_14428_ net287 _04037_ VSS VSS VDD VDD _03112_ sky130_fd_sc_hd__nor2_1
X_14429_ _03994_ net287 VSS VSS VDD VDD _03111_ sky130_fd_sc_hd__nor2_1
X_14430_ _03994_ _04028_ VSS VSS VDD VDD _03128_ sky130_fd_sc_hd__nor2_1
X_14431_ _04004_ net287 VSS VSS VDD VDD _03109_ sky130_fd_sc_hd__nor2_1
X_14432_ _03997_ net287 VSS VSS VDD VDD _03108_ sky130_fd_sc_hd__nor2_1
X_14433_ _01107_ _03996_ VSS VSS VDD VDD _04039_ sky130_fd_sc_hd__nand2_4
Xplace456 net457 VSS VSS VDD VDD net455 sky130_fd_sc_hd__buf_4
X_14435_ net287 _04039_ VSS VSS VDD VDD _03107_ sky130_fd_sc_hd__nor2_1
X_14436_ _03999_ net287 VSS VSS VDD VDD _03106_ sky130_fd_sc_hd__nor2_1
X_14437_ _04015_ net287 VSS VSS VDD VDD _03105_ sky130_fd_sc_hd__nor2_1
X_14438_ _04017_ net287 VSS VSS VDD VDD _03104_ sky130_fd_sc_hd__nor2_1
X_14439_ network.neuron_in153.counter\[2\] _00474_ VSS VSS
+ VDD VDD _04041_ sky130_fd_sc_hd__xnor2_1
X_14440_ net401 _06403_ network.in_period\[153\]\[2\] VSS
+ VSS VDD VDD _04042_ sky130_fd_sc_hd__a21oi_1
X_14441_ net401 _04041_ _04042_ VSS VSS VDD VDD _02678_ sky130_fd_sc_hd__a21oi_1
X_14442_ _04024_ _04030_ VSS VSS VDD VDD _03245_ sky130_fd_sc_hd__nor2_1
X_14443_ network.neuron_in075.counter\[0\] VSS VSS VDD VDD
+ _00113_ sky130_fd_sc_hd__inv_1
X_14444_ _04030_ net287 VSS VSS VDD VDD _03103_ sky130_fd_sc_hd__nor2_1
X_14445_ _03991_ net299 VSS VSS VDD VDD _03237_ sky130_fd_sc_hd__nor2_1
X_14446_ net290 _04035_ VSS VSS VDD VDD _03220_ sky130_fd_sc_hd__nor2_1
X_14447_ net290 _04037_ VSS VSS VDD VDD _03218_ sky130_fd_sc_hd__nor2_1
X_14448_ net290 _04004_ VSS VSS VDD VDD _03216_ sky130_fd_sc_hd__nor2_1
X_14449_ net289 _04035_ VSS VSS VDD VDD _03203_ sky130_fd_sc_hd__nor2_1
X_14450_ net289 _04039_ VSS VSS VDD VDD _03195_ sky130_fd_sc_hd__nor2_1
X_14451_ net288 _04035_ VSS VSS VDD VDD _03184_ sky130_fd_sc_hd__nor2_1
X_14452_ _03950_ _04037_ VSS VSS VDD VDD _03164_ sky130_fd_sc_hd__nor2_1
X_14453_ _04019_ _03950_ VSS VSS VDD VDD _03155_ sky130_fd_sc_hd__nor2_1
X_14454_ net300 _04026_ VSS VSS VDD VDD _03150_ sky130_fd_sc_hd__nor2_1
X_14455_ _04026_ _04037_ VSS VSS VDD VDD _03147_ sky130_fd_sc_hd__nor2_1
X_14456_ network.neuron_in044.counter\[0\] VSS VSS VDD VDD
+ _00270_ sky130_fd_sc_hd__inv_1
X_14457_ network.neuron_in044.counter\[3\] _00272_ VSS VSS
+ VDD VDD _04043_ sky130_fd_sc_hd__nand2b_1
X_14458_ network.neuron_in044.counter\[2\] VSS VSS VDD VDD
+ _04044_ sky130_fd_sc_hd__inv_1
X_14459_ _04043_ _04044_ VSS VSS VDD VDD _04045_ sky130_fd_sc_hd__nand2b_1
X_14460_ net386 _04045_ VSS VSS VDD VDD _04046_ sky130_fd_sc_hd__nand2_1
X_14461_ network.in_period\[44\]\[0\] _04046_ VSS VSS VDD
+ VDD _04047_ sky130_fd_sc_hd__nand2_1
X_14462_ network.neuron_in044.counter\[0\] _04046_ _04047_
+ VSS VSS VDD VDD _02240_ sky130_fd_sc_hd__o21ai_0
X_14463_ network.neuron_in045.counter\[2\] network.neuron_in045.counter\[3\]
+ VSS VSS VDD VDD _04048_ sky130_fd_sc_hd__nor2_1
X_14464_ _00288_ _04048_ VSS VSS VDD VDD _04049_ sky130_fd_sc_hd__nand2_1
X_14465_ net386 _04049_ VSS VSS VDD VDD _04050_ sky130_fd_sc_hd__nand2_1
X_14466_ network.in_period\[45\]\[0\] _04050_ VSS VSS VDD
+ VDD _04051_ sky130_fd_sc_hd__nand2_1
X_14467_ network.neuron_in045.counter\[0\] _04050_ _04051_
+ VSS VSS VDD VDD _02244_ sky130_fd_sc_hd__o21ai_0
X_14468_ network.neuron_in046.counter\[0\] VSS VSS VDD VDD
+ _00274_ sky130_fd_sc_hd__inv_1
Xplace455 net458 VSS VSS VDD VDD net454 sky130_fd_sc_hd__buf_4
X_14470_ network.neuron_in046.counter\[2\] VSS VSS VDD VDD
+ _04053_ sky130_fd_sc_hd__inv_1
X_14471_ network.neuron_in046.counter\[3\] VSS VSS VDD VDD
+ _04054_ sky130_fd_sc_hd__inv_1
X_14472_ _04053_ _00276_ _04054_ VSS VSS VDD VDD _04055_ sky130_fd_sc_hd__nand3_1
X_14473_ net386 _04055_ VSS VSS VDD VDD _04056_ sky130_fd_sc_hd__nand2_1
X_14474_ network.in_period\[46\]\[0\] _04056_ VSS VSS VDD
+ VDD _04057_ sky130_fd_sc_hd__nand2_1
X_14475_ network.neuron_in046.counter\[0\] _04056_ _04057_
+ VSS VSS VDD VDD _02248_ sky130_fd_sc_hd__o21ai_0
X_14476_ network.neuron_in047.counter\[3\] _00268_ VSS VSS
+ VDD VDD _04058_ sky130_fd_sc_hd__nand2b_1
X_14477_ network.neuron_in047.counter\[2\] VSS VSS VDD VDD
+ _04059_ sky130_fd_sc_hd__inv_1
X_14478_ _04058_ _04059_ VSS VSS VDD VDD _04060_ sky130_fd_sc_hd__nand2b_1
X_14479_ net386 _04060_ VSS VSS VDD VDD _04061_ sky130_fd_sc_hd__nand2_1
X_14480_ network.in_period\[47\]\[0\] _04061_ VSS VSS VDD
+ VDD _04062_ sky130_fd_sc_hd__nand2_1
X_14481_ network.neuron_in047.counter\[0\] _04061_ _04062_
+ VSS VSS VDD VDD _02252_ sky130_fd_sc_hd__o21ai_0
X_14482_ network.in_period\[44\]\[1\] _04046_ VSS VSS VDD
+ VDD _04063_ sky130_fd_sc_hd__nand2_1
X_14483_ _00273_ _04046_ _04063_ VSS VSS VDD VDD _02241_ sky130_fd_sc_hd__o21ai_0
X_14484_ network.in_period\[45\]\[1\] _04050_ VSS VSS VDD
+ VDD _04064_ sky130_fd_sc_hd__nand2_1
X_14485_ _00289_ _04050_ _04064_ VSS VSS VDD VDD _02245_ sky130_fd_sc_hd__o21ai_0
X_14486_ network.in_period\[46\]\[1\] _04056_ VSS VSS VDD
+ VDD _04065_ sky130_fd_sc_hd__nand2_1
X_14487_ _00277_ _04056_ _04065_ VSS VSS VDD VDD _02249_ sky130_fd_sc_hd__o21ai_0
X_14488_ network.in_period\[47\]\[1\] _04061_ VSS VSS VDD
+ VDD _04066_ sky130_fd_sc_hd__nand2_1
X_14489_ _00269_ _04061_ _04066_ VSS VSS VDD VDD _02253_ sky130_fd_sc_hd__o21ai_0
X_14490_ net397 _03742_ VSS VSS VDD VDD _04067_ sky130_fd_sc_hd__nand2_1
X_14491_ network.in_period\[43\]\[1\] _04067_ VSS VSS VDD
+ VDD _04068_ sky130_fd_sc_hd__nand2_1
X_14492_ _00297_ _04067_ _04068_ VSS VSS VDD VDD _02237_ sky130_fd_sc_hd__o21ai_0
X_14493_ network.in_period\[43\]\[0\] _04067_ VSS VSS VDD
+ VDD _04069_ sky130_fd_sc_hd__nand2_1
X_14494_ network.neuron_in043.counter\[0\] _04067_ _04069_
+ VSS VSS VDD VDD _02236_ sky130_fd_sc_hd__o21ai_0
X_14495_ network.neuron_in044.counter\[3\] network.in_period\[44\]\[2\]
+ _00272_ net380 VSS VSS VDD VDD _04070_ sky130_fd_sc_hd__o22ai_1
X_14496_ network.neuron_in044.counter\[2\] _00272_ net386
+ VSS VSS VDD VDD _04071_ sky130_fd_sc_hd__nand3_1
X_14497_ network.in_period\[44\]\[2\] net386 _04071_ VSS VSS
+ VDD VDD _04072_ sky130_fd_sc_hd__o21ai_0
X_14498_ _04044_ _04070_ _04072_ VSS VSS VDD VDD _02242_ sky130_fd_sc_hd__a21oi_1
Xplace454 net454 VSS VSS VDD VDD net453 sky130_fd_sc_hd__buf_4
X_14500_ network.neuron_in045.counter\[2\] _00288_ VSS VSS
+ VDD VDD _04074_ sky130_fd_sc_hd__xnor2_1
X_14501_ net386 _04049_ network.in_period\[45\]\[2\] VSS VSS
+ VDD VDD _04075_ sky130_fd_sc_hd__a21oi_1
X_14502_ net386 _04074_ _04075_ VSS VSS VDD VDD _02246_ sky130_fd_sc_hd__a21oi_1
X_14503_ network.neuron_in046.counter\[3\] network.in_period\[46\]\[2\]
+ net380 _00276_ VSS VSS VDD VDD _04076_ sky130_fd_sc_hd__o22ai_1
X_14504_ network.neuron_in046.counter\[2\] _00276_ net386
+ VSS VSS VDD VDD _04077_ sky130_fd_sc_hd__nand3_1
X_14505_ network.in_period\[46\]\[2\] net386 _04077_ VSS VSS
+ VDD VDD _04078_ sky130_fd_sc_hd__o21ai_0
X_14506_ _04053_ _04076_ _04078_ VSS VSS VDD VDD _02250_ sky130_fd_sc_hd__a21oi_1
X_14507_ network.neuron_in047.counter\[3\] network.in_period\[47\]\[2\]
+ net377 _00268_ VSS VSS VDD VDD _04079_ sky130_fd_sc_hd__o22ai_1
X_14508_ network.neuron_in047.counter\[2\] _00268_ net386
+ VSS VSS VDD VDD _04080_ sky130_fd_sc_hd__nand3_1
X_14509_ network.in_period\[47\]\[2\] net386 _04080_ VSS VSS
+ VDD VDD _04081_ sky130_fd_sc_hd__o21ai_0
X_14510_ _04059_ _04079_ _04081_ VSS VSS VDD VDD _02254_ sky130_fd_sc_hd__a21oi_1
X_14511_ _03949_ _04032_ VSS VSS VDD VDD _04082_ sky130_fd_sc_hd__nand2_1
Xplace453 net453 VSS VSS VDD VDD net452 sky130_fd_sc_hd__buf_4
X_14513_ _04035_ _04082_ VSS VSS VDD VDD _03096_ sky130_fd_sc_hd__nor2_1
X_14514_ _03994_ _04082_ VSS VSS VDD VDD _03093_ sky130_fd_sc_hd__nor2_1
X_14515_ _04039_ _04082_ VSS VSS VDD VDD _03090_ sky130_fd_sc_hd__nor2_1
X_14516_ _04017_ _04082_ VSS VSS VDD VDD _03341_ sky130_fd_sc_hd__nor2_1
X_14517_ _04019_ _04082_ VSS VSS VDD VDD _03339_ sky130_fd_sc_hd__nor2_1
X_14518_ _04001_ _04032_ VSS VSS VDD VDD _04084_ sky130_fd_sc_hd__nand2_1
Xplace451 net451 VSS VSS VDD VDD net450 sky130_fd_sc_hd__buf_4
X_14520_ _03945_ _04084_ VSS VSS VDD VDD _03338_ sky130_fd_sc_hd__nor2_1
X_14521_ _04035_ _04084_ VSS VSS VDD VDD _03334_ sky130_fd_sc_hd__nor2_1
X_14522_ _04039_ _04084_ VSS VSS VDD VDD _03327_ sky130_fd_sc_hd__nor2_1
X_14523_ network.neuron_in114.counter\[0\] VSS VSS VDD VDD
+ _00496_ sky130_fd_sc_hd__inv_1
X_14524_ network.neuron_in051.counter\[2\] VSS VSS VDD VDD
+ _04086_ sky130_fd_sc_hd__inv_1
X_14525_ network.neuron_in051.counter\[3\] network.in_period\[51\]\[2\]
+ _00523_ net371 VSS VSS VDD VDD _04087_ sky130_fd_sc_hd__o22ai_1
X_14526_ network.neuron_in051.counter\[2\] _00523_ net389
+ VSS VSS VDD VDD _04088_ sky130_fd_sc_hd__nand3_1
X_14527_ network.in_period\[51\]\[2\] net389 _04088_ VSS VSS
+ VDD VDD _04089_ sky130_fd_sc_hd__o21ai_0
X_14528_ _04086_ _04087_ _04089_ VSS VSS VDD VDD _02270_ sky130_fd_sc_hd__a21oi_1
X_14529_ net301 _04007_ VSS VSS VDD VDD _03284_ sky130_fd_sc_hd__nor2_1
X_14530_ _03999_ _04007_ VSS VSS VDD VDD _03273_ sky130_fd_sc_hd__nor2_1
X_14531_ _04007_ _04015_ VSS VSS VDD VDD _03272_ sky130_fd_sc_hd__nor2_1
X_14532_ net325 _07608_ net413 VSS VSS VDD VDD _04090_ sky130_fd_sc_hd__o21ai_0
X_14533_ _07599_ _07127_ net342 _04090_ VSS VSS VDD VDD _04091_
+ sky130_fd_sc_hd__o211ai_1
X_14534_ net413 _07109_ _07115_ VSS VSS VDD VDD _04092_ sky130_fd_sc_hd__o21ai_0
X_14535_ net419 _04091_ _04092_ _07056_ _07623_ VSS VSS VDD
+ VDD _04093_ sky130_fd_sc_hd__a221oi_1
X_14536_ net409 net415 _07921_ VSS VSS VDD VDD _04094_ sky130_fd_sc_hd__nor3_1
X_14537_ net409 net415 _07116_ _04094_ VSS VSS VDD VDD _04095_
+ sky130_fd_sc_hd__a31oi_1
X_14538_ net409 _07331_ _07115_ VSS VSS VDD VDD _04096_ sky130_fd_sc_hd__o21ai_0
X_14539_ net362 _07884_ net425 VSS VSS VDD VDD _04097_ sky130_fd_sc_hd__o21ai_0
X_14540_ net419 net361 network.neuron_hid0.ROM0.address\[4\]
+ VSS VSS VDD VDD _04098_ sky130_fd_sc_hd__o21ai_0
X_14541_ _04097_ _04098_ net339 VSS VSS VDD VDD _04099_ sky130_fd_sc_hd__a21oi_1
X_14542_ _07581_ _04096_ _04099_ net422 VSS VSS VDD VDD _04100_
+ sky130_fd_sc_hd__a211oi_1
X_14543_ net422 _04095_ _04100_ VSS VSS VDD VDD _04101_ sky130_fd_sc_hd__a21oi_1
X_14544_ net361 _07884_ _04101_ VSS VSS VDD VDD _04102_ sky130_fd_sc_hd__a21oi_1
X_14545_ net421 net417 net357 VSS VSS VDD VDD _04103_ sky130_fd_sc_hd__nor3_1
X_14546_ net421 _07751_ _07875_ VSS VSS VDD VDD _04104_ sky130_fd_sc_hd__a21oi_1
X_14547_ _07046_ net363 _07162_ VSS VSS VDD VDD _04105_ sky130_fd_sc_hd__nor3_1
X_14548_ net345 _04105_ net412 VSS VSS VDD VDD _04106_ sky130_fd_sc_hd__o21ai_0
X_14549_ net412 _04104_ _04106_ VSS VSS VDD VDD _04107_ sky130_fd_sc_hd__o21ai_0
X_14550_ _04103_ _04107_ net416 VSS VSS VDD VDD _04108_ sky130_fd_sc_hd__o21ai_0
X_14551_ _07758_ _07171_ VSS VSS VDD VDD _04109_ sky130_fd_sc_hd__nor2_1
X_14552_ net421 _04109_ VSS VSS VDD VDD _04110_ sky130_fd_sc_hd__nor2_1
X_14553_ _07731_ _04110_ net412 VSS VSS VDD VDD _04111_ sky130_fd_sc_hd__o21ai_0
X_14554_ _04108_ _04111_ net408 VSS VSS VDD VDD _04112_ sky130_fd_sc_hd__a21o_1
X_14555_ _07254_ _04093_ _04102_ net410 _04112_ VSS VSS VDD
+ VDD _04113_ sky130_fd_sc_hd__o221ai_1
X_14556_ net350 _07573_ net423 VSS VSS VDD VDD _04114_ sky130_fd_sc_hd__a21oi_1
X_14557_ net424 net353 _07322_ net414 _04114_ VSS VSS VDD
+ VDD _04115_ sky130_fd_sc_hd__a221oi_1
X_14558_ net306 _04113_ _04115_ net307 VSS VSS VDD VDD _01757_
+ sky130_fd_sc_hd__a22o_1
X_14559_ _04007_ _04030_ VSS VSS VDD VDD _03270_ sky130_fd_sc_hd__nor2_1
X_14560_ _04019_ _04007_ VSS VSS VDD VDD _03269_ sky130_fd_sc_hd__nor2_1
X_14561_ network.neuron_in048.counter\[2\] _00264_ VSS VSS
+ VDD VDD _04116_ sky130_fd_sc_hd__nor2b_1
X_14562_ network.neuron_in048.counter\[3\] _04116_ VSS VSS
+ VDD VDD _04117_ sky130_fd_sc_hd__nand2b_1
X_14563_ net389 _04117_ VSS VSS VDD VDD _04118_ sky130_fd_sc_hd__nand2_1
X_14564_ network.in_period\[48\]\[0\] _04118_ VSS VSS VDD
+ VDD _04119_ sky130_fd_sc_hd__nand2_1
X_14565_ network.neuron_in048.counter\[0\] _04118_ _04119_
+ VSS VSS VDD VDD _02256_ sky130_fd_sc_hd__o21ai_0
X_14566_ _04001_ net294 VSS VSS VDD VDD _04120_ sky130_fd_sc_hd__nand2_1
Xplace448 net449 VSS VSS VDD VDD net447 sky130_fd_sc_hd__buf_4
X_14568_ _03945_ _04120_ VSS VSS VDD VDD _03268_ sky130_fd_sc_hd__nor2_1
X_14569_ net301 _04120_ VSS VSS VDD VDD _03267_ sky130_fd_sc_hd__nor2_1
X_14570_ _03954_ _04120_ VSS VSS VDD VDD _03265_ sky130_fd_sc_hd__nor2_1
X_14571_ network.neuron_in049.counter\[3\] _00260_ VSS VSS
+ VDD VDD _04122_ sky130_fd_sc_hd__nand2b_1
X_14572_ network.neuron_in049.counter\[2\] VSS VSS VDD VDD
+ _04123_ sky130_fd_sc_hd__inv_1
X_14573_ _04122_ _04123_ VSS VSS VDD VDD _04124_ sky130_fd_sc_hd__nand2b_1
X_14574_ net388 _04124_ VSS VSS VDD VDD _04125_ sky130_fd_sc_hd__nand2_1
X_14575_ network.in_period\[49\]\[0\] _04125_ VSS VSS VDD
+ VDD _04126_ sky130_fd_sc_hd__nand2_1
X_14576_ network.neuron_in049.counter\[0\] _04125_ _04126_
+ VSS VSS VDD VDD _02260_ sky130_fd_sc_hd__o21ai_0
X_14577_ net300 _04120_ VSS VSS VDD VDD _03264_ sky130_fd_sc_hd__nor2_1
X_14578_ _04035_ _04120_ VSS VSS VDD VDD _03263_ sky130_fd_sc_hd__nor2_1
X_14579_ network.neuron_in050.counter\[0\] VSS VSS VDD VDD
+ _00335_ sky130_fd_sc_hd__inv_1
X_14580_ network.neuron_in050.counter\[2\] network.neuron_in050.counter\[3\]
+ VSS VSS VDD VDD _04127_ sky130_fd_sc_hd__nor2_1
X_14581_ _00337_ _04127_ VSS VSS VDD VDD _04128_ sky130_fd_sc_hd__nand2_1
X_14582_ net389 _04128_ VSS VSS VDD VDD _04129_ sky130_fd_sc_hd__nand2_1
X_14583_ network.in_period\[50\]\[0\] _04129_ VSS VSS VDD
+ VDD _04130_ sky130_fd_sc_hd__nand2_1
X_14584_ network.neuron_in050.counter\[0\] _04129_ _04130_
+ VSS VSS VDD VDD _02264_ sky130_fd_sc_hd__o21ai_0
X_14585_ net299 _04120_ VSS VSS VDD VDD _03262_ sky130_fd_sc_hd__nor2_1
X_14586_ network.neuron_in052.counter\[2\] VSS VSS VDD VDD
+ _04131_ sky130_fd_sc_hd__inv_1
X_14587_ network.neuron_in052.counter\[3\] network.in_period\[52\]\[2\]
+ net371 _00256_ VSS VSS VDD VDD _04132_ sky130_fd_sc_hd__o22ai_1
Xplace450 net450 VSS VSS VDD VDD net449 sky130_fd_sc_hd__buf_4
X_14589_ network.neuron_in052.counter\[2\] _00256_ net389
+ VSS VSS VDD VDD _04134_ sky130_fd_sc_hd__nand3_1
X_14590_ network.in_period\[52\]\[2\] net389 _04134_ VSS VSS
+ VDD VDD _04135_ sky130_fd_sc_hd__o21ai_0
X_14591_ _04131_ _04132_ _04135_ VSS VSS VDD VDD _02274_ sky130_fd_sc_hd__a21oi_1
X_14592_ _04037_ _04120_ VSS VSS VDD VDD _03261_ sky130_fd_sc_hd__nor2_1
X_14593_ _04004_ _04120_ VSS VSS VDD VDD _03243_ sky130_fd_sc_hd__nor2_1
X_14594_ _03997_ _04120_ VSS VSS VDD VDD _03232_ sky130_fd_sc_hd__nor2_1
X_14595_ network.neuron_in048.counter\[2\] VSS VSS VDD VDD
+ _04136_ sky130_fd_sc_hd__inv_1
X_14596_ network.neuron_in048.counter\[3\] network.in_period\[48\]\[2\]
+ net371 _00264_ VSS VSS VDD VDD _04137_ sky130_fd_sc_hd__o22ai_1
X_14597_ network.neuron_in048.counter\[2\] _00264_ net389
+ VSS VSS VDD VDD _04138_ sky130_fd_sc_hd__nand3_1
X_14598_ network.in_period\[48\]\[2\] net389 _04138_ VSS VSS
+ VDD VDD _04139_ sky130_fd_sc_hd__o21ai_0
X_14599_ _04136_ _04137_ _04139_ VSS VSS VDD VDD _02258_ sky130_fd_sc_hd__a21oi_1
X_14600_ _03999_ _04120_ VSS VSS VDD VDD _03210_ sky130_fd_sc_hd__nor2_1
X_14601_ _04015_ _04120_ VSS VSS VDD VDD _03198_ sky130_fd_sc_hd__nor2_1
X_14602_ _04017_ _04120_ VSS VSS VDD VDD _03187_ sky130_fd_sc_hd__nor2_1
X_14603_ network.in_period\[48\]\[1\] _04118_ VSS VSS VDD
+ VDD _04140_ sky130_fd_sc_hd__nand2_1
X_14604_ _00265_ _04118_ _04140_ VSS VSS VDD VDD _02257_ sky130_fd_sc_hd__o21ai_0
X_14605_ _04019_ _04120_ VSS VSS VDD VDD _03165_ sky130_fd_sc_hd__nor2_1
X_14606_ net301 _04024_ VSS VSS VDD VDD _03259_ sky130_fd_sc_hd__nor2_1
X_14607_ net326 net294 VSS VSS VDD VDD _04141_ sky130_fd_sc_hd__nand2_1
Xplace447 net451 VSS VSS VDD VDD net446 sky130_fd_sc_hd__buf_4
X_14609_ _03945_ net286 VSS VSS VDD VDD _03154_ sky130_fd_sc_hd__nor2_1
X_14610_ net301 net286 VSS VSS VDD VDD _03143_ sky130_fd_sc_hd__nor2_1
X_14611_ _03954_ net286 VSS VSS VDD VDD _03132_ sky130_fd_sc_hd__nor2_1
X_14612_ _04019_ net287 VSS VSS VDD VDD _03102_ sky130_fd_sc_hd__nor2_1
X_14613_ _03945_ _04082_ VSS VSS VDD VDD _03101_ sky130_fd_sc_hd__nor2_1
X_14614_ _04037_ net286 VSS VSS VDD VDD _03343_ sky130_fd_sc_hd__nor2_1
X_14615_ _03994_ net286 VSS VSS VDD VDD _03332_ sky130_fd_sc_hd__nor2_1
X_14616_ _03997_ net286 VSS VSS VDD VDD _03310_ sky130_fd_sc_hd__nor2_1
X_14617_ net301 _04082_ VSS VSS VDD VDD _03100_ sky130_fd_sc_hd__nor2_1
X_14618_ _03999_ net286 VSS VSS VDD VDD _03288_ sky130_fd_sc_hd__nor2_1
X_14619_ _03954_ _04082_ VSS VSS VDD VDD _03098_ sky130_fd_sc_hd__nor2_1
X_14620_ _03954_ _04024_ VSS VSS VDD VDD _03258_ sky130_fd_sc_hd__nor2_1
X_14621_ network.neuron_in049.counter\[3\] network.in_period\[49\]\[2\]
+ net373 _00260_ VSS VSS VDD VDD _04143_ sky130_fd_sc_hd__o22ai_1
X_14622_ network.neuron_in049.counter\[2\] _00260_ net388
+ VSS VSS VDD VDD _04144_ sky130_fd_sc_hd__nand3_1
X_14623_ network.in_period\[49\]\[2\] net388 _04144_ VSS VSS
+ VDD VDD _04145_ sky130_fd_sc_hd__o21ai_0
X_14624_ _04123_ _04143_ _04145_ VSS VSS VDD VDD _02262_ sky130_fd_sc_hd__a21oi_1
X_14625_ _04030_ net286 VSS VSS VDD VDD _03199_ sky130_fd_sc_hd__nor2_1
X_14626_ network.neuron_in091.counter\[0\] VSS VSS VDD VDD
+ _00129_ sky130_fd_sc_hd__inv_1
X_14627_ network.in_period\[49\]\[1\] _04125_ VSS VSS VDD
+ VDD _04146_ sky130_fd_sc_hd__nand2_1
X_14628_ _00261_ _04125_ _04146_ VSS VSS VDD VDD _02261_ sky130_fd_sc_hd__o21ai_0
X_14629_ _04019_ net286 VSS VSS VDD VDD _03088_ sky130_fd_sc_hd__nor2_1
X_14630_ network.neuron_in050.counter\[2\] _00337_ VSS VSS
+ VDD VDD _04147_ sky130_fd_sc_hd__xnor2_1
X_14631_ net389 _04128_ network.in_period\[50\]\[2\] VSS VSS
+ VDD VDD _04148_ sky130_fd_sc_hd__a21oi_1
X_14632_ net389 _04147_ _04148_ VSS VSS VDD VDD _02266_ sky130_fd_sc_hd__a21oi_1
X_14633_ network.in_period\[50\]\[1\] _04129_ VSS VSS VDD
+ VDD _04149_ sky130_fd_sc_hd__nand2_1
X_14634_ _00338_ _04129_ _04149_ VSS VSS VDD VDD _02265_ sky130_fd_sc_hd__o21ai_0
X_14635_ network.neuron_in051.counter\[3\] _00523_ VSS VSS
+ VDD VDD _04150_ sky130_fd_sc_hd__nand2b_1
X_14636_ _04150_ _04086_ VSS VSS VDD VDD _04151_ sky130_fd_sc_hd__nand2b_1
X_14637_ net389 _04151_ VSS VSS VDD VDD _04152_ sky130_fd_sc_hd__nand2_1
X_14638_ network.in_period\[51\]\[1\] _04152_ VSS VSS VDD
+ VDD _04153_ sky130_fd_sc_hd__nand2_1
X_14639_ _00524_ _04152_ _04153_ VSS VSS VDD VDD _02269_ sky130_fd_sc_hd__o21ai_0
X_14640_ network.in_period\[51\]\[0\] _04152_ VSS VSS VDD
+ VDD _04154_ sky130_fd_sc_hd__nand2_1
X_14641_ network.neuron_in051.counter\[0\] _04152_ _04154_
+ VSS VSS VDD VDD _02268_ sky130_fd_sc_hd__o21ai_0
X_14642_ network.neuron_in052.counter\[2\] _00256_ VSS VSS
+ VDD VDD _04155_ sky130_fd_sc_hd__nor2b_1
X_14643_ network.neuron_in052.counter\[3\] _04155_ VSS VSS
+ VDD VDD _04156_ sky130_fd_sc_hd__nand2b_1
X_14644_ net389 _04156_ VSS VSS VDD VDD _04157_ sky130_fd_sc_hd__nand2_1
X_14645_ network.in_period\[52\]\[1\] _04157_ VSS VSS VDD
+ VDD _04158_ sky130_fd_sc_hd__nand2_1
X_14646_ _00257_ _04157_ _04158_ VSS VSS VDD VDD _02273_ sky130_fd_sc_hd__o21ai_0
X_14647_ network.in_period\[52\]\[0\] _04157_ VSS VSS VDD
+ VDD _04159_ sky130_fd_sc_hd__nand2_1
X_14648_ network.neuron_in052.counter\[0\] _04157_ _04159_
+ VSS VSS VDD VDD _02272_ sky130_fd_sc_hd__o21ai_0
Xplace446 net446 VSS VSS VDD VDD net445 sky130_fd_sc_hd__buf_4
X_14650_ network.neuron_in055.counter\[2\] _00242_ VSS VSS
+ VDD VDD _04161_ sky130_fd_sc_hd__nor2b_1
X_14651_ network.neuron_in055.counter\[3\] _04161_ VSS VSS
+ VDD VDD _04162_ sky130_fd_sc_hd__nand2b_1
X_14652_ net388 _04162_ VSS VSS VDD VDD _04163_ sky130_fd_sc_hd__nand2_1
X_14653_ network.in_period\[55\]\[1\] _04163_ VSS VSS VDD
+ VDD _04164_ sky130_fd_sc_hd__nand2_1
X_14654_ _00243_ _04163_ _04164_ VSS VSS VDD VDD _02285_ sky130_fd_sc_hd__o21ai_0
X_14655_ network.neuron_in057.counter\[2\] network.neuron_in057.counter\[3\]
+ _00234_ VSS VSS VDD VDD _04165_ sky130_fd_sc_hd__or3b_2
X_14656_ net388 _04165_ VSS VSS VDD VDD _04166_ sky130_fd_sc_hd__nand2_1
X_14657_ network.in_period\[57\]\[0\] _04166_ VSS VSS VDD
+ VDD _04167_ sky130_fd_sc_hd__nand2_1
X_14658_ network.neuron_in057.counter\[0\] _04166_ _04167_
+ VSS VSS VDD VDD _02292_ sky130_fd_sc_hd__o21ai_0
X_14659_ net300 _04024_ VSS VSS VDD VDD _03257_ sky130_fd_sc_hd__nor2_1
X_14660_ network.neuron_in055.counter\[2\] VSS VSS VDD VDD
+ _04168_ sky130_fd_sc_hd__inv_1
Xplace449 net449 VSS VSS VDD VDD net448 sky130_fd_sc_hd__buf_4
X_14662_ network.neuron_in055.counter\[3\] network.in_period\[55\]\[2\]
+ net373 _00242_ VSS VSS VDD VDD _04170_ sky130_fd_sc_hd__o22ai_1
Xplace443 net443 VSS VSS VDD VDD net442 sky130_fd_sc_hd__buf_4
X_14664_ network.neuron_in055.counter\[2\] _00242_ net388
+ VSS VSS VDD VDD _04172_ sky130_fd_sc_hd__nand3_1
X_14665_ network.in_period\[55\]\[2\] net388 _04172_ VSS VSS
+ VDD VDD _04173_ sky130_fd_sc_hd__o21ai_0
X_14666_ _04168_ _04170_ _04173_ VSS VSS VDD VDD _02286_ sky130_fd_sc_hd__a21oi_1
X_14667_ network.in_period\[57\]\[1\] _04166_ VSS VSS VDD
+ VDD _04174_ sky130_fd_sc_hd__nand2_1
X_14668_ _00235_ _04166_ _04174_ VSS VSS VDD VDD _02293_ sky130_fd_sc_hd__o21ai_0
X_14669_ network.neuron_in053.counter\[2\] network.neuron_in053.counter\[3\]
+ VSS VSS VDD VDD _04175_ sky130_fd_sc_hd__nor2_1
X_14670_ _00252_ _04175_ VSS VSS VDD VDD _04176_ sky130_fd_sc_hd__nand2_1
X_14671_ net388 _04176_ VSS VSS VDD VDD _04177_ sky130_fd_sc_hd__nand2_1
X_14672_ network.in_period\[53\]\[0\] _04177_ VSS VSS VDD
+ VDD _04178_ sky130_fd_sc_hd__nand2_1
X_14673_ network.neuron_in053.counter\[0\] _04177_ _04178_
+ VSS VSS VDD VDD _02276_ sky130_fd_sc_hd__o21ai_0
X_14674_ network.neuron_in054.counter\[2\] VSS VSS VDD VDD
+ _04179_ sky130_fd_sc_hd__inv_1
X_14675_ network.neuron_in054.counter\[3\] network.in_period\[54\]\[2\]
+ net371 _00248_ VSS VSS VDD VDD _04180_ sky130_fd_sc_hd__o22ai_1
X_14676_ network.neuron_in054.counter\[2\] _00248_ net389
+ VSS VSS VDD VDD _04181_ sky130_fd_sc_hd__nand3_1
X_14677_ network.in_period\[54\]\[2\] net389 _04181_ VSS VSS
+ VDD VDD _04182_ sky130_fd_sc_hd__o21ai_0
X_14678_ _04179_ _04180_ _04182_ VSS VSS VDD VDD _02282_ sky130_fd_sc_hd__a21oi_1
X_14679_ network.neuron_in056.counter\[2\] _00226_ VSS VSS
+ VDD VDD _04183_ sky130_fd_sc_hd__nor2b_1
X_14680_ network.neuron_in056.counter\[3\] _04183_ VSS VSS
+ VDD VDD _04184_ sky130_fd_sc_hd__nand2b_1
X_14681_ net388 _04184_ VSS VSS VDD VDD _04185_ sky130_fd_sc_hd__nand2_1
X_14682_ network.in_period\[56\]\[0\] _04185_ VSS VSS VDD
+ VDD _04186_ sky130_fd_sc_hd__nand2_1
X_14683_ network.neuron_in056.counter\[0\] _04185_ _04186_
+ VSS VSS VDD VDD _02288_ sky130_fd_sc_hd__o21ai_0
X_14684_ network.neuron_in057.counter\[2\] _00234_ VSS VSS
+ VDD VDD _04187_ sky130_fd_sc_hd__xnor2_1
X_14685_ net388 _04165_ network.in_period\[57\]\[2\] VSS VSS
+ VDD VDD _04188_ sky130_fd_sc_hd__a21oi_1
X_14686_ net388 _04187_ _04188_ VSS VSS VDD VDD _02294_ sky130_fd_sc_hd__a21oi_1
X_14687_ network.neuron_in053.counter\[2\] _00252_ VSS VSS
+ VDD VDD _04189_ sky130_fd_sc_hd__xnor2_1
X_14688_ net388 _04176_ network.in_period\[53\]\[2\] VSS VSS
+ VDD VDD _04190_ sky130_fd_sc_hd__a21oi_1
X_14689_ net389 _04189_ _04190_ VSS VSS VDD VDD _02278_ sky130_fd_sc_hd__a21oi_1
X_14690_ network.in_period\[53\]\[1\] _04177_ VSS VSS VDD
+ VDD _04191_ sky130_fd_sc_hd__nand2_1
X_14691_ _00253_ _04177_ _04191_ VSS VSS VDD VDD _02277_ sky130_fd_sc_hd__o21ai_0
X_14692_ network.neuron_in054.counter\[2\] _00248_ VSS VSS
+ VDD VDD _04192_ sky130_fd_sc_hd__nor2b_1
X_14693_ network.neuron_in054.counter\[3\] _04192_ VSS VSS
+ VDD VDD _04193_ sky130_fd_sc_hd__nand2b_1
X_14694_ net389 _04193_ VSS VSS VDD VDD _04194_ sky130_fd_sc_hd__nand2_1
X_14695_ network.in_period\[54\]\[1\] _04194_ VSS VSS VDD
+ VDD _04195_ sky130_fd_sc_hd__nand2_1
X_14696_ _00249_ _04194_ _04195_ VSS VSS VDD VDD _02281_ sky130_fd_sc_hd__o21ai_0
X_14697_ network.in_period\[54\]\[0\] _04194_ VSS VSS VDD
+ VDD _04196_ sky130_fd_sc_hd__nand2_1
X_14698_ network.neuron_in054.counter\[0\] _04194_ _04196_
+ VSS VSS VDD VDD _02280_ sky130_fd_sc_hd__o21ai_0
X_14699_ network.in_period\[55\]\[0\] _04163_ VSS VSS VDD
+ VDD _04197_ sky130_fd_sc_hd__nand2_1
X_14700_ network.neuron_in055.counter\[0\] _04163_ _04197_
+ VSS VSS VDD VDD _02284_ sky130_fd_sc_hd__o21ai_0
X_14701_ network.neuron_in130.counter\[0\] VSS VSS VDD VDD
+ _00500_ sky130_fd_sc_hd__inv_1
X_14702_ network.neuron_in083.counter\[0\] VSS VSS VDD VDD
+ _00058_ sky130_fd_sc_hd__inv_1
X_14703_ _07720_ _07254_ _07682_ VSS VSS VDD VDD _04198_ sky130_fd_sc_hd__nor3_1
X_14704_ net305 _03867_ _04198_ VSS VSS VDD VDD _04199_ sky130_fd_sc_hd__a21oi_1
X_14705_ _03840_ _04199_ net316 VSS VSS VDD VDD _01758_ sky130_fd_sc_hd__a21oi_1
X_14706_ _03991_ _04017_ VSS VSS VDD VDD _03228_ sky130_fd_sc_hd__nor2_1
X_14707_ _03999_ net290 VSS VSS VDD VDD _03213_ sky130_fd_sc_hd__nor2_1
X_14708_ net290 _04015_ VSS VSS VDD VDD _03212_ sky130_fd_sc_hd__nor2_1
X_14709_ _03994_ net290 VSS VSS VDD VDD _03217_ sky130_fd_sc_hd__nor2_1
X_14710_ _04007_ _04039_ VSS VSS VDD VDD _03274_ sky130_fd_sc_hd__nor2_1
X_14711_ _03994_ net289 VSS VSS VDD VDD _03200_ sky130_fd_sc_hd__nor2_1
X_14712_ _04004_ net289 VSS VSS VDD VDD _03197_ sky130_fd_sc_hd__nor2_1
X_14713_ _03945_ net288 VSS VSS VDD VDD _03189_ sky130_fd_sc_hd__nor2_1
X_14714_ _03952_ net288 VSS VSS VDD VDD _03188_ sky130_fd_sc_hd__nor2_1
X_14715_ net419 net340 _07805_ _07616_ _07587_ VSS VSS VDD
+ VDD _04200_ sky130_fd_sc_hd__o32a_1
X_14716_ net339 _07186_ net316 _04200_ VSS VSS VDD VDD _01759_
+ sky130_fd_sc_hd__nor4_1
X_14717_ _03991_ _04035_ VSS VSS VDD VDD _03238_ sky130_fd_sc_hd__nor2_1
X_14718_ net288 _04039_ VSS VSS VDD VDD _03178_ sky130_fd_sc_hd__nor2_1
X_14719_ net300 net290 VSS VSS VDD VDD _03222_ sky130_fd_sc_hd__nor2_1
X_14720_ _03997_ _04007_ VSS VSS VDD VDD _03275_ sky130_fd_sc_hd__nor2_1
X_14721_ net289 _04030_ VSS VSS VDD VDD _03191_ sky130_fd_sc_hd__nor2_1
X_14722_ _04024_ _04035_ VSS VSS VDD VDD _03256_ sky130_fd_sc_hd__nor2_1
X_14723_ _04024_ _04039_ VSS VSS VDD VDD _03249_ sky130_fd_sc_hd__nor2_1
X_14724_ _03950_ _04039_ VSS VSS VDD VDD _03160_ sky130_fd_sc_hd__nor2_1
X_14725_ _03950_ _03999_ VSS VSS VDD VDD _03159_ sky130_fd_sc_hd__nor2_1
X_14726_ _04015_ _04024_ VSS VSS VDD VDD _03247_ sky130_fd_sc_hd__nor2_1
X_14727_ network.neuron_in056.counter\[2\] VSS VSS VDD VDD
+ _04201_ sky130_fd_sc_hd__inv_1
X_14728_ network.neuron_in056.counter\[3\] network.in_period\[56\]\[2\]
+ net373 _00226_ VSS VSS VDD VDD _04202_ sky130_fd_sc_hd__o22ai_1
X_14729_ network.neuron_in056.counter\[2\] _00226_ net388
+ VSS VSS VDD VDD _04203_ sky130_fd_sc_hd__nand3_1
X_14730_ network.in_period\[56\]\[2\] net388 _04203_ VSS VSS
+ VDD VDD _04204_ sky130_fd_sc_hd__o21ai_0
X_14731_ _04201_ _04202_ _04204_ VSS VSS VDD VDD _02290_ sky130_fd_sc_hd__a21oi_1
X_14732_ net299 _04082_ VSS VSS VDD VDD _03095_ sky130_fd_sc_hd__nor2_1
X_14733_ net288 _04037_ VSS VSS VDD VDD _03182_ sky130_fd_sc_hd__nor2_1
X_14734_ _04037_ _04082_ VSS VSS VDD VDD _03094_ sky130_fd_sc_hd__nor2_1
X_14735_ _03950_ _04030_ VSS VSS VDD VDD _03156_ sky130_fd_sc_hd__nor2_1
X_14736_ _04004_ _04082_ VSS VSS VDD VDD _03092_ sky130_fd_sc_hd__nor2_1
X_14737_ network.in_period\[56\]\[1\] _04185_ VSS VSS VDD
+ VDD _04205_ sky130_fd_sc_hd__nand2_1
X_14738_ _00227_ _04185_ _04205_ VSS VSS VDD VDD _02289_ sky130_fd_sc_hd__o21ai_0
X_14739_ _03997_ _04082_ VSS VSS VDD VDD _03091_ sky130_fd_sc_hd__nor2_1
X_14740_ _03999_ _04082_ VSS VSS VDD VDD _03089_ sky130_fd_sc_hd__nor2_1
X_14741_ _03945_ _04026_ VSS VSS VDD VDD _03153_ sky130_fd_sc_hd__nor2_1
X_14742_ net301 _04026_ VSS VSS VDD VDD _03152_ sky130_fd_sc_hd__nor2_1
X_14743_ network.neuron_out0.ROM0.address\[1\] network.neuron_out0.ROM0.address\[0\]
+ _08062_ VSS VSS VDD VDD _01760_ sky130_fd_sc_hd__nor3_1
X_14744_ _04015_ _04082_ VSS VSS VDD VDD _03342_ sky130_fd_sc_hd__nor2_1
X_14745_ _03945_ _03991_ VSS VSS VDD VDD _03242_ sky130_fd_sc_hd__nor2_1
X_14746_ _04030_ _04082_ VSS VSS VDD VDD _03340_ sky130_fd_sc_hd__nor2_1
X_14747_ net301 _03991_ VSS VSS VDD VDD _03241_ sky130_fd_sc_hd__nor2_1
X_14748_ _04026_ _04035_ VSS VSS VDD VDD _03149_ sky130_fd_sc_hd__nor2_1
X_14749_ net349 _07880_ _07818_ net366 VSS VSS VDD VDD _04206_
+ sky130_fd_sc_hd__o22ai_1
X_14750_ net357 _07215_ net412 VSS VSS VDD VDD _04207_ sky130_fd_sc_hd__o21ai_0
X_14751_ net412 _07140_ _04207_ VSS VSS VDD VDD _04208_ sky130_fd_sc_hd__o21ai_0
X_14752_ net422 net325 _03880_ _04208_ net421 VSS VSS VDD
+ VDD _04209_ sky130_fd_sc_hd__a32oi_1
X_14753_ _07164_ _03831_ _04209_ net416 VSS VSS VDD VDD _04210_
+ sky130_fd_sc_hd__o22ai_1
X_14754_ net425 net344 _04206_ _04210_ net408 VSS VSS VDD
+ VDD _04211_ sky130_fd_sc_hd__a32oi_1
X_14755_ net318 net360 _07682_ _04211_ net316 VSS VSS VDD
+ VDD _01761_ sky130_fd_sc_hd__o32ai_1
X_14756_ net299 _04026_ VSS VSS VDD VDD _03148_ sky130_fd_sc_hd__nor2_1
X_14757_ _04017_ _04024_ VSS VSS VDD VDD _03246_ sky130_fd_sc_hd__nor2_1
X_14758_ _04019_ _03991_ VSS VSS VDD VDD _03226_ sky130_fd_sc_hd__nor2_1
X_14759_ net290 _04030_ VSS VSS VDD VDD _03209_ sky130_fd_sc_hd__nor2_1
X_14760_ _04019_ net290 VSS VSS VDD VDD _03208_ sky130_fd_sc_hd__nor2_1
X_14761_ net299 net289 VSS VSS VDD VDD _03202_ sky130_fd_sc_hd__nor2_1
X_14762_ net289 _04037_ VSS VSS VDD VDD _03201_ sky130_fd_sc_hd__nor2_1
X_14763_ _03954_ net288 VSS VSS VDD VDD _03186_ sky130_fd_sc_hd__nor2_1
X_14764_ _03950_ _03987_ VSS VSS VDD VDD _03168_ sky130_fd_sc_hd__nor2_1
X_14765_ _03950_ _04035_ VSS VSS VDD VDD _03167_ sky130_fd_sc_hd__nor2_1
X_14766_ _03997_ _04024_ VSS VSS VDD VDD _03250_ sky130_fd_sc_hd__nor2_1
X_14767_ _03950_ _04004_ VSS VSS VDD VDD _03162_ sky130_fd_sc_hd__nor2_1
X_14768_ _03950_ _03997_ VSS VSS VDD VDD _03161_ sky130_fd_sc_hd__nor2_1
X_14769_ _03999_ _04024_ VSS VSS VDD VDD _03248_ sky130_fd_sc_hd__nor2_1
X_14770_ _03950_ _04017_ VSS VSS VDD VDD _03157_ sky130_fd_sc_hd__nor2_1
X_14771_ _03999_ net288 VSS VSS VDD VDD _03177_ sky130_fd_sc_hd__nor2_1
X_14772_ _03954_ _04026_ VSS VSS VDD VDD _03151_ sky130_fd_sc_hd__nor2_1
X_14773_ net429 net428 net294 VSS VSS VDD VDD _04212_ sky130_fd_sc_hd__nand3_1
Xplace432 net433 VSS VSS VDD VDD net431 sky130_fd_sc_hd__buf_4
X_14775_ _04037_ net285 VSS VSS VDD VDD _03296_ sky130_fd_sc_hd__nor2_1
X_14776_ _03994_ net285 VSS VSS VDD VDD _03295_ sky130_fd_sc_hd__nor2_1
X_14777_ net299 _04024_ VSS VSS VDD VDD _03255_ sky130_fd_sc_hd__nor2_1
X_14778_ _04024_ _04037_ VSS VSS VDD VDD _03253_ sky130_fd_sc_hd__nor2_1
X_14779_ _04039_ net285 VSS VSS VDD VDD _03292_ sky130_fd_sc_hd__nor2_1
X_14780_ _03999_ net285 VSS VSS VDD VDD _03291_ sky130_fd_sc_hd__nor2_1
X_14781_ _03991_ _04030_ VSS VSS VDD VDD _03227_ sky130_fd_sc_hd__nor2_1
X_14782_ _03945_ net290 VSS VSS VDD VDD _03225_ sky130_fd_sc_hd__nor2_1
X_14783_ net290 _04017_ VSS VSS VDD VDD _03211_ sky130_fd_sc_hd__nor2_1
X_14784_ net340 _07573_ VSS VSS VDD VDD _04214_ sky130_fd_sc_hd__nand2_1
X_14785_ net411 net423 _04214_ VSS VSS VDD VDD _04215_ sky130_fd_sc_hd__nand3_1
X_14786_ net417 net324 _07106_ VSS VSS VDD VDD _04216_ sky130_fd_sc_hd__o21ai_0
X_14787_ net412 net423 VSS VSS VDD VDD _04217_ sky130_fd_sc_hd__xor2_1
X_14788_ net412 _07614_ VSS VSS VDD VDD _04218_ sky130_fd_sc_hd__nor2_1
X_14789_ net412 net334 _04218_ VSS VSS VDD VDD _04219_ sky130_fd_sc_hd__a21oi_1
X_14790_ net417 _04219_ VSS VSS VDD VDD _04220_ sky130_fd_sc_hd__nor2_1
X_14791_ network.neuron_hid0.ROM0.address\[0\] _04217_ _04220_
+ VSS VSS VDD VDD _04221_ sky130_fd_sc_hd__a21oi_1
X_14792_ _04215_ _04216_ _04221_ VSS VSS VDD VDD _04222_ sky130_fd_sc_hd__nand3_1
X_14793_ net362 net342 net421 VSS VSS VDD VDD _04223_ sky130_fd_sc_hd__a21oi_1
X_14794_ net325 _07188_ _07616_ _04223_ VSS VSS VDD VDD _04224_
+ sky130_fd_sc_hd__nor4_1
X_14795_ _07046_ _07796_ _07307_ _07930_ net364 VSS VSS VDD
+ VDD _04225_ sky130_fd_sc_hd__a2111oi_0
X_14796_ net416 _04222_ _04224_ _04225_ net408 VSS VSS VDD
+ VDD _04226_ sky130_fd_sc_hd__a2111oi_2
X_14797_ _07720_ net322 VSS VSS VDD VDD _04227_ sky130_fd_sc_hd__nand2_1
X_14798_ net418 net422 net314 _07614_ _07720_ VSS VSS VDD
+ VDD _04228_ sky130_fd_sc_hd__o32ai_1
X_14799_ net410 _07115_ _07901_ VSS VSS VDD VDD _04229_ sky130_fd_sc_hd__nand3_1
X_14800_ net410 _04228_ _04229_ VSS VSS VDD VDD _04230_ sky130_fd_sc_hd__o21ai_0
X_14801_ _04227_ _04230_ net413 VSS VSS VDD VDD _04231_ sky130_fd_sc_hd__a21oi_1
X_14802_ net343 net345 _07362_ _07624_ VSS VSS VDD VDD _04232_
+ sky130_fd_sc_hd__nor4_1
X_14803_ _07864_ _03918_ _07805_ VSS VSS VDD VDD _04233_ sky130_fd_sc_hd__a21oi_1
X_14804_ net339 _04231_ _04232_ _04233_ net306 VSS VSS VDD
+ VDD _04234_ sky130_fd_sc_hd__o41ai_1
X_14805_ net318 _04110_ VSS VSS VDD VDD _04235_ sky130_fd_sc_hd__nor2_1
X_14806_ net366 _07645_ VSS VSS VDD VDD _04236_ sky130_fd_sc_hd__nand2_1
X_14807_ net413 _07115_ _04236_ net418 net364 _07109_ VSS
+ VSS VDD VDD _04237_ sky130_fd_sc_hd__a222oi_1
X_14808_ _04235_ _04237_ VSS VSS VDD VDD _04238_ sky130_fd_sc_hd__nand2_1
X_14809_ _04226_ _04234_ _04238_ VSS VSS VDD VDD _01762_ sky130_fd_sc_hd__o21ai_0
X_14810_ _03994_ _04024_ VSS VSS VDD VDD _03252_ sky130_fd_sc_hd__nor2_1
X_14811_ _04017_ net288 VSS VSS VDD VDD _03174_ sky130_fd_sc_hd__nor2_1
X_14812_ _03950_ _03994_ VSS VSS VDD VDD _03163_ sky130_fd_sc_hd__nor2_1
X_14813_ _03950_ _04015_ VSS VSS VDD VDD _03158_ sky130_fd_sc_hd__nor2_1
X_14814_ network.neuron_in058.counter\[2\] VSS VSS VDD VDD
+ _04239_ sky130_fd_sc_hd__inv_1
X_14815_ network.neuron_in058.counter\[3\] VSS VSS VDD VDD
+ _04240_ sky130_fd_sc_hd__inv_1
X_14816_ _04239_ _00222_ _04240_ VSS VSS VDD VDD _04241_ sky130_fd_sc_hd__nand3_1
X_14817_ net388 _04241_ VSS VSS VDD VDD _04242_ sky130_fd_sc_hd__nand2_1
X_14818_ network.in_period\[58\]\[1\] _04242_ VSS VSS VDD
+ VDD _04243_ sky130_fd_sc_hd__nand2_1
X_14819_ _00223_ _04242_ _04243_ VSS VSS VDD VDD _02297_ sky130_fd_sc_hd__o21ai_0
X_14820_ network.neuron_in060.counter\[2\] _00196_ VSS VSS
+ VDD VDD _04244_ sky130_fd_sc_hd__nor2b_1
X_14821_ network.neuron_in060.counter\[3\] _04244_ VSS VSS
+ VDD VDD _04245_ sky130_fd_sc_hd__nand2b_1
X_14822_ net391 _04245_ VSS VSS VDD VDD _04246_ sky130_fd_sc_hd__nand2_1
X_14823_ network.in_period\[60\]\[0\] _04246_ VSS VSS VDD
+ VDD _04247_ sky130_fd_sc_hd__nand2_1
X_14824_ network.neuron_in060.counter\[0\] _04246_ _04247_
+ VSS VSS VDD VDD _02304_ sky130_fd_sc_hd__o21ai_0
X_14825_ network.neuron_in058.counter\[3\] network.in_period\[58\]\[2\]
+ net373 _00222_ VSS VSS VDD VDD _04248_ sky130_fd_sc_hd__o22ai_1
X_14826_ network.neuron_in058.counter\[2\] _00222_ net388
+ VSS VSS VDD VDD _04249_ sky130_fd_sc_hd__nand3_1
X_14827_ network.in_period\[58\]\[2\] net388 _04249_ VSS VSS
+ VDD VDD _04250_ sky130_fd_sc_hd__o21ai_0
X_14828_ _04239_ _04248_ _04250_ VSS VSS VDD VDD _02298_ sky130_fd_sc_hd__a21oi_1
X_14829_ network.neuron_in059.counter\[3\] _00206_ VSS VSS
+ VDD VDD _04251_ sky130_fd_sc_hd__nand2b_1
X_14830_ network.neuron_in059.counter\[2\] VSS VSS VDD VDD
+ _04252_ sky130_fd_sc_hd__inv_1
X_14831_ _04251_ _04252_ VSS VSS VDD VDD _04253_ sky130_fd_sc_hd__nand2b_1
X_14832_ net388 _04253_ VSS VSS VDD VDD _04254_ sky130_fd_sc_hd__nand2_1
X_14833_ network.in_period\[59\]\[1\] _04254_ VSS VSS VDD
+ VDD _04255_ sky130_fd_sc_hd__nand2_1
X_14834_ _00207_ _04254_ _04255_ VSS VSS VDD VDD _02301_ sky130_fd_sc_hd__o21ai_0
X_14835_ network.in_period\[132\]\[1\] _08045_ VSS VSS VDD
+ VDD _04256_ sky130_fd_sc_hd__nand2_1
X_14836_ _00516_ _08045_ _04256_ VSS VSS VDD VDD _02593_ sky130_fd_sc_hd__o21ai_0
X_14837_ network.in_period\[60\]\[1\] _04246_ VSS VSS VDD
+ VDD _04257_ sky130_fd_sc_hd__nand2_1
X_14838_ _00197_ _04246_ _04257_ VSS VSS VDD VDD _02305_ sky130_fd_sc_hd__o21ai_0
X_14839_ network.in_period\[129\]\[0\] _03605_ VSS VSS VDD
+ VDD _04258_ sky130_fd_sc_hd__nand2_1
X_14840_ network.neuron_in129.counter\[0\] _03605_ _04258_
+ VSS VSS VDD VDD _02580_ sky130_fd_sc_hd__o21ai_0
X_14841_ _03997_ net289 VSS VSS VDD VDD _03196_ sky130_fd_sc_hd__nor2_1
X_14842_ net300 net288 VSS VSS VDD VDD _03185_ sky130_fd_sc_hd__nor2_1
X_14843_ _03950_ net299 VSS VSS VDD VDD _03166_ sky130_fd_sc_hd__nor2_1
X_14844_ network.neuron_in094.counter\[1\] VSS VSS VDD VDD
+ _01241_ sky130_fd_sc_hd__inv_1
X_14845_ network.neuron_in058.counter\[0\] VSS VSS VDD VDD
+ _00220_ sky130_fd_sc_hd__inv_1
X_14846_ network.in_period\[58\]\[0\] _04242_ VSS VSS VDD
+ VDD _04259_ sky130_fd_sc_hd__nand2_1
X_14847_ network.neuron_in058.counter\[0\] _04242_ _04259_
+ VSS VSS VDD VDD _02296_ sky130_fd_sc_hd__o21ai_0
X_14848_ _04004_ _04026_ VSS VSS VDD VDD _03145_ sky130_fd_sc_hd__nor2_1
X_14849_ _03991_ _04037_ VSS VSS VDD VDD _03236_ sky130_fd_sc_hd__nor2_1
X_14850_ _04007_ net299 VSS VSS VDD VDD _03280_ sky130_fd_sc_hd__nor2_1
X_14851_ _04019_ net288 VSS VSS VDD VDD _03172_ sky130_fd_sc_hd__nor2_1
X_14852_ _03991_ _04004_ VSS VSS VDD VDD _03234_ sky130_fd_sc_hd__nor2_1
X_14853_ _04026_ _04039_ VSS VSS VDD VDD _03142_ sky130_fd_sc_hd__nor2_1
X_14854_ _03991_ _04039_ VSS VSS VDD VDD _03231_ sky130_fd_sc_hd__nor2_1
X_14855_ _03999_ _04026_ VSS VSS VDD VDD _03141_ sky130_fd_sc_hd__nor2_1
X_14856_ _04015_ _04026_ VSS VSS VDD VDD _03140_ sky130_fd_sc_hd__nor2_1
X_14857_ _03954_ net290 VSS VSS VDD VDD _03223_ sky130_fd_sc_hd__nor2_1
X_14858_ _04017_ _04026_ VSS VSS VDD VDD _03139_ sky130_fd_sc_hd__nor2_1
X_14859_ _04026_ _04030_ VSS VSS VDD VDD _03138_ sky130_fd_sc_hd__nor2_1
X_14860_ _04019_ _04026_ VSS VSS VDD VDD _03137_ sky130_fd_sc_hd__nor2_1
X_14861_ _03945_ _04028_ VSS VSS VDD VDD _03136_ sky130_fd_sc_hd__nor2_1
X_14862_ net301 _04028_ VSS VSS VDD VDD _03135_ sky130_fd_sc_hd__nor2_1
X_14863_ _03954_ _04028_ VSS VSS VDD VDD _03134_ sky130_fd_sc_hd__nor2_1
X_14864_ net290 _04039_ VSS VSS VDD VDD _03214_ sky130_fd_sc_hd__nor2_1
X_14865_ net300 _04028_ VSS VSS VDD VDD _03133_ sky130_fd_sc_hd__nor2_1
X_14866_ _04028_ _04035_ VSS VSS VDD VDD _03131_ sky130_fd_sc_hd__nor2_1
X_14867_ net299 _04028_ VSS VSS VDD VDD _03130_ sky130_fd_sc_hd__nor2_1
X_14868_ net301 net289 VSS VSS VDD VDD _03206_ sky130_fd_sc_hd__nor2_1
X_14869_ _04028_ _04037_ VSS VSS VDD VDD _03129_ sky130_fd_sc_hd__nor2_1
X_14870_ net300 net289 VSS VSS VDD VDD _03204_ sky130_fd_sc_hd__nor2_1
X_14871_ _04004_ _04028_ VSS VSS VDD VDD _03127_ sky130_fd_sc_hd__nor2_1
X_14872_ _03997_ _04028_ VSS VSS VDD VDD _03126_ sky130_fd_sc_hd__nor2_1
X_14873_ _04028_ _04039_ VSS VSS VDD VDD _03125_ sky130_fd_sc_hd__nor2_1
X_14874_ _04030_ net285 VSS VSS VDD VDD _03287_ sky130_fd_sc_hd__nor2_1
X_14875_ _04019_ _04028_ VSS VSS VDD VDD _03119_ sky130_fd_sc_hd__nor2_1
X_14876_ _04019_ net285 VSS VSS VDD VDD _03286_ sky130_fd_sc_hd__nor2_1
X_14877_ net301 net287 VSS VSS VDD VDD _03117_ sky130_fd_sc_hd__nor2_1
X_14878_ net301 _04084_ VSS VSS VDD VDD _03337_ sky130_fd_sc_hd__nor2_1
X_14879_ _03954_ _04084_ VSS VSS VDD VDD _03336_ sky130_fd_sc_hd__nor2_1
X_14880_ network.neuron_out0.ROM0.address\[1\] _08058_ _08062_
+ VSS VSS VDD VDD _01764_ sky130_fd_sc_hd__a21oi_1
X_14881_ _08073_ _01764_ VSS VSS VDD VDD _01763_ sky130_fd_sc_hd__and2_1
X_14882_ net300 _04084_ VSS VSS VDD VDD _03335_ sky130_fd_sc_hd__nor2_1
X_14883_ net299 _04084_ VSS VSS VDD VDD _03333_ sky130_fd_sc_hd__nor2_1
X_14884_ _04037_ _04084_ VSS VSS VDD VDD _03331_ sky130_fd_sc_hd__nor2_1
X_14885_ network.neuron_in059.counter\[3\] network.in_period\[59\]\[2\]
+ _00206_ net373 VSS VSS VDD VDD _04260_ sky130_fd_sc_hd__o22ai_1
X_14886_ network.neuron_in059.counter\[2\] _00206_ net388
+ VSS VSS VDD VDD _04261_ sky130_fd_sc_hd__nand3_1
X_14887_ network.in_period\[59\]\[2\] net388 _04261_ VSS VSS
+ VDD VDD _04262_ sky130_fd_sc_hd__o21ai_0
X_14888_ _04252_ _04260_ _04262_ VSS VSS VDD VDD _02302_ sky130_fd_sc_hd__a21oi_1
X_14889_ network.neuron_in059.counter\[0\] VSS VSS VDD VDD
+ _00204_ sky130_fd_sc_hd__inv_1
X_14890_ network.in_period\[59\]\[0\] _04254_ VSS VSS VDD
+ VDD _04263_ sky130_fd_sc_hd__nand2_1
X_14891_ network.neuron_in059.counter\[0\] _04254_ _04263_
+ VSS VSS VDD VDD _02300_ sky130_fd_sc_hd__o21ai_0
X_14892_ network.neuron_in060.counter\[2\] net391 VSS VSS
+ VDD VDD _04264_ sky130_fd_sc_hd__nand2_1
X_14893_ network.neuron_in060.counter\[3\] network.in_period\[60\]\[2\]
+ _04264_ VSS VSS VDD VDD _04265_ sky130_fd_sc_hd__o21ai_0
X_14894_ _00196_ network.neuron_in060.counter\[2\] net373
+ VSS VSS VDD VDD _04266_ sky130_fd_sc_hd__or3_1
X_14895_ network.in_period\[60\]\[2\] net391 _04266_ VSS VSS
+ VDD VDD _04267_ sky130_fd_sc_hd__o21ai_0
X_14896_ _00196_ _04265_ _04267_ VSS VSS VDD VDD _02306_ sky130_fd_sc_hd__a21oi_1
X_14897_ network.neuron_in062.counter\[2\] _00561_ VSS VSS
+ VDD VDD _04268_ sky130_fd_sc_hd__nor2b_1
X_14898_ network.neuron_in062.counter\[3\] _04268_ VSS VSS
+ VDD VDD _04269_ sky130_fd_sc_hd__nand2b_1
X_14899_ net388 _04269_ VSS VSS VDD VDD _04270_ sky130_fd_sc_hd__nand2_1
X_14900_ network.in_period\[62\]\[1\] _04270_ VSS VSS VDD
+ VDD _04271_ sky130_fd_sc_hd__nand2_1
X_14901_ _00562_ _04270_ _04271_ VSS VSS VDD VDD _02313_ sky130_fd_sc_hd__o21ai_0
X_14902_ network.neuron_in064.counter\[2\] _00188_ VSS VSS
+ VDD VDD _04272_ sky130_fd_sc_hd__nor2b_1
X_14903_ network.neuron_in064.counter\[3\] _04272_ VSS VSS
+ VDD VDD _04273_ sky130_fd_sc_hd__nand2b_1
X_14904_ net395 _04273_ VSS VSS VDD VDD _04274_ sky130_fd_sc_hd__nand2_1
X_14905_ network.in_period\[64\]\[0\] _04274_ VSS VSS VDD
+ VDD _04275_ sky130_fd_sc_hd__nand2_1
X_14906_ network.neuron_in064.counter\[0\] _04274_ _04275_
+ VSS VSS VDD VDD _02320_ sky130_fd_sc_hd__o21ai_0
X_14907_ network.neuron_in062.counter\[2\] VSS VSS VDD VDD
+ _04276_ sky130_fd_sc_hd__inv_1
X_14908_ network.neuron_in062.counter\[3\] network.in_period\[62\]\[2\]
+ net373 _00561_ VSS VSS VDD VDD _04277_ sky130_fd_sc_hd__o22ai_1
X_14909_ network.neuron_in062.counter\[2\] _00561_ net388
+ VSS VSS VDD VDD _04278_ sky130_fd_sc_hd__nand3_1
X_14910_ network.in_period\[62\]\[2\] net388 _04278_ VSS VSS
+ VDD VDD _04279_ sky130_fd_sc_hd__o21ai_0
X_14911_ _04276_ _04277_ _04279_ VSS VSS VDD VDD _02314_ sky130_fd_sc_hd__a21oi_1
X_14912_ network.neuron_in063.counter\[2\] network.neuron_in063.counter\[3\]
+ VSS VSS VDD VDD _04280_ sky130_fd_sc_hd__nor2_1
X_14913_ _00192_ _04280_ VSS VSS VDD VDD _04281_ sky130_fd_sc_hd__nand2_1
X_14914_ net391 _04281_ VSS VSS VDD VDD _04282_ sky130_fd_sc_hd__nand2_1
X_14915_ network.in_period\[63\]\[1\] _04282_ VSS VSS VDD
+ VDD _04283_ sky130_fd_sc_hd__nand2_1
X_14916_ _00193_ _04282_ _04283_ VSS VSS VDD VDD _02317_ sky130_fd_sc_hd__o21ai_0
X_14917_ network.in_period\[64\]\[1\] _04274_ VSS VSS VDD
+ VDD _04284_ sky130_fd_sc_hd__nand2_1
X_14918_ _00189_ _04274_ _04284_ VSS VSS VDD VDD _02321_ sky130_fd_sc_hd__o21ai_0
X_14919_ network.neuron_in061.counter\[2\] _00557_ VSS VSS
+ VDD VDD _04285_ sky130_fd_sc_hd__xnor2_1
X_14920_ network.neuron_in061.counter\[2\] network.neuron_in061.counter\[3\]
+ VSS VSS VDD VDD _04286_ sky130_fd_sc_hd__nor2_1
X_14921_ _00557_ _04286_ VSS VSS VDD VDD _04287_ sky130_fd_sc_hd__nand2_1
X_14922_ net388 _04287_ network.in_period\[61\]\[2\] VSS VSS
+ VDD VDD _04288_ sky130_fd_sc_hd__a21oi_1
X_14923_ net388 _04285_ _04288_ VSS VSS VDD VDD _02310_ sky130_fd_sc_hd__a21oi_1
X_14924_ net300 _04082_ VSS VSS VDD VDD _03097_ sky130_fd_sc_hd__nor2_1
X_14925_ _03954_ _04007_ VSS VSS VDD VDD _03283_ sky130_fd_sc_hd__nor2_1
X_14926_ net300 _04007_ VSS VSS VDD VDD _03282_ sky130_fd_sc_hd__nor2_1
X_14927_ _04007_ _04035_ VSS VSS VDD VDD _03281_ sky130_fd_sc_hd__nor2_1
X_14928_ _04007_ _04037_ VSS VSS VDD VDD _03279_ sky130_fd_sc_hd__nor2_1
X_14929_ net326 _04032_ VSS VSS VDD VDD _04289_ sky130_fd_sc_hd__nand2_1
Xplace428 loaded\[6\] VSS VSS VDD VDD net427 sky130_fd_sc_hd__buf_4
X_14931_ _03945_ net284 VSS VSS VDD VDD _03320_ sky130_fd_sc_hd__nor2_1
X_14932_ network.neuron_in063.counter\[2\] net391 VSS VSS
+ VDD VDD _04291_ sky130_fd_sc_hd__nand2_1
X_14933_ network.neuron_in063.counter\[3\] network.in_period\[63\]\[2\]
+ _04291_ VSS VSS VDD VDD _04292_ sky130_fd_sc_hd__o21ai_0
Xplace427 loaded\[7\] VSS VSS VDD VDD net426 sky130_fd_sc_hd__buf_4
X_14935_ _00192_ network.neuron_in063.counter\[2\] net373
+ VSS VSS VDD VDD _04294_ sky130_fd_sc_hd__or3_1
X_14936_ network.in_period\[63\]\[2\] net391 _04294_ VSS VSS
+ VDD VDD _04295_ sky130_fd_sc_hd__o21ai_0
X_14937_ _00192_ _04292_ _04295_ VSS VSS VDD VDD _02318_ sky130_fd_sc_hd__a21oi_1
X_14938_ _03994_ _04084_ VSS VSS VDD VDD _03330_ sky130_fd_sc_hd__nor2_1
X_14939_ _04004_ _04084_ VSS VSS VDD VDD _03329_ sky130_fd_sc_hd__nor2_1
X_14940_ _03997_ _04084_ VSS VSS VDD VDD _03328_ sky130_fd_sc_hd__nor2_1
X_14941_ _03999_ _04084_ VSS VSS VDD VDD _03326_ sky130_fd_sc_hd__nor2_1
X_14942_ _04015_ _04084_ VSS VSS VDD VDD _03325_ sky130_fd_sc_hd__nor2_1
X_14943_ _04017_ _04084_ VSS VSS VDD VDD _03324_ sky130_fd_sc_hd__nor2_1
X_14944_ _04030_ _04084_ VSS VSS VDD VDD _03323_ sky130_fd_sc_hd__nor2_1
X_14945_ _04019_ _04084_ VSS VSS VDD VDD _03322_ sky130_fd_sc_hd__nor2_1
X_14946_ _08052_ _08059_ VSS VSS VDD VDD _01765_ sky130_fd_sc_hd__nor2_1
X_14947_ net301 net284 VSS VSS VDD VDD _03319_ sky130_fd_sc_hd__nor2_1
X_14948_ _03954_ net284 VSS VSS VDD VDD _03318_ sky130_fd_sc_hd__nor2_1
X_14949_ network.neuron_in064.counter\[2\] net396 VSS VSS
+ VDD VDD _04296_ sky130_fd_sc_hd__nand2_1
X_14950_ network.neuron_in064.counter\[3\] network.in_period\[64\]\[2\]
+ _04296_ VSS VSS VDD VDD _04297_ sky130_fd_sc_hd__o21ai_0
X_14951_ _00188_ network.neuron_in064.counter\[2\] net379
+ VSS VSS VDD VDD _04298_ sky130_fd_sc_hd__or3_1
X_14952_ network.in_period\[64\]\[2\] net396 _04298_ VSS VSS
+ VDD VDD _04299_ sky130_fd_sc_hd__o21ai_0
X_14953_ _00188_ _04297_ _04299_ VSS VSS VDD VDD _02322_ sky130_fd_sc_hd__a21oi_1
X_14954_ net388 _04287_ VSS VSS VDD VDD _04300_ sky130_fd_sc_hd__nand2_1
X_14955_ network.in_period\[61\]\[1\] _04300_ VSS VSS VDD
+ VDD _04301_ sky130_fd_sc_hd__nand2_1
X_14956_ _00558_ _04300_ _04301_ VSS VSS VDD VDD _02309_ sky130_fd_sc_hd__o21ai_0
X_14957_ network.in_period\[61\]\[0\] _04300_ VSS VSS VDD
+ VDD _04302_ sky130_fd_sc_hd__nand2_1
X_14958_ network.neuron_in061.counter\[0\] _04300_ _04302_
+ VSS VSS VDD VDD _02308_ sky130_fd_sc_hd__o21ai_0
X_14959_ network.in_period\[62\]\[0\] _04270_ VSS VSS VDD
+ VDD _04303_ sky130_fd_sc_hd__nand2_1
X_14960_ network.neuron_in062.counter\[0\] _04270_ _04303_
+ VSS VSS VDD VDD _02312_ sky130_fd_sc_hd__o21ai_0
X_14961_ network.in_period\[63\]\[0\] _04282_ VSS VSS VDD
+ VDD _04304_ sky130_fd_sc_hd__nand2_1
X_14962_ network.neuron_in063.counter\[0\] _04282_ _04304_
+ VSS VSS VDD VDD _02316_ sky130_fd_sc_hd__o21ai_0
X_14963_ _03945_ _04007_ VSS VSS VDD VDD _03285_ sky130_fd_sc_hd__nor2_1
X_14964_ network.neuron_in067.counter\[3\] _00157_ VSS VSS
+ VDD VDD _04305_ sky130_fd_sc_hd__nand2b_1
X_14965_ network.neuron_in067.counter\[2\] VSS VSS VDD VDD
+ _04306_ sky130_fd_sc_hd__inv_1
X_14966_ _04305_ _04306_ VSS VSS VDD VDD _04307_ sky130_fd_sc_hd__nand2b_1
X_14967_ net398 _04307_ VSS VSS VDD VDD _04308_ sky130_fd_sc_hd__nand2_1
X_14968_ network.in_period\[67\]\[0\] _04308_ VSS VSS VDD
+ VDD _04309_ sky130_fd_sc_hd__nand2_1
X_14969_ network.neuron_in067.counter\[0\] _04308_ _04309_
+ VSS VSS VDD VDD _02332_ sky130_fd_sc_hd__o21ai_0
X_14970_ network.neuron_in065.counter\[2\] _00174_ VSS VSS
+ VDD VDD _04310_ sky130_fd_sc_hd__nor2b_1
X_14971_ network.neuron_in065.counter\[3\] _04310_ VSS VSS
+ VDD VDD _04311_ sky130_fd_sc_hd__nand2b_1
X_14972_ net395 _04311_ VSS VSS VDD VDD _04312_ sky130_fd_sc_hd__nand2_1
X_14973_ network.in_period\[65\]\[1\] _04312_ VSS VSS VDD
+ VDD _04313_ sky130_fd_sc_hd__nand2_1
X_14974_ _00175_ _04312_ _04313_ VSS VSS VDD VDD _02325_ sky130_fd_sc_hd__o21ai_0
X_14975_ network.neuron_in101.counter\[0\] VSS VSS VDD VDD
+ _00834_ sky130_fd_sc_hd__inv_1
X_14976_ network.neuron_in066.counter\[2\] network.neuron_in066.counter\[3\]
+ _00170_ VSS VSS VDD VDD _04314_ sky130_fd_sc_hd__or3b_2
X_14977_ net398 _04314_ VSS VSS VDD VDD _04315_ sky130_fd_sc_hd__nand2_1
X_14978_ network.in_period\[66\]\[1\] _04315_ VSS VSS VDD
+ VDD _04316_ sky130_fd_sc_hd__nand2_1
X_14979_ _00171_ _04315_ _04316_ VSS VSS VDD VDD _02329_ sky130_fd_sc_hd__o21ai_0
X_14980_ _04035_ net285 VSS VSS VDD VDD _03298_ sky130_fd_sc_hd__nor2_1
X_14981_ net299 net285 VSS VSS VDD VDD _03297_ sky130_fd_sc_hd__nor2_1
X_14982_ _04015_ net288 VSS VSS VDD VDD _03175_ sky130_fd_sc_hd__nor2_1
X_14983_ _04004_ net285 VSS VSS VDD VDD _03294_ sky130_fd_sc_hd__nor2_1
X_14984_ _03997_ net285 VSS VSS VDD VDD _03293_ sky130_fd_sc_hd__nor2_1
X_14985_ _04015_ net285 VSS VSS VDD VDD _03290_ sky130_fd_sc_hd__nor2_1
X_14986_ _04017_ net285 VSS VSS VDD VDD _03289_ sky130_fd_sc_hd__nor2_1
X_14987_ network.in_period\[67\]\[1\] _04308_ VSS VSS VDD
+ VDD _04317_ sky130_fd_sc_hd__nand2_1
X_14988_ _00158_ _04308_ _04317_ VSS VSS VDD VDD _02333_ sky130_fd_sc_hd__o21ai_0
X_14989_ _03994_ _04007_ VSS VSS VDD VDD _03278_ sky130_fd_sc_hd__nor2_1
X_14990_ _03994_ _04120_ VSS VSS VDD VDD _03254_ sky130_fd_sc_hd__nor2_1
X_14991_ _04039_ _04120_ VSS VSS VDD VDD _03221_ sky130_fd_sc_hd__nor2_1
X_14992_ network.neuron_hid0.ROM0.address\[0\] net356 net353
+ VSS VSS VDD VDD _04318_ sky130_fd_sc_hd__a21oi_1
X_14993_ _07046_ _04318_ _04223_ VSS VSS VDD VDD _04319_ sky130_fd_sc_hd__o21bai_1
X_14994_ net343 _07376_ net321 VSS VSS VDD VDD _04320_ sky130_fd_sc_hd__o21ai_0
X_14995_ net366 net340 net349 _04320_ net420 VSS VSS VDD VDD
+ _04321_ sky130_fd_sc_hd__a311oi_1
X_14996_ _08158_ _07162_ _07208_ net414 net365 VSS VSS VDD
+ VDD _04322_ sky130_fd_sc_hd__a221oi_1
X_14997_ _04321_ _04322_ _07312_ VSS VSS VDD VDD _04323_ sky130_fd_sc_hd__o21ai_0
X_14998_ net358 net363 net346 VSS VSS VDD VDD _04324_ sky130_fd_sc_hd__o21ai_0
X_14999_ net416 _04324_ _07245_ VSS VSS VDD VDD _04325_ sky130_fd_sc_hd__a21oi_1
X_15000_ _07134_ _07366_ net416 VSS VSS VDD VDD _04326_ sky130_fd_sc_hd__a21o_1
X_15001_ net411 net313 VSS VSS VDD VDD _04327_ sky130_fd_sc_hd__nor2_1
X_15002_ net324 net313 _04327_ net408 VSS VSS VDD VDD _04328_
+ sky130_fd_sc_hd__a211oi_1
X_15003_ net366 net342 VSS VSS VDD VDD _04329_ sky130_fd_sc_hd__nor2_1
X_15004_ net322 _04329_ net417 VSS VSS VDD VDD _04330_ sky130_fd_sc_hd__o21ai_0
X_15005_ net420 _04325_ _04326_ _04328_ _04330_ VSS VSS VDD
+ VDD _04331_ sky130_fd_sc_hd__o2111ai_1
X_15006_ net419 _07720_ _07659_ net334 _07613_ VSS VSS VDD
+ VDD _04332_ sky130_fd_sc_hd__a32oi_1
X_15007_ net425 _07241_ VSS VSS VDD VDD _04333_ sky130_fd_sc_hd__nand2_1
X_15008_ net305 _04332_ _04333_ _03823_ VSS VSS VDD VDD _04334_
+ sky130_fd_sc_hd__a22oi_1
X_15009_ _07313_ net332 net325 VSS VSS VDD VDD _04335_ sky130_fd_sc_hd__a21oi_1
X_15010_ net325 _03817_ net422 VSS VSS VDD VDD _04336_ sky130_fd_sc_hd__o21ai_0
X_15011_ net415 _04335_ _04336_ VSS VSS VDD VDD _04337_ sky130_fd_sc_hd__o21ai_0
X_15012_ _07215_ _07754_ VSS VSS VDD VDD _04338_ sky130_fd_sc_hd__nor2_1
X_15013_ net419 _04338_ _07366_ VSS VSS VDD VDD _04339_ sky130_fd_sc_hd__o21ai_0
X_15014_ _04337_ _04339_ _07580_ VSS VSS VDD VDD _04340_ sky130_fd_sc_hd__o21ai_0
X_15015_ _04323_ _04331_ _04334_ _04340_ network.neuron_hid0.ROM0.address\[7\]
+ VSS VSS VDD VDD _04341_ sky130_fd_sc_hd__a41oi_1
X_15016_ network.neuron_hid0.ROM0.address\[7\] _07308_ _04319_
+ _04341_ VSS VSS VDD VDD _04342_ sky130_fd_sc_hd__a31oi_1
X_15017_ net307 _07744_ net313 VSS VSS VDD VDD _04343_ sky130_fd_sc_hd__nand3_1
X_15018_ _07042_ _04342_ _04343_ VSS VSS VDD VDD _01766_ sky130_fd_sc_hd__o21ai_0
X_15019_ _04030_ _04120_ VSS VSS VDD VDD _03176_ sky130_fd_sc_hd__nor2_1
X_15020_ network.neuron_in065.counter\[2\] VSS VSS VDD VDD
+ _04344_ sky130_fd_sc_hd__inv_1
X_15021_ network.neuron_in065.counter\[3\] network.in_period\[65\]\[2\]
+ net378 _00174_ VSS VSS VDD VDD _04345_ sky130_fd_sc_hd__o22ai_1
X_15022_ network.neuron_in065.counter\[2\] _00174_ net395
+ VSS VSS VDD VDD _04346_ sky130_fd_sc_hd__nand3_1
X_15023_ network.in_period\[65\]\[2\] net395 _04346_ VSS VSS
+ VDD VDD _04347_ sky130_fd_sc_hd__o21ai_0
X_15024_ _04344_ _04345_ _04347_ VSS VSS VDD VDD _02326_ sky130_fd_sc_hd__a21oi_1
X_15025_ network.in_period\[65\]\[0\] _04312_ VSS VSS VDD
+ VDD _04348_ sky130_fd_sc_hd__nand2_1
X_15026_ network.neuron_in065.counter\[0\] _04312_ _04348_
+ VSS VSS VDD VDD _02324_ sky130_fd_sc_hd__o21ai_0
X_15027_ net300 net286 VSS VSS VDD VDD _03121_ sky130_fd_sc_hd__nor2_1
X_15028_ _04035_ net286 VSS VSS VDD VDD _03110_ sky130_fd_sc_hd__nor2_1
X_15029_ network.neuron_in066.counter\[2\] _00170_ VSS VSS
+ VDD VDD _04349_ sky130_fd_sc_hd__xnor2_1
X_15030_ net398 _04314_ network.in_period\[66\]\[2\] VSS VSS
+ VDD VDD _04350_ sky130_fd_sc_hd__a21oi_1
X_15031_ net398 _04349_ _04350_ VSS VSS VDD VDD _02330_ sky130_fd_sc_hd__a21oi_1
X_15032_ net299 net286 VSS VSS VDD VDD _03099_ sky130_fd_sc_hd__nor2_1
X_15033_ network.in_period\[66\]\[0\] _04315_ VSS VSS VDD
+ VDD _04351_ sky130_fd_sc_hd__nand2_1
X_15034_ network.neuron_in066.counter\[0\] _04315_ _04351_
+ VSS VSS VDD VDD _02328_ sky130_fd_sc_hd__o21ai_0
X_15035_ _04004_ net286 VSS VSS VDD VDD _03321_ sky130_fd_sc_hd__nor2_1
X_15036_ _04039_ net286 VSS VSS VDD VDD _03299_ sky130_fd_sc_hd__nor2_1
X_15037_ _04015_ net286 VSS VSS VDD VDD _03277_ sky130_fd_sc_hd__nor2_1
X_15038_ network.neuron_in067.counter\[3\] network.in_period\[67\]\[2\]
+ net378 _00157_ VSS VSS VDD VDD _04352_ sky130_fd_sc_hd__o22ai_1
X_15039_ network.neuron_in067.counter\[2\] _00157_ net398
+ VSS VSS VDD VDD _04353_ sky130_fd_sc_hd__nand3_1
X_15040_ network.in_period\[67\]\[2\] net398 _04353_ VSS VSS
+ VDD VDD _04354_ sky130_fd_sc_hd__o21ai_0
X_15041_ _04306_ _04352_ _04354_ VSS VSS VDD VDD _02334_ sky130_fd_sc_hd__a21oi_1
X_15042_ _04017_ net286 VSS VSS VDD VDD _03266_ sky130_fd_sc_hd__nor2_1
X_15043_ net300 net284 VSS VSS VDD VDD _03317_ sky130_fd_sc_hd__nor2_1
X_15044_ _04035_ net284 VSS VSS VDD VDD _03316_ sky130_fd_sc_hd__nor2_1
X_15045_ net299 net284 VSS VSS VDD VDD _03315_ sky130_fd_sc_hd__nor2_1
X_15046_ _04037_ net284 VSS VSS VDD VDD _03314_ sky130_fd_sc_hd__nor2_1
X_15047_ _03994_ net284 VSS VSS VDD VDD _03313_ sky130_fd_sc_hd__nor2_1
X_15048_ _08062_ _08071_ VSS VSS VDD VDD _01767_ sky130_fd_sc_hd__nor2_1
X_15049_ _04004_ net284 VSS VSS VDD VDD _03312_ sky130_fd_sc_hd__nor2_1
X_15050_ _03997_ net284 VSS VSS VDD VDD _03311_ sky130_fd_sc_hd__nor2_1
X_15051_ _04039_ net284 VSS VSS VDD VDD _03309_ sky130_fd_sc_hd__nor2_1
X_15052_ _03999_ net284 VSS VSS VDD VDD _03308_ sky130_fd_sc_hd__nor2_1
X_15053_ _04015_ net284 VSS VSS VDD VDD _03307_ sky130_fd_sc_hd__nor2_1
X_15054_ _04017_ net284 VSS VSS VDD VDD _03306_ sky130_fd_sc_hd__nor2_1
X_15055_ _04030_ net284 VSS VSS VDD VDD _03305_ sky130_fd_sc_hd__nor2_1
X_15056_ _08052_ _08060_ VSS VSS VDD VDD _01768_ sky130_fd_sc_hd__nor2_1
X_15057_ _04019_ net284 VSS VSS VDD VDD _03304_ sky130_fd_sc_hd__nor2_1
X_15058_ _03945_ net285 VSS VSS VDD VDD _03303_ sky130_fd_sc_hd__nor2_1
X_15059_ net301 net285 VSS VSS VDD VDD _03302_ sky130_fd_sc_hd__nor2_1
X_15060_ _03954_ net285 VSS VSS VDD VDD _03301_ sky130_fd_sc_hd__nor2_1
X_15061_ network.neuron_in070.counter\[2\] VSS VSS VDD VDD
+ _04355_ sky130_fd_sc_hd__inv_1
X_15062_ network.neuron_in070.counter\[3\] network.in_period\[70\]\[2\]
+ net378 _00139_ VSS VSS VDD VDD _04356_ sky130_fd_sc_hd__o22ai_1
X_15063_ network.neuron_in070.counter\[2\] _00139_ net398
+ VSS VSS VDD VDD _04357_ sky130_fd_sc_hd__nand3_1
X_15064_ network.in_period\[70\]\[2\] net398 _04357_ VSS VSS
+ VDD VDD _04358_ sky130_fd_sc_hd__o21ai_0
X_15065_ _04355_ _04356_ _04358_ VSS VSS VDD VDD _02346_ sky130_fd_sc_hd__a21oi_1
X_15066_ network.neuron_in130.counter\[2\] _00502_ VSS VSS
+ VDD VDD _04359_ sky130_fd_sc_hd__xnor2_1
X_15067_ network.neuron_in130.counter\[2\] network.neuron_in130.counter\[3\]
+ VSS VSS VDD VDD _04360_ sky130_fd_sc_hd__nor2_1
X_15068_ _00502_ _04360_ VSS VSS VDD VDD _04361_ sky130_fd_sc_hd__nand2_1
X_15069_ net393 _04361_ network.in_period\[130\]\[2\] VSS
+ VSS VDD VDD _04362_ sky130_fd_sc_hd__a21oi_1
X_15070_ net386 _04359_ _04362_ VSS VSS VDD VDD _02586_ sky130_fd_sc_hd__a21oi_1
X_15071_ network.neuron_in068.counter\[2\] _00151_ VSS VSS
+ VDD VDD _04363_ sky130_fd_sc_hd__nor2b_1
X_15072_ network.neuron_in068.counter\[3\] _04363_ VSS VSS
+ VDD VDD _04364_ sky130_fd_sc_hd__nand2b_1
X_15073_ net398 _04364_ VSS VSS VDD VDD _04365_ sky130_fd_sc_hd__nand2_1
X_15074_ network.in_period\[68\]\[0\] _04365_ VSS VSS VDD
+ VDD _04366_ sky130_fd_sc_hd__nand2_1
X_15075_ network.neuron_in068.counter\[0\] _04365_ _04366_
+ VSS VSS VDD VDD _02336_ sky130_fd_sc_hd__o21ai_0
X_15076_ network.neuron_in069.counter\[2\] network.neuron_in069.counter\[3\]
+ _00145_ VSS VSS VDD VDD _04367_ sky130_fd_sc_hd__or3b_2
X_15077_ net395 _04367_ VSS VSS VDD VDD _04368_ sky130_fd_sc_hd__nand2_1
X_15078_ network.in_period\[69\]\[0\] _04368_ VSS VSS VDD
+ VDD _04369_ sky130_fd_sc_hd__nand2_1
X_15079_ network.neuron_in069.counter\[0\] _04368_ _04369_
+ VSS VSS VDD VDD _02340_ sky130_fd_sc_hd__o21ai_0
X_15080_ network.neuron_in068.counter\[2\] VSS VSS VDD VDD
+ _04370_ sky130_fd_sc_hd__inv_1
X_15081_ network.neuron_in068.counter\[3\] network.in_period\[68\]\[2\]
+ net378 _00151_ VSS VSS VDD VDD _04371_ sky130_fd_sc_hd__o22ai_1
X_15082_ network.neuron_in068.counter\[2\] _00151_ net398
+ VSS VSS VDD VDD _04372_ sky130_fd_sc_hd__nand3_1
X_15083_ network.in_period\[68\]\[2\] net398 _04372_ VSS VSS
+ VDD VDD _04373_ sky130_fd_sc_hd__o21ai_0
X_15084_ _04370_ _04371_ _04373_ VSS VSS VDD VDD _02338_ sky130_fd_sc_hd__a21oi_1
X_15085_ network.in_period\[68\]\[1\] _04365_ VSS VSS VDD
+ VDD _04374_ sky130_fd_sc_hd__nand2_1
X_15086_ _00152_ _04365_ _04374_ VSS VSS VDD VDD _02337_ sky130_fd_sc_hd__o21ai_0
X_15087_ network.neuron_in069.counter\[2\] _00145_ VSS VSS
+ VDD VDD _04375_ sky130_fd_sc_hd__xnor2_1
Xplace442 net443 VSS VSS VDD VDD net441 sky130_fd_sc_hd__buf_4
X_15089_ net395 _04367_ network.in_period\[69\]\[2\] VSS VSS
+ VDD VDD _04377_ sky130_fd_sc_hd__a21oi_1
X_15090_ net395 _04375_ _04377_ VSS VSS VDD VDD _02342_ sky130_fd_sc_hd__a21oi_1
X_15091_ network.in_period\[69\]\[1\] _04368_ VSS VSS VDD
+ VDD _04378_ sky130_fd_sc_hd__nand2_1
X_15092_ _00146_ _04368_ _04378_ VSS VSS VDD VDD _02341_ sky130_fd_sc_hd__o21ai_0
Xplace425 net425 VSS VSS VDD VDD net424 sky130_fd_sc_hd__buf_4
X_15094_ network.neuron_in070.counter\[2\] _00139_ VSS VSS
+ VDD VDD _04380_ sky130_fd_sc_hd__nor2b_1
X_15095_ network.neuron_in070.counter\[3\] _04380_ VSS VSS
+ VDD VDD _04381_ sky130_fd_sc_hd__nand2b_1
X_15096_ net398 _04381_ VSS VSS VDD VDD _04382_ sky130_fd_sc_hd__nand2_1
X_15097_ network.in_period\[70\]\[1\] _04382_ VSS VSS VDD
+ VDD _04383_ sky130_fd_sc_hd__nand2_1
X_15098_ _00140_ _04382_ _04383_ VSS VSS VDD VDD _02345_ sky130_fd_sc_hd__o21ai_0
X_15099_ network.in_period\[70\]\[0\] _04382_ VSS VSS VDD
+ VDD _04384_ sky130_fd_sc_hd__nand2_1
X_15100_ network.neuron_in070.counter\[0\] _04382_ _04384_
+ VSS VSS VDD VDD _02344_ sky130_fd_sc_hd__o21ai_0
X_15101_ network.neuron_in074.counter\[2\] _00111_ VSS VSS
+ VDD VDD _04385_ sky130_fd_sc_hd__xnor2_1
X_15102_ network.neuron_in074.counter\[2\] network.neuron_in074.counter\[3\]
+ VSS VSS VDD VDD _04386_ sky130_fd_sc_hd__nor2_1
X_15103_ _00111_ _04386_ VSS VSS VDD VDD _04387_ sky130_fd_sc_hd__nand2_1
X_15104_ net398 _04387_ network.in_period\[74\]\[2\] VSS VSS
+ VDD VDD _04388_ sky130_fd_sc_hd__a21oi_1
X_15105_ net398 _04385_ _04388_ VSS VSS VDD VDD _02362_ sky130_fd_sc_hd__a21oi_1
X_15106_ network.neuron_hid6.IF0.ref_counter\[1\] VSS VSS
+ VDD VDD _01156_ sky130_fd_sc_hd__inv_1
X_15107_ net386 _04361_ VSS VSS VDD VDD _04389_ sky130_fd_sc_hd__nand2_1
X_15108_ network.in_period\[130\]\[1\] _04389_ VSS VSS VDD
+ VDD _04390_ sky130_fd_sc_hd__nand2_1
X_15109_ _00503_ _04389_ _04390_ VSS VSS VDD VDD _02585_ sky130_fd_sc_hd__o21ai_0
X_15110_ network.in_period\[130\]\[0\] _04389_ VSS VSS VDD
+ VDD _04391_ sky130_fd_sc_hd__nand2_1
X_15111_ network.neuron_in130.counter\[0\] _04389_ _04391_
+ VSS VSS VDD VDD _02584_ sky130_fd_sc_hd__o21ai_0
X_15112_ net420 _07357_ _07612_ _07645_ VSS VSS VDD VDD _04392_
+ sky130_fd_sc_hd__o211ai_1
X_15113_ net423 net340 _07904_ VSS VSS VDD VDD _04393_ sky130_fd_sc_hd__a21oi_1
X_15114_ net360 _07614_ _07298_ net421 VSS VSS VDD VDD _04394_
+ sky130_fd_sc_hd__o22ai_1
X_15115_ _07616_ _04394_ net408 VSS VSS VDD VDD _04395_ sky130_fd_sc_hd__o21ai_0
X_15116_ _07800_ _04393_ _04395_ VSS VSS VDD VDD _04396_ sky130_fd_sc_hd__a21oi_1
X_15117_ net352 net345 _03830_ net417 VSS VSS VDD VDD _04397_
+ sky130_fd_sc_hd__o22ai_1
X_15118_ _07632_ _04397_ VSS VSS VDD VDD _04398_ sky130_fd_sc_hd__nand2_1
X_15119_ net414 net420 net417 net358 VSS VSS VDD VDD _04399_
+ sky130_fd_sc_hd__a31oi_1
X_15120_ net415 _07665_ _07710_ VSS VSS VDD VDD _04400_ sky130_fd_sc_hd__o21ai_0
X_15121_ net415 net359 _07329_ VSS VSS VDD VDD _04401_ sky130_fd_sc_hd__nand3_1
X_15122_ net419 _07714_ net418 VSS VSS VDD VDD _04402_ sky130_fd_sc_hd__o21ai_0
X_15123_ _07365_ _04401_ _04402_ _07186_ VSS VSS VDD VDD _04403_
+ sky130_fd_sc_hd__a31oi_1
X_15124_ _07186_ _04400_ _04403_ VSS VSS VDD VDD _04404_ sky130_fd_sc_hd__a21oi_1
X_15125_ net420 net357 _07197_ net361 VSS VSS VDD VDD _04405_
+ sky130_fd_sc_hd__a211oi_1
X_15126_ net359 net347 _07307_ VSS VSS VDD VDD _04406_ sky130_fd_sc_hd__a21oi_1
X_15127_ _07366_ _07647_ _04406_ net409 VSS VSS VDD VDD _04407_
+ sky130_fd_sc_hd__a31oi_1
X_15128_ _07805_ _04405_ _04407_ VSS VSS VDD VDD _04408_ sky130_fd_sc_hd__o21ai_0
X_15129_ _04399_ _04404_ _04408_ VSS VSS VDD VDD _04409_ sky130_fd_sc_hd__a21oi_1
X_15130_ _04392_ _04396_ _04398_ _04409_ network.neuron_hid0.ROM0.address\[7\]
+ VSS VSS VDD VDD _04410_ sky130_fd_sc_hd__a311o_1
X_15131_ net421 net354 net364 VSS VSS VDD VDD _04411_ sky130_fd_sc_hd__a21oi_1
X_15132_ net425 _04411_ _07231_ VSS VSS VDD VDD _04412_ sky130_fd_sc_hd__o21ai_0
X_15133_ net364 net320 _04412_ net366 VSS VSS VDD VDD _04413_
+ sky130_fd_sc_hd__a22o_1
X_15134_ network.neuron_hid0.ROM0.address\[7\] net344 _04413_
+ VSS VSS VDD VDD _04414_ sky130_fd_sc_hd__nand3_1
X_15135_ _04410_ _04414_ _07042_ VSS VSS VDD VDD _01769_ sky130_fd_sc_hd__a21oi_1
X_15136_ network.neuron_in097.counter\[3\] _01215_ VSS VSS
+ VDD VDD _04415_ sky130_fd_sc_hd__nand2b_1
X_15137_ network.neuron_in097.counter\[2\] VSS VSS VDD VDD
+ _04416_ sky130_fd_sc_hd__inv_1
X_15138_ _04415_ _04416_ VSS VSS VDD VDD _04417_ sky130_fd_sc_hd__nand2b_1
X_15139_ network.in_spk01_06 _09303_ VSS VSS VDD VDD _04418_
+ sky130_fd_sc_hd__nand2_1
Xplace426 network.neuron_hid0.ROM0.address\[0\] VSS VSS VDD
+ VDD net425 sky130_fd_sc_hd__buf_4
X_15141_ _04417_ _04418_ net372 VSS VSS VDD VDD _01770_ sky130_fd_sc_hd__a21oi_1
X_15142_ network.neuron_in096.counter\[3\] _01211_ VSS VSS
+ VDD VDD _04420_ sky130_fd_sc_hd__nand2b_1
X_15143_ network.neuron_in096.counter\[2\] VSS VSS VDD VDD
+ _04421_ sky130_fd_sc_hd__inv_1
X_15144_ _04420_ _04421_ VSS VSS VDD VDD _04422_ sky130_fd_sc_hd__nand2b_1
X_15145_ network.in_spk00_06 _09013_ VSS VSS VDD VDD _04423_
+ sky130_fd_sc_hd__nand2_1
X_15146_ _04422_ _04423_ net372 VSS VSS VDD VDD _01771_ sky130_fd_sc_hd__a21oi_1
X_15147_ network.neuron_in095.counter\[2\] network.neuron_in095.counter\[3\]
+ VSS VSS VDD VDD _04424_ sky130_fd_sc_hd__nor2_1
X_15148_ _01247_ _04424_ VSS VSS VDD VDD _04425_ sky130_fd_sc_hd__nand2_1
X_15149_ _08969_ _09270_ VSS VSS VDD VDD _04426_ sky130_fd_sc_hd__nand2b_1
X_15150_ network.in_spk12_05 network.in_spk13_05 network.in_spk14_05
+ _04426_ network.in_spk15_05 VSS VSS VDD VDD _04427_ sky130_fd_sc_hd__o41ai_1
X_15151_ _04425_ _04427_ net371 VSS VSS VDD VDD _01772_ sky130_fd_sc_hd__a21oi_1
X_15152_ network.neuron_in094.counter\[2\] network.neuron_in094.counter\[3\]
+ VSS VSS VDD VDD _04428_ sky130_fd_sc_hd__nor2_1
X_15153_ _01242_ _04428_ VSS VSS VDD VDD _04429_ sky130_fd_sc_hd__nand2_1
X_15154_ network.in_spk12_05 network.in_spk13_05 _04426_ network.in_spk14_05
+ VSS VSS VDD VDD _04430_ sky130_fd_sc_hd__o31ai_1
X_15155_ _04429_ _04430_ net371 VSS VSS VDD VDD _01773_ sky130_fd_sc_hd__a21oi_1
X_15156_ network.neuron_in093.counter\[2\] network.neuron_in093.counter\[3\]
+ VSS VSS VDD VDD _04431_ sky130_fd_sc_hd__nor2_1
X_15157_ _01238_ _04431_ VSS VSS VDD VDD _04432_ sky130_fd_sc_hd__nand2_1
X_15158_ network.in_spk12_05 _04426_ network.in_spk13_05 VSS
+ VSS VDD VDD _04433_ sky130_fd_sc_hd__o21ai_0
X_15159_ _04432_ _04433_ net371 VSS VSS VDD VDD _01774_ sky130_fd_sc_hd__a21oi_1
X_15160_ network.neuron_in092.counter\[2\] _01234_ VSS VSS
+ VDD VDD _04434_ sky130_fd_sc_hd__nor2b_1
X_15161_ network.neuron_in092.counter\[3\] _04434_ VSS VSS
+ VDD VDD _04435_ sky130_fd_sc_hd__nand2b_1
X_15162_ network.in_spk12_05 _04426_ VSS VSS VDD VDD _04436_
+ sky130_fd_sc_hd__nand2_1
X_15163_ _04435_ _04436_ net371 VSS VSS VDD VDD _01775_ sky130_fd_sc_hd__a21oi_1
X_15164_ network.neuron_in091.counter\[2\] network.neuron_in091.counter\[3\]
+ VSS VSS VDD VDD _04437_ sky130_fd_sc_hd__nor2_1
X_15165_ _00131_ _04437_ VSS VSS VDD VDD _04438_ sky130_fd_sc_hd__nand2_1
X_15166_ _08969_ _09017_ VSS VSS VDD VDD _04439_ sky130_fd_sc_hd__nor2_1
X_15167_ _09273_ _04439_ VSS VSS VDD VDD _04440_ sky130_fd_sc_hd__nand2_1
X_15168_ network.in_spk11_05 _04440_ VSS VSS VDD VDD _04441_
+ sky130_fd_sc_hd__nand2_1
X_15169_ _04438_ _04441_ net371 VSS VSS VDD VDD _01776_ sky130_fd_sc_hd__a21oi_1
X_15170_ network.neuron_in090.counter\[2\] network.neuron_in090.counter\[3\]
+ VSS VSS VDD VDD _04442_ sky130_fd_sc_hd__nor2_1
X_15171_ _00573_ _04442_ VSS VSS VDD VDD _04443_ sky130_fd_sc_hd__nand2_1
X_15172_ _09281_ _04439_ _09283_ VSS VSS VDD VDD _04444_ sky130_fd_sc_hd__a21o_1
X_15173_ _04443_ _04444_ net371 VSS VSS VDD VDD _01777_ sky130_fd_sc_hd__a21oi_1
X_15174_ network.neuron_in089.counter\[2\] network.neuron_in089.counter\[3\]
+ VSS VSS VDD VDD _04445_ sky130_fd_sc_hd__nor2_1
X_15175_ _01223_ _04445_ VSS VSS VDD VDD _04446_ sky130_fd_sc_hd__nand2_1
X_15176_ network.in_spk08_05 _09018_ network.in_spk09_05 VSS
+ VSS VDD VDD _04447_ sky130_fd_sc_hd__o21ai_0
X_15177_ _04446_ _04447_ net371 VSS VSS VDD VDD _01778_ sky130_fd_sc_hd__a21oi_1
X_15178_ network.neuron_in088.counter\[2\] _00036_ VSS VSS
+ VDD VDD _04448_ sky130_fd_sc_hd__nor2b_1
X_15179_ network.neuron_in088.counter\[3\] _04448_ VSS VSS
+ VDD VDD _04449_ sky130_fd_sc_hd__nand2b_1
X_15180_ network.in_spk08_05 _09018_ VSS VSS VDD VDD _04450_
+ sky130_fd_sc_hd__nand2_1
X_15181_ _04449_ _04450_ net371 VSS VSS VDD VDD _01779_ sky130_fd_sc_hd__a21oi_1
X_15182_ network.neuron_in087.counter\[3\] _00044_ VSS VSS
+ VDD VDD _04451_ sky130_fd_sc_hd__nand2b_1
X_15183_ network.neuron_in087.counter\[2\] VSS VSS VDD VDD
+ _04452_ sky130_fd_sc_hd__inv_1
X_15184_ _04451_ _04452_ VSS VSS VDD VDD _04453_ sky130_fd_sc_hd__nand2b_1
X_15185_ _08969_ _09276_ network.in_spk07_05 VSS VSS VDD VDD
+ _04454_ sky130_fd_sc_hd__o21ai_0
Xplace423 net423 VSS VSS VDD VDD net422 sky130_fd_sc_hd__buf_4
X_15187_ _04453_ _04454_ net377 VSS VSS VDD VDD _01780_ sky130_fd_sc_hd__a21oi_1
X_15188_ network.neuron_in086.counter\[2\] network.neuron_in086.counter\[3\]
+ VSS VSS VDD VDD _04456_ sky130_fd_sc_hd__nor2_1
X_15189_ _00048_ _04456_ VSS VSS VDD VDD _04457_ sky130_fd_sc_hd__nand2_1
X_15190_ _08868_ _08969_ VSS VSS VDD VDD _04458_ sky130_fd_sc_hd__or2_2
X_15191_ network.in_spk04_05 network.in_spk05_05 _04458_ network.in_spk06_05
+ VSS VSS VDD VDD _04459_ sky130_fd_sc_hd__o31ai_1
X_15192_ _04457_ _04459_ net377 VSS VSS VDD VDD _01781_ sky130_fd_sc_hd__a21oi_1
X_15193_ network.neuron_in085.counter\[2\] network.neuron_in085.counter\[3\]
+ VSS VSS VDD VDD _04460_ sky130_fd_sc_hd__nor2_1
X_15194_ _00052_ _04460_ VSS VSS VDD VDD _04461_ sky130_fd_sc_hd__nand2_1
X_15195_ network.in_spk04_05 _04458_ network.in_spk05_05 VSS
+ VSS VDD VDD _04462_ sky130_fd_sc_hd__o21ai_0
X_15196_ _04461_ _04462_ net377 VSS VSS VDD VDD _01782_ sky130_fd_sc_hd__a21oi_1
X_15197_ network.neuron_in084.counter\[2\] _00056_ VSS VSS
+ VDD VDD _04463_ sky130_fd_sc_hd__nor2b_1
X_15198_ network.neuron_in084.counter\[3\] _04463_ VSS VSS
+ VDD VDD _04464_ sky130_fd_sc_hd__nand2b_1
X_15199_ network.in_spk04_05 _04458_ VSS VSS VDD VDD _04465_
+ sky130_fd_sc_hd__nand2_1
X_15200_ _04464_ _04465_ net377 VSS VSS VDD VDD _01783_ sky130_fd_sc_hd__a21oi_1
X_15201_ network.neuron_in083.counter\[2\] network.neuron_in083.counter\[3\]
+ VSS VSS VDD VDD _04466_ sky130_fd_sc_hd__nor2_1
X_15202_ _00060_ _04466_ VSS VSS VDD VDD _04467_ sky130_fd_sc_hd__nand2_1
X_15203_ network.in_spk00_05 network.in_spk01_05 network.in_spk02_05
+ _08969_ network.in_spk03_05 VSS VSS VDD VDD _04468_ sky130_fd_sc_hd__o41ai_1
X_15204_ _04467_ _04468_ net377 VSS VSS VDD VDD _01784_ sky130_fd_sc_hd__a21oi_1
X_15205_ network.neuron_in082.counter\[2\] _00064_ VSS VSS
+ VDD VDD _04469_ sky130_fd_sc_hd__nor2b_1
X_15206_ network.neuron_in082.counter\[3\] _04469_ VSS VSS
+ VDD VDD _04470_ sky130_fd_sc_hd__nand2b_1
X_15207_ network.in_spk00_05 network.in_spk01_05 _08969_ network.in_spk02_05
+ VSS VSS VDD VDD _04471_ sky130_fd_sc_hd__o31ai_1
X_15208_ _04470_ _04471_ net377 VSS VSS VDD VDD _01785_ sky130_fd_sc_hd__a21oi_1
X_15209_ network.neuron_in081.counter\[2\] _00074_ VSS VSS
+ VDD VDD _04472_ sky130_fd_sc_hd__nor2b_1
X_15210_ network.neuron_in081.counter\[3\] _04472_ VSS VSS
+ VDD VDD _04473_ sky130_fd_sc_hd__nand2b_1
X_15211_ _09290_ network.in_spk01_05 VSS VSS VDD VDD _04474_
+ sky130_fd_sc_hd__nand2b_1
X_15212_ _04473_ _04474_ net377 VSS VSS VDD VDD _01786_ sky130_fd_sc_hd__a21oi_1
X_15213_ network.neuron_in080.counter\[3\] _00070_ VSS VSS
+ VDD VDD _04475_ sky130_fd_sc_hd__nand2b_1
X_15214_ network.neuron_in080.counter\[2\] VSS VSS VDD VDD
+ _04476_ sky130_fd_sc_hd__inv_1
X_15215_ _04475_ _04476_ VSS VSS VDD VDD _04477_ sky130_fd_sc_hd__nand2b_1
X_15216_ network.in_spk00_05 _08969_ VSS VSS VDD VDD _04478_
+ sky130_fd_sc_hd__nand2_1
X_15217_ _04477_ _04478_ net377 VSS VSS VDD VDD _01787_ sky130_fd_sc_hd__a21oi_1
X_15218_ network.neuron_in079.counter\[3\] _00091_ VSS VSS
+ VDD VDD _04479_ sky130_fd_sc_hd__nand2b_1
X_15219_ network.neuron_in079.counter\[2\] VSS VSS VDD VDD
+ _04480_ sky130_fd_sc_hd__inv_1
X_15220_ _04479_ _04480_ VSS VSS VDD VDD _04481_ sky130_fd_sc_hd__nand2b_1
X_15221_ net296 _09306_ VSS VSS VDD VDD _04482_ sky130_fd_sc_hd__nand2_1
X_15222_ network.in_spk12_04 network.in_spk13_04 network.in_spk14_04
+ _04482_ network.in_spk15_04 VSS VSS VDD VDD _04483_ sky130_fd_sc_hd__o41ai_1
X_15223_ _04481_ _04483_ net378 VSS VSS VDD VDD _01788_ sky130_fd_sc_hd__a21oi_1
X_15224_ network.neuron_in078.counter\[2\] network.neuron_in078.counter\[3\]
+ VSS VSS VDD VDD _04484_ sky130_fd_sc_hd__nor2_1
X_15225_ _00098_ _04484_ VSS VSS VDD VDD _04485_ sky130_fd_sc_hd__nand2_1
X_15226_ network.in_spk12_04 network.in_spk13_04 _04482_ network.in_spk14_04
+ VSS VSS VDD VDD _04486_ sky130_fd_sc_hd__o31ai_1
X_15227_ _04485_ _04486_ net378 VSS VSS VDD VDD _01789_ sky130_fd_sc_hd__a21oi_1
X_15228_ network.neuron_in077.counter\[2\] network.neuron_in077.counter\[3\]
+ VSS VSS VDD VDD _04487_ sky130_fd_sc_hd__nor2_1
X_15229_ _00103_ _04487_ VSS VSS VDD VDD _04488_ sky130_fd_sc_hd__nand2_1
X_15230_ network.in_spk12_04 _04482_ network.in_spk13_04 VSS
+ VSS VDD VDD _04489_ sky130_fd_sc_hd__o21ai_0
Xplace429 loaded\[5\] VSS VSS VDD VDD net428 sky130_fd_sc_hd__buf_4
X_15232_ _04488_ _04489_ net378 VSS VSS VDD VDD _01790_ sky130_fd_sc_hd__a21oi_1
X_15233_ network.neuron_in076.counter\[2\] _00107_ VSS VSS
+ VDD VDD _04491_ sky130_fd_sc_hd__nor2b_1
X_15234_ network.neuron_in076.counter\[3\] _04491_ VSS VSS
+ VDD VDD _04492_ sky130_fd_sc_hd__nand2b_1
X_15235_ network.in_spk12_04 _04482_ VSS VSS VDD VDD _04493_
+ sky130_fd_sc_hd__nand2_1
X_15236_ _04492_ _04493_ net378 VSS VSS VDD VDD _01791_ sky130_fd_sc_hd__a21oi_1
X_15237_ network.neuron_in075.counter\[2\] _00115_ VSS VSS
+ VDD VDD _04494_ sky130_fd_sc_hd__nor2b_1
X_15238_ network.neuron_in075.counter\[3\] _04494_ VSS VSS
+ VDD VDD _04495_ sky130_fd_sc_hd__nand2b_1
X_15239_ network.in_spk08_04 network.in_spk09_04 network.in_spk10_04
+ _09009_ network.in_spk11_04 VSS VSS VDD VDD _04496_ sky130_fd_sc_hd__o41ai_1
X_15240_ _04495_ _04496_ net378 VSS VSS VDD VDD _01792_ sky130_fd_sc_hd__a21oi_1
X_15241_ network.in_spk08_04 network.in_spk09_04 _09009_ network.in_spk10_04
+ VSS VSS VDD VDD _04497_ sky130_fd_sc_hd__o31ai_1
X_15242_ _04387_ _04497_ net378 VSS VSS VDD VDD _01793_ sky130_fd_sc_hd__a21oi_1
X_15243_ network.neuron_in073.counter\[2\] network.neuron_in073.counter\[3\]
+ VSS VSS VDD VDD _04498_ sky130_fd_sc_hd__nor2_1
X_15244_ _00202_ _04498_ VSS VSS VDD VDD _04499_ sky130_fd_sc_hd__nand2_1
X_15245_ network.in_spk08_04 _09009_ network.in_spk09_04 VSS
+ VSS VDD VDD _04500_ sky130_fd_sc_hd__o21ai_0
X_15246_ _04499_ _04500_ net378 VSS VSS VDD VDD _01794_ sky130_fd_sc_hd__a21oi_1
X_15247_ network.neuron_in072.counter\[2\] _00531_ VSS VSS
+ VDD VDD _04501_ sky130_fd_sc_hd__nor2b_1
X_15248_ network.neuron_in072.counter\[3\] _04501_ VSS VSS
+ VDD VDD _04502_ sky130_fd_sc_hd__nand2b_1
X_15249_ network.in_spk08_04 _09009_ VSS VSS VDD VDD _04503_
+ sky130_fd_sc_hd__nand2_1
X_15250_ _04502_ _04503_ net378 VSS VSS VDD VDD _01795_ sky130_fd_sc_hd__a21oi_1
X_15251_ network.neuron_in071.counter\[2\] _00135_ VSS VSS
+ VDD VDD _04504_ sky130_fd_sc_hd__nor2b_1
X_15252_ network.neuron_in071.counter\[3\] _04504_ VSS VSS
+ VDD VDD _04505_ sky130_fd_sc_hd__nand2b_1
X_15253_ _08859_ _09311_ net309 net296 VSS VSS VDD VDD _04506_
+ sky130_fd_sc_hd__nand4_1
X_15254_ network.in_spk06_04 _04506_ network.in_spk07_04 VSS
+ VSS VDD VDD _04507_ sky130_fd_sc_hd__o21ai_0
X_15255_ _04505_ _04507_ net378 VSS VSS VDD VDD _01796_ sky130_fd_sc_hd__a21oi_1
X_15256_ network.in_spk06_04 _04506_ VSS VSS VDD VDD _04508_
+ sky130_fd_sc_hd__nand2_1
X_15257_ _04381_ _04508_ net378 VSS VSS VDD VDD _01797_ sky130_fd_sc_hd__a21oi_1
X_15258_ _08859_ net309 net296 VSS VSS VDD VDD _04509_ sky130_fd_sc_hd__nand3_1
X_15259_ network.in_spk04_04 _04509_ network.in_spk05_04 VSS
+ VSS VDD VDD _04510_ sky130_fd_sc_hd__o21ai_0
X_15260_ _04367_ _04510_ net378 VSS VSS VDD VDD _01798_ sky130_fd_sc_hd__a21oi_1
X_15261_ network.in_spk04_04 _04509_ VSS VSS VDD VDD _04511_
+ sky130_fd_sc_hd__nand2_1
X_15262_ _04364_ _04511_ net378 VSS VSS VDD VDD _01799_ sky130_fd_sc_hd__a21oi_1
X_15263_ network.in_spk00_04 network.in_spk01_04 _09315_ VSS
+ VSS VDD VDD _04512_ sky130_fd_sc_hd__or3_1
X_15264_ network.in_spk02_04 _04512_ network.in_spk03_04 VSS
+ VSS VDD VDD _04513_ sky130_fd_sc_hd__o21ai_0
Xplace424 network.neuron_hid0.ROM0.address\[1\] VSS VSS VDD
+ VDD net423 sky130_fd_sc_hd__buf_4
X_15266_ _04307_ _04513_ net378 VSS VSS VDD VDD _01800_ sky130_fd_sc_hd__a21oi_1
X_15267_ network.in_spk02_04 _04512_ VSS VSS VDD VDD _04515_
+ sky130_fd_sc_hd__nand2_1
X_15268_ _04314_ _04515_ net378 VSS VSS VDD VDD _01801_ sky130_fd_sc_hd__a21oi_1
X_15269_ network.in_spk00_04 _09315_ network.in_spk01_04 VSS
+ VSS VDD VDD _04516_ sky130_fd_sc_hd__o21ai_0
X_15270_ _04311_ _04516_ net378 VSS VSS VDD VDD _01802_ sky130_fd_sc_hd__a21oi_1
X_15271_ network.in_spk00_04 _09315_ VSS VSS VDD VDD _04517_
+ sky130_fd_sc_hd__nand2_1
X_15272_ _04273_ _04517_ net378 VSS VSS VDD VDD _01803_ sky130_fd_sc_hd__a21oi_1
X_15273_ network.in_spk12_03 network.in_spk13_03 _08880_ _09015_
+ VSS VSS VDD VDD _04518_ sky130_fd_sc_hd__or4_1
X_15274_ network.in_spk14_03 _04518_ network.in_spk15_03 VSS
+ VSS VDD VDD _04519_ sky130_fd_sc_hd__o21ai_0
X_15275_ _04281_ _04519_ net373 VSS VSS VDD VDD _01804_ sky130_fd_sc_hd__a21oi_1
X_15276_ network.in_spk14_03 _04518_ VSS VSS VDD VDD _04520_
+ sky130_fd_sc_hd__nand2_1
X_15277_ _04269_ _04520_ net373 VSS VSS VDD VDD _01805_ sky130_fd_sc_hd__a21oi_1
X_15278_ _08876_ _08878_ _08967_ VSS VSS VDD VDD _04521_ sky130_fd_sc_hd__nor3_1
X_15279_ _09064_ _04521_ VSS VSS VDD VDD _04522_ sky130_fd_sc_hd__nand2_1
X_15280_ network.in_spk12_03 _04522_ network.in_spk13_03 VSS
+ VSS VDD VDD _04523_ sky130_fd_sc_hd__o21ai_0
X_15281_ _04287_ _04523_ net373 VSS VSS VDD VDD _01806_ sky130_fd_sc_hd__a21oi_1
X_15282_ network.in_spk12_03 _04522_ VSS VSS VDD VDD _04524_
+ sky130_fd_sc_hd__nand2_1
X_15283_ _04245_ _04524_ net373 VSS VSS VDD VDD _01807_ sky130_fd_sc_hd__a21oi_1
X_15284_ _09144_ _04521_ VSS VSS VDD VDD _04525_ sky130_fd_sc_hd__nand2_1
X_15285_ network.in_spk10_03 _04525_ network.in_spk11_03 VSS
+ VSS VDD VDD _04526_ sky130_fd_sc_hd__o21ai_0
X_15286_ _04253_ _04526_ net373 VSS VSS VDD VDD _01808_ sky130_fd_sc_hd__a21oi_1
X_15287_ network.in_spk10_03 _04525_ VSS VSS VDD VDD _04527_
+ sky130_fd_sc_hd__nand2_1
X_15288_ _04241_ _04527_ net373 VSS VSS VDD VDD _01809_ sky130_fd_sc_hd__a21oi_1
X_15289_ network.in_spk08_03 _09015_ network.in_spk09_03 VSS
+ VSS VDD VDD _04528_ sky130_fd_sc_hd__o21ai_0
Xplace420 network.neuron_hid0.ROM0.address\[2\] VSS VSS VDD
+ VDD net419 sky130_fd_sc_hd__buf_4
X_15291_ _04165_ _04528_ net373 VSS VSS VDD VDD _01810_ sky130_fd_sc_hd__a21oi_1
X_15292_ network.in_spk08_03 _09015_ VSS VSS VDD VDD _04530_
+ sky130_fd_sc_hd__nand2_1
X_15293_ _04184_ _04530_ net373 VSS VSS VDD VDD _01811_ sky130_fd_sc_hd__a21oi_1
X_15294_ _08947_ _08966_ _08882_ _03346_ VSS VSS VDD VDD _04531_
+ sky130_fd_sc_hd__nand4_1
X_15295_ network.in_spk07_03 _04531_ VSS VSS VDD VDD _04532_
+ sky130_fd_sc_hd__nand2_1
X_15296_ _04162_ _04532_ net371 VSS VSS VDD VDD _01812_ sky130_fd_sc_hd__a21oi_1
X_15297_ network.in_spk04_03 network.in_spk05_03 _09067_ network.in_spk06_03
+ VSS VSS VDD VDD _04533_ sky130_fd_sc_hd__o31ai_1
X_15298_ _04193_ _04533_ net371 VSS VSS VDD VDD _01813_ sky130_fd_sc_hd__a21oi_1
X_15299_ network.in_spk04_03 _09067_ network.in_spk05_03 VSS
+ VSS VDD VDD _04534_ sky130_fd_sc_hd__o21ai_0
X_15300_ _04176_ _04534_ net372 VSS VSS VDD VDD _01814_ sky130_fd_sc_hd__a21oi_1
X_15301_ network.in_spk04_03 _09067_ VSS VSS VDD VDD _04535_
+ sky130_fd_sc_hd__nand2_1
X_15302_ _04156_ _04535_ net371 VSS VSS VDD VDD _01815_ sky130_fd_sc_hd__a21oi_1
X_15303_ network.in_spk00_03 network.in_spk01_03 network.in_spk02_03
+ _08967_ network.in_spk03_03 VSS VSS VDD VDD _04536_ sky130_fd_sc_hd__o41ai_1
X_15304_ _04151_ _04536_ net371 VSS VSS VDD VDD _01816_ sky130_fd_sc_hd__a21oi_1
X_15305_ network.in_spk00_03 network.in_spk01_03 _08967_ network.in_spk02_03
+ VSS VSS VDD VDD _04537_ sky130_fd_sc_hd__o31ai_1
X_15306_ _04128_ _04537_ net371 VSS VSS VDD VDD _01817_ sky130_fd_sc_hd__a21oi_1
X_15307_ network.in_spk00_03 _08967_ network.in_spk01_03 VSS
+ VSS VDD VDD _04538_ sky130_fd_sc_hd__o21ai_0
X_15308_ _04124_ _04538_ net371 VSS VSS VDD VDD _01818_ sky130_fd_sc_hd__a21oi_1
X_15309_ network.in_spk00_03 _08967_ VSS VSS VDD VDD _04539_
+ sky130_fd_sc_hd__nand2_1
X_15310_ _04117_ _04539_ net371 VSS VSS VDD VDD _01819_ sky130_fd_sc_hd__a21oi_1
X_15311_ net302 _08872_ _09118_ net308 VSS VSS VDD VDD _04540_
+ sky130_fd_sc_hd__nand4_1
X_15312_ network.in_spk12_02 network.in_spk13_02 network.in_spk14_02
+ _04540_ network.in_spk15_02 VSS VSS VDD VDD _04541_ sky130_fd_sc_hd__o41ai_1
Xplace422 network.neuron_hid0.ROM0.address\[2\] VSS VSS VDD
+ VDD net421 sky130_fd_sc_hd__buf_4
X_15314_ _04060_ _04541_ net377 VSS VSS VDD VDD _01820_ sky130_fd_sc_hd__a21oi_1
X_15315_ network.in_spk12_02 network.in_spk13_02 _04540_ network.in_spk14_02
+ VSS VSS VDD VDD _04543_ sky130_fd_sc_hd__o31ai_1
X_15316_ _04055_ _04543_ net377 VSS VSS VDD VDD _01821_ sky130_fd_sc_hd__a21oi_1
X_15317_ network.in_spk12_02 _04540_ network.in_spk13_02 VSS
+ VSS VDD VDD _04544_ sky130_fd_sc_hd__o21ai_0
X_15318_ _04049_ _04544_ net377 VSS VSS VDD VDD _01822_ sky130_fd_sc_hd__a21oi_1
X_15319_ network.in_spk12_02 _04540_ VSS VSS VDD VDD _04545_
+ sky130_fd_sc_hd__nand2_1
X_15320_ _04045_ _04545_ net377 VSS VSS VDD VDD _01823_ sky130_fd_sc_hd__a21oi_1
X_15321_ net302 _09076_ _09003_ VSS VSS VDD VDD _04546_ sky130_fd_sc_hd__nand3_1
X_15322_ network.in_spk10_02 _04546_ network.in_spk11_02 VSS
+ VSS VDD VDD _04547_ sky130_fd_sc_hd__o21ai_0
X_15323_ _03742_ _04547_ net377 VSS VSS VDD VDD _01824_ sky130_fd_sc_hd__a21oi_1
X_15324_ network.in_spk10_02 _04546_ VSS VSS VDD VDD _04548_
+ sky130_fd_sc_hd__nand2_1
X_15325_ _03774_ _04548_ net377 VSS VSS VDD VDD _01825_ sky130_fd_sc_hd__a21oi_1
X_15326_ network.in_spk08_02 net303 _09001_ _09002_ network.in_spk09_02
+ VSS VSS VDD VDD _04549_ sky130_fd_sc_hd__o41ai_1
X_15327_ _03745_ _04549_ net377 VSS VSS VDD VDD _01826_ sky130_fd_sc_hd__a21oi_1
X_15328_ net303 _09001_ _09002_ network.in_spk08_02 VSS VSS
+ VDD VDD _04550_ sky130_fd_sc_hd__o31ai_1
X_15329_ _03760_ _04550_ net377 VSS VSS VDD VDD _01827_ sky130_fd_sc_hd__a21oi_1
X_15330_ net303 _09117_ network.in_spk07_02 VSS VSS VDD VDD
+ _04551_ sky130_fd_sc_hd__o21ai_0
X_15331_ _03756_ _04551_ net377 VSS VSS VDD VDD _01828_ sky130_fd_sc_hd__a21oi_1
X_15332_ network.in_spk01_02 _09126_ VSS VSS VDD VDD _04552_
+ sky130_fd_sc_hd__nor2_1
X_15333_ _09121_ _04552_ VSS VSS VDD VDD _04553_ sky130_fd_sc_hd__nand2_1
X_15334_ network.in_spk04_02 network.in_spk05_02 _04553_ network.in_spk06_02
+ VSS VSS VDD VDD _04554_ sky130_fd_sc_hd__o31ai_1
X_15335_ _03735_ _04554_ net380 VSS VSS VDD VDD _01829_ sky130_fd_sc_hd__a21oi_1
X_15336_ network.in_spk04_02 _04553_ network.in_spk05_02 VSS
+ VSS VDD VDD _04555_ sky130_fd_sc_hd__o21ai_0
Xplace421 net421 VSS VSS VDD VDD net420 sky130_fd_sc_hd__buf_4
X_15338_ _03710_ _04555_ net380 VSS VSS VDD VDD _01830_ sky130_fd_sc_hd__a21oi_1
X_15339_ network.in_spk04_02 _04553_ VSS VSS VDD VDD _04557_
+ sky130_fd_sc_hd__nand2_1
X_15340_ _03730_ _04557_ net380 VSS VSS VDD VDD _01831_ sky130_fd_sc_hd__a21oi_1
X_15341_ network.in_spk01_02 network.in_spk02_02 _09126_ network.in_spk03_02
+ VSS VSS VDD VDD _04558_ sky130_fd_sc_hd__o31ai_1
X_15342_ _03678_ _04558_ net377 VSS VSS VDD VDD _01832_ sky130_fd_sc_hd__a21oi_1
X_15343_ network.in_spk01_02 _09126_ network.in_spk02_02 VSS
+ VSS VDD VDD _04559_ sky130_fd_sc_hd__o21ai_0
X_15344_ _03673_ _04559_ net380 VSS VSS VDD VDD _01833_ sky130_fd_sc_hd__a21oi_1
X_15345_ network.in_spk01_02 _09126_ VSS VSS VDD VDD _04560_
+ sky130_fd_sc_hd__nand2_1
X_15346_ _03647_ _04560_ net380 VSS VSS VDD VDD _01834_ sky130_fd_sc_hd__a21oi_1
X_15347_ net303 _08966_ network.in_spk00_02 VSS VSS VDD VDD
+ _04561_ sky130_fd_sc_hd__o21ai_0
X_15348_ _03635_ _04561_ net377 VSS VSS VDD VDD _01835_ sky130_fd_sc_hd__a21oi_1
X_15349_ _08848_ _08852_ _08854_ VSS VSS VDD VDD _04562_ sky130_fd_sc_hd__or3_1
X_15350_ network.in_spk12_01 network.in_spk13_01 network.in_spk14_01
+ _04562_ network.in_spk15_01 VSS VSS VDD VDD _04563_ sky130_fd_sc_hd__o41ai_1
X_15351_ _03651_ _04563_ net373 VSS VSS VDD VDD _01836_ sky130_fd_sc_hd__a21oi_1
X_15352_ network.in_spk12_01 network.in_spk13_01 _04562_ network.in_spk14_01
+ VSS VSS VDD VDD _04564_ sky130_fd_sc_hd__o31ai_1
X_15353_ _07547_ _04564_ net373 VSS VSS VDD VDD _01837_ sky130_fd_sc_hd__a21oi_1
X_15354_ network.in_spk12_01 _04562_ network.in_spk13_01 VSS
+ VSS VDD VDD _04565_ sky130_fd_sc_hd__o21ai_0
X_15355_ _07535_ _04565_ net373 VSS VSS VDD VDD _01838_ sky130_fd_sc_hd__a21oi_1
X_15356_ network.neuron_in028.counter\[3\] _00357_ VSS VSS
+ VDD VDD _04566_ sky130_fd_sc_hd__nand2b_1
X_15357_ network.neuron_in028.counter\[2\] VSS VSS VDD VDD
+ _04567_ sky130_fd_sc_hd__inv_1
X_15358_ _04566_ _04567_ VSS VSS VDD VDD _04568_ sky130_fd_sc_hd__nand2b_1
X_15359_ network.in_spk12_01 _04562_ VSS VSS VDD VDD _04569_
+ sky130_fd_sc_hd__nand2_1
X_15360_ _04568_ _04569_ net373 VSS VSS VDD VDD _01839_ sky130_fd_sc_hd__a21oi_1
X_15361_ _09154_ _08961_ _08851_ VSS VSS VDD VDD _04570_ sky130_fd_sc_hd__nand3_1
X_15362_ network.in_spk08_01 network.in_spk09_01 network.in_spk10_01
+ _04570_ network.in_spk11_01 VSS VSS VDD VDD _04571_ sky130_fd_sc_hd__o41ai_1
Xplace419 network.neuron_hid0.ROM0.address\[3\] VSS VSS VDD
+ VDD net418 sky130_fd_sc_hd__buf_4
Xplace431 net23 VSS VSS VDD VDD net430 sky130_fd_sc_hd__buf_4
X_15365_ _03630_ _04571_ net373 VSS VSS VDD VDD _01840_ sky130_fd_sc_hd__a21oi_1
X_15366_ network.in_spk08_01 network.in_spk09_01 _04570_ network.in_spk10_01
+ VSS VSS VDD VDD _04574_ sky130_fd_sc_hd__o31ai_1
X_15367_ _03625_ _04574_ net373 VSS VSS VDD VDD _01841_ sky130_fd_sc_hd__a21oi_1
X_15368_ network.in_spk08_01 _04570_ network.in_spk09_01 VSS
+ VSS VDD VDD _04575_ sky130_fd_sc_hd__o21ai_0
X_15369_ _03620_ _04575_ net373 VSS VSS VDD VDD _01842_ sky130_fd_sc_hd__a21oi_1
X_15370_ network.in_spk08_01 _04570_ VSS VSS VDD VDD _04576_
+ sky130_fd_sc_hd__nand2_1
X_15371_ _03593_ _04576_ net373 VSS VSS VDD VDD _01843_ sky130_fd_sc_hd__a21oi_1
X_15372_ network.in_spk06_01 _08849_ _09167_ _08964_ network.in_spk07_01
+ VSS VSS VDD VDD _04577_ sky130_fd_sc_hd__o41ai_1
X_15373_ _03584_ _04577_ net372 VSS VSS VDD VDD _01844_ sky130_fd_sc_hd__a21oi_1
X_15374_ _08849_ _08964_ VSS VSS VDD VDD _04578_ sky130_fd_sc_hd__or2_2
X_15375_ _09167_ _04578_ network.in_spk06_01 VSS VSS VDD VDD
+ _04579_ sky130_fd_sc_hd__o21ai_0
X_15376_ _03575_ _04579_ net372 VSS VSS VDD VDD _01845_ sky130_fd_sc_hd__a21oi_1
X_15377_ network.in_spk04_01 _04578_ network.in_spk05_01 VSS
+ VSS VDD VDD _04580_ sky130_fd_sc_hd__o21ai_0
X_15378_ _03563_ _04580_ net372 VSS VSS VDD VDD _01846_ sky130_fd_sc_hd__a21oi_1
X_15379_ network.in_spk04_01 _04578_ VSS VSS VDD VDD _04581_
+ sky130_fd_sc_hd__nand2_1
X_15380_ _03557_ _04581_ net372 VSS VSS VDD VDD _01847_ sky130_fd_sc_hd__a21oi_1
X_15381_ network.in_spk02_01 _09171_ network.in_spk03_01 VSS
+ VSS VDD VDD _04582_ sky130_fd_sc_hd__o21ai_0
X_15382_ _03544_ _04582_ net371 VSS VSS VDD VDD _01848_ sky130_fd_sc_hd__a21oi_1
X_15383_ network.in_spk02_01 _09171_ VSS VSS VDD VDD _04583_
+ sky130_fd_sc_hd__nand2_1
X_15384_ _03535_ _04583_ net372 VSS VSS VDD VDD _01849_ sky130_fd_sc_hd__a21oi_1
X_15385_ network.in_spk00_01 _08964_ network.in_spk01_01 VSS
+ VSS VDD VDD _04584_ sky130_fd_sc_hd__o21ai_0
Xplace414 network.neuron_hid0.ROM0.address\[4\] VSS VSS VDD
+ VDD net413 sky130_fd_sc_hd__buf_4
X_15387_ _03526_ _04584_ net371 VSS VSS VDD VDD _01850_ sky130_fd_sc_hd__a21oi_1
X_15388_ network.in_spk00_01 _08964_ VSS VSS VDD VDD _04586_
+ sky130_fd_sc_hd__nand2_1
X_15389_ _03516_ _04586_ net371 VSS VSS VDD VDD _01851_ sky130_fd_sc_hd__a21oi_1
X_15390_ network.in_spk14_00 _09155_ network.in_spk15_00 VSS
+ VSS VDD VDD _04587_ sky130_fd_sc_hd__o21ai_0
X_15391_ _03490_ _04587_ net377 VSS VSS VDD VDD _01852_ sky130_fd_sc_hd__a21oi_1
X_15392_ _08925_ net292 VSS VSS VDD VDD _04588_ sky130_fd_sc_hd__nor2_1
X_15393_ _09155_ _04588_ network.in_spk14_00 VSS VSS VDD VDD
+ _04589_ sky130_fd_sc_hd__o21ai_0
X_15394_ _03500_ _04589_ net377 VSS VSS VDD VDD _01853_ sky130_fd_sc_hd__a21oi_1
X_15395_ network.in_spk13_00 _08848_ VSS VSS VDD VDD _04590_
+ sky130_fd_sc_hd__nand2_1
X_15396_ _03486_ _04590_ net377 VSS VSS VDD VDD _01854_ sky130_fd_sc_hd__a21oi_1
X_15397_ network.in_spk08_00 network.in_spk09_00 _08998_ VSS
+ VSS VDD VDD _04591_ sky130_fd_sc_hd__or3_1
X_15398_ network.in_spk10_00 network.in_spk11_00 _04591_ network.in_spk12_00
+ VSS VSS VDD VDD _04592_ sky130_fd_sc_hd__o31ai_1
X_15399_ _03476_ _04592_ net377 VSS VSS VDD VDD _01855_ sky130_fd_sc_hd__a21oi_1
X_15400_ network.in_spk10_00 _04591_ network.in_spk11_00 VSS
+ VSS VDD VDD _04593_ sky130_fd_sc_hd__o21ai_0
X_15401_ _03470_ _04593_ net377 VSS VSS VDD VDD _01856_ sky130_fd_sc_hd__a21oi_1
X_15402_ network.in_spk10_00 _04591_ VSS VSS VDD VDD _04594_
+ sky130_fd_sc_hd__nand2_1
X_15403_ _03460_ _04594_ net377 VSS VSS VDD VDD _01857_ sky130_fd_sc_hd__a21oi_1
X_15404_ network.in_spk08_00 _08998_ network.in_spk09_00 VSS
+ VSS VDD VDD _04595_ sky130_fd_sc_hd__o21ai_0
X_15405_ _03450_ _04595_ net377 VSS VSS VDD VDD _01858_ sky130_fd_sc_hd__a21oi_1
X_15406_ network.in_spk08_00 _08998_ VSS VSS VDD VDD _04596_
+ sky130_fd_sc_hd__nand2_1
X_15407_ _03444_ _04596_ net377 VSS VSS VDD VDD _01859_ sky130_fd_sc_hd__a21oi_1
X_15408_ network.in_spk06_00 _09157_ network.in_spk07_00 VSS
+ VSS VDD VDD _04597_ sky130_fd_sc_hd__o21ai_0
Xplace327 _04011_ VSS VSS VDD VDD net326 sky130_fd_sc_hd__buf_4
X_15410_ _08282_ _04597_ net379 VSS VSS VDD VDD _01860_ sky130_fd_sc_hd__a21oi_1
X_15411_ network.in_spk06_00 _09157_ VSS VSS VDD VDD _04599_
+ sky130_fd_sc_hd__nand2_1
X_15412_ _08274_ _04599_ net379 VSS VSS VDD VDD _01861_ sky130_fd_sc_hd__a21oi_1
X_15413_ network.in_spk04_00 _09153_ network.in_spk05_00 VSS
+ VSS VDD VDD _04600_ sky130_fd_sc_hd__o21ai_0
X_15414_ _08249_ _04600_ net379 VSS VSS VDD VDD _01862_ sky130_fd_sc_hd__a21oi_1
X_15415_ network.in_spk04_00 _09153_ VSS VSS VDD VDD _04601_
+ sky130_fd_sc_hd__nand2_1
X_15416_ _08244_ _04601_ net379 VSS VSS VDD VDD _01863_ sky130_fd_sc_hd__a21oi_1
X_15417_ network.in_spk00_00 network.in_spk01_00 network.in_spk02_00
+ network.in_spk03_00 VSS VSS VDD VDD _04602_ sky130_fd_sc_hd__o31ai_1
X_15418_ _08240_ _04602_ net379 VSS VSS VDD VDD _01864_ sky130_fd_sc_hd__a21oi_1
X_15419_ network.in_spk00_00 network.in_spk01_00 network.in_spk02_00
+ VSS VSS VDD VDD _04603_ sky130_fd_sc_hd__o21ai_0
X_15420_ _08220_ _04603_ net379 VSS VSS VDD VDD _01865_ sky130_fd_sc_hd__a21oi_1
X_15421_ network.in_spk00_00 network.in_spk01_00 VSS VSS VDD
+ VDD _04604_ sky130_fd_sc_hd__nand2_1
X_15422_ _08230_ _04604_ net379 VSS VSS VDD VDD _01866_ sky130_fd_sc_hd__a21oi_1
X_15423_ net379 _08205_ VSS VSS VDD VDD _01867_ sky130_fd_sc_hd__nor2_1
X_15424_ _08407_ _03692_ VSS VSS VDD VDD _04605_ sky130_fd_sc_hd__nor2b_1
X_15425_ network.cnt_main.counter\[13\] _04605_ VSS VSS VDD
+ VDD _04606_ sky130_fd_sc_hd__xnor2_1
X_15426_ _03682_ _04606_ VSS VSS VDD VDD _01868_ sky130_fd_sc_hd__nor2_1
X_15427_ loaded\[8\] _08323_ _08327_ VSS VSS VDD VDD net43
+ sky130_fd_sc_hd__and3_1
X_15428_ net24 net43 VSS VSS VDD VDD _04607_ sky130_fd_sc_hd__nand2_1
X_15429_ _08328_ net430 _04607_ VSS VSS VDD VDD _01249_ sky130_fd_sc_hd__nor3_1
X_15430_ net430 _08317_ _08329_ VSS VSS VDD VDD _01250_ sky130_fd_sc_hd__or3b_2
X_15431_ net430 net283 VSS VSS VDD VDD _01251_ sky130_fd_sc_hd__nor2_1
X_15432_ network.neuron_in071.counter\[2\] VSS VSS VDD VDD
+ _04608_ sky130_fd_sc_hd__inv_1
X_15433_ network.neuron_in071.counter\[3\] network.in_period\[71\]\[2\]
+ net378 _00135_ VSS VSS VDD VDD _04609_ sky130_fd_sc_hd__o22ai_1
Xplace309 _08875_ VSS VSS VDD VDD net308 sky130_fd_sc_hd__buf_4
X_15435_ network.neuron_in071.counter\[2\] _00135_ net398
+ VSS VSS VDD VDD _04611_ sky130_fd_sc_hd__nand3_1
X_15436_ network.in_period\[71\]\[2\] net398 _04611_ VSS VSS
+ VDD VDD _04612_ sky130_fd_sc_hd__o21ai_0
X_15437_ _04608_ _04609_ _04612_ VSS VSS VDD VDD _02350_ sky130_fd_sc_hd__a21oi_1
Xplace418 net418 VSS VSS VDD VDD net417 sky130_fd_sc_hd__buf_4
Xplace415 net415 VSS VSS VDD VDD net414 sky130_fd_sc_hd__buf_4
X_15440_ _08015_ net279 VSS VSS VDD VDD _01252_ sky130_fd_sc_hd__nand2_1
X_15441_ _08011_ net279 VSS VSS VDD VDD _01253_ sky130_fd_sc_hd__nand2_1
X_15442_ _08000_ net279 VSS VSS VDD VDD _01254_ sky130_fd_sc_hd__nand2_1
X_15443_ _08005_ net279 VSS VSS VDD VDD _01255_ sky130_fd_sc_hd__nand2_1
X_15444_ _07950_ net279 VSS VSS VDD VDD _01256_ sky130_fd_sc_hd__nand2_1
X_15445_ _07974_ net279 VSS VSS VDD VDD _01257_ sky130_fd_sc_hd__nand2_1
X_15446_ _07959_ net279 VSS VSS VDD VDD _01258_ sky130_fd_sc_hd__nand2_1
Xplace411 net412 VSS VSS VDD VDD net410 sky130_fd_sc_hd__buf_4
Xplace310 _08863_ VSS VSS VDD VDD net309 sky130_fd_sc_hd__buf_4
X_15449_ _07969_ net279 VSS VSS VDD VDD _01259_ sky130_fd_sc_hd__nand2_1
X_15450_ _07954_ net279 VSS VSS VDD VDD _01260_ sky130_fd_sc_hd__nand2_1
X_15451_ _07964_ net279 VSS VSS VDD VDD _01261_ sky130_fd_sc_hd__nand2_1
X_15452_ _07435_ net279 VSS VSS VDD VDD _01262_ sky130_fd_sc_hd__nand2_1
X_15453_ _07444_ net277 VSS VSS VDD VDD _01263_ sky130_fd_sc_hd__nand2_1
X_15454_ _07431_ net277 VSS VSS VDD VDD _01264_ sky130_fd_sc_hd__nand2_1
X_15455_ _07560_ net277 VSS VSS VDD VDD _01265_ sky130_fd_sc_hd__nand2_1
X_15456_ _07553_ net277 VSS VSS VDD VDD _01266_ sky130_fd_sc_hd__nand2_1
X_15457_ _07405_ net277 VSS VSS VDD VDD _01267_ sky130_fd_sc_hd__nand2_1
X_15458_ _07401_ net280 VSS VSS VDD VDD _01268_ sky130_fd_sc_hd__nand2_1
Xplace440 net444 VSS VSS VDD VDD net439 sky130_fd_sc_hd__buf_4
X_15460_ _07396_ net280 VSS VSS VDD VDD _01269_ sky130_fd_sc_hd__nand2_1
X_15461_ _07391_ net280 VSS VSS VDD VDD _01270_ sky130_fd_sc_hd__nand2_1
X_15462_ _06991_ net280 VSS VSS VDD VDD _01271_ sky130_fd_sc_hd__nand2_1
X_15463_ _07283_ net280 VSS VSS VDD VDD _01272_ sky130_fd_sc_hd__nand2_1
X_15464_ _07035_ net280 VSS VSS VDD VDD _01273_ sky130_fd_sc_hd__nand2_1
X_15465_ _06996_ net280 VSS VSS VDD VDD _01274_ sky130_fd_sc_hd__nand2_1
X_15466_ _07006_ net280 VSS VSS VDD VDD _01275_ sky130_fd_sc_hd__nand2_1
X_15467_ _07028_ net282 VSS VSS VDD VDD _01276_ sky130_fd_sc_hd__nand2_1
X_15468_ _07001_ net282 VSS VSS VDD VDD _01277_ sky130_fd_sc_hd__nand2_1
X_15469_ _07022_ net281 VSS VSS VDD VDD _01278_ sky130_fd_sc_hd__nand2_1
Xplace439 net444 VSS VSS VDD VDD net438 sky130_fd_sc_hd__buf_4
X_15471_ _07258_ net281 VSS VSS VDD VDD _01279_ sky130_fd_sc_hd__nand2_1
X_15472_ _06876_ net282 VSS VSS VDD VDD _01280_ sky130_fd_sc_hd__nand2_1
X_15473_ _06922_ net282 VSS VSS VDD VDD _01281_ sky130_fd_sc_hd__nand2_1
X_15474_ _06978_ net281 VSS VSS VDD VDD _01282_ sky130_fd_sc_hd__nand2_1
X_15475_ _06916_ net281 VSS VSS VDD VDD _01283_ sky130_fd_sc_hd__nand2_1
X_15476_ _06972_ net279 VSS VSS VDD VDD _01284_ sky130_fd_sc_hd__nand2_1
X_15477_ _06885_ net279 VSS VSS VDD VDD _01285_ sky130_fd_sc_hd__nand2_1
X_15478_ _06906_ net279 VSS VSS VDD VDD _01286_ sky130_fd_sc_hd__nand2_1
X_15479_ _06881_ net279 VSS VSS VDD VDD _01287_ sky130_fd_sc_hd__nand2_1
X_15480_ _06959_ net279 VSS VSS VDD VDD _01288_ sky130_fd_sc_hd__nand2_1
Xplace433 net433 VSS VSS VDD VDD net432 sky130_fd_sc_hd__buf_4
X_15482_ _06778_ net277 VSS VSS VDD VDD _01289_ sky130_fd_sc_hd__nand2_1
X_15483_ _06785_ net279 VSS VSS VDD VDD _01290_ sky130_fd_sc_hd__nand2_1
X_15484_ _06862_ net277 VSS VSS VDD VDD _01291_ sky130_fd_sc_hd__nand2_1
X_15485_ _06800_ net277 VSS VSS VDD VDD _01292_ sky130_fd_sc_hd__nand2_1
X_15486_ _06819_ net277 VSS VSS VDD VDD _01293_ sky130_fd_sc_hd__nand2_1
X_15487_ _06782_ net277 VSS VSS VDD VDD _01294_ sky130_fd_sc_hd__nand2_1
X_15488_ _06794_ net277 VSS VSS VDD VDD _01295_ sky130_fd_sc_hd__nand2_1
X_15489_ _06811_ net277 VSS VSS VDD VDD _01296_ sky130_fd_sc_hd__nand2_1
X_15490_ _06790_ net277 VSS VSS VDD VDD _01297_ sky130_fd_sc_hd__nand2_1
X_15491_ _06843_ net277 VSS VSS VDD VDD _01298_ sky130_fd_sc_hd__nand2_1
X_15492_ network.neuron_in208.counter\[3\] _06653_ net277
+ VSS VSS VDD VDD _01299_ sky130_fd_sc_hd__o21ai_0
Xplace430 loaded\[4\] VSS VSS VDD VDD net429 sky130_fd_sc_hd__buf_4
X_15494_ _06671_ net277 VSS VSS VDD VDD _01300_ sky130_fd_sc_hd__nand2_1
X_15495_ _06772_ net277 VSS VSS VDD VDD _01301_ sky130_fd_sc_hd__nand2_1
X_15496_ _06702_ net277 VSS VSS VDD VDD _01302_ sky130_fd_sc_hd__nand2_1
X_15497_ _06766_ net277 VSS VSS VDD VDD _01303_ sky130_fd_sc_hd__nand2_1
X_15498_ _06761_ net277 VSS VSS VDD VDD _01304_ sky130_fd_sc_hd__nand2_1
X_15499_ _06680_ net277 VSS VSS VDD VDD _01305_ sky130_fd_sc_hd__nand2_1
X_15500_ _06715_ net277 VSS VSS VDD VDD _01306_ sky130_fd_sc_hd__nand2_1
X_15501_ _06675_ net277 VSS VSS VDD VDD _01307_ sky130_fd_sc_hd__nand2_1
X_15502_ _06741_ net277 VSS VSS VDD VDD _01308_ sky130_fd_sc_hd__nand2_1
X_15503_ _06736_ net277 VSS VSS VDD VDD _01309_ sky130_fd_sc_hd__nand2_1
Xplace311 _08312_ VSS VSS VDD VDD net310 sky130_fd_sc_hd__buf_4
X_15505_ _06558_ net277 VSS VSS VDD VDD _01310_ sky130_fd_sc_hd__nand2_1
X_15506_ _06649_ net277 VSS VSS VDD VDD _01311_ sky130_fd_sc_hd__nand2_1
X_15507_ _06573_ net277 VSS VSS VDD VDD _01312_ sky130_fd_sc_hd__nand2_1
X_15508_ _06600_ net277 VSS VSS VDD VDD _01313_ sky130_fd_sc_hd__nand2_1
X_15509_ _06639_ net277 VSS VSS VDD VDD _01314_ sky130_fd_sc_hd__nand2_1
X_15510_ _06568_ net277 VSS VSS VDD VDD _01315_ sky130_fd_sc_hd__nand2_1
X_15511_ _06594_ net276 VSS VSS VDD VDD _01316_ sky130_fd_sc_hd__nand2_1
X_15512_ _06563_ net276 VSS VSS VDD VDD _01317_ sky130_fd_sc_hd__nand2_1
X_15513_ _06587_ net276 VSS VSS VDD VDD _01318_ sky130_fd_sc_hd__nand2_1
X_15514_ _06616_ net276 VSS VSS VDD VDD _01319_ sky130_fd_sc_hd__nand2_1
Xplace444 net444 VSS VSS VDD VDD net443 sky130_fd_sc_hd__buf_4
X_15516_ _06454_ net276 VSS VSS VDD VDD _01320_ sky130_fd_sc_hd__nand2_1
X_15517_ _06503_ net276 VSS VSS VDD VDD _01321_ sky130_fd_sc_hd__nand2_1
X_15518_ _06474_ net276 VSS VSS VDD VDD _01322_ sky130_fd_sc_hd__nand2_1
X_15519_ _06534_ net276 VSS VSS VDD VDD _01323_ sky130_fd_sc_hd__nand2_1
X_15520_ _06450_ net276 VSS VSS VDD VDD _01324_ sky130_fd_sc_hd__nand2_1
X_15521_ _06462_ net276 VSS VSS VDD VDD _01325_ sky130_fd_sc_hd__nand2_1
X_15522_ _06492_ net276 VSS VSS VDD VDD _01326_ sky130_fd_sc_hd__nand2_1
X_15523_ _06458_ net276 VSS VSS VDD VDD _01327_ sky130_fd_sc_hd__nand2_1
X_15524_ _06516_ net276 VSS VSS VDD VDD _01328_ sky130_fd_sc_hd__nand2_1
X_15525_ _06489_ net276 VSS VSS VDD VDD _01329_ sky130_fd_sc_hd__nand2_1
Xplace441 net443 VSS VSS VDD VDD net440 sky130_fd_sc_hd__buf_4
X_15527_ _06894_ net276 VSS VSS VDD VDD _01330_ sky130_fd_sc_hd__nand2_1
X_15528_ _07450_ net276 VSS VSS VDD VDD _01331_ sky130_fd_sc_hd__nand2_1
X_15529_ _07499_ net276 VSS VSS VDD VDD _01332_ sky130_fd_sc_hd__nand2_1
X_15530_ _07495_ net276 VSS VSS VDD VDD _01333_ sky130_fd_sc_hd__nand2_1
X_15531_ _07468_ net276 VSS VSS VDD VDD _01334_ sky130_fd_sc_hd__nand2_1
X_15532_ _07489_ net276 VSS VSS VDD VDD _01335_ sky130_fd_sc_hd__nand2_1
X_15533_ _07455_ net276 VSS VSS VDD VDD _01336_ sky130_fd_sc_hd__nand2_1
X_15534_ _07484_ net276 VSS VSS VDD VDD _01337_ sky130_fd_sc_hd__nand2_1
X_15535_ _07480_ net276 VSS VSS VDD VDD _01338_ sky130_fd_sc_hd__nand2_1
X_15536_ _07461_ net276 VSS VSS VDD VDD _01339_ sky130_fd_sc_hd__nand2_1
Xplace312 _08303_ VSS VSS VDD VDD net311 sky130_fd_sc_hd__buf_4
X_15538_ _07475_ net277 VSS VSS VDD VDD _01340_ sky130_fd_sc_hd__nand2_1
X_15539_ _07503_ net276 VSS VSS VDD VDD _01341_ sky130_fd_sc_hd__nand2_1
X_15540_ net276 _03935_ VSS VSS VDD VDD _01342_ sky130_fd_sc_hd__nand2_1
X_15541_ net276 _03929_ VSS VSS VDD VDD _01343_ sky130_fd_sc_hd__nand2_1
X_15542_ net282 _03801_ VSS VSS VDD VDD _01344_ sky130_fd_sc_hd__nand2_1
X_15543_ net276 _03770_ VSS VSS VDD VDD _01345_ sky130_fd_sc_hd__nand2_1
X_15544_ _06438_ net277 VSS VSS VDD VDD _01346_ sky130_fd_sc_hd__nand2_1
X_15545_ _06433_ net277 VSS VSS VDD VDD _01347_ sky130_fd_sc_hd__nand2_1
X_15546_ _06383_ net282 VSS VSS VDD VDD _01348_ sky130_fd_sc_hd__nand2_1
X_15547_ _06378_ net280 VSS VSS VDD VDD _01349_ sky130_fd_sc_hd__nand2_1
X_15548_ _06372_ net280 VSS VSS VDD VDD _01350_ sky130_fd_sc_hd__nand2_1
X_15549_ _06418_ net280 VSS VSS VDD VDD _01351_ sky130_fd_sc_hd__nand2_1
X_15550_ _06413_ net282 VSS VSS VDD VDD _01352_ sky130_fd_sc_hd__nand2_1
X_15551_ _06408_ net282 VSS VSS VDD VDD _01353_ sky130_fd_sc_hd__nand2_1
Xplace452 net19 VSS VSS VDD VDD net451 sky130_fd_sc_hd__buf_4
X_15553_ _06403_ net282 VSS VSS VDD VDD _01354_ sky130_fd_sc_hd__nand2_1
X_15554_ _06400_ net280 VSS VSS VDD VDD _01355_ sky130_fd_sc_hd__nand2_1
X_15555_ network.neuron_in151.counter\[2\] VSS VSS VDD VDD
+ _04626_ sky130_fd_sc_hd__inv_1
X_15556_ _04626_ _00482_ VSS VSS VDD VDD _04627_ sky130_fd_sc_hd__nand2_1
X_15557_ network.neuron_in151.counter\[3\] _04627_ VSS VSS
+ VDD VDD _04628_ sky130_fd_sc_hd__or2_2
X_15558_ net282 _04628_ VSS VSS VDD VDD _01356_ sky130_fd_sc_hd__nand2_1
X_15559_ network.neuron_in150.counter\[2\] network.neuron_in150.counter\[3\]
+ _00494_ VSS VSS VDD VDD _04629_ sky130_fd_sc_hd__or3b_2
X_15560_ net282 _04629_ VSS VSS VDD VDD _01357_ sky130_fd_sc_hd__nand2_1
X_15561_ network.neuron_in149.counter\[2\] network.neuron_in149.counter\[3\]
+ VSS VSS VDD VDD _04630_ sky130_fd_sc_hd__nor2_1
X_15562_ _00506_ _04630_ VSS VSS VDD VDD _04631_ sky130_fd_sc_hd__nand2_1
X_15563_ net282 _04631_ VSS VSS VDD VDD _01358_ sky130_fd_sc_hd__nand2_1
Xplace313 _08299_ VSS VSS VDD VDD net312 sky130_fd_sc_hd__buf_4
X_15565_ network.neuron_in148.counter\[2\] _00593_ VSS VSS
+ VDD VDD _04633_ sky130_fd_sc_hd__nand2b_1
X_15566_ network.neuron_in148.counter\[3\] _04633_ VSS VSS
+ VDD VDD _04634_ sky130_fd_sc_hd__or2_2
X_15567_ net282 _04634_ VSS VSS VDD VDD _01359_ sky130_fd_sc_hd__nand2_1
X_15568_ _06983_ net282 VSS VSS VDD VDD _01360_ sky130_fd_sc_hd__nand2_1
X_15569_ _03507_ net282 VSS VSS VDD VDD _01361_ sky130_fd_sc_hd__nand2_1
X_15570_ _07419_ net279 VSS VSS VDD VDD _01362_ sky130_fd_sc_hd__nand2_1
X_15571_ network.neuron_in144.counter\[3\] _06694_ net282
+ VSS VSS VDD VDD _01363_ sky130_fd_sc_hd__o21ai_0
X_15572_ _06521_ net280 VSS VSS VDD VDD _01364_ sky130_fd_sc_hd__nand2_1
X_15573_ _06546_ net280 VSS VSS VDD VDD _01365_ sky130_fd_sc_hd__nand2_1
X_15574_ _06578_ net280 VSS VSS VDD VDD _01366_ sky130_fd_sc_hd__nand2_1
X_15575_ _06628_ net280 VSS VSS VDD VDD _01367_ sky130_fd_sc_hd__nand2_1
X_15576_ _06685_ net276 VSS VSS VDD VDD _01368_ sky130_fd_sc_hd__nand2_1
Xplace308 _07043_ VSS VSS VDD VDD net307 sky130_fd_sc_hd__buf_4
X_15578_ _06925_ net280 VSS VSS VDD VDD _01369_ sky130_fd_sc_hd__nand2_1
X_15579_ _06928_ net276 VSS VSS VDD VDD _01370_ sky130_fd_sc_hd__nand2_1
X_15580_ _06940_ net276 VSS VSS VDD VDD _01371_ sky130_fd_sc_hd__nand2_1
X_15581_ _06745_ net280 VSS VSS VDD VDD _01372_ sky130_fd_sc_hd__nand2_1
X_15582_ _06825_ net276 VSS VSS VDD VDD _01373_ sky130_fd_sc_hd__nand2_1
X_15583_ _08214_ net276 VSS VSS VDD VDD _01374_ sky130_fd_sc_hd__nand2_1
X_15584_ _08044_ net276 VSS VSS VDD VDD _01375_ sky130_fd_sc_hd__nand2_1
X_15585_ net276 _03783_ VSS VSS VDD VDD _01376_ sky130_fd_sc_hd__nand2_1
X_15586_ net280 _04361_ VSS VSS VDD VDD _01377_ sky130_fd_sc_hd__nand2_1
X_15587_ _03604_ net276 VSS VSS VDD VDD _01378_ sky130_fd_sc_hd__nand2_1
X_15588_ _08266_ net280 VSS VSS VDD VDD _01379_ sky130_fd_sc_hd__nand2_1
X_15589_ _08080_ net276 VSS VSS VDD VDD _01380_ sky130_fd_sc_hd__nand2_1
Xplace306 _07308_ VSS VSS VDD VDD net305 sky130_fd_sc_hd__buf_4
X_15591_ _06752_ net276 VSS VSS VDD VDD _01381_ sky130_fd_sc_hd__nand2_1
X_15592_ _07265_ net280 VSS VSS VDD VDD _01382_ sky130_fd_sc_hd__nand2_1
X_15593_ net276 _03715_ VSS VSS VDD VDD _01383_ sky130_fd_sc_hd__nand2_1
X_15594_ network.neuron_in123.counter\[2\] network.neuron_in123.counter\[3\]
+ _00218_ VSS VSS VDD VDD _04637_ sky130_fd_sc_hd__or3b_2
X_15595_ net280 _04637_ VSS VSS VDD VDD _01384_ sky130_fd_sc_hd__nand2_1
X_15596_ network.neuron_in122.counter\[2\] network.neuron_in122.counter\[3\]
+ VSS VSS VDD VDD _04638_ sky130_fd_sc_hd__nor2_1
X_15597_ _00537_ _04638_ VSS VSS VDD VDD _04639_ sky130_fd_sc_hd__nand2_1
X_15598_ net280 _04639_ VSS VSS VDD VDD _01385_ sky130_fd_sc_hd__nand2_1
X_15599_ network.neuron_in121.counter\[2\] network.neuron_in121.counter\[3\]
+ VSS VSS VDD VDD _04640_ sky130_fd_sc_hd__nor2_1
X_15600_ _00125_ _04640_ VSS VSS VDD VDD _04641_ sky130_fd_sc_hd__nand2_1
X_15601_ net280 _04641_ VSS VSS VDD VDD _01386_ sky130_fd_sc_hd__nand2_1
X_15602_ network.neuron_in120.counter\[2\] _00792_ VSS VSS
+ VDD VDD _04642_ sky130_fd_sc_hd__nor2b_1
X_15603_ network.neuron_in120.counter\[3\] _04642_ VSS VSS
+ VDD VDD _04643_ sky130_fd_sc_hd__nand2b_1
X_15604_ net280 _04643_ VSS VSS VDD VDD _01387_ sky130_fd_sc_hd__nand2_1
X_15605_ network.neuron_in119.counter\[2\] network.neuron_in119.counter\[3\]
+ VSS VSS VDD VDD _04644_ sky130_fd_sc_hd__nor2_1
X_15606_ _00581_ _04644_ VSS VSS VDD VDD _04645_ sky130_fd_sc_hd__nand2_1
X_15607_ net276 _04645_ VSS VSS VDD VDD _01388_ sky130_fd_sc_hd__nand2_1
X_15608_ network.neuron_in118.counter\[2\] network.neuron_in118.counter\[3\]
+ VSS VSS VDD VDD _04646_ sky130_fd_sc_hd__nor2_1
X_15609_ _00084_ _04646_ VSS VSS VDD VDD _04647_ sky130_fd_sc_hd__nand2_1
X_15610_ net276 _04647_ VSS VSS VDD VDD _01389_ sky130_fd_sc_hd__nand2_1
Xplace317 _07388_ VSS VSS VDD VDD net316 sky130_fd_sc_hd__buf_4
X_15612_ network.neuron_in117.counter\[3\] network.neuron_in117.counter\[2\]
+ VSS VSS VDD VDD _04649_ sky130_fd_sc_hd__nor2_1
X_15613_ _01219_ _04649_ VSS VSS VDD VDD _04650_ sky130_fd_sc_hd__nand2_1
X_15614_ net276 _04650_ VSS VSS VDD VDD _01390_ sky130_fd_sc_hd__nand2_1
X_15615_ network.neuron_in116.counter\[2\] _00040_ VSS VSS
+ VDD VDD _04651_ sky130_fd_sc_hd__nor2b_1
X_15616_ network.neuron_in116.counter\[3\] _04651_ VSS VSS
+ VDD VDD _04652_ sky130_fd_sc_hd__nand2b_1
X_15617_ net280 _04652_ VSS VSS VDD VDD _01391_ sky130_fd_sc_hd__nand2_1
X_15618_ network.neuron_in115.counter\[2\] _01228_ VSS VSS
+ VDD VDD _04653_ sky130_fd_sc_hd__nor2b_1
X_15619_ network.neuron_in115.counter\[3\] _04653_ VSS VSS
+ VDD VDD _04654_ sky130_fd_sc_hd__nand2b_1
X_15620_ net280 _04654_ VSS VSS VDD VDD _01392_ sky130_fd_sc_hd__nand2_1
X_15621_ network.neuron_in114.counter\[2\] network.neuron_in114.counter\[3\]
+ VSS VSS VDD VDD _04655_ sky130_fd_sc_hd__nor2_1
X_15622_ _00498_ _04655_ VSS VSS VDD VDD _04656_ sky130_fd_sc_hd__nand2_1
X_15623_ net280 _04656_ VSS VSS VDD VDD _01393_ sky130_fd_sc_hd__nand2_1
X_15624_ network.neuron_in113.counter\[2\] network.neuron_in113.counter\[3\]
+ _00577_ VSS VSS VDD VDD _04657_ sky130_fd_sc_hd__or3b_2
X_15625_ net280 _04657_ VSS VSS VDD VDD _01394_ sky130_fd_sc_hd__nand2_1
X_15626_ network.neuron_in112.counter\[3\] _00545_ VSS VSS
+ VDD VDD _04658_ sky130_fd_sc_hd__nand2b_1
X_15627_ network.neuron_in112.counter\[2\] VSS VSS VDD VDD
+ _04659_ sky130_fd_sc_hd__inv_1
X_15628_ _04658_ _04659_ VSS VSS VDD VDD _04660_ sky130_fd_sc_hd__nand2b_1
X_15629_ net280 _04660_ VSS VSS VDD VDD _01395_ sky130_fd_sc_hd__nand2_1
X_15630_ network.neuron_in111.counter\[2\] _00569_ VSS VSS
+ VDD VDD _04661_ sky130_fd_sc_hd__nor2b_1
X_15631_ network.neuron_in111.counter\[3\] _04661_ VSS VSS
+ VDD VDD _04662_ sky130_fd_sc_hd__nand2b_1
X_15632_ net281 _04662_ VSS VSS VDD VDD _01396_ sky130_fd_sc_hd__nand2_1
X_15633_ network.neuron_in110.counter\[3\] _00080_ VSS VSS
+ VDD VDD _04663_ sky130_fd_sc_hd__nand2b_1
X_15634_ network.neuron_in110.counter\[2\] VSS VSS VDD VDD
+ _04664_ sky130_fd_sc_hd__inv_1
X_15635_ _04663_ _04664_ VSS VSS VDD VDD _04665_ sky130_fd_sc_hd__nand2b_1
X_15636_ net281 _04665_ VSS VSS VDD VDD _01397_ sky130_fd_sc_hd__nand2_1
X_15637_ network.neuron_in109.counter\[2\] network.neuron_in109.counter\[3\]
+ VSS VSS VDD VDD _04666_ sky130_fd_sc_hd__nor2_1
X_15638_ _01008_ _04666_ VSS VSS VDD VDD _04667_ sky130_fd_sc_hd__nand2_1
X_15639_ net281 _04667_ VSS VSS VDD VDD _01398_ sky130_fd_sc_hd__nand2_1
X_15640_ network.neuron_in108.counter\[3\] _00684_ VSS VSS
+ VDD VDD _04668_ sky130_fd_sc_hd__nand2b_1
X_15641_ network.neuron_in108.counter\[2\] VSS VSS VDD VDD
+ _04669_ sky130_fd_sc_hd__inv_1
X_15642_ _04668_ _04669_ VSS VSS VDD VDD _04670_ sky130_fd_sc_hd__nand2b_1
X_15643_ net281 _04670_ VSS VSS VDD VDD _01399_ sky130_fd_sc_hd__nand2_1
Xplace302 _03952_ VSS VSS VDD VDD net301 sky130_fd_sc_hd__buf_4
X_15645_ network.neuron_in107.counter\[3\] _01069_ VSS VSS
+ VDD VDD _04672_ sky130_fd_sc_hd__nand2b_1
X_15646_ network.neuron_in107.counter\[2\] VSS VSS VDD VDD
+ _04673_ sky130_fd_sc_hd__inv_1
X_15647_ _04672_ _04673_ VSS VSS VDD VDD _04674_ sky130_fd_sc_hd__nand2b_1
X_15648_ net282 _04674_ VSS VSS VDD VDD _01400_ sky130_fd_sc_hd__nand2_1
X_15649_ network.neuron_in106.counter\[3\] _00672_ VSS VSS
+ VDD VDD _04675_ sky130_fd_sc_hd__nand2b_1
X_15650_ network.neuron_in106.counter\[2\] VSS VSS VDD VDD
+ _04676_ sky130_fd_sc_hd__inv_1
X_15651_ _04675_ _04676_ VSS VSS VDD VDD _04677_ sky130_fd_sc_hd__nand2b_1
X_15652_ net281 _04677_ VSS VSS VDD VDD _01401_ sky130_fd_sc_hd__nand2_1
X_15653_ network.neuron_in105.counter\[2\] network.neuron_in105.counter\[3\]
+ VSS VSS VDD VDD _04678_ sky130_fd_sc_hd__nor2_1
X_15654_ _01077_ _04678_ VSS VSS VDD VDD _04679_ sky130_fd_sc_hd__nand2_1
X_15655_ net281 _04679_ VSS VSS VDD VDD _01402_ sky130_fd_sc_hd__nand2_1
X_15656_ network.neuron_in104.counter\[3\] _00680_ VSS VSS
+ VDD VDD _04680_ sky130_fd_sc_hd__nand2b_1
X_15657_ network.neuron_in104.counter\[2\] VSS VSS VDD VDD
+ _04681_ sky130_fd_sc_hd__inv_1
X_15658_ _04680_ _04681_ VSS VSS VDD VDD _04682_ sky130_fd_sc_hd__nand2b_1
X_15659_ net282 _04682_ VSS VSS VDD VDD _01403_ sky130_fd_sc_hd__nand2_1
X_15660_ network.neuron_in103.counter\[2\] _00904_ VSS VSS
+ VDD VDD _04683_ sky130_fd_sc_hd__nor2b_1
X_15661_ network.neuron_in103.counter\[3\] _04683_ VSS VSS
+ VDD VDD _04684_ sky130_fd_sc_hd__nand2b_1
X_15662_ net282 _04684_ VSS VSS VDD VDD _01404_ sky130_fd_sc_hd__nand2_1
X_15663_ network.neuron_in102.counter\[3\] _00996_ VSS VSS
+ VDD VDD _04685_ sky130_fd_sc_hd__nand2b_1
X_15664_ network.neuron_in102.counter\[2\] VSS VSS VDD VDD
+ _04686_ sky130_fd_sc_hd__inv_1
X_15665_ _04685_ _04686_ VSS VSS VDD VDD _04687_ sky130_fd_sc_hd__nand2b_1
X_15666_ net282 _04687_ VSS VSS VDD VDD _01405_ sky130_fd_sc_hd__nand2_1
X_15667_ network.neuron_in101.counter\[2\] network.neuron_in101.counter\[3\]
+ VSS VSS VDD VDD _04688_ sky130_fd_sc_hd__nor2_1
X_15668_ _00836_ _04688_ VSS VSS VDD VDD _04689_ sky130_fd_sc_hd__nand2_1
X_15669_ net282 _04689_ VSS VSS VDD VDD _01406_ sky130_fd_sc_hd__nand2_1
X_15670_ network.neuron_in100.counter\[2\] _00704_ VSS VSS
+ VDD VDD _04690_ sky130_fd_sc_hd__nor2b_1
X_15671_ network.neuron_in100.counter\[3\] _04690_ VSS VSS
+ VDD VDD _04691_ sky130_fd_sc_hd__nand2b_1
X_15672_ net282 _04691_ VSS VSS VDD VDD _01407_ sky130_fd_sc_hd__nand2_1
X_15673_ network.neuron_in099.counter\[3\] _00724_ VSS VSS
+ VDD VDD _04692_ sky130_fd_sc_hd__nand2b_1
X_15674_ network.neuron_in099.counter\[2\] _04692_ VSS VSS
+ VDD VDD _04693_ sky130_fd_sc_hd__or2_2
X_15675_ net282 _04693_ VSS VSS VDD VDD _01408_ sky130_fd_sc_hd__nand2_1
X_15676_ network.neuron_in098.counter\[2\] network.neuron_in098.counter\[3\]
+ VSS VSS VDD VDD _04694_ sky130_fd_sc_hd__nor2_1
X_15677_ _00944_ _04694_ VSS VSS VDD VDD _04695_ sky130_fd_sc_hd__nand2_1
X_15678_ net282 _04695_ VSS VSS VDD VDD _01409_ sky130_fd_sc_hd__nand2_1
Xplace316 _07608_ VSS VSS VDD VDD net315 sky130_fd_sc_hd__buf_4
X_15680_ net282 _04417_ VSS VSS VDD VDD _01410_ sky130_fd_sc_hd__nand2_1
X_15681_ net282 _04422_ VSS VSS VDD VDD _01411_ sky130_fd_sc_hd__nand2_1
X_15682_ net281 _04425_ VSS VSS VDD VDD _01412_ sky130_fd_sc_hd__nand2_1
X_15683_ net281 _04429_ VSS VSS VDD VDD _01413_ sky130_fd_sc_hd__nand2_1
X_15684_ net281 _04432_ VSS VSS VDD VDD _01414_ sky130_fd_sc_hd__nand2_1
X_15685_ net281 _04435_ VSS VSS VDD VDD _01415_ sky130_fd_sc_hd__nand2_1
X_15686_ net281 _04438_ VSS VSS VDD VDD _01416_ sky130_fd_sc_hd__nand2_1
X_15687_ net281 _04443_ VSS VSS VDD VDD _01417_ sky130_fd_sc_hd__nand2_1
X_15688_ net281 _04446_ VSS VSS VDD VDD _01418_ sky130_fd_sc_hd__nand2_1
X_15689_ net278 _04449_ VSS VSS VDD VDD _01419_ sky130_fd_sc_hd__nand2_1
Xplace301 _03987_ VSS VSS VDD VDD net300 sky130_fd_sc_hd__buf_4
X_15691_ net278 _04453_ VSS VSS VDD VDD _01420_ sky130_fd_sc_hd__nand2_1
X_15692_ net278 _04457_ VSS VSS VDD VDD _01421_ sky130_fd_sc_hd__nand2_1
X_15693_ net278 _04461_ VSS VSS VDD VDD _01422_ sky130_fd_sc_hd__nand2_1
X_15694_ net278 _04464_ VSS VSS VDD VDD _01423_ sky130_fd_sc_hd__nand2_1
X_15695_ net278 _04467_ VSS VSS VDD VDD _01424_ sky130_fd_sc_hd__nand2_1
X_15696_ net278 _04470_ VSS VSS VDD VDD _01425_ sky130_fd_sc_hd__nand2_1
X_15697_ net278 _04473_ VSS VSS VDD VDD _01426_ sky130_fd_sc_hd__nand2_1
X_15698_ net278 _04477_ VSS VSS VDD VDD _01427_ sky130_fd_sc_hd__nand2_1
X_15699_ net278 _04481_ VSS VSS VDD VDD _01428_ sky130_fd_sc_hd__nand2_1
X_15700_ net279 _04485_ VSS VSS VDD VDD _01429_ sky130_fd_sc_hd__nand2_1
Xplace315 _07652_ VSS VSS VDD VDD net314 sky130_fd_sc_hd__buf_4
X_15702_ net279 _04488_ VSS VSS VDD VDD _01430_ sky130_fd_sc_hd__nand2_1
X_15703_ net278 _04492_ VSS VSS VDD VDD _01431_ sky130_fd_sc_hd__nand2_1
X_15704_ net279 _04495_ VSS VSS VDD VDD _01432_ sky130_fd_sc_hd__nand2_1
X_15705_ net279 _04387_ VSS VSS VDD VDD _01433_ sky130_fd_sc_hd__nand2_1
X_15706_ net279 _04499_ VSS VSS VDD VDD _01434_ sky130_fd_sc_hd__nand2_1
X_15707_ net279 _04502_ VSS VSS VDD VDD _01435_ sky130_fd_sc_hd__nand2_1
X_15708_ net279 _04505_ VSS VSS VDD VDD _01436_ sky130_fd_sc_hd__nand2_1
X_15709_ net279 _04381_ VSS VSS VDD VDD _01437_ sky130_fd_sc_hd__nand2_1
X_15710_ net279 _04367_ VSS VSS VDD VDD _01438_ sky130_fd_sc_hd__nand2_1
X_15711_ net279 _04364_ VSS VSS VDD VDD _01439_ sky130_fd_sc_hd__nand2_1
Xclkbuf_leaf_14_clk clknet_5_2__leaf_clk VSS VSS VDD VDD clknet_leaf_14_clk
+ sky130_fd_sc_hd__clkbuf_16
X_15713_ net279 _04307_ VSS VSS VDD VDD _01440_ sky130_fd_sc_hd__nand2_1
X_15714_ net279 _04314_ VSS VSS VDD VDD _01441_ sky130_fd_sc_hd__nand2_1
X_15715_ net278 _04311_ VSS VSS VDD VDD _01442_ sky130_fd_sc_hd__nand2_1
X_15716_ net278 _04273_ VSS VSS VDD VDD _01443_ sky130_fd_sc_hd__nand2_1
X_15717_ net281 _04281_ VSS VSS VDD VDD _01444_ sky130_fd_sc_hd__nand2_1
X_15718_ net281 _04269_ VSS VSS VDD VDD _01445_ sky130_fd_sc_hd__nand2_1
X_15719_ net281 _04287_ VSS VSS VDD VDD _01446_ sky130_fd_sc_hd__nand2_1
X_15720_ net281 _04245_ VSS VSS VDD VDD _01447_ sky130_fd_sc_hd__nand2_1
X_15721_ net281 _04253_ VSS VSS VDD VDD _01448_ sky130_fd_sc_hd__nand2_1
X_15722_ net281 _04241_ VSS VSS VDD VDD _01449_ sky130_fd_sc_hd__nand2_1
Xclkbuf_leaf_8_clk clknet_5_3__leaf_clk VSS VSS VDD VDD clknet_leaf_8_clk
+ sky130_fd_sc_hd__clkbuf_16
X_15724_ net281 _04165_ VSS VSS VDD VDD _01450_ sky130_fd_sc_hd__nand2_1
X_15725_ net281 _04184_ VSS VSS VDD VDD _01451_ sky130_fd_sc_hd__nand2_1
X_15726_ net281 _04162_ VSS VSS VDD VDD _01452_ sky130_fd_sc_hd__nand2_1
X_15727_ net281 _04193_ VSS VSS VDD VDD _01453_ sky130_fd_sc_hd__nand2_1
X_15728_ net281 _04176_ VSS VSS VDD VDD _01454_ sky130_fd_sc_hd__nand2_1
X_15729_ net281 _04156_ VSS VSS VDD VDD _01455_ sky130_fd_sc_hd__nand2_1
X_15730_ net281 _04151_ VSS VSS VDD VDD _01456_ sky130_fd_sc_hd__nand2_1
X_15731_ net281 _04128_ VSS VSS VDD VDD _01457_ sky130_fd_sc_hd__nand2_1
X_15732_ net281 _04124_ VSS VSS VDD VDD _01458_ sky130_fd_sc_hd__nand2_1
X_15733_ net281 _04117_ VSS VSS VDD VDD _01459_ sky130_fd_sc_hd__nand2_1
Xclkbuf_leaf_13_clk clknet_5_2__leaf_clk VSS VSS VDD VDD clknet_leaf_13_clk
+ sky130_fd_sc_hd__clkbuf_16
X_15735_ net282 _04060_ VSS VSS VDD VDD _01460_ sky130_fd_sc_hd__nand2_1
X_15736_ net282 _04055_ VSS VSS VDD VDD _01461_ sky130_fd_sc_hd__nand2_1
X_15737_ net282 _04049_ VSS VSS VDD VDD _01462_ sky130_fd_sc_hd__nand2_1
X_15738_ net282 _04045_ VSS VSS VDD VDD _01463_ sky130_fd_sc_hd__nand2_1
X_15739_ net279 _03742_ VSS VSS VDD VDD _01464_ sky130_fd_sc_hd__nand2_1
X_15740_ net278 _03774_ VSS VSS VDD VDD _01465_ sky130_fd_sc_hd__nand2_1
X_15741_ net279 _03745_ VSS VSS VDD VDD _01466_ sky130_fd_sc_hd__nand2_1
X_15742_ net278 _03760_ VSS VSS VDD VDD _01467_ sky130_fd_sc_hd__nand2_1
X_15743_ net278 _03756_ VSS VSS VDD VDD _01468_ sky130_fd_sc_hd__nand2_1
X_15744_ net278 _03735_ VSS VSS VDD VDD _01469_ sky130_fd_sc_hd__nand2_1
X_15745_ net279 _03710_ VSS VSS VDD VDD _01470_ sky130_fd_sc_hd__nand2_1
X_15746_ net279 _03730_ VSS VSS VDD VDD _01471_ sky130_fd_sc_hd__nand2_1
X_15747_ _03678_ net279 VSS VSS VDD VDD _01472_ sky130_fd_sc_hd__nand2_1
X_15748_ _03673_ net278 VSS VSS VDD VDD _01473_ sky130_fd_sc_hd__nand2_1
X_15749_ _03647_ net279 VSS VSS VDD VDD _01474_ sky130_fd_sc_hd__nand2_1
X_15750_ _03635_ net278 VSS VSS VDD VDD _01475_ sky130_fd_sc_hd__nand2_1
X_15751_ _03651_ net281 VSS VSS VDD VDD _01476_ sky130_fd_sc_hd__nand2_1
X_15752_ _07547_ net280 VSS VSS VDD VDD _01477_ sky130_fd_sc_hd__nand2_1
X_15753_ _07535_ net280 VSS VSS VDD VDD _01478_ sky130_fd_sc_hd__nand2_1
X_15754_ net280 _04568_ VSS VSS VDD VDD _01479_ sky130_fd_sc_hd__nand2_1
X_15755_ _03630_ net281 VSS VSS VDD VDD _01480_ sky130_fd_sc_hd__nand2_1
Xclkbuf_leaf_17_clk clknet_5_2__leaf_clk VSS VSS VDD VDD clknet_leaf_17_clk
+ sky130_fd_sc_hd__clkbuf_16
X_15757_ _03625_ net281 VSS VSS VDD VDD _01481_ sky130_fd_sc_hd__nand2_1
X_15758_ _03620_ net281 VSS VSS VDD VDD _01482_ sky130_fd_sc_hd__nand2_1
X_15759_ _03593_ net281 VSS VSS VDD VDD _01483_ sky130_fd_sc_hd__nand2_1
X_15760_ _03584_ net281 VSS VSS VDD VDD _01484_ sky130_fd_sc_hd__nand2_1
X_15761_ _03575_ net281 VSS VSS VDD VDD _01485_ sky130_fd_sc_hd__nand2_1
X_15762_ _03563_ net281 VSS VSS VDD VDD _01486_ sky130_fd_sc_hd__nand2_1
X_15763_ _03557_ net281 VSS VSS VDD VDD _01487_ sky130_fd_sc_hd__nand2_1
X_15764_ _03544_ net281 VSS VSS VDD VDD _01488_ sky130_fd_sc_hd__nand2_1
X_15765_ _03535_ net281 VSS VSS VDD VDD _01489_ sky130_fd_sc_hd__nand2_1
X_15766_ _03526_ net281 VSS VSS VDD VDD _01490_ sky130_fd_sc_hd__nand2_1
Xclkbuf_leaf_16_clk clknet_5_2__leaf_clk VSS VSS VDD VDD clknet_leaf_16_clk
+ sky130_fd_sc_hd__clkbuf_16
X_15768_ _03516_ net281 VSS VSS VDD VDD _01491_ sky130_fd_sc_hd__nand2_1
X_15769_ _03490_ net278 VSS VSS VDD VDD _01492_ sky130_fd_sc_hd__nand2_1
X_15770_ _03500_ net278 VSS VSS VDD VDD _01493_ sky130_fd_sc_hd__nand2_1
X_15771_ _03486_ net278 VSS VSS VDD VDD _01494_ sky130_fd_sc_hd__nand2_1
X_15772_ _03476_ net278 VSS VSS VDD VDD _01495_ sky130_fd_sc_hd__nand2_1
X_15773_ _03470_ net278 VSS VSS VDD VDD _01496_ sky130_fd_sc_hd__nand2_1
X_15774_ _03460_ net278 VSS VSS VDD VDD _01497_ sky130_fd_sc_hd__nand2_1
X_15775_ _03450_ net278 VSS VSS VDD VDD _01498_ sky130_fd_sc_hd__nand2_1
X_15776_ _03444_ net278 VSS VSS VDD VDD _01499_ sky130_fd_sc_hd__nand2_1
X_15777_ _08282_ net278 VSS VSS VDD VDD _01500_ sky130_fd_sc_hd__nand2_1
X_15778_ _08274_ net278 VSS VSS VDD VDD _01501_ sky130_fd_sc_hd__nand2_1
X_15779_ _08249_ net278 VSS VSS VDD VDD _01502_ sky130_fd_sc_hd__nand2_1
X_15780_ _08244_ net278 VSS VSS VDD VDD _01503_ sky130_fd_sc_hd__nand2_1
X_15781_ _08240_ net278 VSS VSS VDD VDD _01504_ sky130_fd_sc_hd__nand2_1
X_15782_ _08220_ net278 VSS VSS VDD VDD _01505_ sky130_fd_sc_hd__nand2_1
X_15783_ _08230_ net279 VSS VSS VDD VDD _01506_ sky130_fd_sc_hd__nand2_1
X_15784_ _08205_ net278 VSS VSS VDD VDD _01507_ sky130_fd_sc_hd__nand2_1
X_15785_ _08818_ _08992_ VSS VSS VDD VDD _04704_ sky130_fd_sc_hd__or2_2
X_15786_ network.in_spk12_14 _04704_ VSS VSS VDD VDD _04705_
+ sky130_fd_sc_hd__nand2_1
X_15787_ _06991_ _04705_ net374 VSS VSS VDD VDD _01869_ sky130_fd_sc_hd__a21oi_1
X_15788_ network.neuron_in071.counter\[0\] VSS VSS VDD VDD
+ _00133_ sky130_fd_sc_hd__inv_1
X_15789_ net398 _04505_ VSS VSS VDD VDD _04706_ sky130_fd_sc_hd__nand2_1
X_15790_ network.in_period\[71\]\[0\] _04706_ VSS VSS VDD
+ VDD _04707_ sky130_fd_sc_hd__nand2_1
X_15791_ network.neuron_in071.counter\[0\] _04706_ _04707_
+ VSS VSS VDD VDD _02348_ sky130_fd_sc_hd__o21ai_0
X_15792_ net398 _04502_ VSS VSS VDD VDD _04708_ sky130_fd_sc_hd__nand2_1
X_15793_ network.in_period\[72\]\[1\] _04708_ VSS VSS VDD
+ VDD _04709_ sky130_fd_sc_hd__nand2_1
X_15794_ _00532_ _04708_ _04709_ VSS VSS VDD VDD _02353_ sky130_fd_sc_hd__o21ai_0
X_15795_ network.in_spk08_14 _08992_ VSS VSS VDD VDD _04710_
+ sky130_fd_sc_hd__nand2_1
X_15796_ _07006_ _04710_ net374 VSS VSS VDD VDD _01870_ sky130_fd_sc_hd__a21oi_1
X_15797_ _03997_ _04026_ VSS VSS VDD VDD _03144_ sky130_fd_sc_hd__nor2_1
X_15798_ network.neuron_in073.counter\[2\] _00202_ VSS VSS
+ VDD VDD _04711_ sky130_fd_sc_hd__xnor2_1
X_15799_ net395 _04499_ network.in_period\[73\]\[2\] VSS VSS
+ VDD VDD _04712_ sky130_fd_sc_hd__a21oi_1
X_15800_ net395 _04711_ _04712_ VSS VSS VDD VDD _02358_ sky130_fd_sc_hd__a21oi_1
X_15801_ _03991_ _04015_ VSS VSS VDD VDD _03229_ sky130_fd_sc_hd__nor2_1
X_15802_ network.in_spk08_14 _08992_ network.in_spk09_14 VSS
+ VSS VDD VDD _04713_ sky130_fd_sc_hd__o21ai_0
X_15803_ _06996_ _04713_ net374 VSS VSS VDD VDD _01871_ sky130_fd_sc_hd__a21oi_1
X_15804_ _04007_ _04017_ VSS VSS VDD VDD _03271_ sky130_fd_sc_hd__nor2_1
X_15805_ network.neuron_in077.counter\[0\] VSS VSS VDD VDD
+ _00101_ sky130_fd_sc_hd__inv_1
X_15806_ net288 _04030_ VSS VSS VDD VDD _03173_ sky130_fd_sc_hd__nor2_1
X_15807_ network.in_spk09_14 network.in_spk08_14 _08992_ network.in_spk10_14
+ VSS VSS VDD VDD _04714_ sky130_fd_sc_hd__o31ai_1
Xclkbuf_leaf_12_clk clknet_5_2__leaf_clk VSS VSS VDD VDD clknet_leaf_12_clk
+ sky130_fd_sc_hd__clkbuf_16
X_15809_ _07035_ _04714_ net374 VSS VSS VDD VDD _01872_ sky130_fd_sc_hd__a21oi_1
X_15810_ _03997_ net288 VSS VSS VDD VDD _03179_ sky130_fd_sc_hd__nor2_1
X_15811_ network.in_spk10_14 network.in_spk09_14 network.in_spk08_14
+ _08992_ network.in_spk11_14 VSS VSS VDD VDD _04716_ sky130_fd_sc_hd__o41ai_1
X_15812_ _07283_ _04716_ net374 VSS VSS VDD VDD _01873_ sky130_fd_sc_hd__a21oi_1
X_15813_ _03999_ _04028_ VSS VSS VDD VDD _03124_ sky130_fd_sc_hd__nor2_1
X_15814_ network.in_spk12_14 _04704_ network.in_spk13_14 VSS
+ VSS VDD VDD _04717_ sky130_fd_sc_hd__o21ai_0
X_15815_ _07391_ _04717_ net374 VSS VSS VDD VDD _01874_ sky130_fd_sc_hd__a21oi_1
X_15816_ _00548_ _08223_ _00547_ VSS VSS VDD VDD _04718_ sky130_fd_sc_hd__nand3_1
X_15817_ net379 _08204_ _04718_ VSS VSS VDD VDD _04719_ sky130_fd_sc_hd__nor3_1
X_15818_ network.in_period\[0\]\[3\] _08204_ _04719_ VSS VSS
+ VDD VDD _04720_ sky130_fd_sc_hd__a21oi_1
Xclkbuf_leaf_11_clk clknet_5_2__leaf_clk VSS VSS VDD VDD clknet_leaf_11_clk
+ sky130_fd_sc_hd__clkbuf_16
Xclkbuf_leaf_7_clk clknet_5_1__leaf_clk VSS VSS VDD VDD clknet_leaf_7_clk
+ sky130_fd_sc_hd__clkbuf_16
Xclkbuf_leaf_9_clk clknet_5_3__leaf_clk VSS VSS VDD VDD clknet_leaf_9_clk
+ sky130_fd_sc_hd__clkbuf_16
X_15822_ network.in_period\[0\]\[3\] net379 VSS VSS VDD VDD
+ _04724_ sky130_fd_sc_hd__and2_1
X_15823_ network.neuron_in000.counter\[3\] net395 _04718_
+ _04724_ VSS VSS VDD VDD _04725_ sky130_fd_sc_hd__a31oi_1
X_15824_ network.neuron_in000.counter\[3\] _04720_ _04725_
+ VSS VSS VDD VDD _02067_ sky130_fd_sc_hd__o21ai_0
X_15825_ net304 _09114_ VSS VSS VDD VDD _04726_ sky130_fd_sc_hd__nand2_1
X_15826_ _08925_ _04726_ network.in_spk01_14 VSS VSS VDD VDD
+ _04727_ sky130_fd_sc_hd__o21ai_0
X_15827_ _06978_ _04727_ net375 VSS VSS VDD VDD _01875_ sky130_fd_sc_hd__a21oi_1
X_15828_ network.in_spk13_14 network.in_spk12_14 _04704_ network.in_spk14_14
+ VSS VSS VDD VDD _04728_ sky130_fd_sc_hd__o31ai_1
X_15829_ _07396_ _04728_ net374 VSS VSS VDD VDD _01876_ sky130_fd_sc_hd__a21oi_1
Xplace459 net18 VSS VSS VDD VDD net458 sky130_fd_sc_hd__buf_4
X_15831_ network.neuron_in001.counter\[0\] network.neuron_in001.counter\[2\]
+ network.neuron_in001.counter\[1\] VSS VSS VDD VDD _04730_
+ sky130_fd_sc_hd__or3_1
X_15832_ net379 _08229_ _04730_ VSS VSS VDD VDD _04731_ sky130_fd_sc_hd__nor3_1
X_15833_ network.in_period\[1\]\[3\] _08229_ _04731_ VSS VSS
+ VDD VDD _04732_ sky130_fd_sc_hd__a21oi_1
X_15834_ network.in_period\[1\]\[3\] net379 VSS VSS VDD VDD
+ _04733_ sky130_fd_sc_hd__and2_1
X_15835_ network.neuron_in001.counter\[3\] net398 _04730_
+ _04733_ VSS VSS VDD VDD _04734_ sky130_fd_sc_hd__a31oi_1
X_15836_ network.neuron_in001.counter\[3\] _04732_ _04734_
+ VSS VSS VDD VDD _02071_ sky130_fd_sc_hd__o21ai_0
X_15837_ network.in_period\[71\]\[1\] _04706_ VSS VSS VDD
+ VDD _04735_ sky130_fd_sc_hd__nand2_1
X_15838_ _00136_ _04706_ _04735_ VSS VSS VDD VDD _02349_ sky130_fd_sc_hd__o21ai_0
X_15839_ _08819_ _04704_ network.in_spk15_14 VSS VSS VDD VDD
+ _04736_ sky130_fd_sc_hd__o21ai_0
X_15840_ _07401_ _04736_ net374 VSS VSS VDD VDD _01877_ sky130_fd_sc_hd__a21oi_1
X_15841_ network.neuron_in002.counter\[0\] network.neuron_in002.counter\[1\]
+ network.neuron_in002.counter\[2\] VSS VSS VDD VDD _04737_
+ sky130_fd_sc_hd__or3_1
X_15842_ net379 _08219_ _04737_ VSS VSS VDD VDD _04738_ sky130_fd_sc_hd__nor3_1
X_15843_ network.in_period\[2\]\[3\] _08219_ _04738_ VSS VSS
+ VDD VDD _04739_ sky130_fd_sc_hd__a21oi_1
X_15844_ network.in_period\[2\]\[3\] net379 VSS VSS VDD VDD
+ _04740_ sky130_fd_sc_hd__and2_1
X_15845_ network.neuron_in002.counter\[3\] net395 _04737_
+ _04740_ VSS VSS VDD VDD _04741_ sky130_fd_sc_hd__a31oi_1
X_15846_ network.neuron_in002.counter\[3\] _04739_ _04741_
+ VSS VSS VDD VDD _02075_ sky130_fd_sc_hd__o21ai_0
X_15847_ network.in_spk00_14 _08946_ VSS VSS VDD VDD _04742_
+ sky130_fd_sc_hd__nand2_1
X_15848_ _06916_ _04742_ net375 VSS VSS VDD VDD _01878_ sky130_fd_sc_hd__a21oi_1
X_15849_ network.in_spk00_15 _08935_ VSS VSS VDD VDD _04743_
+ sky130_fd_sc_hd__nand2_1
X_15850_ _07405_ _04743_ net368 VSS VSS VDD VDD _01879_ sky130_fd_sc_hd__a21oi_1
X_15851_ network.neuron_in003.counter\[0\] network.neuron_in003.counter\[1\]
+ network.neuron_in003.counter\[2\] VSS VSS VDD VDD _04744_
+ sky130_fd_sc_hd__nor3_1
X_15852_ network.neuron_in003.counter\[3\] _04744_ VSS VSS
+ VDD VDD _04745_ sky130_fd_sc_hd__xnor2_1
X_15853_ network.in_period\[3\]\[3\] _08241_ VSS VSS VDD VDD
+ _04746_ sky130_fd_sc_hd__nand2_1
X_15854_ _08241_ _04745_ _04746_ VSS VSS VDD VDD _02079_ sky130_fd_sc_hd__o21ai_0
X_15855_ network.in_spk00_15 _08935_ network.in_spk01_15 VSS
+ VSS VDD VDD _04747_ sky130_fd_sc_hd__o21ai_0
X_15856_ _07553_ _04747_ net368 VSS VSS VDD VDD _01880_ sky130_fd_sc_hd__a21oi_1
X_15857_ network.neuron_in004.counter\[0\] network.neuron_in004.counter\[1\]
+ network.neuron_in004.counter\[2\] VSS VSS VDD VDD _04748_
+ sky130_fd_sc_hd__or3_1
X_15858_ net379 _08243_ _04748_ VSS VSS VDD VDD _04749_ sky130_fd_sc_hd__nor3_1
X_15859_ network.in_period\[4\]\[3\] _08243_ _04749_ VSS VSS
+ VDD VDD _04750_ sky130_fd_sc_hd__a21oi_1
X_15860_ network.in_period\[4\]\[3\] net379 VSS VSS VDD VDD
+ _04751_ sky130_fd_sc_hd__and2_1
X_15861_ network.neuron_in004.counter\[3\] net395 _04748_
+ _04751_ VSS VSS VDD VDD _04752_ sky130_fd_sc_hd__a31oi_1
X_15862_ network.neuron_in004.counter\[3\] _04750_ _04752_
+ VSS VSS VDD VDD _02083_ sky130_fd_sc_hd__o21ai_0
X_15863_ network.neuron_in072.counter\[2\] VSS VSS VDD VDD
+ _04753_ sky130_fd_sc_hd__inv_1
Xclkbuf_leaf_6_clk clknet_5_1__leaf_clk VSS VSS VDD VDD clknet_leaf_6_clk
+ sky130_fd_sc_hd__clkbuf_16
X_15865_ network.neuron_in072.counter\[3\] network.in_period\[72\]\[2\]
+ net378 _00531_ VSS VSS VDD VDD _04755_ sky130_fd_sc_hd__o22ai_1
X_15866_ network.neuron_in072.counter\[2\] _00531_ net398
+ VSS VSS VDD VDD _04756_ sky130_fd_sc_hd__nand3_1
X_15867_ network.in_period\[72\]\[2\] net398 _04756_ VSS VSS
+ VDD VDD _04757_ sky130_fd_sc_hd__o21ai_0
X_15868_ _04753_ _04755_ _04757_ VSS VSS VDD VDD _02354_ sky130_fd_sc_hd__a21oi_1
X_15869_ _08925_ _09231_ _08972_ VSS VSS VDD VDD _04758_ sky130_fd_sc_hd__or3_1
X_15870_ network.in_spk12_13 network.in_spk13_13 _04758_ VSS
+ VSS VDD VDD _04759_ sky130_fd_sc_hd__or3_1
X_15871_ network.in_spk14_13 _04759_ network.in_spk15_13 VSS
+ VSS VDD VDD _04760_ sky130_fd_sc_hd__o21ai_1
X_15872_ _06972_ _04760_ net381 VSS VSS VDD VDD _01881_ sky130_fd_sc_hd__a21oi_1
X_15873_ _09028_ _09032_ VSS VSS VDD VDD _04761_ sky130_fd_sc_hd__nand2_1
X_15874_ network.in_spk02_15 _04761_ VSS VSS VDD VDD _04762_
+ sky130_fd_sc_hd__nand2_1
Xclkbuf_leaf_10_clk clknet_5_3__leaf_clk VSS VSS VDD VDD clknet_leaf_10_clk
+ sky130_fd_sc_hd__clkbuf_16
X_15876_ _07560_ _04762_ net368 VSS VSS VDD VDD _01882_ sky130_fd_sc_hd__a21oi_1
X_15877_ network.neuron_in005.counter\[1\] network.neuron_in005.counter\[0\]
+ network.neuron_in005.counter\[2\] VSS VSS VDD VDD _04764_
+ sky130_fd_sc_hd__nor3_1
X_15878_ network.neuron_in005.counter\[3\] _04764_ VSS VSS
+ VDD VDD _04765_ sky130_fd_sc_hd__xnor2_1
X_15879_ network.in_period\[5\]\[3\] _08262_ VSS VSS VDD VDD
+ _04766_ sky130_fd_sc_hd__nand2_1
X_15880_ _08262_ _04765_ _04766_ VSS VSS VDD VDD _02087_ sky130_fd_sc_hd__o21ai_0
X_15881_ network.in_period\[72\]\[0\] _04708_ VSS VSS VDD
+ VDD _04767_ sky130_fd_sc_hd__nand2_1
X_15882_ network.neuron_in072.counter\[0\] _04708_ _04767_
+ VSS VSS VDD VDD _02352_ sky130_fd_sc_hd__o21ai_0
X_15883_ network.in_spk02_15 _04761_ network.in_spk03_15 VSS
+ VSS VDD VDD _04768_ sky130_fd_sc_hd__o21ai_0
X_15884_ _07431_ _04768_ net368 VSS VSS VDD VDD _01883_ sky130_fd_sc_hd__a21oi_1
X_15885_ _00510_ _08269_ _00509_ VSS VSS VDD VDD _04769_ sky130_fd_sc_hd__nand3_1
X_15886_ net379 _08273_ _04769_ VSS VSS VDD VDD _04770_ sky130_fd_sc_hd__nor3_1
X_15887_ network.in_period\[6\]\[3\] _08273_ _04770_ VSS VSS
+ VDD VDD _04771_ sky130_fd_sc_hd__a21oi_1
X_15888_ network.in_period\[6\]\[3\] net379 VSS VSS VDD VDD
+ _04772_ sky130_fd_sc_hd__and2_1
X_15889_ network.neuron_in006.counter\[3\] net395 _04769_
+ _04772_ VSS VSS VDD VDD _04773_ sky130_fd_sc_hd__a31oi_1
X_15890_ network.neuron_in006.counter\[3\] _04771_ _04773_
+ VSS VSS VDD VDD _02091_ sky130_fd_sc_hd__o21ai_0
X_15891_ network.in_spk14_13 _04759_ VSS VSS VDD VDD _04774_
+ sky130_fd_sc_hd__nand2_1
X_15892_ _06885_ _04774_ net381 VSS VSS VDD VDD _01884_ sky130_fd_sc_hd__a21oi_1
X_15893_ network.in_spk04_15 _09041_ VSS VSS VDD VDD _04775_
+ sky130_fd_sc_hd__nand2_1
X_15894_ _07444_ _04775_ net368 VSS VSS VDD VDD _01885_ sky130_fd_sc_hd__a21oi_1
X_15895_ network.neuron_in007.counter\[2\] network.neuron_in007.counter\[1\]
+ network.neuron_in007.counter\[0\] VSS VSS VDD VDD _04776_
+ sky130_fd_sc_hd__nor3_1
X_15896_ network.neuron_in007.counter\[3\] _04776_ VSS VSS
+ VDD VDD _04777_ sky130_fd_sc_hd__xnor2_1
X_15897_ network.in_period\[7\]\[3\] _08284_ VSS VSS VDD VDD
+ _04778_ sky130_fd_sc_hd__nand2_1
X_15898_ _08284_ _04777_ _04778_ VSS VSS VDD VDD _02095_ sky130_fd_sc_hd__o21ai_0
X_15899_ network.in_spk03_15 network.in_spk02_15 _04761_ VSS
+ VSS VDD VDD _04779_ sky130_fd_sc_hd__nor3_1
X_15900_ network.in_spk05_15 VSS VSS VDD VDD _04780_ sky130_fd_sc_hd__inv_1
X_15901_ _04780_ _07435_ net368 VSS VSS VDD VDD _04781_ sky130_fd_sc_hd__a21o_1
X_15902_ _09330_ _07435_ _04779_ _04781_ VSS VSS VDD VDD _01886_
+ sky130_fd_sc_hd__a31oi_1
X_15903_ _00464_ _03439_ _00465_ VSS VSS VDD VDD _04782_ sky130_fd_sc_hd__nand3_1
X_15904_ net377 _03443_ _04782_ VSS VSS VDD VDD _04783_ sky130_fd_sc_hd__nor3_1
X_15905_ network.in_period\[8\]\[3\] _03443_ _04783_ VSS VSS
+ VDD VDD _04784_ sky130_fd_sc_hd__a21oi_1
X_15906_ network.in_period\[8\]\[3\] net377 VSS VSS VDD VDD
+ _04785_ sky130_fd_sc_hd__and2_1
X_15907_ network.neuron_in008.counter\[3\] net396 _04782_
+ _04785_ VSS VSS VDD VDD _04786_ sky130_fd_sc_hd__a31oi_1
X_15908_ network.neuron_in008.counter\[3\] _04784_ _04786_
+ VSS VSS VDD VDD _02099_ sky130_fd_sc_hd__o21ai_0
X_15909_ network.in_spk12_13 _04758_ network.in_spk13_13 VSS
+ VSS VDD VDD _04787_ sky130_fd_sc_hd__o21ai_0
X_15910_ _06906_ _04787_ net381 VSS VSS VDD VDD _01887_ sky130_fd_sc_hd__a21oi_1
X_15911_ _07964_ VSS VSS VDD VDD _04788_ sky130_fd_sc_hd__inv_1
X_15912_ network.in_spk06_15 _04788_ net399 VSS VSS VDD VDD
+ _04789_ sky130_fd_sc_hd__o21ai_0
X_15913_ _07964_ _08839_ _04779_ _04789_ VSS VSS VDD VDD _01888_
+ sky130_fd_sc_hd__a31oi_1
X_15914_ network.neuron_in009.counter\[2\] network.neuron_in009.counter\[1\]
+ network.neuron_in009.counter\[0\] VSS VSS VDD VDD _04790_
+ sky130_fd_sc_hd__nor3_1
X_15915_ network.neuron_in009.counter\[3\] _04790_ VSS VSS
+ VDD VDD _04791_ sky130_fd_sc_hd__xnor2_1
X_15916_ network.in_period\[9\]\[3\] _03452_ VSS VSS VDD VDD
+ _04792_ sky130_fd_sc_hd__nand2_1
X_15917_ _03452_ _04791_ _04792_ VSS VSS VDD VDD _02103_ sky130_fd_sc_hd__o21ai_0
Xplace329 _08844_ VSS VSS VDD VDD net328 sky130_fd_sc_hd__buf_4
X_15919_ net395 _04499_ VSS VSS VDD VDD _04794_ sky130_fd_sc_hd__nand2_1
X_15920_ network.in_period\[73\]\[1\] _04794_ VSS VSS VDD
+ VDD _04795_ sky130_fd_sc_hd__nand2_1
X_15921_ _00203_ _04794_ _04795_ VSS VSS VDD VDD _02357_ sky130_fd_sc_hd__o21ai_0
X_15922_ _08838_ _09029_ VSS VSS VDD VDD _04796_ sky130_fd_sc_hd__nand2_1
X_15923_ _04796_ _04761_ network.in_spk07_15 VSS VSS VDD VDD
+ _04797_ sky130_fd_sc_hd__o21ai_0
X_15924_ _07954_ _04797_ net368 VSS VSS VDD VDD _01889_ sky130_fd_sc_hd__a21oi_1
X_15925_ _00434_ _00435_ _03455_ VSS VSS VDD VDD _04798_ sky130_fd_sc_hd__nand3_1
X_15926_ net377 _03459_ _04798_ VSS VSS VDD VDD _04799_ sky130_fd_sc_hd__nor3_1
X_15927_ network.in_period\[10\]\[3\] _03459_ _04799_ VSS
+ VSS VDD VDD _04800_ sky130_fd_sc_hd__a21oi_1
X_15928_ network.in_period\[10\]\[3\] net377 VSS VSS VDD VDD
+ _04801_ sky130_fd_sc_hd__and2_1
X_15929_ network.neuron_in010.counter\[3\] net396 _04798_
+ _04801_ VSS VSS VDD VDD _04802_ sky130_fd_sc_hd__a31oi_1
X_15930_ network.neuron_in010.counter\[3\] _04800_ _04802_
+ VSS VSS VDD VDD _02107_ sky130_fd_sc_hd__o21ai_0
X_15931_ network.in_period\[73\]\[0\] _04794_ VSS VSS VDD
+ VDD _04803_ sky130_fd_sc_hd__nand2_1
X_15932_ network.neuron_in073.counter\[0\] _04794_ _04803_
+ VSS VSS VDD VDD _02356_ sky130_fd_sc_hd__o21ai_0
X_15933_ network.in_spk12_13 _04758_ VSS VSS VDD VDD _04804_
+ sky130_fd_sc_hd__nand2_1
X_15934_ _06881_ _04804_ net381 VSS VSS VDD VDD _01890_ sky130_fd_sc_hd__a21oi_1
X_15935_ network.in_spk08_15 _09033_ VSS VSS VDD VDD _04805_
+ sky130_fd_sc_hd__nand2_1
X_15936_ _07969_ _04805_ net381 VSS VSS VDD VDD _01891_ sky130_fd_sc_hd__a21oi_1
Xplace328 _08845_ VSS VSS VDD VDD net327 sky130_fd_sc_hd__buf_4
X_15938_ network.neuron_in011.counter\[0\] network.neuron_in011.counter\[1\]
+ _00440_ VSS VSS VDD VDD _04807_ sky130_fd_sc_hd__o21bai_1
X_15939_ _03464_ _04807_ network.neuron_in011.counter\[3\]
+ VSS VSS VDD VDD _04808_ sky130_fd_sc_hd__a21oi_1
X_15940_ _03464_ _00438_ _00439_ network.neuron_in011.counter\[3\]
+ _04808_ VSS VSS VDD VDD _04809_ sky130_fd_sc_hd__a41o_1
X_15941_ net396 _03469_ network.in_period\[11\]\[3\] VSS VSS
+ VDD VDD _04810_ sky130_fd_sc_hd__a21oi_1
X_15942_ net396 _04809_ _04810_ VSS VSS VDD VDD _02111_ sky130_fd_sc_hd__a21oi_1
X_15943_ network.in_spk08_15 _09033_ network.in_spk09_15 VSS
+ VSS VDD VDD _04811_ sky130_fd_sc_hd__o21ai_0
X_15944_ _07959_ _04811_ net381 VSS VSS VDD VDD _01892_ sky130_fd_sc_hd__a21oi_1
X_15945_ network.neuron_in012.counter\[1\] network.neuron_in012.counter\[2\]
+ network.neuron_in012.counter\[0\] VSS VSS VDD VDD _04812_
+ sky130_fd_sc_hd__nor3_1
X_15946_ network.neuron_in012.counter\[3\] _04812_ VSS VSS
+ VDD VDD _04813_ sky130_fd_sc_hd__xnor2_1
X_15947_ network.in_period\[12\]\[3\] _03478_ VSS VSS VDD
+ VDD _04814_ sky130_fd_sc_hd__nand2_1
X_15948_ _03478_ _04813_ _04814_ VSS VSS VDD VDD _02115_ sky130_fd_sc_hd__o21ai_0
X_15949_ network.in_spk08_13 network.in_spk09_13 _09027_ VSS
+ VSS VDD VDD _04815_ sky130_fd_sc_hd__or3_1
X_15950_ network.in_spk10_13 _04815_ network.in_spk11_13 VSS
+ VSS VDD VDD _04816_ sky130_fd_sc_hd__o21ai_0
X_15951_ _06959_ _04816_ net368 VSS VSS VDD VDD _01893_ sky130_fd_sc_hd__a21oi_1
X_15952_ network.in_spk09_15 network.in_spk08_15 _09033_ network.in_spk10_15
+ VSS VSS VDD VDD _04817_ sky130_fd_sc_hd__o31ai_1
Xplace331 _07692_ VSS VSS VDD VDD net330 sky130_fd_sc_hd__buf_4
X_15954_ _07974_ _04817_ net381 VSS VSS VDD VDD _01894_ sky130_fd_sc_hd__a21oi_1
X_15955_ _00423_ _03481_ _00422_ VSS VSS VDD VDD _04819_ sky130_fd_sc_hd__nand3_1
X_15956_ net371 _03485_ _04819_ VSS VSS VDD VDD _04820_ sky130_fd_sc_hd__nor3_1
X_15957_ network.in_period\[13\]\[3\] _03485_ _04820_ VSS
+ VSS VDD VDD _04821_ sky130_fd_sc_hd__a21oi_1
X_15958_ network.in_period\[13\]\[3\] net371 VSS VSS VDD VDD
+ _04822_ sky130_fd_sc_hd__and2_1
X_15959_ network.neuron_in013.counter\[3\] net387 _04819_
+ _04822_ VSS VSS VDD VDD _04823_ sky130_fd_sc_hd__a31oi_1
X_15960_ network.neuron_in013.counter\[3\] _04821_ _04823_
+ VSS VSS VDD VDD _02119_ sky130_fd_sc_hd__o21ai_0
X_15961_ _09038_ _09033_ network.in_spk11_15 VSS VSS VDD VDD
+ _04824_ sky130_fd_sc_hd__o21ai_0
X_15962_ _07950_ _04824_ net381 VSS VSS VDD VDD _01895_ sky130_fd_sc_hd__a21oi_1
X_15963_ network.neuron_in014.counter\[0\] network.neuron_in014.counter\[2\]
+ network.neuron_in014.counter\[1\] VSS VSS VDD VDD _04825_
+ sky130_fd_sc_hd__nor3_1
X_15964_ network.neuron_in014.counter\[3\] _04825_ VSS VSS
+ VDD VDD _04826_ sky130_fd_sc_hd__xnor2_1
X_15965_ network.in_period\[14\]\[3\] _03501_ VSS VSS VDD
+ VDD _04827_ sky130_fd_sc_hd__nand2_1
X_15966_ _03501_ _04826_ _04827_ VSS VSS VDD VDD _02123_ sky130_fd_sc_hd__o21ai_0
X_15967_ network.in_spk10_13 _04815_ VSS VSS VDD VDD _04828_
+ sky130_fd_sc_hd__nand2_1
X_15968_ _06778_ _04828_ net368 VSS VSS VDD VDD _01896_ sky130_fd_sc_hd__a21oi_1
X_15969_ _08842_ _09032_ VSS VSS VDD VDD _04829_ sky130_fd_sc_hd__nand2_1
X_15970_ network.in_spk12_15 _04829_ VSS VSS VDD VDD _04830_
+ sky130_fd_sc_hd__nand2_1
X_15971_ _08005_ _04830_ net381 VSS VSS VDD VDD _01897_ sky130_fd_sc_hd__a21oi_1
X_15972_ network.neuron_in015.counter\[1\] network.neuron_in015.counter\[0\]
+ network.neuron_in015.counter\[2\] VSS VSS VDD VDD _04831_
+ sky130_fd_sc_hd__nor3_1
X_15973_ network.neuron_in015.counter\[3\] _04831_ VSS VSS
+ VDD VDD _04832_ sky130_fd_sc_hd__xnor2_1
X_15974_ network.in_period\[15\]\[3\] _03491_ VSS VSS VDD
+ VDD _04833_ sky130_fd_sc_hd__nand2_1
X_15975_ _03491_ _04832_ _04833_ VSS VSS VDD VDD _02127_ sky130_fd_sc_hd__o21ai_0
X_15976_ network.in_spk12_15 _04829_ network.in_spk13_15 VSS
+ VSS VDD VDD _04834_ sky130_fd_sc_hd__o21ai_0
X_15977_ _08000_ _04834_ net381 VSS VSS VDD VDD _01898_ sky130_fd_sc_hd__a21oi_1
X_15978_ network.neuron_in016.counter\[0\] network.neuron_in016.counter\[2\]
+ network.neuron_in016.counter\[1\] VSS VSS VDD VDD _04835_
+ sky130_fd_sc_hd__or3_1
X_15979_ net371 _03515_ _04835_ VSS VSS VDD VDD _04836_ sky130_fd_sc_hd__nor3_1
X_15980_ network.in_period\[16\]\[3\] _03515_ _04836_ VSS
+ VSS VDD VDD _04837_ sky130_fd_sc_hd__a21oi_1
X_15981_ network.in_period\[16\]\[3\] net371 VSS VSS VDD VDD
+ _04838_ sky130_fd_sc_hd__and2_1
X_15982_ network.neuron_in016.counter\[3\] net387 _04835_
+ _04838_ VSS VSS VDD VDD _04839_ sky130_fd_sc_hd__a31oi_1
X_15983_ network.neuron_in016.counter\[3\] _04837_ _04839_
+ VSS VSS VDD VDD _02131_ sky130_fd_sc_hd__o21ai_0
X_15984_ network.in_spk08_13 _09027_ network.in_spk09_13 VSS
+ VSS VDD VDD _04840_ sky130_fd_sc_hd__o21ai_0
X_15985_ _06785_ _04840_ net368 VSS VSS VDD VDD _01899_ sky130_fd_sc_hd__a21oi_1
X_15986_ network.in_spk13_15 network.in_spk12_15 _04829_ network.in_spk14_15
+ VSS VSS VDD VDD _04841_ sky130_fd_sc_hd__o31ai_1
X_15987_ _08011_ _04841_ net381 VSS VSS VDD VDD _01900_ sky130_fd_sc_hd__a21oi_1
X_15988_ network.neuron_in017.counter\[0\] network.neuron_in017.counter\[1\]
+ _00412_ VSS VSS VDD VDD _04842_ sky130_fd_sc_hd__o21bai_1
X_15989_ _03520_ _04842_ network.neuron_in017.counter\[3\]
+ VSS VSS VDD VDD _04843_ sky130_fd_sc_hd__a21oi_1
X_15990_ _03520_ _00410_ _00411_ network.neuron_in017.counter\[3\]
+ _04843_ VSS VSS VDD VDD _04844_ sky130_fd_sc_hd__a41o_1
X_15991_ net387 _03525_ network.in_period\[17\]\[3\] VSS VSS
+ VDD VDD _04845_ sky130_fd_sc_hd__a21oi_1
X_15992_ net387 _04844_ _04845_ VSS VSS VDD VDD _02135_ sky130_fd_sc_hd__a21oi_1
X_15993_ net395 _04492_ VSS VSS VDD VDD _04846_ sky130_fd_sc_hd__nand2_1
X_15994_ network.in_period\[76\]\[1\] _04846_ VSS VSS VDD
+ VDD _04847_ sky130_fd_sc_hd__nand2_1
X_15995_ _00108_ _04846_ _04847_ VSS VSS VDD VDD _02369_ sky130_fd_sc_hd__o21ai_0
X_15996_ _08912_ net295 net292 VSS VSS VDD VDD _04848_ sky130_fd_sc_hd__a21oi_1
X_15997_ net369 _04848_ VSS VSS VDD VDD _01901_ sky130_fd_sc_hd__nor2_1
X_15998_ network.in_spk14_15 network.in_spk13_15 network.in_spk12_15
+ _04829_ network.in_spk15_15 VSS VSS VDD VDD _04849_ sky130_fd_sc_hd__o41ai_1
X_15999_ _08015_ _04849_ net381 VSS VSS VDD VDD _01902_ sky130_fd_sc_hd__a21oi_1
X_16000_ network.neuron_in018.counter\[1\] network.neuron_in018.counter\[0\]
+ _00400_ VSS VSS VDD VDD _04850_ sky130_fd_sc_hd__o21bai_1
X_16001_ _03530_ _04850_ network.neuron_in018.counter\[3\]
+ VSS VSS VDD VDD _04851_ sky130_fd_sc_hd__a21oi_1
X_16002_ _03530_ _00399_ _00398_ network.neuron_in018.counter\[3\]
+ _04851_ VSS VSS VDD VDD _04852_ sky130_fd_sc_hd__a41o_1
X_16003_ net387 _03534_ network.in_period\[18\]\[3\] VSS VSS
+ VDD VDD _04853_ sky130_fd_sc_hd__a21oi_1
X_16004_ net390 _04852_ _04853_ VSS VSS VDD VDD _02139_ sky130_fd_sc_hd__a21oi_1
X_16005_ _08805_ _08799_ network.neuron_hid0.IF0.membrane_potential\[9\]
+ VSS VSS VDD VDD _04854_ sky130_fd_sc_hd__nor3b_1
X_16006_ network.neuron_hid0.IF0.membrane_potential\[10\]
+ _04854_ VSS VSS VDD VDD _04855_ sky130_fd_sc_hd__xnor2_1
X_16007_ _08791_ _04855_ VSS VSS VDD VDD _01903_ sky130_fd_sc_hd__nor2_1
X_16008_ network.in_spk08_13 _09027_ VSS VSS VDD VDD _04856_
+ sky130_fd_sc_hd__nand2_1
X_16009_ _06862_ _04856_ net368 VSS VSS VDD VDD _01904_ sky130_fd_sc_hd__a21oi_1
X_16010_ _08957_ VSS VSS VDD VDD _01905_ sky130_fd_sc_hd__inv_1
X_16011_ _00394_ _03547_ _00395_ VSS VSS VDD VDD _04857_ sky130_fd_sc_hd__nand3_1
X_16012_ net371 _03543_ _04857_ VSS VSS VDD VDD _04858_ sky130_fd_sc_hd__nor3_1
X_16013_ network.in_period\[19\]\[3\] _03543_ _04858_ VSS
+ VSS VDD VDD _04859_ sky130_fd_sc_hd__a21oi_1
X_16014_ network.in_period\[19\]\[3\] net371 VSS VSS VDD VDD
+ _04860_ sky130_fd_sc_hd__and2_1
X_16015_ network.neuron_in019.counter\[3\] net387 _04857_
+ _04860_ VSS VSS VDD VDD _04861_ sky130_fd_sc_hd__a31oi_1
X_16016_ network.neuron_in019.counter\[3\] _04859_ _04861_
+ VSS VSS VDD VDD _02143_ sky130_fd_sc_hd__o21ai_0
X_16017_ net370 net297 VSS VSS VDD VDD _01906_ sky130_fd_sc_hd__nor2_1
X_16018_ network.neuron_hid0.IF0.ref_counter\[1\] _08793_
+ VSS VSS VDD VDD _04862_ sky130_fd_sc_hd__nor2_1
X_16019_ _00913_ _08793_ _04862_ _08791_ VSS VSS VDD VDD _01907_
+ sky130_fd_sc_hd__a211oi_1
X_16020_ network.neuron_in020.counter\[1\] network.neuron_in020.counter\[2\]
+ network.neuron_in020.counter\[0\] VSS VSS VDD VDD _04863_
+ sky130_fd_sc_hd__or3_1
X_16021_ net373 _03556_ _04863_ VSS VSS VDD VDD _04864_ sky130_fd_sc_hd__nor3_1
X_16022_ network.in_period\[20\]\[3\] _03556_ _04864_ VSS
+ VSS VDD VDD _04865_ sky130_fd_sc_hd__a21oi_1
Xplace346 _07224_ VSS VSS VDD VDD net345 sky130_fd_sc_hd__buf_4
Xplace396 net396 VSS VSS VDD VDD net395 sky130_fd_sc_hd__buf_4
X_16025_ network.in_period\[20\]\[3\] net373 VSS VSS VDD VDD
+ _04868_ sky130_fd_sc_hd__and2_1
X_16026_ network.neuron_in020.counter\[3\] net390 _04863_
+ _04868_ VSS VSS VDD VDD _04869_ sky130_fd_sc_hd__a31oi_1
X_16027_ network.neuron_in020.counter\[3\] _04865_ _04869_
+ VSS VSS VDD VDD _02147_ sky130_fd_sc_hd__o21ai_0
X_16028_ network.neuron_in076.counter\[2\] VSS VSS VDD VDD
+ _04870_ sky130_fd_sc_hd__inv_1
X_16029_ network.neuron_in076.counter\[3\] network.in_period\[76\]\[2\]
+ net378 _00107_ VSS VSS VDD VDD _04871_ sky130_fd_sc_hd__o22ai_1
X_16030_ network.neuron_in076.counter\[2\] _00107_ net395
+ VSS VSS VDD VDD _04872_ sky130_fd_sc_hd__nand3_1
X_16031_ network.in_period\[76\]\[2\] net395 _04872_ VSS VSS
+ VDD VDD _04873_ sky130_fd_sc_hd__o21ai_0
X_16032_ _04870_ _04871_ _04873_ VSS VSS VDD VDD _02370_ sky130_fd_sc_hd__a21oi_1
X_16033_ network.ctrl_spk net406 VSS VSS VDD VDD _01908_ sky130_fd_sc_hd__and2_1
X_16034_ _08973_ _03391_ VSS VSS VDD VDD _04874_ sky130_fd_sc_hd__nand2_1
X_16035_ network.in_spk07_13 _04874_ VSS VSS VDD VDD _04875_
+ sky130_fd_sc_hd__nand2_1
X_16036_ _06800_ _04875_ net368 VSS VSS VDD VDD _01909_ sky130_fd_sc_hd__a21oi_1
X_16037_ network.neuron_in021.counter\[2\] network.neuron_in021.counter\[0\]
+ network.neuron_in021.counter\[1\] VSS VSS VDD VDD _04876_
+ sky130_fd_sc_hd__nor3_1
X_16038_ network.neuron_in021.counter\[3\] _04876_ VSS VSS
+ VDD VDD _04877_ sky130_fd_sc_hd__xnor2_1
X_16039_ network.in_period\[21\]\[3\] _03566_ VSS VSS VDD
+ VDD _04878_ sky130_fd_sc_hd__nand2_1
X_16040_ _03566_ _04877_ _04878_ VSS VSS VDD VDD _02151_ sky130_fd_sc_hd__o21ai_0
X_16041_ net398 _04488_ VSS VSS VDD VDD _04879_ sky130_fd_sc_hd__nand2_1
X_16042_ network.in_period\[77\]\[0\] _04879_ VSS VSS VDD
+ VDD _04880_ sky130_fd_sc_hd__nand2_1
X_16043_ network.neuron_in077.counter\[0\] _04879_ _04880_
+ VSS VSS VDD VDD _02372_ sky130_fd_sc_hd__o21ai_0
X_16044_ _08775_ _08769_ network.neuron_hid1.IF0.membrane_potential\[9\]
+ VSS VSS VDD VDD _04881_ sky130_fd_sc_hd__nor3b_1
X_16045_ network.neuron_hid1.IF0.membrane_potential\[10\]
+ _04881_ VSS VSS VDD VDD _04882_ sky130_fd_sc_hd__xnor2_1
X_16046_ _08761_ _04882_ VSS VSS VDD VDD _01910_ sky130_fd_sc_hd__nor2_1
X_16047_ network.ctrl_addr\[7\] net404 VSS VSS VDD VDD _01911_
+ sky130_fd_sc_hd__and2_1
X_16048_ network.neuron_in022.counter\[0\] network.neuron_in022.counter\[1\]
+ _00373_ VSS VSS VDD VDD _04883_ sky130_fd_sc_hd__o21bai_1
X_16049_ _03569_ _04883_ network.neuron_in022.counter\[3\]
+ VSS VSS VDD VDD _04884_ sky130_fd_sc_hd__a21oi_1
X_16050_ _03569_ _00371_ _00372_ network.neuron_in022.counter\[3\]
+ _04884_ VSS VSS VDD VDD _04885_ sky130_fd_sc_hd__a41o_1
X_16051_ net390 _03574_ network.in_period\[22\]\[3\] VSS VSS
+ VDD VDD _04886_ sky130_fd_sc_hd__a21oi_1
X_16052_ net390 _04885_ _04886_ VSS VSS VDD VDD _02155_ sky130_fd_sc_hd__a21oi_1
X_16053_ network.hid_spk1 network.hid_spk0 VSS VSS VDD VDD
+ _04887_ sky130_fd_sc_hd__nand2_1
Xplace305 _08837_ VSS VSS VDD VDD net304 sky130_fd_sc_hd__buf_4
X_16055_ _08760_ _04887_ net370 VSS VSS VDD VDD _01912_ sky130_fd_sc_hd__a21oi_1
X_16056_ _09048_ _09228_ network.in_spk06_13 VSS VSS VDD VDD
+ _04889_ sky130_fd_sc_hd__o21ai_0
X_16057_ _06819_ _04889_ net368 VSS VSS VDD VDD _01913_ sky130_fd_sc_hd__a21oi_1
X_16058_ network.neuron_hid1.IF0.ref_counter\[1\] _08763_
+ VSS VSS VDD VDD _04890_ sky130_fd_sc_hd__nor2_1
X_16059_ _00713_ _08763_ _04890_ _08761_ VSS VSS VDD VDD _01914_
+ sky130_fd_sc_hd__a211oi_1
X_16060_ network.neuron_in023.counter\[0\] network.neuron_in023.counter\[1\]
+ _00383_ VSS VSS VDD VDD _04891_ sky130_fd_sc_hd__o21bai_1
X_16061_ _03579_ _04891_ network.neuron_in023.counter\[3\]
+ VSS VSS VDD VDD _04892_ sky130_fd_sc_hd__a21oi_1
X_16062_ _03579_ network.neuron_in023.counter\[3\] _00381_
+ _00382_ _04892_ VSS VSS VDD VDD _04893_ sky130_fd_sc_hd__a41o_1
X_16063_ net389 _03583_ network.in_period\[23\]\[3\] VSS VSS
+ VDD VDD _04894_ sky130_fd_sc_hd__a21oi_1
X_16064_ net389 _04893_ _04894_ VSS VSS VDD VDD _02159_ sky130_fd_sc_hd__a21oi_1
X_16065_ network.neuron_hid2.IF0.membrane_potential\[8\] network.neuron_hid2.IF0.membrane_potential\[9\]
+ _08748_ VSS VSS VDD VDD _04895_ sky130_fd_sc_hd__nand3_1
X_16066_ network.neuron_hid2.IF0.membrane_potential\[10\]
+ _04895_ VSS VSS VDD VDD _04896_ sky130_fd_sc_hd__xor2_1
X_16067_ _08725_ _04896_ VSS VSS VDD VDD _01915_ sky130_fd_sc_hd__nor2_1
X_16068_ network.in_spk04_14 network.in_spk05_14 network.in_spk06_14
+ _09099_ network.in_spk07_14 VSS VSS VDD VDD _04897_ sky130_fd_sc_hd__o41ai_1
X_16069_ _07028_ _04897_ net375 VSS VSS VDD VDD _01916_ sky130_fd_sc_hd__a21oi_1
Xplace304 _08857_ VSS VSS VDD VDD net303 sky130_fd_sc_hd__buf_4
X_16071_ _00375_ _00376_ _03588_ VSS VSS VDD VDD _04899_ sky130_fd_sc_hd__nand3_1
X_16072_ net374 _03592_ _04899_ VSS VSS VDD VDD _04900_ sky130_fd_sc_hd__nor3_1
X_16073_ network.in_period\[24\]\[3\] _03592_ _04900_ VSS
+ VSS VDD VDD _04901_ sky130_fd_sc_hd__a21oi_1
X_16074_ network.in_period\[24\]\[3\] net373 VSS VSS VDD VDD
+ _04902_ sky130_fd_sc_hd__and2_1
X_16075_ network.neuron_in024.counter\[3\] net391 _04899_
+ _04902_ VSS VSS VDD VDD _04903_ sky130_fd_sc_hd__a31oi_1
X_16076_ network.neuron_in024.counter\[3\] _04901_ _04903_
+ VSS VSS VDD VDD _02163_ sky130_fd_sc_hd__o21ai_0
X_16077_ network.hid_spk1 network.hid_spk0 network.hid_spk2
+ VSS VSS VDD VDD _04904_ sky130_fd_sc_hd__o21ai_0
X_16078_ _08724_ _04904_ net370 VSS VSS VDD VDD _01917_ sky130_fd_sc_hd__a21oi_1
X_16079_ net329 _08973_ VSS VSS VDD VDD _04905_ sky130_fd_sc_hd__nand2_1
X_16080_ network.in_spk04_13 _04905_ network.in_spk05_13 VSS
+ VSS VDD VDD _04906_ sky130_fd_sc_hd__o21ai_0
X_16081_ _06782_ _04906_ net368 VSS VSS VDD VDD _01918_ sky130_fd_sc_hd__a21oi_1
X_16082_ network.neuron_hid2.IF0.ref_counter\[1\] _08727_
+ VSS VSS VDD VDD _04907_ sky130_fd_sc_hd__nor2_1
X_16083_ _01021_ _08727_ _04907_ _08725_ VSS VSS VDD VDD _01919_
+ sky130_fd_sc_hd__a211oi_1
X_16084_ network.neuron_in025.counter\[2\] network.neuron_in025.counter\[1\]
+ network.neuron_in025.counter\[0\] VSS VSS VDD VDD _04908_
+ sky130_fd_sc_hd__nor3_1
X_16085_ network.neuron_in025.counter\[3\] _04908_ VSS VSS
+ VDD VDD _04909_ sky130_fd_sc_hd__xnor2_1
X_16086_ network.in_period\[25\]\[3\] _03622_ VSS VSS VDD
+ VDD _04910_ sky130_fd_sc_hd__nand2_1
X_16087_ _03622_ _04909_ _04910_ VSS VSS VDD VDD _02167_ sky130_fd_sc_hd__o21ai_0
X_16088_ net398 _04495_ VSS VSS VDD VDD _04911_ sky130_fd_sc_hd__nand2_1
X_16089_ network.in_period\[75\]\[0\] _04911_ VSS VSS VDD
+ VDD _04912_ sky130_fd_sc_hd__nand2_1
X_16090_ network.neuron_in075.counter\[0\] _04911_ _04912_
+ VSS VSS VDD VDD _02364_ sky130_fd_sc_hd__o21ai_0
X_16091_ network.neuron_hid3.IF0.ref_counter\[1\] _08691_
+ VSS VSS VDD VDD _04913_ sky130_fd_sc_hd__nor2_1
X_16092_ _01030_ _08691_ _04913_ _08689_ VSS VSS VDD VDD _01920_
+ sky130_fd_sc_hd__a211oi_1
X_16093_ network.neuron_hid3.IF0.membrane_potential\[9\] network.neuron_hid3.IF0.membrane_potential\[8\]
+ _08712_ VSS VSS VDD VDD _04914_ sky130_fd_sc_hd__nand3_1
X_16094_ network.neuron_hid3.IF0.membrane_potential\[10\]
+ _04914_ VSS VSS VDD VDD _04915_ sky130_fd_sc_hd__xor2_1
X_16095_ _08689_ _04915_ VSS VSS VDD VDD _01921_ sky130_fd_sc_hd__nor2_1
X_16096_ network.neuron_in026.counter\[1\] network.neuron_in026.counter\[0\]
+ VSS VSS VDD VDD _04916_ sky130_fd_sc_hd__nor2_1
X_16097_ _00450_ _04916_ VSS VSS VDD VDD _04917_ sky130_fd_sc_hd__nor2_1
X_16098_ network.neuron_in026.counter\[2\] _04917_ VSS VSS
+ VDD VDD _04918_ sky130_fd_sc_hd__nor2_1
X_16099_ network.neuron_in026.counter\[2\] network.neuron_in026.counter\[3\]
+ _04916_ VSS VSS VDD VDD _04919_ sky130_fd_sc_hd__nand3b_1
X_16100_ network.neuron_in026.counter\[3\] _04918_ _04919_
+ VSS VSS VDD VDD _04920_ sky130_fd_sc_hd__o21ai_0
X_16101_ net388 _03624_ network.in_period\[26\]\[3\] VSS VSS
+ VDD VDD _04921_ sky130_fd_sc_hd__a21oi_1
X_16102_ net388 _04920_ _04921_ VSS VSS VDD VDD _02171_ sky130_fd_sc_hd__a21oi_1
X_16103_ _08673_ _08667_ network.neuron_hid4.IF0.membrane_potential\[9\]
+ VSS VSS VDD VDD _04922_ sky130_fd_sc_hd__nor3b_1
X_16104_ network.neuron_hid4.IF0.membrane_potential\[10\]
+ _04922_ VSS VSS VDD VDD _04923_ sky130_fd_sc_hd__xnor2_1
X_16105_ _08659_ _04923_ VSS VSS VDD VDD _01922_ sky130_fd_sc_hd__nor2_1
X_16106_ network.in_spk04_13 _04905_ VSS VSS VDD VDD _04924_
+ sky130_fd_sc_hd__nand2_1
X_16107_ _06794_ _04924_ net368 VSS VSS VDD VDD _01923_ sky130_fd_sc_hd__a21oi_1
X_16108_ network.hid_spk2 network.hid_spk1 network.hid_spk0
+ network.hid_spk3 VSS VSS VDD VDD _04925_ sky130_fd_sc_hd__o31ai_1
X_16109_ _08688_ _04925_ net370 VSS VSS VDD VDD _01924_ sky130_fd_sc_hd__a21oi_1
X_16110_ network.neuron_in027.counter\[0\] network.neuron_in027.counter\[2\]
+ network.neuron_in027.counter\[1\] VSS VSS VDD VDD _04926_
+ sky130_fd_sc_hd__or3_1
X_16111_ net373 _03629_ _04926_ VSS VSS VDD VDD _04927_ sky130_fd_sc_hd__nor3_1
X_16112_ network.in_period\[27\]\[3\] _03629_ _04927_ VSS
+ VSS VDD VDD _04928_ sky130_fd_sc_hd__a21oi_1
X_16113_ network.in_period\[27\]\[3\] net373 VSS VSS VDD VDD
+ _04929_ sky130_fd_sc_hd__and2_1
X_16114_ network.neuron_in027.counter\[3\] net391 _04926_
+ _04929_ VSS VSS VDD VDD _04930_ sky130_fd_sc_hd__a31oi_1
X_16115_ network.neuron_in027.counter\[3\] _04928_ _04930_
+ VSS VSS VDD VDD _02175_ sky130_fd_sc_hd__o21ai_0
X_16116_ network.hid_spk1 network.hid_spk0 VSS VSS VDD VDD
+ _04931_ sky130_fd_sc_hd__nor2_1
X_16117_ _08539_ _04931_ VSS VSS VDD VDD _04932_ sky130_fd_sc_hd__nand2_1
X_16118_ network.hid_spk4 _04932_ VSS VSS VDD VDD _04933_
+ sky130_fd_sc_hd__nand2_1
X_16119_ _08658_ _04933_ net370 VSS VSS VDD VDD _01925_ sky130_fd_sc_hd__a21oi_1
X_16120_ network.neuron_hid4.IF0.ref_counter\[1\] _08661_
+ VSS VSS VDD VDD _04934_ sky130_fd_sc_hd__nor2_1
X_16121_ _00709_ _08661_ _04934_ _08659_ VSS VSS VDD VDD _01926_
+ sky130_fd_sc_hd__a211oi_1
X_16122_ network.neuron_in028.counter\[1\] network.neuron_in028.counter\[0\]
+ _00357_ VSS VSS VDD VDD _04935_ sky130_fd_sc_hd__o21bai_1
X_16123_ _04567_ _04935_ network.neuron_in028.counter\[3\]
+ VSS VSS VDD VDD _04936_ sky130_fd_sc_hd__a21oi_1
X_16124_ _04567_ network.neuron_in028.counter\[3\] _00356_
+ _00355_ _04936_ VSS VSS VDD VDD _04937_ sky130_fd_sc_hd__a41o_1
X_16125_ net391 _04566_ network.in_period\[28\]\[3\] VSS VSS
+ VDD VDD _04938_ sky130_fd_sc_hd__a21oi_1
X_16126_ net391 _04937_ _04938_ VSS VSS VDD VDD _02179_ sky130_fd_sc_hd__a21oi_1
X_16127_ network.in_period\[77\]\[1\] _04879_ VSS VSS VDD
+ VDD _04939_ sky130_fd_sc_hd__nand2_1
X_16128_ _00104_ _04879_ _04939_ VSS VSS VDD VDD _02373_ sky130_fd_sc_hd__o21ai_0
X_16129_ _08643_ _08637_ network.neuron_hid5.IF0.membrane_potential\[9\]
+ VSS VSS VDD VDD _04940_ sky130_fd_sc_hd__nor3b_1
X_16130_ network.neuron_hid5.IF0.membrane_potential\[10\]
+ _04940_ VSS VSS VDD VDD _04941_ sky130_fd_sc_hd__xnor2_1
X_16131_ _08629_ _04941_ VSS VSS VDD VDD _01927_ sky130_fd_sc_hd__nor2_1
X_16132_ _03386_ _03389_ _08973_ VSS VSS VDD VDD _04942_ sky130_fd_sc_hd__nand3_1
X_16133_ network.in_spk02_13 _04942_ network.in_spk03_13 VSS
+ VSS VDD VDD _04943_ sky130_fd_sc_hd__o21ai_0
X_16134_ _06811_ _04943_ net368 VSS VSS VDD VDD _01928_ sky130_fd_sc_hd__a21oi_1
X_16135_ network.neuron_in029.counter\[2\] network.neuron_in029.counter\[0\]
+ network.neuron_in029.counter\[1\] VSS VSS VDD VDD _04944_
+ sky130_fd_sc_hd__nor3_1
X_16136_ network.neuron_in029.counter\[3\] _04944_ VSS VSS
+ VDD VDD _04945_ sky130_fd_sc_hd__xnor2_1
X_16137_ network.in_period\[29\]\[3\] _07536_ VSS VSS VDD
+ VDD _04946_ sky130_fd_sc_hd__nand2_1
X_16138_ _07536_ _04945_ _04946_ VSS VSS VDD VDD _02183_ sky130_fd_sc_hd__o21ai_0
X_16139_ network.neuron_in078.counter\[2\] VSS VSS VDD VDD
+ _04947_ sky130_fd_sc_hd__inv_1
X_16140_ network.neuron_in078.counter\[3\] network.in_period\[78\]\[2\]
+ net379 _00098_ VSS VSS VDD VDD _04948_ sky130_fd_sc_hd__o22ai_1
X_16141_ network.neuron_in078.counter\[2\] _00098_ net398
+ VSS VSS VDD VDD _04949_ sky130_fd_sc_hd__nand3_1
X_16142_ network.in_period\[78\]\[2\] net398 _04949_ VSS VSS
+ VDD VDD _04950_ sky130_fd_sc_hd__o21ai_0
X_16143_ _04947_ _04948_ _04950_ VSS VSS VDD VDD _02378_ sky130_fd_sc_hd__a21oi_1
X_16144_ network.hid_spk4 _04932_ network.hid_spk5 VSS VSS
+ VDD VDD _04951_ sky130_fd_sc_hd__o21ai_0
X_16145_ _08628_ _04951_ net370 VSS VSS VDD VDD _01929_ sky130_fd_sc_hd__a21oi_1
X_16146_ network.neuron_hid5.IF0.ref_counter\[1\] _08631_
+ VSS VSS VDD VDD _04952_ sky130_fd_sc_hd__nor2_1
X_16147_ _01146_ _08631_ _04952_ _08629_ VSS VSS VDD VDD _01930_
+ sky130_fd_sc_hd__a211oi_1
X_16148_ network.neuron_in030.counter\[1\] network.neuron_in030.counter\[0\]
+ _00676_ VSS VSS VDD VDD _04953_ sky130_fd_sc_hd__o21bai_1
X_16149_ _07538_ _04953_ network.neuron_in030.counter\[3\]
+ VSS VSS VDD VDD _04954_ sky130_fd_sc_hd__a21oi_1
X_16150_ _07538_ network.neuron_in030.counter\[3\] _00675_
+ _00674_ _04954_ VSS VSS VDD VDD _04955_ sky130_fd_sc_hd__a41o_1
Xplace303 _08947_ VSS VSS VDD VDD net302 sky130_fd_sc_hd__buf_4
X_16152_ net391 _07546_ network.in_period\[30\]\[3\] VSS VSS
+ VDD VDD _04957_ sky130_fd_sc_hd__a21oi_1
X_16153_ net391 _04955_ _04957_ VSS VSS VDD VDD _02187_ sky130_fd_sc_hd__a21oi_1
X_16154_ _08613_ _08607_ network.neuron_hid6.IF0.membrane_potential\[9\]
+ VSS VSS VDD VDD _04958_ sky130_fd_sc_hd__nor3b_1
X_16155_ network.neuron_hid6.IF0.membrane_potential\[10\]
+ _04958_ VSS VSS VDD VDD _04959_ sky130_fd_sc_hd__xnor2_1
X_16156_ _08599_ _04959_ VSS VSS VDD VDD _01931_ sky130_fd_sc_hd__nor2_1
X_16157_ network.in_spk02_13 _04942_ VSS VSS VDD VDD _04960_
+ sky130_fd_sc_hd__nand2_1
Xplace314 _07787_ VSS VSS VDD VDD net313 sky130_fd_sc_hd__buf_4
X_16159_ _06790_ _04960_ net368 VSS VSS VDD VDD _01932_ sky130_fd_sc_hd__a21oi_1
X_16160_ network.in_spk04_14 network.in_spk05_14 _09099_ network.in_spk06_14
+ VSS VSS VDD VDD _04962_ sky130_fd_sc_hd__o31ai_1
X_16161_ _07001_ _04962_ net375 VSS VSS VDD VDD _01933_ sky130_fd_sc_hd__a21oi_1
X_16162_ network.neuron_in031.counter\[1\] VSS VSS VDD VDD
+ _01200_ sky130_fd_sc_hd__inv_1
X_16163_ network.neuron_in031.counter\[0\] network.neuron_in031.counter\[1\]
+ _01201_ VSS VSS VDD VDD _04963_ sky130_fd_sc_hd__o21bai_1
X_16164_ _03639_ _04963_ network.neuron_in031.counter\[3\]
+ VSS VSS VDD VDD _04964_ sky130_fd_sc_hd__a21oi_1
X_16165_ _03639_ network.neuron_in031.counter\[3\] _01199_
+ _01200_ _04964_ VSS VSS VDD VDD _04965_ sky130_fd_sc_hd__a41o_1
X_16166_ net391 _03650_ network.in_period\[31\]\[3\] VSS VSS
+ VDD VDD _04966_ sky130_fd_sc_hd__a21oi_1
X_16167_ net391 _04965_ _04966_ VSS VSS VDD VDD _02191_ sky130_fd_sc_hd__a21oi_1
X_16168_ net398 _04387_ VSS VSS VDD VDD _04967_ sky130_fd_sc_hd__nand2_1
X_16169_ network.in_period\[74\]\[1\] _04967_ VSS VSS VDD
+ VDD _04968_ sky130_fd_sc_hd__nand2_1
X_16170_ _00112_ _04967_ _04968_ VSS VSS VDD VDD _02361_ sky130_fd_sc_hd__o21ai_0
X_16171_ network.hid_spk6 _08548_ VSS VSS VDD VDD _04969_
+ sky130_fd_sc_hd__nand2_1
X_16172_ net298 _04969_ net370 VSS VSS VDD VDD _01934_ sky130_fd_sc_hd__a21oi_1
X_16173_ network.neuron_hid6.IF0.ref_counter\[1\] _08601_
+ VSS VSS VDD VDD _04970_ sky130_fd_sc_hd__nor2_1
X_16174_ _01158_ _08601_ _04970_ _08599_ VSS VSS VDD VDD _01935_
+ sky130_fd_sc_hd__a211oi_1
X_16175_ network.neuron_in032.counter\[1\] VSS VSS VDD VDD
+ _01164_ sky130_fd_sc_hd__inv_1
X_16176_ network.neuron_in032.counter\[0\] network.neuron_in032.counter\[1\]
+ _01165_ VSS VSS VDD VDD _04971_ sky130_fd_sc_hd__o21bai_1
X_16177_ _03634_ _04971_ network.neuron_in032.counter\[3\]
+ VSS VSS VDD VDD _04972_ sky130_fd_sc_hd__a21oi_1
X_16178_ _03634_ network.neuron_in032.counter\[3\] _01163_
+ _01164_ _04972_ VSS VSS VDD VDD _04973_ sky130_fd_sc_hd__a41o_1
X_16179_ net396 _03633_ network.in_period\[32\]\[3\] VSS VSS
+ VDD VDD _04974_ sky130_fd_sc_hd__a21oi_1
X_16180_ net396 _04973_ _04974_ VSS VSS VDD VDD _02195_ sky130_fd_sc_hd__a21oi_1
X_16181_ network.neuron_in074.counter\[0\] VSS VSS VDD VDD
+ _00109_ sky130_fd_sc_hd__inv_1
X_16182_ network.in_period\[74\]\[0\] _04967_ VSS VSS VDD
+ VDD _04975_ sky130_fd_sc_hd__nand2_1
X_16183_ network.neuron_in074.counter\[0\] _04967_ _04975_
+ VSS VSS VDD VDD _02360_ sky130_fd_sc_hd__o21ai_0
X_16184_ network.neuron_hid7.IF0.membrane_potential\[8\] network.neuron_hid7.IF0.membrane_potential\[9\]
+ _08583_ VSS VSS VDD VDD _04976_ sky130_fd_sc_hd__nand3_1
X_16185_ network.neuron_hid7.IF0.membrane_potential\[10\]
+ _04976_ VSS VSS VDD VDD _04977_ sky130_fd_sc_hd__xor2_1
X_16186_ _08560_ _04977_ VSS VSS VDD VDD _01936_ sky130_fd_sc_hd__nor2_1
X_16187_ net329 _08834_ VSS VSS VDD VDD _04978_ sky130_fd_sc_hd__nand2_1
X_16188_ network.in_spk00_13 _03389_ _04978_ _09223_ _09047_
+ VSS VSS VDD VDD _04979_ sky130_fd_sc_hd__o221ai_1
X_16189_ _09225_ _04979_ VSS VSS VDD VDD _04980_ sky130_fd_sc_hd__nor2_1
X_16190_ _09048_ _04980_ network.in_spk01_13 VSS VSS VDD VDD
+ _04981_ sky130_fd_sc_hd__o21ai_0
X_16191_ _06843_ _04981_ net368 VSS VSS VDD VDD _01937_ sky130_fd_sc_hd__a21oi_1
X_16192_ network.neuron_in033.counter\[1\] network.neuron_in033.counter\[0\]
+ network.neuron_in033.counter\[2\] VSS VSS VDD VDD _04982_
+ sky130_fd_sc_hd__or3_1
X_16193_ net381 _03646_ _04982_ VSS VSS VDD VDD _04983_ sky130_fd_sc_hd__nor3_1
X_16194_ network.in_period\[33\]\[3\] _03646_ _04983_ VSS
+ VSS VDD VDD _04984_ sky130_fd_sc_hd__a21oi_1
X_16195_ network.in_period\[33\]\[3\] net381 VSS VSS VDD VDD
+ _04985_ sky130_fd_sc_hd__and2_1
X_16196_ network.neuron_in033.counter\[3\] net397 _04982_
+ _04985_ VSS VSS VDD VDD _04986_ sky130_fd_sc_hd__a31oi_1
X_16197_ network.neuron_in033.counter\[3\] _04984_ _04986_
+ VSS VSS VDD VDD _02199_ sky130_fd_sc_hd__o21ai_0
X_16198_ network.hid_spk6 _08548_ network.hid_spk7 VSS VSS
+ VDD VDD _04987_ sky130_fd_sc_hd__o21ai_0
X_16199_ _08559_ _04987_ net370 VSS VSS VDD VDD _01938_ sky130_fd_sc_hd__a21oi_1
X_16200_ network.neuron_hid7.IF0.ref_counter\[1\] _08562_
+ VSS VSS VDD VDD _04988_ sky130_fd_sc_hd__nor2_1
X_16201_ _00733_ _08562_ _04988_ _08560_ VSS VSS VDD VDD _01939_
+ sky130_fd_sc_hd__a211oi_1
Xplace307 _07083_ VSS VSS VDD VDD net306 sky130_fd_sc_hd__buf_4
X_16203_ network.neuron_in034.counter\[1\] network.neuron_in034.counter\[0\]
+ _00361_ VSS VSS VDD VDD _04990_ sky130_fd_sc_hd__o21bai_1
X_16204_ _03664_ _04990_ network.neuron_in034.counter\[3\]
+ VSS VSS VDD VDD _04991_ sky130_fd_sc_hd__a21oi_1
X_16205_ _03664_ _00360_ _00359_ network.neuron_in034.counter\[3\]
+ _04991_ VSS VSS VDD VDD _04992_ sky130_fd_sc_hd__a41o_1
X_16206_ net397 _03672_ network.in_period\[34\]\[3\] VSS VSS
+ VDD VDD _04993_ sky130_fd_sc_hd__a21oi_1
X_16207_ net397 _04992_ _04993_ VSS VSS VDD VDD _02203_ sky130_fd_sc_hd__a21oi_1
X_16208_ _08542_ _08547_ net370 VSS VSS VDD VDD _01940_ sky130_fd_sc_hd__a21oi_1
X_16209_ _00641_ _06656_ _09048_ network.in_spk00_13 VSS VSS
+ VDD VDD _04994_ sky130_fd_sc_hd__a22oi_1
X_16210_ net369 _04994_ VSS VSS VDD VDD _01941_ sky130_fd_sc_hd__nor2_1
X_16211_ net370 _08542_ _04932_ VSS VSS VDD VDD _01942_ sky130_fd_sc_hd__nor3_1
X_16212_ network.neuron_in035.counter\[1\] network.neuron_in035.counter\[0\]
+ network.neuron_in035.counter\[2\] VSS VSS VDD VDD _04995_
+ sky130_fd_sc_hd__nor3_1
X_16213_ network.neuron_in035.counter\[3\] _04995_ VSS VSS
+ VDD VDD _04996_ sky130_fd_sc_hd__xnor2_1
X_16214_ network.in_period\[35\]\[3\] _03679_ VSS VSS VDD
+ VDD _04997_ sky130_fd_sc_hd__nand2_1
X_16215_ _03679_ _04996_ _04997_ VSS VSS VDD VDD _02207_ sky130_fd_sc_hd__o21ai_0
X_16216_ network.neuron_in075.counter\[2\] VSS VSS VDD VDD
+ _04998_ sky130_fd_sc_hd__inv_1
X_16217_ network.neuron_in075.counter\[3\] network.in_period\[75\]\[2\]
+ net378 _00115_ VSS VSS VDD VDD _04999_ sky130_fd_sc_hd__o22ai_1
Xplace386 net386 VSS VSS VDD VDD net385 sky130_fd_sc_hd__buf_4
X_16219_ network.neuron_in075.counter\[2\] _00115_ net398
+ VSS VSS VDD VDD _05001_ sky130_fd_sc_hd__nand3_1
X_16220_ network.in_period\[75\]\[2\] net398 _05001_ VSS VSS
+ VDD VDD _05002_ sky130_fd_sc_hd__o21ai_0
X_16221_ _04998_ _04999_ _05002_ VSS VSS VDD VDD _02366_ sky130_fd_sc_hd__a21oi_1
X_16222_ network.in_spk02_14 network.in_spk01_14 _08925_ _04726_
+ network.in_spk03_14 VSS VSS VDD VDD _05003_ sky130_fd_sc_hd__o41ai_1
X_16223_ _06876_ _05003_ net372 VSS VSS VDD VDD _01943_ sky130_fd_sc_hd__a21oi_1
X_16224_ _00348_ _03660_ _00347_ VSS VSS VDD VDD _05004_ sky130_fd_sc_hd__nand3_1
X_16225_ net380 _03729_ _05004_ VSS VSS VDD VDD _05005_ sky130_fd_sc_hd__nor3_1
X_16226_ network.in_period\[36\]\[3\] _03729_ _05005_ VSS
+ VSS VDD VDD _05006_ sky130_fd_sc_hd__a21oi_1
X_16227_ network.in_period\[36\]\[3\] net380 VSS VSS VDD VDD
+ _05007_ sky130_fd_sc_hd__and2_1
X_16228_ network.neuron_in036.counter\[3\] net397 _05004_
+ _05007_ VSS VSS VDD VDD _05008_ sky130_fd_sc_hd__a31oi_1
X_16229_ network.neuron_in036.counter\[3\] _05006_ _05008_
+ VSS VSS VDD VDD _02211_ sky130_fd_sc_hd__o21ai_0
X_16230_ network.in_period\[75\]\[1\] _04911_ VSS VSS VDD
+ VDD _05009_ sky130_fd_sc_hd__nand2_1
X_16231_ _00116_ _04911_ _05009_ VSS VSS VDD VDD _02365_ sky130_fd_sc_hd__o21ai_0
X_16232_ _08831_ _09088_ network.in_spk15_12 VSS VSS VDD VDD
+ _05010_ sky130_fd_sc_hd__o21ai_0
X_16233_ _06671_ _05010_ net369 VSS VSS VDD VDD _01944_ sky130_fd_sc_hd__a21oi_1
X_16234_ network.neuron_in037.counter\[1\] network.neuron_in037.counter\[2\]
+ network.neuron_in037.counter\[0\] VSS VSS VDD VDD _05011_
+ sky130_fd_sc_hd__nor3_1
X_16235_ network.neuron_in037.counter\[3\] _05011_ VSS VSS
+ VDD VDD _05012_ sky130_fd_sc_hd__xnor2_1
X_16236_ network.in_period\[37\]\[3\] _03711_ VSS VSS VDD
+ VDD _05013_ sky130_fd_sc_hd__nand2_1
X_16237_ _03711_ _05012_ _05013_ VSS VSS VDD VDD _02215_ sky130_fd_sc_hd__o21ai_0
X_16238_ network.neuron_in082.counter\[0\] VSS VSS VDD VDD
+ _00062_ sky130_fd_sc_hd__inv_1
X_16239_ network.in_spk04_14 _09099_ network.in_spk05_14 VSS
+ VSS VDD VDD _05014_ sky130_fd_sc_hd__o21ai_0
X_16240_ _07022_ _05014_ net375 VSS VSS VDD VDD _01945_ sky130_fd_sc_hd__a21oi_1
X_16241_ network.neuron_in038.counter\[1\] network.neuron_in038.counter\[2\]
+ network.neuron_in038.counter\[0\] VSS VSS VDD VDD _05015_
+ sky130_fd_sc_hd__nor3_1
X_16242_ network.neuron_in038.counter\[3\] _05015_ VSS VSS
+ VDD VDD _05016_ sky130_fd_sc_hd__xnor2_1
X_16243_ network.in_period\[38\]\[3\] _03736_ VSS VSS VDD
+ VDD _05017_ sky130_fd_sc_hd__nand2_1
X_16244_ _03736_ _05016_ _05017_ VSS VSS VDD VDD _02219_ sky130_fd_sc_hd__o21ai_0
X_16245_ _09237_ _09088_ network.in_spk14_12 VSS VSS VDD VDD
+ _05018_ sky130_fd_sc_hd__o21ai_0
X_16246_ _06772_ _05018_ net369 VSS VSS VDD VDD _01946_ sky130_fd_sc_hd__a21oi_1
X_16247_ network.neuron_in039.counter\[0\] network.neuron_in039.counter\[1\]
+ _00329_ VSS VSS VDD VDD _05019_ sky130_fd_sc_hd__o21bai_1
X_16248_ _03755_ _05019_ network.neuron_in039.counter\[3\]
+ VSS VSS VDD VDD _05020_ sky130_fd_sc_hd__a21oi_1
X_16249_ _03755_ network.neuron_in039.counter\[3\] _00327_
+ _00328_ _05020_ VSS VSS VDD VDD _05021_ sky130_fd_sc_hd__a41o_1
X_16250_ net397 _03754_ network.in_period\[39\]\[3\] VSS VSS
+ VDD VDD _05022_ sky130_fd_sc_hd__a21oi_1
X_16251_ net397 _05021_ _05022_ VSS VSS VDD VDD _02223_ sky130_fd_sc_hd__a21oi_1
X_16252_ network.neuron_in076.counter\[0\] VSS VSS VDD VDD
+ _00105_ sky130_fd_sc_hd__inv_1
X_16253_ network.in_period\[76\]\[0\] _04846_ VSS VSS VDD
+ VDD _05023_ sky130_fd_sc_hd__nand2_1
X_16254_ network.neuron_in076.counter\[0\] _04846_ _05023_
+ VSS VSS VDD VDD _02368_ sky130_fd_sc_hd__o21ai_0
X_16255_ network.in_spk04_14 _09099_ VSS VSS VDD VDD _05024_
+ sky130_fd_sc_hd__nand2_1
Xplace384 net384 VSS VSS VDD VDD net383 sky130_fd_sc_hd__buf_4
X_16257_ _07258_ _05024_ net375 VSS VSS VDD VDD _01947_ sky130_fd_sc_hd__a21oi_1
X_16258_ network.neuron_in040.counter\[1\] network.neuron_in040.counter\[0\]
+ network.neuron_in040.counter\[2\] VSS VSS VDD VDD _05026_
+ sky130_fd_sc_hd__or3_1
X_16259_ net379 _03759_ _05026_ VSS VSS VDD VDD _05027_ sky130_fd_sc_hd__nor3_1
X_16260_ network.in_period\[40\]\[3\] _03759_ _05027_ VSS
+ VSS VDD VDD _05028_ sky130_fd_sc_hd__a21oi_1
X_16261_ network.in_period\[40\]\[3\] net379 VSS VSS VDD VDD
+ _05029_ sky130_fd_sc_hd__and2_1
X_16262_ network.neuron_in040.counter\[3\] net397 _05026_
+ _05029_ VSS VSS VDD VDD _05030_ sky130_fd_sc_hd__a31oi_1
X_16263_ network.neuron_in040.counter\[3\] _05028_ _05030_
+ VSS VSS VDD VDD _02227_ sky130_fd_sc_hd__o21ai_0
X_16264_ network.in_spk00_14 network.in_spk01_14 _08946_ network.in_spk02_14
+ VSS VSS VDD VDD _05031_ sky130_fd_sc_hd__o31ai_1
X_16265_ _06922_ _05031_ net375 VSS VSS VDD VDD _01948_ sky130_fd_sc_hd__a21oi_1
X_16266_ network.in_spk11_12 network.in_spk12_12 _09088_ network.in_spk13_12
+ VSS VSS VDD VDD _05032_ sky130_fd_sc_hd__o31ai_1
X_16267_ _06702_ _05032_ net369 VSS VSS VDD VDD _01949_ sky130_fd_sc_hd__a21oi_1
X_16268_ network.neuron_in041.counter\[0\] network.neuron_in041.counter\[2\]
+ network.neuron_in041.counter\[1\] VSS VSS VDD VDD _05033_
+ sky130_fd_sc_hd__nor3_1
X_16269_ network.neuron_in041.counter\[3\] _05033_ VSS VSS
+ VDD VDD _05034_ sky130_fd_sc_hd__xnor2_1
X_16270_ network.in_period\[41\]\[3\] _03746_ VSS VSS VDD
+ VDD _05035_ sky130_fd_sc_hd__nand2_1
X_16271_ _03746_ _05034_ _05035_ VSS VSS VDD VDD _02231_ sky130_fd_sc_hd__o21ai_0
X_16272_ net427 net426 _08381_ _08388_ loaded\[8\] VSS VSS
+ VDD VDD _05036_ sky130_fd_sc_hd__a41oi_1
X_16273_ _05036_ _08377_ VSS VSS VDD VDD _01950_ sky130_fd_sc_hd__nor2b_1
X_16274_ network.arbit.counter\[0\] network.arbit.counter\[1\]
+ network.arbit.counter\[2\] net293 VSS VSS VDD VDD _05037_
+ sky130_fd_sc_hd__nor4_1
X_16275_ network.arbit.counter\[3\] _05037_ VSS VSS VDD VDD
+ _05038_ sky130_fd_sc_hd__xnor2_1
X_16276_ net402 _05038_ VSS VSS VDD VDD _01951_ sky130_fd_sc_hd__nand2_1
X_16277_ network.neuron_in042.counter\[1\] network.neuron_in042.counter\[0\]
+ network.neuron_in042.counter\[2\] VSS VSS VDD VDD _05039_
+ sky130_fd_sc_hd__or3_1
X_16278_ net380 _03773_ _05039_ VSS VSS VDD VDD _05040_ sky130_fd_sc_hd__nor3_1
X_16279_ network.in_period\[42\]\[3\] _03773_ _05040_ VSS
+ VSS VDD VDD _05041_ sky130_fd_sc_hd__a21oi_1
X_16280_ network.in_period\[42\]\[3\] net380 VSS VSS VDD VDD
+ _05042_ sky130_fd_sc_hd__and2_1
X_16281_ network.neuron_in042.counter\[3\] net396 _05039_
+ _05042_ VSS VSS VDD VDD _05043_ sky130_fd_sc_hd__a31oi_1
X_16282_ network.neuron_in042.counter\[3\] _05041_ _05043_
+ VSS VSS VDD VDD _02235_ sky130_fd_sc_hd__o21ai_0
X_16283_ network.neuron_in077.counter\[2\] _00103_ VSS VSS
+ VDD VDD _05044_ sky130_fd_sc_hd__xnor2_1
X_16284_ net398 _04488_ network.in_period\[77\]\[2\] VSS VSS
+ VDD VDD _05045_ sky130_fd_sc_hd__a21oi_1
X_16285_ net398 _05044_ _05045_ VSS VSS VDD VDD _02374_ sky130_fd_sc_hd__a21oi_1
X_16286_ net45 _08314_ _08317_ VSS VSS VDD VDD _05046_ sky130_fd_sc_hd__mux2i_1
X_16287_ net430 _05046_ VSS VSS VDD VDD _01952_ sky130_fd_sc_hd__nor2_1
X_16288_ network.in_spk11_12 _09088_ network.in_spk12_12 VSS
+ VSS VDD VDD _05047_ sky130_fd_sc_hd__o21ai_0
X_16289_ _06766_ _05047_ net369 VSS VSS VDD VDD _01953_ sky130_fd_sc_hd__a21oi_1
X_16290_ net32 _08340_ _08346_ VSS VSS VDD VDD _05048_ sky130_fd_sc_hd__nand3_1
X_16291_ net33 _05048_ VSS VSS VDD VDD _05049_ sky130_fd_sc_hd__xor2_1
X_16292_ _08331_ _05049_ VSS VSS VDD VDD _01954_ sky130_fd_sc_hd__nor2_1
X_16293_ network.neuron_in043.counter\[1\] network.neuron_in043.counter\[2\]
+ network.neuron_in043.counter\[0\] VSS VSS VDD VDD _05050_
+ sky130_fd_sc_hd__nor3_1
X_16294_ network.neuron_in043.counter\[3\] _05050_ VSS VSS
+ VDD VDD _05051_ sky130_fd_sc_hd__xnor2_1
X_16295_ network.in_period\[43\]\[3\] _04067_ VSS VSS VDD
+ VDD _05052_ sky130_fd_sc_hd__nand2_1
X_16296_ _04067_ _05051_ _05052_ VSS VSS VDD VDD _02239_ sky130_fd_sc_hd__o21ai_0
X_16297_ net430 _08317_ VSS VSS VDD VDD _01955_ sky130_fd_sc_hd__nor2b_1
X_16298_ net312 net311 VSS VSS VDD VDD _05053_ sky130_fd_sc_hd__nor2_1
X_16299_ _08291_ net310 _08295_ VSS VSS VDD VDD _05054_ sky130_fd_sc_hd__o21bai_1
X_16300_ _08317_ net47 VSS VSS VDD VDD _05055_ sky130_fd_sc_hd__nor2b_1
X_16301_ _05053_ _08317_ _05054_ _05055_ net430 VSS VSS VDD
+ VDD _01956_ sky130_fd_sc_hd__a311o_1
X_16302_ network.neuron_in044.counter\[0\] network.neuron_in044.counter\[1\]
+ _00272_ VSS VSS VDD VDD _05056_ sky130_fd_sc_hd__o21bai_1
X_16303_ _04044_ _05056_ network.neuron_in044.counter\[3\]
+ VSS VSS VDD VDD _05057_ sky130_fd_sc_hd__a21oi_1
X_16304_ _04044_ _00270_ _00271_ network.neuron_in044.counter\[3\]
+ _05057_ VSS VSS VDD VDD _05058_ sky130_fd_sc_hd__a41o_1
X_16305_ net386 _04043_ network.in_period\[44\]\[3\] VSS VSS
+ VDD VDD _05059_ sky130_fd_sc_hd__a21oi_1
X_16306_ net386 _05058_ _05059_ VSS VSS VDD VDD _02243_ sky130_fd_sc_hd__a21oi_1
X_16307_ network.in_spk11_12 _09088_ VSS VSS VDD VDD _05060_
+ sky130_fd_sc_hd__nand2_1
X_16308_ _06761_ _05060_ net369 VSS VSS VDD VDD _01957_ sky130_fd_sc_hd__a21oi_1
X_16309_ _08329_ net283 net25 VSS VSS VDD VDD _05061_ sky130_fd_sc_hd__a21oi_1
X_16310_ _05061_ _08377_ VSS VSS VDD VDD _01958_ sky130_fd_sc_hd__nor2b_1
X_16311_ network.neuron_in045.counter\[0\] network.neuron_in045.counter\[2\]
+ network.neuron_in045.counter\[1\] VSS VSS VDD VDD _05062_
+ sky130_fd_sc_hd__nor3_1
X_16312_ network.neuron_in045.counter\[3\] _05062_ VSS VSS
+ VDD VDD _05063_ sky130_fd_sc_hd__xnor2_1
X_16313_ network.in_period\[45\]\[3\] _04050_ VSS VSS VDD
+ VDD _05064_ sky130_fd_sc_hd__nand2_1
X_16314_ _04050_ _05063_ _05064_ VSS VSS VDD VDD _02247_ sky130_fd_sc_hd__o21ai_0
X_16315_ net398 _04485_ VSS VSS VDD VDD _05065_ sky130_fd_sc_hd__nand2_1
X_16316_ network.in_period\[78\]\[1\] _05065_ VSS VSS VDD
+ VDD _05066_ sky130_fd_sc_hd__nand2_1
X_16317_ _00099_ _05065_ _05066_ VSS VSS VDD VDD _02377_ sky130_fd_sc_hd__o21ai_0
X_16318_ network.neuron_in046.counter\[2\] network.neuron_in046.counter\[0\]
+ network.neuron_in046.counter\[1\] VSS VSS VDD VDD _05067_
+ sky130_fd_sc_hd__nor3_1
X_16319_ network.neuron_in046.counter\[3\] _05067_ VSS VSS
+ VDD VDD _05068_ sky130_fd_sc_hd__xnor2_1
X_16320_ network.in_period\[46\]\[3\] _04056_ VSS VSS VDD
+ VDD _05069_ sky130_fd_sc_hd__nand2_1
X_16321_ _04056_ _05068_ _05069_ VSS VSS VDD VDD _02251_ sky130_fd_sc_hd__o21ai_0
X_16322_ network.in_period\[78\]\[0\] _05065_ VSS VSS VDD
+ VDD _05070_ sky130_fd_sc_hd__nand2_1
X_16323_ network.neuron_in078.counter\[0\] _05065_ _05070_
+ VSS VSS VDD VDD _02376_ sky130_fd_sc_hd__o21ai_0
X_16324_ network.in_spk08_12 network.in_spk09_12 _09036_ network.in_spk10_12
+ VSS VSS VDD VDD _05071_ sky130_fd_sc_hd__o31ai_1
X_16325_ _06680_ _05071_ net369 VSS VSS VDD VDD _01959_ sky130_fd_sc_hd__a21oi_1
X_16326_ network.neuron_in047.counter\[1\] network.neuron_in047.counter\[0\]
+ _00268_ VSS VSS VDD VDD _05072_ sky130_fd_sc_hd__o21bai_1
X_16327_ _04059_ _05072_ network.neuron_in047.counter\[3\]
+ VSS VSS VDD VDD _05073_ sky130_fd_sc_hd__a21oi_1
X_16328_ _04059_ _00267_ _00266_ network.neuron_in047.counter\[3\]
+ _05073_ VSS VSS VDD VDD _05074_ sky130_fd_sc_hd__a41o_1
X_16329_ net386 _04058_ network.in_period\[47\]\[3\] VSS VSS
+ VDD VDD _05075_ sky130_fd_sc_hd__a21oi_1
X_16330_ net386 _05074_ _05075_ VSS VSS VDD VDD _02255_ sky130_fd_sc_hd__a21oi_1
X_16331_ _00262_ _04136_ _00263_ VSS VSS VDD VDD _05076_ sky130_fd_sc_hd__nand3_1
X_16332_ net371 _04116_ _05076_ VSS VSS VDD VDD _05077_ sky130_fd_sc_hd__nor3_1
X_16333_ network.in_period\[48\]\[3\] _04116_ _05077_ VSS
+ VSS VDD VDD _05078_ sky130_fd_sc_hd__a21oi_1
X_16334_ network.in_period\[48\]\[3\] net371 VSS VSS VDD VDD
+ _05079_ sky130_fd_sc_hd__and2_1
X_16335_ network.neuron_in048.counter\[3\] net389 _05076_
+ _05079_ VSS VSS VDD VDD _05080_ sky130_fd_sc_hd__a31oi_1
X_16336_ network.neuron_in048.counter\[3\] _05078_ _05080_
+ VSS VSS VDD VDD _02259_ sky130_fd_sc_hd__o21ai_0
X_16337_ network.neuron_in088.counter\[2\] VSS VSS VDD VDD
+ _05081_ sky130_fd_sc_hd__inv_1
X_16338_ network.neuron_in088.counter\[3\] network.in_period\[88\]\[2\]
+ net377 _00036_ VSS VSS VDD VDD _05082_ sky130_fd_sc_hd__o22ai_1
X_16339_ network.neuron_in088.counter\[2\] _00036_ net387
+ VSS VSS VDD VDD _05083_ sky130_fd_sc_hd__nand3_1
X_16340_ network.in_period\[88\]\[2\] net387 _05083_ VSS VSS
+ VDD VDD _05084_ sky130_fd_sc_hd__o21ai_0
X_16341_ _05081_ _05082_ _05084_ VSS VSS VDD VDD _02418_ sky130_fd_sc_hd__a21oi_1
X_16342_ network.in_spk08_12 _09036_ network.in_spk09_12 VSS
+ VSS VDD VDD _05085_ sky130_fd_sc_hd__o21ai_0
X_16343_ _06715_ _05085_ net369 VSS VSS VDD VDD _01960_ sky130_fd_sc_hd__a21oi_1
X_16344_ network.neuron_in049.counter\[0\] network.neuron_in049.counter\[1\]
+ _00260_ VSS VSS VDD VDD _05086_ sky130_fd_sc_hd__o21bai_1
X_16345_ _04123_ _05086_ network.neuron_in049.counter\[3\]
+ VSS VSS VDD VDD _05087_ sky130_fd_sc_hd__a21oi_1
X_16346_ _04123_ _00258_ _00259_ network.neuron_in049.counter\[3\]
+ _05087_ VSS VSS VDD VDD _05088_ sky130_fd_sc_hd__a41o_1
X_16347_ net388 _04122_ network.in_period\[49\]\[3\] VSS VSS
+ VDD VDD _05089_ sky130_fd_sc_hd__a21oi_1
X_16348_ net388 _05088_ _05089_ VSS VSS VDD VDD _02263_ sky130_fd_sc_hd__a21oi_1
X_16349_ net396 _04470_ VSS VSS VDD VDD _05090_ sky130_fd_sc_hd__nand2_1
X_16350_ network.in_period\[82\]\[0\] _05090_ VSS VSS VDD
+ VDD _05091_ sky130_fd_sc_hd__nand2_1
X_16351_ network.neuron_in082.counter\[0\] _05090_ _05091_
+ VSS VSS VDD VDD _02392_ sky130_fd_sc_hd__o21ai_0
X_16352_ network.neuron_in050.counter\[2\] network.neuron_in050.counter\[1\]
+ network.neuron_in050.counter\[0\] VSS VSS VDD VDD _05092_
+ sky130_fd_sc_hd__nor3_1
X_16353_ network.neuron_in050.counter\[3\] _05092_ VSS VSS
+ VDD VDD _05093_ sky130_fd_sc_hd__xnor2_1
X_16354_ network.in_period\[50\]\[3\] _04129_ VSS VSS VDD
+ VDD _05094_ sky130_fd_sc_hd__nand2_1
X_16355_ _04129_ _05093_ _05094_ VSS VSS VDD VDD _02267_ sky130_fd_sc_hd__o21ai_0
X_16356_ net387 _04453_ VSS VSS VDD VDD _05095_ sky130_fd_sc_hd__nand2_1
X_16357_ network.in_period\[87\]\[0\] _05095_ VSS VSS VDD
+ VDD _05096_ sky130_fd_sc_hd__nand2_1
X_16358_ network.neuron_in087.counter\[0\] _05095_ _05096_
+ VSS VSS VDD VDD _02412_ sky130_fd_sc_hd__o21ai_0
X_16359_ network.in_spk08_12 _09036_ VSS VSS VDD VDD _05097_
+ sky130_fd_sc_hd__nand2_1
X_16360_ _06675_ _05097_ net369 VSS VSS VDD VDD _01961_ sky130_fd_sc_hd__a21oi_1
X_16361_ network.neuron_in051.counter\[1\] network.neuron_in051.counter\[0\]
+ _00523_ VSS VSS VDD VDD _05098_ sky130_fd_sc_hd__o21bai_1
X_16362_ _04086_ _05098_ network.neuron_in051.counter\[3\]
+ VSS VSS VDD VDD _05099_ sky130_fd_sc_hd__a21oi_1
X_16363_ _04086_ _00522_ _00521_ network.neuron_in051.counter\[3\]
+ _05099_ VSS VSS VDD VDD _05100_ sky130_fd_sc_hd__a41o_1
X_16364_ net389 _04150_ network.in_period\[51\]\[3\] VSS VSS
+ VDD VDD _05101_ sky130_fd_sc_hd__a21oi_1
X_16365_ net389 _05100_ _05101_ VSS VSS VDD VDD _02271_ sky130_fd_sc_hd__a21oi_1
X_16366_ network.neuron_in080.counter\[3\] network.in_period\[80\]\[2\]
+ _00070_ net377 VSS VSS VDD VDD _05102_ sky130_fd_sc_hd__o22ai_1
X_16367_ network.neuron_in080.counter\[2\] _00070_ net396
+ VSS VSS VDD VDD _05103_ sky130_fd_sc_hd__nand3_1
X_16368_ network.in_period\[80\]\[2\] net396 _05103_ VSS VSS
+ VDD VDD _05104_ sky130_fd_sc_hd__o21ai_0
X_16369_ _04476_ _05102_ _05104_ VSS VSS VDD VDD _02386_ sky130_fd_sc_hd__a21oi_1
X_16370_ _00254_ _00255_ _04131_ VSS VSS VDD VDD _05105_ sky130_fd_sc_hd__nand3_1
X_16371_ net371 _04155_ _05105_ VSS VSS VDD VDD _05106_ sky130_fd_sc_hd__nor3_1
X_16372_ network.in_period\[52\]\[3\] _04155_ _05106_ VSS
+ VSS VDD VDD _05107_ sky130_fd_sc_hd__a21oi_1
X_16373_ network.in_period\[52\]\[3\] net371 VSS VSS VDD VDD
+ _05108_ sky130_fd_sc_hd__and2_1
X_16374_ network.neuron_in052.counter\[3\] net389 _05105_
+ _05108_ VSS VSS VDD VDD _05109_ sky130_fd_sc_hd__a31oi_1
X_16375_ network.neuron_in052.counter\[3\] _05107_ _05109_
+ VSS VSS VDD VDD _02275_ sky130_fd_sc_hd__o21ai_0
X_16376_ network.in_period\[82\]\[1\] _05090_ VSS VSS VDD
+ VDD _05110_ sky130_fd_sc_hd__nand2_1
X_16377_ _00065_ _05090_ _05110_ VSS VSS VDD VDD _02393_ sky130_fd_sc_hd__o21ai_0
X_16378_ _09034_ _09035_ VSS VSS VDD VDD _05111_ sky130_fd_sc_hd__nand2_1
X_16379_ network.in_spk06_12 _05111_ network.in_spk07_12 VSS
+ VSS VDD VDD _05112_ sky130_fd_sc_hd__o21ai_0
X_16380_ _06741_ _05112_ net369 VSS VSS VDD VDD _01962_ sky130_fd_sc_hd__a21oi_1
X_16381_ network.neuron_in053.counter\[2\] network.neuron_in053.counter\[1\]
+ network.neuron_in053.counter\[0\] VSS VSS VDD VDD _05113_
+ sky130_fd_sc_hd__nor3_1
X_16382_ network.neuron_in053.counter\[3\] _05113_ VSS VSS
+ VDD VDD _05114_ sky130_fd_sc_hd__xnor2_1
X_16383_ network.in_period\[53\]\[3\] _04177_ VSS VSS VDD
+ VDD _05115_ sky130_fd_sc_hd__nand2_1
X_16384_ _04177_ _05114_ _05115_ VSS VSS VDD VDD _02279_ sky130_fd_sc_hd__o21ai_0
X_16385_ _00052_ network.neuron_in085.counter\[2\] VSS VSS
+ VDD VDD _05116_ sky130_fd_sc_hd__xnor2_1
Xplace383 net407 VSS VSS VDD VDD net382 sky130_fd_sc_hd__buf_4
X_16387_ net387 _04461_ network.in_period\[85\]\[2\] VSS VSS
+ VDD VDD _05118_ sky130_fd_sc_hd__a21oi_1
X_16388_ net387 _05116_ _05118_ VSS VSS VDD VDD _02406_ sky130_fd_sc_hd__a21oi_1
X_16389_ _00247_ _00246_ _04179_ VSS VSS VDD VDD _05119_ sky130_fd_sc_hd__nand3_1
X_16390_ net371 _04192_ _05119_ VSS VSS VDD VDD _05120_ sky130_fd_sc_hd__nor3_1
X_16391_ network.in_period\[54\]\[3\] _04192_ _05120_ VSS
+ VSS VDD VDD _05121_ sky130_fd_sc_hd__a21oi_1
X_16392_ network.in_period\[54\]\[3\] net371 VSS VSS VDD VDD
+ _05122_ sky130_fd_sc_hd__and2_1
X_16393_ network.neuron_in054.counter\[3\] net389 _05119_
+ _05122_ VSS VSS VDD VDD _05123_ sky130_fd_sc_hd__a31oi_1
X_16394_ network.neuron_in054.counter\[3\] _05121_ _05123_
+ VSS VSS VDD VDD _02283_ sky130_fd_sc_hd__o21ai_0
X_16395_ network.in_period\[87\]\[1\] _05095_ VSS VSS VDD
+ VDD _05124_ sky130_fd_sc_hd__nand2_1
X_16396_ _00045_ _05095_ _05124_ VSS VSS VDD VDD _02413_ sky130_fd_sc_hd__o21ai_0
X_16397_ network.in_spk06_12 _05111_ VSS VSS VDD VDD _05125_
+ sky130_fd_sc_hd__nand2_1
X_16398_ _06736_ _05125_ net369 VSS VSS VDD VDD _01963_ sky130_fd_sc_hd__a21oi_1
X_16399_ _00241_ _04168_ _00240_ VSS VSS VDD VDD _05126_ sky130_fd_sc_hd__nand3_1
X_16400_ net373 _04161_ _05126_ VSS VSS VDD VDD _05127_ sky130_fd_sc_hd__nor3_1
X_16401_ network.in_period\[55\]\[3\] _04161_ _05127_ VSS
+ VSS VDD VDD _05128_ sky130_fd_sc_hd__a21oi_1
Xplace385 net394 VSS VSS VDD VDD net384 sky130_fd_sc_hd__buf_4
Xplace388 net390 VSS VSS VDD VDD net387 sky130_fd_sc_hd__buf_4
X_16404_ network.in_period\[55\]\[3\] net373 VSS VSS VDD VDD
+ _05131_ sky130_fd_sc_hd__and2_1
X_16405_ network.neuron_in055.counter\[3\] net388 _05126_
+ _05131_ VSS VSS VDD VDD _05132_ sky130_fd_sc_hd__a31oi_1
X_16406_ network.neuron_in055.counter\[3\] _05128_ _05132_
+ VSS VSS VDD VDD _02287_ sky130_fd_sc_hd__o21ai_0
X_16407_ net395 _04481_ VSS VSS VDD VDD _05133_ sky130_fd_sc_hd__nand2_1
X_16408_ network.in_period\[79\]\[1\] _05133_ VSS VSS VDD
+ VDD _05134_ sky130_fd_sc_hd__nand2_1
X_16409_ _00092_ _05133_ _05134_ VSS VSS VDD VDD _02381_ sky130_fd_sc_hd__o21ai_0
Xplace387 net393 VSS VSS VDD VDD net386 sky130_fd_sc_hd__buf_4
X_16411_ _00224_ _04201_ _00225_ VSS VSS VDD VDD _05136_ sky130_fd_sc_hd__nand3_1
X_16412_ net373 _04183_ _05136_ VSS VSS VDD VDD _05137_ sky130_fd_sc_hd__nor3_1
X_16413_ network.in_period\[56\]\[3\] _04183_ _05137_ VSS
+ VSS VDD VDD _05138_ sky130_fd_sc_hd__a21oi_1
X_16414_ network.in_period\[56\]\[3\] net373 VSS VSS VDD VDD
+ _05139_ sky130_fd_sc_hd__and2_1
X_16415_ network.neuron_in056.counter\[3\] net388 _05136_
+ _05139_ VSS VSS VDD VDD _05140_ sky130_fd_sc_hd__a31oi_1
X_16416_ network.neuron_in056.counter\[3\] _05138_ _05140_
+ VSS VSS VDD VDD _02291_ sky130_fd_sc_hd__o21ai_0
X_16417_ network.in_spk04_12 _09087_ network.in_spk05_12 VSS
+ VSS VDD VDD _05141_ sky130_fd_sc_hd__o21ai_0
Xplace394 net394 VSS VSS VDD VDD net393 sky130_fd_sc_hd__buf_4
X_16419_ _06558_ _05141_ net369 VSS VSS VDD VDD _01964_ sky130_fd_sc_hd__a21oi_1
X_16420_ network.neuron_in057.counter\[1\] network.neuron_in057.counter\[2\]
+ network.neuron_in057.counter\[0\] VSS VSS VDD VDD _05143_
+ sky130_fd_sc_hd__nor3_1
X_16421_ network.neuron_in057.counter\[3\] _05143_ VSS VSS
+ VDD VDD _05144_ sky130_fd_sc_hd__xnor2_1
X_16422_ network.in_period\[57\]\[3\] _04166_ VSS VSS VDD
+ VDD _05145_ sky130_fd_sc_hd__nand2_1
X_16423_ _04166_ _05144_ _05145_ VSS VSS VDD VDD _02295_ sky130_fd_sc_hd__o21ai_0
X_16424_ network.neuron_in081.counter\[2\] net396 VSS VSS
+ VDD VDD _05146_ sky130_fd_sc_hd__nand2_1
X_16425_ network.neuron_in081.counter\[3\] network.in_period\[81\]\[2\]
+ _05146_ VSS VSS VDD VDD _05147_ sky130_fd_sc_hd__o21ai_0
X_16426_ _00074_ network.neuron_in081.counter\[2\] net379
+ VSS VSS VDD VDD _05148_ sky130_fd_sc_hd__or3_1
X_16427_ network.in_period\[81\]\[2\] net396 _05148_ VSS VSS
+ VDD VDD _05149_ sky130_fd_sc_hd__o21ai_0
X_16428_ _00074_ _05147_ _05149_ VSS VSS VDD VDD _02390_ sky130_fd_sc_hd__a21oi_1
X_16429_ network.neuron_in058.counter\[1\] network.neuron_in058.counter\[2\]
+ network.neuron_in058.counter\[0\] VSS VSS VDD VDD _05150_
+ sky130_fd_sc_hd__nor3_1
X_16430_ network.neuron_in058.counter\[3\] _05150_ VSS VSS
+ VDD VDD _05151_ sky130_fd_sc_hd__xnor2_1
X_16431_ network.in_period\[58\]\[3\] _04242_ VSS VSS VDD
+ VDD _05152_ sky130_fd_sc_hd__nand2_1
X_16432_ _04242_ _05151_ _05152_ VSS VSS VDD VDD _02299_ sky130_fd_sc_hd__o21ai_0
X_16433_ network.neuron_in082.counter\[2\] VSS VSS VDD VDD
+ _05153_ sky130_fd_sc_hd__inv_1
X_16434_ network.neuron_in082.counter\[3\] network.in_period\[82\]\[2\]
+ _00064_ net377 VSS VSS VDD VDD _05154_ sky130_fd_sc_hd__o22ai_1
X_16435_ network.neuron_in082.counter\[2\] _00064_ net396
+ VSS VSS VDD VDD _05155_ sky130_fd_sc_hd__nand3_1
X_16436_ network.in_period\[82\]\[2\] net396 _05155_ VSS VSS
+ VDD VDD _05156_ sky130_fd_sc_hd__o21ai_0
X_16437_ _05153_ _05154_ _05156_ VSS VSS VDD VDD _02394_ sky130_fd_sc_hd__a21oi_1
X_16438_ network.in_spk04_12 _09087_ VSS VSS VDD VDD _05157_
+ sky130_fd_sc_hd__nand2_1
X_16439_ _06649_ _05157_ net369 VSS VSS VDD VDD _01965_ sky130_fd_sc_hd__a21oi_1
X_16440_ network.neuron_in059.counter\[0\] network.neuron_in059.counter\[1\]
+ _00206_ VSS VSS VDD VDD _05158_ sky130_fd_sc_hd__o21bai_1
X_16441_ _04252_ _05158_ network.neuron_in059.counter\[3\]
+ VSS VSS VDD VDD _05159_ sky130_fd_sc_hd__a21oi_1
X_16442_ _04252_ _00204_ _00205_ network.neuron_in059.counter\[3\]
+ _05159_ VSS VSS VDD VDD _05160_ sky130_fd_sc_hd__a41o_1
X_16443_ net388 _04251_ network.in_period\[59\]\[3\] VSS VSS
+ VDD VDD _05161_ sky130_fd_sc_hd__a21oi_1
X_16444_ net388 _05160_ _05161_ VSS VSS VDD VDD _02303_ sky130_fd_sc_hd__a21oi_1
X_16445_ net385 _04467_ VSS VSS VDD VDD _05162_ sky130_fd_sc_hd__nand2_1
X_16446_ network.in_period\[83\]\[0\] _05162_ VSS VSS VDD
+ VDD _05163_ sky130_fd_sc_hd__nand2_1
X_16447_ network.neuron_in083.counter\[0\] _05162_ _05163_
+ VSS VSS VDD VDD _02396_ sky130_fd_sc_hd__o21ai_0
X_16448_ network.neuron_in060.counter\[0\] network.neuron_in060.counter\[1\]
+ network.neuron_in060.counter\[2\] VSS VSS VDD VDD _05164_
+ sky130_fd_sc_hd__or3_1
X_16449_ net373 _04244_ _05164_ VSS VSS VDD VDD _05165_ sky130_fd_sc_hd__nor3_1
X_16450_ network.in_period\[60\]\[3\] _04244_ _05165_ VSS
+ VSS VDD VDD _05166_ sky130_fd_sc_hd__a21oi_1
X_16451_ network.in_period\[60\]\[3\] net373 VSS VSS VDD VDD
+ _05167_ sky130_fd_sc_hd__and2_1
X_16452_ network.neuron_in060.counter\[3\] net391 _05164_
+ _05167_ VSS VSS VDD VDD _05168_ sky130_fd_sc_hd__a31oi_1
X_16453_ network.neuron_in060.counter\[3\] _05166_ _05168_
+ VSS VSS VDD VDD _02307_ sky130_fd_sc_hd__o21ai_0
X_16454_ net396 _04464_ VSS VSS VDD VDD _05169_ sky130_fd_sc_hd__nand2_1
X_16455_ network.in_period\[84\]\[0\] _05169_ VSS VSS VDD
+ VDD _05170_ sky130_fd_sc_hd__nand2_1
X_16456_ network.neuron_in084.counter\[0\] _05169_ _05170_
+ VSS VSS VDD VDD _02400_ sky130_fd_sc_hd__o21ai_0
X_16457_ _09085_ _09086_ network.in_spk03_12 VSS VSS VDD VDD
+ _05171_ sky130_fd_sc_hd__o21ai_0
X_16458_ _06573_ _05171_ net369 VSS VSS VDD VDD _01966_ sky130_fd_sc_hd__a21oi_1
X_16459_ network.neuron_in061.counter\[2\] network.neuron_in061.counter\[1\]
+ network.neuron_in061.counter\[0\] VSS VSS VDD VDD _05172_
+ sky130_fd_sc_hd__nor3_1
X_16460_ network.neuron_in061.counter\[3\] _05172_ VSS VSS
+ VDD VDD _05173_ sky130_fd_sc_hd__xnor2_1
X_16461_ network.in_period\[61\]\[3\] _04300_ VSS VSS VDD
+ VDD _05174_ sky130_fd_sc_hd__nand2_1
X_16462_ _04300_ _05173_ _05174_ VSS VSS VDD VDD _02311_ sky130_fd_sc_hd__o21ai_0
X_16463_ network.neuron_in086.counter\[2\] _00048_ VSS VSS
+ VDD VDD _05175_ sky130_fd_sc_hd__xnor2_1
X_16464_ net387 _04457_ network.in_period\[86\]\[2\] VSS VSS
+ VDD VDD _05176_ sky130_fd_sc_hd__a21oi_1
X_16465_ net387 _05175_ _05176_ VSS VSS VDD VDD _02410_ sky130_fd_sc_hd__a21oi_1
X_16466_ _00559_ _04276_ _00560_ VSS VSS VDD VDD _05177_ sky130_fd_sc_hd__nand3_1
X_16467_ net373 _04268_ _05177_ VSS VSS VDD VDD _05178_ sky130_fd_sc_hd__nor3_1
X_16468_ network.in_period\[62\]\[3\] _04268_ _05178_ VSS
+ VSS VDD VDD _05179_ sky130_fd_sc_hd__a21oi_1
X_16469_ network.in_period\[62\]\[3\] net373 VSS VSS VDD VDD
+ _05180_ sky130_fd_sc_hd__and2_1
X_16470_ network.neuron_in062.counter\[3\] net388 _05177_
+ _05180_ VSS VSS VDD VDD _05181_ sky130_fd_sc_hd__a31oi_1
X_16471_ network.neuron_in062.counter\[3\] _05179_ _05181_
+ VSS VSS VDD VDD _02315_ sky130_fd_sc_hd__o21ai_0
X_16472_ network.neuron_in087.counter\[3\] network.in_period\[87\]\[2\]
+ net377 _00044_ VSS VSS VDD VDD _05182_ sky130_fd_sc_hd__o22ai_1
X_16473_ network.neuron_in087.counter\[2\] _00044_ net387
+ VSS VSS VDD VDD _05183_ sky130_fd_sc_hd__nand3_1
X_16474_ network.in_period\[87\]\[2\] net387 _05183_ VSS VSS
+ VDD VDD _05184_ sky130_fd_sc_hd__o21ai_0
X_16475_ _04452_ _05182_ _05184_ VSS VSS VDD VDD _02414_ sky130_fd_sc_hd__a21oi_1
X_16476_ _09234_ _09035_ VSS VSS VDD VDD _05185_ sky130_fd_sc_hd__nand2_1
X_16477_ network.in_spk02_12 _05185_ VSS VSS VDD VDD _05186_
+ sky130_fd_sc_hd__nand2_1
X_16478_ _06600_ _05186_ net369 VSS VSS VDD VDD _01967_ sky130_fd_sc_hd__a21oi_1
X_16479_ network.neuron_in063.counter\[1\] network.neuron_in063.counter\[0\]
+ network.neuron_in063.counter\[2\] VSS VSS VDD VDD _05187_
+ sky130_fd_sc_hd__nor3_1
X_16480_ network.neuron_in063.counter\[3\] _05187_ VSS VSS
+ VDD VDD _05188_ sky130_fd_sc_hd__xnor2_1
X_16481_ network.in_period\[63\]\[3\] _04282_ VSS VSS VDD
+ VDD _05189_ sky130_fd_sc_hd__nand2_1
X_16482_ _04282_ _05188_ _05189_ VSS VSS VDD VDD _02319_ sky130_fd_sc_hd__o21ai_0
X_16483_ network.neuron_in079.counter\[3\] network.in_period\[79\]\[2\]
+ net378 _00091_ VSS VSS VDD VDD _05190_ sky130_fd_sc_hd__o22ai_1
X_16484_ network.neuron_in079.counter\[2\] _00091_ net395
+ VSS VSS VDD VDD _05191_ sky130_fd_sc_hd__nand3_1
X_16485_ network.in_period\[79\]\[2\] net395 _05191_ VSS VSS
+ VDD VDD _05192_ sky130_fd_sc_hd__o21ai_0
X_16486_ _04480_ _05190_ _05192_ VSS VSS VDD VDD _02382_ sky130_fd_sc_hd__a21oi_1
X_16487_ network.neuron_in064.counter\[1\] network.neuron_in064.counter\[0\]
+ network.neuron_in064.counter\[2\] VSS VSS VDD VDD _05193_
+ sky130_fd_sc_hd__or3_1
X_16488_ net378 _04272_ _05193_ VSS VSS VDD VDD _05194_ sky130_fd_sc_hd__nor3_1
X_16489_ network.in_period\[64\]\[3\] _04272_ _05194_ VSS
+ VSS VDD VDD _05195_ sky130_fd_sc_hd__a21oi_1
X_16490_ network.in_period\[64\]\[3\] net378 VSS VSS VDD VDD
+ _05196_ sky130_fd_sc_hd__and2_1
X_16491_ network.neuron_in064.counter\[3\] net396 _05193_
+ _05196_ VSS VSS VDD VDD _05197_ sky130_fd_sc_hd__a31oi_1
X_16492_ network.neuron_in064.counter\[3\] _05195_ _05197_
+ VSS VSS VDD VDD _02323_ sky130_fd_sc_hd__o21ai_0
X_16493_ network.in_spk00_12 _09086_ network.in_spk01_12 VSS
+ VSS VDD VDD _05198_ sky130_fd_sc_hd__o21ai_0
X_16494_ _06639_ _05198_ net369 VSS VSS VDD VDD _01968_ sky130_fd_sc_hd__a21oi_1
X_16495_ _00173_ _00172_ _04344_ VSS VSS VDD VDD _05199_ sky130_fd_sc_hd__nand3_1
X_16496_ net378 _04310_ _05199_ VSS VSS VDD VDD _05200_ sky130_fd_sc_hd__nor3_1
X_16497_ network.in_period\[65\]\[3\] _04310_ _05200_ VSS
+ VSS VDD VDD _05201_ sky130_fd_sc_hd__a21oi_1
X_16498_ network.in_period\[65\]\[3\] net378 VSS VSS VDD VDD
+ _05202_ sky130_fd_sc_hd__and2_1
X_16499_ network.neuron_in065.counter\[3\] net395 _05199_
+ _05202_ VSS VSS VDD VDD _05203_ sky130_fd_sc_hd__a31oi_1
X_16500_ network.neuron_in065.counter\[3\] _05201_ _05203_
+ VSS VSS VDD VDD _02327_ sky130_fd_sc_hd__o21ai_0
X_16501_ network.neuron_in079.counter\[0\] VSS VSS VDD VDD
+ _00089_ sky130_fd_sc_hd__inv_1
X_16502_ network.in_period\[79\]\[0\] _05133_ VSS VSS VDD
+ VDD _05204_ sky130_fd_sc_hd__nand2_1
X_16503_ network.neuron_in079.counter\[0\] _05133_ _05204_
+ VSS VSS VDD VDD _02380_ sky130_fd_sc_hd__o21ai_0
X_16504_ network.neuron_in066.counter\[1\] network.neuron_in066.counter\[2\]
+ network.neuron_in066.counter\[0\] VSS VSS VDD VDD _05205_
+ sky130_fd_sc_hd__nor3_1
X_16505_ network.neuron_in066.counter\[3\] _05205_ VSS VSS
+ VDD VDD _05206_ sky130_fd_sc_hd__xnor2_1
X_16506_ network.in_period\[66\]\[3\] _04315_ VSS VSS VDD
+ VDD _05207_ sky130_fd_sc_hd__nand2_1
X_16507_ _04315_ _05206_ _05207_ VSS VSS VDD VDD _02331_ sky130_fd_sc_hd__o21ai_0
X_16508_ network.in_spk00_12 _09086_ VSS VSS VDD VDD _05208_
+ sky130_fd_sc_hd__nand2_1
X_16509_ _06568_ _05208_ net369 VSS VSS VDD VDD _01969_ sky130_fd_sc_hd__a21oi_1
Xplace390 net390 VSS VSS VDD VDD net389 sky130_fd_sc_hd__buf_4
X_16511_ network.neuron_in067.counter\[1\] network.neuron_in067.counter\[0\]
+ _00157_ VSS VSS VDD VDD _05210_ sky130_fd_sc_hd__o21bai_1
X_16512_ _04306_ _05210_ network.neuron_in067.counter\[3\]
+ VSS VSS VDD VDD _05211_ sky130_fd_sc_hd__a21oi_1
X_16513_ _04306_ _00156_ _00155_ network.neuron_in067.counter\[3\]
+ _05211_ VSS VSS VDD VDD _05212_ sky130_fd_sc_hd__a41o_1
X_16514_ net398 _04305_ network.in_period\[67\]\[3\] VSS VSS
+ VDD VDD _05213_ sky130_fd_sc_hd__a21oi_1
X_16515_ net398 _05212_ _05213_ VSS VSS VDD VDD _02335_ sky130_fd_sc_hd__a21oi_1
X_16516_ net396 _04477_ VSS VSS VDD VDD _05214_ sky130_fd_sc_hd__nand2_1
X_16517_ network.in_period\[80\]\[1\] _05214_ VSS VSS VDD
+ VDD _05215_ sky130_fd_sc_hd__nand2_1
X_16518_ _00071_ _05214_ _05215_ VSS VSS VDD VDD _02385_ sky130_fd_sc_hd__o21ai_0
X_16519_ _00150_ _04370_ _00149_ VSS VSS VDD VDD _05216_ sky130_fd_sc_hd__nand3_1
X_16520_ net378 _04363_ _05216_ VSS VSS VDD VDD _05217_ sky130_fd_sc_hd__nor3_1
X_16521_ network.in_period\[68\]\[3\] _04363_ _05217_ VSS
+ VSS VDD VDD _05218_ sky130_fd_sc_hd__a21oi_1
X_16522_ network.in_period\[68\]\[3\] net378 VSS VSS VDD VDD
+ _05219_ sky130_fd_sc_hd__and2_1
X_16523_ network.neuron_in068.counter\[3\] net398 _05216_
+ _05219_ VSS VSS VDD VDD _05220_ sky130_fd_sc_hd__a31oi_1
X_16524_ network.neuron_in068.counter\[3\] _05218_ _05220_
+ VSS VSS VDD VDD _02339_ sky130_fd_sc_hd__o21ai_0
X_16525_ network.neuron_in080.counter\[0\] VSS VSS VDD VDD
+ _00068_ sky130_fd_sc_hd__inv_1
X_16526_ network.in_period\[80\]\[0\] _05214_ VSS VSS VDD
+ VDD _05221_ sky130_fd_sc_hd__nand2_1
X_16527_ network.neuron_in080.counter\[0\] _05214_ _05221_
+ VSS VSS VDD VDD _02384_ sky130_fd_sc_hd__o21ai_0
X_16528_ _08889_ _09198_ _08979_ VSS VSS VDD VDD _05222_ sky130_fd_sc_hd__nand3_1
X_16529_ network.in_spk12_11 network.in_spk13_11 network.in_spk14_11
+ _05222_ network.in_spk15_11 VSS VSS VDD VDD _05223_ sky130_fd_sc_hd__o41ai_1
X_16530_ _06594_ _05223_ net367 VSS VSS VDD VDD _01970_ sky130_fd_sc_hd__a21oi_1
X_16531_ network.neuron_in069.counter\[0\] network.neuron_in069.counter\[1\]
+ network.neuron_in069.counter\[2\] VSS VSS VDD VDD _05224_
+ sky130_fd_sc_hd__nor3_1
X_16532_ network.neuron_in069.counter\[3\] _05224_ VSS VSS
+ VDD VDD _05225_ sky130_fd_sc_hd__xnor2_1
X_16533_ network.in_period\[69\]\[3\] _04368_ VSS VSS VDD
+ VDD _05226_ sky130_fd_sc_hd__nand2_1
X_16534_ _04368_ _05225_ _05226_ VSS VSS VDD VDD _02343_ sky130_fd_sc_hd__o21ai_0
Xplace395 net407 VSS VSS VDD VDD net394 sky130_fd_sc_hd__buf_4
X_16536_ net396 _04473_ VSS VSS VDD VDD _05228_ sky130_fd_sc_hd__nand2_1
X_16537_ network.in_period\[81\]\[1\] _05228_ VSS VSS VDD
+ VDD _05229_ sky130_fd_sc_hd__nand2_1
X_16538_ _00075_ _05228_ _05229_ VSS VSS VDD VDD _02389_ sky130_fd_sc_hd__o21ai_0
X_16539_ _00138_ _04355_ _00137_ VSS VSS VDD VDD _05230_ sky130_fd_sc_hd__nand3_1
X_16540_ net378 _04380_ _05230_ VSS VSS VDD VDD _05231_ sky130_fd_sc_hd__nor3_1
X_16541_ network.in_period\[70\]\[3\] _04380_ _05231_ VSS
+ VSS VDD VDD _05232_ sky130_fd_sc_hd__a21oi_1
X_16542_ network.in_period\[70\]\[3\] net378 VSS VSS VDD VDD
+ _05233_ sky130_fd_sc_hd__and2_1
X_16543_ network.neuron_in070.counter\[3\] net398 _05230_
+ _05233_ VSS VSS VDD VDD _05234_ sky130_fd_sc_hd__a31oi_1
X_16544_ network.neuron_in070.counter\[3\] _05232_ _05234_
+ VSS VSS VDD VDD _02347_ sky130_fd_sc_hd__o21ai_0
X_16545_ network.in_period\[81\]\[0\] _05228_ VSS VSS VDD
+ VDD _05235_ sky130_fd_sc_hd__nand2_1
X_16546_ network.neuron_in081.counter\[0\] _05228_ _05235_
+ VSS VSS VDD VDD _02388_ sky130_fd_sc_hd__o21ai_0
X_16547_ network.in_spk12_11 network.in_spk13_11 _05222_ network.in_spk14_11
+ VSS VSS VDD VDD _05236_ sky130_fd_sc_hd__o31ai_1
X_16548_ _06563_ _05236_ net367 VSS VSS VDD VDD _01971_ sky130_fd_sc_hd__a21oi_1
X_16549_ _00133_ _00134_ _04608_ VSS VSS VDD VDD _05237_ sky130_fd_sc_hd__nand3_1
X_16550_ net378 _04504_ _05237_ VSS VSS VDD VDD _05238_ sky130_fd_sc_hd__nor3_1
X_16551_ network.in_period\[71\]\[3\] _04504_ _05238_ VSS
+ VSS VDD VDD _05239_ sky130_fd_sc_hd__a21oi_1
X_16552_ network.in_period\[71\]\[3\] net378 VSS VSS VDD VDD
+ _05240_ sky130_fd_sc_hd__and2_1
X_16553_ network.neuron_in071.counter\[3\] net398 _05237_
+ _05240_ VSS VSS VDD VDD _05241_ sky130_fd_sc_hd__a31oi_1
X_16554_ network.neuron_in071.counter\[3\] _05239_ _05241_
+ VSS VSS VDD VDD _02351_ sky130_fd_sc_hd__o21ai_0
X_16555_ network.neuron_in083.counter\[2\] _00060_ VSS VSS
+ VDD VDD _05242_ sky130_fd_sc_hd__xnor2_1
X_16556_ net385 _04467_ network.in_period\[83\]\[2\] VSS VSS
+ VDD VDD _05243_ sky130_fd_sc_hd__a21oi_1
X_16557_ net385 _05242_ _05243_ VSS VSS VDD VDD _02398_ sky130_fd_sc_hd__a21oi_1
X_16558_ _00529_ _04753_ _00530_ VSS VSS VDD VDD _05244_ sky130_fd_sc_hd__nand3_1
X_16559_ net378 _04501_ _05244_ VSS VSS VDD VDD _05245_ sky130_fd_sc_hd__nor3_1
X_16560_ network.in_period\[72\]\[3\] _04501_ _05245_ VSS
+ VSS VDD VDD _05246_ sky130_fd_sc_hd__a21oi_1
X_16561_ network.in_period\[72\]\[3\] net378 VSS VSS VDD VDD
+ _05247_ sky130_fd_sc_hd__and2_1
X_16562_ network.neuron_in072.counter\[3\] net398 _05244_
+ _05247_ VSS VSS VDD VDD _05248_ sky130_fd_sc_hd__a31oi_1
X_16563_ network.neuron_in072.counter\[3\] _05246_ _05248_
+ VSS VSS VDD VDD _02355_ sky130_fd_sc_hd__o21ai_0
X_16564_ network.in_period\[83\]\[1\] _05162_ VSS VSS VDD
+ VDD _05249_ sky130_fd_sc_hd__nand2_1
X_16565_ _00061_ _05162_ _05249_ VSS VSS VDD VDD _02397_ sky130_fd_sc_hd__o21ai_0
X_16566_ network.in_spk12_11 _05222_ network.in_spk13_11 VSS
+ VSS VDD VDD _05250_ sky130_fd_sc_hd__o21ai_0
X_16567_ _06587_ _05250_ net367 VSS VSS VDD VDD _01972_ sky130_fd_sc_hd__a21oi_1
X_16568_ network.neuron_in073.counter\[2\] network.neuron_in073.counter\[1\]
+ network.neuron_in073.counter\[0\] VSS VSS VDD VDD _05251_
+ sky130_fd_sc_hd__nor3_1
X_16569_ network.neuron_in073.counter\[3\] _05251_ VSS VSS
+ VDD VDD _05252_ sky130_fd_sc_hd__xnor2_1
X_16570_ network.in_period\[73\]\[3\] _04794_ VSS VSS VDD
+ VDD _05253_ sky130_fd_sc_hd__nand2_1
X_16571_ _04794_ _05252_ _05253_ VSS VSS VDD VDD _02359_ sky130_fd_sc_hd__o21ai_0
X_16572_ network.neuron_in084.counter\[2\] VSS VSS VDD VDD
+ _05254_ sky130_fd_sc_hd__inv_1
X_16573_ network.neuron_in084.counter\[3\] network.in_period\[84\]\[2\]
+ net379 _00056_ VSS VSS VDD VDD _05255_ sky130_fd_sc_hd__o22ai_1
Xplace393 net393 VSS VSS VDD VDD net392 sky130_fd_sc_hd__buf_4
X_16575_ network.neuron_in084.counter\[2\] _00056_ net396
+ VSS VSS VDD VDD _05257_ sky130_fd_sc_hd__nand3_1
X_16576_ network.in_period\[84\]\[2\] net396 _05257_ VSS VSS
+ VDD VDD _05258_ sky130_fd_sc_hd__o21ai_0
X_16577_ _05254_ _05255_ _05258_ VSS VSS VDD VDD _02402_ sky130_fd_sc_hd__a21oi_1
X_16578_ network.neuron_in074.counter\[2\] network.neuron_in074.counter\[0\]
+ network.neuron_in074.counter\[1\] VSS VSS VDD VDD _05259_
+ sky130_fd_sc_hd__nor3_1
X_16579_ network.neuron_in074.counter\[3\] _05259_ VSS VSS
+ VDD VDD _05260_ sky130_fd_sc_hd__xnor2_1
X_16580_ network.in_period\[74\]\[3\] _04967_ VSS VSS VDD
+ VDD _05261_ sky130_fd_sc_hd__nand2_1
X_16581_ _04967_ _05260_ _05261_ VSS VSS VDD VDD _02363_ sky130_fd_sc_hd__o21ai_0
X_16582_ network.in_period\[84\]\[1\] _05169_ VSS VSS VDD
+ VDD _05262_ sky130_fd_sc_hd__nand2_1
X_16583_ _00057_ _05169_ _05262_ VSS VSS VDD VDD _02401_ sky130_fd_sc_hd__o21ai_0
X_16584_ network.in_spk12_11 _05222_ VSS VSS VDD VDD _05263_
+ sky130_fd_sc_hd__nand2_1
X_16585_ _06616_ _05263_ net367 VSS VSS VDD VDD _01973_ sky130_fd_sc_hd__a21oi_1
X_16586_ network.in_period\[146\]\[2\] VSS VSS VDD VDD _05264_
+ sky130_fd_sc_hd__inv_1
X_16587_ _00609_ network.neuron_in146.counter\[2\] VSS VSS
+ VDD VDD _05265_ sky130_fd_sc_hd__xnor2_1
X_16588_ _05264_ _03508_ _05265_ net400 VSS VSS VDD VDD _02650_
+ sky130_fd_sc_hd__a22oi_1
X_16589_ _00113_ _00114_ _04998_ VSS VSS VDD VDD _05266_ sky130_fd_sc_hd__nand3_1
X_16590_ net378 _04494_ _05266_ VSS VSS VDD VDD _05267_ sky130_fd_sc_hd__nor3_1
X_16591_ network.in_period\[75\]\[3\] _04494_ _05267_ VSS
+ VSS VDD VDD _05268_ sky130_fd_sc_hd__a21oi_1
Xplace297 _08931_ VSS VSS VDD VDD net296 sky130_fd_sc_hd__buf_4
Xplace389 net389 VSS VSS VDD VDD net388 sky130_fd_sc_hd__buf_4
X_16594_ network.in_period\[75\]\[3\] net378 VSS VSS VDD VDD
+ _05271_ sky130_fd_sc_hd__and2_1
X_16595_ network.neuron_in075.counter\[3\] net398 _05266_
+ _05271_ VSS VSS VDD VDD _05272_ sky130_fd_sc_hd__a31oi_1
X_16596_ network.neuron_in075.counter\[3\] _05268_ _05272_
+ VSS VSS VDD VDD _02367_ sky130_fd_sc_hd__o21ai_0
X_16597_ net387 _04461_ VSS VSS VDD VDD _05273_ sky130_fd_sc_hd__nand2_1
X_16598_ network.in_period\[85\]\[1\] _05273_ VSS VSS VDD
+ VDD _05274_ sky130_fd_sc_hd__nand2_1
X_16599_ _00053_ _05273_ _05274_ VSS VSS VDD VDD _02405_ sky130_fd_sc_hd__o21ai_0
Xplace392 net392 VSS VSS VDD VDD net391 sky130_fd_sc_hd__buf_4
X_16601_ _00106_ _04870_ _00105_ VSS VSS VDD VDD _05276_ sky130_fd_sc_hd__nand3_1
X_16602_ net378 _04491_ _05276_ VSS VSS VDD VDD _05277_ sky130_fd_sc_hd__nor3_1
X_16603_ network.in_period\[76\]\[3\] _04491_ _05277_ VSS
+ VSS VDD VDD _05278_ sky130_fd_sc_hd__a21oi_1
X_16604_ network.in_period\[76\]\[3\] net378 VSS VSS VDD VDD
+ _05279_ sky130_fd_sc_hd__and2_1
X_16605_ network.neuron_in076.counter\[3\] net395 _05276_
+ _05279_ VSS VSS VDD VDD _05280_ sky130_fd_sc_hd__a31oi_1
X_16606_ network.neuron_in076.counter\[3\] _05278_ _05280_
+ VSS VSS VDD VDD _02371_ sky130_fd_sc_hd__o21ai_0
X_16607_ network.in_period\[85\]\[0\] _05273_ VSS VSS VDD
+ VDD _05281_ sky130_fd_sc_hd__nand2_1
X_16608_ network.neuron_in085.counter\[0\] _05273_ _05281_
+ VSS VSS VDD VDD _02404_ sky130_fd_sc_hd__o21ai_0
X_16609_ network.in_spk08_11 network.in_spk09_11 network.in_spk10_11
+ _08980_ network.in_spk11_11 VSS VSS VDD VDD _05282_ sky130_fd_sc_hd__o41ai_1
Xplace391 net391 VSS VSS VDD VDD net390 sky130_fd_sc_hd__buf_4
X_16611_ _06454_ _05282_ net367 VSS VSS VDD VDD _01974_ sky130_fd_sc_hd__a21oi_1
X_16612_ network.neuron_in077.counter\[2\] network.neuron_in077.counter\[0\]
+ network.neuron_in077.counter\[1\] VSS VSS VDD VDD _05284_
+ sky130_fd_sc_hd__nor3_1
X_16613_ network.neuron_in077.counter\[3\] _05284_ VSS VSS
+ VDD VDD _05285_ sky130_fd_sc_hd__xnor2_1
X_16614_ network.in_period\[77\]\[3\] _04879_ VSS VSS VDD
+ VDD _05286_ sky130_fd_sc_hd__nand2_1
X_16615_ _04879_ _05285_ _05286_ VSS VSS VDD VDD _02375_ sky130_fd_sc_hd__o21ai_0
X_16616_ net387 _04457_ VSS VSS VDD VDD _05287_ sky130_fd_sc_hd__nand2_1
X_16617_ network.in_period\[86\]\[1\] _05287_ VSS VSS VDD
+ VDD _05288_ sky130_fd_sc_hd__nand2_1
X_16618_ _00049_ _05287_ _05288_ VSS VSS VDD VDD _02409_ sky130_fd_sc_hd__o21ai_0
X_16619_ network.neuron_in078.counter\[2\] network.neuron_in078.counter\[0\]
+ network.neuron_in078.counter\[1\] VSS VSS VDD VDD _05289_
+ sky130_fd_sc_hd__nor3_1
X_16620_ network.neuron_in078.counter\[3\] _05289_ VSS VSS
+ VDD VDD _05290_ sky130_fd_sc_hd__xnor2_1
X_16621_ network.in_period\[78\]\[3\] _05065_ VSS VSS VDD
+ VDD _05291_ sky130_fd_sc_hd__nand2_1
X_16622_ _05065_ _05290_ _05291_ VSS VSS VDD VDD _02379_ sky130_fd_sc_hd__o21ai_0
X_16623_ network.in_period\[86\]\[0\] _05287_ VSS VSS VDD
+ VDD _05292_ sky130_fd_sc_hd__nand2_1
X_16624_ network.neuron_in086.counter\[0\] _05287_ _05292_
+ VSS VSS VDD VDD _02408_ sky130_fd_sc_hd__o21ai_0
X_16625_ network.in_spk08_11 network.in_spk09_11 _08980_ network.in_spk10_11
+ VSS VSS VDD VDD _05293_ sky130_fd_sc_hd__o31ai_1
X_16626_ _06503_ _05293_ net367 VSS VSS VDD VDD _01975_ sky130_fd_sc_hd__a21oi_1
X_16627_ network.neuron_in079.counter\[0\] network.neuron_in079.counter\[1\]
+ _00091_ VSS VSS VDD VDD _05294_ sky130_fd_sc_hd__o21bai_1
X_16628_ _04480_ _05294_ network.neuron_in079.counter\[3\]
+ VSS VSS VDD VDD _05295_ sky130_fd_sc_hd__a21oi_1
X_16629_ _04480_ network.neuron_in079.counter\[3\] _00089_
+ _00090_ _05295_ VSS VSS VDD VDD _05296_ sky130_fd_sc_hd__a41o_1
X_16630_ net395 _04479_ network.in_period\[79\]\[3\] VSS VSS
+ VDD VDD _05297_ sky130_fd_sc_hd__a21oi_1
X_16631_ net395 _05296_ _05297_ VSS VSS VDD VDD _02383_ sky130_fd_sc_hd__a21oi_1
X_16632_ network.neuron_in080.counter\[1\] network.neuron_in080.counter\[0\]
+ _00070_ VSS VSS VDD VDD _05298_ sky130_fd_sc_hd__o21bai_1
X_16633_ _04476_ _05298_ network.neuron_in080.counter\[3\]
+ VSS VSS VDD VDD _05299_ sky130_fd_sc_hd__a21oi_1
X_16634_ _04476_ network.neuron_in080.counter\[3\] _00069_
+ _00068_ _05299_ VSS VSS VDD VDD _05300_ sky130_fd_sc_hd__a41o_1
X_16635_ net396 _04475_ network.in_period\[80\]\[3\] VSS VSS
+ VDD VDD _05301_ sky130_fd_sc_hd__a21oi_1
X_16636_ net396 _05300_ _05301_ VSS VSS VDD VDD _02387_ sky130_fd_sc_hd__a21oi_1
X_16637_ net385 _04422_ VSS VSS VDD VDD _05302_ sky130_fd_sc_hd__nand2_1
X_16638_ network.in_period\[96\]\[1\] _05302_ VSS VSS VDD
+ VDD _05303_ sky130_fd_sc_hd__nand2_1
X_16639_ _01212_ _05302_ _05303_ VSS VSS VDD VDD _02449_ sky130_fd_sc_hd__o21ai_0
X_16640_ network.in_spk08_11 _08980_ network.in_spk09_11 VSS
+ VSS VDD VDD _05304_ sky130_fd_sc_hd__o21ai_0
X_16641_ _06474_ _05304_ net367 VSS VSS VDD VDD _01976_ sky130_fd_sc_hd__a21oi_1
X_16642_ network.neuron_in081.counter\[0\] network.neuron_in081.counter\[1\]
+ network.neuron_in081.counter\[2\] VSS VSS VDD VDD _05305_
+ sky130_fd_sc_hd__or3_1
X_16643_ net379 _04472_ _05305_ VSS VSS VDD VDD _05306_ sky130_fd_sc_hd__nor3_1
X_16644_ network.in_period\[81\]\[3\] _04472_ _05306_ VSS
+ VSS VDD VDD _05307_ sky130_fd_sc_hd__a21oi_1
X_16645_ network.in_period\[81\]\[3\] net379 VSS VSS VDD VDD
+ _05308_ sky130_fd_sc_hd__and2_1
X_16646_ network.neuron_in081.counter\[3\] net396 _05305_
+ _05308_ VSS VSS VDD VDD _05309_ sky130_fd_sc_hd__a31oi_1
X_16647_ network.neuron_in081.counter\[3\] _05307_ _05309_
+ VSS VSS VDD VDD _02391_ sky130_fd_sc_hd__o21ai_0
X_16648_ network.neuron_in092.counter\[2\] VSS VSS VDD VDD
+ _05310_ sky130_fd_sc_hd__inv_1
X_16649_ network.neuron_in092.counter\[3\] network.in_period\[92\]\[2\]
+ net371 _01234_ VSS VSS VDD VDD _05311_ sky130_fd_sc_hd__o22ai_1
X_16650_ network.neuron_in092.counter\[2\] _01234_ net389
+ VSS VSS VDD VDD _05312_ sky130_fd_sc_hd__nand3_1
X_16651_ network.in_period\[92\]\[2\] net389 _05312_ VSS VSS
+ VDD VDD _05313_ sky130_fd_sc_hd__o21ai_0
X_16652_ _05310_ _05311_ _05313_ VSS VSS VDD VDD _02434_ sky130_fd_sc_hd__a21oi_1
X_16653_ _00063_ _00062_ _05153_ VSS VSS VDD VDD _05314_ sky130_fd_sc_hd__nand3_1
X_16654_ net377 _04469_ _05314_ VSS VSS VDD VDD _05315_ sky130_fd_sc_hd__nor3_1
X_16655_ network.in_period\[82\]\[3\] _04469_ _05315_ VSS
+ VSS VDD VDD _05316_ sky130_fd_sc_hd__a21oi_1
X_16656_ network.in_period\[82\]\[3\] net377 VSS VSS VDD VDD
+ _05317_ sky130_fd_sc_hd__and2_1
X_16657_ network.neuron_in082.counter\[3\] net396 _05314_
+ _05317_ VSS VSS VDD VDD _05318_ sky130_fd_sc_hd__a31oi_1
X_16658_ network.neuron_in082.counter\[3\] _05316_ _05318_
+ VSS VSS VDD VDD _02395_ sky130_fd_sc_hd__o21ai_0
X_16659_ network.neuron_in096.counter\[3\] network.in_period\[96\]\[2\]
+ net377 _01211_ VSS VSS VDD VDD _05319_ sky130_fd_sc_hd__o22ai_1
X_16660_ network.neuron_in096.counter\[2\] _01211_ net385
+ VSS VSS VDD VDD _05320_ sky130_fd_sc_hd__nand3_1
X_16661_ network.in_period\[96\]\[2\] net385 _05320_ VSS VSS
+ VDD VDD _05321_ sky130_fd_sc_hd__o21ai_0
X_16662_ _04421_ _05319_ _05321_ VSS VSS VDD VDD _02450_ sky130_fd_sc_hd__a21oi_1
X_16663_ network.in_spk08_11 _08980_ VSS VSS VDD VDD _05322_
+ sky130_fd_sc_hd__nand2_1
X_16664_ _06534_ _05322_ net367 VSS VSS VDD VDD _01977_ sky130_fd_sc_hd__a21oi_1
X_16665_ network.neuron_in083.counter\[1\] network.neuron_in083.counter\[2\]
+ network.neuron_in083.counter\[0\] VSS VSS VDD VDD _05323_
+ sky130_fd_sc_hd__nor3_1
X_16666_ network.neuron_in083.counter\[3\] _05323_ VSS VSS
+ VDD VDD _05324_ sky130_fd_sc_hd__xnor2_1
X_16667_ network.in_period\[83\]\[3\] _05162_ VSS VSS VDD
+ VDD _05325_ sky130_fd_sc_hd__nand2_1
X_16668_ _05162_ _05324_ _05325_ VSS VSS VDD VDD _02399_ sky130_fd_sc_hd__o21ai_0
X_16669_ _00573_ network.neuron_in090.counter\[2\] VSS VSS
+ VDD VDD _05326_ sky130_fd_sc_hd__xnor2_1
X_16670_ net389 _04443_ network.in_period\[90\]\[2\] VSS VSS
+ VDD VDD _05327_ sky130_fd_sc_hd__a21oi_1
X_16671_ net389 _05326_ _05327_ VSS VSS VDD VDD _02426_ sky130_fd_sc_hd__a21oi_1
X_16672_ _00055_ _05254_ _00054_ VSS VSS VDD VDD _05328_ sky130_fd_sc_hd__nand3_1
X_16673_ net379 _04463_ _05328_ VSS VSS VDD VDD _05329_ sky130_fd_sc_hd__nor3_1
X_16674_ network.in_period\[84\]\[3\] _04463_ _05329_ VSS
+ VSS VDD VDD _05330_ sky130_fd_sc_hd__a21oi_1
X_16675_ network.in_period\[84\]\[3\] net379 VSS VSS VDD VDD
+ _05331_ sky130_fd_sc_hd__and2_1
X_16676_ network.neuron_in084.counter\[3\] net396 _05328_
+ _05331_ VSS VSS VDD VDD _05332_ sky130_fd_sc_hd__a31oi_1
X_16677_ network.neuron_in084.counter\[3\] _05330_ _05332_
+ VSS VSS VDD VDD _02403_ sky130_fd_sc_hd__o21ai_0
X_16678_ network.in_spk06_11 _08941_ _09188_ network.in_spk07_11
+ VSS VSS VDD VDD _05333_ sky130_fd_sc_hd__o31ai_1
X_16679_ _06450_ _05333_ _06361_ VSS VSS VDD VDD _01978_ sky130_fd_sc_hd__a21oi_1
X_16680_ network.neuron_in085.counter\[1\] network.neuron_in085.counter\[0\]
+ network.neuron_in085.counter\[2\] VSS VSS VDD VDD _05334_
+ sky130_fd_sc_hd__nor3_1
X_16681_ network.neuron_in085.counter\[3\] _05334_ VSS VSS
+ VDD VDD _05335_ sky130_fd_sc_hd__xnor2_1
X_16682_ network.in_period\[85\]\[3\] _05273_ VSS VSS VDD
+ VDD _05336_ sky130_fd_sc_hd__nand2_1
X_16683_ _05273_ _05335_ _05336_ VSS VSS VDD VDD _02407_ sky130_fd_sc_hd__o21ai_0
X_16684_ network.neuron_in086.counter\[2\] network.neuron_in086.counter\[1\]
+ network.neuron_in086.counter\[0\] VSS VSS VDD VDD _05337_
+ sky130_fd_sc_hd__nor3_1
X_16685_ network.neuron_in086.counter\[3\] _05337_ VSS VSS
+ VDD VDD _05338_ sky130_fd_sc_hd__xnor2_1
X_16686_ network.in_period\[86\]\[3\] _05287_ VSS VSS VDD
+ VDD _05339_ sky130_fd_sc_hd__nand2_1
X_16687_ _05287_ _05338_ _05339_ VSS VSS VDD VDD _02411_ sky130_fd_sc_hd__o21ai_0
X_16688_ net387 _04449_ VSS VSS VDD VDD _05340_ sky130_fd_sc_hd__nand2_1
X_16689_ network.in_period\[88\]\[0\] _05340_ VSS VSS VDD
+ VDD _05341_ sky130_fd_sc_hd__nand2_1
X_16690_ network.neuron_in088.counter\[0\] _05340_ _05341_
+ VSS VSS VDD VDD _02416_ sky130_fd_sc_hd__o21ai_0
X_16691_ _08941_ _09188_ network.in_spk06_11 VSS VSS VDD VDD
+ _05342_ sky130_fd_sc_hd__o21ai_0
X_16692_ _06462_ _05342_ _06361_ VSS VSS VDD VDD _01979_ sky130_fd_sc_hd__a21oi_1
X_16693_ network.neuron_in087.counter\[0\] network.neuron_in087.counter\[1\]
+ _00044_ VSS VSS VDD VDD _05343_ sky130_fd_sc_hd__o21bai_1
X_16694_ _04452_ _05343_ network.neuron_in087.counter\[3\]
+ VSS VSS VDD VDD _05344_ sky130_fd_sc_hd__a21oi_1
X_16695_ _04452_ network.neuron_in087.counter\[3\] _00042_
+ _00043_ _05344_ VSS VSS VDD VDD _05345_ sky130_fd_sc_hd__a41o_1
X_16696_ net387 _04451_ network.in_period\[87\]\[3\] VSS VSS
+ VDD VDD _05346_ sky130_fd_sc_hd__a21oi_1
X_16697_ net387 _05345_ _05346_ VSS VSS VDD VDD _02415_ sky130_fd_sc_hd__a21oi_1
X_16698_ net387 _04446_ VSS VSS VDD VDD _05347_ sky130_fd_sc_hd__nand2_1
X_16699_ network.in_period\[89\]\[0\] _05347_ VSS VSS VDD
+ VDD _05348_ sky130_fd_sc_hd__nand2_1
X_16700_ network.neuron_in089.counter\[0\] _05347_ _05348_
+ VSS VSS VDD VDD _02420_ sky130_fd_sc_hd__o21ai_0
X_16701_ _00034_ _05081_ _00035_ VSS VSS VDD VDD _05349_ sky130_fd_sc_hd__nand3_1
X_16702_ net377 _04448_ _05349_ VSS VSS VDD VDD _05350_ sky130_fd_sc_hd__nor3_1
X_16703_ network.in_period\[88\]\[3\] _04448_ _05350_ VSS
+ VSS VDD VDD _05351_ sky130_fd_sc_hd__a21oi_1
X_16704_ network.in_period\[88\]\[3\] net377 VSS VSS VDD VDD
+ _05352_ sky130_fd_sc_hd__and2_1
X_16705_ network.neuron_in088.counter\[3\] net387 _05349_
+ _05352_ VSS VSS VDD VDD _05353_ sky130_fd_sc_hd__a31oi_1
X_16706_ network.neuron_in088.counter\[3\] _05351_ _05353_
+ VSS VSS VDD VDD _02419_ sky130_fd_sc_hd__o21ai_0
X_16707_ network.neuron_in091.counter\[2\] _00131_ VSS VSS
+ VDD VDD _05354_ sky130_fd_sc_hd__xnor2_1
X_16708_ net387 _04438_ VSS VSS VDD VDD _05355_ sky130_fd_sc_hd__nand2_1
X_16709_ network.in_period\[91\]\[2\] VSS VSS VDD VDD _05356_
+ sky130_fd_sc_hd__inv_1
X_16710_ net387 _05354_ _05355_ _05356_ VSS VSS VDD VDD _02430_
+ sky130_fd_sc_hd__a22oi_1
X_16711_ network.in_spk04_11 _08886_ _08941_ network.in_spk05_11
+ VSS VSS VDD VDD _05357_ sky130_fd_sc_hd__o31ai_1
X_16712_ _06492_ _05357_ _06361_ VSS VSS VDD VDD _01980_ sky130_fd_sc_hd__a21oi_1
X_16713_ network.neuron_in089.counter\[2\] network.neuron_in089.counter\[1\]
+ network.neuron_in089.counter\[0\] VSS VSS VDD VDD _05358_
+ sky130_fd_sc_hd__nor3_1
X_16714_ network.neuron_in089.counter\[3\] _05358_ VSS VSS
+ VDD VDD _05359_ sky130_fd_sc_hd__xnor2_1
X_16715_ network.in_period\[89\]\[3\] _05347_ VSS VSS VDD
+ VDD _05360_ sky130_fd_sc_hd__nand2_1
X_16716_ _05347_ _05359_ _05360_ VSS VSS VDD VDD _02423_ sky130_fd_sc_hd__o21ai_0
X_16717_ net389 _04443_ VSS VSS VDD VDD _05361_ sky130_fd_sc_hd__nand2_1
X_16718_ network.neuron_in090.counter\[0\] network.neuron_in090.counter\[1\]
+ network.neuron_in090.counter\[2\] VSS VSS VDD VDD _05362_
+ sky130_fd_sc_hd__nor3_1
X_16719_ network.neuron_in090.counter\[3\] _05362_ VSS VSS
+ VDD VDD _05363_ sky130_fd_sc_hd__xnor2_1
X_16720_ network.in_period\[90\]\[3\] _05361_ VSS VSS VDD
+ VDD _05364_ sky130_fd_sc_hd__nand2_1
X_16721_ _05361_ _05363_ _05364_ VSS VSS VDD VDD _02427_ sky130_fd_sc_hd__o21ai_0
X_16722_ _01238_ network.neuron_in093.counter\[2\] VSS VSS
+ VDD VDD _05365_ sky130_fd_sc_hd__xnor2_1
X_16723_ net389 _04432_ network.in_period\[93\]\[2\] VSS VSS
+ VDD VDD _05366_ sky130_fd_sc_hd__a21oi_1
X_16724_ net389 _05365_ _05366_ VSS VSS VDD VDD _02438_ sky130_fd_sc_hd__a21oi_1
X_16725_ _08886_ _08941_ network.in_spk04_11 VSS VSS VDD VDD
+ _05367_ sky130_fd_sc_hd__o21ai_0
X_16726_ _06458_ _05367_ _06361_ VSS VSS VDD VDD _01981_ sky130_fd_sc_hd__a21oi_1
X_16727_ network.neuron_in091.counter\[2\] network.neuron_in091.counter\[1\]
+ network.neuron_in091.counter\[0\] VSS VSS VDD VDD _05368_
+ sky130_fd_sc_hd__nor3_1
X_16728_ network.neuron_in091.counter\[3\] _05368_ VSS VSS
+ VDD VDD _05369_ sky130_fd_sc_hd__xnor2_1
X_16729_ network.in_period\[91\]\[3\] _05355_ VSS VSS VDD
+ VDD _05370_ sky130_fd_sc_hd__nand2_1
X_16730_ _05355_ _05369_ _05370_ VSS VSS VDD VDD _02431_ sky130_fd_sc_hd__o21ai_0
X_16731_ _01233_ _05310_ _01232_ VSS VSS VDD VDD _05371_ sky130_fd_sc_hd__nand3_1
X_16732_ net371 _04434_ _05371_ VSS VSS VDD VDD _05372_ sky130_fd_sc_hd__nor3_1
X_16733_ network.in_period\[92\]\[3\] _04434_ _05372_ VSS
+ VSS VDD VDD _05373_ sky130_fd_sc_hd__a21oi_1
X_16734_ network.in_period\[92\]\[3\] net371 VSS VSS VDD VDD
+ _05374_ sky130_fd_sc_hd__and2_1
X_16735_ network.neuron_in092.counter\[3\] net389 _05371_
+ _05374_ VSS VSS VDD VDD _05375_ sky130_fd_sc_hd__a31oi_1
X_16736_ network.neuron_in092.counter\[3\] _05373_ _05375_
+ VSS VSS VDD VDD _02435_ sky130_fd_sc_hd__o21ai_0
Xoutput48 net47 VSS VSS VDD VDD result_class[1] sky130_fd_sc_hd__buf_1
X_16738_ net387 _04429_ VSS VSS VDD VDD _05377_ sky130_fd_sc_hd__nand2_1
X_16739_ network.in_period\[94\]\[0\] _05377_ VSS VSS VDD
+ VDD _05378_ sky130_fd_sc_hd__nand2_1
X_16740_ network.neuron_in094.counter\[0\] _05377_ _05378_
+ VSS VSS VDD VDD _02440_ sky130_fd_sc_hd__o21ai_0
X_16741_ network.in_spk00_11 network.in_spk01_11 network.in_spk02_11
+ _08941_ network.in_spk03_11 VSS VSS VDD VDD _05379_ sky130_fd_sc_hd__o41ai_1
X_16742_ _06516_ _05379_ _06361_ VSS VSS VDD VDD _01982_ sky130_fd_sc_hd__a21oi_1
X_16743_ net389 _04432_ VSS VSS VDD VDD _05380_ sky130_fd_sc_hd__nand2_1
X_16744_ network.neuron_in093.counter\[0\] network.neuron_in093.counter\[2\]
+ network.neuron_in093.counter\[1\] VSS VSS VDD VDD _05381_
+ sky130_fd_sc_hd__nor3_1
X_16745_ network.neuron_in093.counter\[3\] _05381_ VSS VSS
+ VDD VDD _05382_ sky130_fd_sc_hd__xnor2_1
X_16746_ network.in_period\[93\]\[3\] _05380_ VSS VSS VDD
+ VDD _05383_ sky130_fd_sc_hd__nand2_1
X_16747_ _05380_ _05382_ _05383_ VSS VSS VDD VDD _02439_ sky130_fd_sc_hd__o21ai_0
X_16748_ net389 _04425_ VSS VSS VDD VDD _05384_ sky130_fd_sc_hd__nand2_1
X_16749_ network.in_period\[95\]\[0\] _05384_ VSS VSS VDD
+ VDD _05385_ sky130_fd_sc_hd__nand2_1
X_16750_ network.neuron_in095.counter\[0\] _05384_ _05385_
+ VSS VSS VDD VDD _02444_ sky130_fd_sc_hd__o21ai_0
X_16751_ network.neuron_in094.counter\[2\] network.neuron_in094.counter\[0\]
+ network.neuron_in094.counter\[1\] VSS VSS VDD VDD _05386_
+ sky130_fd_sc_hd__nor3_1
X_16752_ network.neuron_in094.counter\[3\] _05386_ VSS VSS
+ VDD VDD _05387_ sky130_fd_sc_hd__xnor2_1
X_16753_ network.in_period\[94\]\[3\] _05377_ VSS VSS VDD
+ VDD _05388_ sky130_fd_sc_hd__nand2_1
X_16754_ _05377_ _05387_ _05388_ VSS VSS VDD VDD _02443_ sky130_fd_sc_hd__o21ai_0
X_16755_ network.in_spk01_11 _09202_ network.in_spk02_11 VSS
+ VSS VDD VDD _05389_ sky130_fd_sc_hd__o21ai_0
X_16756_ _06489_ _05389_ _06361_ VSS VSS VDD VDD _01983_ sky130_fd_sc_hd__a21oi_1
X_16757_ network.neuron_in095.counter\[2\] network.neuron_in095.counter\[0\]
+ network.neuron_in095.counter\[1\] VSS VSS VDD VDD _05390_
+ sky130_fd_sc_hd__nor3_1
X_16758_ network.neuron_in095.counter\[3\] _05390_ VSS VSS
+ VDD VDD _05391_ sky130_fd_sc_hd__xnor2_1
X_16759_ network.in_period\[95\]\[3\] _05384_ VSS VSS VDD
+ VDD _05392_ sky130_fd_sc_hd__nand2_1
X_16760_ _05384_ _05391_ _05392_ VSS VSS VDD VDD _02447_ sky130_fd_sc_hd__o21ai_0
X_16761_ network.in_period\[88\]\[1\] _05340_ VSS VSS VDD
+ VDD _05393_ sky130_fd_sc_hd__nand2_1
X_16762_ _00037_ _05340_ _05393_ VSS VSS VDD VDD _02417_ sky130_fd_sc_hd__o21ai_0
X_16763_ network.neuron_in096.counter\[1\] network.neuron_in096.counter\[0\]
+ _01211_ VSS VSS VDD VDD _05394_ sky130_fd_sc_hd__o21bai_1
X_16764_ _04421_ _05394_ network.neuron_in096.counter\[3\]
+ VSS VSS VDD VDD _05395_ sky130_fd_sc_hd__a21oi_1
X_16765_ _04421_ network.neuron_in096.counter\[3\] _01210_
+ _01209_ _05395_ VSS VSS VDD VDD _05396_ sky130_fd_sc_hd__a41o_1
Xoutput47 net46 VSS VSS VDD VDD result_class[0] sky130_fd_sc_hd__buf_1
X_16767_ net385 _04420_ network.in_period\[96\]\[3\] VSS VSS
+ VDD VDD _05398_ sky130_fd_sc_hd__a21oi_1
X_16768_ net385 _05396_ _05398_ VSS VSS VDD VDD _02451_ sky130_fd_sc_hd__a21oi_1
X_16769_ network.neuron_in089.counter\[2\] _01223_ VSS VSS
+ VDD VDD _05399_ sky130_fd_sc_hd__xnor2_1
X_16770_ net387 _04446_ network.in_period\[89\]\[2\] VSS VSS
+ VDD VDD _05400_ sky130_fd_sc_hd__a21oi_1
X_16771_ net387 _05399_ _05400_ VSS VSS VDD VDD _02422_ sky130_fd_sc_hd__a21oi_1
X_16772_ network.in_spk01_11 _09202_ VSS VSS VDD VDD _05401_
+ sky130_fd_sc_hd__nand2_1
Xoutput46 net45 VSS VSS VDD VDD no_spike sky130_fd_sc_hd__buf_1
X_16774_ _06894_ _05401_ _06361_ VSS VSS VDD VDD _01984_ sky130_fd_sc_hd__a21oi_1
X_16775_ network.neuron_in097.counter\[0\] network.neuron_in097.counter\[1\]
+ _01215_ VSS VSS VDD VDD _05403_ sky130_fd_sc_hd__o21bai_1
X_16776_ _04416_ _05403_ network.neuron_in097.counter\[3\]
+ VSS VSS VDD VDD _05404_ sky130_fd_sc_hd__a21oi_1
X_16777_ _04416_ network.neuron_in097.counter\[3\] _01213_
+ _01214_ _05404_ VSS VSS VDD VDD _05405_ sky130_fd_sc_hd__a41o_1
X_16778_ net385 _04415_ network.in_period\[97\]\[3\] VSS VSS
+ VDD VDD _05406_ sky130_fd_sc_hd__a21oi_1
X_16779_ net385 _05405_ _05406_ VSS VSS VDD VDD _02455_ sky130_fd_sc_hd__a21oi_1
X_16780_ network.in_period\[89\]\[1\] _05347_ VSS VSS VDD
+ VDD _05407_ sky130_fd_sc_hd__nand2_1
X_16781_ _01224_ _05347_ _05407_ VSS VSS VDD VDD _02421_ sky130_fd_sc_hd__o21ai_0
X_16782_ net390 _04695_ VSS VSS VDD VDD _05408_ sky130_fd_sc_hd__nand2_1
X_16783_ network.neuron_in098.counter\[2\] network.neuron_in098.counter\[1\]
+ network.neuron_in098.counter\[0\] VSS VSS VDD VDD _05409_
+ sky130_fd_sc_hd__nor3_1
X_16784_ network.neuron_in098.counter\[3\] _05409_ VSS VSS
+ VDD VDD _05410_ sky130_fd_sc_hd__xnor2_1
X_16785_ network.in_period\[98\]\[3\] _05408_ VSS VSS VDD
+ VDD _05411_ sky130_fd_sc_hd__nand2_1
X_16786_ _05408_ _05410_ _05411_ VSS VSS VDD VDD _02459_ sky130_fd_sc_hd__o21ai_0
X_16787_ network.in_period\[90\]\[1\] _05361_ VSS VSS VDD
+ VDD _05412_ sky130_fd_sc_hd__nand2_1
X_16788_ _00574_ _05361_ _05412_ VSS VSS VDD VDD _02425_ sky130_fd_sc_hd__o21ai_0
X_16789_ network.in_spk00_11 _08941_ VSS VSS VDD VDD _05413_
+ sky130_fd_sc_hd__nand2_1
X_16790_ _07450_ _05413_ _06361_ VSS VSS VDD VDD _01985_ sky130_fd_sc_hd__a21oi_1
Xoutput45 net44 VSS VSS VDD VDD load_ready sky130_fd_sc_hd__buf_1
X_16792_ network.neuron_in099.counter\[1\] network.neuron_in099.counter\[0\]
+ VSS VSS VDD VDD _05415_ sky130_fd_sc_hd__nor2_1
X_16793_ _00724_ _05415_ VSS VSS VDD VDD _05416_ sky130_fd_sc_hd__nor2_1
X_16794_ network.neuron_in099.counter\[2\] _05416_ VSS VSS
+ VDD VDD _05417_ sky130_fd_sc_hd__nor2_1
X_16795_ network.neuron_in099.counter\[2\] network.neuron_in099.counter\[3\]
+ _05415_ VSS VSS VDD VDD _05418_ sky130_fd_sc_hd__nand3b_1
X_16796_ network.neuron_in099.counter\[3\] _05417_ _05418_
+ VSS VSS VDD VDD _05419_ sky130_fd_sc_hd__o21ai_0
X_16797_ net390 _04692_ network.in_period\[99\]\[3\] VSS VSS
+ VDD VDD _05420_ sky130_fd_sc_hd__a21oi_1
X_16798_ net390 _05419_ _05420_ VSS VSS VDD VDD _02463_ sky130_fd_sc_hd__a21oi_1
X_16799_ network.in_period\[90\]\[0\] _05361_ VSS VSS VDD
+ VDD _05421_ sky130_fd_sc_hd__nand2_1
X_16800_ network.neuron_in090.counter\[0\] _05361_ _05421_
+ VSS VSS VDD VDD _02424_ sky130_fd_sc_hd__o21ai_0
X_16801_ network.neuron_in100.counter\[2\] VSS VSS VDD VDD
+ _05422_ sky130_fd_sc_hd__inv_1
X_16802_ _00703_ _05422_ _00702_ VSS VSS VDD VDD _05423_ sky130_fd_sc_hd__nand3_1
X_16803_ net377 _04690_ _05423_ VSS VSS VDD VDD _05424_ sky130_fd_sc_hd__nor3_1
X_16804_ network.in_period\[100\]\[3\] _04690_ _05424_ VSS
+ VSS VDD VDD _05425_ sky130_fd_sc_hd__a21oi_1
X_16805_ network.in_period\[100\]\[3\] net377 VSS VSS VDD
+ VDD _05426_ sky130_fd_sc_hd__and2_1
X_16806_ network.neuron_in100.counter\[3\] net385 _05423_
+ _05426_ VSS VSS VDD VDD _05427_ sky130_fd_sc_hd__a31oi_1
X_16807_ network.neuron_in100.counter\[3\] _05425_ _05427_
+ VSS VSS VDD VDD _02467_ sky130_fd_sc_hd__o21ai_0
X_16808_ network.in_period\[91\]\[1\] _05355_ VSS VSS VDD
+ VDD _05428_ sky130_fd_sc_hd__nand2_1
X_16809_ _00132_ _05355_ _05428_ VSS VSS VDD VDD _02429_ sky130_fd_sc_hd__o21ai_0
X_16810_ _09020_ _08908_ _08955_ VSS VSS VDD VDD _05429_ sky130_fd_sc_hd__nand3_1
X_16811_ network.in_spk12_10 network.in_spk13_10 network.in_spk14_10
+ _05429_ network.in_spk15_10 VSS VSS VDD VDD _05430_ sky130_fd_sc_hd__o41ai_1
X_16812_ _07499_ _05430_ net376 VSS VSS VDD VDD _01986_ sky130_fd_sc_hd__a21oi_1
X_16813_ net385 _04689_ VSS VSS VDD VDD _05431_ sky130_fd_sc_hd__nand2_1
X_16814_ network.neuron_in101.counter\[2\] network.neuron_in101.counter\[0\]
+ network.neuron_in101.counter\[1\] VSS VSS VDD VDD _05432_
+ sky130_fd_sc_hd__nor3_1
X_16815_ network.neuron_in101.counter\[3\] _05432_ VSS VSS
+ VDD VDD _05433_ sky130_fd_sc_hd__xnor2_1
X_16816_ network.in_period\[101\]\[3\] _05431_ VSS VSS VDD
+ VDD _05434_ sky130_fd_sc_hd__nand2_1
X_16817_ _05431_ _05433_ _05434_ VSS VSS VDD VDD _02471_ sky130_fd_sc_hd__o21ai_0
X_16818_ network.in_period\[91\]\[0\] _05355_ VSS VSS VDD
+ VDD _05435_ sky130_fd_sc_hd__nand2_1
X_16819_ network.neuron_in091.counter\[0\] _05355_ _05435_
+ VSS VSS VDD VDD _02428_ sky130_fd_sc_hd__o21ai_0
X_16820_ network.neuron_in102.counter\[1\] network.neuron_in102.counter\[0\]
+ _00996_ VSS VSS VDD VDD _05436_ sky130_fd_sc_hd__o21bai_1
X_16821_ _04686_ _05436_ network.neuron_in102.counter\[3\]
+ VSS VSS VDD VDD _05437_ sky130_fd_sc_hd__a21oi_1
X_16822_ _04686_ network.neuron_in102.counter\[3\] _00995_
+ _00994_ _05437_ VSS VSS VDD VDD _05438_ sky130_fd_sc_hd__a41o_1
X_16823_ net385 _04685_ network.in_period\[102\]\[3\] VSS
+ VSS VDD VDD _05439_ sky130_fd_sc_hd__a21oi_1
X_16824_ net385 _05438_ _05439_ VSS VSS VDD VDD _02475_ sky130_fd_sc_hd__a21oi_1
X_16825_ net389 _04435_ VSS VSS VDD VDD _05440_ sky130_fd_sc_hd__nand2_1
X_16826_ network.in_period\[92\]\[1\] _05440_ VSS VSS VDD
+ VDD _05441_ sky130_fd_sc_hd__nand2_1
X_16827_ _01235_ _05440_ _05441_ VSS VSS VDD VDD _02433_ sky130_fd_sc_hd__o21ai_0
X_16828_ network.in_spk12_10 network.in_spk13_10 _05429_ network.in_spk14_10
+ VSS VSS VDD VDD _05442_ sky130_fd_sc_hd__o31ai_1
X_16829_ _07495_ _05442_ net376 VSS VSS VDD VDD _01987_ sky130_fd_sc_hd__a21oi_1
X_16830_ network.neuron_in103.counter\[2\] VSS VSS VDD VDD
+ _05443_ sky130_fd_sc_hd__inv_1
X_16831_ _00902_ _05443_ _00903_ VSS VSS VDD VDD _05444_ sky130_fd_sc_hd__nand3_1
X_16832_ net372 _04683_ _05444_ VSS VSS VDD VDD _05445_ sky130_fd_sc_hd__nor3_1
X_16833_ network.in_period\[103\]\[3\] _04683_ _05445_ VSS
+ VSS VDD VDD _05446_ sky130_fd_sc_hd__a21oi_1
X_16834_ network.in_period\[103\]\[3\] net372 VSS VSS VDD
+ VDD _05447_ sky130_fd_sc_hd__and2_1
X_16835_ network.neuron_in103.counter\[3\] net385 _05444_
+ _05447_ VSS VSS VDD VDD _05448_ sky130_fd_sc_hd__a31oi_1
X_16836_ network.neuron_in103.counter\[3\] _05446_ _05448_
+ VSS VSS VDD VDD _02479_ sky130_fd_sc_hd__o21ai_0
X_16837_ network.in_period\[92\]\[0\] _05440_ VSS VSS VDD
+ VDD _05449_ sky130_fd_sc_hd__nand2_1
X_16838_ network.neuron_in092.counter\[0\] _05440_ _05449_
+ VSS VSS VDD VDD _02432_ sky130_fd_sc_hd__o21ai_0
X_16839_ network.neuron_in104.counter\[1\] network.neuron_in104.counter\[0\]
+ _00680_ VSS VSS VDD VDD _05450_ sky130_fd_sc_hd__o21bai_1
X_16840_ _04681_ _05450_ network.neuron_in104.counter\[3\]
+ VSS VSS VDD VDD _05451_ sky130_fd_sc_hd__a21oi_1
X_16841_ _04681_ network.neuron_in104.counter\[3\] _00679_
+ _00678_ _05451_ VSS VSS VDD VDD _05452_ sky130_fd_sc_hd__a41o_1
X_16842_ net392 _04680_ network.in_period\[104\]\[3\] VSS
+ VSS VDD VDD _05453_ sky130_fd_sc_hd__a21oi_1
X_16843_ net392 _05452_ _05453_ VSS VSS VDD VDD _02483_ sky130_fd_sc_hd__a21oi_1
X_16844_ network.in_period\[93\]\[1\] _05380_ VSS VSS VDD
+ VDD _05454_ sky130_fd_sc_hd__nand2_1
X_16845_ _01239_ _05380_ _05454_ VSS VSS VDD VDD _02437_ sky130_fd_sc_hd__o21ai_0
X_16846_ network.in_spk12_10 _05429_ network.in_spk13_10 VSS
+ VSS VDD VDD _05455_ sky130_fd_sc_hd__o21ai_0
X_16847_ _07468_ _05455_ net376 VSS VSS VDD VDD _01988_ sky130_fd_sc_hd__a21oi_1
X_16848_ net392 _04679_ VSS VSS VDD VDD _05456_ sky130_fd_sc_hd__nand2_1
X_16849_ network.neuron_in105.counter\[1\] network.neuron_in105.counter\[2\]
+ network.neuron_in105.counter\[0\] VSS VSS VDD VDD _05457_
+ sky130_fd_sc_hd__nor3_1
X_16850_ network.neuron_in105.counter\[3\] _05457_ VSS VSS
+ VDD VDD _05458_ sky130_fd_sc_hd__xnor2_1
X_16851_ network.in_period\[105\]\[3\] _05456_ VSS VSS VDD
+ VDD _05459_ sky130_fd_sc_hd__nand2_1
X_16852_ _05456_ _05458_ _05459_ VSS VSS VDD VDD _02487_ sky130_fd_sc_hd__o21ai_0
X_16853_ network.in_period\[93\]\[0\] _05380_ VSS VSS VDD
+ VDD _05460_ sky130_fd_sc_hd__nand2_1
X_16854_ network.neuron_in093.counter\[0\] _05380_ _05460_
+ VSS VSS VDD VDD _02436_ sky130_fd_sc_hd__o21ai_0
X_16855_ network.neuron_in106.counter\[1\] network.neuron_in106.counter\[0\]
+ _00672_ VSS VSS VDD VDD _05461_ sky130_fd_sc_hd__o21bai_1
X_16856_ _04676_ _05461_ network.neuron_in106.counter\[3\]
+ VSS VSS VDD VDD _05462_ sky130_fd_sc_hd__a21oi_1
X_16857_ _04676_ network.neuron_in106.counter\[3\] _00671_
+ _00670_ _05462_ VSS VSS VDD VDD _05463_ sky130_fd_sc_hd__a41o_1
X_16858_ net390 _04675_ network.in_period\[106\]\[3\] VSS
+ VSS VDD VDD _05464_ sky130_fd_sc_hd__a21oi_1
X_16859_ net390 _05463_ _05464_ VSS VSS VDD VDD _02491_ sky130_fd_sc_hd__a21oi_1
X_16860_ network.neuron_in094.counter\[2\] _01242_ VSS VSS
+ VDD VDD _05465_ sky130_fd_sc_hd__xnor2_1
X_16861_ net387 _04429_ network.in_period\[94\]\[2\] VSS VSS
+ VDD VDD _05466_ sky130_fd_sc_hd__a21oi_1
X_16862_ net387 _05465_ _05466_ VSS VSS VDD VDD _02442_ sky130_fd_sc_hd__a21oi_1
X_16863_ network.in_spk12_10 _05429_ VSS VSS VDD VDD _05467_
+ sky130_fd_sc_hd__nand2_1
X_16864_ _07489_ _05467_ net376 VSS VSS VDD VDD _01989_ sky130_fd_sc_hd__a21oi_1
X_16865_ network.neuron_in107.counter\[1\] network.neuron_in107.counter\[0\]
+ _01069_ VSS VSS VDD VDD _05468_ sky130_fd_sc_hd__o21bai_1
X_16866_ _04673_ _05468_ network.neuron_in107.counter\[3\]
+ VSS VSS VDD VDD _05469_ sky130_fd_sc_hd__a21oi_1
X_16867_ _04673_ _01068_ _01067_ network.neuron_in107.counter\[3\]
+ _05469_ VSS VSS VDD VDD _05470_ sky130_fd_sc_hd__a41o_1
X_16868_ net390 _04672_ network.in_period\[107\]\[3\] VSS
+ VSS VDD VDD _05471_ sky130_fd_sc_hd__a21oi_1
X_16869_ net390 _05470_ _05471_ VSS VSS VDD VDD _02495_ sky130_fd_sc_hd__a21oi_1
X_16870_ network.in_period\[94\]\[1\] _05377_ VSS VSS VDD
+ VDD _05472_ sky130_fd_sc_hd__nand2_1
X_16871_ _01243_ _05377_ _05472_ VSS VSS VDD VDD _02441_ sky130_fd_sc_hd__o21ai_0
X_16872_ network.neuron_in108.counter\[1\] network.neuron_in108.counter\[0\]
+ _00684_ VSS VSS VDD VDD _05473_ sky130_fd_sc_hd__o21bai_1
X_16873_ _04669_ _05473_ network.neuron_in108.counter\[3\]
+ VSS VSS VDD VDD _05474_ sky130_fd_sc_hd__a21oi_1
X_16874_ _04669_ network.neuron_in108.counter\[3\] _00683_
+ _00682_ _05474_ VSS VSS VDD VDD _05475_ sky130_fd_sc_hd__a41o_1
X_16875_ net389 _04668_ network.in_period\[108\]\[3\] VSS
+ VSS VDD VDD _05476_ sky130_fd_sc_hd__a21oi_1
X_16876_ net389 _05475_ _05476_ VSS VSS VDD VDD _02499_ sky130_fd_sc_hd__a21oi_1
X_16877_ network.in_period\[95\]\[2\] VSS VSS VDD VDD _05477_
+ sky130_fd_sc_hd__inv_1
X_16878_ network.neuron_in095.counter\[2\] _01247_ VSS VSS
+ VDD VDD _05478_ sky130_fd_sc_hd__xnor2_1
X_16879_ _05477_ _05384_ _05478_ net389 VSS VSS VDD VDD _02446_
+ sky130_fd_sc_hd__a22oi_1
X_16880_ _08938_ net295 VSS VSS VDD VDD _05479_ sky130_fd_sc_hd__nand2_1
X_16881_ network.in_spk10_10 _05479_ _09129_ network.in_spk11_10
+ VSS VSS VDD VDD _05480_ sky130_fd_sc_hd__o31ai_1
X_16882_ _07455_ _05480_ net376 VSS VSS VDD VDD _01990_ sky130_fd_sc_hd__a21oi_1
X_16883_ net390 _04667_ VSS VSS VDD VDD _05481_ sky130_fd_sc_hd__nand2_1
X_16884_ network.neuron_in109.counter\[1\] network.neuron_in109.counter\[2\]
+ network.neuron_in109.counter\[0\] VSS VSS VDD VDD _05482_
+ sky130_fd_sc_hd__nor3_1
X_16885_ network.neuron_in109.counter\[3\] _05482_ VSS VSS
+ VDD VDD _05483_ sky130_fd_sc_hd__xnor2_1
X_16886_ network.in_period\[109\]\[3\] _05481_ VSS VSS VDD
+ VDD _05484_ sky130_fd_sc_hd__nand2_1
X_16887_ _05481_ _05483_ _05484_ VSS VSS VDD VDD _02503_ sky130_fd_sc_hd__o21ai_0
X_16888_ network.in_period\[95\]\[1\] _05384_ VSS VSS VDD
+ VDD _05485_ sky130_fd_sc_hd__nand2_1
X_16889_ _01248_ _05384_ _05485_ VSS VSS VDD VDD _02445_ sky130_fd_sc_hd__o21ai_0
X_16890_ network.neuron_in110.counter\[0\] network.neuron_in110.counter\[1\]
+ _00080_ VSS VSS VDD VDD _05486_ sky130_fd_sc_hd__o21bai_1
X_16891_ _04664_ _05486_ network.neuron_in110.counter\[3\]
+ VSS VSS VDD VDD _05487_ sky130_fd_sc_hd__a21oi_1
X_16892_ _04664_ _00078_ network.neuron_in110.counter\[3\]
+ _00079_ _05487_ VSS VSS VDD VDD _05488_ sky130_fd_sc_hd__a41o_1
Xoutput44 net43 VSS VSS VDD VDD input_complete sky130_fd_sc_hd__buf_1
X_16894_ net390 _04663_ network.in_period\[110\]\[3\] VSS
+ VSS VDD VDD _05490_ sky130_fd_sc_hd__a21oi_1
X_16895_ net390 _05488_ _05490_ VSS VSS VDD VDD _02507_ sky130_fd_sc_hd__a21oi_1
X_16896_ network.in_spk08_10 network.in_spk09_10 _09023_ network.in_spk10_10
+ VSS VSS VDD VDD _05491_ sky130_fd_sc_hd__o31ai_1
X_16897_ _07484_ _05491_ net376 VSS VSS VDD VDD _01991_ sky130_fd_sc_hd__a21oi_1
X_16898_ network.neuron_in111.counter\[2\] VSS VSS VDD VDD
+ _05492_ sky130_fd_sc_hd__inv_1
X_16899_ _00567_ _00568_ _05492_ VSS VSS VDD VDD _05493_ sky130_fd_sc_hd__nand3_1
X_16900_ net373 _04661_ _05493_ VSS VSS VDD VDD _05494_ sky130_fd_sc_hd__nor3_1
X_16901_ network.in_period\[111\]\[3\] _04661_ _05494_ VSS
+ VSS VDD VDD _05495_ sky130_fd_sc_hd__a21oi_1
X_16902_ network.in_period\[111\]\[3\] net373 VSS VSS VDD
+ VDD _05496_ sky130_fd_sc_hd__and2_1
X_16903_ network.neuron_in111.counter\[3\] net390 _05493_
+ _05496_ VSS VSS VDD VDD _05497_ sky130_fd_sc_hd__a31oi_1
X_16904_ network.neuron_in111.counter\[3\] _05495_ _05497_
+ VSS VSS VDD VDD _02511_ sky130_fd_sc_hd__o21ai_0
X_16905_ network.neuron_in112.counter\[0\] VSS VSS VDD VDD
+ _00543_ sky130_fd_sc_hd__inv_1
X_16906_ network.neuron_in112.counter\[0\] network.neuron_in112.counter\[1\]
+ _00545_ VSS VSS VDD VDD _05498_ sky130_fd_sc_hd__o21bai_1
X_16907_ _04659_ _05498_ network.neuron_in112.counter\[3\]
+ VSS VSS VDD VDD _05499_ sky130_fd_sc_hd__a21oi_1
X_16908_ _04659_ network.neuron_in112.counter\[3\] _00543_
+ _00544_ _05499_ VSS VSS VDD VDD _05500_ sky130_fd_sc_hd__a41o_1
X_16909_ net383 _04658_ network.in_period\[112\]\[3\] VSS
+ VSS VDD VDD _05501_ sky130_fd_sc_hd__a21oi_1
X_16910_ net383 _05500_ _05501_ VSS VSS VDD VDD _02515_ sky130_fd_sc_hd__a21oi_1
X_16911_ network.in_spk08_10 _09023_ network.in_spk09_10 VSS
+ VSS VDD VDD _05502_ sky130_fd_sc_hd__o21ai_0
X_16912_ _07480_ _05502_ net376 VSS VSS VDD VDD _01992_ sky130_fd_sc_hd__a21oi_1
X_16913_ net384 _04657_ VSS VSS VDD VDD _05503_ sky130_fd_sc_hd__nand2_1
X_16914_ network.neuron_in113.counter\[0\] network.neuron_in113.counter\[1\]
+ network.neuron_in113.counter\[2\] VSS VSS VDD VDD _05504_
+ sky130_fd_sc_hd__nor3_1
X_16915_ network.neuron_in113.counter\[3\] _05504_ VSS VSS
+ VDD VDD _05505_ sky130_fd_sc_hd__xnor2_1
X_16916_ network.in_period\[113\]\[3\] _05503_ VSS VSS VDD
+ VDD _05506_ sky130_fd_sc_hd__nand2_1
X_16917_ _05503_ _05505_ _05506_ VSS VSS VDD VDD _02519_ sky130_fd_sc_hd__o21ai_0
X_16918_ net383 _04656_ VSS VSS VDD VDD _05507_ sky130_fd_sc_hd__nand2_1
X_16919_ network.neuron_in114.counter\[2\] network.neuron_in114.counter\[1\]
+ network.neuron_in114.counter\[0\] VSS VSS VDD VDD _05508_
+ sky130_fd_sc_hd__nor3_1
X_16920_ network.neuron_in114.counter\[3\] _05508_ VSS VSS
+ VDD VDD _05509_ sky130_fd_sc_hd__xnor2_1
X_16921_ network.in_period\[114\]\[3\] _05507_ VSS VSS VDD
+ VDD _05510_ sky130_fd_sc_hd__nand2_1
X_16922_ _05507_ _05509_ _05510_ VSS VSS VDD VDD _02523_ sky130_fd_sc_hd__o21ai_0
X_16923_ network.in_spk08_10 _09023_ VSS VSS VDD VDD _05511_
+ sky130_fd_sc_hd__nand2_1
X_16924_ _07461_ _05511_ net376 VSS VSS VDD VDD _01993_ sky130_fd_sc_hd__a21oi_1
X_16925_ network.neuron_in115.counter\[1\] network.neuron_in115.counter\[2\]
+ network.neuron_in115.counter\[0\] VSS VSS VDD VDD _05512_
+ sky130_fd_sc_hd__or3_1
X_16926_ net374 _04653_ _05512_ VSS VSS VDD VDD _05513_ sky130_fd_sc_hd__nor3_1
X_16927_ network.in_period\[115\]\[3\] _04653_ _05513_ VSS
+ VSS VDD VDD _05514_ sky130_fd_sc_hd__a21oi_1
Xoutput43 net42 VSS VSS VDD VDD inference_cycles[9] sky130_fd_sc_hd__buf_1
Xoutput42 net41 VSS VSS VDD VDD inference_cycles[8] sky130_fd_sc_hd__buf_1
X_16930_ network.in_period\[115\]\[3\] net374 VSS VSS VDD
+ VDD _05517_ sky130_fd_sc_hd__and2_1
X_16931_ network.neuron_in115.counter\[3\] net383 _05512_
+ _05517_ VSS VSS VDD VDD _05518_ sky130_fd_sc_hd__a31oi_1
X_16932_ network.neuron_in115.counter\[3\] _05514_ _05518_
+ VSS VSS VDD VDD _02527_ sky130_fd_sc_hd__o21ai_0
Xoutput41 net40 VSS VSS VDD VDD inference_cycles[7] sky130_fd_sc_hd__buf_1
X_16934_ network.neuron_in116.counter\[2\] VSS VSS VDD VDD
+ _05520_ sky130_fd_sc_hd__inv_1
X_16935_ _00038_ _00039_ _05520_ VSS VSS VDD VDD _05521_ sky130_fd_sc_hd__nand3_1
X_16936_ net374 _04651_ _05521_ VSS VSS VDD VDD _05522_ sky130_fd_sc_hd__nor3_1
X_16937_ network.in_period\[116\]\[3\] _04651_ _05522_ VSS
+ VSS VDD VDD _05523_ sky130_fd_sc_hd__a21oi_1
X_16938_ network.in_period\[116\]\[3\] net374 VSS VSS VDD
+ VDD _05524_ sky130_fd_sc_hd__and2_1
X_16939_ network.neuron_in116.counter\[3\] net384 _05521_
+ _05524_ VSS VSS VDD VDD _05525_ sky130_fd_sc_hd__a31oi_1
X_16940_ network.neuron_in116.counter\[3\] _05523_ _05525_
+ VSS VSS VDD VDD _02531_ sky130_fd_sc_hd__o21ai_0
X_16941_ _08907_ _08955_ VSS VSS VDD VDD _05526_ sky130_fd_sc_hd__nand2_1
X_16942_ network.in_spk04_10 network.in_spk05_10 network.in_spk06_10
+ _05526_ network.in_spk07_10 VSS VSS VDD VDD _05527_ sky130_fd_sc_hd__o41ai_1
Xoutput40 net39 VSS VSS VDD VDD inference_cycles[6] sky130_fd_sc_hd__buf_1
X_16944_ _07475_ _05527_ net370 VSS VSS VDD VDD _01994_ sky130_fd_sc_hd__a21oi_1
X_16945_ net384 _04650_ VSS VSS VDD VDD _05529_ sky130_fd_sc_hd__nand2_1
X_16946_ network.neuron_in117.counter\[1\] network.neuron_in117.counter\[0\]
+ network.neuron_in117.counter\[2\] VSS VSS VDD VDD _05530_
+ sky130_fd_sc_hd__nor3_1
X_16947_ network.neuron_in117.counter\[3\] _05530_ VSS VSS
+ VDD VDD _05531_ sky130_fd_sc_hd__xnor2_1
X_16948_ network.in_period\[117\]\[3\] _05529_ VSS VSS VDD
+ VDD _05532_ sky130_fd_sc_hd__nand2_1
X_16949_ _05529_ _05531_ _05532_ VSS VSS VDD VDD _02535_ sky130_fd_sc_hd__o21ai_0
X_16950_ net384 _04647_ VSS VSS VDD VDD _05533_ sky130_fd_sc_hd__nand2_1
X_16951_ network.neuron_in118.counter\[0\] network.neuron_in118.counter\[1\]
+ network.neuron_in118.counter\[2\] VSS VSS VDD VDD _05534_
+ sky130_fd_sc_hd__nor3_1
X_16952_ network.neuron_in118.counter\[3\] _05534_ VSS VSS
+ VDD VDD _05535_ sky130_fd_sc_hd__xnor2_1
X_16953_ network.in_period\[118\]\[3\] _05533_ VSS VSS VDD
+ VDD _05536_ sky130_fd_sc_hd__nand2_1
X_16954_ _05533_ _05535_ _05536_ VSS VSS VDD VDD _02539_ sky130_fd_sc_hd__o21ai_0
X_16955_ network.in_spk04_10 network.in_spk05_10 _05526_ network.in_spk06_10
+ VSS VSS VDD VDD _05537_ sky130_fd_sc_hd__o31ai_1
X_16956_ _07503_ _05537_ net370 VSS VSS VDD VDD _01995_ sky130_fd_sc_hd__a21oi_1
X_16957_ net384 _04645_ VSS VSS VDD VDD _05538_ sky130_fd_sc_hd__nand2_1
X_16958_ network.neuron_in119.counter\[1\] network.neuron_in119.counter\[2\]
+ network.neuron_in119.counter\[0\] VSS VSS VDD VDD _05539_
+ sky130_fd_sc_hd__nor3_1
X_16959_ network.neuron_in119.counter\[3\] _05539_ VSS VSS
+ VDD VDD _05540_ sky130_fd_sc_hd__xnor2_1
X_16960_ network.in_period\[119\]\[3\] _05538_ VSS VSS VDD
+ VDD _05541_ sky130_fd_sc_hd__nand2_1
X_16961_ _05538_ _05540_ _05541_ VSS VSS VDD VDD _02543_ sky130_fd_sc_hd__o21ai_0
X_16962_ network.neuron_in120.counter\[0\] network.neuron_in120.counter\[1\]
+ network.neuron_in120.counter\[2\] VSS VSS VDD VDD _05542_
+ sky130_fd_sc_hd__or3_1
X_16963_ net374 _04642_ _05542_ VSS VSS VDD VDD _05543_ sky130_fd_sc_hd__nor3_1
X_16964_ network.in_period\[120\]\[3\] _04642_ _05543_ VSS
+ VSS VDD VDD _05544_ sky130_fd_sc_hd__a21oi_1
X_16965_ network.in_period\[120\]\[3\] net374 VSS VSS VDD
+ VDD _05545_ sky130_fd_sc_hd__and2_1
X_16966_ network.neuron_in120.counter\[3\] net383 _05542_
+ _05545_ VSS VSS VDD VDD _05546_ sky130_fd_sc_hd__a31oi_1
X_16967_ network.neuron_in120.counter\[3\] _05544_ _05546_
+ VSS VSS VDD VDD _02547_ sky130_fd_sc_hd__o21ai_0
X_16968_ network.in_spk04_10 _05526_ network.in_spk05_10 VSS
+ VSS VDD VDD _05547_ sky130_fd_sc_hd__o21ai_0
X_16969_ _03935_ _05547_ net370 VSS VSS VDD VDD _01996_ sky130_fd_sc_hd__a21oi_1
X_16970_ net383 _04641_ VSS VSS VDD VDD _05548_ sky130_fd_sc_hd__nand2_1
X_16971_ network.neuron_in121.counter\[0\] network.neuron_in121.counter\[2\]
+ network.neuron_in121.counter\[1\] VSS VSS VDD VDD _05549_
+ sky130_fd_sc_hd__nor3_1
X_16972_ network.neuron_in121.counter\[3\] _05549_ VSS VSS
+ VDD VDD _05550_ sky130_fd_sc_hd__xnor2_1
X_16973_ network.in_period\[121\]\[3\] _05548_ VSS VSS VDD
+ VDD _05551_ sky130_fd_sc_hd__nand2_1
X_16974_ _05548_ _05550_ _05551_ VSS VSS VDD VDD _02551_ sky130_fd_sc_hd__o21ai_0
X_16975_ net383 _04639_ VSS VSS VDD VDD _05552_ sky130_fd_sc_hd__nand2_1
X_16976_ network.neuron_in122.counter\[0\] network.neuron_in122.counter\[1\]
+ network.neuron_in122.counter\[2\] VSS VSS VDD VDD _05553_
+ sky130_fd_sc_hd__nor3_1
X_16977_ network.neuron_in122.counter\[3\] _05553_ VSS VSS
+ VDD VDD _05554_ sky130_fd_sc_hd__xnor2_1
X_16978_ network.in_period\[122\]\[3\] _05552_ VSS VSS VDD
+ VDD _05555_ sky130_fd_sc_hd__nand2_1
X_16979_ _05552_ _05554_ _05555_ VSS VSS VDD VDD _02555_ sky130_fd_sc_hd__o21ai_0
X_16980_ network.in_spk04_10 _05526_ VSS VSS VDD VDD _05556_
+ sky130_fd_sc_hd__nand2_1
X_16981_ _03929_ _05556_ net370 VSS VSS VDD VDD _01997_ sky130_fd_sc_hd__a21oi_1
X_16982_ net383 _04637_ VSS VSS VDD VDD _05557_ sky130_fd_sc_hd__nand2_1
X_16983_ network.neuron_in123.counter\[1\] network.neuron_in123.counter\[2\]
+ network.neuron_in123.counter\[0\] VSS VSS VDD VDD _05558_
+ sky130_fd_sc_hd__nor3_1
X_16984_ network.neuron_in123.counter\[3\] _05558_ VSS VSS
+ VDD VDD _05559_ sky130_fd_sc_hd__xnor2_1
X_16985_ network.in_period\[123\]\[3\] _05557_ VSS VSS VDD
+ VDD _05560_ sky130_fd_sc_hd__nand2_1
X_16986_ _05557_ _05559_ _05560_ VSS VSS VDD VDD _02559_ sky130_fd_sc_hd__o21ai_0
X_16987_ network.neuron_in124.counter\[1\] network.neuron_in124.counter\[0\]
+ network.neuron_in124.counter\[2\] VSS VSS VDD VDD _05561_
+ sky130_fd_sc_hd__nor3_1
X_16988_ network.neuron_in124.counter\[3\] _05561_ VSS VSS
+ VDD VDD _05562_ sky130_fd_sc_hd__xnor2_1
X_16989_ network.in_period\[124\]\[3\] _03716_ VSS VSS VDD
+ VDD _05563_ sky130_fd_sc_hd__nand2_1
X_16990_ _03716_ _05562_ _05563_ VSS VSS VDD VDD _02563_ sky130_fd_sc_hd__o21ai_0
X_16991_ _09136_ _08955_ VSS VSS VDD VDD _05564_ sky130_fd_sc_hd__nand2_1
X_16992_ network.in_spk02_10 _05564_ network.in_spk03_10 VSS
+ VSS VDD VDD _05565_ sky130_fd_sc_hd__o21ai_0
X_16993_ _03801_ _05565_ net370 VSS VSS VDD VDD _01998_ sky130_fd_sc_hd__a21oi_1
X_16994_ network.neuron_in125.counter\[0\] network.neuron_in125.counter\[1\]
+ network.neuron_in125.counter\[2\] VSS VSS VDD VDD _05566_
+ sky130_fd_sc_hd__nor3_1
X_16995_ network.neuron_in125.counter\[3\] _05566_ VSS VSS
+ VDD VDD _05567_ sky130_fd_sc_hd__xnor2_1
X_16996_ network.in_period\[125\]\[3\] _07266_ VSS VSS VDD
+ VDD _05568_ sky130_fd_sc_hd__nand2_1
X_16997_ _07266_ _05567_ _05568_ VSS VSS VDD VDD _02567_ sky130_fd_sc_hd__o21ai_0
X_16998_ network.neuron_in126.counter\[0\] network.neuron_in126.counter\[2\]
+ network.neuron_in126.counter\[1\] VSS VSS VDD VDD _05569_
+ sky130_fd_sc_hd__nor3_1
X_16999_ network.neuron_in126.counter\[3\] _05569_ VSS VSS
+ VDD VDD _05570_ sky130_fd_sc_hd__xnor2_1
X_17000_ network.in_period\[126\]\[3\] _06753_ VSS VSS VDD
+ VDD _05571_ sky130_fd_sc_hd__nand2_1
X_17001_ _06753_ _05570_ _05571_ VSS VSS VDD VDD _02571_ sky130_fd_sc_hd__o21ai_0
X_17002_ network.in_spk02_10 _05564_ VSS VSS VDD VDD _05572_
+ sky130_fd_sc_hd__nand2_1
X_17003_ _03770_ _05572_ net370 VSS VSS VDD VDD _01999_ sky130_fd_sc_hd__a21oi_1
X_17004_ network.neuron_in127.counter\[0\] network.neuron_in127.counter\[1\]
+ VSS VSS VDD VDD _05573_ sky130_fd_sc_hd__nor2_1
X_17005_ _01153_ _05573_ VSS VSS VDD VDD _05574_ sky130_fd_sc_hd__nor2_1
X_17006_ network.neuron_in127.counter\[2\] _05574_ VSS VSS
+ VDD VDD _05575_ sky130_fd_sc_hd__nor2_1
X_17007_ network.neuron_in127.counter\[2\] network.neuron_in127.counter\[3\]
+ _05573_ VSS VSS VDD VDD _05576_ sky130_fd_sc_hd__nand3b_1
X_17008_ network.neuron_in127.counter\[3\] _05575_ _05576_
+ VSS VSS VDD VDD _05577_ sky130_fd_sc_hd__o21ai_0
X_17009_ net384 _08079_ network.in_period\[127\]\[3\] VSS
+ VSS VDD VDD _05578_ sky130_fd_sc_hd__a21oi_1
X_17010_ net384 _05577_ _05578_ VSS VSS VDD VDD _02575_ sky130_fd_sc_hd__a21oi_1
Xoutput39 net38 VSS VSS VDD VDD inference_cycles[5] sky130_fd_sc_hd__buf_1
X_17012_ network.neuron_in128.counter\[0\] network.neuron_in128.counter\[1\]
+ _00637_ VSS VSS VDD VDD _05580_ sky130_fd_sc_hd__o21bai_1
X_17013_ _08200_ _05580_ network.neuron_in128.counter\[3\]
+ VSS VSS VDD VDD _05581_ sky130_fd_sc_hd__a21oi_1
X_17014_ _08200_ network.neuron_in128.counter\[3\] _00635_
+ _00636_ _05581_ VSS VSS VDD VDD _05582_ sky130_fd_sc_hd__a41o_1
X_17015_ net394 _08265_ network.in_period\[128\]\[3\] VSS
+ VSS VDD VDD _05583_ sky130_fd_sc_hd__a21oi_1
X_17016_ net394 _05582_ _05583_ VSS VSS VDD VDD _02579_ sky130_fd_sc_hd__a21oi_1
X_17017_ network.in_spk01_10 _09141_ VSS VSS VDD VDD _05584_
+ sky130_fd_sc_hd__nand2_1
X_17018_ _06438_ _05584_ net370 VSS VSS VDD VDD _02000_ sky130_fd_sc_hd__a21oi_1
X_17019_ network.neuron_in129.counter\[1\] network.neuron_in129.counter\[0\]
+ network.neuron_in129.counter\[2\] VSS VSS VDD VDD _05585_
+ sky130_fd_sc_hd__or3_1
X_17020_ _06361_ _03603_ _05585_ VSS VSS VDD VDD _05586_ sky130_fd_sc_hd__nor3_1
X_17021_ network.in_period\[129\]\[3\] _03603_ _05586_ VSS
+ VSS VDD VDD _05587_ sky130_fd_sc_hd__a21oi_1
X_17022_ network.in_period\[129\]\[3\] net375 VSS VSS VDD
+ VDD _05588_ sky130_fd_sc_hd__and2_1
X_17023_ network.neuron_in129.counter\[3\] net394 _05585_
+ _05588_ VSS VSS VDD VDD _05589_ sky130_fd_sc_hd__a31oi_1
X_17024_ network.neuron_in129.counter\[3\] _05587_ _05589_
+ VSS VSS VDD VDD _02583_ sky130_fd_sc_hd__o21ai_0
X_17025_ network.neuron_in130.counter\[2\] network.neuron_in130.counter\[0\]
+ network.neuron_in130.counter\[1\] VSS VSS VDD VDD _05590_
+ sky130_fd_sc_hd__nor3_1
X_17026_ network.neuron_in130.counter\[3\] _05590_ VSS VSS
+ VDD VDD _05591_ sky130_fd_sc_hd__xnor2_1
X_17027_ network.in_period\[130\]\[3\] _04389_ VSS VSS VDD
+ VDD _05592_ sky130_fd_sc_hd__nand2_1
X_17028_ _04389_ _05591_ _05592_ VSS VSS VDD VDD _02587_ sky130_fd_sc_hd__o21ai_0
X_17029_ network.in_spk00_10 _05479_ VSS VSS VDD VDD _05593_
+ sky130_fd_sc_hd__nand2_1
X_17030_ _06433_ _05593_ net370 VSS VSS VDD VDD _02001_ sky130_fd_sc_hd__a21oi_1
X_17031_ network.neuron_in131.counter\[0\] network.neuron_in131.counter\[1\]
+ network.neuron_in131.counter\[2\] VSS VSS VDD VDD _05594_
+ sky130_fd_sc_hd__or3_1
X_17032_ _06361_ _06467_ _05594_ VSS VSS VDD VDD _05595_ sky130_fd_sc_hd__nor3_1
X_17033_ network.in_period\[131\]\[3\] _06467_ _05595_ VSS
+ VSS VDD VDD _05596_ sky130_fd_sc_hd__a21oi_1
X_17034_ network.in_period\[131\]\[3\] _06361_ VSS VSS VDD
+ VDD _05597_ sky130_fd_sc_hd__and2_1
X_17035_ network.neuron_in131.counter\[3\] net384 _05594_
+ _05597_ VSS VSS VDD VDD _05598_ sky130_fd_sc_hd__a31oi_1
X_17036_ network.neuron_in131.counter\[3\] _05596_ _05598_
+ VSS VSS VDD VDD _02591_ sky130_fd_sc_hd__o21ai_0
X_17037_ network.neuron_in132.counter\[2\] _00515_ VSS VSS
+ VDD VDD _05599_ sky130_fd_sc_hd__nor2b_1
X_17038_ network.neuron_in132.counter\[1\] network.neuron_in132.counter\[0\]
+ network.neuron_in132.counter\[2\] VSS VSS VDD VDD _05600_
+ sky130_fd_sc_hd__or3_1
X_17039_ net367 _05599_ _05600_ VSS VSS VDD VDD _05601_ sky130_fd_sc_hd__nor3_1
X_17040_ network.in_period\[132\]\[3\] _05599_ _05601_ VSS
+ VSS VDD VDD _05602_ sky130_fd_sc_hd__a21oi_1
X_17041_ network.in_period\[132\]\[3\] net367 VSS VSS VDD
+ VDD _05603_ sky130_fd_sc_hd__and2_1
X_17042_ network.neuron_in132.counter\[3\] net384 _05600_
+ _05603_ VSS VSS VDD VDD _05604_ sky130_fd_sc_hd__a31oi_1
X_17043_ network.neuron_in132.counter\[3\] _05602_ _05604_
+ VSS VSS VDD VDD _02595_ sky130_fd_sc_hd__o21ai_0
X_17044_ _08982_ _08974_ VSS VSS VDD VDD _05605_ sky130_fd_sc_hd__nand2_1
X_17045_ network.in_spk13_09 network.in_spk14_09 _09206_ _05605_
+ network.in_spk15_09 VSS VSS VDD VDD _05606_ sky130_fd_sc_hd__o41ai_1
X_17046_ _06383_ _05606_ net376 VSS VSS VDD VDD _02002_ sky130_fd_sc_hd__a21oi_1
X_17047_ network.neuron_in133.counter\[1\] network.neuron_in133.counter\[2\]
+ network.neuron_in133.counter\[0\] VSS VSS VDD VDD _05607_
+ sky130_fd_sc_hd__nor3_1
X_17048_ network.neuron_in133.counter\[3\] _05607_ VSS VSS
+ VDD VDD _05608_ sky130_fd_sc_hd__xnor2_1
X_17049_ network.in_period\[133\]\[3\] _08216_ VSS VSS VDD
+ VDD _05609_ sky130_fd_sc_hd__nand2_1
X_17050_ _08216_ _05608_ _05609_ VSS VSS VDD VDD _02599_ sky130_fd_sc_hd__o21ai_0
X_17051_ network.neuron_in134.counter\[1\] network.neuron_in134.counter\[2\]
+ network.neuron_in134.counter\[0\] VSS VSS VDD VDD _05610_
+ sky130_fd_sc_hd__or3_1
X_17052_ _06361_ _06821_ _05610_ VSS VSS VDD VDD _05611_ sky130_fd_sc_hd__nor3_1
X_17053_ network.in_period\[134\]\[3\] _06821_ _05611_ VSS
+ VSS VDD VDD _05612_ sky130_fd_sc_hd__a21oi_1
X_17054_ network.in_period\[134\]\[3\] _06361_ VSS VSS VDD
+ VDD _05613_ sky130_fd_sc_hd__and2_1
X_17055_ network.neuron_in134.counter\[3\] net384 _05610_
+ _05613_ VSS VSS VDD VDD _05614_ sky130_fd_sc_hd__a31oi_1
X_17056_ network.neuron_in134.counter\[3\] _05612_ _05614_
+ VSS VSS VDD VDD _02603_ sky130_fd_sc_hd__o21ai_0
X_17057_ network.in_spk13_09 _09206_ _05605_ network.in_spk14_09
+ VSS VSS VDD VDD _05615_ sky130_fd_sc_hd__o31ai_1
X_17058_ _06378_ _05615_ net376 VSS VSS VDD VDD _02003_ sky130_fd_sc_hd__a21oi_1
X_17059_ network.neuron_in135.counter\[0\] network.neuron_in135.counter\[1\]
+ network.neuron_in135.counter\[2\] VSS VSS VDD VDD _05616_
+ sky130_fd_sc_hd__nor3_1
X_17060_ network.neuron_in135.counter\[3\] _05616_ VSS VSS
+ VDD VDD _05617_ sky130_fd_sc_hd__xnor2_1
X_17061_ network.in_period\[135\]\[3\] _08040_ VSS VSS VDD
+ VDD _05618_ sky130_fd_sc_hd__nand2_1
X_17062_ _08040_ _05617_ _05618_ VSS VSS VDD VDD _02607_ sky130_fd_sc_hd__o21ai_0
X_17063_ network.neuron_in136.counter\[1\] network.neuron_in136.counter\[0\]
+ _00875_ VSS VSS VDD VDD _05619_ sky130_fd_sc_hd__o21bai_1
X_17064_ _06939_ _05619_ network.neuron_in136.counter\[3\]
+ VSS VSS VDD VDD _05620_ sky130_fd_sc_hd__a21oi_1
X_17065_ _06939_ network.neuron_in136.counter\[3\] _00874_
+ _00873_ _05620_ VSS VSS VDD VDD _05621_ sky130_fd_sc_hd__a41o_1
X_17066_ net384 _06938_ network.in_period\[136\]\[3\] VSS
+ VSS VDD VDD _05622_ sky130_fd_sc_hd__a21oi_1
X_17067_ net384 _05621_ _05622_ VSS VSS VDD VDD _02611_ sky130_fd_sc_hd__a21oi_1
X_17068_ _09206_ _05605_ network.in_spk13_09 VSS VSS VDD VDD
+ _05623_ sky130_fd_sc_hd__o21ai_0
Xoutput38 net37 VSS VSS VDD VDD inference_cycles[4] sky130_fd_sc_hd__buf_1
X_17070_ _06372_ _05623_ net376 VSS VSS VDD VDD _02004_ sky130_fd_sc_hd__a21oi_1
X_17071_ network.neuron_in137.counter\[2\] network.neuron_in137.counter\[1\]
+ network.neuron_in137.counter\[0\] VSS VSS VDD VDD _05625_
+ sky130_fd_sc_hd__nor3_1
X_17072_ network.neuron_in137.counter\[3\] _05625_ VSS VSS
+ VDD VDD _05626_ sky130_fd_sc_hd__xnor2_1
X_17073_ network.in_period\[137\]\[3\] _06929_ VSS VSS VDD
+ VDD _05627_ sky130_fd_sc_hd__nand2_1
X_17074_ _06929_ _05626_ _05627_ VSS VSS VDD VDD _02615_ sky130_fd_sc_hd__o21ai_0
X_17075_ network.in_period\[27\]\[0\] _03631_ VSS VSS VDD
+ VDD _05628_ sky130_fd_sc_hd__nand2_1
X_17076_ network.neuron_in027.counter\[0\] _03631_ _05628_
+ VSS VSS VDD VDD _02172_ sky130_fd_sc_hd__o21ai_0
X_17077_ network.neuron_in138.counter\[0\] network.neuron_in138.counter\[1\]
+ network.neuron_in138.counter\[2\] VSS VSS VDD VDD _05629_
+ sky130_fd_sc_hd__nor3_1
X_17078_ network.neuron_in138.counter\[3\] _05629_ VSS VSS
+ VDD VDD _05630_ sky130_fd_sc_hd__xnor2_1
X_17079_ network.in_period\[138\]\[3\] _06926_ VSS VSS VDD
+ VDD _05631_ sky130_fd_sc_hd__nand2_1
X_17080_ _06926_ _05630_ _05631_ VSS VSS VDD VDD _02619_ sky130_fd_sc_hd__o21ai_0
X_17081_ _09092_ _05605_ network.in_spk12_09 VSS VSS VDD VDD
+ _05632_ sky130_fd_sc_hd__o21ai_0
X_17082_ _06418_ _05632_ net376 VSS VSS VDD VDD _02005_ sky130_fd_sc_hd__a21oi_1
X_17083_ network.neuron_in139.counter\[0\] network.neuron_in139.counter\[1\]
+ _00651_ VSS VSS VDD VDD _05633_ sky130_fd_sc_hd__o21bai_1
X_17084_ _06684_ _05633_ network.neuron_in139.counter\[3\]
+ VSS VSS VDD VDD _05634_ sky130_fd_sc_hd__a21oi_1
X_17085_ _06684_ _00649_ network.neuron_in139.counter\[3\]
+ _00650_ _05634_ VSS VSS VDD VDD _05635_ sky130_fd_sc_hd__a41o_1
X_17086_ net384 _06683_ network.in_period\[139\]\[3\] VSS
+ VSS VDD VDD _05636_ sky130_fd_sc_hd__a21oi_1
X_17087_ net384 _05635_ _05636_ VSS VSS VDD VDD _02623_ sky130_fd_sc_hd__a21oi_1
X_17088_ network.neuron_in140.counter\[1\] network.neuron_in140.counter\[0\]
+ network.neuron_in140.counter\[2\] VSS VSS VDD VDD _05637_
+ sky130_fd_sc_hd__or3_1
X_17089_ net374 _06627_ _05637_ VSS VSS VDD VDD _05638_ sky130_fd_sc_hd__nor3_1
X_17090_ network.in_period\[140\]\[3\] _06627_ _05638_ VSS
+ VSS VDD VDD _05639_ sky130_fd_sc_hd__a21oi_1
X_17091_ network.in_period\[140\]\[3\] net374 VSS VSS VDD
+ VDD _05640_ sky130_fd_sc_hd__and2_1
X_17092_ network.neuron_in140.counter\[3\] net393 _05637_
+ _05640_ VSS VSS VDD VDD _05641_ sky130_fd_sc_hd__a31oi_1
X_17093_ network.neuron_in140.counter\[3\] _05639_ _05641_
+ VSS VSS VDD VDD _02627_ sky130_fd_sc_hd__o21ai_0
X_17094_ network.in_spk08_09 network.in_spk09_09 network.in_spk10_09
+ _05605_ network.in_spk11_09 VSS VSS VDD VDD _05642_ sky130_fd_sc_hd__o41ai_1
X_17095_ _06413_ _05642_ net376 VSS VSS VDD VDD _02006_ sky130_fd_sc_hd__a21oi_1
X_17096_ network.neuron_in141.counter\[1\] network.neuron_in141.counter\[0\]
+ network.neuron_in141.counter\[2\] VSS VSS VDD VDD _05643_
+ sky130_fd_sc_hd__nor3_1
X_17097_ network.neuron_in141.counter\[3\] _05643_ VSS VSS
+ VDD VDD _05644_ sky130_fd_sc_hd__xnor2_1
X_17098_ network.in_period\[141\]\[3\] _06579_ VSS VSS VDD
+ VDD _05645_ sky130_fd_sc_hd__nand2_1
X_17099_ _06579_ _05644_ _05645_ VSS VSS VDD VDD _02631_ sky130_fd_sc_hd__o21ai_0
X_17100_ network.neuron_in142.counter\[1\] network.neuron_in142.counter\[2\]
+ network.neuron_in142.counter\[0\] VSS VSS VDD VDD _05646_
+ sky130_fd_sc_hd__nor3_1
X_17101_ network.neuron_in142.counter\[3\] _05646_ VSS VSS
+ VDD VDD _05647_ sky130_fd_sc_hd__xnor2_1
X_17102_ network.in_period\[142\]\[3\] _06547_ VSS VSS VDD
+ VDD _05648_ sky130_fd_sc_hd__nand2_1
X_17103_ _06547_ _05647_ _05648_ VSS VSS VDD VDD _02635_ sky130_fd_sc_hd__o21ai_0
X_17104_ network.in_spk08_09 network.in_spk09_09 _05605_ network.in_spk10_09
+ VSS VSS VDD VDD _05649_ sky130_fd_sc_hd__o31ai_1
X_17105_ _06408_ _05649_ net376 VSS VSS VDD VDD _02007_ sky130_fd_sc_hd__a21oi_1
X_17106_ network.neuron_in143.counter\[1\] network.neuron_in143.counter\[0\]
+ network.neuron_in143.counter\[2\] VSS VSS VDD VDD _05650_
+ sky130_fd_sc_hd__nor3_1
X_17107_ network.neuron_in143.counter\[3\] _05650_ VSS VSS
+ VDD VDD _05651_ sky130_fd_sc_hd__xnor2_1
X_17108_ network.in_period\[143\]\[3\] _06522_ VSS VSS VDD
+ VDD _05652_ sky130_fd_sc_hd__nand2_1
X_17109_ _06522_ _05651_ _05652_ VSS VSS VDD VDD _02639_ sky130_fd_sc_hd__o21ai_0
X_17110_ network.neuron_in144.counter\[1\] network.neuron_in144.counter\[0\]
+ network.neuron_in144.counter\[2\] VSS VSS VDD VDD _05653_
+ sky130_fd_sc_hd__or3_1
X_17111_ net376 _05653_ VSS VSS VDD VDD _05654_ sky130_fd_sc_hd__nor2_1
X_17112_ network.in_period\[144\]\[3\] net394 VSS VSS VDD
+ VDD _05655_ sky130_fd_sc_hd__nor2_1
X_17113_ network.in_period\[144\]\[3\] _06694_ VSS VSS VDD
+ VDD _05656_ sky130_fd_sc_hd__nor2_1
X_17114_ net394 _06694_ _05653_ _05656_ VSS VSS VDD VDD _05657_
+ sky130_fd_sc_hd__a31oi_1
X_17115_ network.neuron_in144.counter\[3\] _05657_ VSS VSS
+ VDD VDD _05658_ sky130_fd_sc_hd__nor2_1
X_17116_ network.neuron_in144.counter\[3\] _05654_ _05655_
+ _05658_ VSS VSS VDD VDD _02643_ sky130_fd_sc_hd__a211oi_1
X_17117_ network.in_spk08_09 _05605_ network.in_spk09_09 VSS
+ VSS VDD VDD _05659_ sky130_fd_sc_hd__o21ai_0
X_17118_ _06403_ _05659_ net376 VSS VSS VDD VDD _02008_ sky130_fd_sc_hd__a21oi_1
X_17119_ network.neuron_in145.counter\[2\] _00621_ VSS VSS
+ VDD VDD _05660_ sky130_fd_sc_hd__nor2b_1
X_17120_ network.neuron_in145.counter\[0\] network.neuron_in145.counter\[1\]
+ network.neuron_in145.counter\[2\] VSS VSS VDD VDD _05661_
+ sky130_fd_sc_hd__or3_1
X_17121_ net381 _05660_ _05661_ VSS VSS VDD VDD _05662_ sky130_fd_sc_hd__nor3_1
X_17122_ network.in_period\[145\]\[3\] _05660_ _05662_ VSS
+ VSS VDD VDD _05663_ sky130_fd_sc_hd__a21oi_1
X_17123_ network.in_period\[145\]\[3\] net381 VSS VSS VDD
+ VDD _05664_ sky130_fd_sc_hd__and2_1
X_17124_ network.neuron_in145.counter\[3\] net400 _05661_
+ _05664_ VSS VSS VDD VDD _05665_ sky130_fd_sc_hd__a31oi_1
X_17125_ network.neuron_in145.counter\[3\] _05663_ _05665_
+ VSS VSS VDD VDD _02647_ sky130_fd_sc_hd__o21ai_0
X_17126_ network.neuron_in146.counter\[1\] network.neuron_in146.counter\[2\]
+ network.neuron_in146.counter\[0\] VSS VSS VDD VDD _05666_
+ sky130_fd_sc_hd__nor3_1
X_17127_ network.neuron_in146.counter\[3\] _05666_ VSS VSS
+ VDD VDD _05667_ sky130_fd_sc_hd__xnor2_1
X_17128_ network.in_period\[146\]\[3\] _03508_ VSS VSS VDD
+ VDD _05668_ sky130_fd_sc_hd__nand2_1
X_17129_ _03508_ _05667_ _05668_ VSS VSS VDD VDD _02651_ sky130_fd_sc_hd__o21ai_0
Xoutput37 net36 VSS VSS VDD VDD inference_cycles[3] sky130_fd_sc_hd__buf_1
X_17131_ network.neuron_in028.counter\[3\] network.in_period\[28\]\[2\]
+ net373 _00357_ VSS VSS VDD VDD _05670_ sky130_fd_sc_hd__o22ai_1
Xoutput36 net35 VSS VSS VDD VDD inference_cycles[2] sky130_fd_sc_hd__buf_1
X_17133_ network.neuron_in028.counter\[2\] _00357_ net391
+ VSS VSS VDD VDD _05672_ sky130_fd_sc_hd__nand3_1
X_17134_ network.in_period\[28\]\[2\] net391 _05672_ VSS VSS
+ VDD VDD _05673_ sky130_fd_sc_hd__o21ai_0
X_17135_ _04567_ _05670_ _05673_ VSS VSS VDD VDD _02178_ sky130_fd_sc_hd__a21oi_1
X_17136_ net391 _04568_ VSS VSS VDD VDD _05674_ sky130_fd_sc_hd__nand2_1
X_17137_ network.in_period\[28\]\[1\] _05674_ VSS VSS VDD
+ VDD _05675_ sky130_fd_sc_hd__nand2_1
X_17138_ _00358_ _05674_ _05675_ VSS VSS VDD VDD _02177_ sky130_fd_sc_hd__o21ai_0
X_17139_ network.in_spk08_09 _05605_ VSS VSS VDD VDD _05676_
+ sky130_fd_sc_hd__nand2_1
X_17140_ _06400_ _05676_ net376 VSS VSS VDD VDD _02009_ sky130_fd_sc_hd__a21oi_1
X_17141_ network.in_period\[28\]\[0\] _05674_ VSS VSS VDD
+ VDD _05677_ sky130_fd_sc_hd__nand2_1
X_17142_ network.neuron_in028.counter\[0\] _05674_ _05677_
+ VSS VSS VDD VDD _02176_ sky130_fd_sc_hd__o21ai_0
X_17143_ network.neuron_in147.counter\[1\] network.neuron_in147.counter\[2\]
+ network.neuron_in147.counter\[0\] VSS VSS VDD VDD _05678_
+ sky130_fd_sc_hd__or3_1
X_17144_ net369 _06982_ _05678_ VSS VSS VDD VDD _05679_ sky130_fd_sc_hd__nor3_1
X_17145_ network.in_period\[147\]\[3\] _06982_ _05679_ VSS
+ VSS VDD VDD _05680_ sky130_fd_sc_hd__a21oi_1
X_17146_ network.in_period\[147\]\[3\] net369 VSS VSS VDD
+ VDD _05681_ sky130_fd_sc_hd__and2_1
X_17147_ network.neuron_in147.counter\[3\] net403 _05678_
+ _05681_ VSS VSS VDD VDD _05682_ sky130_fd_sc_hd__a31oi_1
X_17148_ network.neuron_in147.counter\[3\] _05680_ _05682_
+ VSS VSS VDD VDD _02655_ sky130_fd_sc_hd__o21ai_0
X_17149_ network.neuron_in148.counter\[0\] network.neuron_in148.counter\[1\]
+ network.neuron_in148.counter\[2\] VSS VSS VDD VDD _05683_
+ sky130_fd_sc_hd__nor3_1
X_17150_ net369 _05683_ VSS VSS VDD VDD _05684_ sky130_fd_sc_hd__nor2_1
X_17151_ net403 _04633_ _05683_ VSS VSS VDD VDD _05685_ sky130_fd_sc_hd__nand3_1
X_17152_ network.neuron_in148.counter\[2\] network.in_period\[148\]\[3\]
+ _00593_ VSS VSS VDD VDD _05686_ sky130_fd_sc_hd__nand3b_1
X_17153_ _05685_ _05686_ network.neuron_in148.counter\[3\]
+ VSS VSS VDD VDD _05687_ sky130_fd_sc_hd__a21oi_1
X_17154_ network.in_period\[148\]\[3\] net369 _05684_ network.neuron_in148.counter\[3\]
+ _05687_ VSS VSS VDD VDD _02659_ sky130_fd_sc_hd__a221o_1
X_17155_ network.in_period\[25\]\[1\] _03622_ VSS VSS VDD
+ VDD _05688_ sky130_fd_sc_hd__nand2_1
X_17156_ _00455_ _03622_ _05688_ VSS VSS VDD VDD _02165_ sky130_fd_sc_hd__o21ai_0
X_17157_ _08974_ _09214_ VSS VSS VDD VDD _05689_ sky130_fd_sc_hd__nand2_1
X_17158_ network.in_spk07_09 _05689_ VSS VSS VDD VDD _05690_
+ sky130_fd_sc_hd__nand2_1
X_17159_ _04628_ _05690_ net376 VSS VSS VDD VDD _02010_ sky130_fd_sc_hd__a21oi_1
X_17160_ net385 _04687_ VSS VSS VDD VDD _05691_ sky130_fd_sc_hd__nand2_1
X_17161_ network.in_period\[102\]\[1\] _05691_ VSS VSS VDD
+ VDD _05692_ sky130_fd_sc_hd__nand2_1
X_17162_ _00997_ _05691_ _05692_ VSS VSS VDD VDD _02473_ sky130_fd_sc_hd__o21ai_0
X_17163_ net403 _04631_ VSS VSS VDD VDD _05693_ sky130_fd_sc_hd__nand2_1
X_17164_ network.neuron_in149.counter\[1\] network.neuron_in149.counter\[2\]
+ network.neuron_in149.counter\[0\] VSS VSS VDD VDD _05694_
+ sky130_fd_sc_hd__nor3_1
X_17165_ network.neuron_in149.counter\[3\] _05694_ VSS VSS
+ VDD VDD _05695_ sky130_fd_sc_hd__xnor2_1
X_17166_ network.in_period\[149\]\[3\] _05693_ VSS VSS VDD
+ VDD _05696_ sky130_fd_sc_hd__nand2_1
X_17167_ _05693_ _05695_ _05696_ VSS VSS VDD VDD _02663_ sky130_fd_sc_hd__o21ai_0
X_17168_ network.neuron_in100.counter\[3\] network.in_period\[100\]\[2\]
+ net377 _00704_ VSS VSS VDD VDD _05697_ sky130_fd_sc_hd__o22ai_1
X_17169_ network.neuron_in100.counter\[2\] _00704_ net385
+ VSS VSS VDD VDD _05698_ sky130_fd_sc_hd__nand3_1
X_17170_ network.in_period\[100\]\[2\] net385 _05698_ VSS
+ VSS VDD VDD _05699_ sky130_fd_sc_hd__o21ai_0
X_17171_ _05422_ _05697_ _05699_ VSS VSS VDD VDD _02466_ sky130_fd_sc_hd__a21oi_1
X_17172_ net401 _04629_ VSS VSS VDD VDD _05700_ sky130_fd_sc_hd__nand2_1
X_17173_ network.neuron_in150.counter\[0\] network.neuron_in150.counter\[2\]
+ network.neuron_in150.counter\[1\] VSS VSS VDD VDD _05701_
+ sky130_fd_sc_hd__nor3_1
X_17174_ network.neuron_in150.counter\[3\] _05701_ VSS VSS
+ VDD VDD _05702_ sky130_fd_sc_hd__xnor2_1
X_17175_ network.in_period\[150\]\[3\] _05700_ VSS VSS VDD
+ VDD _05703_ sky130_fd_sc_hd__nand2_1
X_17176_ _05700_ _05702_ _05703_ VSS VSS VDD VDD _02667_ sky130_fd_sc_hd__o21ai_0
X_17177_ net385 _04417_ VSS VSS VDD VDD _05704_ sky130_fd_sc_hd__nand2_1
X_17178_ network.in_period\[97\]\[0\] _05704_ VSS VSS VDD
+ VDD _05705_ sky130_fd_sc_hd__nand2_1
X_17179_ network.neuron_in097.counter\[0\] _05704_ _05705_
+ VSS VSS VDD VDD _02452_ sky130_fd_sc_hd__o21ai_0
X_17180_ net390 _04693_ VSS VSS VDD VDD _05706_ sky130_fd_sc_hd__nand2_1
X_17181_ network.in_period\[99\]\[0\] _05706_ VSS VSS VDD
+ VDD _05707_ sky130_fd_sc_hd__nand2_1
X_17182_ network.neuron_in099.counter\[0\] _05706_ _05707_
+ VSS VSS VDD VDD _02460_ sky130_fd_sc_hd__o21ai_0
X_17183_ _08903_ _08974_ VSS VSS VDD VDD _05708_ sky130_fd_sc_hd__nand2_1
X_17184_ network.in_spk04_09 network.in_spk05_09 _05708_ network.in_spk06_09
+ VSS VSS VDD VDD _05709_ sky130_fd_sc_hd__o31ai_1
X_17185_ _04629_ _05709_ net376 VSS VSS VDD VDD _02011_ sky130_fd_sc_hd__a21oi_1
X_17186_ network.neuron_in151.counter\[0\] network.neuron_in151.counter\[2\]
+ network.neuron_in151.counter\[1\] VSS VSS VDD VDD _05710_
+ sky130_fd_sc_hd__nor3_1
X_17187_ net381 _05710_ VSS VSS VDD VDD _05711_ sky130_fd_sc_hd__nor2_1
X_17188_ net400 _04627_ _05710_ VSS VSS VDD VDD _05712_ sky130_fd_sc_hd__nand3_1
X_17189_ _04626_ _00482_ network.in_period\[151\]\[3\] VSS
+ VSS VDD VDD _05713_ sky130_fd_sc_hd__nand3_1
X_17190_ _05712_ _05713_ network.neuron_in151.counter\[3\]
+ VSS VSS VDD VDD _05714_ sky130_fd_sc_hd__a21oi_1
X_17191_ network.in_period\[151\]\[3\] net381 _05711_ network.neuron_in151.counter\[3\]
+ _05714_ VSS VSS VDD VDD _02671_ sky130_fd_sc_hd__a221o_1
X_17192_ network.neuron_in097.counter\[3\] network.in_period\[97\]\[2\]
+ net372 _01215_ VSS VSS VDD VDD _05715_ sky130_fd_sc_hd__o22ai_1
X_17193_ network.neuron_in097.counter\[2\] _01215_ net385
+ VSS VSS VDD VDD _05716_ sky130_fd_sc_hd__nand3_1
X_17194_ network.in_period\[97\]\[2\] net385 _05716_ VSS VSS
+ VDD VDD _05717_ sky130_fd_sc_hd__o21ai_0
X_17195_ _04416_ _05715_ _05717_ VSS VSS VDD VDD _02454_ sky130_fd_sc_hd__a21oi_1
X_17196_ network.neuron_in152.counter\[2\] VSS VSS VDD VDD
+ _05718_ sky130_fd_sc_hd__inv_1
X_17197_ _00477_ _05718_ _00476_ VSS VSS VDD VDD _05719_ sky130_fd_sc_hd__nand3_1
X_17198_ net376 _06399_ _05719_ VSS VSS VDD VDD _05720_ sky130_fd_sc_hd__nor3_1
X_17199_ network.in_period\[152\]\[3\] _06399_ _05720_ VSS
+ VSS VDD VDD _05721_ sky130_fd_sc_hd__a21oi_1
Xoutput35 net34 VSS VSS VDD VDD inference_cycles[1] sky130_fd_sc_hd__buf_1
Xoutput34 net33 VSS VSS VDD VDD inference_cycles[15] sky130_fd_sc_hd__buf_1
X_17202_ network.in_period\[152\]\[3\] net376 VSS VSS VDD
+ VDD _05724_ sky130_fd_sc_hd__and2_1
X_17203_ network.neuron_in152.counter\[3\] net401 _05719_
+ _05724_ VSS VSS VDD VDD _05725_ sky130_fd_sc_hd__a31oi_1
X_17204_ network.neuron_in152.counter\[3\] _05721_ _05725_
+ VSS VSS VDD VDD _02675_ sky130_fd_sc_hd__o21ai_0
X_17205_ network.in_period\[98\]\[0\] _05408_ VSS VSS VDD
+ VDD _05726_ sky130_fd_sc_hd__nand2_1
X_17206_ network.neuron_in098.counter\[0\] _05408_ _05726_
+ VSS VSS VDD VDD _02456_ sky130_fd_sc_hd__o21ai_0
X_17207_ network.in_spk04_09 _05708_ network.in_spk05_09 VSS
+ VSS VDD VDD _05727_ sky130_fd_sc_hd__o21ai_0
X_17208_ _04631_ _05727_ net376 VSS VSS VDD VDD _02012_ sky130_fd_sc_hd__a21oi_1
X_17209_ network.in_period\[99\]\[1\] _05706_ VSS VSS VDD
+ VDD _05728_ sky130_fd_sc_hd__nand2_1
X_17210_ _00725_ _05706_ _05728_ VSS VSS VDD VDD _02461_ sky130_fd_sc_hd__o21ai_0
X_17211_ network.neuron_in153.counter\[0\] network.neuron_in153.counter\[2\]
+ network.neuron_in153.counter\[1\] VSS VSS VDD VDD _05729_
+ sky130_fd_sc_hd__nor3_1
X_17212_ network.neuron_in153.counter\[3\] _05729_ VSS VSS
+ VDD VDD _05730_ sky130_fd_sc_hd__xnor2_1
X_17213_ network.in_period\[153\]\[3\] _06404_ VSS VSS VDD
+ VDD _05731_ sky130_fd_sc_hd__nand2_1
X_17214_ _06404_ _05730_ _05731_ VSS VSS VDD VDD _02679_ sky130_fd_sc_hd__o21ai_0
X_17215_ network.neuron_in154.counter\[2\] network.neuron_in154.counter\[1\]
+ network.neuron_in154.counter\[0\] VSS VSS VDD VDD _05732_
+ sky130_fd_sc_hd__nor3_1
X_17216_ network.neuron_in154.counter\[3\] _05732_ VSS VSS
+ VDD VDD _05733_ sky130_fd_sc_hd__xnor2_1
X_17217_ network.in_period\[154\]\[3\] _06410_ VSS VSS VDD
+ VDD _05734_ sky130_fd_sc_hd__nand2_1
X_17218_ _06410_ _05733_ _05734_ VSS VSS VDD VDD _02683_ sky130_fd_sc_hd__o21ai_0
X_17219_ network.in_spk04_09 _05708_ VSS VSS VDD VDD _05735_
+ sky130_fd_sc_hd__nand2_1
X_17220_ _04634_ _05735_ net376 VSS VSS VDD VDD _02013_ sky130_fd_sc_hd__a21oi_1
X_17221_ network.neuron_in155.counter\[1\] network.neuron_in155.counter\[2\]
+ network.neuron_in155.counter\[0\] VSS VSS VDD VDD _05736_
+ sky130_fd_sc_hd__nor3_1
X_17222_ network.neuron_in155.counter\[3\] _05736_ VSS VSS
+ VDD VDD _05737_ sky130_fd_sc_hd__xnor2_1
X_17223_ network.in_period\[155\]\[3\] _06414_ VSS VSS VDD
+ VDD _05738_ sky130_fd_sc_hd__nand2_1
X_17224_ _06414_ _05737_ _05738_ VSS VSS VDD VDD _02687_ sky130_fd_sc_hd__o21ai_0
X_17225_ network.in_period\[97\]\[1\] _05704_ VSS VSS VDD
+ VDD _05739_ sky130_fd_sc_hd__nand2_1
X_17226_ _01216_ _05704_ _05739_ VSS VSS VDD VDD _02453_ sky130_fd_sc_hd__o21ai_0
X_17227_ network.neuron_in156.counter\[1\] network.neuron_in156.counter\[0\]
+ VSS VSS VDD VDD _05740_ sky130_fd_sc_hd__nor2_1
X_17228_ _01065_ _05740_ VSS VSS VDD VDD _05741_ sky130_fd_sc_hd__nor2_1
X_17229_ network.neuron_in156.counter\[2\] _05741_ VSS VSS
+ VDD VDD _05742_ sky130_fd_sc_hd__nor2_1
X_17230_ network.neuron_in156.counter\[2\] network.neuron_in156.counter\[3\]
+ _05740_ VSS VSS VDD VDD _05743_ sky130_fd_sc_hd__nand3b_1
X_17231_ network.neuron_in156.counter\[3\] _05742_ _05743_
+ VSS VSS VDD VDD _05744_ sky130_fd_sc_hd__o21ai_0
X_17232_ net394 _06417_ network.in_period\[156\]\[3\] VSS
+ VSS VDD VDD _05745_ sky130_fd_sc_hd__a21oi_1
X_17233_ net394 _05744_ _05745_ VSS VSS VDD VDD _02691_ sky130_fd_sc_hd__a21oi_1
X_17234_ network.in_period\[96\]\[0\] _05302_ VSS VSS VDD
+ VDD _05746_ sky130_fd_sc_hd__nand2_1
X_17235_ network.neuron_in096.counter\[0\] _05302_ _05746_
+ VSS VSS VDD VDD _02448_ sky130_fd_sc_hd__o21ai_0
X_17236_ _09210_ _08974_ VSS VSS VDD VDD _05747_ sky130_fd_sc_hd__nand2_1
X_17237_ network.in_spk02_09 _05747_ network.in_spk03_09 VSS
+ VSS VDD VDD _05748_ sky130_fd_sc_hd__o21ai_0
Xoutput33 net32 VSS VSS VDD VDD inference_cycles[14] sky130_fd_sc_hd__buf_1
X_17239_ _06983_ _05748_ net376 VSS VSS VDD VDD _02014_ sky130_fd_sc_hd__a21oi_1
X_17240_ network.neuron_in157.counter\[2\] network.neuron_in157.counter\[0\]
+ network.neuron_in157.counter\[1\] VSS VSS VDD VDD _05750_
+ sky130_fd_sc_hd__nor3_1
X_17241_ network.neuron_in157.counter\[3\] _05750_ VSS VSS
+ VDD VDD _05751_ sky130_fd_sc_hd__xnor2_1
X_17242_ network.in_period\[157\]\[3\] _06513_ VSS VSS VDD
+ VDD _05752_ sky130_fd_sc_hd__nand2_1
X_17243_ _06513_ _05751_ _05752_ VSS VSS VDD VDD _02695_ sky130_fd_sc_hd__o21ai_0
X_17244_ network.neuron_in158.counter\[1\] network.neuron_in158.counter\[0\]
+ _00645_ VSS VSS VDD VDD _05753_ sky130_fd_sc_hd__o21bai_1
X_17245_ _06377_ _05753_ network.neuron_in158.counter\[3\]
+ VSS VSS VDD VDD _05754_ sky130_fd_sc_hd__a21oi_1
X_17246_ _06377_ network.neuron_in158.counter\[3\] _00644_
+ _00643_ _05754_ VSS VSS VDD VDD _05755_ sky130_fd_sc_hd__a41o_1
X_17247_ net394 _06376_ network.in_period\[158\]\[3\] VSS
+ VSS VDD VDD _05756_ sky130_fd_sc_hd__a21oi_1
X_17248_ net394 _05755_ _05756_ VSS VSS VDD VDD _02699_ sky130_fd_sc_hd__a21oi_1
X_17249_ network.neuron_in098.counter\[2\] _00944_ VSS VSS
+ VDD VDD _05757_ sky130_fd_sc_hd__xnor2_1
X_17250_ net390 _04695_ network.in_period\[98\]\[2\] VSS VSS
+ VDD VDD _05758_ sky130_fd_sc_hd__a21oi_1
X_17251_ net390 _05757_ _05758_ VSS VSS VDD VDD _02458_ sky130_fd_sc_hd__a21oi_1
X_17252_ network.in_spk02_09 _05747_ _03507_ VSS VSS VDD VDD
+ _05759_ sky130_fd_sc_hd__a21boi_0
X_17253_ net376 _05759_ VSS VSS VDD VDD _02015_ sky130_fd_sc_hd__nor2_1
X_17254_ network.neuron_in159.counter\[2\] network.neuron_in159.counter\[0\]
+ network.neuron_in159.counter\[1\] VSS VSS VDD VDD _05760_
+ sky130_fd_sc_hd__nor3_1
X_17255_ network.neuron_in159.counter\[3\] _05760_ VSS VSS
+ VDD VDD _05761_ sky130_fd_sc_hd__xnor2_1
X_17256_ network.in_period\[159\]\[3\] _06384_ VSS VSS VDD
+ VDD _05762_ sky130_fd_sc_hd__nand2_1
X_17257_ _06384_ _05761_ _05762_ VSS VSS VDD VDD _02703_ sky130_fd_sc_hd__o21ai_0
X_17258_ network.in_period\[98\]\[1\] _05408_ VSS VSS VDD
+ VDD _05763_ sky130_fd_sc_hd__nand2_1
X_17259_ _00945_ _05408_ _05763_ VSS VSS VDD VDD _02457_ sky130_fd_sc_hd__o21ai_0
Xoutput32 net31 VSS VSS VDD VDD inference_cycles[13] sky130_fd_sc_hd__buf_1
X_17261_ _01092_ _06934_ _01091_ VSS VSS VDD VDD _05765_ sky130_fd_sc_hd__nand3_1
X_17262_ net369 _06432_ _05765_ VSS VSS VDD VDD _05766_ sky130_fd_sc_hd__nor3_1
X_17263_ network.in_period\[160\]\[3\] _06432_ _05766_ VSS
+ VSS VDD VDD _05767_ sky130_fd_sc_hd__a21oi_1
X_17264_ network.in_period\[160\]\[3\] net369 VSS VSS VDD
+ VDD _05768_ sky130_fd_sc_hd__and2_1
X_17265_ network.neuron_in160.counter\[3\] net404 _05765_
+ _05768_ VSS VSS VDD VDD _05769_ sky130_fd_sc_hd__a31oi_1
X_17266_ network.neuron_in160.counter\[3\] _05767_ _05769_
+ VSS VSS VDD VDD _02707_ sky130_fd_sc_hd__o21ai_0
X_17267_ _09221_ network.in_spk01_09 VSS VSS VDD VDD _05770_
+ sky130_fd_sc_hd__nand2b_1
X_17268_ _07419_ _05770_ net380 VSS VSS VDD VDD _02016_ sky130_fd_sc_hd__a21oi_1
X_17269_ network.neuron_in161.counter\[0\] network.neuron_in161.counter\[1\]
+ _00764_ VSS VSS VDD VDD _05771_ sky130_fd_sc_hd__o21bai_1
X_17270_ _06386_ _05771_ network.neuron_in161.counter\[3\]
+ VSS VSS VDD VDD _05772_ sky130_fd_sc_hd__a21oi_1
X_17271_ _06386_ network.neuron_in161.counter\[3\] _00762_
+ _00763_ _05772_ VSS VSS VDD VDD _05773_ sky130_fd_sc_hd__a41o_1
X_17272_ net404 _06437_ network.in_period\[161\]\[3\] VSS
+ VSS VDD VDD _05774_ sky130_fd_sc_hd__a21oi_1
X_17273_ net403 _05773_ _05774_ VSS VSS VDD VDD _02711_ sky130_fd_sc_hd__a21oi_1
X_17274_ network.neuron_in099.counter\[2\] net390 VSS VSS
+ VDD VDD _05775_ sky130_fd_sc_hd__nand2_1
X_17275_ network.neuron_in099.counter\[3\] network.in_period\[99\]\[2\]
+ _05775_ VSS VSS VDD VDD _05776_ sky130_fd_sc_hd__o21ai_0
X_17276_ _00724_ network.neuron_in099.counter\[2\] net372
+ VSS VSS VDD VDD _05777_ sky130_fd_sc_hd__or3_1
X_17277_ network.in_period\[99\]\[2\] net390 _05777_ VSS VSS
+ VDD VDD _05778_ sky130_fd_sc_hd__o21ai_0
X_17278_ _00724_ _05776_ _05778_ VSS VSS VDD VDD _02462_ sky130_fd_sc_hd__a21oi_1
X_17279_ network.neuron_in162.counter\[1\] network.neuron_in162.counter\[0\]
+ _00776_ VSS VSS VDD VDD _05779_ sky130_fd_sc_hd__o21bai_1
X_17280_ _03764_ _05779_ network.neuron_in162.counter\[3\]
+ VSS VSS VDD VDD _05780_ sky130_fd_sc_hd__a21oi_1
X_17281_ _03764_ network.neuron_in162.counter\[3\] _00775_
+ _00774_ _05780_ VSS VSS VDD VDD _05781_ sky130_fd_sc_hd__a41o_1
Xoutput31 net30 VSS VSS VDD VDD inference_cycles[12] sky130_fd_sc_hd__buf_1
X_17283_ net402 _03769_ network.in_period\[162\]\[3\] VSS
+ VSS VDD VDD _05783_ sky130_fd_sc_hd__a21oi_1
X_17284_ net402 _05781_ _05783_ VSS VSS VDD VDD _02715_ sky130_fd_sc_hd__a21oi_1
X_17285_ net385 _04691_ VSS VSS VDD VDD _05784_ sky130_fd_sc_hd__nand2_1
X_17286_ network.in_period\[100\]\[1\] _05784_ VSS VSS VDD
+ VDD _05785_ sky130_fd_sc_hd__nand2_1
X_17287_ _00705_ _05784_ _05785_ VSS VSS VDD VDD _02465_ sky130_fd_sc_hd__o21ai_0
X_17288_ network.in_period\[100\]\[0\] _05784_ VSS VSS VDD
+ VDD _05786_ sky130_fd_sc_hd__nand2_1
X_17289_ network.neuron_in100.counter\[0\] _05784_ _05786_
+ VSS VSS VDD VDD _02464_ sky130_fd_sc_hd__o21ai_0
X_17290_ _00736_ _06696_ _09095_ network.in_spk00_09 VSS VSS
+ VDD VDD _05787_ sky130_fd_sc_hd__a22oi_1
X_17291_ net376 _05787_ VSS VSS VDD VDD _02017_ sky130_fd_sc_hd__nor2_1
X_17292_ network.neuron_in163.counter\[2\] network.neuron_in163.counter\[0\]
+ network.neuron_in163.counter\[1\] VSS VSS VDD VDD _05788_
+ sky130_fd_sc_hd__nor3_1
X_17293_ network.neuron_in163.counter\[3\] _05788_ VSS VSS
+ VDD VDD _05789_ sky130_fd_sc_hd__xnor2_1
X_17294_ network.in_period\[163\]\[3\] _03802_ VSS VSS VDD
+ VDD _05790_ sky130_fd_sc_hd__nand2_1
X_17295_ _03802_ _05789_ _05790_ VSS VSS VDD VDD _02719_ sky130_fd_sc_hd__o21ai_0
X_17296_ network.neuron_in164.counter\[0\] network.neuron_in164.counter\[1\]
+ _00861_ VSS VSS VDD VDD _05791_ sky130_fd_sc_hd__o21bai_1
X_17297_ _03924_ _05791_ network.neuron_in164.counter\[3\]
+ VSS VSS VDD VDD _05792_ sky130_fd_sc_hd__a21oi_1
X_17298_ _03924_ network.neuron_in164.counter\[3\] _00859_
+ _00860_ _05792_ VSS VSS VDD VDD _05793_ sky130_fd_sc_hd__a41o_1
X_17299_ net401 _03928_ network.in_period\[164\]\[3\] VSS
+ VSS VDD VDD _05794_ sky130_fd_sc_hd__a21oi_1
X_17300_ net401 _05793_ _05794_ VSS VSS VDD VDD _02723_ sky130_fd_sc_hd__a21oi_1
X_17301_ _08898_ _08940_ VSS VSS VDD VDD _05795_ sky130_fd_sc_hd__nor2_1
X_17302_ _08894_ _08987_ _05795_ VSS VSS VDD VDD _05796_ sky130_fd_sc_hd__nand3_1
X_17303_ network.in_spk12_08 network.in_spk13_08 network.in_spk14_08
+ _05796_ network.in_spk15_08 VSS VSS VDD VDD _05797_ sky130_fd_sc_hd__o41ai_1
X_17304_ _06521_ _05797_ net375 VSS VSS VDD VDD _02018_ sky130_fd_sc_hd__a21oi_1
X_17305_ network.neuron_in165.counter\[2\] network.neuron_in165.counter\[0\]
+ network.neuron_in165.counter\[1\] VSS VSS VDD VDD _05798_
+ sky130_fd_sc_hd__nor3_1
X_17306_ network.neuron_in165.counter\[3\] _05798_ VSS VSS
+ VDD VDD _05799_ sky130_fd_sc_hd__xnor2_1
X_17307_ network.in_period\[165\]\[3\] _03936_ VSS VSS VDD
+ VDD _05800_ sky130_fd_sc_hd__nand2_1
X_17308_ _03936_ _05799_ _05800_ VSS VSS VDD VDD _02727_ sky130_fd_sc_hd__o21ai_0
X_17309_ network.neuron_in101.counter\[2\] _00836_ VSS VSS
+ VDD VDD _05801_ sky130_fd_sc_hd__xnor2_1
X_17310_ net385 _04689_ network.in_period\[101\]\[2\] VSS
+ VSS VDD VDD _05802_ sky130_fd_sc_hd__a21oi_1
X_17311_ net385 _05801_ _05802_ VSS VSS VDD VDD _02470_ sky130_fd_sc_hd__a21oi_1
X_17312_ network.neuron_in166.counter\[2\] network.neuron_in166.counter\[0\]
+ network.neuron_in166.counter\[1\] VSS VSS VDD VDD _05803_
+ sky130_fd_sc_hd__nor3_1
X_17313_ network.neuron_in166.counter\[3\] _05803_ VSS VSS
+ VDD VDD _05804_ sky130_fd_sc_hd__xnor2_1
X_17314_ network.in_period\[166\]\[3\] _07504_ VSS VSS VDD
+ VDD _05805_ sky130_fd_sc_hd__nand2_1
X_17315_ _07504_ _05804_ _05805_ VSS VSS VDD VDD _02731_ sky130_fd_sc_hd__o21ai_0
X_17316_ network.in_period\[101\]\[1\] _05431_ VSS VSS VDD
+ VDD _05806_ sky130_fd_sc_hd__nand2_1
X_17317_ _00837_ _05431_ _05806_ VSS VSS VDD VDD _02469_ sky130_fd_sc_hd__o21ai_0
X_17318_ network.in_spk12_08 network.in_spk13_08 _05796_ network.in_spk14_08
+ VSS VSS VDD VDD _05807_ sky130_fd_sc_hd__o31ai_1
X_17319_ _06546_ _05807_ net375 VSS VSS VDD VDD _02019_ sky130_fd_sc_hd__a21oi_1
X_17320_ network.neuron_in167.counter\[2\] network.neuron_in167.counter\[1\]
+ network.neuron_in167.counter\[0\] VSS VSS VDD VDD _05808_
+ sky130_fd_sc_hd__nor3_1
X_17321_ network.neuron_in167.counter\[3\] _05808_ VSS VSS
+ VDD VDD _05809_ sky130_fd_sc_hd__xnor2_1
X_17322_ network.in_period\[167\]\[3\] _07476_ VSS VSS VDD
+ VDD _05810_ sky130_fd_sc_hd__nand2_1
X_17323_ _07476_ _05809_ _05810_ VSS VSS VDD VDD _02735_ sky130_fd_sc_hd__o21ai_0
X_17324_ network.in_period\[101\]\[0\] _05431_ VSS VSS VDD
+ VDD _05811_ sky130_fd_sc_hd__nand2_1
X_17325_ network.neuron_in101.counter\[0\] _05431_ _05811_
+ VSS VSS VDD VDD _02468_ sky130_fd_sc_hd__o21ai_0
Xoutput30 net29 VSS VSS VDD VDD inference_cycles[11] sky130_fd_sc_hd__buf_1
X_17327_ network.neuron_in168.counter\[1\] network.neuron_in168.counter\[0\]
+ _00956_ VSS VSS VDD VDD _05813_ sky130_fd_sc_hd__o21bai_1
X_17328_ _07460_ _05813_ network.neuron_in168.counter\[3\]
+ VSS VSS VDD VDD _05814_ sky130_fd_sc_hd__a21oi_1
X_17329_ _07460_ network.neuron_in168.counter\[3\] _00955_
+ _00954_ _05814_ VSS VSS VDD VDD _05815_ sky130_fd_sc_hd__a41o_1
X_17330_ net401 _07459_ network.in_period\[168\]\[3\] VSS
+ VSS VDD VDD _05816_ sky130_fd_sc_hd__a21oi_1
X_17331_ net406 _05815_ _05816_ VSS VSS VDD VDD _02739_ sky130_fd_sc_hd__a21oi_1
X_17332_ network.neuron_in102.counter\[3\] network.in_period\[102\]\[2\]
+ net372 _00996_ VSS VSS VDD VDD _05817_ sky130_fd_sc_hd__o22ai_1
X_17333_ network.neuron_in102.counter\[2\] _00996_ net385
+ VSS VSS VDD VDD _05818_ sky130_fd_sc_hd__nand3_1
X_17334_ network.in_period\[102\]\[2\] net385 _05818_ VSS
+ VSS VDD VDD _05819_ sky130_fd_sc_hd__o21ai_0
X_17335_ _04686_ _05817_ _05819_ VSS VSS VDD VDD _02474_ sky130_fd_sc_hd__a21oi_1
X_17336_ network.in_spk12_08 _05796_ network.in_spk13_08 VSS
+ VSS VDD VDD _05820_ sky130_fd_sc_hd__o21ai_0
X_17337_ _06578_ _05820_ net375 VSS VSS VDD VDD _02020_ sky130_fd_sc_hd__a21oi_1
X_17338_ network.neuron_in169.counter\[2\] network.neuron_in169.counter\[1\]
+ network.neuron_in169.counter\[0\] VSS VSS VDD VDD _05821_
+ sky130_fd_sc_hd__nor3_1
X_17339_ network.neuron_in169.counter\[3\] _05821_ VSS VSS
+ VDD VDD _05822_ sky130_fd_sc_hd__xnor2_1
X_17340_ network.in_period\[169\]\[3\] _07481_ VSS VSS VDD
+ VDD _05823_ sky130_fd_sc_hd__nand2_1
X_17341_ _07481_ _05822_ _05823_ VSS VSS VDD VDD _02743_ sky130_fd_sc_hd__o21ai_0
X_17342_ network.neuron_in170.counter\[2\] network.neuron_in170.counter\[1\]
+ network.neuron_in170.counter\[0\] VSS VSS VDD VDD _05824_
+ sky130_fd_sc_hd__nor3_1
X_17343_ network.neuron_in170.counter\[3\] _05824_ VSS VSS
+ VDD VDD _05825_ sky130_fd_sc_hd__xnor2_1
X_17344_ network.in_period\[170\]\[3\] _07485_ VSS VSS VDD
+ VDD _05826_ sky130_fd_sc_hd__nand2_1
X_17345_ _07485_ _05825_ _05826_ VSS VSS VDD VDD _02747_ sky130_fd_sc_hd__o21ai_0
X_17346_ network.neuron_in105.counter\[2\] _01077_ VSS VSS
+ VDD VDD _05827_ sky130_fd_sc_hd__xnor2_1
X_17347_ net392 _04679_ network.in_period\[105\]\[2\] VSS
+ VSS VDD VDD _05828_ sky130_fd_sc_hd__a21oi_1
X_17348_ net392 _05827_ _05828_ VSS VSS VDD VDD _02486_ sky130_fd_sc_hd__a21oi_1
X_17349_ network.in_spk12_08 _05796_ VSS VSS VDD VDD _05829_
+ sky130_fd_sc_hd__nand2_1
X_17350_ _06628_ _05829_ net375 VSS VSS VDD VDD _02021_ sky130_fd_sc_hd__a21oi_1
X_17351_ network.neuron_in171.counter\[1\] network.neuron_in171.counter\[0\]
+ _01025_ VSS VSS VDD VDD _05830_ sky130_fd_sc_hd__o21bai_1
X_17352_ _07454_ _05830_ network.neuron_in171.counter\[3\]
+ VSS VSS VDD VDD _05831_ sky130_fd_sc_hd__a21oi_1
X_17353_ _07454_ network.neuron_in171.counter\[3\] _01024_
+ _01023_ _05831_ VSS VSS VDD VDD _05832_ sky130_fd_sc_hd__a41o_1
X_17354_ net401 _07453_ network.in_period\[171\]\[3\] VSS
+ VSS VDD VDD _05833_ sky130_fd_sc_hd__a21oi_1
X_17355_ net401 _05832_ _05833_ VSS VSS VDD VDD _02751_ sky130_fd_sc_hd__a21oi_1
X_17356_ net389 _04670_ VSS VSS VDD VDD _05834_ sky130_fd_sc_hd__nand2_1
X_17357_ network.in_period\[108\]\[0\] _05834_ VSS VSS VDD
+ VDD _05835_ sky130_fd_sc_hd__nand2_1
X_17358_ network.neuron_in108.counter\[0\] _05834_ _05835_
+ VSS VSS VDD VDD _02496_ sky130_fd_sc_hd__o21ai_0
X_17359_ network.neuron_in172.counter\[1\] network.neuron_in172.counter\[0\]
+ _01035_ VSS VSS VDD VDD _05836_ sky130_fd_sc_hd__o21bai_1
X_17360_ _07488_ _05836_ network.neuron_in172.counter\[3\]
+ VSS VSS VDD VDD _05837_ sky130_fd_sc_hd__a21oi_1
X_17361_ _07488_ network.neuron_in172.counter\[3\] _01034_
+ _01033_ _05837_ VSS VSS VDD VDD _05838_ sky130_fd_sc_hd__a41o_1
X_17362_ net401 _07487_ network.in_period\[172\]\[3\] VSS
+ VSS VDD VDD _05839_ sky130_fd_sc_hd__a21oi_1
X_17363_ net401 _05838_ _05839_ VSS VSS VDD VDD _02755_ sky130_fd_sc_hd__a21oi_1
X_17364_ _08983_ _08987_ net295 VSS VSS VDD VDD _05840_ sky130_fd_sc_hd__nand3_1
X_17365_ network.in_spk08_08 network.in_spk09_08 network.in_spk10_08
+ _05840_ network.in_spk11_08 VSS VSS VDD VDD _05841_ sky130_fd_sc_hd__o41ai_1
X_17366_ _06685_ _05841_ net375 VSS VSS VDD VDD _02022_ sky130_fd_sc_hd__a21oi_1
X_17367_ network.neuron_in173.counter\[2\] network.neuron_in173.counter\[0\]
+ network.neuron_in173.counter\[1\] VSS VSS VDD VDD _05842_
+ sky130_fd_sc_hd__nor3_1
X_17368_ network.neuron_in173.counter\[3\] _05842_ VSS VSS
+ VDD VDD _05843_ sky130_fd_sc_hd__xnor2_1
X_17369_ network.in_period\[173\]\[3\] _07469_ VSS VSS VDD
+ VDD _05844_ sky130_fd_sc_hd__nand2_1
X_17370_ _07469_ _05843_ _05844_ VSS VSS VDD VDD _02759_ sky130_fd_sc_hd__o21ai_0
X_17371_ network.neuron_in174.counter\[2\] network.neuron_in174.counter\[0\]
+ network.neuron_in174.counter\[1\] VSS VSS VDD VDD _05845_
+ sky130_fd_sc_hd__nor3_1
X_17372_ network.neuron_in174.counter\[3\] _05845_ VSS VSS
+ VDD VDD _05846_ sky130_fd_sc_hd__xnor2_1
X_17373_ network.in_period\[174\]\[3\] _07496_ VSS VSS VDD
+ VDD _05847_ sky130_fd_sc_hd__nand2_1
X_17374_ _07496_ _05846_ _05847_ VSS VSS VDD VDD _02763_ sky130_fd_sc_hd__o21ai_0
X_17375_ network.neuron_in107.counter\[3\] network.in_period\[107\]\[2\]
+ net371 _01069_ VSS VSS VDD VDD _05848_ sky130_fd_sc_hd__o22ai_1
X_17376_ network.neuron_in107.counter\[2\] _01069_ net390
+ VSS VSS VDD VDD _05849_ sky130_fd_sc_hd__nand3_1
X_17377_ network.in_period\[107\]\[2\] net390 _05849_ VSS
+ VSS VDD VDD _05850_ sky130_fd_sc_hd__o21ai_0
X_17378_ _04673_ _05848_ _05850_ VSS VSS VDD VDD _02494_ sky130_fd_sc_hd__a21oi_1
X_17379_ network.in_spk08_08 network.in_spk09_08 _05840_ network.in_spk10_08
+ VSS VSS VDD VDD _05851_ sky130_fd_sc_hd__o31ai_1
X_17380_ _06925_ _05851_ net375 VSS VSS VDD VDD _02023_ sky130_fd_sc_hd__a21oi_1
X_17381_ network.neuron_in175.counter\[2\] network.neuron_in175.counter\[1\]
+ network.neuron_in175.counter\[0\] VSS VSS VDD VDD _05852_
+ sky130_fd_sc_hd__nor3_1
X_17382_ network.neuron_in175.counter\[3\] _05852_ VSS VSS
+ VDD VDD _05853_ sky130_fd_sc_hd__xnor2_1
X_17383_ network.in_period\[175\]\[3\] _07500_ VSS VSS VDD
+ VDD _05854_ sky130_fd_sc_hd__nand2_1
X_17384_ _07500_ _05853_ _05854_ VSS VSS VDD VDD _02767_ sky130_fd_sc_hd__o21ai_0
X_17385_ network.neuron_in176.counter\[1\] network.neuron_in176.counter\[0\]
+ _01061_ VSS VSS VDD VDD _05855_ sky130_fd_sc_hd__o21bai_1
X_17386_ _07449_ _05855_ network.neuron_in176.counter\[3\]
+ VSS VSS VDD VDD _05856_ sky130_fd_sc_hd__a21oi_1
X_17387_ _07449_ network.neuron_in176.counter\[3\] _01060_
+ _01059_ _05856_ VSS VSS VDD VDD _05857_ sky130_fd_sc_hd__a41o_1
X_17388_ net382 _07448_ network.in_period\[176\]\[3\] VSS
+ VSS VDD VDD _05858_ sky130_fd_sc_hd__a21oi_1
X_17389_ net407 _05857_ _05858_ VSS VSS VDD VDD _02771_ sky130_fd_sc_hd__a21oi_1
Xoutput29 net28 VSS VSS VDD VDD inference_cycles[10] sky130_fd_sc_hd__buf_1
X_17391_ net385 _04684_ VSS VSS VDD VDD _05860_ sky130_fd_sc_hd__nand2_1
X_17392_ network.in_period\[103\]\[1\] _05860_ VSS VSS VDD
+ VDD _05861_ sky130_fd_sc_hd__nand2_1
X_17393_ _00905_ _05860_ _05861_ VSS VSS VDD VDD _02477_ sky130_fd_sc_hd__o21ai_0
X_17394_ network.in_spk08_08 _05840_ network.in_spk09_08 VSS
+ VSS VDD VDD _05862_ sky130_fd_sc_hd__o21ai_0
X_17395_ _06928_ _05862_ net375 VSS VSS VDD VDD _02024_ sky130_fd_sc_hd__a21oi_1
X_17396_ network.neuron_in177.counter\[1\] network.neuron_in177.counter\[0\]
+ VSS VSS VDD VDD _05863_ sky130_fd_sc_hd__nor2_1
X_17397_ _00812_ _05863_ VSS VSS VDD VDD _05864_ sky130_fd_sc_hd__nor2_1
X_17398_ network.neuron_in177.counter\[2\] _05864_ VSS VSS
+ VDD VDD _05865_ sky130_fd_sc_hd__nor2_1
X_17399_ network.neuron_in177.counter\[2\] network.neuron_in177.counter\[3\]
+ _05863_ VSS VSS VDD VDD _05866_ sky130_fd_sc_hd__nand3b_1
X_17400_ network.neuron_in177.counter\[3\] _05865_ _05866_
+ VSS VSS VDD VDD _05867_ sky130_fd_sc_hd__o21ai_0
X_17401_ net394 _06893_ network.in_period\[177\]\[3\] VSS
+ VSS VDD VDD _05868_ sky130_fd_sc_hd__a21oi_1
X_17402_ net394 _05867_ _05868_ VSS VSS VDD VDD _02775_ sky130_fd_sc_hd__a21oi_1
X_17403_ network.neuron_in178.counter\[2\] network.neuron_in178.counter\[1\]
+ network.neuron_in178.counter\[0\] VSS VSS VDD VDD _05869_
+ sky130_fd_sc_hd__nor3_1
X_17404_ network.neuron_in178.counter\[3\] _05869_ VSS VSS
+ VDD VDD _05870_ sky130_fd_sc_hd__xnor2_1
X_17405_ network.in_period\[178\]\[3\] _06510_ VSS VSS VDD
+ VDD _05871_ sky130_fd_sc_hd__nand2_1
X_17406_ _06510_ _05870_ _05871_ VSS VSS VDD VDD _02779_ sky130_fd_sc_hd__o21ai_0
X_17407_ network.in_spk08_08 _05840_ VSS VSS VDD VDD _05872_
+ sky130_fd_sc_hd__nand2_1
X_17408_ _06940_ _05872_ net375 VSS VSS VDD VDD _02025_ sky130_fd_sc_hd__a21oi_1
X_17409_ network.neuron_in179.counter\[1\] network.neuron_in179.counter\[0\]
+ _00816_ VSS VSS VDD VDD _05873_ sky130_fd_sc_hd__o21bai_1
X_17410_ _06478_ _05873_ network.neuron_in179.counter\[3\]
+ VSS VSS VDD VDD _05874_ sky130_fd_sc_hd__a21oi_1
X_17411_ _06478_ network.neuron_in179.counter\[3\] _00815_
+ _00814_ _05874_ VSS VSS VDD VDD _05875_ sky130_fd_sc_hd__a41o_1
X_17412_ net394 _06515_ network.in_period\[179\]\[3\] VSS
+ VSS VDD VDD _05876_ sky130_fd_sc_hd__a21oi_1
X_17413_ net394 _05875_ _05876_ VSS VSS VDD VDD _02783_ sky130_fd_sc_hd__a21oi_1
X_17414_ network.neuron_in180.counter\[0\] network.neuron_in180.counter\[1\]
+ VSS VSS VDD VDD _05877_ sky130_fd_sc_hd__nor2_1
X_17415_ _00625_ _05877_ VSS VSS VDD VDD _05878_ sky130_fd_sc_hd__nor2_1
X_17416_ network.neuron_in180.counter\[2\] _05878_ VSS VSS
+ VDD VDD _05879_ sky130_fd_sc_hd__nor2_1
X_17417_ network.neuron_in180.counter\[2\] network.neuron_in180.counter\[3\]
+ _05877_ VSS VSS VDD VDD _05880_ sky130_fd_sc_hd__nand3b_1
X_17418_ network.neuron_in180.counter\[3\] _05879_ _05880_
+ VSS VSS VDD VDD _05881_ sky130_fd_sc_hd__o21ai_0
Xoutput28 net27 VSS VSS VDD VDD inference_cycles[0] sky130_fd_sc_hd__buf_1
X_17420_ net382 _06457_ network.in_period\[180\]\[3\] VSS
+ VSS VDD VDD _05883_ sky130_fd_sc_hd__a21oi_1
X_17421_ net382 _05881_ _05883_ VSS VSS VDD VDD _02787_ sky130_fd_sc_hd__a21oi_1
X_17422_ net390 _04677_ VSS VSS VDD VDD _05884_ sky130_fd_sc_hd__nand2_1
X_17423_ network.in_period\[106\]\[0\] _05884_ VSS VSS VDD
+ VDD _05885_ sky130_fd_sc_hd__nand2_1
X_17424_ network.neuron_in106.counter\[0\] _05884_ _05885_
+ VSS VSS VDD VDD _02488_ sky130_fd_sc_hd__o21ai_0
X_17425_ _08986_ _08940_ network.in_spk07_08 VSS VSS VDD VDD
+ _05886_ sky130_fd_sc_hd__o21ai_0
Xoutput27 net26 VSS VSS VDD VDD done sky130_fd_sc_hd__buf_1
X_17427_ _06745_ _05886_ net375 VSS VSS VDD VDD _02026_ sky130_fd_sc_hd__a21oi_1
X_17428_ network.neuron_in181.counter\[2\] network.neuron_in181.counter\[0\]
+ network.neuron_in181.counter\[1\] VSS VSS VDD VDD _05888_
+ sky130_fd_sc_hd__nor3_1
X_17429_ network.neuron_in181.counter\[3\] _05888_ VSS VSS
+ VDD VDD _05889_ sky130_fd_sc_hd__xnor2_1
X_17430_ network.in_period\[181\]\[3\] _06493_ VSS VSS VDD
+ VDD _05890_ sky130_fd_sc_hd__nand2_1
X_17431_ _06493_ _05889_ _05890_ VSS VSS VDD VDD _02791_ sky130_fd_sc_hd__o21ai_0
X_17432_ network.neuron_in182.counter\[2\] network.neuron_in182.counter\[1\]
+ network.neuron_in182.counter\[0\] VSS VSS VDD VDD _05891_
+ sky130_fd_sc_hd__nor3_1
X_17433_ network.neuron_in182.counter\[3\] _05891_ VSS VSS
+ VDD VDD _05892_ sky130_fd_sc_hd__xnor2_1
X_17434_ network.in_period\[182\]\[3\] _06463_ VSS VSS VDD
+ VDD _05893_ sky130_fd_sc_hd__nand2_1
X_17435_ _06463_ _05892_ _05893_ VSS VSS VDD VDD _02795_ sky130_fd_sc_hd__o21ai_0
X_17436_ _08896_ _05795_ VSS VSS VDD VDD _05894_ sky130_fd_sc_hd__nand2_1
X_17437_ network.in_spk04_08 network.in_spk05_08 _05894_ network.in_spk06_08
+ VSS VSS VDD VDD _05895_ sky130_fd_sc_hd__o31ai_1
X_17438_ _06825_ _05895_ net375 VSS VSS VDD VDD _02027_ sky130_fd_sc_hd__a21oi_1
X_17439_ network.neuron_in183.counter\[2\] network.neuron_in183.counter\[1\]
+ network.neuron_in183.counter\[0\] VSS VSS VDD VDD _05896_
+ sky130_fd_sc_hd__nor3_1
X_17440_ network.neuron_in183.counter\[3\] _05896_ VSS VSS
+ VDD VDD _05897_ sky130_fd_sc_hd__xnor2_1
X_17441_ network.in_period\[183\]\[3\] _06530_ VSS VSS VDD
+ VDD _05898_ sky130_fd_sc_hd__nand2_1
X_17442_ _06530_ _05897_ _05898_ VSS VSS VDD VDD _02799_ sky130_fd_sc_hd__o21ai_0
X_17443_ network.in_period\[103\]\[0\] _05860_ VSS VSS VDD
+ VDD _05899_ sky130_fd_sc_hd__nand2_1
X_17444_ network.neuron_in103.counter\[0\] _05860_ _05899_
+ VSS VSS VDD VDD _02476_ sky130_fd_sc_hd__o21ai_0
X_17445_ network.neuron_in184.counter\[1\] network.neuron_in184.counter\[0\]
+ VSS VSS VDD VDD _05900_ sky130_fd_sc_hd__nor2_1
X_17446_ _01113_ _05900_ VSS VSS VDD VDD _05901_ sky130_fd_sc_hd__nor2_1
X_17447_ network.neuron_in184.counter\[2\] _05901_ VSS VSS
+ VDD VDD _05902_ sky130_fd_sc_hd__nor2_1
X_17448_ network.neuron_in184.counter\[2\] network.neuron_in184.counter\[3\]
+ _05900_ VSS VSS VDD VDD _05903_ sky130_fd_sc_hd__nand3b_1
X_17449_ network.neuron_in184.counter\[3\] _05902_ _05903_
+ VSS VSS VDD VDD _05904_ sky130_fd_sc_hd__o21ai_0
X_17450_ net382 _06533_ network.in_period\[184\]\[3\] VSS
+ VSS VDD VDD _05905_ sky130_fd_sc_hd__a21oi_1
X_17451_ net382 _05904_ _05905_ VSS VSS VDD VDD _02803_ sky130_fd_sc_hd__a21oi_1
X_17452_ network.in_period\[102\]\[0\] _05691_ VSS VSS VDD
+ VDD _05906_ sky130_fd_sc_hd__nand2_1
X_17453_ network.neuron_in102.counter\[0\] _05691_ _05906_
+ VSS VSS VDD VDD _02472_ sky130_fd_sc_hd__o21ai_0
X_17454_ network.in_spk04_08 _05894_ network.in_spk05_08 VSS
+ VSS VDD VDD _05907_ sky130_fd_sc_hd__o21ai_0
X_17455_ _08214_ _05907_ net375 VSS VSS VDD VDD _02028_ sky130_fd_sc_hd__a21oi_1
X_17456_ network.neuron_in185.counter\[2\] network.neuron_in185.counter\[0\]
+ network.neuron_in185.counter\[1\] VSS VSS VDD VDD _05908_
+ sky130_fd_sc_hd__nor3_1
X_17457_ network.neuron_in185.counter\[3\] _05908_ VSS VSS
+ VDD VDD _05909_ sky130_fd_sc_hd__xnor2_1
X_17458_ network.in_period\[185\]\[3\] _06475_ VSS VSS VDD
+ VDD _05910_ sky130_fd_sc_hd__nand2_1
X_17459_ _06475_ _05909_ _05910_ VSS VSS VDD VDD _02807_ sky130_fd_sc_hd__o21ai_0
X_17460_ network.neuron_in103.counter\[3\] network.in_period\[103\]\[2\]
+ net372 _00904_ VSS VSS VDD VDD _05911_ sky130_fd_sc_hd__o22ai_1
X_17461_ network.neuron_in103.counter\[2\] _00904_ net385
+ VSS VSS VDD VDD _05912_ sky130_fd_sc_hd__nand3_1
X_17462_ network.in_period\[103\]\[2\] net385 _05912_ VSS
+ VSS VDD VDD _05913_ sky130_fd_sc_hd__o21ai_0
X_17463_ _05443_ _05911_ _05913_ VSS VSS VDD VDD _02478_ sky130_fd_sc_hd__a21oi_1
X_17464_ network.neuron_in186.counter\[2\] network.neuron_in186.counter\[0\]
+ network.neuron_in186.counter\[1\] VSS VSS VDD VDD _05914_
+ sky130_fd_sc_hd__nor3_1
X_17465_ network.neuron_in186.counter\[3\] _05914_ VSS VSS
+ VDD VDD _05915_ sky130_fd_sc_hd__xnor2_1
X_17466_ network.in_period\[186\]\[3\] _06504_ VSS VSS VDD
+ VDD _05916_ sky130_fd_sc_hd__nand2_1
X_17467_ _06504_ _05915_ _05916_ VSS VSS VDD VDD _02811_ sky130_fd_sc_hd__o21ai_0
X_17468_ network.in_spk04_08 _05894_ VSS VSS VDD VDD _05917_
+ sky130_fd_sc_hd__nand2_1
X_17469_ _08044_ _05917_ net375 VSS VSS VDD VDD _02029_ sky130_fd_sc_hd__a21oi_1
X_17470_ network.neuron_in187.counter\[1\] network.neuron_in187.counter\[0\]
+ VSS VSS VDD VDD _05918_ sky130_fd_sc_hd__nor2_1
X_17471_ _00210_ _05918_ VSS VSS VDD VDD _05919_ sky130_fd_sc_hd__nor2_1
X_17472_ network.neuron_in187.counter\[2\] _05919_ VSS VSS
+ VDD VDD _05920_ sky130_fd_sc_hd__nor2_1
X_17473_ network.neuron_in187.counter\[2\] network.neuron_in187.counter\[3\]
+ _05918_ VSS VSS VDD VDD _05921_ sky130_fd_sc_hd__nand3b_1
X_17474_ network.neuron_in187.counter\[3\] _05920_ _05921_
+ VSS VSS VDD VDD _05922_ sky130_fd_sc_hd__o21ai_0
X_17475_ net382 _06453_ network.in_period\[187\]\[3\] VSS
+ VSS VDD VDD _05923_ sky130_fd_sc_hd__a21oi_1
X_17476_ net382 _05922_ _05923_ VSS VSS VDD VDD _02815_ sky130_fd_sc_hd__a21oi_1
X_17477_ network.neuron_in104.counter\[3\] network.in_period\[104\]\[2\]
+ net375 _00680_ VSS VSS VDD VDD _05924_ sky130_fd_sc_hd__o22ai_1
X_17478_ network.neuron_in104.counter\[2\] _00680_ net392
+ VSS VSS VDD VDD _05925_ sky130_fd_sc_hd__nand3_1
X_17479_ network.in_period\[104\]\[2\] net392 _05925_ VSS
+ VSS VDD VDD _05926_ sky130_fd_sc_hd__o21ai_0
X_17480_ _04681_ _05924_ _05926_ VSS VSS VDD VDD _02482_ sky130_fd_sc_hd__a21oi_1
Xoutput26 net25 VSS VSS VDD VDD busy sky130_fd_sc_hd__buf_1
X_17482_ network.neuron_in188.counter\[0\] network.neuron_in188.counter\[1\]
+ VSS VSS VDD VDD _05928_ sky130_fd_sc_hd__nor2_1
X_17483_ _00238_ _05928_ VSS VSS VDD VDD _05929_ sky130_fd_sc_hd__nor2_1
X_17484_ network.neuron_in188.counter\[2\] _05929_ VSS VSS
+ VDD VDD _05930_ sky130_fd_sc_hd__nor2_1
X_17485_ network.neuron_in188.counter\[2\] network.neuron_in188.counter\[3\]
+ _05928_ VSS VSS VDD VDD _05931_ sky130_fd_sc_hd__nand3b_1
X_17486_ network.neuron_in188.counter\[3\] _05930_ _05931_
+ VSS VSS VDD VDD _05932_ sky130_fd_sc_hd__o21ai_0
X_17487_ net382 _06615_ network.in_period\[188\]\[3\] VSS
+ VSS VDD VDD _05933_ sky130_fd_sc_hd__a21oi_1
X_17488_ net382 _05932_ _05933_ VSS VSS VDD VDD _02819_ sky130_fd_sc_hd__a21oi_1
X_17489_ net392 _04682_ VSS VSS VDD VDD _05934_ sky130_fd_sc_hd__nand2_1
X_17490_ network.in_period\[104\]\[1\] _05934_ VSS VSS VDD
+ VDD _05935_ sky130_fd_sc_hd__nand2_1
X_17491_ _00681_ _05934_ _05935_ VSS VSS VDD VDD _02481_ sky130_fd_sc_hd__o21ai_0
X_17492_ network.in_spk00_08 _08898_ _08940_ VSS VSS VDD VDD
+ _05936_ sky130_fd_sc_hd__or3_1
X_17493_ network.in_spk01_08 network.in_spk02_08 _05936_ network.in_spk03_08
+ VSS VSS VDD VDD _05937_ sky130_fd_sc_hd__o31ai_1
X_17494_ _03783_ _05937_ net375 VSS VSS VDD VDD _02030_ sky130_fd_sc_hd__a21oi_1
X_17495_ network.neuron_in189.counter\[2\] network.neuron_in189.counter\[0\]
+ network.neuron_in189.counter\[1\] VSS VSS VDD VDD _05938_
+ sky130_fd_sc_hd__nor3_1
X_17496_ network.neuron_in189.counter\[3\] _05938_ VSS VSS
+ VDD VDD _05939_ sky130_fd_sc_hd__xnor2_1
X_17497_ network.in_period\[189\]\[3\] _06622_ VSS VSS VDD
+ VDD _05940_ sky130_fd_sc_hd__nand2_1
X_17498_ _06622_ _05939_ _05940_ VSS VSS VDD VDD _02823_ sky130_fd_sc_hd__o21ai_0
X_17499_ network.in_period\[104\]\[0\] _05934_ VSS VSS VDD
+ VDD _05941_ sky130_fd_sc_hd__nand2_1
X_17500_ network.neuron_in104.counter\[0\] _05934_ _05941_
+ VSS VSS VDD VDD _02480_ sky130_fd_sc_hd__o21ai_0
X_17501_ network.neuron_in190.counter\[1\] network.neuron_in190.counter\[0\]
+ _00976_ VSS VSS VDD VDD _05942_ sky130_fd_sc_hd__o21bai_1
X_17502_ _06562_ _05942_ network.neuron_in190.counter\[3\]
+ VSS VSS VDD VDD _05943_ sky130_fd_sc_hd__a21oi_1
X_17503_ _06562_ network.neuron_in190.counter\[3\] _00975_
+ _00974_ _05943_ VSS VSS VDD VDD _05944_ sky130_fd_sc_hd__a41o_1
X_17504_ net382 _06561_ network.in_period\[190\]\[3\] VSS
+ VSS VDD VDD _05945_ sky130_fd_sc_hd__a21oi_1
X_17505_ net382 _05944_ _05945_ VSS VSS VDD VDD _02827_ sky130_fd_sc_hd__a21oi_1
X_17506_ network.in_period\[105\]\[1\] _05456_ VSS VSS VDD
+ VDD _05946_ sky130_fd_sc_hd__nand2_1
X_17507_ _01078_ _05456_ _05946_ VSS VSS VDD VDD _02485_ sky130_fd_sc_hd__o21ai_0
X_17508_ network.in_spk01_08 _05936_ network.in_spk02_08 VSS
+ VSS VDD VDD _05947_ sky130_fd_sc_hd__o21ai_0
X_17509_ _04361_ _05947_ net375 VSS VSS VDD VDD _02031_ sky130_fd_sc_hd__a21oi_1
X_17510_ network.neuron_in191.counter\[0\] network.neuron_in191.counter\[1\]
+ _01177_ VSS VSS VDD VDD _05948_ sky130_fd_sc_hd__o21bai_1
X_17511_ _06593_ _05948_ network.neuron_in191.counter\[3\]
+ VSS VSS VDD VDD _05949_ sky130_fd_sc_hd__a21oi_1
X_17512_ _06593_ network.neuron_in191.counter\[3\] _01175_
+ _01176_ _05949_ VSS VSS VDD VDD _05950_ sky130_fd_sc_hd__a41o_1
X_17513_ net382 _06592_ network.in_period\[191\]\[3\] VSS
+ VSS VDD VDD _05951_ sky130_fd_sc_hd__a21oi_1
X_17514_ net382 _05950_ _05951_ VSS VSS VDD VDD _02831_ sky130_fd_sc_hd__a21oi_1
X_17515_ network.in_period\[105\]\[0\] _05456_ VSS VSS VDD
+ VDD _05952_ sky130_fd_sc_hd__nand2_1
X_17516_ network.neuron_in105.counter\[0\] _05456_ _05952_
+ VSS VSS VDD VDD _02484_ sky130_fd_sc_hd__o21ai_0
X_17517_ network.neuron_in192.counter\[1\] network.neuron_in192.counter\[0\]
+ _00749_ VSS VSS VDD VDD _05953_ sky130_fd_sc_hd__o21bai_1
X_17518_ _06567_ _05953_ network.neuron_in192.counter\[3\]
+ VSS VSS VDD VDD _05954_ sky130_fd_sc_hd__a21oi_1
X_17519_ _06567_ network.neuron_in192.counter\[3\] _00748_
+ _00747_ _05954_ VSS VSS VDD VDD _05955_ sky130_fd_sc_hd__a41o_1
X_17520_ net405 _06566_ network.in_period\[192\]\[3\] VSS
+ VSS VDD VDD _05956_ sky130_fd_sc_hd__a21oi_1
X_17521_ net405 _05955_ _05956_ VSS VSS VDD VDD _02835_ sky130_fd_sc_hd__a21oi_1
X_17522_ network.neuron_in106.counter\[3\] network.in_period\[106\]\[2\]
+ net372 _00672_ VSS VSS VDD VDD _05957_ sky130_fd_sc_hd__o22ai_1
X_17523_ network.neuron_in106.counter\[2\] _00672_ net390
+ VSS VSS VDD VDD _05958_ sky130_fd_sc_hd__nand3_1
X_17524_ network.in_period\[106\]\[2\] net390 _05958_ VSS
+ VSS VDD VDD _05959_ sky130_fd_sc_hd__o21ai_0
X_17525_ _04676_ _05957_ _05959_ VSS VSS VDD VDD _02490_ sky130_fd_sc_hd__a21oi_1
X_17526_ network.in_spk01_08 _05936_ VSS VSS VDD VDD _05960_
+ sky130_fd_sc_hd__nand2_1
X_17527_ _03604_ _05960_ net375 VSS VSS VDD VDD _02032_ sky130_fd_sc_hd__a21oi_1
X_17528_ network.neuron_in193.counter\[0\] network.neuron_in193.counter\[2\]
+ network.neuron_in193.counter\[1\] VSS VSS VDD VDD _05961_
+ sky130_fd_sc_hd__or3_1
X_17529_ net368 _06553_ _05961_ VSS VSS VDD VDD _05962_ sky130_fd_sc_hd__nor3_1
X_17530_ network.in_period\[193\]\[3\] _06553_ _05962_ VSS
+ VSS VDD VDD _05963_ sky130_fd_sc_hd__a21oi_1
X_17531_ network.in_period\[193\]\[3\] net368 VSS VSS VDD
+ VDD _05964_ sky130_fd_sc_hd__and2_1
X_17532_ network.neuron_in193.counter\[3\] net405 _05961_
+ _05964_ VSS VSS VDD VDD _05965_ sky130_fd_sc_hd__a31oi_1
X_17533_ network.neuron_in193.counter\[3\] _05963_ _05965_
+ VSS VSS VDD VDD _02839_ sky130_fd_sc_hd__o21ai_0
X_17534_ network.in_period\[106\]\[1\] _05884_ VSS VSS VDD
+ VDD _05966_ sky130_fd_sc_hd__nand2_1
X_17535_ _00673_ _05884_ _05966_ VSS VSS VDD VDD _02489_ sky130_fd_sc_hd__o21ai_0
X_17536_ network.neuron_in194.counter\[2\] network.neuron_in194.counter\[0\]
+ network.neuron_in194.counter\[1\] VSS VSS VDD VDD _05967_
+ sky130_fd_sc_hd__nor3_1
X_17537_ network.neuron_in194.counter\[3\] _05967_ VSS VSS
+ VDD VDD _05968_ sky130_fd_sc_hd__xnor2_1
X_17538_ network.in_period\[194\]\[3\] _06643_ VSS VSS VDD
+ VDD _05969_ sky130_fd_sc_hd__nand2_1
X_17539_ _06643_ _05968_ _05969_ VSS VSS VDD VDD _02843_ sky130_fd_sc_hd__o21ai_0
X_17540_ net390 _04674_ VSS VSS VDD VDD _05970_ sky130_fd_sc_hd__nand2_1
X_17541_ network.in_period\[107\]\[1\] _05970_ VSS VSS VDD
+ VDD _05971_ sky130_fd_sc_hd__nand2_1
X_17542_ _01070_ _05970_ _05971_ VSS VSS VDD VDD _02493_ sky130_fd_sc_hd__o21ai_0
X_17543_ network.in_spk00_08 _08940_ VSS VSS VDD VDD _05972_
+ sky130_fd_sc_hd__nand2_1
X_17544_ _08266_ _05972_ net375 VSS VSS VDD VDD _02033_ sky130_fd_sc_hd__a21oi_1
X_17545_ network.neuron_in195.counter\[1\] network.neuron_in195.counter\[0\]
+ _00828_ VSS VSS VDD VDD _05973_ sky130_fd_sc_hd__o21bai_1
X_17546_ _06572_ _05973_ network.neuron_in195.counter\[3\]
+ VSS VSS VDD VDD _05974_ sky130_fd_sc_hd__a21oi_1
X_17547_ _06572_ network.neuron_in195.counter\[3\] _00827_
+ _00826_ _05974_ VSS VSS VDD VDD _05975_ sky130_fd_sc_hd__a41o_1
X_17548_ net406 _06571_ network.in_period\[195\]\[3\] VSS
+ VSS VDD VDD _05976_ sky130_fd_sc_hd__a21oi_1
X_17549_ net406 _05975_ _05976_ VSS VSS VDD VDD _02847_ sky130_fd_sc_hd__a21oi_1
X_17550_ network.in_period\[107\]\[0\] _05970_ VSS VSS VDD
+ VDD _05977_ sky130_fd_sc_hd__nand2_1
X_17551_ network.neuron_in107.counter\[0\] _05970_ _05977_
+ VSS VSS VDD VDD _02492_ sky130_fd_sc_hd__o21ai_0
X_17552_ network.neuron_in196.counter\[0\] network.neuron_in196.counter\[1\]
+ _01181_ VSS VSS VDD VDD _05978_ sky130_fd_sc_hd__o21bai_1
X_17553_ _06607_ _05978_ network.neuron_in196.counter\[3\]
+ VSS VSS VDD VDD _05979_ sky130_fd_sc_hd__a21oi_1
X_17554_ _06607_ network.neuron_in196.counter\[3\] _01179_
+ _01180_ _05979_ VSS VSS VDD VDD _05980_ sky130_fd_sc_hd__a41o_1
X_17555_ net404 _06648_ network.in_period\[196\]\[3\] VSS
+ VSS VDD VDD _05981_ sky130_fd_sc_hd__a21oi_1
X_17556_ net404 _05980_ _05981_ VSS VSS VDD VDD _02851_ sky130_fd_sc_hd__a21oi_1
X_17557_ network.neuron_in108.counter\[3\] network.in_period\[108\]\[2\]
+ net373 _00684_ VSS VSS VDD VDD _05982_ sky130_fd_sc_hd__o22ai_1
X_17558_ network.neuron_in108.counter\[2\] _00684_ net389
+ VSS VSS VDD VDD _05983_ sky130_fd_sc_hd__nand3_1
X_17559_ network.in_period\[108\]\[2\] net389 _05983_ VSS
+ VSS VDD VDD _05984_ sky130_fd_sc_hd__o21ai_0
X_17560_ _04669_ _05982_ _05984_ VSS VSS VDD VDD _02498_ sky130_fd_sc_hd__a21oi_1
X_17561_ network.neuron_in127.counter\[1\] VSS VSS VDD VDD
+ _01152_ sky130_fd_sc_hd__inv_1
X_17562_ _09176_ _08916_ _08997_ VSS VSS VDD VDD _05985_ sky130_fd_sc_hd__nand3_1
X_17563_ network.in_spk14_07 _05985_ network.in_spk15_07 VSS
+ VSS VDD VDD _05986_ sky130_fd_sc_hd__o21ai_0
X_17564_ _08080_ _05986_ net374 VSS VSS VDD VDD _02034_ sky130_fd_sc_hd__a21oi_1
X_17565_ network.neuron_in197.counter\[0\] network.neuron_in197.counter\[1\]
+ VSS VSS VDD VDD _05987_ sky130_fd_sc_hd__nor2_1
X_17566_ _00824_ _05987_ VSS VSS VDD VDD _05988_ sky130_fd_sc_hd__nor2_1
X_17567_ network.neuron_in197.counter\[2\] _05988_ VSS VSS
+ VDD VDD _05989_ sky130_fd_sc_hd__nor2_1
X_17568_ network.neuron_in197.counter\[2\] network.neuron_in197.counter\[3\]
+ _05987_ VSS VSS VDD VDD _05990_ sky130_fd_sc_hd__nand3b_1
X_17569_ network.neuron_in197.counter\[3\] _05989_ _05990_
+ VSS VSS VDD VDD _05991_ sky130_fd_sc_hd__o21ai_0
X_17570_ net404 _06557_ network.in_period\[197\]\[3\] VSS
+ VSS VDD VDD _05992_ sky130_fd_sc_hd__a21oi_1
X_17571_ net404 _05991_ _05992_ VSS VSS VDD VDD _02855_ sky130_fd_sc_hd__a21oi_1
X_17572_ network.in_period\[108\]\[1\] _05834_ VSS VSS VDD
+ VDD _05993_ sky130_fd_sc_hd__nand2_1
X_17573_ _00685_ _05834_ _05993_ VSS VSS VDD VDD _02497_ sky130_fd_sc_hd__o21ai_0
X_17574_ network.neuron_in198.counter\[2\] network.neuron_in198.counter\[1\]
+ network.neuron_in198.counter\[0\] VSS VSS VDD VDD _05994_
+ sky130_fd_sc_hd__nor3_1
X_17575_ network.neuron_in198.counter\[3\] _05994_ VSS VSS
+ VDD VDD _05995_ sky130_fd_sc_hd__xnor2_1
X_17576_ network.in_period\[198\]\[3\] _06737_ VSS VSS VDD
+ VDD _05996_ sky130_fd_sc_hd__nand2_1
X_17577_ _06737_ _05995_ _05996_ VSS VSS VDD VDD _02859_ sky130_fd_sc_hd__o21ai_0
X_17578_ network.in_spk14_07 _05985_ VSS VSS VDD VDD _05997_
+ sky130_fd_sc_hd__nand2_1
X_17579_ _06752_ _05997_ net374 VSS VSS VDD VDD _02035_ sky130_fd_sc_hd__a21oi_1
X_17580_ network.neuron_in199.counter\[2\] network.neuron_in199.counter\[1\]
+ network.neuron_in199.counter\[0\] VSS VSS VDD VDD _05998_
+ sky130_fd_sc_hd__nor3_1
X_17581_ network.neuron_in199.counter\[3\] _05998_ VSS VSS
+ VDD VDD _05999_ sky130_fd_sc_hd__xnor2_1
X_17582_ network.in_period\[199\]\[3\] _06742_ VSS VSS VDD
+ VDD _06000_ sky130_fd_sc_hd__nand2_1
X_17583_ _06742_ _05999_ _06000_ VSS VSS VDD VDD _02863_ sky130_fd_sc_hd__o21ai_0
X_17584_ _00526_ _06710_ _00525_ VSS VSS VDD VDD _06001_ sky130_fd_sc_hd__nand3_1
X_17585_ net369 _06674_ _06001_ VSS VSS VDD VDD _06002_ sky130_fd_sc_hd__nor3_1
X_17586_ network.in_period\[200\]\[3\] _06674_ _06002_ VSS
+ VSS VDD VDD _06003_ sky130_fd_sc_hd__a21oi_1
X_17587_ network.in_period\[200\]\[3\] net369 VSS VSS VDD
+ VDD _06004_ sky130_fd_sc_hd__and2_1
X_17588_ network.neuron_in200.counter\[3\] net404 _06001_
+ _06004_ VSS VSS VDD VDD _06005_ sky130_fd_sc_hd__a31oi_1
X_17589_ network.neuron_in200.counter\[3\] _06003_ _06005_
+ VSS VSS VDD VDD _02867_ sky130_fd_sc_hd__o21ai_0
X_17590_ _08916_ _08997_ VSS VSS VDD VDD _06006_ sky130_fd_sc_hd__nand2_1
X_17591_ network.in_spk12_07 _06006_ network.in_spk13_07 VSS
+ VSS VDD VDD _06007_ sky130_fd_sc_hd__o21ai_0
Xinput25 net460 VSS VSS VDD VDD net24 sky130_fd_sc_hd__buf_1
X_17593_ _07265_ _06007_ net374 VSS VSS VDD VDD _02036_ sky130_fd_sc_hd__a21oi_1
X_17594_ network.neuron_in201.counter\[2\] network.neuron_in201.counter\[0\]
+ network.neuron_in201.counter\[1\] VSS VSS VDD VDD _06009_
+ sky130_fd_sc_hd__nor3_1
X_17595_ network.neuron_in201.counter\[3\] _06009_ VSS VSS
+ VDD VDD _06010_ sky130_fd_sc_hd__xnor2_1
X_17596_ network.in_period\[201\]\[3\] _06716_ VSS VSS VDD
+ VDD _06011_ sky130_fd_sc_hd__nand2_1
X_17597_ _06716_ _06010_ _06011_ VSS VSS VDD VDD _02871_ sky130_fd_sc_hd__o21ai_0
X_17598_ network.neuron_in202.counter\[1\] network.neuron_in202.counter\[0\]
+ network.neuron_in202.counter\[2\] VSS VSS VDD VDD _06012_
+ sky130_fd_sc_hd__nor3_1
X_17599_ network.neuron_in202.counter\[3\] _06012_ VSS VSS
+ VDD VDD _06013_ sky130_fd_sc_hd__xnor2_1
X_17600_ network.in_period\[202\]\[3\] _06681_ VSS VSS VDD
+ VDD _06014_ sky130_fd_sc_hd__nand2_1
X_17601_ _06681_ _06013_ _06014_ VSS VSS VDD VDD _02875_ sky130_fd_sc_hd__o21ai_0
X_17602_ network.in_period\[109\]\[1\] _05481_ VSS VSS VDD
+ VDD _06015_ sky130_fd_sc_hd__nand2_1
X_17603_ _01009_ _05481_ _06015_ VSS VSS VDD VDD _02501_ sky130_fd_sc_hd__o21ai_0
X_17604_ network.in_spk12_07 _06006_ VSS VSS VDD VDD _06016_
+ sky130_fd_sc_hd__nand2_1
X_17605_ _03715_ _06016_ net374 VSS VSS VDD VDD _02037_ sky130_fd_sc_hd__a21oi_1
X_17606_ network.neuron_in203.counter\[1\] network.neuron_in203.counter\[0\]
+ _01051_ VSS VSS VDD VDD _06017_ sky130_fd_sc_hd__o21bai_1
X_17607_ _06659_ _06017_ network.neuron_in203.counter\[3\]
+ VSS VSS VDD VDD _06018_ sky130_fd_sc_hd__a21oi_1
X_17608_ _06659_ network.neuron_in203.counter\[3\] _01050_
+ _01049_ _06018_ VSS VSS VDD VDD _06019_ sky130_fd_sc_hd__a41o_1
Xinput24 net459 VSS VSS VDD VDD net23 sky130_fd_sc_hd__buf_1
X_17610_ net403 _06760_ network.in_period\[203\]\[3\] VSS
+ VSS VDD VDD _06021_ sky130_fd_sc_hd__a21oi_1
X_17611_ net403 _06019_ _06021_ VSS VSS VDD VDD _02879_ sky130_fd_sc_hd__a21oi_1
X_17612_ network.neuron_in111.counter\[3\] network.in_period\[111\]\[2\]
+ net373 _00569_ VSS VSS VDD VDD _06022_ sky130_fd_sc_hd__o22ai_1
Xinput23 load_valid VSS VSS VDD VDD net22 sky130_fd_sc_hd__buf_1
X_17614_ network.neuron_in111.counter\[2\] _00569_ net390
+ VSS VSS VDD VDD _06024_ sky130_fd_sc_hd__nand3_1
X_17615_ network.in_period\[111\]\[2\] net390 _06024_ VSS
+ VSS VDD VDD _06025_ sky130_fd_sc_hd__o21ai_0
X_17616_ _05492_ _06022_ _06025_ VSS VSS VDD VDD _02510_ sky130_fd_sc_hd__a21oi_1
X_17617_ network.neuron_in204.counter\[1\] network.neuron_in204.counter\[0\]
+ _00214_ VSS VSS VDD VDD _06026_ sky130_fd_sc_hd__o21bai_1
X_17618_ _06719_ _06026_ network.neuron_in204.counter\[3\]
+ VSS VSS VDD VDD _06027_ sky130_fd_sc_hd__a21oi_1
X_17619_ _06719_ _00213_ network.neuron_in204.counter\[3\]
+ _00212_ _06027_ VSS VSS VDD VDD _06028_ sky130_fd_sc_hd__a41o_1
X_17620_ net403 _06765_ network.in_period\[204\]\[3\] VSS
+ VSS VDD VDD _06029_ sky130_fd_sc_hd__a21oi_1
X_17621_ net403 _06028_ _06029_ VSS VSS VDD VDD _02883_ sky130_fd_sc_hd__a21oi_1
X_17622_ _09175_ _08997_ VSS VSS VDD VDD _06030_ sky130_fd_sc_hd__nand2_1
X_17623_ network.in_spk10_07 _06030_ network.in_spk11_07 VSS
+ VSS VDD VDD _06031_ sky130_fd_sc_hd__o21ai_0
X_17624_ _04637_ _06031_ net374 VSS VSS VDD VDD _02038_ sky130_fd_sc_hd__a21oi_1
X_17625_ network.neuron_in205.counter\[1\] network.neuron_in205.counter\[0\]
+ _00968_ VSS VSS VDD VDD _06032_ sky130_fd_sc_hd__o21bai_1
X_17626_ _06701_ _06032_ network.neuron_in205.counter\[3\]
+ VSS VSS VDD VDD _06033_ sky130_fd_sc_hd__a21oi_1
X_17627_ _06701_ network.neuron_in205.counter\[3\] _00967_
+ _00966_ _06033_ VSS VSS VDD VDD _06034_ sky130_fd_sc_hd__a41o_1
X_17628_ net403 _06700_ network.in_period\[205\]\[3\] VSS
+ VSS VDD VDD _06035_ sky130_fd_sc_hd__a21oi_1
X_17629_ net403 _06034_ _06035_ VSS VSS VDD VDD _02887_ sky130_fd_sc_hd__a21oi_1
X_17630_ network.in_period\[113\]\[0\] _05503_ VSS VSS VDD
+ VDD _06036_ sky130_fd_sc_hd__nand2_1
X_17631_ network.neuron_in113.counter\[0\] _05503_ _06036_
+ VSS VSS VDD VDD _02516_ sky130_fd_sc_hd__o21ai_0
X_17632_ network.neuron_in206.counter\[2\] network.neuron_in206.counter\[0\]
+ network.neuron_in206.counter\[1\] VSS VSS VDD VDD _06037_
+ sky130_fd_sc_hd__nor3_1
X_17633_ network.neuron_in206.counter\[3\] _06037_ VSS VSS
+ VDD VDD _06038_ sky130_fd_sc_hd__xnor2_1
X_17634_ network.in_period\[206\]\[3\] _06773_ VSS VSS VDD
+ VDD _06039_ sky130_fd_sc_hd__nand2_1
X_17635_ _06773_ _06038_ _06039_ VSS VSS VDD VDD _02891_ sky130_fd_sc_hd__o21ai_0
X_17636_ network.in_spk10_07 _06030_ VSS VSS VDD VDD _06040_
+ sky130_fd_sc_hd__nand2_1
X_17637_ _04639_ _06040_ net374 VSS VSS VDD VDD _02039_ sky130_fd_sc_hd__a21oi_1
X_17638_ network.neuron_in207.counter\[0\] network.neuron_in207.counter\[2\]
+ network.neuron_in207.counter\[1\] VSS VSS VDD VDD _06041_
+ sky130_fd_sc_hd__nor3_1
X_17639_ network.neuron_in207.counter\[3\] _06041_ VSS VSS
+ VDD VDD _06042_ sky130_fd_sc_hd__xnor2_1
X_17640_ network.in_period\[207\]\[3\] _06672_ VSS VSS VDD
+ VDD _06043_ sky130_fd_sc_hd__nand2_1
X_17641_ _06672_ _06042_ _06043_ VSS VSS VDD VDD _02895_ sky130_fd_sc_hd__o21ai_0
X_17642_ net390 _04665_ VSS VSS VDD VDD _06044_ sky130_fd_sc_hd__nand2_1
X_17643_ network.in_period\[110\]\[1\] _06044_ VSS VSS VDD
+ VDD _06045_ sky130_fd_sc_hd__nand2_1
X_17644_ _00081_ _06044_ _06045_ VSS VSS VDD VDD _02505_ sky130_fd_sc_hd__o21ai_0
X_17645_ network.neuron_in208.counter\[1\] network.neuron_in208.counter\[2\]
+ network.neuron_in208.counter\[0\] VSS VSS VDD VDD _06046_
+ sky130_fd_sc_hd__or3_1
X_17646_ net369 _06046_ VSS VSS VDD VDD _06047_ sky130_fd_sc_hd__nor2_1
X_17647_ network.in_period\[208\]\[3\] net403 VSS VSS VDD
+ VDD _06048_ sky130_fd_sc_hd__nor2_1
X_17648_ network.in_period\[208\]\[3\] _06653_ VSS VSS VDD
+ VDD _06049_ sky130_fd_sc_hd__nor2_1
X_17649_ net403 _06653_ _06046_ _06049_ VSS VSS VDD VDD _06050_
+ sky130_fd_sc_hd__a31oi_1
X_17650_ network.neuron_in208.counter\[3\] _06050_ VSS VSS
+ VDD VDD _06051_ sky130_fd_sc_hd__nor2_1
X_17651_ network.neuron_in208.counter\[3\] _06047_ _06048_
+ _06051_ VSS VSS VDD VDD _02899_ sky130_fd_sc_hd__a211oi_1
X_17652_ network.neuron_in177.counter\[1\] VSS VSS VDD VDD
+ _00811_ sky130_fd_sc_hd__inv_1
X_17653_ _03409_ _08997_ VSS VSS VDD VDD _06052_ sky130_fd_sc_hd__nand2_1
X_17654_ network.in_spk09_07 _06052_ VSS VSS VDD VDD _06053_
+ sky130_fd_sc_hd__nand2_1
X_17655_ _04641_ _06053_ net374 VSS VSS VDD VDD _02040_ sky130_fd_sc_hd__a21oi_1
Xinput22 net462 VSS VSS VDD VDD net21 sky130_fd_sc_hd__buf_1
X_17657_ network.neuron_in209.counter\[1\] network.neuron_in209.counter\[0\]
+ _00284_ VSS VSS VDD VDD _06055_ sky130_fd_sc_hd__o21bai_1
X_17658_ _06803_ _06055_ network.neuron_in209.counter\[3\]
+ VSS VSS VDD VDD _06056_ sky130_fd_sc_hd__a21oi_1
X_17659_ _06803_ network.neuron_in209.counter\[3\] _00283_
+ _00282_ _06056_ VSS VSS VDD VDD _06057_ sky130_fd_sc_hd__a41o_1
X_17660_ net405 _06842_ network.in_period\[209\]\[3\] VSS
+ VSS VDD VDD _06058_ sky130_fd_sc_hd__a21oi_1
X_17661_ net405 _06057_ _06058_ VSS VSS VDD VDD _02903_ sky130_fd_sc_hd__a21oi_1
X_17662_ network.neuron_in210.counter\[2\] network.neuron_in210.counter\[1\]
+ network.neuron_in210.counter\[0\] VSS VSS VDD VDD _06059_
+ sky130_fd_sc_hd__nor3_1
X_17663_ network.neuron_in210.counter\[3\] _06059_ VSS VSS
+ VDD VDD _06060_ sky130_fd_sc_hd__xnor2_1
X_17664_ network.in_period\[210\]\[3\] _06791_ VSS VSS VDD
+ VDD _06061_ sky130_fd_sc_hd__nand2_1
X_17665_ _06791_ _06060_ _06061_ VSS VSS VDD VDD _02907_ sky130_fd_sc_hd__o21ai_0
X_17666_ _08996_ _08959_ network.in_spk08_07 VSS VSS VDD VDD
+ _06062_ sky130_fd_sc_hd__o21ai_0
X_17667_ _04643_ _06062_ net374 VSS VSS VDD VDD _02041_ sky130_fd_sc_hd__a21oi_1
X_17668_ network.neuron_in211.counter\[1\] network.neuron_in211.counter\[0\]
+ _00280_ VSS VSS VDD VDD _06063_ sky130_fd_sc_hd__o21bai_1
X_17669_ _06810_ _06063_ network.neuron_in211.counter\[3\]
+ VSS VSS VDD VDD _06064_ sky130_fd_sc_hd__a21oi_1
X_17670_ _06810_ _00279_ network.neuron_in211.counter\[3\]
+ _00278_ _06064_ VSS VSS VDD VDD _06065_ sky130_fd_sc_hd__a41o_1
X_17671_ net405 _06809_ network.in_period\[211\]\[3\] VSS
+ VSS VDD VDD _06066_ sky130_fd_sc_hd__a21oi_1
X_17672_ net405 _06065_ _06066_ VSS VSS VDD VDD _02911_ sky130_fd_sc_hd__a21oi_1
X_17673_ net383 _04660_ VSS VSS VDD VDD _06067_ sky130_fd_sc_hd__nand2_1
X_17674_ network.in_period\[112\]\[0\] _06067_ VSS VSS VDD
+ VDD _06068_ sky130_fd_sc_hd__nand2_1
X_17675_ network.neuron_in112.counter\[0\] _06067_ _06068_
+ VSS VSS VDD VDD _02512_ sky130_fd_sc_hd__o21ai_0
X_17676_ network.neuron_in212.counter\[1\] network.neuron_in212.counter\[2\]
+ network.neuron_in212.counter\[0\] VSS VSS VDD VDD _06069_
+ sky130_fd_sc_hd__nor3_1
X_17677_ network.neuron_in212.counter\[3\] _06069_ VSS VSS
+ VDD VDD _06070_ sky130_fd_sc_hd__xnor2_1
X_17678_ network.in_period\[212\]\[3\] _06795_ VSS VSS VDD
+ VDD _06071_ sky130_fd_sc_hd__nand2_1
X_17679_ _06795_ _06070_ _06071_ VSS VSS VDD VDD _02915_ sky130_fd_sc_hd__o21ai_0
X_17680_ _08913_ _08959_ VSS VSS VDD VDD _06072_ sky130_fd_sc_hd__or2_2
X_17681_ _08994_ _06072_ network.in_spk07_07 VSS VSS VDD VDD
+ _06073_ sky130_fd_sc_hd__o21ai_0
X_17682_ _04645_ _06073_ net374 VSS VSS VDD VDD _02042_ sky130_fd_sc_hd__a21oi_1
X_17683_ network.neuron_in213.counter\[1\] network.neuron_in213.counter\[2\]
+ network.neuron_in213.counter\[0\] VSS VSS VDD VDD _06074_
+ sky130_fd_sc_hd__nor3_1
X_17684_ network.neuron_in213.counter\[3\] _06074_ VSS VSS
+ VDD VDD _06075_ sky130_fd_sc_hd__xnor2_1
X_17685_ network.in_period\[213\]\[3\] _06854_ VSS VSS VDD
+ VDD _06076_ sky130_fd_sc_hd__nand2_1
X_17686_ _06854_ _06075_ _06076_ VSS VSS VDD VDD _02919_ sky130_fd_sc_hd__o21ai_0
X_17687_ network.neuron_in109.counter\[2\] _01008_ VSS VSS
+ VDD VDD _06077_ sky130_fd_sc_hd__xnor2_1
X_17688_ net390 _04667_ network.in_period\[109\]\[2\] VSS
+ VSS VDD VDD _06078_ sky130_fd_sc_hd__a21oi_1
X_17689_ net390 _06077_ _06078_ VSS VSS VDD VDD _02502_ sky130_fd_sc_hd__a21oi_1
X_17690_ network.neuron_in214.counter\[2\] network.neuron_in214.counter\[1\]
+ network.neuron_in214.counter\[0\] VSS VSS VDD VDD _06079_
+ sky130_fd_sc_hd__nor3_1
X_17691_ network.neuron_in214.counter\[3\] _06079_ VSS VSS
+ VDD VDD _06080_ sky130_fd_sc_hd__xnor2_1
X_17692_ network.in_period\[214\]\[3\] _06828_ VSS VSS VDD
+ VDD _06081_ sky130_fd_sc_hd__nand2_1
X_17693_ _06828_ _06080_ _06081_ VSS VSS VDD VDD _02923_ sky130_fd_sc_hd__o21ai_0
X_17694_ network.in_spk04_07 network.in_spk05_07 _06072_ network.in_spk06_07
+ VSS VSS VDD VDD _06082_ sky130_fd_sc_hd__o31ai_1
X_17695_ _04647_ _06082_ net374 VSS VSS VDD VDD _02043_ sky130_fd_sc_hd__a21oi_1
X_17696_ network.neuron_in215.counter\[0\] network.neuron_in215.counter\[2\]
+ network.neuron_in215.counter\[1\] VSS VSS VDD VDD _06083_
+ sky130_fd_sc_hd__nor3_1
X_17697_ network.neuron_in215.counter\[3\] _06083_ VSS VSS
+ VDD VDD _06084_ sky130_fd_sc_hd__xnor2_1
X_17698_ network.in_period\[215\]\[3\] _06858_ VSS VSS VDD
+ VDD _06085_ sky130_fd_sc_hd__nand2_1
X_17699_ _06858_ _06084_ _06085_ VSS VSS VDD VDD _02927_ sky130_fd_sc_hd__o21ai_0
X_17700_ network.in_period\[109\]\[0\] _05481_ VSS VSS VDD
+ VDD _06086_ sky130_fd_sc_hd__nand2_1
X_17701_ network.neuron_in109.counter\[0\] _05481_ _06086_
+ VSS VSS VDD VDD _02500_ sky130_fd_sc_hd__o21ai_0
X_17702_ network.neuron_in216.counter\[1\] network.neuron_in216.counter\[0\]
+ network.neuron_in216.counter\[2\] VSS VSS VDD VDD _06087_
+ sky130_fd_sc_hd__or3_1
X_17703_ net368 _06861_ _06087_ VSS VSS VDD VDD _06088_ sky130_fd_sc_hd__nor3_1
X_17704_ network.in_period\[216\]\[3\] _06861_ _06088_ VSS
+ VSS VDD VDD _06089_ sky130_fd_sc_hd__a21oi_1
X_17705_ network.in_period\[216\]\[3\] net368 VSS VSS VDD
+ VDD _06090_ sky130_fd_sc_hd__and2_1
X_17706_ network.neuron_in216.counter\[3\] net405 _06087_
+ _06090_ VSS VSS VDD VDD _06091_ sky130_fd_sc_hd__a31oi_1
X_17707_ network.neuron_in216.counter\[3\] _06089_ _06091_
+ VSS VSS VDD VDD _02931_ sky130_fd_sc_hd__o21ai_0
X_17708_ network.neuron_in110.counter\[3\] network.in_period\[110\]\[2\]
+ net372 _00080_ VSS VSS VDD VDD _06092_ sky130_fd_sc_hd__o22ai_1
X_17709_ network.neuron_in110.counter\[2\] _00080_ net390
+ VSS VSS VDD VDD _06093_ sky130_fd_sc_hd__nand3_1
X_17710_ network.in_period\[110\]\[2\] net390 _06093_ VSS
+ VSS VDD VDD _06094_ sky130_fd_sc_hd__o21ai_0
X_17711_ _04664_ _06092_ _06094_ VSS VSS VDD VDD _02506_ sky130_fd_sc_hd__a21oi_1
X_17712_ network.in_spk04_07 _06072_ network.in_spk05_07 VSS
+ VSS VDD VDD _06095_ sky130_fd_sc_hd__o21ai_0
X_17713_ _04650_ _06095_ net374 VSS VSS VDD VDD _02044_ sky130_fd_sc_hd__a21oi_1
X_17714_ network.neuron_in217.counter\[0\] network.neuron_in217.counter\[2\]
+ network.neuron_in217.counter\[1\] VSS VSS VDD VDD _06096_
+ sky130_fd_sc_hd__nor3_1
X_17715_ network.neuron_in217.counter\[3\] _06096_ VSS VSS
+ VDD VDD _06097_ sky130_fd_sc_hd__xnor2_1
X_17716_ network.in_period\[217\]\[3\] _06786_ VSS VSS VDD
+ VDD _06098_ sky130_fd_sc_hd__nand2_1
X_17717_ _06786_ _06097_ _06098_ VSS VSS VDD VDD _02935_ sky130_fd_sc_hd__o21ai_0
X_17718_ network.in_period\[110\]\[0\] _06044_ VSS VSS VDD
+ VDD _06099_ sky130_fd_sc_hd__nand2_1
X_17719_ network.neuron_in110.counter\[0\] _06044_ _06099_
+ VSS VSS VDD VDD _02504_ sky130_fd_sc_hd__o21ai_0
X_17720_ network.neuron_in218.counter\[2\] network.neuron_in218.counter\[0\]
+ network.neuron_in218.counter\[1\] VSS VSS VDD VDD _06100_
+ sky130_fd_sc_hd__nor3_1
X_17721_ network.neuron_in218.counter\[3\] _06100_ VSS VSS
+ VDD VDD _06101_ sky130_fd_sc_hd__xnor2_1
X_17722_ network.in_period\[218\]\[3\] _06955_ VSS VSS VDD
+ VDD _06102_ sky130_fd_sc_hd__nand2_1
X_17723_ _06955_ _06101_ _06102_ VSS VSS VDD VDD _02939_ sky130_fd_sc_hd__o21ai_0
X_17724_ network.in_spk04_07 _06072_ VSS VSS VDD VDD _06103_
+ sky130_fd_sc_hd__nand2_1
X_17725_ _04652_ _06103_ net374 VSS VSS VDD VDD _02045_ sky130_fd_sc_hd__a21oi_1
X_17726_ network.neuron_in219.counter\[1\] network.neuron_in219.counter\[0\]
+ _01000_ VSS VSS VDD VDD _06104_ sky130_fd_sc_hd__o21bai_1
X_17727_ _06897_ _06104_ network.neuron_in219.counter\[3\]
+ VSS VSS VDD VDD _06105_ sky130_fd_sc_hd__a21oi_1
X_17728_ _06897_ _00999_ network.neuron_in219.counter\[3\]
+ _00998_ _06105_ VSS VSS VDD VDD _06106_ sky130_fd_sc_hd__a41o_1
X_17729_ net399 _06958_ network.in_period\[219\]\[3\] VSS
+ VSS VDD VDD _06107_ sky130_fd_sc_hd__a21oi_1
X_17730_ net399 _06106_ _06107_ VSS VSS VDD VDD _02943_ sky130_fd_sc_hd__a21oi_1
X_17731_ net390 _04662_ VSS VSS VDD VDD _06108_ sky130_fd_sc_hd__nand2_1
X_17732_ network.in_period\[111\]\[1\] _06108_ VSS VSS VDD
+ VDD _06109_ sky130_fd_sc_hd__nand2_1
X_17733_ _00570_ _06108_ _06109_ VSS VSS VDD VDD _02509_ sky130_fd_sc_hd__o21ai_0
X_17734_ network.neuron_in220.counter\[1\] network.neuron_in220.counter\[0\]
+ _00964_ VSS VSS VDD VDD _06110_ sky130_fd_sc_hd__o21bai_1
X_17735_ _06880_ _06110_ network.neuron_in220.counter\[3\]
+ VSS VSS VDD VDD _06111_ sky130_fd_sc_hd__a21oi_1
X_17736_ _06880_ network.neuron_in220.counter\[3\] _00963_
+ _00962_ _06111_ VSS VSS VDD VDD _06112_ sky130_fd_sc_hd__a41o_1
X_17737_ net397 _06879_ network.in_period\[220\]\[3\] VSS
+ VSS VDD VDD _06113_ sky130_fd_sc_hd__a21oi_1
X_17738_ net397 _06112_ _06113_ VSS VSS VDD VDD _02947_ sky130_fd_sc_hd__a21oi_1
X_17739_ network.in_period\[111\]\[0\] _06108_ VSS VSS VDD
+ VDD _06114_ sky130_fd_sc_hd__nand2_1
X_17740_ network.neuron_in111.counter\[0\] _06108_ _06114_
+ VSS VSS VDD VDD _02508_ sky130_fd_sc_hd__o21ai_0
X_17741_ network.in_spk00_07 network.in_spk01_07 network.in_spk02_07
+ _08959_ network.in_spk03_07 VSS VSS VDD VDD _06115_ sky130_fd_sc_hd__o41ai_1
Xinput21 net461 VSS VSS VDD VDD net20 sky130_fd_sc_hd__buf_1
X_17743_ _04654_ _06115_ net374 VSS VSS VDD VDD _02046_ sky130_fd_sc_hd__a21oi_1
X_17744_ network.neuron_in221.counter\[2\] network.neuron_in221.counter\[1\]
+ network.neuron_in221.counter\[0\] VSS VSS VDD VDD _06117_
+ sky130_fd_sc_hd__nor3_1
X_17745_ network.neuron_in221.counter\[3\] _06117_ VSS VSS
+ VDD VDD _06118_ sky130_fd_sc_hd__xnor2_1
X_17746_ network.in_period\[221\]\[3\] _06907_ VSS VSS VDD
+ VDD _06119_ sky130_fd_sc_hd__nand2_1
X_17747_ _06907_ _06118_ _06119_ VSS VSS VDD VDD _02951_ sky130_fd_sc_hd__o21ai_0
X_17748_ _00894_ _06967_ _00895_ VSS VSS VDD VDD _06120_ sky130_fd_sc_hd__nand3_1
X_17749_ net381 _06884_ _06120_ VSS VSS VDD VDD _06121_ sky130_fd_sc_hd__nor3_1
X_17750_ network.in_period\[222\]\[3\] _06884_ _06121_ VSS
+ VSS VDD VDD _06122_ sky130_fd_sc_hd__a21oi_1
X_17751_ network.in_period\[222\]\[3\] net381 VSS VSS VDD
+ VDD _06123_ sky130_fd_sc_hd__and2_1
X_17752_ network.neuron_in222.counter\[3\] net400 _06120_
+ _06123_ VSS VSS VDD VDD _06124_ sky130_fd_sc_hd__a31oi_1
X_17753_ network.neuron_in222.counter\[3\] _06122_ _06124_
+ VSS VSS VDD VDD _02955_ sky130_fd_sc_hd__o21ai_0
X_17754_ network.neuron_in112.counter\[3\] network.in_period\[112\]\[2\]
+ _00545_ net374 VSS VSS VDD VDD _06125_ sky130_fd_sc_hd__o22ai_1
X_17755_ network.neuron_in112.counter\[2\] _00545_ net383
+ VSS VSS VDD VDD _06126_ sky130_fd_sc_hd__nand3_1
X_17756_ network.in_period\[112\]\[2\] net383 _06126_ VSS
+ VSS VDD VDD _06127_ sky130_fd_sc_hd__o21ai_0
X_17757_ _04659_ _06125_ _06127_ VSS VSS VDD VDD _02514_ sky130_fd_sc_hd__a21oi_1
X_17758_ network.in_period\[112\]\[1\] _06067_ VSS VSS VDD
+ VDD _06128_ sky130_fd_sc_hd__nand2_1
X_17759_ _00546_ _06067_ _06128_ VSS VSS VDD VDD _02513_ sky130_fd_sc_hd__o21ai_0
X_17760_ network.in_spk00_07 network.in_spk01_07 _08959_ network.in_spk02_07
+ VSS VSS VDD VDD _06129_ sky130_fd_sc_hd__o31ai_1
X_17761_ _04656_ _06129_ net374 VSS VSS VDD VDD _02047_ sky130_fd_sc_hd__a21oi_1
X_17762_ network.neuron_in113.counter\[2\] net384 VSS VSS
+ VDD VDD _06130_ sky130_fd_sc_hd__nand2_1
X_17763_ network.neuron_in113.counter\[3\] network.in_period\[113\]\[2\]
+ _06130_ VSS VSS VDD VDD _06131_ sky130_fd_sc_hd__o21ai_0
X_17764_ _00577_ network.neuron_in113.counter\[2\] net374
+ VSS VSS VDD VDD _06132_ sky130_fd_sc_hd__or3_1
X_17765_ network.in_period\[113\]\[2\] net384 _06132_ VSS
+ VSS VDD VDD _06133_ sky130_fd_sc_hd__o21ai_0
X_17766_ _00577_ _06131_ _06133_ VSS VSS VDD VDD _02518_ sky130_fd_sc_hd__a21oi_1
X_17767_ network.neuron_in223.counter\[1\] network.neuron_in223.counter\[0\]
+ _00900_ VSS VSS VDD VDD _06134_ sky130_fd_sc_hd__o21bai_1
X_17768_ _06870_ _06134_ network.neuron_in223.counter\[3\]
+ VSS VSS VDD VDD _06135_ sky130_fd_sc_hd__a21oi_1
X_17769_ _06870_ network.neuron_in223.counter\[3\] _00899_
+ _00898_ _06135_ VSS VSS VDD VDD _06136_ sky130_fd_sc_hd__a41o_1
X_17770_ net400 _06971_ network.in_period\[223\]\[3\] VSS
+ VSS VDD VDD _06137_ sky130_fd_sc_hd__a21oi_1
X_17771_ net400 _06136_ _06137_ VSS VSS VDD VDD _02959_ sky130_fd_sc_hd__a21oi_1
X_17772_ network.in_period\[113\]\[1\] _05503_ VSS VSS VDD
+ VDD _06138_ sky130_fd_sc_hd__nand2_1
X_17773_ _00578_ _05503_ _06138_ VSS VSS VDD VDD _02517_ sky130_fd_sc_hd__o21ai_0
X_17774_ _01168_ _06911_ _01167_ VSS VSS VDD VDD _06139_ sky130_fd_sc_hd__nand3_1
X_17775_ net375 _06915_ _06139_ VSS VSS VDD VDD _06140_ sky130_fd_sc_hd__nor3_1
X_17776_ network.in_period\[224\]\[3\] _06915_ _06140_ VSS
+ VSS VDD VDD _06141_ sky130_fd_sc_hd__a21oi_1
X_17777_ network.in_period\[224\]\[3\] net375 VSS VSS VDD
+ VDD _06142_ sky130_fd_sc_hd__and2_1
X_17778_ network.neuron_in224.counter\[3\] net386 _06139_
+ _06142_ VSS VSS VDD VDD _06143_ sky130_fd_sc_hd__a31oi_1
X_17779_ network.neuron_in224.counter\[3\] _06141_ _06143_
+ VSS VSS VDD VDD _02963_ sky130_fd_sc_hd__o21ai_0
X_17780_ network.in_spk00_07 _08959_ network.in_spk01_07 VSS
+ VSS VDD VDD _06144_ sky130_fd_sc_hd__o21ai_0
X_17781_ _04657_ _06144_ net374 VSS VSS VDD VDD _02048_ sky130_fd_sc_hd__a21oi_1
X_17782_ network.neuron_in225.counter\[1\] network.neuron_in225.counter\[0\]
+ _00341_ VSS VSS VDD VDD _06145_ sky130_fd_sc_hd__o21bai_1
X_17783_ _06888_ _06145_ network.neuron_in225.counter\[3\]
+ VSS VSS VDD VDD _06146_ sky130_fd_sc_hd__a21oi_1
X_17784_ _06888_ network.neuron_in225.counter\[3\] _00340_
+ _00339_ _06146_ VSS VSS VDD VDD _06147_ sky130_fd_sc_hd__a41o_1
X_17785_ net386 _06977_ network.in_period\[225\]\[3\] VSS
+ VSS VDD VDD _06148_ sky130_fd_sc_hd__a21oi_1
X_17786_ net386 _06147_ _06148_ VSS VSS VDD VDD _02967_ sky130_fd_sc_hd__a21oi_1
X_17787_ network.neuron_in226.counter\[2\] network.neuron_in226.counter\[1\]
+ network.neuron_in226.counter\[0\] VSS VSS VDD VDD _06149_
+ sky130_fd_sc_hd__nor3_1
X_17788_ network.neuron_in226.counter\[3\] _06149_ VSS VSS
+ VDD VDD _06150_ sky130_fd_sc_hd__xnor2_1
X_17789_ network.in_period\[226\]\[3\] _06987_ VSS VSS VDD
+ VDD _06151_ sky130_fd_sc_hd__nand2_1
X_17790_ _06987_ _06150_ _06151_ VSS VSS VDD VDD _02971_ sky130_fd_sc_hd__o21ai_0
X_17791_ network.in_period\[114\]\[0\] _05507_ VSS VSS VDD
+ VDD _06152_ sky130_fd_sc_hd__nand2_1
X_17792_ network.neuron_in114.counter\[0\] _05507_ _06152_
+ VSS VSS VDD VDD _02520_ sky130_fd_sc_hd__o21ai_0
X_17793_ net383 _04654_ VSS VSS VDD VDD _06153_ sky130_fd_sc_hd__nand2_1
X_17794_ network.in_period\[115\]\[0\] _06153_ VSS VSS VDD
+ VDD _06154_ sky130_fd_sc_hd__nand2_1
X_17795_ network.neuron_in115.counter\[0\] _06153_ _06154_
+ VSS VSS VDD VDD _02524_ sky130_fd_sc_hd__o21ai_0
X_17796_ network.in_spk00_07 _08959_ VSS VSS VDD VDD _06155_
+ sky130_fd_sc_hd__nand2_1
X_17797_ _04660_ _06155_ net374 VSS VSS VDD VDD _02049_ sky130_fd_sc_hd__a21oi_1
X_17798_ net384 _04652_ VSS VSS VDD VDD _06156_ sky130_fd_sc_hd__nand2_1
X_17799_ network.in_period\[116\]\[0\] _06156_ VSS VSS VDD
+ VDD _06157_ sky130_fd_sc_hd__nand2_1
X_17800_ network.neuron_in116.counter\[0\] _06156_ _06157_
+ VSS VSS VDD VDD _02528_ sky130_fd_sc_hd__o21ai_0
X_17801_ network.neuron_in227.counter\[1\] network.neuron_in227.counter\[2\]
+ network.neuron_in227.counter\[0\] VSS VSS VDD VDD _06158_
+ sky130_fd_sc_hd__nor3_1
X_17802_ network.neuron_in227.counter\[3\] _06158_ VSS VSS
+ VDD VDD _06159_ sky130_fd_sc_hd__xnor2_1
X_17803_ network.in_period\[227\]\[3\] _06877_ VSS VSS VDD
+ VDD _06160_ sky130_fd_sc_hd__nand2_1
X_17804_ _06877_ _06159_ _06160_ VSS VSS VDD VDD _02975_ sky130_fd_sc_hd__o21ai_0
X_17805_ _01219_ network.neuron_in117.counter\[2\] VSS VSS
+ VDD VDD _06161_ sky130_fd_sc_hd__xnor2_1
Xinput20 net463 VSS VSS VDD VDD net19 sky130_fd_sc_hd__buf_1
X_17807_ net384 _04650_ network.in_period\[117\]\[2\] VSS
+ VSS VDD VDD _06163_ sky130_fd_sc_hd__a21oi_1
X_17808_ net384 _06161_ _06163_ VSS VSS VDD VDD _02534_ sky130_fd_sc_hd__a21oi_1
X_17809_ _00084_ network.neuron_in118.counter\[2\] VSS VSS
+ VDD VDD _06164_ sky130_fd_sc_hd__xnor2_1
X_17810_ net384 _04647_ network.in_period\[118\]\[2\] VSS
+ VSS VDD VDD _06165_ sky130_fd_sc_hd__a21oi_1
X_17811_ net384 _06164_ _06165_ VSS VSS VDD VDD _02538_ sky130_fd_sc_hd__a21oi_1
X_17812_ _00581_ network.neuron_in119.counter\[2\] VSS VSS
+ VDD VDD _06166_ sky130_fd_sc_hd__xnor2_1
X_17813_ net384 _04645_ network.in_period\[119\]\[2\] VSS
+ VSS VDD VDD _06167_ sky130_fd_sc_hd__a21oi_1
X_17814_ net384 _06166_ _06167_ VSS VSS VDD VDD _02542_ sky130_fd_sc_hd__a21oi_1
Xinput19 net464 VSS VSS VDD VDD net18 sky130_fd_sc_hd__buf_1
X_17816_ network.neuron_in228.counter\[1\] network.neuron_in228.counter\[0\]
+ _00808_ VSS VSS VDD VDD _06169_ sky130_fd_sc_hd__o21bai_1
X_17817_ _06866_ _06169_ network.neuron_in228.counter\[3\]
+ VSS VSS VDD VDD _06170_ sky130_fd_sc_hd__a21oi_1
X_17818_ _06866_ network.neuron_in228.counter\[3\] _00807_
+ _00806_ _06170_ VSS VSS VDD VDD _06171_ sky130_fd_sc_hd__a41o_1
X_17819_ net392 _07257_ network.in_period\[228\]\[3\] VSS
+ VSS VDD VDD _06172_ sky130_fd_sc_hd__a21oi_1
X_17820_ net392 _06171_ _06172_ VSS VSS VDD VDD _02979_ sky130_fd_sc_hd__a21oi_1
X_17821_ _08949_ _09013_ VSS VSS VDD VDD _06173_ sky130_fd_sc_hd__or2_2
X_17822_ network.in_spk12_06 network.in_spk13_06 _06173_ VSS
+ VSS VDD VDD _06174_ sky130_fd_sc_hd__or3_1
X_17823_ network.in_spk14_06 _06174_ network.in_spk15_06 VSS
+ VSS VDD VDD _06175_ sky130_fd_sc_hd__o21ai_0
X_17824_ _04662_ _06175_ net372 VSS VSS VDD VDD _02050_ sky130_fd_sc_hd__a21oi_1
X_17825_ network.neuron_in114.counter\[2\] _00498_ VSS VSS
+ VDD VDD _06176_ sky130_fd_sc_hd__xnor2_1
X_17826_ net383 _04656_ network.in_period\[114\]\[2\] VSS
+ VSS VDD VDD _06177_ sky130_fd_sc_hd__a21oi_1
X_17827_ net383 _06176_ _06177_ VSS VSS VDD VDD _02522_ sky130_fd_sc_hd__a21oi_1
X_17828_ network.neuron_in229.counter\[2\] network.neuron_in229.counter\[0\]
+ network.neuron_in229.counter\[1\] VSS VSS VDD VDD _06178_
+ sky130_fd_sc_hd__nor3_1
X_17829_ network.neuron_in229.counter\[3\] _06178_ VSS VSS
+ VDD VDD _06179_ sky130_fd_sc_hd__xnor2_1
X_17830_ network.in_period\[229\]\[3\] _07262_ VSS VSS VDD
+ VDD _06180_ sky130_fd_sc_hd__nand2_1
X_17831_ _07262_ _06179_ _06180_ VSS VSS VDD VDD _02983_ sky130_fd_sc_hd__o21ai_0
X_17832_ network.in_period\[114\]\[1\] _05507_ VSS VSS VDD
+ VDD _06181_ sky130_fd_sc_hd__nand2_1
X_17833_ _00499_ _05507_ _06181_ VSS VSS VDD VDD _02521_ sky130_fd_sc_hd__o21ai_0
X_17834_ network.neuron_in115.counter\[2\] net383 VSS VSS
+ VDD VDD _06182_ sky130_fd_sc_hd__nand2_1
X_17835_ network.neuron_in115.counter\[3\] network.in_period\[115\]\[2\]
+ _06182_ VSS VSS VDD VDD _06183_ sky130_fd_sc_hd__o21ai_0
X_17836_ _01228_ network.neuron_in115.counter\[2\] net374
+ VSS VSS VDD VDD _06184_ sky130_fd_sc_hd__or3_1
X_17837_ network.in_period\[115\]\[2\] net383 _06184_ VSS
+ VSS VDD VDD _06185_ sky130_fd_sc_hd__o21ai_0
X_17838_ _01228_ _06183_ _06185_ VSS VSS VDD VDD _02526_ sky130_fd_sc_hd__a21oi_1
X_17839_ network.in_period\[115\]\[1\] _06153_ VSS VSS VDD
+ VDD _06186_ sky130_fd_sc_hd__nand2_1
X_17840_ _01229_ _06153_ _06186_ VSS VSS VDD VDD _02525_ sky130_fd_sc_hd__o21ai_0
X_17841_ network.neuron_in230.counter\[2\] network.neuron_in230.counter\[0\]
+ network.neuron_in230.counter\[1\] VSS VSS VDD VDD _06187_
+ sky130_fd_sc_hd__nor3_1
X_17842_ network.neuron_in230.counter\[3\] _06187_ VSS VSS
+ VDD VDD _06188_ sky130_fd_sc_hd__xnor2_1
X_17843_ network.in_period\[230\]\[3\] _07002_ VSS VSS VDD
+ VDD _06189_ sky130_fd_sc_hd__nand2_1
X_17844_ _07002_ _06188_ _06189_ VSS VSS VDD VDD _02987_ sky130_fd_sc_hd__o21ai_0
X_17845_ network.neuron_in116.counter\[3\] network.in_period\[116\]\[2\]
+ net374 _00040_ VSS VSS VDD VDD _06190_ sky130_fd_sc_hd__o22ai_1
X_17846_ network.neuron_in116.counter\[2\] _00040_ net384
+ VSS VSS VDD VDD _06191_ sky130_fd_sc_hd__nand3_1
X_17847_ network.in_period\[116\]\[2\] net384 _06191_ VSS
+ VSS VDD VDD _06192_ sky130_fd_sc_hd__o21ai_0
X_17848_ _05520_ _06190_ _06192_ VSS VSS VDD VDD _02530_ sky130_fd_sc_hd__a21oi_1
X_17849_ network.in_period\[116\]\[1\] _06156_ VSS VSS VDD
+ VDD _06193_ sky130_fd_sc_hd__nand2_1
X_17850_ _00041_ _06156_ _06193_ VSS VSS VDD VDD _02529_ sky130_fd_sc_hd__o21ai_0
X_17851_ network.in_spk14_06 _06174_ VSS VSS VDD VDD _06194_
+ sky130_fd_sc_hd__nand2_1
X_17852_ _04665_ _06194_ net372 VSS VSS VDD VDD _02051_ sky130_fd_sc_hd__a21oi_1
X_17853_ network.neuron_in231.counter\[1\] network.neuron_in231.counter\[0\]
+ _00664_ VSS VSS VDD VDD _06195_ sky130_fd_sc_hd__o21bai_1
X_17854_ _07027_ _06195_ network.neuron_in231.counter\[3\]
+ VSS VSS VDD VDD _06196_ sky130_fd_sc_hd__a21oi_1
X_17855_ _07027_ network.neuron_in231.counter\[3\] _00663_
+ _00662_ _06196_ VSS VSS VDD VDD _06197_ sky130_fd_sc_hd__a41o_1
X_17856_ net392 _07026_ network.in_period\[231\]\[3\] VSS
+ VSS VDD VDD _06198_ sky130_fd_sc_hd__a21oi_1
X_17857_ net392 _06197_ _06198_ VSS VSS VDD VDD _02991_ sky130_fd_sc_hd__a21oi_1
X_17858_ network.in_period\[117\]\[1\] _05529_ VSS VSS VDD
+ VDD _06199_ sky130_fd_sc_hd__nand2_1
X_17859_ _01220_ _05529_ _06199_ VSS VSS VDD VDD _02533_ sky130_fd_sc_hd__o21ai_0
X_17860_ network.in_period\[117\]\[0\] _05529_ VSS VSS VDD
+ VDD _06200_ sky130_fd_sc_hd__nand2_1
X_17861_ network.neuron_in117.counter\[0\] _05529_ _06200_
+ VSS VSS VDD VDD _02532_ sky130_fd_sc_hd__o21ai_0
X_17862_ network.neuron_in232.counter\[0\] network.neuron_in232.counter\[1\]
+ _00940_ VSS VSS VDD VDD _06201_ sky130_fd_sc_hd__o21bai_1
X_17863_ _07005_ _06201_ network.neuron_in232.counter\[3\]
+ VSS VSS VDD VDD _06202_ sky130_fd_sc_hd__a21oi_1
X_17864_ _07005_ network.neuron_in232.counter\[3\] _00938_
+ _00939_ _06202_ VSS VSS VDD VDD _06203_ sky130_fd_sc_hd__a41o_1
X_17865_ net393 _07004_ network.in_period\[232\]\[3\] VSS
+ VSS VDD VDD _06204_ sky130_fd_sc_hd__a21oi_1
X_17866_ net393 _06203_ _06204_ VSS VSS VDD VDD _02995_ sky130_fd_sc_hd__a21oi_1
X_17867_ network.in_period\[118\]\[1\] _05533_ VSS VSS VDD
+ VDD _06205_ sky130_fd_sc_hd__nand2_1
X_17868_ _00085_ _05533_ _06205_ VSS VSS VDD VDD _02537_ sky130_fd_sc_hd__o21ai_0
X_17869_ network.in_period\[118\]\[0\] _05533_ VSS VSS VDD
+ VDD _06206_ sky130_fd_sc_hd__nand2_1
X_17870_ network.neuron_in118.counter\[0\] _05533_ _06206_
+ VSS VSS VDD VDD _02536_ sky130_fd_sc_hd__o21ai_0
X_17871_ network.in_spk12_06 _06173_ network.in_spk13_06 VSS
+ VSS VDD VDD _06207_ sky130_fd_sc_hd__o21ai_0
X_17872_ _04667_ _06207_ net372 VSS VSS VDD VDD _02052_ sky130_fd_sc_hd__a21oi_1
X_17873_ network.in_period\[119\]\[1\] _05538_ VSS VSS VDD
+ VDD _06208_ sky130_fd_sc_hd__nand2_1
X_17874_ _00582_ _05538_ _06208_ VSS VSS VDD VDD _02541_ sky130_fd_sc_hd__o21ai_0
X_17875_ network.neuron_in233.counter\[1\] network.neuron_in233.counter\[0\]
+ network.neuron_in233.counter\[2\] VSS VSS VDD VDD _06209_
+ sky130_fd_sc_hd__nor3_1
X_17876_ network.neuron_in233.counter\[3\] _06209_ VSS VSS
+ VDD VDD _06210_ sky130_fd_sc_hd__xnor2_1
X_17877_ network.in_period\[233\]\[3\] _07032_ VSS VSS VDD
+ VDD _06211_ sky130_fd_sc_hd__nand2_1
X_17878_ _07032_ _06210_ _06211_ VSS VSS VDD VDD _02999_ sky130_fd_sc_hd__o21ai_0
X_17879_ network.in_period\[119\]\[0\] _05538_ VSS VSS VDD
+ VDD _06212_ sky130_fd_sc_hd__nand2_1
X_17880_ network.neuron_in119.counter\[0\] _05538_ _06212_
+ VSS VSS VDD VDD _02540_ sky130_fd_sc_hd__o21ai_0
X_17881_ network.neuron_in234.counter\[2\] network.neuron_in234.counter\[1\]
+ network.neuron_in234.counter\[0\] VSS VSS VDD VDD _06213_
+ sky130_fd_sc_hd__nor3_1
X_17882_ network.neuron_in234.counter\[3\] _06213_ VSS VSS
+ VDD VDD _06214_ sky130_fd_sc_hd__xnor2_1
X_17883_ network.in_period\[234\]\[3\] _07036_ VSS VSS VDD
+ VDD _06215_ sky130_fd_sc_hd__nand2_1
X_17884_ _07036_ _06214_ _06215_ VSS VSS VDD VDD _03003_ sky130_fd_sc_hd__o21ai_0
X_17885_ network.in_spk12_06 _06173_ VSS VSS VDD VDD _06216_
+ sky130_fd_sc_hd__nand2_1
X_17886_ _04670_ _06216_ net372 VSS VSS VDD VDD _02053_ sky130_fd_sc_hd__a21oi_1
X_17887_ network.neuron_in235.counter\[0\] network.neuron_in235.counter\[1\]
+ _00589_ VSS VSS VDD VDD _06217_ sky130_fd_sc_hd__o21bai_1
X_17888_ _07009_ _06217_ network.neuron_in235.counter\[3\]
+ VSS VSS VDD VDD _06218_ sky130_fd_sc_hd__a21oi_1
X_17889_ _07009_ _00587_ _00588_ network.neuron_in235.counter\[3\]
+ _06218_ VSS VSS VDD VDD _06219_ sky130_fd_sc_hd__a41o_1
X_17890_ net393 _07282_ network.in_period\[235\]\[3\] VSS
+ VSS VDD VDD _06220_ sky130_fd_sc_hd__a21oi_1
X_17891_ net393 _06219_ _06220_ VSS VSS VDD VDD _03007_ sky130_fd_sc_hd__a21oi_1
X_17892_ network.neuron_in236.counter\[2\] network.neuron_in236.counter\[1\]
+ network.neuron_in236.counter\[0\] VSS VSS VDD VDD _06221_
+ sky130_fd_sc_hd__nor3_1
X_17893_ network.neuron_in236.counter\[3\] _06221_ VSS VSS
+ VDD VDD _06222_ sky130_fd_sc_hd__xnor2_1
X_17894_ network.in_period\[236\]\[3\] _06992_ VSS VSS VDD
+ VDD _06223_ sky130_fd_sc_hd__nand2_1
X_17895_ _06992_ _06222_ _06223_ VSS VSS VDD VDD _03011_ sky130_fd_sc_hd__o21ai_0
X_17896_ network.in_spk08_06 network.in_spk09_06 _09014_ VSS
+ VSS VDD VDD _06224_ sky130_fd_sc_hd__or3_1
X_17897_ network.in_spk10_06 _06224_ network.in_spk11_06 VSS
+ VSS VDD VDD _06225_ sky130_fd_sc_hd__o21ai_0
X_17898_ _04674_ _06225_ net372 VSS VSS VDD VDD _02054_ sky130_fd_sc_hd__a21oi_1
X_17899_ network.neuron_in237.counter\[2\] network.neuron_in237.counter\[1\]
+ network.neuron_in237.counter\[0\] VSS VSS VDD VDD _06226_
+ sky130_fd_sc_hd__nor3_1
X_17900_ network.neuron_in237.counter\[3\] _06226_ VSS VSS
+ VDD VDD _06227_ sky130_fd_sc_hd__xnor2_1
X_17901_ network.in_period\[237\]\[3\] _07392_ VSS VSS VDD
+ VDD _06228_ sky130_fd_sc_hd__nand2_1
X_17902_ _07392_ _06227_ _06228_ VSS VSS VDD VDD _03015_ sky130_fd_sc_hd__o21ai_0
X_17903_ network.neuron_in238.counter\[1\] network.neuron_in238.counter\[0\]
+ _00788_ VSS VSS VDD VDD _06229_ sky130_fd_sc_hd__o21bai_1
X_17904_ _07395_ _06229_ network.neuron_in238.counter\[3\]
+ VSS VSS VDD VDD _06230_ sky130_fd_sc_hd__a21oi_1
X_17905_ _07395_ network.neuron_in238.counter\[3\] _00787_
+ _00786_ _06230_ VSS VSS VDD VDD _06231_ sky130_fd_sc_hd__a41o_1
X_17906_ net393 _07394_ network.in_period\[238\]\[3\] VSS
+ VSS VDD VDD _06232_ sky130_fd_sc_hd__a21oi_1
X_17907_ net393 _06231_ _06232_ VSS VSS VDD VDD _03019_ sky130_fd_sc_hd__a21oi_1
X_17908_ network.in_spk10_06 _06224_ VSS VSS VDD VDD _06233_
+ sky130_fd_sc_hd__nand2_1
X_17909_ _04677_ _06233_ net372 VSS VSS VDD VDD _02055_ sky130_fd_sc_hd__a21oi_1
X_17910_ network.neuron_in120.counter\[2\] net383 VSS VSS
+ VDD VDD _06234_ sky130_fd_sc_hd__nand2_1
X_17911_ network.neuron_in120.counter\[3\] network.in_period\[120\]\[2\]
+ _06234_ VSS VSS VDD VDD _06235_ sky130_fd_sc_hd__o21ai_0
X_17912_ _00792_ network.neuron_in120.counter\[2\] net374
+ VSS VSS VDD VDD _06236_ sky130_fd_sc_hd__or3_1
X_17913_ network.in_period\[120\]\[2\] net383 _06236_ VSS
+ VSS VDD VDD _06237_ sky130_fd_sc_hd__o21ai_0
X_17914_ _00792_ _06235_ _06237_ VSS VSS VDD VDD _02546_ sky130_fd_sc_hd__a21oi_1
X_17915_ network.neuron_in239.counter\[0\] network.neuron_in239.counter\[1\]
+ _00490_ VSS VSS VDD VDD _06238_ sky130_fd_sc_hd__o21bai_1
X_17916_ _07400_ _06238_ network.neuron_in239.counter\[3\]
+ VSS VSS VDD VDD _06239_ sky130_fd_sc_hd__a21oi_1
X_17917_ _07400_ network.neuron_in239.counter\[3\] _00488_
+ _00489_ _06239_ VSS VSS VDD VDD _06240_ sky130_fd_sc_hd__a41o_1
X_17918_ net391 _07399_ network.in_period\[239\]\[3\] VSS
+ VSS VDD VDD _06241_ sky130_fd_sc_hd__a21oi_1
X_17919_ net391 _06240_ _06241_ VSS VSS VDD VDD _03023_ sky130_fd_sc_hd__a21oi_1
X_17920_ net383 _04643_ VSS VSS VDD VDD _06242_ sky130_fd_sc_hd__nand2_1
X_17921_ network.in_period\[120\]\[1\] _06242_ VSS VSS VDD
+ VDD _06243_ sky130_fd_sc_hd__nand2_1
X_17922_ _00793_ _06242_ _06243_ VSS VSS VDD VDD _02545_ sky130_fd_sc_hd__o21ai_0
X_17923_ network.neuron_in240.counter\[1\] network.neuron_in240.counter\[2\]
+ network.neuron_in240.counter\[0\] VSS VSS VDD VDD _06244_
+ sky130_fd_sc_hd__or3_1
X_17924_ net368 _07427_ _06244_ VSS VSS VDD VDD _06245_ sky130_fd_sc_hd__nor3_1
X_17925_ network.in_period\[240\]\[3\] _07427_ _06245_ VSS
+ VSS VDD VDD _06246_ sky130_fd_sc_hd__a21oi_1
X_17926_ network.in_period\[240\]\[3\] net368 VSS VSS VDD
+ VDD _06247_ sky130_fd_sc_hd__and2_1
X_17927_ network.neuron_in240.counter\[3\] net400 _06244_
+ _06247_ VSS VSS VDD VDD _06248_ sky130_fd_sc_hd__a31oi_1
X_17928_ network.neuron_in240.counter\[3\] _06246_ _06248_
+ VSS VSS VDD VDD _03027_ sky130_fd_sc_hd__o21ai_0
X_17929_ network.in_spk08_06 _09014_ network.in_spk09_06 VSS
+ VSS VDD VDD _06249_ sky130_fd_sc_hd__o21ai_0
X_17930_ _04679_ _06249_ net372 VSS VSS VDD VDD _02056_ sky130_fd_sc_hd__a21oi_1
X_17931_ network.in_period\[120\]\[0\] _06242_ VSS VSS VDD
+ VDD _06250_ sky130_fd_sc_hd__nand2_1
X_17932_ network.neuron_in120.counter\[0\] _06242_ _06250_
+ VSS VSS VDD VDD _02544_ sky130_fd_sc_hd__o21ai_0
X_17933_ network.neuron_in241.counter\[0\] network.neuron_in241.counter\[2\]
+ network.neuron_in241.counter\[1\] VSS VSS VDD VDD _06251_
+ sky130_fd_sc_hd__nor3_1
X_17934_ network.neuron_in241.counter\[3\] _06251_ VSS VSS
+ VDD VDD _06252_ sky130_fd_sc_hd__xnor2_1
X_17935_ network.in_period\[241\]\[3\] _07833_ VSS VSS VDD
+ VDD _06253_ sky130_fd_sc_hd__nand2_1
X_17936_ _07833_ _06252_ _06253_ VSS VSS VDD VDD _03031_ sky130_fd_sc_hd__o21ai_0
X_17937_ network.neuron_in242.counter\[0\] network.neuron_in242.counter\[1\]
+ network.neuron_in242.counter\[2\] VSS VSS VDD VDD _06254_
+ sky130_fd_sc_hd__nor3_1
X_17938_ network.neuron_in242.counter\[3\] _06254_ VSS VSS
+ VDD VDD _06255_ sky130_fd_sc_hd__xnor2_1
X_17939_ network.in_period\[242\]\[3\] _07561_ VSS VSS VDD
+ VDD _06256_ sky130_fd_sc_hd__nand2_1
X_17940_ _07561_ _06255_ _06256_ VSS VSS VDD VDD _03035_ sky130_fd_sc_hd__o21ai_0
X_17941_ network.in_spk08_06 _09014_ VSS VSS VDD VDD _06257_
+ sky130_fd_sc_hd__nand2_1
X_17942_ _04682_ _06257_ net372 VSS VSS VDD VDD _02057_ sky130_fd_sc_hd__a21oi_1
X_17943_ _00779_ _07438_ _00778_ VSS VSS VDD VDD _06258_ sky130_fd_sc_hd__nand3_1
X_17944_ net368 _07430_ _06258_ VSS VSS VDD VDD _06259_ sky130_fd_sc_hd__nor3_1
X_17945_ network.in_period\[243\]\[3\] _07430_ _06259_ VSS
+ VSS VDD VDD _06260_ sky130_fd_sc_hd__a21oi_1
X_17946_ network.in_period\[243\]\[3\] net368 VSS VSS VDD
+ VDD _06261_ sky130_fd_sc_hd__and2_1
X_17947_ network.neuron_in243.counter\[3\] net399 _06258_
+ _06261_ VSS VSS VDD VDD _06262_ sky130_fd_sc_hd__a31oi_1
X_17948_ network.neuron_in243.counter\[3\] _06260_ _06262_
+ VSS VSS VDD VDD _03039_ sky130_fd_sc_hd__o21ai_0
X_17949_ network.neuron_in121.counter\[2\] _00125_ VSS VSS
+ VDD VDD _06263_ sky130_fd_sc_hd__xnor2_1
X_17950_ net383 _04641_ network.in_period\[121\]\[2\] VSS
+ VSS VDD VDD _06264_ sky130_fd_sc_hd__a21oi_1
X_17951_ net383 _06263_ _06264_ VSS VSS VDD VDD _02550_ sky130_fd_sc_hd__a21oi_1
X_17952_ network.in_period\[121\]\[1\] _05548_ VSS VSS VDD
+ VDD _06265_ sky130_fd_sc_hd__nand2_1
X_17953_ _00126_ _05548_ _06265_ VSS VSS VDD VDD _02549_ sky130_fd_sc_hd__o21ai_0
X_17954_ _00922_ _07564_ _00923_ VSS VSS VDD VDD _06266_ sky130_fd_sc_hd__nand3_1
X_17955_ net368 _07443_ _06266_ VSS VSS VDD VDD _06267_ sky130_fd_sc_hd__nor3_1
X_17956_ network.in_period\[244\]\[3\] _07443_ _06267_ VSS
+ VSS VDD VDD _06268_ sky130_fd_sc_hd__a21oi_1
X_17957_ network.in_period\[244\]\[3\] net368 VSS VSS VDD
+ VDD _06269_ sky130_fd_sc_hd__and2_1
X_17958_ network.neuron_in244.counter\[3\] net400 _06266_
+ _06269_ VSS VSS VDD VDD _06270_ sky130_fd_sc_hd__a31oi_1
X_17959_ network.neuron_in244.counter\[3\] _06268_ _06270_
+ VSS VSS VDD VDD _03043_ sky130_fd_sc_hd__o21ai_0
X_17960_ network.in_period\[121\]\[0\] _05548_ VSS VSS VDD
+ VDD _06271_ sky130_fd_sc_hd__nand2_1
X_17961_ network.neuron_in121.counter\[0\] _05548_ _06271_
+ VSS VSS VDD VDD _02548_ sky130_fd_sc_hd__o21ai_0
X_17962_ network.in_spk04_06 network.in_spk05_06 network.in_spk06_06
+ _09044_ network.in_spk07_06 VSS VSS VDD VDD _06272_ sky130_fd_sc_hd__o41ai_1
X_17963_ _04684_ _06272_ net372 VSS VSS VDD VDD _02058_ sky130_fd_sc_hd__a21oi_1
X_17964_ network.neuron_in245.counter\[0\] network.neuron_in245.counter\[2\]
+ network.neuron_in245.counter\[1\] VSS VSS VDD VDD _06273_
+ sky130_fd_sc_hd__nor3_1
X_17965_ network.neuron_in245.counter\[3\] _06273_ VSS VSS
+ VDD VDD _06274_ sky130_fd_sc_hd__xnor2_1
X_17966_ network.in_period\[245\]\[3\] _07436_ VSS VSS VDD
+ VDD _06275_ sky130_fd_sc_hd__nand2_1
X_17967_ _07436_ _06274_ _06275_ VSS VSS VDD VDD _03047_ sky130_fd_sc_hd__o21ai_0
X_17968_ network.neuron_in246.counter\[1\] network.neuron_in246.counter\[0\]
+ _00668_ VSS VSS VDD VDD _06276_ sky130_fd_sc_hd__o21bai_1
X_17969_ _07963_ _06276_ network.neuron_in246.counter\[3\]
+ VSS VSS VDD VDD _06277_ sky130_fd_sc_hd__a21oi_1
X_17970_ _07963_ _00667_ network.neuron_in246.counter\[3\]
+ _00666_ _06277_ VSS VSS VDD VDD _06278_ sky130_fd_sc_hd__a41o_1
X_17971_ net399 _07962_ network.in_period\[246\]\[3\] VSS
+ VSS VDD VDD _06279_ sky130_fd_sc_hd__a21oi_1
X_17972_ net399 _06278_ _06279_ VSS VSS VDD VDD _03051_ sky130_fd_sc_hd__a21oi_1
X_17973_ network.in_spk04_06 network.in_spk05_06 _09044_ network.in_spk06_06
+ VSS VSS VDD VDD _06280_ sky130_fd_sc_hd__o31ai_1
X_17974_ _04687_ _06280_ net372 VSS VSS VDD VDD _02059_ sky130_fd_sc_hd__a21oi_1
X_17975_ network.neuron_in247.counter\[1\] network.neuron_in247.counter\[0\]
+ VSS VSS VDD VDD _06281_ sky130_fd_sc_hd__nor2_1
X_17976_ _00758_ _06281_ VSS VSS VDD VDD _06282_ sky130_fd_sc_hd__nor2_1
X_17977_ network.neuron_in247.counter\[2\] _06282_ VSS VSS
+ VDD VDD _06283_ sky130_fd_sc_hd__nor2_1
X_17978_ network.neuron_in247.counter\[2\] network.neuron_in247.counter\[3\]
+ _06281_ VSS VSS VDD VDD _06284_ sky130_fd_sc_hd__nand3b_1
X_17979_ network.neuron_in247.counter\[3\] _06283_ _06284_
+ VSS VSS VDD VDD _06285_ sky130_fd_sc_hd__o21ai_0
X_17980_ net399 _07953_ network.in_period\[247\]\[3\] VSS
+ VSS VDD VDD _06286_ sky130_fd_sc_hd__a21oi_1
X_17981_ net399 _06285_ _06286_ VSS VSS VDD VDD _03055_ sky130_fd_sc_hd__a21oi_1
X_17982_ _00537_ network.neuron_in122.counter\[2\] VSS VSS
+ VDD VDD _06287_ sky130_fd_sc_hd__xnor2_1
X_17983_ net383 _04639_ network.in_period\[122\]\[2\] VSS
+ VSS VDD VDD _06288_ sky130_fd_sc_hd__a21oi_1
X_17984_ net383 _06287_ _06288_ VSS VSS VDD VDD _02554_ sky130_fd_sc_hd__a21oi_1
X_17985_ network.in_period\[122\]\[1\] _05552_ VSS VSS VDD
+ VDD _06289_ sky130_fd_sc_hd__nand2_1
X_17986_ _00538_ _05552_ _06289_ VSS VSS VDD VDD _02553_ sky130_fd_sc_hd__o21ai_0
X_17987_ _00919_ _00918_ _07988_ VSS VSS VDD VDD _06290_ sky130_fd_sc_hd__nand3_1
X_17988_ net368 _07968_ _06290_ VSS VSS VDD VDD _06291_ sky130_fd_sc_hd__nor3_1
X_17989_ network.in_period\[248\]\[3\] _07968_ _06291_ VSS
+ VSS VDD VDD _06292_ sky130_fd_sc_hd__a21oi_1
X_17990_ network.in_period\[248\]\[3\] net368 VSS VSS VDD
+ VDD _06293_ sky130_fd_sc_hd__and2_0
X_17991_ network.neuron_in248.counter\[3\] net399 _06290_
+ _06293_ VSS VSS VDD VDD _06294_ sky130_fd_sc_hd__a31oi_1
X_17992_ network.neuron_in248.counter\[3\] _06292_ _06294_
+ VSS VSS VDD VDD _03059_ sky130_fd_sc_hd__o21ai_0
X_17993_ network.in_period\[122\]\[0\] _05552_ VSS VSS VDD
+ VDD _06295_ sky130_fd_sc_hd__nand2_1
X_17994_ network.neuron_in122.counter\[0\] _05552_ _06295_
+ VSS VSS VDD VDD _02552_ sky130_fd_sc_hd__o21ai_0
X_17995_ network.in_spk04_06 _09044_ network.in_spk05_06 VSS
+ VSS VDD VDD _06296_ sky130_fd_sc_hd__o21ai_0
X_17996_ _04689_ _06296_ net372 VSS VSS VDD VDD _02060_ sky130_fd_sc_hd__a21oi_1
X_17997_ network.neuron_in249.counter\[0\] network.neuron_in249.counter\[2\]
+ network.neuron_in249.counter\[1\] VSS VSS VDD VDD _06297_
+ sky130_fd_sc_hd__nor3_1
X_17998_ network.neuron_in249.counter\[3\] _06297_ VSS VSS
+ VDD VDD _06298_ sky130_fd_sc_hd__xnor2_1
X_17999_ network.in_period\[249\]\[3\] _07993_ VSS VSS VDD
+ VDD _06299_ sky130_fd_sc_hd__nand2_1
X_18000_ _07993_ _06298_ _06299_ VSS VSS VDD VDD _03063_ sky130_fd_sc_hd__o21ai_0
X_18001_ network.neuron_in250.counter\[1\] network.neuron_in250.counter\[0\]
+ network.neuron_in250.counter\[2\] VSS VSS VDD VDD _06300_
+ sky130_fd_sc_hd__nor3_1
X_18002_ network.neuron_in250.counter\[3\] _06300_ VSS VSS
+ VDD VDD _06301_ sky130_fd_sc_hd__xnor2_1
X_18003_ network.in_period\[250\]\[3\] _07996_ VSS VSS VDD
+ VDD _06302_ sky130_fd_sc_hd__nand2_1
X_18004_ _07996_ _06301_ _06302_ VSS VSS VDD VDD _03067_ sky130_fd_sc_hd__o21ai_0
X_18005_ network.in_spk04_06 _09044_ VSS VSS VDD VDD _06303_
+ sky130_fd_sc_hd__nand2_1
X_18006_ _04691_ _06303_ net372 VSS VSS VDD VDD _02061_ sky130_fd_sc_hd__a21oi_1
X_18007_ network.neuron_in123.counter\[2\] _00218_ VSS VSS
+ VDD VDD _06304_ sky130_fd_sc_hd__xnor2_1
X_18008_ net383 _04637_ network.in_period\[123\]\[2\] VSS
+ VSS VDD VDD _06305_ sky130_fd_sc_hd__a21oi_1
X_18009_ net383 _06304_ _06305_ VSS VSS VDD VDD _02558_ sky130_fd_sc_hd__a21oi_1
X_18010_ network.neuron_in251.counter\[1\] network.neuron_in251.counter\[2\]
+ network.neuron_in251.counter\[0\] VSS VSS VDD VDD _06306_
+ sky130_fd_sc_hd__nor3_1
X_18011_ network.neuron_in251.counter\[3\] _06306_ VSS VSS
+ VDD VDD _06307_ sky130_fd_sc_hd__xnor2_1
X_18012_ network.in_period\[251\]\[3\] _07951_ VSS VSS VDD
+ VDD _06308_ sky130_fd_sc_hd__nand2_1
X_18013_ _07951_ _06307_ _06308_ VSS VSS VDD VDD _03071_ sky130_fd_sc_hd__o21ai_0
X_18014_ network.in_period\[123\]\[1\] _05557_ VSS VSS VDD
+ VDD _06309_ sky130_fd_sc_hd__nand2_1
X_18015_ _00219_ _05557_ _06309_ VSS VSS VDD VDD _02557_ sky130_fd_sc_hd__o21ai_0
X_18016_ network.in_period\[123\]\[0\] _05557_ VSS VSS VDD
+ VDD _06310_ sky130_fd_sc_hd__nand2_1
X_18017_ network.neuron_in123.counter\[0\] _05557_ _06310_
+ VSS VSS VDD VDD _02556_ sky130_fd_sc_hd__o21ai_0
X_18018_ network.neuron_in252.counter\[1\] network.neuron_in252.counter\[0\]
+ _00932_ VSS VSS VDD VDD _06311_ sky130_fd_sc_hd__o21bai_1
X_18019_ _08004_ _06311_ network.neuron_in252.counter\[3\]
+ VSS VSS VDD VDD _06312_ sky130_fd_sc_hd__a21oi_1
X_18020_ _08004_ network.neuron_in252.counter\[3\] _00931_
+ _00930_ _06312_ VSS VSS VDD VDD _06313_ sky130_fd_sc_hd__a41o_1
X_18021_ net399 _08003_ network.in_period\[252\]\[3\] VSS
+ VSS VDD VDD _06314_ sky130_fd_sc_hd__a21oi_1
X_18022_ net399 _06313_ _06314_ VSS VSS VDD VDD _03075_ sky130_fd_sc_hd__a21oi_1
X_18023_ _00300_ network.neuron_in124.counter\[2\] VSS VSS
+ VDD VDD _06315_ sky130_fd_sc_hd__xnor2_1
X_18024_ net383 _03715_ network.in_period\[124\]\[2\] VSS
+ VSS VDD VDD _06316_ sky130_fd_sc_hd__a21oi_1
X_18025_ net383 _06315_ _06316_ VSS VSS VDD VDD _02562_ sky130_fd_sc_hd__a21oi_1
X_18026_ network.in_period\[124\]\[1\] _03716_ VSS VSS VDD
+ VDD _06317_ sky130_fd_sc_hd__nand2_1
X_18027_ _00301_ _03716_ _06317_ VSS VSS VDD VDD _02561_ sky130_fd_sc_hd__o21ai_0
X_18028_ network.in_spk02_06 network.in_spk01_06 _09303_ VSS
+ VSS VDD VDD _06318_ sky130_fd_sc_hd__or3_1
X_18029_ network.in_spk03_06 _06318_ _04693_ VSS VSS VDD VDD
+ _06319_ sky130_fd_sc_hd__a21boi_0
X_18030_ net372 _06319_ VSS VSS VDD VDD _02062_ sky130_fd_sc_hd__nor2_1
X_18031_ network.neuron_in253.counter\[1\] network.neuron_in253.counter\[2\]
+ network.neuron_in253.counter\[0\] VSS VSS VDD VDD _06320_
+ sky130_fd_sc_hd__nor3_1
X_18032_ network.neuron_in253.counter\[3\] _06320_ VSS VSS
+ VDD VDD _06321_ sky130_fd_sc_hd__xnor2_1
X_18033_ network.in_period\[253\]\[3\] _08001_ VSS VSS VDD
+ VDD _06322_ sky130_fd_sc_hd__nand2_1
X_18034_ _08001_ _06321_ _06322_ VSS VSS VDD VDD _03079_ sky130_fd_sc_hd__o21ai_0
X_18035_ network.neuron_in254.counter\[1\] network.neuron_in254.counter\[2\]
+ network.neuron_in254.counter\[0\] VSS VSS VDD VDD _06323_
+ sky130_fd_sc_hd__nor3_1
X_18036_ network.neuron_in254.counter\[3\] _06323_ VSS VSS
+ VDD VDD _06324_ sky130_fd_sc_hd__xnor2_1
X_18037_ network.in_period\[254\]\[3\] _08012_ VSS VSS VDD
+ VDD _06325_ sky130_fd_sc_hd__nand2_1
X_18038_ _08012_ _06324_ _06325_ VSS VSS VDD VDD _03083_ sky130_fd_sc_hd__o21ai_0
X_18039_ network.in_spk00_06 network.in_spk01_06 _09013_ network.in_spk02_06
+ VSS VSS VDD VDD _06326_ sky130_fd_sc_hd__o31ai_1
X_18040_ _04695_ _06326_ net372 VSS VSS VDD VDD _02063_ sky130_fd_sc_hd__a21oi_1
X_18041_ network.neuron_in255.counter\[1\] network.neuron_in255.counter\[2\]
+ network.neuron_in255.counter\[0\] VSS VSS VDD VDD _06327_
+ sky130_fd_sc_hd__nor3_1
X_18042_ network.neuron_in255.counter\[3\] _06327_ VSS VSS
+ VDD VDD _06328_ sky130_fd_sc_hd__xnor2_1
X_18043_ network.in_period\[255\]\[3\] _08016_ VSS VSS VDD
+ VDD _06329_ sky130_fd_sc_hd__nand2_1
X_18044_ _08016_ _06328_ _06329_ VSS VSS VDD VDD _03087_ sky130_fd_sc_hd__o21ai_0
X_18045_ net300 net285 VSS VSS VDD VDD _03300_ sky130_fd_sc_hd__nor2_1
X_18046_ network.in_period\[152\]\[1\] _06401_ VSS VSS VDD
+ VDD _06330_ sky130_fd_sc_hd__nand2_1
X_18047_ _00479_ _06401_ _06330_ VSS VSS VDD VDD _02673_ sky130_fd_sc_hd__o21ai_0
X_18048_ network.neuron_in152.counter\[3\] network.in_period\[152\]\[2\]
+ net376 _00478_ VSS VSS VDD VDD _06331_ sky130_fd_sc_hd__o22ai_1
X_18049_ network.neuron_in152.counter\[2\] _00478_ net401
+ VSS VSS VDD VDD _06332_ sky130_fd_sc_hd__nand3_1
X_18050_ network.in_period\[152\]\[2\] net401 _06332_ VSS
+ VSS VDD VDD _06333_ sky130_fd_sc_hd__o21ai_0
X_18051_ _05718_ _06331_ _06333_ VSS VSS VDD VDD _02674_ sky130_fd_sc_hd__a21oi_1
X_18052_ net400 _04628_ VSS VSS VDD VDD _06334_ sky130_fd_sc_hd__nand2_1
X_18053_ network.in_period\[151\]\[0\] _06334_ VSS VSS VDD
+ VDD _06335_ sky130_fd_sc_hd__nand2_1
X_18054_ network.neuron_in151.counter\[0\] _06334_ _06335_
+ VSS VSS VDD VDD _02668_ sky130_fd_sc_hd__o21ai_0
X_18055_ network.in_period\[151\]\[1\] _06334_ VSS VSS VDD
+ VDD _06336_ sky130_fd_sc_hd__nand2_1
X_18056_ _00483_ _06334_ _06336_ VSS VSS VDD VDD _02669_ sky130_fd_sc_hd__o21ai_0
X_18057_ network.neuron_in151.counter\[3\] network.in_period\[151\]\[2\]
+ net381 _00482_ VSS VSS VDD VDD _06337_ sky130_fd_sc_hd__o22ai_1
X_18058_ network.neuron_in151.counter\[2\] _00482_ net400
+ VSS VSS VDD VDD _06338_ sky130_fd_sc_hd__nand3_1
X_18059_ network.in_period\[151\]\[2\] net400 _06338_ VSS
+ VSS VDD VDD _06339_ sky130_fd_sc_hd__o21ai_0
X_18060_ _04626_ _06337_ _06339_ VSS VSS VDD VDD _02670_ sky130_fd_sc_hd__a21oi_1
X_18061_ network.in_period\[150\]\[0\] _05700_ VSS VSS VDD
+ VDD _06340_ sky130_fd_sc_hd__nand2_1
X_18062_ network.neuron_in150.counter\[0\] _05700_ _06340_
+ VSS VSS VDD VDD _02664_ sky130_fd_sc_hd__o21ai_0
X_18063_ network.in_period\[150\]\[1\] _05700_ VSS VSS VDD
+ VDD _06341_ sky130_fd_sc_hd__nand2_1
X_18064_ _00495_ _05700_ _06341_ VSS VSS VDD VDD _02665_ sky130_fd_sc_hd__o21ai_0
X_18065_ network.neuron_in150.counter\[2\] _00494_ VSS VSS
+ VDD VDD _06342_ sky130_fd_sc_hd__xnor2_1
X_18066_ net401 _04629_ network.in_period\[150\]\[2\] VSS
+ VSS VDD VDD _06343_ sky130_fd_sc_hd__a21oi_1
X_18067_ net401 _06342_ _06343_ VSS VSS VDD VDD _02666_ sky130_fd_sc_hd__a21oi_1
X_18068_ network.in_period\[149\]\[0\] _05693_ VSS VSS VDD
+ VDD _06344_ sky130_fd_sc_hd__nand2_1
X_18069_ network.neuron_in149.counter\[0\] _05693_ _06344_
+ VSS VSS VDD VDD _02660_ sky130_fd_sc_hd__o21ai_0
X_18070_ network.in_period\[149\]\[1\] _05693_ VSS VSS VDD
+ VDD _06345_ sky130_fd_sc_hd__nand2_1
X_18071_ _00507_ _05693_ _06345_ VSS VSS VDD VDD _02661_ sky130_fd_sc_hd__o21ai_0
X_18072_ _00506_ network.neuron_in149.counter\[2\] VSS VSS
+ VDD VDD _06346_ sky130_fd_sc_hd__xnor2_1
X_18073_ net403 _04631_ network.in_period\[149\]\[2\] VSS
+ VSS VDD VDD _06347_ sky130_fd_sc_hd__a21oi_1
X_18074_ net403 _06346_ _06347_ VSS VSS VDD VDD _02662_ sky130_fd_sc_hd__a21oi_1
X_18075_ net403 _04634_ VSS VSS VDD VDD _06348_ sky130_fd_sc_hd__nand2_1
X_18076_ network.in_period\[148\]\[0\] _06348_ VSS VSS VDD
+ VDD _06349_ sky130_fd_sc_hd__nand2_1
X_18077_ network.neuron_in148.counter\[0\] _06348_ _06349_
+ VSS VSS VDD VDD _02656_ sky130_fd_sc_hd__o21ai_0
X_18078_ network.in_period\[148\]\[1\] _06348_ VSS VSS VDD
+ VDD _06350_ sky130_fd_sc_hd__nand2_1
X_18079_ _00594_ _06348_ _06350_ VSS VSS VDD VDD _02657_ sky130_fd_sc_hd__o21ai_0
X_18080_ network.neuron_in148.counter\[2\] net403 VSS VSS
+ VDD VDD _06351_ sky130_fd_sc_hd__nand2_1
X_18081_ network.neuron_in148.counter\[3\] network.in_period\[148\]\[2\]
+ _06351_ VSS VSS VDD VDD _06352_ sky130_fd_sc_hd__o21ai_0
X_18082_ _00593_ network.neuron_in148.counter\[2\] net369
+ VSS VSS VDD VDD _06353_ sky130_fd_sc_hd__or3_1
X_18083_ network.in_period\[148\]\[2\] net403 _06353_ VSS
+ VSS VDD VDD _06354_ sky130_fd_sc_hd__o21ai_0
X_18084_ _00593_ _06352_ _06354_ VSS VSS VDD VDD _02658_ sky130_fd_sc_hd__a21oi_1
X_18085_ network.neuron_hid6.IF0.membrane_potential\[1\] network.neuron_hid6.IF0.input_current\[1\]
+ _00000_ VSS VSS VDD VDD _00001_ network.neuron_hid6.IF0.add_out\[1\]
+ sky130_fd_sc_hd__fa_1
X_18086_ network.neuron_hid3.IF0.membrane_potential\[1\] network.neuron_hid3.IF0.input_current\[1\]
+ _00002_ VSS VSS VDD VDD _00003_ network.neuron_hid3.IF0.add_out\[1\]
+ sky130_fd_sc_hd__fa_1
X_18087_ network.neuron_hid7.IF0.membrane_potential\[1\] network.neuron_hid7.IF0.input_current\[1\]
+ _00004_ VSS VSS VDD VDD _00005_ network.neuron_hid7.IF0.add_out\[1\]
+ sky130_fd_sc_hd__fa_1
X_18088_ network.neuron_out2.IF0.membrane_potential\[1\] network.neuron_out2.IF0.input_current\[1\]
+ _00006_ VSS VSS VDD VDD _00007_ _00008_ sky130_fd_sc_hd__fa_1
X_18089_ network.neuron_hid1.IF0.membrane_potential\[1\] network.neuron_hid1.IF0.input_current\[1\]
+ _00009_ VSS VSS VDD VDD _00010_ network.neuron_hid1.IF0.add_out\[1\]
+ sky130_fd_sc_hd__fa_1
X_18090_ network.neuron_out0.IF0.membrane_potential\[1\] network.neuron_out0.IF0.input_current\[1\]
+ _00011_ VSS VSS VDD VDD _00012_ _00013_ sky130_fd_sc_hd__fa_1
X_18091_ network.neuron_out1.IF0.membrane_potential\[1\] network.neuron_out1.IF0.input_current\[1\]
+ _00014_ VSS VSS VDD VDD _00015_ _00016_ sky130_fd_sc_hd__fa_1
X_18092_ network.neuron_hid0.IF0.membrane_potential\[1\] network.neuron_hid0.IF0.input_current\[1\]
+ _00017_ VSS VSS VDD VDD _00018_ network.neuron_hid0.IF0.add_out\[1\]
+ sky130_fd_sc_hd__fa_1
X_18093_ network.neuron_hid4.IF0.membrane_potential\[1\] network.neuron_hid4.IF0.input_current\[1\]
+ _00019_ VSS VSS VDD VDD _00020_ network.neuron_hid4.IF0.add_out\[1\]
+ sky130_fd_sc_hd__fa_1
X_18094_ network.neuron_hid2.IF0.membrane_potential\[1\] network.neuron_hid2.IF0.input_current\[1\]
+ _00021_ VSS VSS VDD VDD _00022_ network.neuron_hid2.IF0.add_out\[1\]
+ sky130_fd_sc_hd__fa_1
X_18095_ network.neuron_hid5.IF0.membrane_potential\[1\] network.neuron_hid5.IF0.input_current\[1\]
+ _00023_ VSS VSS VDD VDD _00024_ network.neuron_hid5.IF0.add_out\[1\]
+ sky130_fd_sc_hd__fa_1
X_18096_ network.neuron_out3.IF0.membrane_potential\[1\] network.neuron_out3.IF0.input_current\[1\]
+ _00025_ VSS VSS VDD VDD _00026_ _00027_ sky130_fd_sc_hd__fa_1
X_18097_ network.neuron_out5.IF0.membrane_potential\[1\] network.neuron_out5.IF0.input_current\[1\]
+ _00028_ VSS VSS VDD VDD _00029_ _00030_ sky130_fd_sc_hd__fa_1
X_18098_ network.neuron_out4.IF0.membrane_potential\[1\] network.neuron_out4.IF0.input_current\[1\]
+ _00031_ VSS VSS VDD VDD _00032_ _00033_ sky130_fd_sc_hd__fa_1
X_18099_ _00034_ _00035_ VSS VSS VDD VDD _00036_ _00037_ sky130_fd_sc_hd__ha_1
X_18100_ _00038_ _00039_ VSS VSS VDD VDD _00040_ _00041_ sky130_fd_sc_hd__ha_1
X_18101_ _00042_ _00043_ VSS VSS VDD VDD _00044_ _00045_ sky130_fd_sc_hd__ha_1
X_18102_ _00046_ _00047_ VSS VSS VDD VDD _00048_ _00049_ sky130_fd_sc_hd__ha_1
X_18103_ _00050_ _00051_ VSS VSS VDD VDD _00052_ _00053_ sky130_fd_sc_hd__ha_1
X_18104_ _00054_ _00055_ VSS VSS VDD VDD _00056_ _00057_ sky130_fd_sc_hd__ha_1
X_18105_ _00058_ _00059_ VSS VSS VDD VDD _00060_ _00061_ sky130_fd_sc_hd__ha_1
X_18106_ _00062_ _00063_ VSS VSS VDD VDD _00064_ _00065_ sky130_fd_sc_hd__ha_1
X_18107_ network.neuron_hid1.IF0.membrane_potential\[2\] network.neuron_hid1.IF0.input_current\[2\]
+ VSS VSS VDD VDD _00066_ _00067_ sky130_fd_sc_hd__ha_1
X_18108_ _00068_ _00069_ VSS VSS VDD VDD _00070_ _00071_ sky130_fd_sc_hd__ha_1
X_18109_ _00072_ _00073_ VSS VSS VDD VDD _00074_ _00075_ sky130_fd_sc_hd__ha_1
X_18110_ network.neuron_hid1.IF0.membrane_potential\[1\] network.neuron_hid1.IF0.input_current\[1\]
+ VSS VSS VDD VDD _00076_ _00077_ sky130_fd_sc_hd__ha_1
X_18111_ _00078_ _00079_ VSS VSS VDD VDD _00080_ _00081_ sky130_fd_sc_hd__ha_1
X_18112_ _00082_ _00083_ VSS VSS VDD VDD _00084_ _00085_ sky130_fd_sc_hd__ha_1
X_18113_ network.neuron_hid6.IF0.membrane_potential\[4\] network.neuron_hid6.IF0.input_current\[4\]
+ VSS VSS VDD VDD _00087_ _00088_ sky130_fd_sc_hd__ha_1
X_18114_ _00089_ _00090_ VSS VSS VDD VDD _00091_ _00092_ sky130_fd_sc_hd__ha_1
X_18115_ network.neuron_out4.IF0.membrane_potential\[3\] network.neuron_out4.IF0.input_current\[0\]
+ VSS VSS VDD VDD _00093_ _00094_ sky130_fd_sc_hd__ha_1
X_18116_ _00096_ _00097_ VSS VSS VDD VDD _00098_ _00099_ sky130_fd_sc_hd__ha_1
X_18117_ _00101_ _00102_ VSS VSS VDD VDD _00103_ _00104_ sky130_fd_sc_hd__ha_1
X_18118_ _00105_ _00106_ VSS VSS VDD VDD _00107_ _00108_ sky130_fd_sc_hd__ha_1
X_18119_ _00109_ _00110_ VSS VSS VDD VDD _00111_ _00112_ sky130_fd_sc_hd__ha_1
X_18120_ _00113_ _00114_ VSS VSS VDD VDD _00115_ _00116_ sky130_fd_sc_hd__ha_1
X_18121_ network.neuron_hid6.IF0.membrane_potential\[0\] network.neuron_hid6.IF0.input_current\[0\]
+ VSS VSS VDD VDD _00000_ network.neuron_hid6.IF0.add_out\[0\]
+ sky130_fd_sc_hd__ha_1
X_18122_ _00117_ _00118_ VSS VSS VDD VDD _00119_ _00120_ sky130_fd_sc_hd__ha_1
X_18123_ network.neuron_hid7.IF0.membrane_potential\[2\] network.neuron_hid7.IF0.input_current\[2\]
+ VSS VSS VDD VDD _00121_ _00122_ sky130_fd_sc_hd__ha_1
X_18124_ _00123_ _00124_ VSS VSS VDD VDD _00125_ _00126_ sky130_fd_sc_hd__ha_1
X_18125_ network.neuron_out5.IF0.membrane_potential\[1\] network.neuron_out5.IF0.input_current\[1\]
+ VSS VSS VDD VDD _00127_ _00128_ sky130_fd_sc_hd__ha_1
X_18126_ _00129_ _00130_ VSS VSS VDD VDD _00131_ _00132_ sky130_fd_sc_hd__ha_1
X_18127_ _00133_ _00134_ VSS VSS VDD VDD _00135_ _00136_ sky130_fd_sc_hd__ha_1
X_18128_ _00137_ _00138_ VSS VSS VDD VDD _00139_ _00140_ sky130_fd_sc_hd__ha_1
X_18129_ network.neuron_out1.IF0.membrane_potential\[3\] network.neuron_out1.IF0.input_current\[3\]
+ VSS VSS VDD VDD _00141_ _00142_ sky130_fd_sc_hd__ha_1
X_18130_ _00143_ _00144_ VSS VSS VDD VDD _00145_ _00146_ sky130_fd_sc_hd__ha_1
X_18131_ network.neuron_out5.IF0.membrane_potential\[3\] network.neuron_out5.IF0.input_current\[3\]
+ VSS VSS VDD VDD _00147_ _00148_ sky130_fd_sc_hd__ha_1
X_18132_ _00149_ _00150_ VSS VSS VDD VDD _00151_ _00152_ sky130_fd_sc_hd__ha_1
X_18133_ network.neuron_out5.IF0.membrane_potential\[5\] network.neuron_out5.IF0.input_current\[5\]
+ VSS VSS VDD VDD _00153_ _00154_ sky130_fd_sc_hd__ha_1
X_18134_ _00155_ _00156_ VSS VSS VDD VDD _00157_ _00158_ sky130_fd_sc_hd__ha_1
X_18135_ network.neuron_hid7.IF0.membrane_potential\[0\] network.neuron_hid7.IF0.input_current\[0\]
+ VSS VSS VDD VDD _00004_ network.neuron_hid7.IF0.add_out\[0\]
+ sky130_fd_sc_hd__ha_1
X_18136_ network.neuron_out3.IF0.membrane_potential\[3\] network.neuron_out3.IF0.input_current\[3\]
+ VSS VSS VDD VDD _00159_ _00160_ sky130_fd_sc_hd__ha_1
X_18137_ network.neuron_out2.IF0.membrane_potential\[0\] network.neuron_out2.IF0.input_current\[0\]
+ VSS VSS VDD VDD _00006_ _00161_ sky130_fd_sc_hd__ha_1
X_18138_ network.neuron_out0.IF0.membrane_potential\[4\] network.neuron_out0.IF0.input_current\[4\]
+ VSS VSS VDD VDD _00162_ _00163_ sky130_fd_sc_hd__ha_1
X_18139_ network.neuron_hid0.IF0.membrane_potential\[1\] network.neuron_hid0.IF0.input_current\[1\]
+ VSS VSS VDD VDD _00164_ _00165_ sky130_fd_sc_hd__ha_1
X_18140_ network.neuron_out5.IF0.membrane_potential\[6\] network.neuron_out5.IF0.input_current\[6\]
+ VSS VSS VDD VDD _00166_ _00167_ sky130_fd_sc_hd__ha_1
X_18141_ _00168_ _00169_ VSS VSS VDD VDD _00170_ _00171_ sky130_fd_sc_hd__ha_1
X_18142_ _00172_ _00173_ VSS VSS VDD VDD _00174_ _00175_ sky130_fd_sc_hd__ha_1
X_18143_ network.neuron_out3.IF0.membrane_potential\[2\] network.neuron_out3.IF0.input_current\[2\]
+ VSS VSS VDD VDD _00176_ _00177_ sky130_fd_sc_hd__ha_1
X_18144_ network.neuron_out4.IF0.membrane_potential\[1\] network.neuron_out4.IF0.input_current\[1\]
+ VSS VSS VDD VDD _00178_ _00179_ sky130_fd_sc_hd__ha_1
X_18145_ network.neuron_out5.IF0.membrane_potential\[2\] network.neuron_out0.IF0.input_current\[2\]
+ VSS VSS VDD VDD _00180_ _00181_ sky130_fd_sc_hd__ha_1
X_18146_ _00182_ _00183_ VSS VSS VDD VDD _00184_ _00185_ sky130_fd_sc_hd__ha_1
X_18147_ _00186_ _00187_ VSS VSS VDD VDD _00188_ _00189_ sky130_fd_sc_hd__ha_1
X_18148_ _00190_ _00191_ VSS VSS VDD VDD _00192_ _00193_ sky130_fd_sc_hd__ha_1
X_18149_ _00194_ _00195_ VSS VSS VDD VDD _00196_ _00197_ sky130_fd_sc_hd__ha_1
X_18150_ network.neuron_hid3.IF0.membrane_potential\[2\] network.neuron_hid3.IF0.input_current\[2\]
+ VSS VSS VDD VDD _00198_ _00199_ sky130_fd_sc_hd__ha_1
X_18151_ _00200_ _00201_ VSS VSS VDD VDD _00202_ _00203_ sky130_fd_sc_hd__ha_1
X_18152_ _00204_ _00205_ VSS VSS VDD VDD _00206_ _00207_ sky130_fd_sc_hd__ha_1
X_18153_ _00208_ _00209_ VSS VSS VDD VDD _00210_ _00211_ sky130_fd_sc_hd__ha_1
X_18154_ _00212_ _00213_ VSS VSS VDD VDD _00214_ _00215_ sky130_fd_sc_hd__ha_1
X_18155_ _00216_ _00217_ VSS VSS VDD VDD _00218_ _00219_ sky130_fd_sc_hd__ha_1
X_18156_ _00220_ _00221_ VSS VSS VDD VDD _00222_ _00223_ sky130_fd_sc_hd__ha_1
X_18157_ _00224_ _00225_ VSS VSS VDD VDD _00226_ _00227_ sky130_fd_sc_hd__ha_1
X_18158_ _00228_ _00229_ VSS VSS VDD VDD _00230_ _00231_ sky130_fd_sc_hd__ha_1
X_18159_ _00232_ _00233_ VSS VSS VDD VDD _00234_ _00235_ sky130_fd_sc_hd__ha_1
X_18160_ _00236_ _00237_ VSS VSS VDD VDD _00238_ _00239_ sky130_fd_sc_hd__ha_1
X_18161_ _00240_ _00241_ VSS VSS VDD VDD _00242_ _00243_ sky130_fd_sc_hd__ha_1
X_18162_ network.neuron_hid4.IF0.membrane_potential\[4\] network.neuron_hid4.IF0.input_current\[4\]
+ VSS VSS VDD VDD _00244_ _00245_ sky130_fd_sc_hd__ha_1
X_18163_ _00246_ _00247_ VSS VSS VDD VDD _00248_ _00249_ sky130_fd_sc_hd__ha_1
X_18164_ _00250_ _00251_ VSS VSS VDD VDD _00252_ _00253_ sky130_fd_sc_hd__ha_1
X_18165_ _00254_ _00255_ VSS VSS VDD VDD _00256_ _00257_ sky130_fd_sc_hd__ha_1
X_18166_ _00258_ _00259_ VSS VSS VDD VDD _00260_ _00261_ sky130_fd_sc_hd__ha_1
X_18167_ _00262_ _00263_ VSS VSS VDD VDD _00264_ _00265_ sky130_fd_sc_hd__ha_1
X_18168_ _00266_ _00267_ VSS VSS VDD VDD _00268_ _00269_ sky130_fd_sc_hd__ha_1
X_18169_ _00270_ _00271_ VSS VSS VDD VDD _00272_ _00273_ sky130_fd_sc_hd__ha_1
X_18170_ _00274_ _00275_ VSS VSS VDD VDD _00276_ _00277_ sky130_fd_sc_hd__ha_1
X_18171_ _00278_ _00279_ VSS VSS VDD VDD _00280_ _00281_ sky130_fd_sc_hd__ha_1
X_18172_ _00282_ _00283_ VSS VSS VDD VDD _00284_ _00285_ sky130_fd_sc_hd__ha_1
X_18173_ _00286_ _00287_ VSS VSS VDD VDD _00288_ _00289_ sky130_fd_sc_hd__ha_1
X_18174_ _00290_ _00291_ VSS VSS VDD VDD _00292_ _00293_ sky130_fd_sc_hd__ha_1
X_18175_ _00294_ _00295_ VSS VSS VDD VDD _00296_ _00297_ sky130_fd_sc_hd__ha_1
X_18176_ _00298_ _00299_ VSS VSS VDD VDD _00300_ _00301_ sky130_fd_sc_hd__ha_1
X_18177_ _00302_ _00303_ VSS VSS VDD VDD _00304_ _00305_ sky130_fd_sc_hd__ha_1
X_18178_ _00306_ _00307_ VSS VSS VDD VDD _00308_ _00309_ sky130_fd_sc_hd__ha_1
X_18179_ _00310_ _00311_ VSS VSS VDD VDD _00312_ _00313_ sky130_fd_sc_hd__ha_1
X_18180_ _00315_ _00316_ VSS VSS VDD VDD _00317_ _00318_ sky130_fd_sc_hd__ha_1
X_18181_ network.neuron_out3.IF0.membrane_potential\[0\] network.neuron_out3.IF0.input_current\[0\]
+ VSS VSS VDD VDD _00025_ _00319_ sky130_fd_sc_hd__ha_1
X_18182_ network.neuron_hid7.IF0.membrane_potential\[5\] network.neuron_hid2.IF0.input_current\[5\]
+ VSS VSS VDD VDD _00320_ _00321_ sky130_fd_sc_hd__ha_1
X_18183_ network.neuron_out4.IF0.membrane_potential\[4\] network.neuron_out4.IF0.input_current\[4\]
+ VSS VSS VDD VDD _00322_ _00323_ sky130_fd_sc_hd__ha_1
X_18184_ network.neuron_out4.IF0.membrane_potential\[0\] network.neuron_out4.IF0.input_current\[0\]
+ VSS VSS VDD VDD _00031_ _00324_ sky130_fd_sc_hd__ha_1
X_18185_ network.neuron_out3.IF0.membrane_potential\[1\] network.neuron_out3.IF0.input_current\[1\]
+ VSS VSS VDD VDD _00325_ _00326_ sky130_fd_sc_hd__ha_1
X_18186_ _00327_ _00328_ VSS VSS VDD VDD _00329_ _00330_ sky130_fd_sc_hd__ha_1
X_18187_ _00331_ _00332_ VSS VSS VDD VDD _00333_ _00334_ sky130_fd_sc_hd__ha_1
X_18188_ _00335_ _00336_ VSS VSS VDD VDD _00337_ _00338_ sky130_fd_sc_hd__ha_1
X_18189_ _00339_ _00340_ VSS VSS VDD VDD _00341_ _00342_ sky130_fd_sc_hd__ha_1
X_18190_ _00343_ _00344_ VSS VSS VDD VDD _00345_ _00346_ sky130_fd_sc_hd__ha_1
X_18191_ _00347_ _00348_ VSS VSS VDD VDD _00349_ _00350_ sky130_fd_sc_hd__ha_1
X_18192_ _00351_ _00352_ VSS VSS VDD VDD _00353_ _00354_ sky130_fd_sc_hd__ha_1
X_18193_ _00355_ _00356_ VSS VSS VDD VDD _00357_ _00358_ sky130_fd_sc_hd__ha_1
X_18194_ _00359_ _00360_ VSS VSS VDD VDD _00361_ _00362_ sky130_fd_sc_hd__ha_1
X_18195_ _00363_ _00364_ VSS VSS VDD VDD _00365_ _00366_ sky130_fd_sc_hd__ha_1
X_18196_ _00367_ _00368_ VSS VSS VDD VDD _00369_ _00370_ sky130_fd_sc_hd__ha_1
X_18197_ _00371_ _00372_ VSS VSS VDD VDD _00373_ _00374_ sky130_fd_sc_hd__ha_1
X_18198_ _00375_ _00376_ VSS VSS VDD VDD _00377_ _00378_ sky130_fd_sc_hd__ha_1
X_18199_ network.neuron_hid7.IF0.membrane_potential\[6\] network.neuron_hid2.IF0.input_current\[6\]
+ VSS VSS VDD VDD _00379_ _00380_ sky130_fd_sc_hd__ha_1
X_18200_ _00381_ _00382_ VSS VSS VDD VDD _00383_ _00384_ sky130_fd_sc_hd__ha_1
X_18201_ network.neuron_hid3.IF0.membrane_potential\[1\] network.neuron_hid3.IF0.input_current\[1\]
+ VSS VSS VDD VDD _00385_ _00095_ sky130_fd_sc_hd__ha_1
X_18202_ _00386_ _00387_ VSS VSS VDD VDD _00388_ _00389_ sky130_fd_sc_hd__ha_1
X_18203_ _00390_ _00391_ VSS VSS VDD VDD _00392_ _00393_ sky130_fd_sc_hd__ha_1
X_18204_ _00394_ _00395_ VSS VSS VDD VDD _00396_ _00397_ sky130_fd_sc_hd__ha_1
X_18205_ _00398_ _00399_ VSS VSS VDD VDD _00400_ _00401_ sky130_fd_sc_hd__ha_1
X_18206_ _00402_ _00403_ VSS VSS VDD VDD _00404_ _00405_ sky130_fd_sc_hd__ha_1
X_18207_ _00406_ _00407_ VSS VSS VDD VDD _00408_ _00409_ sky130_fd_sc_hd__ha_1
X_18208_ _00410_ _00411_ VSS VSS VDD VDD _00412_ _00413_ sky130_fd_sc_hd__ha_1
X_18209_ _00414_ _00415_ VSS VSS VDD VDD _00416_ _00417_ sky130_fd_sc_hd__ha_1
X_18210_ _00418_ _00419_ VSS VSS VDD VDD _00420_ _00421_ sky130_fd_sc_hd__ha_1
X_18211_ _00422_ _00423_ VSS VSS VDD VDD _00424_ _00425_ sky130_fd_sc_hd__ha_1
X_18212_ _00426_ _00427_ VSS VSS VDD VDD _00428_ _00429_ sky130_fd_sc_hd__ha_1
X_18213_ _00430_ _00431_ VSS VSS VDD VDD _00432_ _00433_ sky130_fd_sc_hd__ha_1
X_18214_ _00434_ _00435_ VSS VSS VDD VDD _00436_ _00437_ sky130_fd_sc_hd__ha_1
X_18215_ _00438_ _00439_ VSS VSS VDD VDD _00440_ _00441_ sky130_fd_sc_hd__ha_1
X_18216_ _00442_ _00443_ VSS VSS VDD VDD _00444_ _00445_ sky130_fd_sc_hd__ha_1
X_18217_ network.neuron_hid6.IF0.membrane_potential\[3\] network.neuron_hid6.IF0.input_current\[3\]
+ VSS VSS VDD VDD _00446_ _00447_ sky130_fd_sc_hd__ha_1
X_18218_ _00448_ _00449_ VSS VSS VDD VDD _00450_ _00451_ sky130_fd_sc_hd__ha_1
X_18219_ _00452_ _00453_ VSS VSS VDD VDD _00454_ _00455_ sky130_fd_sc_hd__ha_1
X_18220_ _00456_ _00457_ VSS VSS VDD VDD _00458_ _00459_ sky130_fd_sc_hd__ha_1
X_18221_ _00460_ _00461_ VSS VSS VDD VDD _00462_ _00463_ sky130_fd_sc_hd__ha_1
X_18222_ _00464_ _00465_ VSS VSS VDD VDD _00466_ _00467_ sky130_fd_sc_hd__ha_1
X_18223_ _00468_ _00469_ VSS VSS VDD VDD _00470_ _00471_ sky130_fd_sc_hd__ha_1
X_18224_ _00472_ _00473_ VSS VSS VDD VDD _00474_ _00475_ sky130_fd_sc_hd__ha_1
X_18225_ _00476_ _00477_ VSS VSS VDD VDD _00478_ _00479_ sky130_fd_sc_hd__ha_1
X_18226_ _00480_ _00481_ VSS VSS VDD VDD _00482_ _00483_ sky130_fd_sc_hd__ha_1
X_18227_ _00484_ _00485_ VSS VSS VDD VDD _00486_ _00487_ sky130_fd_sc_hd__ha_1
X_18228_ _00488_ _00489_ VSS VSS VDD VDD _00490_ _00491_ sky130_fd_sc_hd__ha_1
X_18229_ _00492_ _00493_ VSS VSS VDD VDD _00494_ _00495_ sky130_fd_sc_hd__ha_1
X_18230_ _00496_ _00497_ VSS VSS VDD VDD _00498_ _00499_ sky130_fd_sc_hd__ha_1
X_18231_ _00500_ _00501_ VSS VSS VDD VDD _00502_ _00503_ sky130_fd_sc_hd__ha_1
X_18232_ _00504_ _00505_ VSS VSS VDD VDD _00506_ _00507_ sky130_fd_sc_hd__ha_1
X_18233_ _00509_ _00510_ VSS VSS VDD VDD _00511_ _00512_ sky130_fd_sc_hd__ha_1
X_18234_ _00513_ _00514_ VSS VSS VDD VDD _00515_ _00516_ sky130_fd_sc_hd__ha_1
X_18235_ _00517_ _00518_ VSS VSS VDD VDD _00519_ _00520_ sky130_fd_sc_hd__ha_1
X_18236_ _00521_ _00522_ VSS VSS VDD VDD _00523_ _00524_ sky130_fd_sc_hd__ha_1
X_18237_ _00525_ _00526_ VSS VSS VDD VDD _00527_ _00528_ sky130_fd_sc_hd__ha_1
X_18238_ _00529_ _00530_ VSS VSS VDD VDD _00531_ _00532_ sky130_fd_sc_hd__ha_1
X_18239_ network.neuron_hid5.IF0.membrane_potential\[1\] network.neuron_hid5.IF0.input_current\[1\]
+ VSS VSS VDD VDD _00533_ _00534_ sky130_fd_sc_hd__ha_1
X_18240_ network.neuron_hid5.IF0.membrane_potential\[0\] network.neuron_hid5.IF0.input_current\[0\]
+ VSS VSS VDD VDD _00023_ network.neuron_hid5.IF0.add_out\[0\]
+ sky130_fd_sc_hd__ha_1
X_18241_ _00535_ _00536_ VSS VSS VDD VDD _00537_ _00538_ sky130_fd_sc_hd__ha_1
X_18242_ _00539_ _00540_ VSS VSS VDD VDD _00541_ _00542_ sky130_fd_sc_hd__ha_1
X_18243_ _00543_ _00544_ VSS VSS VDD VDD _00545_ _00546_ sky130_fd_sc_hd__ha_1
X_18244_ _00547_ _00548_ VSS VSS VDD VDD _00549_ _00550_ sky130_fd_sc_hd__ha_1
X_18245_ _00551_ _00552_ VSS VSS VDD VDD _00553_ _00554_ sky130_fd_sc_hd__ha_1
X_18246_ _00555_ _00556_ VSS VSS VDD VDD _00557_ _00558_ sky130_fd_sc_hd__ha_1
X_18247_ _00559_ _00560_ VSS VSS VDD VDD _00561_ _00562_ sky130_fd_sc_hd__ha_1
X_18248_ _00563_ _00564_ VSS VSS VDD VDD _00565_ _00566_ sky130_fd_sc_hd__ha_1
X_18249_ _00567_ _00568_ VSS VSS VDD VDD _00569_ _00570_ sky130_fd_sc_hd__ha_1
X_18250_ _00571_ _00572_ VSS VSS VDD VDD _00573_ _00574_ sky130_fd_sc_hd__ha_1
X_18251_ _00575_ _00576_ VSS VSS VDD VDD _00577_ _00578_ sky130_fd_sc_hd__ha_1
X_18252_ _00579_ _00580_ VSS VSS VDD VDD _00581_ _00582_ sky130_fd_sc_hd__ha_1
X_18253_ _00583_ _00584_ VSS VSS VDD VDD _00585_ _00586_ sky130_fd_sc_hd__ha_1
X_18254_ _00587_ _00588_ VSS VSS VDD VDD _00589_ _00590_ sky130_fd_sc_hd__ha_1
X_18255_ _00591_ _00592_ VSS VSS VDD VDD _00593_ _00594_ sky130_fd_sc_hd__ha_1
X_18256_ _00595_ _00596_ VSS VSS VDD VDD _00597_ _00598_ sky130_fd_sc_hd__ha_1
X_18257_ _00599_ _00600_ VSS VSS VDD VDD _00601_ _00602_ sky130_fd_sc_hd__ha_1
X_18258_ _00603_ _00604_ VSS VSS VDD VDD _00605_ _00606_ sky130_fd_sc_hd__ha_1
X_18259_ _00607_ _00608_ VSS VSS VDD VDD _00609_ _00610_ sky130_fd_sc_hd__ha_1
X_18260_ _00611_ _00612_ VSS VSS VDD VDD _00613_ _00614_ sky130_fd_sc_hd__ha_1
X_18261_ _00615_ _00616_ VSS VSS VDD VDD _00617_ _00618_ sky130_fd_sc_hd__ha_1
X_18262_ _00619_ _00620_ VSS VSS VDD VDD _00621_ _00622_ sky130_fd_sc_hd__ha_1
X_18263_ _00623_ _00624_ VSS VSS VDD VDD _00625_ _00626_ sky130_fd_sc_hd__ha_1
X_18264_ _00627_ _00628_ VSS VSS VDD VDD _00629_ _00630_ sky130_fd_sc_hd__ha_1
X_18265_ _00631_ _00632_ VSS VSS VDD VDD _00633_ _00634_ sky130_fd_sc_hd__ha_1
X_18266_ _00635_ _00636_ VSS VSS VDD VDD _00637_ _00638_ sky130_fd_sc_hd__ha_1
X_18267_ _00639_ _00640_ VSS VSS VDD VDD _00641_ _00642_ sky130_fd_sc_hd__ha_1
X_18268_ _00643_ _00644_ VSS VSS VDD VDD _00645_ _00646_ sky130_fd_sc_hd__ha_1
X_18269_ network.neuron_hid7.IF0.membrane_potential\[1\] network.neuron_hid7.IF0.input_current\[1\]
+ VSS VSS VDD VDD _00647_ _00100_ sky130_fd_sc_hd__ha_1
X_18270_ network.neuron_out0.IF0.membrane_potential\[0\] network.neuron_out0.IF0.input_current\[0\]
+ VSS VSS VDD VDD _00011_ _00648_ sky130_fd_sc_hd__ha_1
X_18271_ _00649_ _00650_ VSS VSS VDD VDD _00651_ _00652_ sky130_fd_sc_hd__ha_1
X_18272_ network.neuron_hid0.IF0.membrane_potential\[4\] network.neuron_hid0.IF0.input_current\[4\]
+ VSS VSS VDD VDD _00654_ _00655_ sky130_fd_sc_hd__ha_1
X_18273_ network.neuron_out0.IF0.membrane_potential\[3\] network.neuron_out0.IF0.input_current\[3\]
+ VSS VSS VDD VDD _00656_ _00657_ sky130_fd_sc_hd__ha_1
X_18274_ _00658_ _00659_ VSS VSS VDD VDD _00660_ _00661_ sky130_fd_sc_hd__ha_1
X_18275_ _00662_ _00663_ VSS VSS VDD VDD _00664_ _00665_ sky130_fd_sc_hd__ha_1
X_18276_ _00666_ _00667_ VSS VSS VDD VDD _00668_ _00669_ sky130_fd_sc_hd__ha_1
X_18277_ _00670_ _00671_ VSS VSS VDD VDD _00672_ _00673_ sky130_fd_sc_hd__ha_1
X_18278_ _00674_ _00675_ VSS VSS VDD VDD _00676_ _00677_ sky130_fd_sc_hd__ha_1
X_18279_ _00678_ _00679_ VSS VSS VDD VDD _00680_ _00681_ sky130_fd_sc_hd__ha_1
X_18280_ _00682_ _00683_ VSS VSS VDD VDD _00684_ _00685_ sky130_fd_sc_hd__ha_1
X_18281_ _00686_ _00687_ VSS VSS VDD VDD _00688_ _00689_ sky130_fd_sc_hd__ha_1
X_18282_ _00690_ _00691_ VSS VSS VDD VDD _00692_ _00693_ sky130_fd_sc_hd__ha_1
X_18283_ network.neuron_hid2.IF0.membrane_potential\[6\] network.neuron_hid2.IF0.input_current\[6\]
+ VSS VSS VDD VDD _00694_ _00695_ sky130_fd_sc_hd__ha_1
X_18284_ network.neuron_hid2.IF0.membrane_potential\[7\] network.neuron_hid2.IF0.input_current\[7\]
+ VSS VSS VDD VDD _00696_ _00697_ sky130_fd_sc_hd__ha_1
X_18285_ network.neuron_hid1.IF0.membrane_potential\[3\] network.neuron_hid1.IF0.input_current\[3\]
+ VSS VSS VDD VDD _00698_ _00699_ sky130_fd_sc_hd__ha_1
X_18286_ network.neuron_hid3.IF0.membrane_potential\[5\] network.neuron_hid2.IF0.input_current\[5\]
+ VSS VSS VDD VDD _00700_ _00701_ sky130_fd_sc_hd__ha_1
X_18287_ _00702_ _00703_ VSS VSS VDD VDD _00704_ _00705_ sky130_fd_sc_hd__ha_1
X_18288_ _00706_ _00707_ VSS VSS VDD VDD _00708_ _00709_ sky130_fd_sc_hd__ha_1
X_18289_ _00710_ _00711_ VSS VSS VDD VDD _00712_ _00713_ sky130_fd_sc_hd__ha_1
X_18290_ network.neuron_out2.IF0.membrane_potential\[3\] network.neuron_out2.IF0.input_current\[3\]
+ VSS VSS VDD VDD _00714_ _00715_ sky130_fd_sc_hd__ha_1
X_18291_ network.neuron_hid4.IF0.membrane_potential\[1\] network.neuron_hid4.IF0.input_current\[1\]
+ VSS VSS VDD VDD _00716_ _00717_ sky130_fd_sc_hd__ha_1
X_18292_ _00718_ _00719_ VSS VSS VDD VDD _00720_ _00721_ sky130_fd_sc_hd__ha_1
X_18293_ _00722_ _00723_ VSS VSS VDD VDD _00724_ _00725_ sky130_fd_sc_hd__ha_1
X_18294_ _00726_ _00727_ VSS VSS VDD VDD _00728_ _00729_ sky130_fd_sc_hd__ha_1
X_18295_ _00730_ _00731_ VSS VSS VDD VDD _00732_ _00733_ sky130_fd_sc_hd__ha_1
X_18296_ _00734_ _00735_ VSS VSS VDD VDD _00736_ _00737_ sky130_fd_sc_hd__ha_1
X_18297_ _00738_ _00739_ VSS VSS VDD VDD _00740_ _00741_ sky130_fd_sc_hd__ha_1
X_18298_ network.neuron_out5.IF0.membrane_potential\[0\] network.neuron_out5.IF0.input_current\[0\]
+ VSS VSS VDD VDD _00028_ _00742_ sky130_fd_sc_hd__ha_1
X_18299_ _00743_ _00744_ VSS VSS VDD VDD _00745_ _00746_ sky130_fd_sc_hd__ha_1
X_18300_ _00747_ _00748_ VSS VSS VDD VDD _00749_ _00750_ sky130_fd_sc_hd__ha_1
X_18301_ _00751_ _00752_ VSS VSS VDD VDD _00753_ _00754_ sky130_fd_sc_hd__ha_1
X_18302_ network.neuron_hid6.IF0.membrane_potential\[1\] network.neuron_hid6.IF0.input_current\[1\]
+ VSS VSS VDD VDD _00755_ _00086_ sky130_fd_sc_hd__ha_1
X_18303_ _00756_ _00757_ VSS VSS VDD VDD _00758_ _00759_ sky130_fd_sc_hd__ha_1
X_18304_ network.neuron_hid4.IF0.membrane_potential\[3\] network.neuron_hid4.IF0.input_current\[3\]
+ VSS VSS VDD VDD _00760_ _00761_ sky130_fd_sc_hd__ha_1
X_18305_ _00762_ _00763_ VSS VSS VDD VDD _00764_ _00765_ sky130_fd_sc_hd__ha_1
X_18306_ network.neuron_out1.IF0.membrane_potential\[4\] network.neuron_out1.IF0.input_current\[4\]
+ VSS VSS VDD VDD _00766_ _00767_ sky130_fd_sc_hd__ha_1
X_18307_ network.neuron_hid0.IF0.membrane_potential\[0\] network.neuron_hid0.IF0.input_current\[0\]
+ VSS VSS VDD VDD _00017_ network.neuron_hid0.IF0.add_out\[0\]
+ sky130_fd_sc_hd__ha_1
X_18308_ network.neuron_hid2.IF0.membrane_potential\[5\] network.neuron_hid2.IF0.input_current\[5\]
+ VSS VSS VDD VDD _00768_ _00769_ sky130_fd_sc_hd__ha_1
X_18309_ _00770_ _00771_ VSS VSS VDD VDD _00772_ _00773_ sky130_fd_sc_hd__ha_1
X_18310_ _00774_ _00775_ VSS VSS VDD VDD _00776_ _00777_ sky130_fd_sc_hd__ha_1
X_18311_ _00778_ _00779_ VSS VSS VDD VDD _00780_ _00781_ sky130_fd_sc_hd__ha_1
X_18312_ _00782_ _00783_ VSS VSS VDD VDD _00784_ _00785_ sky130_fd_sc_hd__ha_1
X_18313_ _00786_ _00787_ VSS VSS VDD VDD _00788_ _00789_ sky130_fd_sc_hd__ha_1
X_18314_ _00790_ _00791_ VSS VSS VDD VDD _00792_ _00793_ sky130_fd_sc_hd__ha_1
X_18315_ _00794_ _00795_ VSS VSS VDD VDD _00796_ _00797_ sky130_fd_sc_hd__ha_1
X_18316_ _00798_ _00799_ VSS VSS VDD VDD _00800_ _00801_ sky130_fd_sc_hd__ha_1
X_18317_ _00802_ _00803_ VSS VSS VDD VDD _00804_ _00805_ sky130_fd_sc_hd__ha_1
X_18318_ _00806_ _00807_ VSS VSS VDD VDD _00808_ _00809_ sky130_fd_sc_hd__ha_1
X_18319_ _00810_ _00811_ VSS VSS VDD VDD _00812_ _00813_ sky130_fd_sc_hd__ha_1
X_18320_ _00814_ _00815_ VSS VSS VDD VDD _00816_ _00817_ sky130_fd_sc_hd__ha_1
X_18321_ _00818_ _00819_ VSS VSS VDD VDD _00820_ _00821_ sky130_fd_sc_hd__ha_1
X_18322_ _00822_ _00823_ VSS VSS VDD VDD _00824_ _00825_ sky130_fd_sc_hd__ha_1
X_18323_ _00826_ _00827_ VSS VSS VDD VDD _00828_ _00829_ sky130_fd_sc_hd__ha_1
X_18324_ _00830_ _00831_ VSS VSS VDD VDD _00832_ _00833_ sky130_fd_sc_hd__ha_1
X_18325_ _00834_ _00835_ VSS VSS VDD VDD _00836_ _00837_ sky130_fd_sc_hd__ha_1
X_18326_ _00838_ _00839_ VSS VSS VDD VDD _00840_ _00841_ sky130_fd_sc_hd__ha_1
X_18327_ _00842_ _00843_ VSS VSS VDD VDD _00844_ _00845_ sky130_fd_sc_hd__ha_1
X_18328_ network.neuron_hid7.IF0.membrane_potential\[7\] network.neuron_hid2.IF0.input_current\[7\]
+ VSS VSS VDD VDD _00846_ _00847_ sky130_fd_sc_hd__ha_1
X_18329_ network.neuron_out4.IF0.membrane_potential\[2\] network.neuron_out1.IF0.input_current\[2\]
+ VSS VSS VDD VDD _00848_ _00849_ sky130_fd_sc_hd__ha_1
X_18330_ network.neuron_out1.IF0.membrane_potential\[1\] network.neuron_out1.IF0.input_current\[1\]
+ VSS VSS VDD VDD _00850_ _00653_ sky130_fd_sc_hd__ha_1
X_18331_ network.neuron_hid7.IF0.membrane_potential\[4\] network.neuron_hid2.IF0.input_current\[4\]
+ VSS VSS VDD VDD _00851_ _00852_ sky130_fd_sc_hd__ha_1
X_18332_ network.neuron_hid1.IF0.membrane_potential\[0\] network.neuron_hid1.IF0.input_current\[0\]
+ VSS VSS VDD VDD _00009_ network.neuron_hid1.IF0.add_out\[0\]
+ sky130_fd_sc_hd__ha_1
X_18333_ network.neuron_hid5.IF0.membrane_potential\[4\] network.neuron_hid5.IF0.input_current\[4\]
+ VSS VSS VDD VDD _00853_ _00854_ sky130_fd_sc_hd__ha_1
X_18334_ network.neuron_hid5.IF0.membrane_potential\[2\] network.neuron_hid5.IF0.input_current\[2\]
+ VSS VSS VDD VDD _00855_ _00856_ sky130_fd_sc_hd__ha_1
X_18335_ network.neuron_hid7.IF0.membrane_potential\[3\] network.neuron_hid7.IF0.input_current\[3\]
+ VSS VSS VDD VDD _00857_ _00858_ sky130_fd_sc_hd__ha_1
X_18336_ _00859_ _00860_ VSS VSS VDD VDD _00861_ _00862_ sky130_fd_sc_hd__ha_1
X_18337_ _00863_ _00864_ VSS VSS VDD VDD _00865_ _00866_ sky130_fd_sc_hd__ha_1
X_18338_ network.neuron_hid4.IF0.membrane_potential\[0\] network.neuron_hid4.IF0.input_current\[0\]
+ VSS VSS VDD VDD _00019_ network.neuron_hid4.IF0.add_out\[0\]
+ sky130_fd_sc_hd__ha_1
X_18339_ _00867_ _00868_ VSS VSS VDD VDD _00869_ _00870_ sky130_fd_sc_hd__ha_1
X_18340_ network.neuron_out2.IF0.membrane_potential\[4\] network.neuron_out2.IF0.input_current\[4\]
+ VSS VSS VDD VDD _00871_ _00872_ sky130_fd_sc_hd__ha_1
X_18341_ _00873_ _00874_ VSS VSS VDD VDD _00875_ _00876_ sky130_fd_sc_hd__ha_1
X_18342_ network.neuron_out0.IF0.membrane_potential\[1\] network.neuron_out0.IF0.input_current\[1\]
+ VSS VSS VDD VDD _00877_ _00508_ sky130_fd_sc_hd__ha_1
X_18343_ network.neuron_hid2.IF0.membrane_potential\[4\] network.neuron_hid2.IF0.input_current\[4\]
+ VSS VSS VDD VDD _00878_ _00879_ sky130_fd_sc_hd__ha_1
X_18344_ network.neuron_hid2.IF0.membrane_potential\[2\] network.neuron_hid2.IF0.input_current\[2\]
+ VSS VSS VDD VDD _00880_ _00881_ sky130_fd_sc_hd__ha_1
X_18345_ network.neuron_hid2.IF0.membrane_potential\[0\] network.neuron_hid2.IF0.input_current\[0\]
+ VSS VSS VDD VDD _00021_ network.neuron_hid2.IF0.add_out\[0\]
+ sky130_fd_sc_hd__ha_1
X_18346_ network.neuron_hid1.IF0.membrane_potential\[4\] network.neuron_hid1.IF0.input_current\[4\]
+ VSS VSS VDD VDD _00882_ _00883_ sky130_fd_sc_hd__ha_1
X_18347_ _00884_ _00885_ VSS VSS VDD VDD _00886_ _00887_ sky130_fd_sc_hd__ha_1
X_18348_ _00888_ _00889_ VSS VSS VDD VDD _00890_ _00891_ sky130_fd_sc_hd__ha_1
X_18349_ network.neuron_hid0.IF0.membrane_potential\[2\] network.neuron_hid0.IF0.input_current\[2\]
+ VSS VSS VDD VDD _00892_ _00893_ sky130_fd_sc_hd__ha_1
X_18350_ _00894_ _00895_ VSS VSS VDD VDD _00896_ _00897_ sky130_fd_sc_hd__ha_1
X_18351_ _00898_ _00899_ VSS VSS VDD VDD _00900_ _00901_ sky130_fd_sc_hd__ha_1
X_18352_ _00902_ _00903_ VSS VSS VDD VDD _00904_ _00905_ sky130_fd_sc_hd__ha_1
X_18353_ _00906_ _00907_ VSS VSS VDD VDD _00908_ _00909_ sky130_fd_sc_hd__ha_1
X_18354_ _00910_ _00911_ VSS VSS VDD VDD _00912_ _00913_ sky130_fd_sc_hd__ha_1
X_18355_ _00914_ _00915_ VSS VSS VDD VDD _00916_ _00917_ sky130_fd_sc_hd__ha_1
X_18356_ _00918_ _00919_ VSS VSS VDD VDD _00920_ _00921_ sky130_fd_sc_hd__ha_1
X_18357_ _00922_ _00923_ VSS VSS VDD VDD _00924_ _00925_ sky130_fd_sc_hd__ha_1
X_18358_ _00926_ _00927_ VSS VSS VDD VDD _00928_ _00929_ sky130_fd_sc_hd__ha_1
X_18359_ _00930_ _00931_ VSS VSS VDD VDD _00932_ _00933_ sky130_fd_sc_hd__ha_1
X_18360_ _00934_ _00935_ VSS VSS VDD VDD _00936_ _00937_ sky130_fd_sc_hd__ha_1
X_18361_ _00938_ _00939_ VSS VSS VDD VDD _00940_ _00941_ sky130_fd_sc_hd__ha_1
X_18362_ _00942_ _00943_ VSS VSS VDD VDD _00944_ _00945_ sky130_fd_sc_hd__ha_1
X_18363_ _00946_ _00947_ VSS VSS VDD VDD _00948_ _00949_ sky130_fd_sc_hd__ha_1
X_18364_ _00950_ _00951_ VSS VSS VDD VDD _00952_ _00953_ sky130_fd_sc_hd__ha_1
X_18365_ _00954_ _00955_ VSS VSS VDD VDD _00956_ _00957_ sky130_fd_sc_hd__ha_1
X_18366_ _00958_ _00959_ VSS VSS VDD VDD _00960_ _00961_ sky130_fd_sc_hd__ha_1
X_18367_ _00962_ _00963_ VSS VSS VDD VDD _00964_ _00965_ sky130_fd_sc_hd__ha_1
X_18368_ _00966_ _00967_ VSS VSS VDD VDD _00968_ _00969_ sky130_fd_sc_hd__ha_1
X_18369_ _00970_ _00971_ VSS VSS VDD VDD _00972_ _00973_ sky130_fd_sc_hd__ha_1
X_18370_ _00974_ _00975_ VSS VSS VDD VDD _00976_ _00977_ sky130_fd_sc_hd__ha_1
X_18371_ _00978_ _00979_ VSS VSS VDD VDD _00980_ _00981_ sky130_fd_sc_hd__ha_1
X_18372_ _00982_ _00983_ VSS VSS VDD VDD _00984_ _00985_ sky130_fd_sc_hd__ha_1
X_18373_ _00986_ _00987_ VSS VSS VDD VDD _00988_ _00989_ sky130_fd_sc_hd__ha_1
X_18374_ _00990_ _00991_ VSS VSS VDD VDD _00992_ _00993_ sky130_fd_sc_hd__ha_1
X_18375_ _00994_ _00995_ VSS VSS VDD VDD _00996_ _00997_ sky130_fd_sc_hd__ha_1
X_18376_ _00998_ _00999_ VSS VSS VDD VDD _01000_ _01001_ sky130_fd_sc_hd__ha_1
X_18377_ _01002_ _01003_ VSS VSS VDD VDD _01004_ _01005_ sky130_fd_sc_hd__ha_1
X_18378_ _01006_ _01007_ VSS VSS VDD VDD _01008_ _01009_ sky130_fd_sc_hd__ha_1
X_18379_ _01010_ _01011_ VSS VSS VDD VDD _01012_ _01013_ sky130_fd_sc_hd__ha_1
X_18380_ _01014_ _01015_ VSS VSS VDD VDD _01016_ _01017_ sky130_fd_sc_hd__ha_1
X_18381_ _01018_ _01019_ VSS VSS VDD VDD _01020_ _01021_ sky130_fd_sc_hd__ha_1
X_18382_ network.neuron_out1.IF0.membrane_potential\[0\] network.neuron_out1.IF0.input_current\[0\]
+ VSS VSS VDD VDD _00014_ _01022_ sky130_fd_sc_hd__ha_1
X_18383_ _01023_ _01024_ VSS VSS VDD VDD _01025_ _01026_ sky130_fd_sc_hd__ha_1
X_18384_ _01027_ _01028_ VSS VSS VDD VDD _01029_ _01030_ sky130_fd_sc_hd__ha_1
X_18385_ network.neuron_hid3.IF0.membrane_potential\[6\] network.neuron_hid2.IF0.input_current\[6\]
+ VSS VSS VDD VDD _01031_ _01032_ sky130_fd_sc_hd__ha_1
X_18386_ _01033_ _01034_ VSS VSS VDD VDD _01035_ _01036_ sky130_fd_sc_hd__ha_1
X_18387_ network.neuron_hid3.IF0.membrane_potential\[3\] network.neuron_hid2.IF0.input_current\[3\]
+ VSS VSS VDD VDD _01037_ _01038_ sky130_fd_sc_hd__ha_1
X_18388_ network.neuron_out1.IF0.membrane_potential\[2\] network.neuron_out1.IF0.input_current\[2\]
+ VSS VSS VDD VDD _01039_ _01040_ sky130_fd_sc_hd__ha_1
X_18389_ network.neuron_out3.IF0.membrane_potential\[4\] network.neuron_out3.IF0.input_current\[4\]
+ VSS VSS VDD VDD _01041_ _01042_ sky130_fd_sc_hd__ha_1
X_18390_ network.neuron_hid3.IF0.membrane_potential\[4\] network.neuron_hid2.IF0.input_current\[4\]
+ VSS VSS VDD VDD _01043_ _01044_ sky130_fd_sc_hd__ha_1
X_18391_ network.neuron_hid3.IF0.membrane_potential\[0\] network.neuron_hid3.IF0.input_current\[0\]
+ VSS VSS VDD VDD _00002_ network.neuron_hid3.IF0.add_out\[0\]
+ sky130_fd_sc_hd__ha_1
X_18392_ network.neuron_out0.IF0.membrane_potential\[2\] network.neuron_out0.IF0.input_current\[2\]
+ VSS VSS VDD VDD _01045_ _01046_ sky130_fd_sc_hd__ha_1
X_18393_ network.neuron_out5.IF0.membrane_potential\[4\] network.neuron_out5.IF0.input_current\[4\]
+ VSS VSS VDD VDD _01047_ _01048_ sky130_fd_sc_hd__ha_1
X_18394_ _01049_ _01050_ VSS VSS VDD VDD _01051_ _01052_ sky130_fd_sc_hd__ha_1
X_18395_ network.neuron_hid6.IF0.membrane_potential\[2\] network.neuron_hid6.IF0.input_current\[2\]
+ VSS VSS VDD VDD _01053_ _01054_ sky130_fd_sc_hd__ha_1
X_18396_ _01055_ _01056_ VSS VSS VDD VDD _01057_ _01058_ sky130_fd_sc_hd__ha_1
X_18397_ _01059_ _01060_ VSS VSS VDD VDD _01061_ _01062_ sky130_fd_sc_hd__ha_1
X_18398_ _01063_ _01064_ VSS VSS VDD VDD _01065_ _01066_ sky130_fd_sc_hd__ha_1
X_18399_ _01067_ _01068_ VSS VSS VDD VDD _01069_ _01070_ sky130_fd_sc_hd__ha_1
X_18400_ _01071_ _01072_ VSS VSS VDD VDD _01073_ _01074_ sky130_fd_sc_hd__ha_1
X_18401_ _01075_ _01076_ VSS VSS VDD VDD _01077_ _01078_ sky130_fd_sc_hd__ha_1
X_18402_ _01079_ _01080_ VSS VSS VDD VDD _01081_ _01082_ sky130_fd_sc_hd__ha_1
X_18403_ _01083_ _01084_ VSS VSS VDD VDD _01085_ _01086_ sky130_fd_sc_hd__ha_1
X_18404_ _01087_ _01088_ VSS VSS VDD VDD _01089_ _01090_ sky130_fd_sc_hd__ha_1
X_18405_ _01091_ _01092_ VSS VSS VDD VDD _01093_ _01094_ sky130_fd_sc_hd__ha_1
X_18406_ network.neuron_hid0.IF0.membrane_potential\[3\] network.neuron_hid0.IF0.input_current\[3\]
+ VSS VSS VDD VDD _01096_ _01097_ sky130_fd_sc_hd__ha_1
X_18407_ network.neuron_hid2.IF0.membrane_potential\[3\] network.neuron_hid2.IF0.input_current\[3\]
+ VSS VSS VDD VDD _01098_ _01099_ sky130_fd_sc_hd__ha_1
X_18408_ network.neuron_hid5.IF0.membrane_potential\[3\] network.neuron_hid5.IF0.input_current\[3\]
+ VSS VSS VDD VDD _01100_ _01101_ sky130_fd_sc_hd__ha_1
X_18409_ _01102_ _01103_ VSS VSS VDD VDD _01104_ _01105_ sky130_fd_sc_hd__ha_1
X_18410_ _01102_ loaded\[1\] VSS VSS VDD VDD _01106_ _09397_
+ sky130_fd_sc_hd__ha_1
X_18411_ loaded\[0\] _01103_ VSS VSS VDD VDD _01107_ _09398_
+ sky130_fd_sc_hd__ha_1
X_18412_ loaded\[0\] loaded\[1\] VSS VSS VDD VDD _01108_ _09399_
+ sky130_fd_sc_hd__ha_1
X_18413_ network.neuron_out2.IF0.membrane_potential\[2\] network.neuron_out2.IF0.input_current\[2\]
+ VSS VSS VDD VDD _01109_ _01110_ sky130_fd_sc_hd__ha_1
X_18414_ _01111_ _01112_ VSS VSS VDD VDD _01113_ _01114_ sky130_fd_sc_hd__ha_1
X_18415_ _01115_ _01116_ VSS VSS VDD VDD _01117_ _01118_ sky130_fd_sc_hd__ha_1
X_18416_ _01119_ _01120_ VSS VSS VDD VDD _01121_ _01122_ sky130_fd_sc_hd__ha_1
X_18417_ _01123_ _01124_ VSS VSS VDD VDD _01125_ _01126_ sky130_fd_sc_hd__ha_1
X_18418_ _01127_ _01128_ VSS VSS VDD VDD _01129_ _01130_ sky130_fd_sc_hd__ha_1
X_18419_ net27 net34 VSS VSS VDD VDD _01131_ _01132_ sky130_fd_sc_hd__ha_1
X_18420_ _01133_ _01134_ VSS VSS VDD VDD _01135_ _01136_ sky130_fd_sc_hd__ha_1
X_18421_ _01137_ _01138_ VSS VSS VDD VDD _01139_ _01140_ sky130_fd_sc_hd__ha_1
X_18422_ network.neuron_hid4.IF0.membrane_potential\[2\] network.neuron_hid4.IF0.input_current\[2\]
+ VSS VSS VDD VDD _01141_ _01142_ sky130_fd_sc_hd__ha_1
X_18423_ _01143_ _01144_ VSS VSS VDD VDD _01145_ _01146_ sky130_fd_sc_hd__ha_1
X_18424_ _01147_ _01148_ VSS VSS VDD VDD _01149_ _01150_ sky130_fd_sc_hd__ha_1
X_18425_ _01151_ _01152_ VSS VSS VDD VDD _01153_ _01154_ sky130_fd_sc_hd__ha_1
X_18426_ _01155_ _01156_ VSS VSS VDD VDD _01157_ _01158_ sky130_fd_sc_hd__ha_1
X_18427_ _01159_ _01160_ VSS VSS VDD VDD _01161_ _01162_ sky130_fd_sc_hd__ha_1
X_18428_ _01163_ _01164_ VSS VSS VDD VDD _01165_ _01166_ sky130_fd_sc_hd__ha_1
X_18429_ _01167_ _01168_ VSS VSS VDD VDD _01169_ _01170_ sky130_fd_sc_hd__ha_1
X_18430_ _01171_ _01172_ VSS VSS VDD VDD _01173_ _01174_ sky130_fd_sc_hd__ha_1
X_18431_ _01175_ _01176_ VSS VSS VDD VDD _01177_ _01178_ sky130_fd_sc_hd__ha_1
X_18432_ _01179_ _01180_ VSS VSS VDD VDD _01181_ _01182_ sky130_fd_sc_hd__ha_1
X_18433_ _01183_ _01184_ VSS VSS VDD VDD _01185_ _01186_ sky130_fd_sc_hd__ha_1
X_18434_ _01187_ _01188_ VSS VSS VDD VDD _01189_ _01190_ sky130_fd_sc_hd__ha_1
X_18435_ _01191_ _01192_ VSS VSS VDD VDD _01193_ _01194_ sky130_fd_sc_hd__ha_1
X_18436_ _01195_ _01196_ VSS VSS VDD VDD _01197_ _01198_ sky130_fd_sc_hd__ha_1
X_18437_ _01199_ _01200_ VSS VSS VDD VDD _01201_ _01202_ sky130_fd_sc_hd__ha_1
X_18438_ _01203_ _01204_ VSS VSS VDD VDD _01205_ _01206_ sky130_fd_sc_hd__ha_1
X_18439_ network.neuron_hid3.IF0.membrane_potential\[7\] network.neuron_hid2.IF0.input_current\[7\]
+ VSS VSS VDD VDD _01207_ _01208_ sky130_fd_sc_hd__ha_1
X_18440_ _01209_ _01210_ VSS VSS VDD VDD _01211_ _01212_ sky130_fd_sc_hd__ha_1
X_18441_ _01213_ _01214_ VSS VSS VDD VDD _01215_ _01216_ sky130_fd_sc_hd__ha_1
X_18442_ _01217_ _01218_ VSS VSS VDD VDD _01219_ _01220_ sky130_fd_sc_hd__ha_1
X_18443_ _01221_ _01222_ VSS VSS VDD VDD _01223_ _01224_ sky130_fd_sc_hd__ha_1
X_18444_ network.neuron_out2.IF0.membrane_potential\[1\] network.neuron_out2.IF0.input_current\[1\]
+ VSS VSS VDD VDD _01225_ _00314_ sky130_fd_sc_hd__ha_1
X_18445_ _01226_ _01227_ VSS VSS VDD VDD _01228_ _01229_ sky130_fd_sc_hd__ha_1
X_18446_ network.neuron_out0.IF0.membrane_potential\[5\] network.neuron_out0.IF0.input_current\[5\]
+ VSS VSS VDD VDD _01230_ _01231_ sky130_fd_sc_hd__ha_1
X_18447_ _01232_ _01233_ VSS VSS VDD VDD _01234_ _01235_ sky130_fd_sc_hd__ha_1
X_18448_ _01236_ _01237_ VSS VSS VDD VDD _01238_ _01239_ sky130_fd_sc_hd__ha_1
X_18449_ _01240_ _01241_ VSS VSS VDD VDD _01242_ _01243_ sky130_fd_sc_hd__ha_1
X_18450_ network.neuron_hid2.IF0.membrane_potential\[1\] network.neuron_hid2.IF0.input_current\[1\]
+ VSS VSS VDD VDD _01244_ _01095_ sky130_fd_sc_hd__ha_1
X_18451_ _01245_ _01246_ VSS VSS VDD VDD _01247_ _01248_ sky130_fd_sc_hd__ha_1
XTAP_TAPCELL_ROW_0_0 VSS VDD sky130_fd_sc_hd__tapvpwrvgnd_1
Xbusy$_SDFFE_PP0P_ clknet_leaf_164_clk _01958_ VSS VSS VDD
+ VDD net25 sky130_fd_sc_hd__dfxtp_1
Xdone$_SDFF_PP0_ clknet_leaf_176_clk _01955_ VSS VSS VDD VDD
+ net26 sky130_fd_sc_hd__dfxtp_1
Xinference_cycles\[0\]$_SDFFE_PP0P_ clknet_leaf_178_clk _01567_
+ VSS VSS VDD VDD net27 sky130_fd_sc_hd__dfxtp_1
Xinference_cycles\[10\]$_SDFFE_PP0P_ clknet_leaf_179_clk _01557_
+ VSS VSS VDD VDD net28 sky130_fd_sc_hd__dfxtp_1
Xinference_cycles\[11\]$_SDFFE_PP0P_ clknet_leaf_179_clk _01556_
+ VSS VSS VDD VDD net29 sky130_fd_sc_hd__dfxtp_1
Xinference_cycles\[12\]$_SDFFE_PP0P_ clknet_leaf_179_clk _01555_
+ VSS VSS VDD VDD net30 sky130_fd_sc_hd__dfxtp_1
Xinference_cycles\[13\]$_SDFFE_PP0P_ clknet_leaf_179_clk _01554_
+ VSS VSS VDD VDD net31 sky130_fd_sc_hd__dfxtp_1
Xinference_cycles\[14\]$_SDFFE_PP0P_ clknet_leaf_179_clk _01553_
+ VSS VSS VDD VDD net32 sky130_fd_sc_hd__dfxtp_1
Xinference_cycles\[15\]$_SDFFE_PP0P_ clknet_leaf_179_clk _01954_
+ VSS VSS VDD VDD net33 sky130_fd_sc_hd__dfxtp_1
Xinference_cycles\[1\]$_SDFFE_PP0P_ clknet_leaf_178_clk _01566_
+ VSS VSS VDD VDD net34 sky130_fd_sc_hd__dfxtp_1
Xinference_cycles\[2\]$_SDFFE_PP0P_ clknet_leaf_176_clk _01565_
+ VSS VSS VDD VDD net35 sky130_fd_sc_hd__dfxtp_1
Xinference_cycles\[3\]$_SDFFE_PP0P_ clknet_leaf_176_clk _01564_
+ VSS VSS VDD VDD net36 sky130_fd_sc_hd__dfxtp_1
Xinference_cycles\[4\]$_SDFFE_PP0P_ clknet_leaf_176_clk _01563_
+ VSS VSS VDD VDD net37 sky130_fd_sc_hd__dfxtp_1
Xinference_cycles\[5\]$_SDFFE_PP0P_ clknet_leaf_176_clk _01562_
+ VSS VSS VDD VDD net38 sky130_fd_sc_hd__dfxtp_1
Xinference_cycles\[6\]$_SDFFE_PP0P_ clknet_leaf_176_clk _01561_
+ VSS VSS VDD VDD net39 sky130_fd_sc_hd__dfxtp_1
Xinference_cycles\[7\]$_SDFFE_PP0P_ clknet_leaf_179_clk _01560_
+ VSS VSS VDD VDD net40 sky130_fd_sc_hd__dfxtp_1
Xinference_cycles\[8\]$_SDFFE_PP0P_ clknet_leaf_178_clk _01559_
+ VSS VSS VDD VDD net41 sky130_fd_sc_hd__dfxtp_1
Xinference_cycles\[9\]$_SDFFE_PP0P_ clknet_leaf_178_clk _01558_
+ VSS VSS VDD VDD net42 sky130_fd_sc_hd__dfxtp_1
Xloaded\[0\]$_SDFFE_PP0P_ clknet_leaf_166_clk _01575_ VSS
+ VSS VDD VDD loaded\[0\] sky130_fd_sc_hd__dfxtp_1
Xloaded\[1\]$_SDFFE_PP0P_ clknet_leaf_166_clk _01574_ VSS
+ VSS VDD VDD loaded\[1\] sky130_fd_sc_hd__dfxtp_1
Xloaded\[2\]$_SDFFE_PP0P_ clknet_leaf_164_clk _01573_ VSS
+ VSS VDD VDD loaded\[2\] sky130_fd_sc_hd__dfxtp_1
Xloaded\[3\]$_SDFFE_PP0P_ clknet_leaf_164_clk _01572_ VSS
+ VSS VDD VDD loaded\[3\] sky130_fd_sc_hd__dfxtp_1
Xloaded\[4\]$_SDFFE_PP0P_ clknet_leaf_163_clk _01571_ VSS
+ VSS VDD VDD loaded\[4\] sky130_fd_sc_hd__dfxtp_1
Xloaded\[5\]$_SDFFE_PP0P_ clknet_leaf_163_clk _01570_ VSS
+ VSS VDD VDD loaded\[5\] sky130_fd_sc_hd__dfxtp_1
Xloaded\[6\]$_SDFFE_PP0P_ clknet_leaf_163_clk _01569_ VSS
+ VSS VDD VDD loaded\[6\] sky130_fd_sc_hd__dfxtp_1
Xloaded\[7\]$_SDFFE_PP0P_ clknet_leaf_225_clk _01568_ VSS
+ VSS VDD VDD loaded\[7\] sky130_fd_sc_hd__dfxtp_1
Xloaded\[8\]$_SDFFE_PP0P_ clknet_leaf_164_clk _01950_ VSS
+ VSS VDD VDD loaded\[8\] sky130_fd_sc_hd__dfxtp_1
Xnetwork.arbit.counter\[0\]$_SDFFE_PP0N_ clknet_leaf_174_clk
+ _01578_ VSS VSS VDD VDD network.arbit.counter\[0\] sky130_fd_sc_hd__dfxtp_1
Xnetwork.arbit.counter\[1\]$_SDFFE_PP0N_ clknet_leaf_174_clk
+ _01577_ VSS VSS VDD VDD network.arbit.counter\[1\] sky130_fd_sc_hd__dfxtp_1
Xnetwork.arbit.counter\[2\]$_SDFFE_PP1N_ clknet_leaf_174_clk
+ _01576_ VSS VSS VDD VDD network.arbit.counter\[2\] sky130_fd_sc_hd__dfxtp_1
Xnetwork.arbit.counter\[3\]$_SDFFE_PP1N_ clknet_leaf_175_clk
+ _01951_ VSS VSS VDD VDD network.arbit.counter\[3\] sky130_fd_sc_hd__dfxtp_1
Xnetwork.cnt_main.counter\[0\]$_SDFF_PP0_ clknet_leaf_133_clk
+ _01743_ VSS VSS VDD VDD network.cnt_main.counter\[0\] sky130_fd_sc_hd__dfxtp_1
Xnetwork.cnt_main.counter\[10\]$_SDFF_PP0_ clknet_leaf_134_clk
+ _01733_ VSS VSS VDD VDD network.cnt_main.counter\[10\] sky130_fd_sc_hd__dfxtp_1
Xnetwork.cnt_main.counter\[11\]$_SDFF_PP1_ clknet_leaf_135_clk
+ _01732_ VSS VSS VDD VDD network.cnt_main.counter\[11\] sky130_fd_sc_hd__dfxtp_1
Xnetwork.cnt_main.counter\[12\]$_SDFF_PP0_ clknet_leaf_134_clk
+ _01731_ VSS VSS VDD VDD network.cnt_main.counter\[12\] sky130_fd_sc_hd__dfxtp_1
Xnetwork.cnt_main.counter\[13\]$_SDFF_PP0_ clknet_leaf_134_clk
+ _01868_ VSS VSS VDD VDD network.cnt_main.counter\[13\] sky130_fd_sc_hd__dfxtp_1
Xnetwork.cnt_main.counter\[1\]$_SDFF_PP0_ clknet_leaf_134_clk
+ _01742_ VSS VSS VDD VDD network.cnt_main.counter\[1\] sky130_fd_sc_hd__dfxtp_1
Xnetwork.cnt_main.counter\[2\]$_SDFF_PP1_ clknet_leaf_134_clk
+ _01741_ VSS VSS VDD VDD network.cnt_main.counter\[2\] sky130_fd_sc_hd__dfxtp_1
Xnetwork.cnt_main.counter\[3\]$_SDFF_PP0_ clknet_leaf_134_clk
+ _01740_ VSS VSS VDD VDD network.cnt_main.counter\[3\] sky130_fd_sc_hd__dfxtp_1
Xnetwork.cnt_main.counter\[4\]$_SDFF_PP0_ clknet_leaf_133_clk
+ _01739_ VSS VSS VDD VDD network.cnt_main.counter\[4\] sky130_fd_sc_hd__dfxtp_1
Xnetwork.cnt_main.counter\[5\]$_SDFF_PP0_ clknet_leaf_133_clk
+ _01738_ VSS VSS VDD VDD network.cnt_main.counter\[5\] sky130_fd_sc_hd__dfxtp_1
Xnetwork.cnt_main.counter\[6\]$_SDFF_PP1_ clknet_leaf_134_clk
+ _01737_ VSS VSS VDD VDD network.cnt_main.counter\[6\] sky130_fd_sc_hd__dfxtp_1
Xnetwork.cnt_main.counter\[7\]$_SDFF_PP1_ clknet_leaf_134_clk
+ _01736_ VSS VSS VDD VDD network.cnt_main.counter\[7\] sky130_fd_sc_hd__dfxtp_1
Xnetwork.cnt_main.counter\[8\]$_SDFF_PP1_ clknet_leaf_134_clk
+ _01735_ VSS VSS VDD VDD network.cnt_main.counter\[8\] sky130_fd_sc_hd__dfxtp_1
Xnetwork.cnt_main.counter\[9\]$_SDFF_PP0_ clknet_leaf_134_clk
+ _01734_ VSS VSS VDD VDD network.cnt_main.counter\[9\] sky130_fd_sc_hd__dfxtp_1
Xnetwork.hid_controler.addr_out\[0\]$_SDFF_PP0_ clknet_leaf_107_clk
+ _01730_ VSS VSS VDD VDD network.ctrl_addr\[0\] sky130_fd_sc_hd__dfxtp_1
Xnetwork.hid_controler.addr_out\[1\]$_SDFF_PP0_ clknet_leaf_154_clk
+ _01729_ VSS VSS VDD VDD network.ctrl_addr\[1\] sky130_fd_sc_hd__dfxtp_1
Xnetwork.hid_controler.addr_out\[2\]$_SDFF_PP0_ clknet_leaf_107_clk
+ _01728_ VSS VSS VDD VDD network.ctrl_addr\[2\] sky130_fd_sc_hd__dfxtp_1
Xnetwork.hid_controler.addr_out\[3\]$_SDFF_PP0_ clknet_leaf_107_clk
+ _01727_ VSS VSS VDD VDD network.ctrl_addr\[3\] sky130_fd_sc_hd__dfxtp_1
Xnetwork.hid_controler.addr_out\[4\]$_SDFF_PP0_ clknet_leaf_154_clk
+ _01726_ VSS VSS VDD VDD network.ctrl_addr\[4\] sky130_fd_sc_hd__dfxtp_1
Xnetwork.hid_controler.addr_out\[5\]$_SDFF_PP0_ clknet_leaf_101_clk
+ _01725_ VSS VSS VDD VDD network.ctrl_addr\[5\] sky130_fd_sc_hd__dfxtp_1
Xnetwork.hid_controler.addr_out\[6\]$_SDFF_PP0_ clknet_leaf_157_clk
+ _01724_ VSS VSS VDD VDD network.ctrl_addr\[6\] sky130_fd_sc_hd__dfxtp_1
Xnetwork.hid_controler.addr_out\[7\]$_SDFF_PP0_ clknet_leaf_148_clk
+ _01901_ VSS VSS VDD VDD network.ctrl_addr\[7\] sky130_fd_sc_hd__dfxtp_1
Xnetwork.hid_controler.spike_out$_SDFF_PP0_ clknet_leaf_145_clk
+ _01905_ VSS VSS VDD VDD network.ctrl_spk sky130_fd_sc_hd__dfxtp_1
Xnetwork.in_period\[0\]\[0\]$_DFFE_PP_ clknet_leaf_64_clk
+ net453 _03088_ VSS VSS VDD VDD network.in_period\[0\]\[0\]
+ sky130_fd_sc_hd__edfxtp_1
Xnetwork.in_period\[0\]\[1\]$_DFFE_PP_ clknet_leaf_64_clk
+ net446 _03088_ VSS VSS VDD VDD network.in_period\[0\]\[1\]
+ sky130_fd_sc_hd__edfxtp_1
Xnetwork.in_period\[0\]\[2\]$_DFFE_PP_ clknet_leaf_64_clk
+ net438 _03088_ VSS VSS VDD VDD network.in_period\[0\]\[2\]
+ sky130_fd_sc_hd__edfxtp_1
Xnetwork.in_period\[0\]\[3\]$_DFFE_PP_ clknet_leaf_64_clk
+ net431 _03088_ VSS VSS VDD VDD network.in_period\[0\]\[3\]
+ sky130_fd_sc_hd__edfxtp_1
Xnetwork.in_period\[100\]\[0\]$_DFFE_PP_ clknet_leaf_33_clk
+ net454 _03089_ VSS VSS VDD VDD network.in_period\[100\]\[0\]
+ sky130_fd_sc_hd__edfxtp_1
Xnetwork.in_period\[100\]\[1\]$_DFFE_PP_ clknet_leaf_33_clk
+ net451 _03089_ VSS VSS VDD VDD network.in_period\[100\]\[1\]
+ sky130_fd_sc_hd__edfxtp_1
Xnetwork.in_period\[100\]\[2\]$_DFFE_PP_ clknet_leaf_34_clk
+ net439 _03089_ VSS VSS VDD VDD network.in_period\[100\]\[2\]
+ sky130_fd_sc_hd__edfxtp_1
Xnetwork.in_period\[100\]\[3\]$_DFFE_PP_ clknet_leaf_34_clk
+ net433 _03089_ VSS VSS VDD VDD network.in_period\[100\]\[3\]
+ sky130_fd_sc_hd__edfxtp_1
Xnetwork.in_period\[101\]\[0\]$_DFFE_PP_ clknet_leaf_36_clk
+ net454 _03090_ VSS VSS VDD VDD network.in_period\[101\]\[0\]
+ sky130_fd_sc_hd__edfxtp_1
Xnetwork.in_period\[101\]\[1\]$_DFFE_PP_ clknet_leaf_36_clk
+ net451 _03090_ VSS VSS VDD VDD network.in_period\[101\]\[1\]
+ sky130_fd_sc_hd__edfxtp_1
Xnetwork.in_period\[101\]\[2\]$_DFFE_PP_ clknet_leaf_36_clk
+ net439 _03090_ VSS VSS VDD VDD network.in_period\[101\]\[2\]
+ sky130_fd_sc_hd__edfxtp_1
Xnetwork.in_period\[101\]\[3\]$_DFFE_PP_ clknet_leaf_36_clk
+ net433 _03090_ VSS VSS VDD VDD network.in_period\[101\]\[3\]
+ sky130_fd_sc_hd__edfxtp_1
Xnetwork.in_period\[102\]\[0\]$_DFFE_PP_ clknet_leaf_241_clk
+ net457 _03091_ VSS VSS VDD VDD network.in_period\[102\]\[0\]
+ sky130_fd_sc_hd__edfxtp_1
Xnetwork.in_period\[102\]\[1\]$_DFFE_PP_ clknet_leaf_30_clk
+ net447 _03091_ VSS VSS VDD VDD network.in_period\[102\]\[1\]
+ sky130_fd_sc_hd__edfxtp_1
Xnetwork.in_period\[102\]\[2\]$_DFFE_PP_ clknet_leaf_35_clk
+ net442 _03091_ VSS VSS VDD VDD network.in_period\[102\]\[2\]
+ sky130_fd_sc_hd__edfxtp_1
Xnetwork.in_period\[102\]\[3\]$_DFFE_PP_ clknet_leaf_35_clk
+ net436 _03091_ VSS VSS VDD VDD network.in_period\[102\]\[3\]
+ sky130_fd_sc_hd__edfxtp_1
Xnetwork.in_period\[103\]\[0\]$_DFFE_PP_ clknet_leaf_34_clk
+ net454 _03092_ VSS VSS VDD VDD network.in_period\[103\]\[0\]
+ sky130_fd_sc_hd__edfxtp_1
Xnetwork.in_period\[103\]\[1\]$_DFFE_PP_ clknet_leaf_34_clk
+ net451 _03092_ VSS VSS VDD VDD network.in_period\[103\]\[1\]
+ sky130_fd_sc_hd__edfxtp_1
Xnetwork.in_period\[103\]\[2\]$_DFFE_PP_ clknet_leaf_36_clk
+ net439 _03092_ VSS VSS VDD VDD network.in_period\[103\]\[2\]
+ sky130_fd_sc_hd__edfxtp_1
Xnetwork.in_period\[103\]\[3\]$_DFFE_PP_ clknet_leaf_36_clk
+ net433 _03092_ VSS VSS VDD VDD network.in_period\[103\]\[3\]
+ sky130_fd_sc_hd__edfxtp_1
Xnetwork.in_period\[104\]\[0\]$_DFFE_PP_ clknet_leaf_241_clk
+ net457 _03093_ VSS VSS VDD VDD network.in_period\[104\]\[0\]
+ sky130_fd_sc_hd__edfxtp_1
Xnetwork.in_period\[104\]\[1\]$_DFFE_PP_ clknet_leaf_241_clk
+ net447 _03093_ VSS VSS VDD VDD network.in_period\[104\]\[1\]
+ sky130_fd_sc_hd__edfxtp_1
Xnetwork.in_period\[104\]\[2\]$_DFFE_PP_ clknet_leaf_241_clk
+ net442 _03093_ VSS VSS VDD VDD network.in_period\[104\]\[2\]
+ sky130_fd_sc_hd__edfxtp_1
Xnetwork.in_period\[104\]\[3\]$_DFFE_PP_ clknet_leaf_241_clk
+ net436 _03093_ VSS VSS VDD VDD network.in_period\[104\]\[3\]
+ sky130_fd_sc_hd__edfxtp_1
Xnetwork.in_period\[105\]\[0\]$_DFFE_PP_ clknet_leaf_242_clk
+ net455 _03094_ VSS VSS VDD VDD network.in_period\[105\]\[0\]
+ sky130_fd_sc_hd__edfxtp_1
Xnetwork.in_period\[105\]\[1\]$_DFFE_PP_ clknet_leaf_242_clk
+ net449 _03094_ VSS VSS VDD VDD network.in_period\[105\]\[1\]
+ sky130_fd_sc_hd__edfxtp_1
Xnetwork.in_period\[105\]\[2\]$_DFFE_PP_ clknet_leaf_242_clk
+ net442 _03094_ VSS VSS VDD VDD network.in_period\[105\]\[2\]
+ sky130_fd_sc_hd__edfxtp_1
Xnetwork.in_period\[105\]\[3\]$_DFFE_PP_ clknet_leaf_242_clk
+ net436 _03094_ VSS VSS VDD VDD network.in_period\[105\]\[3\]
+ sky130_fd_sc_hd__edfxtp_1
Xnetwork.in_period\[106\]\[0\]$_DFFE_PP_ clknet_leaf_29_clk
+ net457 _03095_ VSS VSS VDD VDD network.in_period\[106\]\[0\]
+ sky130_fd_sc_hd__edfxtp_1
Xnetwork.in_period\[106\]\[1\]$_DFFE_PP_ clknet_leaf_243_clk
+ net449 _03095_ VSS VSS VDD VDD network.in_period\[106\]\[1\]
+ sky130_fd_sc_hd__edfxtp_1
Xnetwork.in_period\[106\]\[2\]$_DFFE_PP_ clknet_leaf_243_clk
+ net443 _03095_ VSS VSS VDD VDD network.in_period\[106\]\[2\]
+ sky130_fd_sc_hd__edfxtp_1
Xnetwork.in_period\[106\]\[3\]$_DFFE_PP_ clknet_leaf_243_clk
+ net436 _03095_ VSS VSS VDD VDD network.in_period\[106\]\[3\]
+ sky130_fd_sc_hd__edfxtp_1
Xnetwork.in_period\[107\]\[0\]$_DFFE_PP_ clknet_leaf_29_clk
+ net454 _03096_ VSS VSS VDD VDD network.in_period\[107\]\[0\]
+ sky130_fd_sc_hd__edfxtp_1
Xnetwork.in_period\[107\]\[1\]$_DFFE_PP_ clknet_leaf_29_clk
+ net451 _03096_ VSS VSS VDD VDD network.in_period\[107\]\[1\]
+ sky130_fd_sc_hd__edfxtp_1
Xnetwork.in_period\[107\]\[2\]$_DFFE_PP_ clknet_leaf_29_clk
+ net444 _03096_ VSS VSS VDD VDD network.in_period\[107\]\[2\]
+ sky130_fd_sc_hd__edfxtp_1
Xnetwork.in_period\[107\]\[3\]$_DFFE_PP_ clknet_leaf_29_clk
+ net433 _03096_ VSS VSS VDD VDD network.in_period\[107\]\[3\]
+ sky130_fd_sc_hd__edfxtp_1
Xnetwork.in_period\[108\]\[0\]$_DFFE_PP_ clknet_leaf_28_clk
+ net457 _03097_ VSS VSS VDD VDD network.in_period\[108\]\[0\]
+ sky130_fd_sc_hd__edfxtp_1
Xnetwork.in_period\[108\]\[1\]$_DFFE_PP_ clknet_leaf_8_clk
+ net449 _03097_ VSS VSS VDD VDD network.in_period\[108\]\[1\]
+ sky130_fd_sc_hd__edfxtp_1
Xnetwork.in_period\[108\]\[2\]$_DFFE_PP_ clknet_leaf_264_clk
+ net441 _03097_ VSS VSS VDD VDD network.in_period\[108\]\[2\]
+ sky130_fd_sc_hd__edfxtp_1
Xnetwork.in_period\[108\]\[3\]$_DFFE_PP_ clknet_leaf_8_clk
+ net436 _03097_ VSS VSS VDD VDD network.in_period\[108\]\[3\]
+ sky130_fd_sc_hd__edfxtp_1
Xnetwork.in_period\[109\]\[0\]$_DFFE_PP_ clknet_leaf_242_clk
+ net455 _03098_ VSS VSS VDD VDD network.in_period\[109\]\[0\]
+ sky130_fd_sc_hd__edfxtp_1
Xnetwork.in_period\[109\]\[1\]$_DFFE_PP_ clknet_leaf_244_clk
+ net449 _03098_ VSS VSS VDD VDD network.in_period\[109\]\[1\]
+ sky130_fd_sc_hd__edfxtp_1
Xnetwork.in_period\[109\]\[2\]$_DFFE_PP_ clknet_leaf_242_clk
+ net443 _03098_ VSS VSS VDD VDD network.in_period\[109\]\[2\]
+ sky130_fd_sc_hd__edfxtp_1
Xnetwork.in_period\[109\]\[3\]$_DFFE_PP_ clknet_leaf_242_clk
+ net436 _03098_ VSS VSS VDD VDD network.in_period\[109\]\[3\]
+ sky130_fd_sc_hd__edfxtp_1
Xnetwork.in_period\[10\]\[0\]$_DFFE_PP_ clknet_leaf_63_clk
+ net453 _03099_ VSS VSS VDD VDD network.in_period\[10\]\[0\]
+ sky130_fd_sc_hd__edfxtp_1
Xnetwork.in_period\[10\]\[1\]$_DFFE_PP_ clknet_leaf_63_clk
+ net446 _03099_ VSS VSS VDD VDD network.in_period\[10\]\[1\]
+ sky130_fd_sc_hd__edfxtp_1
Xnetwork.in_period\[10\]\[2\]$_DFFE_PP_ clknet_leaf_60_clk
+ net438 _03099_ VSS VSS VDD VDD network.in_period\[10\]\[2\]
+ sky130_fd_sc_hd__edfxtp_1
Xnetwork.in_period\[10\]\[3\]$_DFFE_PP_ clknet_leaf_60_clk
+ net431 _03099_ VSS VSS VDD VDD network.in_period\[10\]\[3\]
+ sky130_fd_sc_hd__edfxtp_1
Xnetwork.in_period\[110\]\[0\]$_DFFE_PP_ clknet_leaf_28_clk
+ net457 _03100_ VSS VSS VDD VDD network.in_period\[110\]\[0\]
+ sky130_fd_sc_hd__edfxtp_1
Xnetwork.in_period\[110\]\[1\]$_DFFE_PP_ clknet_leaf_28_clk
+ net449 _03100_ VSS VSS VDD VDD network.in_period\[110\]\[1\]
+ sky130_fd_sc_hd__edfxtp_1
Xnetwork.in_period\[110\]\[2\]$_DFFE_PP_ clknet_leaf_243_clk
+ net441 _03100_ VSS VSS VDD VDD network.in_period\[110\]\[2\]
+ sky130_fd_sc_hd__edfxtp_1
Xnetwork.in_period\[110\]\[3\]$_DFFE_PP_ clknet_leaf_28_clk
+ net436 _03100_ VSS VSS VDD VDD network.in_period\[110\]\[3\]
+ sky130_fd_sc_hd__edfxtp_1
Xnetwork.in_period\[111\]\[0\]$_DFFE_PP_ clknet_leaf_243_clk
+ net455 _03101_ VSS VSS VDD VDD network.in_period\[111\]\[0\]
+ sky130_fd_sc_hd__edfxtp_1
Xnetwork.in_period\[111\]\[1\]$_DFFE_PP_ clknet_leaf_244_clk
+ net449 _03101_ VSS VSS VDD VDD network.in_period\[111\]\[1\]
+ sky130_fd_sc_hd__edfxtp_1
Xnetwork.in_period\[111\]\[2\]$_DFFE_PP_ clknet_leaf_244_clk
+ net441 _03101_ VSS VSS VDD VDD network.in_period\[111\]\[2\]
+ sky130_fd_sc_hd__edfxtp_1
Xnetwork.in_period\[111\]\[3\]$_DFFE_PP_ clknet_leaf_244_clk
+ net436 _03101_ VSS VSS VDD VDD network.in_period\[111\]\[3\]
+ sky130_fd_sc_hd__edfxtp_1
Xnetwork.in_period\[112\]\[0\]$_DFFE_PP_ clknet_leaf_216_clk
+ net456 _03102_ VSS VSS VDD VDD network.in_period\[112\]\[0\]
+ sky130_fd_sc_hd__edfxtp_1
Xnetwork.in_period\[112\]\[1\]$_DFFE_PP_ clknet_leaf_216_clk
+ net448 _03102_ VSS VSS VDD VDD network.in_period\[112\]\[1\]
+ sky130_fd_sc_hd__edfxtp_1
Xnetwork.in_period\[112\]\[2\]$_DFFE_PP_ clknet_leaf_221_clk
+ net440 _03102_ VSS VSS VDD VDD network.in_period\[112\]\[2\]
+ sky130_fd_sc_hd__edfxtp_1
Xnetwork.in_period\[112\]\[3\]$_DFFE_PP_ clknet_leaf_221_clk
+ net437 _03102_ VSS VSS VDD VDD network.in_period\[112\]\[3\]
+ sky130_fd_sc_hd__edfxtp_1
Xnetwork.in_period\[113\]\[0\]$_DFFE_PP_ clknet_leaf_216_clk
+ net456 _03103_ VSS VSS VDD VDD network.in_period\[113\]\[0\]
+ sky130_fd_sc_hd__edfxtp_1
Xnetwork.in_period\[113\]\[1\]$_DFFE_PP_ clknet_leaf_216_clk
+ net448 _03103_ VSS VSS VDD VDD network.in_period\[113\]\[1\]
+ sky130_fd_sc_hd__edfxtp_1
Xnetwork.in_period\[113\]\[2\]$_DFFE_PP_ clknet_leaf_216_clk
+ net440 _03103_ VSS VSS VDD VDD network.in_period\[113\]\[2\]
+ sky130_fd_sc_hd__edfxtp_1
Xnetwork.in_period\[113\]\[3\]$_DFFE_PP_ clknet_leaf_216_clk
+ net434 _03103_ VSS VSS VDD VDD network.in_period\[113\]\[3\]
+ sky130_fd_sc_hd__edfxtp_1
Xnetwork.in_period\[114\]\[0\]$_DFFE_PP_ clknet_leaf_217_clk
+ net456 _03104_ VSS VSS VDD VDD network.in_period\[114\]\[0\]
+ sky130_fd_sc_hd__edfxtp_1
Xnetwork.in_period\[114\]\[1\]$_DFFE_PP_ clknet_leaf_217_clk
+ net448 _03104_ VSS VSS VDD VDD network.in_period\[114\]\[1\]
+ sky130_fd_sc_hd__edfxtp_1
Xnetwork.in_period\[114\]\[2\]$_DFFE_PP_ clknet_leaf_217_clk
+ net440 _03104_ VSS VSS VDD VDD network.in_period\[114\]\[2\]
+ sky130_fd_sc_hd__edfxtp_1
Xnetwork.in_period\[114\]\[3\]$_DFFE_PP_ clknet_leaf_217_clk
+ net437 _03104_ VSS VSS VDD VDD network.in_period\[114\]\[3\]
+ sky130_fd_sc_hd__edfxtp_1
Xnetwork.in_period\[115\]\[0\]$_DFFE_PP_ clknet_leaf_218_clk
+ net456 _03105_ VSS VSS VDD VDD network.in_period\[115\]\[0\]
+ sky130_fd_sc_hd__edfxtp_1
Xnetwork.in_period\[115\]\[1\]$_DFFE_PP_ clknet_leaf_215_clk
+ net448 _03105_ VSS VSS VDD VDD network.in_period\[115\]\[1\]
+ sky130_fd_sc_hd__edfxtp_1
Xnetwork.in_period\[115\]\[2\]$_DFFE_PP_ clknet_leaf_215_clk
+ net440 _03105_ VSS VSS VDD VDD network.in_period\[115\]\[2\]
+ sky130_fd_sc_hd__edfxtp_1
Xnetwork.in_period\[115\]\[3\]$_DFFE_PP_ clknet_leaf_215_clk
+ net437 _03105_ VSS VSS VDD VDD network.in_period\[115\]\[3\]
+ sky130_fd_sc_hd__edfxtp_1
Xnetwork.in_period\[116\]\[0\]$_DFFE_PP_ clknet_leaf_212_clk
+ net458 _03106_ VSS VSS VDD VDD network.in_period\[116\]\[0\]
+ sky130_fd_sc_hd__edfxtp_1
Xnetwork.in_period\[116\]\[1\]$_DFFE_PP_ clknet_leaf_212_clk
+ net450 _03106_ VSS VSS VDD VDD network.in_period\[116\]\[1\]
+ sky130_fd_sc_hd__edfxtp_1
Xnetwork.in_period\[116\]\[2\]$_DFFE_PP_ clknet_leaf_211_clk
+ net440 _03106_ VSS VSS VDD VDD network.in_period\[116\]\[2\]
+ sky130_fd_sc_hd__edfxtp_1
Xnetwork.in_period\[116\]\[3\]$_DFFE_PP_ clknet_leaf_211_clk
+ net434 _03106_ VSS VSS VDD VDD network.in_period\[116\]\[3\]
+ sky130_fd_sc_hd__edfxtp_1
Xnetwork.in_period\[117\]\[0\]$_DFFE_PP_ clknet_leaf_211_clk
+ net458 _03107_ VSS VSS VDD VDD network.in_period\[117\]\[0\]
+ sky130_fd_sc_hd__edfxtp_1
Xnetwork.in_period\[117\]\[1\]$_DFFE_PP_ clknet_leaf_210_clk
+ net450 _03107_ VSS VSS VDD VDD network.in_period\[117\]\[1\]
+ sky130_fd_sc_hd__edfxtp_1
Xnetwork.in_period\[117\]\[2\]$_DFFE_PP_ clknet_leaf_206_clk
+ net440 _03107_ VSS VSS VDD VDD network.in_period\[117\]\[2\]
+ sky130_fd_sc_hd__edfxtp_1
Xnetwork.in_period\[117\]\[3\]$_DFFE_PP_ clknet_leaf_211_clk
+ net434 _03107_ VSS VSS VDD VDD network.in_period\[117\]\[3\]
+ sky130_fd_sc_hd__edfxtp_1
Xnetwork.in_period\[118\]\[0\]$_DFFE_PP_ clknet_leaf_210_clk
+ net458 _03108_ VSS VSS VDD VDD network.in_period\[118\]\[0\]
+ sky130_fd_sc_hd__edfxtp_1
Xnetwork.in_period\[118\]\[1\]$_DFFE_PP_ clknet_leaf_210_clk
+ net450 _03108_ VSS VSS VDD VDD network.in_period\[118\]\[1\]
+ sky130_fd_sc_hd__edfxtp_1
Xnetwork.in_period\[118\]\[2\]$_DFFE_PP_ clknet_leaf_210_clk
+ net440 _03108_ VSS VSS VDD VDD network.in_period\[118\]\[2\]
+ sky130_fd_sc_hd__edfxtp_1
Xnetwork.in_period\[118\]\[3\]$_DFFE_PP_ clknet_leaf_209_clk
+ net434 _03108_ VSS VSS VDD VDD network.in_period\[118\]\[3\]
+ sky130_fd_sc_hd__edfxtp_1
Xnetwork.in_period\[119\]\[0\]$_DFFE_PP_ clknet_leaf_212_clk
+ net458 _03109_ VSS VSS VDD VDD network.in_period\[119\]\[0\]
+ sky130_fd_sc_hd__edfxtp_1
Xnetwork.in_period\[119\]\[1\]$_DFFE_PP_ clknet_leaf_212_clk
+ net450 _03109_ VSS VSS VDD VDD network.in_period\[119\]\[1\]
+ sky130_fd_sc_hd__edfxtp_1
Xnetwork.in_period\[119\]\[2\]$_DFFE_PP_ clknet_leaf_210_clk
+ net440 _03109_ VSS VSS VDD VDD network.in_period\[119\]\[2\]
+ sky130_fd_sc_hd__edfxtp_1
Xnetwork.in_period\[119\]\[3\]$_DFFE_PP_ clknet_leaf_212_clk
+ net434 _03109_ VSS VSS VDD VDD network.in_period\[119\]\[3\]
+ sky130_fd_sc_hd__edfxtp_1
Xnetwork.in_period\[11\]\[0\]$_DFFE_PP_ clknet_leaf_59_clk
+ net453 _03110_ VSS VSS VDD VDD network.in_period\[11\]\[0\]
+ sky130_fd_sc_hd__edfxtp_1
Xnetwork.in_period\[11\]\[1\]$_DFFE_PP_ clknet_leaf_58_clk
+ net446 _03110_ VSS VSS VDD VDD network.in_period\[11\]\[1\]
+ sky130_fd_sc_hd__edfxtp_1
Xnetwork.in_period\[11\]\[2\]$_DFFE_PP_ clknet_leaf_60_clk
+ net438 _03110_ VSS VSS VDD VDD network.in_period\[11\]\[2\]
+ sky130_fd_sc_hd__edfxtp_1
Xnetwork.in_period\[11\]\[3\]$_DFFE_PP_ clknet_leaf_59_clk
+ net431 _03110_ VSS VSS VDD VDD network.in_period\[11\]\[3\]
+ sky130_fd_sc_hd__edfxtp_1
Xnetwork.in_period\[120\]\[0\]$_DFFE_PP_ clknet_leaf_253_clk
+ net458 _03111_ VSS VSS VDD VDD network.in_period\[120\]\[0\]
+ sky130_fd_sc_hd__edfxtp_1
Xnetwork.in_period\[120\]\[1\]$_DFFE_PP_ clknet_leaf_253_clk
+ net450 _03111_ VSS VSS VDD VDD network.in_period\[120\]\[1\]
+ sky130_fd_sc_hd__edfxtp_1
Xnetwork.in_period\[120\]\[2\]$_DFFE_PP_ clknet_leaf_253_clk
+ net443 _03111_ VSS VSS VDD VDD network.in_period\[120\]\[2\]
+ sky130_fd_sc_hd__edfxtp_1
Xnetwork.in_period\[120\]\[3\]$_DFFE_PP_ clknet_leaf_253_clk
+ net434 _03111_ VSS VSS VDD VDD network.in_period\[120\]\[3\]
+ sky130_fd_sc_hd__edfxtp_1
Xnetwork.in_period\[121\]\[0\]$_DFFE_PP_ clknet_leaf_250_clk
+ net456 _03112_ VSS VSS VDD VDD network.in_period\[121\]\[0\]
+ sky130_fd_sc_hd__edfxtp_1
Xnetwork.in_period\[121\]\[1\]$_DFFE_PP_ clknet_leaf_252_clk
+ net449 _03112_ VSS VSS VDD VDD network.in_period\[121\]\[1\]
+ sky130_fd_sc_hd__edfxtp_1
Xnetwork.in_period\[121\]\[2\]$_DFFE_PP_ clknet_leaf_252_clk
+ net440 _03112_ VSS VSS VDD VDD network.in_period\[121\]\[2\]
+ sky130_fd_sc_hd__edfxtp_1
Xnetwork.in_period\[121\]\[3\]$_DFFE_PP_ clknet_leaf_250_clk
+ net437 _03112_ VSS VSS VDD VDD network.in_period\[121\]\[3\]
+ sky130_fd_sc_hd__edfxtp_1
Xnetwork.in_period\[122\]\[0\]$_DFFE_PP_ clknet_leaf_252_clk
+ net458 _03113_ VSS VSS VDD VDD network.in_period\[122\]\[0\]
+ sky130_fd_sc_hd__edfxtp_1
Xnetwork.in_period\[122\]\[1\]$_DFFE_PP_ clknet_leaf_252_clk
+ net450 _03113_ VSS VSS VDD VDD network.in_period\[122\]\[1\]
+ sky130_fd_sc_hd__edfxtp_1
Xnetwork.in_period\[122\]\[2\]$_DFFE_PP_ clknet_leaf_252_clk
+ net443 _03113_ VSS VSS VDD VDD network.in_period\[122\]\[2\]
+ sky130_fd_sc_hd__edfxtp_1
Xnetwork.in_period\[122\]\[3\]$_DFFE_PP_ clknet_leaf_252_clk
+ net434 _03113_ VSS VSS VDD VDD network.in_period\[122\]\[3\]
+ sky130_fd_sc_hd__edfxtp_1
Xnetwork.in_period\[123\]\[0\]$_DFFE_PP_ clknet_leaf_256_clk
+ net458 _03114_ VSS VSS VDD VDD network.in_period\[123\]\[0\]
+ sky130_fd_sc_hd__edfxtp_1
Xnetwork.in_period\[123\]\[1\]$_DFFE_PP_ clknet_leaf_255_clk
+ net450 _03114_ VSS VSS VDD VDD network.in_period\[123\]\[1\]
+ sky130_fd_sc_hd__edfxtp_1
Xnetwork.in_period\[123\]\[2\]$_DFFE_PP_ clknet_leaf_256_clk
+ net443 _03114_ VSS VSS VDD VDD network.in_period\[123\]\[2\]
+ sky130_fd_sc_hd__edfxtp_1
Xnetwork.in_period\[123\]\[3\]$_DFFE_PP_ clknet_leaf_256_clk
+ net434 _03114_ VSS VSS VDD VDD network.in_period\[123\]\[3\]
+ sky130_fd_sc_hd__edfxtp_1
Xnetwork.in_period\[124\]\[0\]$_DFFE_PP_ clknet_leaf_254_clk
+ net458 _03115_ VSS VSS VDD VDD network.in_period\[124\]\[0\]
+ sky130_fd_sc_hd__edfxtp_1
Xnetwork.in_period\[124\]\[1\]$_DFFE_PP_ clknet_leaf_254_clk
+ net450 _03115_ VSS VSS VDD VDD network.in_period\[124\]\[1\]
+ sky130_fd_sc_hd__edfxtp_1
Xnetwork.in_period\[124\]\[2\]$_DFFE_PP_ clknet_leaf_253_clk
+ net443 _03115_ VSS VSS VDD VDD network.in_period\[124\]\[2\]
+ sky130_fd_sc_hd__edfxtp_1
Xnetwork.in_period\[124\]\[3\]$_DFFE_PP_ clknet_leaf_254_clk
+ net434 _03115_ VSS VSS VDD VDD network.in_period\[124\]\[3\]
+ sky130_fd_sc_hd__edfxtp_1
Xnetwork.in_period\[125\]\[0\]$_DFFE_PP_ clknet_leaf_255_clk
+ net458 _03116_ VSS VSS VDD VDD network.in_period\[125\]\[0\]
+ sky130_fd_sc_hd__edfxtp_1
Xnetwork.in_period\[125\]\[1\]$_DFFE_PP_ clknet_leaf_255_clk
+ net450 _03116_ VSS VSS VDD VDD network.in_period\[125\]\[1\]
+ sky130_fd_sc_hd__edfxtp_1
Xnetwork.in_period\[125\]\[2\]$_DFFE_PP_ clknet_leaf_256_clk
+ net443 _03116_ VSS VSS VDD VDD network.in_period\[125\]\[2\]
+ sky130_fd_sc_hd__edfxtp_1
Xnetwork.in_period\[125\]\[3\]$_DFFE_PP_ clknet_leaf_255_clk
+ net434 _03116_ VSS VSS VDD VDD network.in_period\[125\]\[3\]
+ sky130_fd_sc_hd__edfxtp_1
Xnetwork.in_period\[126\]\[0\]$_DFFE_PP_ clknet_leaf_213_clk
+ net458 _03117_ VSS VSS VDD VDD network.in_period\[126\]\[0\]
+ sky130_fd_sc_hd__edfxtp_1
Xnetwork.in_period\[126\]\[1\]$_DFFE_PP_ clknet_leaf_213_clk
+ net450 _03117_ VSS VSS VDD VDD network.in_period\[126\]\[1\]
+ sky130_fd_sc_hd__edfxtp_1
Xnetwork.in_period\[126\]\[2\]$_DFFE_PP_ clknet_leaf_213_clk
+ net443 _03117_ VSS VSS VDD VDD network.in_period\[126\]\[2\]
+ sky130_fd_sc_hd__edfxtp_1
Xnetwork.in_period\[126\]\[3\]$_DFFE_PP_ clknet_leaf_213_clk
+ net434 _03117_ VSS VSS VDD VDD network.in_period\[126\]\[3\]
+ sky130_fd_sc_hd__edfxtp_1
Xnetwork.in_period\[127\]\[0\]$_DFFE_PP_ clknet_leaf_214_clk
+ net458 _03118_ VSS VSS VDD VDD network.in_period\[127\]\[0\]
+ sky130_fd_sc_hd__edfxtp_1
Xnetwork.in_period\[127\]\[1\]$_DFFE_PP_ clknet_leaf_214_clk
+ net450 _03118_ VSS VSS VDD VDD network.in_period\[127\]\[1\]
+ sky130_fd_sc_hd__edfxtp_1
Xnetwork.in_period\[127\]\[2\]$_DFFE_PP_ clknet_leaf_214_clk
+ net443 _03118_ VSS VSS VDD VDD network.in_period\[127\]\[2\]
+ sky130_fd_sc_hd__edfxtp_1
Xnetwork.in_period\[127\]\[3\]$_DFFE_PP_ clknet_leaf_214_clk
+ net434 _03118_ VSS VSS VDD VDD network.in_period\[127\]\[3\]
+ sky130_fd_sc_hd__edfxtp_1
Xnetwork.in_period\[128\]\[0\]$_DFFE_PP_ clknet_leaf_225_clk
+ net455 _03119_ VSS VSS VDD VDD network.in_period\[128\]\[0\]
+ sky130_fd_sc_hd__edfxtp_1
Xnetwork.in_period\[128\]\[1\]$_DFFE_PP_ clknet_leaf_225_clk
+ net448 _03119_ VSS VSS VDD VDD network.in_period\[128\]\[1\]
+ sky130_fd_sc_hd__edfxtp_1
Xnetwork.in_period\[128\]\[2\]$_DFFE_PP_ clknet_leaf_225_clk
+ net441 _03119_ VSS VSS VDD VDD network.in_period\[128\]\[2\]
+ sky130_fd_sc_hd__edfxtp_1
Xnetwork.in_period\[128\]\[3\]$_DFFE_PP_ clknet_leaf_225_clk
+ net435 _03119_ VSS VSS VDD VDD network.in_period\[128\]\[3\]
+ sky130_fd_sc_hd__edfxtp_1
Xnetwork.in_period\[129\]\[0\]$_DFFE_PP_ clknet_leaf_224_clk
+ net456 _03120_ VSS VSS VDD VDD network.in_period\[129\]\[0\]
+ sky130_fd_sc_hd__edfxtp_1
Xnetwork.in_period\[129\]\[1\]$_DFFE_PP_ clknet_leaf_224_clk
+ net448 _03120_ VSS VSS VDD VDD network.in_period\[129\]\[1\]
+ sky130_fd_sc_hd__edfxtp_1
Xnetwork.in_period\[129\]\[2\]$_DFFE_PP_ clknet_leaf_224_clk
+ net440 _03120_ VSS VSS VDD VDD network.in_period\[129\]\[2\]
+ sky130_fd_sc_hd__edfxtp_1
Xnetwork.in_period\[129\]\[3\]$_DFFE_PP_ clknet_leaf_224_clk
+ net435 _03120_ VSS VSS VDD VDD network.in_period\[129\]\[3\]
+ sky130_fd_sc_hd__edfxtp_1
Xnetwork.in_period\[12\]\[0\]$_DFFE_PP_ clknet_leaf_19_clk
+ net454 _03121_ VSS VSS VDD VDD network.in_period\[12\]\[0\]
+ sky130_fd_sc_hd__edfxtp_1
Xnetwork.in_period\[12\]\[1\]$_DFFE_PP_ clknet_leaf_19_clk
+ net446 _03121_ VSS VSS VDD VDD network.in_period\[12\]\[1\]
+ sky130_fd_sc_hd__edfxtp_1
Xnetwork.in_period\[12\]\[2\]$_DFFE_PP_ clknet_leaf_57_clk
+ net438 _03121_ VSS VSS VDD VDD network.in_period\[12\]\[2\]
+ sky130_fd_sc_hd__edfxtp_1
Xnetwork.in_period\[12\]\[3\]$_DFFE_PP_ clknet_leaf_19_clk
+ net431 _03121_ VSS VSS VDD VDD network.in_period\[12\]\[3\]
+ sky130_fd_sc_hd__edfxtp_1
Xnetwork.in_period\[130\]\[0\]$_DFFE_PP_ clknet_leaf_227_clk
+ net455 _03122_ VSS VSS VDD VDD network.in_period\[130\]\[0\]
+ sky130_fd_sc_hd__edfxtp_1
Xnetwork.in_period\[130\]\[1\]$_DFFE_PP_ clknet_leaf_227_clk
+ net448 _03122_ VSS VSS VDD VDD network.in_period\[130\]\[1\]
+ sky130_fd_sc_hd__edfxtp_1
Xnetwork.in_period\[130\]\[2\]$_DFFE_PP_ clknet_leaf_227_clk
+ net441 _03122_ VSS VSS VDD VDD network.in_period\[130\]\[2\]
+ sky130_fd_sc_hd__edfxtp_1
Xnetwork.in_period\[130\]\[3\]$_DFFE_PP_ clknet_leaf_227_clk
+ net435 _03122_ VSS VSS VDD VDD network.in_period\[130\]\[3\]
+ sky130_fd_sc_hd__edfxtp_1
Xnetwork.in_period\[131\]\[0\]$_DFFE_PP_ clknet_leaf_223_clk
+ net456 _03123_ VSS VSS VDD VDD network.in_period\[131\]\[0\]
+ sky130_fd_sc_hd__edfxtp_1
Xnetwork.in_period\[131\]\[1\]$_DFFE_PP_ clknet_leaf_223_clk
+ net448 _03123_ VSS VSS VDD VDD network.in_period\[131\]\[1\]
+ sky130_fd_sc_hd__edfxtp_1
Xnetwork.in_period\[131\]\[2\]$_DFFE_PP_ clknet_leaf_223_clk
+ net440 _03123_ VSS VSS VDD VDD network.in_period\[131\]\[2\]
+ sky130_fd_sc_hd__edfxtp_1
Xnetwork.in_period\[131\]\[3\]$_DFFE_PP_ clknet_leaf_223_clk
+ net435 _03123_ VSS VSS VDD VDD network.in_period\[131\]\[3\]
+ sky130_fd_sc_hd__edfxtp_1
Xnetwork.in_period\[132\]\[0\]$_DFFE_PP_ clknet_leaf_207_clk
+ net456 _03124_ VSS VSS VDD VDD network.in_period\[132\]\[0\]
+ sky130_fd_sc_hd__edfxtp_1
Xnetwork.in_period\[132\]\[1\]$_DFFE_PP_ clknet_leaf_207_clk
+ net448 _03124_ VSS VSS VDD VDD network.in_period\[132\]\[1\]
+ sky130_fd_sc_hd__edfxtp_1
Xnetwork.in_period\[132\]\[2\]$_DFFE_PP_ clknet_leaf_207_clk
+ net440 _03124_ VSS VSS VDD VDD network.in_period\[132\]\[2\]
+ sky130_fd_sc_hd__edfxtp_1
Xnetwork.in_period\[132\]\[3\]$_DFFE_PP_ clknet_leaf_207_clk
+ net434 _03124_ VSS VSS VDD VDD network.in_period\[132\]\[3\]
+ sky130_fd_sc_hd__edfxtp_1
Xnetwork.in_period\[133\]\[0\]$_DFFE_PP_ clknet_leaf_205_clk
+ net456 _03125_ VSS VSS VDD VDD network.in_period\[133\]\[0\]
+ sky130_fd_sc_hd__edfxtp_1
Xnetwork.in_period\[133\]\[1\]$_DFFE_PP_ clknet_leaf_205_clk
+ net448 _03125_ VSS VSS VDD VDD network.in_period\[133\]\[1\]
+ sky130_fd_sc_hd__edfxtp_1
Xnetwork.in_period\[133\]\[2\]$_DFFE_PP_ clknet_leaf_205_clk
+ net440 _03125_ VSS VSS VDD VDD network.in_period\[133\]\[2\]
+ sky130_fd_sc_hd__edfxtp_1
Xnetwork.in_period\[133\]\[3\]$_DFFE_PP_ clknet_leaf_205_clk
+ net434 _03125_ VSS VSS VDD VDD network.in_period\[133\]\[3\]
+ sky130_fd_sc_hd__edfxtp_1
Xnetwork.in_period\[134\]\[0\]$_DFFE_PP_ clknet_leaf_204_clk
+ net456 _03126_ VSS VSS VDD VDD network.in_period\[134\]\[0\]
+ sky130_fd_sc_hd__edfxtp_1
Xnetwork.in_period\[134\]\[1\]$_DFFE_PP_ clknet_leaf_205_clk
+ net448 _03126_ VSS VSS VDD VDD network.in_period\[134\]\[1\]
+ sky130_fd_sc_hd__edfxtp_1
Xnetwork.in_period\[134\]\[2\]$_DFFE_PP_ clknet_leaf_204_clk
+ net440 _03126_ VSS VSS VDD VDD network.in_period\[134\]\[2\]
+ sky130_fd_sc_hd__edfxtp_1
Xnetwork.in_period\[134\]\[3\]$_DFFE_PP_ clknet_leaf_204_clk
+ net434 _03126_ VSS VSS VDD VDD network.in_period\[134\]\[3\]
+ sky130_fd_sc_hd__edfxtp_1
Xnetwork.in_period\[135\]\[0\]$_DFFE_PP_ clknet_leaf_220_clk
+ net456 _03127_ VSS VSS VDD VDD network.in_period\[135\]\[0\]
+ sky130_fd_sc_hd__edfxtp_1
Xnetwork.in_period\[135\]\[1\]$_DFFE_PP_ clknet_leaf_220_clk
+ net448 _03127_ VSS VSS VDD VDD network.in_period\[135\]\[1\]
+ sky130_fd_sc_hd__edfxtp_1
Xnetwork.in_period\[135\]\[2\]$_DFFE_PP_ clknet_leaf_221_clk
+ net440 _03127_ VSS VSS VDD VDD network.in_period\[135\]\[2\]
+ sky130_fd_sc_hd__edfxtp_1
Xnetwork.in_period\[135\]\[3\]$_DFFE_PP_ clknet_leaf_220_clk
+ net437 _03127_ VSS VSS VDD VDD network.in_period\[135\]\[3\]
+ sky130_fd_sc_hd__edfxtp_1
Xnetwork.in_period\[136\]\[0\]$_DFFE_PP_ clknet_leaf_211_clk
+ net456 _03128_ VSS VSS VDD VDD network.in_period\[136\]\[0\]
+ sky130_fd_sc_hd__edfxtp_1
Xnetwork.in_period\[136\]\[1\]$_DFFE_PP_ clknet_leaf_211_clk
+ net450 _03128_ VSS VSS VDD VDD network.in_period\[136\]\[1\]
+ sky130_fd_sc_hd__edfxtp_1
Xnetwork.in_period\[136\]\[2\]$_DFFE_PP_ clknet_leaf_206_clk
+ net440 _03128_ VSS VSS VDD VDD network.in_period\[136\]\[2\]
+ sky130_fd_sc_hd__edfxtp_1
Xnetwork.in_period\[136\]\[3\]$_DFFE_PP_ clknet_leaf_206_clk
+ net434 _03128_ VSS VSS VDD VDD network.in_period\[136\]\[3\]
+ sky130_fd_sc_hd__edfxtp_1
Xnetwork.in_period\[137\]\[0\]$_DFFE_PP_ clknet_leaf_206_clk
+ net456 _03129_ VSS VSS VDD VDD network.in_period\[137\]\[0\]
+ sky130_fd_sc_hd__edfxtp_1
Xnetwork.in_period\[137\]\[1\]$_DFFE_PP_ clknet_leaf_206_clk
+ net448 _03129_ VSS VSS VDD VDD network.in_period\[137\]\[1\]
+ sky130_fd_sc_hd__edfxtp_1
Xnetwork.in_period\[137\]\[2\]$_DFFE_PP_ clknet_leaf_222_clk
+ net440 _03129_ VSS VSS VDD VDD network.in_period\[137\]\[2\]
+ sky130_fd_sc_hd__edfxtp_1
Xnetwork.in_period\[137\]\[3\]$_DFFE_PP_ clknet_leaf_221_clk
+ net434 _03129_ VSS VSS VDD VDD network.in_period\[137\]\[3\]
+ sky130_fd_sc_hd__edfxtp_1
Xnetwork.in_period\[138\]\[0\]$_DFFE_PP_ clknet_leaf_238_clk
+ net455 _03130_ VSS VSS VDD VDD network.in_period\[138\]\[0\]
+ sky130_fd_sc_hd__edfxtp_1
Xnetwork.in_period\[138\]\[1\]$_DFFE_PP_ clknet_leaf_238_clk
+ net448 _03130_ VSS VSS VDD VDD network.in_period\[138\]\[1\]
+ sky130_fd_sc_hd__edfxtp_1
Xnetwork.in_period\[138\]\[2\]$_DFFE_PP_ clknet_leaf_238_clk
+ net441 _03130_ VSS VSS VDD VDD network.in_period\[138\]\[2\]
+ sky130_fd_sc_hd__edfxtp_1
Xnetwork.in_period\[138\]\[3\]$_DFFE_PP_ clknet_leaf_238_clk
+ net435 _03130_ VSS VSS VDD VDD network.in_period\[138\]\[3\]
+ sky130_fd_sc_hd__edfxtp_1
Xnetwork.in_period\[139\]\[0\]$_DFFE_PP_ clknet_leaf_222_clk
+ net456 _03131_ VSS VSS VDD VDD network.in_period\[139\]\[0\]
+ sky130_fd_sc_hd__edfxtp_1
Xnetwork.in_period\[139\]\[1\]$_DFFE_PP_ clknet_leaf_222_clk
+ net448 _03131_ VSS VSS VDD VDD network.in_period\[139\]\[1\]
+ sky130_fd_sc_hd__edfxtp_1
Xnetwork.in_period\[139\]\[2\]$_DFFE_PP_ clknet_leaf_222_clk
+ net440 _03131_ VSS VSS VDD VDD network.in_period\[139\]\[2\]
+ sky130_fd_sc_hd__edfxtp_1
Xnetwork.in_period\[139\]\[3\]$_DFFE_PP_ clknet_leaf_222_clk
+ net434 _03131_ VSS VSS VDD VDD network.in_period\[139\]\[3\]
+ sky130_fd_sc_hd__edfxtp_1
Xnetwork.in_period\[13\]\[0\]$_DFFE_PP_ clknet_leaf_20_clk
+ net454 _03132_ VSS VSS VDD VDD network.in_period\[13\]\[0\]
+ sky130_fd_sc_hd__edfxtp_1
Xnetwork.in_period\[13\]\[1\]$_DFFE_PP_ clknet_leaf_20_clk
+ net446 _03132_ VSS VSS VDD VDD network.in_period\[13\]\[1\]
+ sky130_fd_sc_hd__edfxtp_1
Xnetwork.in_period\[13\]\[2\]$_DFFE_PP_ clknet_leaf_20_clk
+ net438 _03132_ VSS VSS VDD VDD network.in_period\[13\]\[2\]
+ sky130_fd_sc_hd__edfxtp_1
Xnetwork.in_period\[13\]\[3\]$_DFFE_PP_ clknet_leaf_20_clk
+ net431 _03132_ VSS VSS VDD VDD network.in_period\[13\]\[3\]
+ sky130_fd_sc_hd__edfxtp_1
Xnetwork.in_period\[140\]\[0\]$_DFFE_PP_ clknet_leaf_249_clk
+ net456 _03133_ VSS VSS VDD VDD network.in_period\[140\]\[0\]
+ sky130_fd_sc_hd__edfxtp_1
Xnetwork.in_period\[140\]\[1\]$_DFFE_PP_ clknet_leaf_250_clk
+ net448 _03133_ VSS VSS VDD VDD network.in_period\[140\]\[1\]
+ sky130_fd_sc_hd__edfxtp_1
Xnetwork.in_period\[140\]\[2\]$_DFFE_PP_ clknet_leaf_218_clk
+ net440 _03133_ VSS VSS VDD VDD network.in_period\[140\]\[2\]
+ sky130_fd_sc_hd__edfxtp_1
Xnetwork.in_period\[140\]\[3\]$_DFFE_PP_ clknet_leaf_218_clk
+ net437 _03133_ VSS VSS VDD VDD network.in_period\[140\]\[3\]
+ sky130_fd_sc_hd__edfxtp_1
Xnetwork.in_period\[141\]\[0\]$_DFFE_PP_ clknet_leaf_249_clk
+ net456 _03134_ VSS VSS VDD VDD network.in_period\[141\]\[0\]
+ sky130_fd_sc_hd__edfxtp_1
Xnetwork.in_period\[141\]\[1\]$_DFFE_PP_ clknet_leaf_248_clk
+ net448 _03134_ VSS VSS VDD VDD network.in_period\[141\]\[1\]
+ sky130_fd_sc_hd__edfxtp_1
Xnetwork.in_period\[141\]\[2\]$_DFFE_PP_ clknet_leaf_219_clk
+ net440 _03134_ VSS VSS VDD VDD network.in_period\[141\]\[2\]
+ sky130_fd_sc_hd__edfxtp_1
Xnetwork.in_period\[141\]\[3\]$_DFFE_PP_ clknet_leaf_248_clk
+ net435 _03134_ VSS VSS VDD VDD network.in_period\[141\]\[3\]
+ sky130_fd_sc_hd__edfxtp_1
Xnetwork.in_period\[142\]\[0\]$_DFFE_PP_ clknet_leaf_218_clk
+ net456 _03135_ VSS VSS VDD VDD network.in_period\[142\]\[0\]
+ sky130_fd_sc_hd__edfxtp_1
Xnetwork.in_period\[142\]\[1\]$_DFFE_PP_ clknet_leaf_218_clk
+ net448 _03135_ VSS VSS VDD VDD network.in_period\[142\]\[1\]
+ sky130_fd_sc_hd__edfxtp_1
Xnetwork.in_period\[142\]\[2\]$_DFFE_PP_ clknet_leaf_218_clk
+ net440 _03135_ VSS VSS VDD VDD network.in_period\[142\]\[2\]
+ sky130_fd_sc_hd__edfxtp_1
Xnetwork.in_period\[142\]\[3\]$_DFFE_PP_ clknet_leaf_218_clk
+ net437 _03135_ VSS VSS VDD VDD network.in_period\[142\]\[3\]
+ sky130_fd_sc_hd__edfxtp_1
Xnetwork.in_period\[143\]\[0\]$_DFFE_PP_ clknet_leaf_228_clk
+ net455 _03136_ VSS VSS VDD VDD network.in_period\[143\]\[0\]
+ sky130_fd_sc_hd__edfxtp_1
Xnetwork.in_period\[143\]\[1\]$_DFFE_PP_ clknet_leaf_228_clk
+ net448 _03136_ VSS VSS VDD VDD network.in_period\[143\]\[1\]
+ sky130_fd_sc_hd__edfxtp_1
Xnetwork.in_period\[143\]\[2\]$_DFFE_PP_ clknet_leaf_219_clk
+ net441 _03136_ VSS VSS VDD VDD network.in_period\[143\]\[2\]
+ sky130_fd_sc_hd__edfxtp_1
Xnetwork.in_period\[143\]\[3\]$_DFFE_PP_ clknet_leaf_228_clk
+ net435 _03136_ VSS VSS VDD VDD network.in_period\[143\]\[3\]
+ sky130_fd_sc_hd__edfxtp_1
Xnetwork.in_period\[144\]\[0\]$_DFFE_PP_ clknet_leaf_232_clk
+ net457 _03137_ VSS VSS VDD VDD network.in_period\[144\]\[0\]
+ sky130_fd_sc_hd__edfxtp_1
Xnetwork.in_period\[144\]\[1\]$_DFFE_PP_ clknet_leaf_232_clk
+ net447 _03137_ VSS VSS VDD VDD network.in_period\[144\]\[1\]
+ sky130_fd_sc_hd__edfxtp_1
Xnetwork.in_period\[144\]\[2\]$_DFFE_PP_ clknet_leaf_232_clk
+ net442 _03137_ VSS VSS VDD VDD network.in_period\[144\]\[2\]
+ sky130_fd_sc_hd__edfxtp_1
Xnetwork.in_period\[144\]\[3\]$_DFFE_PP_ clknet_leaf_232_clk
+ net435 _03137_ VSS VSS VDD VDD network.in_period\[144\]\[3\]
+ sky130_fd_sc_hd__edfxtp_1
Xnetwork.in_period\[145\]\[0\]$_DFFE_PP_ clknet_leaf_155_clk
+ net457 _03138_ VSS VSS VDD VDD network.in_period\[145\]\[0\]
+ sky130_fd_sc_hd__edfxtp_1
Xnetwork.in_period\[145\]\[1\]$_DFFE_PP_ clknet_leaf_100_clk
+ net447 _03138_ VSS VSS VDD VDD network.in_period\[145\]\[1\]
+ sky130_fd_sc_hd__edfxtp_1
Xnetwork.in_period\[145\]\[2\]$_DFFE_PP_ clknet_leaf_155_clk
+ net442 _03138_ VSS VSS VDD VDD network.in_period\[145\]\[2\]
+ sky130_fd_sc_hd__edfxtp_1
Xnetwork.in_period\[145\]\[3\]$_DFFE_PP_ clknet_leaf_155_clk
+ net436 _03138_ VSS VSS VDD VDD network.in_period\[145\]\[3\]
+ sky130_fd_sc_hd__edfxtp_1
Xnetwork.in_period\[146\]\[0\]$_DFFE_PP_ clknet_leaf_159_clk
+ net455 _03139_ VSS VSS VDD VDD network.in_period\[146\]\[0\]
+ sky130_fd_sc_hd__edfxtp_1
Xnetwork.in_period\[146\]\[1\]$_DFFE_PP_ clknet_leaf_159_clk
+ net447 _03139_ VSS VSS VDD VDD network.in_period\[146\]\[1\]
+ sky130_fd_sc_hd__edfxtp_1
Xnetwork.in_period\[146\]\[2\]$_DFFE_PP_ clknet_leaf_159_clk
+ net441 _03139_ VSS VSS VDD VDD network.in_period\[146\]\[2\]
+ sky130_fd_sc_hd__edfxtp_1
Xnetwork.in_period\[146\]\[3\]$_DFFE_PP_ clknet_leaf_159_clk
+ net435 _03139_ VSS VSS VDD VDD network.in_period\[146\]\[3\]
+ sky130_fd_sc_hd__edfxtp_1
Xnetwork.in_period\[147\]\[0\]$_DFFE_PP_ clknet_leaf_160_clk
+ net455 _03140_ VSS VSS VDD VDD network.in_period\[147\]\[0\]
+ sky130_fd_sc_hd__edfxtp_1
Xnetwork.in_period\[147\]\[1\]$_DFFE_PP_ clknet_leaf_150_clk
+ net447 _03140_ VSS VSS VDD VDD network.in_period\[147\]\[1\]
+ sky130_fd_sc_hd__edfxtp_1
Xnetwork.in_period\[147\]\[2\]$_DFFE_PP_ clknet_leaf_150_clk
+ net441 _03140_ VSS VSS VDD VDD network.in_period\[147\]\[2\]
+ sky130_fd_sc_hd__edfxtp_1
Xnetwork.in_period\[147\]\[3\]$_DFFE_PP_ clknet_leaf_150_clk
+ net435 _03140_ VSS VSS VDD VDD network.in_period\[147\]\[3\]
+ sky130_fd_sc_hd__edfxtp_1
Xnetwork.in_period\[148\]\[0\]$_DFFE_PP_ clknet_leaf_151_clk
+ net455 _03141_ VSS VSS VDD VDD network.in_period\[148\]\[0\]
+ sky130_fd_sc_hd__edfxtp_1
Xnetwork.in_period\[148\]\[1\]$_DFFE_PP_ clknet_leaf_151_clk
+ net447 _03141_ VSS VSS VDD VDD network.in_period\[148\]\[1\]
+ sky130_fd_sc_hd__edfxtp_1
Xnetwork.in_period\[148\]\[2\]$_DFFE_PP_ clknet_leaf_151_clk
+ net441 _03141_ VSS VSS VDD VDD network.in_period\[148\]\[2\]
+ sky130_fd_sc_hd__edfxtp_1
Xnetwork.in_period\[148\]\[3\]$_DFFE_PP_ clknet_leaf_151_clk
+ net435 _03141_ VSS VSS VDD VDD network.in_period\[148\]\[3\]
+ sky130_fd_sc_hd__edfxtp_1
Xnetwork.in_period\[149\]\[0\]$_DFFE_PP_ clknet_leaf_154_clk
+ net457 _03142_ VSS VSS VDD VDD network.in_period\[149\]\[0\]
+ sky130_fd_sc_hd__edfxtp_1
Xnetwork.in_period\[149\]\[1\]$_DFFE_PP_ clknet_leaf_154_clk
+ net447 _03142_ VSS VSS VDD VDD network.in_period\[149\]\[1\]
+ sky130_fd_sc_hd__edfxtp_1
Xnetwork.in_period\[149\]\[2\]$_DFFE_PP_ clknet_leaf_154_clk
+ net442 _03142_ VSS VSS VDD VDD network.in_period\[149\]\[2\]
+ sky130_fd_sc_hd__edfxtp_1
Xnetwork.in_period\[149\]\[3\]$_DFFE_PP_ clknet_leaf_154_clk
+ net436 _03142_ VSS VSS VDD VDD network.in_period\[149\]\[3\]
+ sky130_fd_sc_hd__edfxtp_1
Xnetwork.in_period\[14\]\[0\]$_DFFE_PP_ clknet_leaf_52_clk
+ net452 _03143_ VSS VSS VDD VDD network.in_period\[14\]\[0\]
+ sky130_fd_sc_hd__edfxtp_1
Xnetwork.in_period\[14\]\[1\]$_DFFE_PP_ clknet_leaf_52_clk
+ net445 _03143_ VSS VSS VDD VDD network.in_period\[14\]\[1\]
+ sky130_fd_sc_hd__edfxtp_1
Xnetwork.in_period\[14\]\[2\]$_DFFE_PP_ clknet_leaf_53_clk
+ net439 _03143_ VSS VSS VDD VDD network.in_period\[14\]\[2\]
+ sky130_fd_sc_hd__edfxtp_1
Xnetwork.in_period\[14\]\[3\]$_DFFE_PP_ clknet_leaf_52_clk
+ net433 _03143_ VSS VSS VDD VDD network.in_period\[14\]\[3\]
+ sky130_fd_sc_hd__edfxtp_1
Xnetwork.in_period\[150\]\[0\]$_DFFE_PP_ clknet_leaf_160_clk
+ net455 _03144_ VSS VSS VDD VDD network.in_period\[150\]\[0\]
+ sky130_fd_sc_hd__edfxtp_1
Xnetwork.in_period\[150\]\[1\]$_DFFE_PP_ clknet_leaf_161_clk
+ net448 _03144_ VSS VSS VDD VDD network.in_period\[150\]\[1\]
+ sky130_fd_sc_hd__edfxtp_1
Xnetwork.in_period\[150\]\[2\]$_DFFE_PP_ clknet_leaf_161_clk
+ net441 _03144_ VSS VSS VDD VDD network.in_period\[150\]\[2\]
+ sky130_fd_sc_hd__edfxtp_1
Xnetwork.in_period\[150\]\[3\]$_DFFE_PP_ clknet_leaf_160_clk
+ net435 _03144_ VSS VSS VDD VDD network.in_period\[150\]\[3\]
+ sky130_fd_sc_hd__edfxtp_1
Xnetwork.in_period\[151\]\[0\]$_DFFE_PP_ clknet_leaf_156_clk
+ net457 _03145_ VSS VSS VDD VDD network.in_period\[151\]\[0\]
+ sky130_fd_sc_hd__edfxtp_1
Xnetwork.in_period\[151\]\[1\]$_DFFE_PP_ clknet_leaf_156_clk
+ net447 _03145_ VSS VSS VDD VDD network.in_period\[151\]\[1\]
+ sky130_fd_sc_hd__edfxtp_1
Xnetwork.in_period\[151\]\[2\]$_DFFE_PP_ clknet_leaf_155_clk
+ net442 _03145_ VSS VSS VDD VDD network.in_period\[151\]\[2\]
+ sky130_fd_sc_hd__edfxtp_1
Xnetwork.in_period\[151\]\[3\]$_DFFE_PP_ clknet_leaf_155_clk
+ net436 _03145_ VSS VSS VDD VDD network.in_period\[151\]\[3\]
+ sky130_fd_sc_hd__edfxtp_1
Xnetwork.in_period\[152\]\[0\]$_DFFE_PP_ clknet_leaf_158_clk
+ net455 _03146_ VSS VSS VDD VDD network.in_period\[152\]\[0\]
+ sky130_fd_sc_hd__edfxtp_1
Xnetwork.in_period\[152\]\[1\]$_DFFE_PP_ clknet_leaf_158_clk
+ net447 _03146_ VSS VSS VDD VDD network.in_period\[152\]\[1\]
+ sky130_fd_sc_hd__edfxtp_1
Xnetwork.in_period\[152\]\[2\]$_DFFE_PP_ clknet_leaf_158_clk
+ net441 _03146_ VSS VSS VDD VDD network.in_period\[152\]\[2\]
+ sky130_fd_sc_hd__edfxtp_1
Xnetwork.in_period\[152\]\[3\]$_DFFE_PP_ clknet_leaf_158_clk
+ net435 _03146_ VSS VSS VDD VDD network.in_period\[152\]\[3\]
+ sky130_fd_sc_hd__edfxtp_1
Xnetwork.in_period\[153\]\[0\]$_DFFE_PP_ clknet_leaf_162_clk
+ net455 _03147_ VSS VSS VDD VDD network.in_period\[153\]\[0\]
+ sky130_fd_sc_hd__edfxtp_1
Xnetwork.in_period\[153\]\[1\]$_DFFE_PP_ clknet_leaf_162_clk
+ net448 _03147_ VSS VSS VDD VDD network.in_period\[153\]\[1\]
+ sky130_fd_sc_hd__edfxtp_1
Xnetwork.in_period\[153\]\[2\]$_DFFE_PP_ clknet_leaf_162_clk
+ net441 _03147_ VSS VSS VDD VDD network.in_period\[153\]\[2\]
+ sky130_fd_sc_hd__edfxtp_1
Xnetwork.in_period\[153\]\[3\]$_DFFE_PP_ clknet_leaf_162_clk
+ net435 _03147_ VSS VSS VDD VDD network.in_period\[153\]\[3\]
+ sky130_fd_sc_hd__edfxtp_1
Xnetwork.in_period\[154\]\[0\]$_DFFE_PP_ clknet_leaf_231_clk
+ net457 _03148_ VSS VSS VDD VDD network.in_period\[154\]\[0\]
+ sky130_fd_sc_hd__edfxtp_1
Xnetwork.in_period\[154\]\[1\]$_DFFE_PP_ clknet_leaf_231_clk
+ net447 _03148_ VSS VSS VDD VDD network.in_period\[154\]\[1\]
+ sky130_fd_sc_hd__edfxtp_1
Xnetwork.in_period\[154\]\[2\]$_DFFE_PP_ clknet_leaf_231_clk
+ net442 _03148_ VSS VSS VDD VDD network.in_period\[154\]\[2\]
+ sky130_fd_sc_hd__edfxtp_1
Xnetwork.in_period\[154\]\[3\]$_DFFE_PP_ clknet_leaf_231_clk
+ net435 _03148_ VSS VSS VDD VDD network.in_period\[154\]\[3\]
+ sky130_fd_sc_hd__edfxtp_1
Xnetwork.in_period\[155\]\[0\]$_DFFE_PP_ clknet_leaf_156_clk
+ net457 _03149_ VSS VSS VDD VDD network.in_period\[155\]\[0\]
+ sky130_fd_sc_hd__edfxtp_1
Xnetwork.in_period\[155\]\[1\]$_DFFE_PP_ clknet_leaf_156_clk
+ net447 _03149_ VSS VSS VDD VDD network.in_period\[155\]\[1\]
+ sky130_fd_sc_hd__edfxtp_1
Xnetwork.in_period\[155\]\[2\]$_DFFE_PP_ clknet_leaf_233_clk
+ net442 _03149_ VSS VSS VDD VDD network.in_period\[155\]\[2\]
+ sky130_fd_sc_hd__edfxtp_1
Xnetwork.in_period\[155\]\[3\]$_DFFE_PP_ clknet_leaf_156_clk
+ net436 _03149_ VSS VSS VDD VDD network.in_period\[155\]\[3\]
+ sky130_fd_sc_hd__edfxtp_1
Xnetwork.in_period\[156\]\[0\]$_DFFE_PP_ clknet_leaf_230_clk
+ net455 _03150_ VSS VSS VDD VDD network.in_period\[156\]\[0\]
+ sky130_fd_sc_hd__edfxtp_1
Xnetwork.in_period\[156\]\[1\]$_DFFE_PP_ clknet_leaf_230_clk
+ net448 _03150_ VSS VSS VDD VDD network.in_period\[156\]\[1\]
+ sky130_fd_sc_hd__edfxtp_1
Xnetwork.in_period\[156\]\[2\]$_DFFE_PP_ clknet_leaf_230_clk
+ net441 _03150_ VSS VSS VDD VDD network.in_period\[156\]\[2\]
+ sky130_fd_sc_hd__edfxtp_1
Xnetwork.in_period\[156\]\[3\]$_DFFE_PP_ clknet_leaf_230_clk
+ net435 _03150_ VSS VSS VDD VDD network.in_period\[156\]\[3\]
+ sky130_fd_sc_hd__edfxtp_1
Xnetwork.in_period\[157\]\[0\]$_DFFE_PP_ clknet_leaf_163_clk
+ net455 _03151_ VSS VSS VDD VDD network.in_period\[157\]\[0\]
+ sky130_fd_sc_hd__edfxtp_1
Xnetwork.in_period\[157\]\[1\]$_DFFE_PP_ clknet_leaf_163_clk
+ net448 _03151_ VSS VSS VDD VDD network.in_period\[157\]\[1\]
+ sky130_fd_sc_hd__edfxtp_1
Xnetwork.in_period\[157\]\[2\]$_DFFE_PP_ clknet_leaf_163_clk
+ net441 _03151_ VSS VSS VDD VDD network.in_period\[157\]\[2\]
+ sky130_fd_sc_hd__edfxtp_1
Xnetwork.in_period\[157\]\[3\]$_DFFE_PP_ clknet_leaf_163_clk
+ net435 _03151_ VSS VSS VDD VDD network.in_period\[157\]\[3\]
+ sky130_fd_sc_hd__edfxtp_1
Xnetwork.in_period\[158\]\[0\]$_DFFE_PP_ clknet_leaf_226_clk
+ net455 _03152_ VSS VSS VDD VDD network.in_period\[158\]\[0\]
+ sky130_fd_sc_hd__edfxtp_1
Xnetwork.in_period\[158\]\[1\]$_DFFE_PP_ clknet_leaf_226_clk
+ net448 _03152_ VSS VSS VDD VDD network.in_period\[158\]\[1\]
+ sky130_fd_sc_hd__edfxtp_1
Xnetwork.in_period\[158\]\[2\]$_DFFE_PP_ clknet_leaf_226_clk
+ net441 _03152_ VSS VSS VDD VDD network.in_period\[158\]\[2\]
+ sky130_fd_sc_hd__edfxtp_1
Xnetwork.in_period\[158\]\[3\]$_DFFE_PP_ clknet_leaf_226_clk
+ net435 _03152_ VSS VSS VDD VDD network.in_period\[158\]\[3\]
+ sky130_fd_sc_hd__edfxtp_1
Xnetwork.in_period\[159\]\[0\]$_DFFE_PP_ clknet_leaf_161_clk
+ net455 _03153_ VSS VSS VDD VDD network.in_period\[159\]\[0\]
+ sky130_fd_sc_hd__edfxtp_1
Xnetwork.in_period\[159\]\[1\]$_DFFE_PP_ clknet_leaf_161_clk
+ net448 _03153_ VSS VSS VDD VDD network.in_period\[159\]\[1\]
+ sky130_fd_sc_hd__edfxtp_1
Xnetwork.in_period\[159\]\[2\]$_DFFE_PP_ clknet_leaf_161_clk
+ net441 _03153_ VSS VSS VDD VDD network.in_period\[159\]\[2\]
+ sky130_fd_sc_hd__edfxtp_1
Xnetwork.in_period\[159\]\[3\]$_DFFE_PP_ clknet_leaf_161_clk
+ net435 _03153_ VSS VSS VDD VDD network.in_period\[159\]\[3\]
+ sky130_fd_sc_hd__edfxtp_1
Xnetwork.in_period\[15\]\[0\]$_DFFE_PP_ clknet_leaf_19_clk
+ net454 _03154_ VSS VSS VDD VDD network.in_period\[15\]\[0\]
+ sky130_fd_sc_hd__edfxtp_1
Xnetwork.in_period\[15\]\[1\]$_DFFE_PP_ clknet_leaf_19_clk
+ net446 _03154_ VSS VSS VDD VDD network.in_period\[15\]\[1\]
+ sky130_fd_sc_hd__edfxtp_1
Xnetwork.in_period\[15\]\[2\]$_DFFE_PP_ clknet_leaf_20_clk
+ net438 _03154_ VSS VSS VDD VDD network.in_period\[15\]\[2\]
+ sky130_fd_sc_hd__edfxtp_1
Xnetwork.in_period\[15\]\[3\]$_DFFE_PP_ clknet_leaf_19_clk
+ net431 _03154_ VSS VSS VDD VDD network.in_period\[15\]\[3\]
+ sky130_fd_sc_hd__edfxtp_1
Xnetwork.in_period\[160\]\[0\]$_DFFE_PP_ clknet_leaf_139_clk
+ net455 _03155_ VSS VSS VDD VDD network.in_period\[160\]\[0\]
+ sky130_fd_sc_hd__edfxtp_1
Xnetwork.in_period\[160\]\[1\]$_DFFE_PP_ clknet_leaf_139_clk
+ net447 _03155_ VSS VSS VDD VDD network.in_period\[160\]\[1\]
+ sky130_fd_sc_hd__edfxtp_1
Xnetwork.in_period\[160\]\[2\]$_DFFE_PP_ clknet_leaf_139_clk
+ net441 _03155_ VSS VSS VDD VDD network.in_period\[160\]\[2\]
+ sky130_fd_sc_hd__edfxtp_1
Xnetwork.in_period\[160\]\[3\]$_DFFE_PP_ clknet_leaf_139_clk
+ net435 _03155_ VSS VSS VDD VDD network.in_period\[160\]\[3\]
+ sky130_fd_sc_hd__edfxtp_1
Xnetwork.in_period\[161\]\[0\]$_DFFE_PP_ clknet_leaf_140_clk
+ net455 _03156_ VSS VSS VDD VDD network.in_period\[161\]\[0\]
+ sky130_fd_sc_hd__edfxtp_1
Xnetwork.in_period\[161\]\[1\]$_DFFE_PP_ clknet_leaf_140_clk
+ net447 _03156_ VSS VSS VDD VDD network.in_period\[161\]\[1\]
+ sky130_fd_sc_hd__edfxtp_1
Xnetwork.in_period\[161\]\[2\]$_DFFE_PP_ clknet_leaf_139_clk
+ net441 _03156_ VSS VSS VDD VDD network.in_period\[161\]\[2\]
+ sky130_fd_sc_hd__edfxtp_1
Xnetwork.in_period\[161\]\[3\]$_DFFE_PP_ clknet_leaf_150_clk
+ net435 _03156_ VSS VSS VDD VDD network.in_period\[161\]\[3\]
+ sky130_fd_sc_hd__edfxtp_1
Xnetwork.in_period\[162\]\[0\]$_DFFE_PP_ clknet_leaf_171_clk
+ net455 _03157_ VSS VSS VDD VDD network.in_period\[162\]\[0\]
+ sky130_fd_sc_hd__edfxtp_1
Xnetwork.in_period\[162\]\[1\]$_DFFE_PP_ clknet_leaf_171_clk
+ net447 _03157_ VSS VSS VDD VDD network.in_period\[162\]\[1\]
+ sky130_fd_sc_hd__edfxtp_1
Xnetwork.in_period\[162\]\[2\]$_DFFE_PP_ clknet_leaf_171_clk
+ net441 _03157_ VSS VSS VDD VDD network.in_period\[162\]\[2\]
+ sky130_fd_sc_hd__edfxtp_1
Xnetwork.in_period\[162\]\[3\]$_DFFE_PP_ clknet_leaf_171_clk
+ net435 _03157_ VSS VSS VDD VDD network.in_period\[162\]\[3\]
+ sky130_fd_sc_hd__edfxtp_1
Xnetwork.in_period\[163\]\[0\]$_DFFE_PP_ clknet_leaf_170_clk
+ net455 _03158_ VSS VSS VDD VDD network.in_period\[163\]\[0\]
+ sky130_fd_sc_hd__edfxtp_1
Xnetwork.in_period\[163\]\[1\]$_DFFE_PP_ clknet_leaf_170_clk
+ net447 _03158_ VSS VSS VDD VDD network.in_period\[163\]\[1\]
+ sky130_fd_sc_hd__edfxtp_1
Xnetwork.in_period\[163\]\[2\]$_DFFE_PP_ clknet_leaf_170_clk
+ net441 _03158_ VSS VSS VDD VDD network.in_period\[163\]\[2\]
+ sky130_fd_sc_hd__edfxtp_1
Xnetwork.in_period\[163\]\[3\]$_DFFE_PP_ clknet_leaf_170_clk
+ net435 _03158_ VSS VSS VDD VDD network.in_period\[163\]\[3\]
+ sky130_fd_sc_hd__edfxtp_1
Xnetwork.in_period\[164\]\[0\]$_DFFE_PP_ clknet_leaf_168_clk
+ net456 _03159_ VSS VSS VDD VDD network.in_period\[164\]\[0\]
+ sky130_fd_sc_hd__edfxtp_1
Xnetwork.in_period\[164\]\[1\]$_DFFE_PP_ clknet_leaf_168_clk
+ net448 _03159_ VSS VSS VDD VDD network.in_period\[164\]\[1\]
+ sky130_fd_sc_hd__edfxtp_1
Xnetwork.in_period\[164\]\[2\]$_DFFE_PP_ clknet_leaf_182_clk
+ net440 _03159_ VSS VSS VDD VDD network.in_period\[164\]\[2\]
+ sky130_fd_sc_hd__edfxtp_1
Xnetwork.in_period\[164\]\[3\]$_DFFE_PP_ clknet_leaf_182_clk
+ net435 _03159_ VSS VSS VDD VDD network.in_period\[164\]\[3\]
+ sky130_fd_sc_hd__edfxtp_1
Xnetwork.in_period\[165\]\[0\]$_DFFE_PP_ clknet_leaf_171_clk
+ net455 _03160_ VSS VSS VDD VDD network.in_period\[165\]\[0\]
+ sky130_fd_sc_hd__edfxtp_1
Xnetwork.in_period\[165\]\[1\]$_DFFE_PP_ clknet_leaf_171_clk
+ net448 _03160_ VSS VSS VDD VDD network.in_period\[165\]\[1\]
+ sky130_fd_sc_hd__edfxtp_1
Xnetwork.in_period\[165\]\[2\]$_DFFE_PP_ clknet_leaf_171_clk
+ net441 _03160_ VSS VSS VDD VDD network.in_period\[165\]\[2\]
+ sky130_fd_sc_hd__edfxtp_1
Xnetwork.in_period\[165\]\[3\]$_DFFE_PP_ clknet_leaf_171_clk
+ net435 _03160_ VSS VSS VDD VDD network.in_period\[165\]\[3\]
+ sky130_fd_sc_hd__edfxtp_1
Xnetwork.in_period\[166\]\[0\]$_DFFE_PP_ clknet_leaf_172_clk
+ net455 _03161_ VSS VSS VDD VDD network.in_period\[166\]\[0\]
+ sky130_fd_sc_hd__edfxtp_1
Xnetwork.in_period\[166\]\[1\]$_DFFE_PP_ clknet_leaf_172_clk
+ net448 _03161_ VSS VSS VDD VDD network.in_period\[166\]\[1\]
+ sky130_fd_sc_hd__edfxtp_1
Xnetwork.in_period\[166\]\[2\]$_DFFE_PP_ clknet_leaf_172_clk
+ net441 _03161_ VSS VSS VDD VDD network.in_period\[166\]\[2\]
+ sky130_fd_sc_hd__edfxtp_1
Xnetwork.in_period\[166\]\[3\]$_DFFE_PP_ clknet_leaf_172_clk
+ net435 _03161_ VSS VSS VDD VDD network.in_period\[166\]\[3\]
+ sky130_fd_sc_hd__edfxtp_1
Xnetwork.in_period\[167\]\[0\]$_DFFE_PP_ clknet_leaf_138_clk
+ net455 _03162_ VSS VSS VDD VDD network.in_period\[167\]\[0\]
+ sky130_fd_sc_hd__edfxtp_1
Xnetwork.in_period\[167\]\[1\]$_DFFE_PP_ clknet_leaf_139_clk
+ net447 _03162_ VSS VSS VDD VDD network.in_period\[167\]\[1\]
+ sky130_fd_sc_hd__edfxtp_1
Xnetwork.in_period\[167\]\[2\]$_DFFE_PP_ clknet_leaf_138_clk
+ net441 _03162_ VSS VSS VDD VDD network.in_period\[167\]\[2\]
+ sky130_fd_sc_hd__edfxtp_1
Xnetwork.in_period\[167\]\[3\]$_DFFE_PP_ clknet_leaf_138_clk
+ net435 _03162_ VSS VSS VDD VDD network.in_period\[167\]\[3\]
+ sky130_fd_sc_hd__edfxtp_1
Xnetwork.in_period\[168\]\[0\]$_DFFE_PP_ clknet_leaf_167_clk
+ net456 _03163_ VSS VSS VDD VDD network.in_period\[168\]\[0\]
+ sky130_fd_sc_hd__edfxtp_1
Xnetwork.in_period\[168\]\[1\]$_DFFE_PP_ clknet_leaf_167_clk
+ net448 _03163_ VSS VSS VDD VDD network.in_period\[168\]\[1\]
+ sky130_fd_sc_hd__edfxtp_1
Xnetwork.in_period\[168\]\[2\]$_DFFE_PP_ clknet_leaf_168_clk
+ net440 _03163_ VSS VSS VDD VDD network.in_period\[168\]\[2\]
+ sky130_fd_sc_hd__edfxtp_1
Xnetwork.in_period\[168\]\[3\]$_DFFE_PP_ clknet_leaf_168_clk
+ net435 _03163_ VSS VSS VDD VDD network.in_period\[168\]\[3\]
+ sky130_fd_sc_hd__edfxtp_1
Xnetwork.in_period\[169\]\[0\]$_DFFE_PP_ clknet_leaf_169_clk
+ net455 _03164_ VSS VSS VDD VDD network.in_period\[169\]\[0\]
+ sky130_fd_sc_hd__edfxtp_1
Xnetwork.in_period\[169\]\[1\]$_DFFE_PP_ clknet_leaf_169_clk
+ net448 _03164_ VSS VSS VDD VDD network.in_period\[169\]\[1\]
+ sky130_fd_sc_hd__edfxtp_1
Xnetwork.in_period\[169\]\[2\]$_DFFE_PP_ clknet_leaf_169_clk
+ net441 _03164_ VSS VSS VDD VDD network.in_period\[169\]\[2\]
+ sky130_fd_sc_hd__edfxtp_1
Xnetwork.in_period\[169\]\[3\]$_DFFE_PP_ clknet_leaf_169_clk
+ net435 _03164_ VSS VSS VDD VDD network.in_period\[169\]\[3\]
+ sky130_fd_sc_hd__edfxtp_1
Xnetwork.in_period\[16\]\[0\]$_DFFE_PP_ clknet_leaf_26_clk
+ net454 _03165_ VSS VSS VDD VDD network.in_period\[16\]\[0\]
+ sky130_fd_sc_hd__edfxtp_1
Xnetwork.in_period\[16\]\[1\]$_DFFE_PP_ clknet_leaf_26_clk
+ net451 _03165_ VSS VSS VDD VDD network.in_period\[16\]\[1\]
+ sky130_fd_sc_hd__edfxtp_1
Xnetwork.in_period\[16\]\[2\]$_DFFE_PP_ clknet_leaf_26_clk
+ net444 _03165_ VSS VSS VDD VDD network.in_period\[16\]\[2\]
+ sky130_fd_sc_hd__edfxtp_1
Xnetwork.in_period\[16\]\[3\]$_DFFE_PP_ clknet_leaf_26_clk
+ net433 _03165_ VSS VSS VDD VDD network.in_period\[16\]\[3\]
+ sky130_fd_sc_hd__edfxtp_1
Xnetwork.in_period\[170\]\[0\]$_DFFE_PP_ clknet_leaf_164_clk
+ net455 _03166_ VSS VSS VDD VDD network.in_period\[170\]\[0\]
+ sky130_fd_sc_hd__edfxtp_1
Xnetwork.in_period\[170\]\[1\]$_DFFE_PP_ clknet_leaf_164_clk
+ net448 _03166_ VSS VSS VDD VDD network.in_period\[170\]\[1\]
+ sky130_fd_sc_hd__edfxtp_1
Xnetwork.in_period\[170\]\[2\]$_DFFE_PP_ clknet_leaf_164_clk
+ net441 _03166_ VSS VSS VDD VDD network.in_period\[170\]\[2\]
+ sky130_fd_sc_hd__edfxtp_1
Xnetwork.in_period\[170\]\[3\]$_DFFE_PP_ clknet_leaf_164_clk
+ net435 _03166_ VSS VSS VDD VDD network.in_period\[170\]\[3\]
+ sky130_fd_sc_hd__edfxtp_1
Xnetwork.in_period\[171\]\[0\]$_DFFE_PP_ clknet_leaf_165_clk
+ net456 _03167_ VSS VSS VDD VDD network.in_period\[171\]\[0\]
+ sky130_fd_sc_hd__edfxtp_1
Xnetwork.in_period\[171\]\[1\]$_DFFE_PP_ clknet_leaf_165_clk
+ net448 _03167_ VSS VSS VDD VDD network.in_period\[171\]\[1\]
+ sky130_fd_sc_hd__edfxtp_1
Xnetwork.in_period\[171\]\[2\]$_DFFE_PP_ clknet_leaf_165_clk
+ net440 _03167_ VSS VSS VDD VDD network.in_period\[171\]\[2\]
+ sky130_fd_sc_hd__edfxtp_1
Xnetwork.in_period\[171\]\[3\]$_DFFE_PP_ clknet_leaf_165_clk
+ net435 _03167_ VSS VSS VDD VDD network.in_period\[171\]\[3\]
+ sky130_fd_sc_hd__edfxtp_1
Xnetwork.in_period\[172\]\[0\]$_DFFE_PP_ clknet_leaf_167_clk
+ net456 _03168_ VSS VSS VDD VDD network.in_period\[172\]\[0\]
+ sky130_fd_sc_hd__edfxtp_1
Xnetwork.in_period\[172\]\[1\]$_DFFE_PP_ clknet_leaf_166_clk
+ net448 _03168_ VSS VSS VDD VDD network.in_period\[172\]\[1\]
+ sky130_fd_sc_hd__edfxtp_1
Xnetwork.in_period\[172\]\[2\]$_DFFE_PP_ clknet_leaf_166_clk
+ net440 _03168_ VSS VSS VDD VDD network.in_period\[172\]\[2\]
+ sky130_fd_sc_hd__edfxtp_1
Xnetwork.in_period\[172\]\[3\]$_DFFE_PP_ clknet_leaf_166_clk
+ net435 _03168_ VSS VSS VDD VDD network.in_period\[172\]\[3\]
+ sky130_fd_sc_hd__edfxtp_1
Xnetwork.in_period\[173\]\[0\]$_DFFE_PP_ clknet_leaf_184_clk
+ net456 _03169_ VSS VSS VDD VDD network.in_period\[173\]\[0\]
+ sky130_fd_sc_hd__edfxtp_1
Xnetwork.in_period\[173\]\[1\]$_DFFE_PP_ clknet_leaf_184_clk
+ net448 _03169_ VSS VSS VDD VDD network.in_period\[173\]\[1\]
+ sky130_fd_sc_hd__edfxtp_1
Xnetwork.in_period\[173\]\[2\]$_DFFE_PP_ clknet_leaf_184_clk
+ net440 _03169_ VSS VSS VDD VDD network.in_period\[173\]\[2\]
+ sky130_fd_sc_hd__edfxtp_1
Xnetwork.in_period\[173\]\[3\]$_DFFE_PP_ clknet_leaf_184_clk
+ net435 _03169_ VSS VSS VDD VDD network.in_period\[173\]\[3\]
+ sky130_fd_sc_hd__edfxtp_1
Xnetwork.in_period\[174\]\[0\]$_DFFE_PP_ clknet_leaf_183_clk
+ net456 _03170_ VSS VSS VDD VDD network.in_period\[174\]\[0\]
+ sky130_fd_sc_hd__edfxtp_1
Xnetwork.in_period\[174\]\[1\]$_DFFE_PP_ clknet_leaf_183_clk
+ net448 _03170_ VSS VSS VDD VDD network.in_period\[174\]\[1\]
+ sky130_fd_sc_hd__edfxtp_1
Xnetwork.in_period\[174\]\[2\]$_DFFE_PP_ clknet_leaf_183_clk
+ net440 _03170_ VSS VSS VDD VDD network.in_period\[174\]\[2\]
+ sky130_fd_sc_hd__edfxtp_1
Xnetwork.in_period\[174\]\[3\]$_DFFE_PP_ clknet_leaf_183_clk
+ net435 _03170_ VSS VSS VDD VDD network.in_period\[174\]\[3\]
+ sky130_fd_sc_hd__edfxtp_1
Xnetwork.in_period\[175\]\[0\]$_DFFE_PP_ clknet_leaf_182_clk
+ net456 _03171_ VSS VSS VDD VDD network.in_period\[175\]\[0\]
+ sky130_fd_sc_hd__edfxtp_1
Xnetwork.in_period\[175\]\[1\]$_DFFE_PP_ clknet_leaf_182_clk
+ net448 _03171_ VSS VSS VDD VDD network.in_period\[175\]\[1\]
+ sky130_fd_sc_hd__edfxtp_1
Xnetwork.in_period\[175\]\[2\]$_DFFE_PP_ clknet_leaf_182_clk
+ net440 _03171_ VSS VSS VDD VDD network.in_period\[175\]\[2\]
+ sky130_fd_sc_hd__edfxtp_1
Xnetwork.in_period\[175\]\[3\]$_DFFE_PP_ clknet_leaf_182_clk
+ net435 _03171_ VSS VSS VDD VDD network.in_period\[175\]\[3\]
+ sky130_fd_sc_hd__edfxtp_1
Xnetwork.in_period\[176\]\[0\]$_DFFE_PP_ clknet_leaf_186_clk
+ net456 _03172_ VSS VSS VDD VDD network.in_period\[176\]\[0\]
+ sky130_fd_sc_hd__edfxtp_1
Xnetwork.in_period\[176\]\[1\]$_DFFE_PP_ clknet_leaf_186_clk
+ net448 _03172_ VSS VSS VDD VDD network.in_period\[176\]\[1\]
+ sky130_fd_sc_hd__edfxtp_1
Xnetwork.in_period\[176\]\[2\]$_DFFE_PP_ clknet_leaf_185_clk
+ net440 _03172_ VSS VSS VDD VDD network.in_period\[176\]\[2\]
+ sky130_fd_sc_hd__edfxtp_1
Xnetwork.in_period\[176\]\[3\]$_DFFE_PP_ clknet_leaf_185_clk
+ net435 _03172_ VSS VSS VDD VDD network.in_period\[176\]\[3\]
+ sky130_fd_sc_hd__edfxtp_1
Xnetwork.in_period\[177\]\[0\]$_DFFE_PP_ clknet_leaf_203_clk
+ net456 _03173_ VSS VSS VDD VDD network.in_period\[177\]\[0\]
+ sky130_fd_sc_hd__edfxtp_1
Xnetwork.in_period\[177\]\[1\]$_DFFE_PP_ clknet_leaf_203_clk
+ net448 _03173_ VSS VSS VDD VDD network.in_period\[177\]\[1\]
+ sky130_fd_sc_hd__edfxtp_1
Xnetwork.in_period\[177\]\[2\]$_DFFE_PP_ clknet_leaf_203_clk
+ net440 _03173_ VSS VSS VDD VDD network.in_period\[177\]\[2\]
+ sky130_fd_sc_hd__edfxtp_1
Xnetwork.in_period\[177\]\[3\]$_DFFE_PP_ clknet_leaf_203_clk
+ net435 _03173_ VSS VSS VDD VDD network.in_period\[177\]\[3\]
+ sky130_fd_sc_hd__edfxtp_1
Xnetwork.in_period\[178\]\[0\]$_DFFE_PP_ clknet_leaf_185_clk
+ net456 _03174_ VSS VSS VDD VDD network.in_period\[178\]\[0\]
+ sky130_fd_sc_hd__edfxtp_1
Xnetwork.in_period\[178\]\[1\]$_DFFE_PP_ clknet_leaf_202_clk
+ net448 _03174_ VSS VSS VDD VDD network.in_period\[178\]\[1\]
+ sky130_fd_sc_hd__edfxtp_1
Xnetwork.in_period\[178\]\[2\]$_DFFE_PP_ clknet_leaf_185_clk
+ net440 _03174_ VSS VSS VDD VDD network.in_period\[178\]\[2\]
+ sky130_fd_sc_hd__edfxtp_1
Xnetwork.in_period\[178\]\[3\]$_DFFE_PP_ clknet_leaf_185_clk
+ net435 _03174_ VSS VSS VDD VDD network.in_period\[178\]\[3\]
+ sky130_fd_sc_hd__edfxtp_1
Xnetwork.in_period\[179\]\[0\]$_DFFE_PP_ clknet_leaf_203_clk
+ net456 _03175_ VSS VSS VDD VDD network.in_period\[179\]\[0\]
+ sky130_fd_sc_hd__edfxtp_1
Xnetwork.in_period\[179\]\[1\]$_DFFE_PP_ clknet_leaf_203_clk
+ net448 _03175_ VSS VSS VDD VDD network.in_period\[179\]\[1\]
+ sky130_fd_sc_hd__edfxtp_1
Xnetwork.in_period\[179\]\[2\]$_DFFE_PP_ clknet_leaf_203_clk
+ net440 _03175_ VSS VSS VDD VDD network.in_period\[179\]\[2\]
+ sky130_fd_sc_hd__edfxtp_1
Xnetwork.in_period\[179\]\[3\]$_DFFE_PP_ clknet_leaf_203_clk
+ net435 _03175_ VSS VSS VDD VDD network.in_period\[179\]\[3\]
+ sky130_fd_sc_hd__edfxtp_1
Xnetwork.in_period\[17\]\[0\]$_DFFE_PP_ clknet_leaf_10_clk
+ net454 _03176_ VSS VSS VDD VDD network.in_period\[17\]\[0\]
+ sky130_fd_sc_hd__edfxtp_1
Xnetwork.in_period\[17\]\[1\]$_DFFE_PP_ clknet_leaf_9_clk
+ net451 _03176_ VSS VSS VDD VDD network.in_period\[17\]\[1\]
+ sky130_fd_sc_hd__edfxtp_1
Xnetwork.in_period\[17\]\[2\]$_DFFE_PP_ clknet_leaf_25_clk
+ net444 _03176_ VSS VSS VDD VDD network.in_period\[17\]\[2\]
+ sky130_fd_sc_hd__edfxtp_1
Xnetwork.in_period\[17\]\[3\]$_DFFE_PP_ clknet_leaf_9_clk
+ net433 _03176_ VSS VSS VDD VDD network.in_period\[17\]\[3\]
+ sky130_fd_sc_hd__edfxtp_1
Xnetwork.in_period\[180\]\[0\]$_DFFE_PP_ clknet_leaf_187_clk
+ net456 _03177_ VSS VSS VDD VDD network.in_period\[180\]\[0\]
+ sky130_fd_sc_hd__edfxtp_1
Xnetwork.in_period\[180\]\[1\]$_DFFE_PP_ clknet_leaf_201_clk
+ net448 _03177_ VSS VSS VDD VDD network.in_period\[180\]\[1\]
+ sky130_fd_sc_hd__edfxtp_1
Xnetwork.in_period\[180\]\[2\]$_DFFE_PP_ clknet_leaf_187_clk
+ net440 _03177_ VSS VSS VDD VDD network.in_period\[180\]\[2\]
+ sky130_fd_sc_hd__edfxtp_1
Xnetwork.in_period\[180\]\[3\]$_DFFE_PP_ clknet_leaf_187_clk
+ net434 _03177_ VSS VSS VDD VDD network.in_period\[180\]\[3\]
+ sky130_fd_sc_hd__edfxtp_1
Xnetwork.in_period\[181\]\[0\]$_DFFE_PP_ clknet_leaf_187_clk
+ net456 _03178_ VSS VSS VDD VDD network.in_period\[181\]\[0\]
+ sky130_fd_sc_hd__edfxtp_1
Xnetwork.in_period\[181\]\[1\]$_DFFE_PP_ clknet_leaf_186_clk
+ net448 _03178_ VSS VSS VDD VDD network.in_period\[181\]\[1\]
+ sky130_fd_sc_hd__edfxtp_1
Xnetwork.in_period\[181\]\[2\]$_DFFE_PP_ clknet_leaf_187_clk
+ net440 _03178_ VSS VSS VDD VDD network.in_period\[181\]\[2\]
+ sky130_fd_sc_hd__edfxtp_1
Xnetwork.in_period\[181\]\[3\]$_DFFE_PP_ clknet_leaf_187_clk
+ net434 _03178_ VSS VSS VDD VDD network.in_period\[181\]\[3\]
+ sky130_fd_sc_hd__edfxtp_1
Xnetwork.in_period\[182\]\[0\]$_DFFE_PP_ clknet_leaf_195_clk
+ net458 _03179_ VSS VSS VDD VDD network.in_period\[182\]\[0\]
+ sky130_fd_sc_hd__edfxtp_1
Xnetwork.in_period\[182\]\[1\]$_DFFE_PP_ clknet_leaf_196_clk
+ net450 _03179_ VSS VSS VDD VDD network.in_period\[182\]\[1\]
+ sky130_fd_sc_hd__edfxtp_1
Xnetwork.in_period\[182\]\[2\]$_DFFE_PP_ clknet_leaf_196_clk
+ net440 _03179_ VSS VSS VDD VDD network.in_period\[182\]\[2\]
+ sky130_fd_sc_hd__edfxtp_1
Xnetwork.in_period\[182\]\[3\]$_DFFE_PP_ clknet_leaf_195_clk
+ net434 _03179_ VSS VSS VDD VDD network.in_period\[182\]\[3\]
+ sky130_fd_sc_hd__edfxtp_1
Xnetwork.in_period\[183\]\[0\]$_DFFE_PP_ clknet_leaf_201_clk
+ net458 _03180_ VSS VSS VDD VDD network.in_period\[183\]\[0\]
+ sky130_fd_sc_hd__edfxtp_1
Xnetwork.in_period\[183\]\[1\]$_DFFE_PP_ clknet_leaf_188_clk
+ net450 _03180_ VSS VSS VDD VDD network.in_period\[183\]\[1\]
+ sky130_fd_sc_hd__edfxtp_1
Xnetwork.in_period\[183\]\[2\]$_DFFE_PP_ clknet_leaf_200_clk
+ net440 _03180_ VSS VSS VDD VDD network.in_period\[183\]\[2\]
+ sky130_fd_sc_hd__edfxtp_1
Xnetwork.in_period\[183\]\[3\]$_DFFE_PP_ clknet_leaf_201_clk
+ net434 _03180_ VSS VSS VDD VDD network.in_period\[183\]\[3\]
+ sky130_fd_sc_hd__edfxtp_1
Xnetwork.in_period\[184\]\[0\]$_DFFE_PP_ clknet_leaf_196_clk
+ net458 _03181_ VSS VSS VDD VDD network.in_period\[184\]\[0\]
+ sky130_fd_sc_hd__edfxtp_1
Xnetwork.in_period\[184\]\[1\]$_DFFE_PP_ clknet_leaf_196_clk
+ net450 _03181_ VSS VSS VDD VDD network.in_period\[184\]\[1\]
+ sky130_fd_sc_hd__edfxtp_1
Xnetwork.in_period\[184\]\[2\]$_DFFE_PP_ clknet_leaf_196_clk
+ net440 _03181_ VSS VSS VDD VDD network.in_period\[184\]\[2\]
+ sky130_fd_sc_hd__edfxtp_1
Xnetwork.in_period\[184\]\[3\]$_DFFE_PP_ clknet_leaf_196_clk
+ net434 _03181_ VSS VSS VDD VDD network.in_period\[184\]\[3\]
+ sky130_fd_sc_hd__edfxtp_1
Xnetwork.in_period\[185\]\[0\]$_DFFE_PP_ clknet_leaf_197_clk
+ net458 _03182_ VSS VSS VDD VDD network.in_period\[185\]\[0\]
+ sky130_fd_sc_hd__edfxtp_1
Xnetwork.in_period\[185\]\[1\]$_DFFE_PP_ clknet_leaf_198_clk
+ net450 _03182_ VSS VSS VDD VDD network.in_period\[185\]\[1\]
+ sky130_fd_sc_hd__edfxtp_1
Xnetwork.in_period\[185\]\[2\]$_DFFE_PP_ clknet_leaf_197_clk
+ net440 _03182_ VSS VSS VDD VDD network.in_period\[185\]\[2\]
+ sky130_fd_sc_hd__edfxtp_1
Xnetwork.in_period\[185\]\[3\]$_DFFE_PP_ clknet_leaf_197_clk
+ net434 _03182_ VSS VSS VDD VDD network.in_period\[185\]\[3\]
+ sky130_fd_sc_hd__edfxtp_1
Xnetwork.in_period\[186\]\[0\]$_DFFE_PP_ clknet_leaf_208_clk
+ net458 _03183_ VSS VSS VDD VDD network.in_period\[186\]\[0\]
+ sky130_fd_sc_hd__edfxtp_1
Xnetwork.in_period\[186\]\[1\]$_DFFE_PP_ clknet_leaf_208_clk
+ net450 _03183_ VSS VSS VDD VDD network.in_period\[186\]\[1\]
+ sky130_fd_sc_hd__edfxtp_1
Xnetwork.in_period\[186\]\[2\]$_DFFE_PP_ clknet_leaf_207_clk
+ net440 _03183_ VSS VSS VDD VDD network.in_period\[186\]\[2\]
+ sky130_fd_sc_hd__edfxtp_1
Xnetwork.in_period\[186\]\[3\]$_DFFE_PP_ clknet_leaf_208_clk
+ net434 _03183_ VSS VSS VDD VDD network.in_period\[186\]\[3\]
+ sky130_fd_sc_hd__edfxtp_1
Xnetwork.in_period\[187\]\[0\]$_DFFE_PP_ clknet_leaf_195_clk
+ net458 _03184_ VSS VSS VDD VDD network.in_period\[187\]\[0\]
+ sky130_fd_sc_hd__edfxtp_1
Xnetwork.in_period\[187\]\[1\]$_DFFE_PP_ clknet_leaf_195_clk
+ net450 _03184_ VSS VSS VDD VDD network.in_period\[187\]\[1\]
+ sky130_fd_sc_hd__edfxtp_1
Xnetwork.in_period\[187\]\[2\]$_DFFE_PP_ clknet_leaf_195_clk
+ net440 _03184_ VSS VSS VDD VDD network.in_period\[187\]\[2\]
+ sky130_fd_sc_hd__edfxtp_1
Xnetwork.in_period\[187\]\[3\]$_DFFE_PP_ clknet_leaf_195_clk
+ net434 _03184_ VSS VSS VDD VDD network.in_period\[187\]\[3\]
+ sky130_fd_sc_hd__edfxtp_1
Xnetwork.in_period\[188\]\[0\]$_DFFE_PP_ clknet_leaf_208_clk
+ net458 _03185_ VSS VSS VDD VDD network.in_period\[188\]\[0\]
+ sky130_fd_sc_hd__edfxtp_1
Xnetwork.in_period\[188\]\[1\]$_DFFE_PP_ clknet_leaf_209_clk
+ net450 _03185_ VSS VSS VDD VDD network.in_period\[188\]\[1\]
+ sky130_fd_sc_hd__edfxtp_1
Xnetwork.in_period\[188\]\[2\]$_DFFE_PP_ clknet_leaf_208_clk
+ net440 _03185_ VSS VSS VDD VDD network.in_period\[188\]\[2\]
+ sky130_fd_sc_hd__edfxtp_1
Xnetwork.in_period\[188\]\[3\]$_DFFE_PP_ clknet_leaf_208_clk
+ net434 _03185_ VSS VSS VDD VDD network.in_period\[188\]\[3\]
+ sky130_fd_sc_hd__edfxtp_1
Xnetwork.in_period\[189\]\[0\]$_DFFE_PP_ clknet_leaf_198_clk
+ net458 _03186_ VSS VSS VDD VDD network.in_period\[189\]\[0\]
+ sky130_fd_sc_hd__edfxtp_1
Xnetwork.in_period\[189\]\[1\]$_DFFE_PP_ clknet_leaf_198_clk
+ net450 _03186_ VSS VSS VDD VDD network.in_period\[189\]\[1\]
+ sky130_fd_sc_hd__edfxtp_1
Xnetwork.in_period\[189\]\[2\]$_DFFE_PP_ clknet_leaf_198_clk
+ net440 _03186_ VSS VSS VDD VDD network.in_period\[189\]\[2\]
+ sky130_fd_sc_hd__edfxtp_1
Xnetwork.in_period\[189\]\[3\]$_DFFE_PP_ clknet_leaf_198_clk
+ net434 _03186_ VSS VSS VDD VDD network.in_period\[189\]\[3\]
+ sky130_fd_sc_hd__edfxtp_1
Xnetwork.in_period\[18\]\[0\]$_DFFE_PP_ clknet_leaf_27_clk
+ net457 _03187_ VSS VSS VDD VDD network.in_period\[18\]\[0\]
+ sky130_fd_sc_hd__edfxtp_1
Xnetwork.in_period\[18\]\[1\]$_DFFE_PP_ clknet_leaf_27_clk
+ net449 _03187_ VSS VSS VDD VDD network.in_period\[18\]\[1\]
+ sky130_fd_sc_hd__edfxtp_1
Xnetwork.in_period\[18\]\[2\]$_DFFE_PP_ clknet_leaf_27_clk
+ net441 _03187_ VSS VSS VDD VDD network.in_period\[18\]\[2\]
+ sky130_fd_sc_hd__edfxtp_1
Xnetwork.in_period\[18\]\[3\]$_DFFE_PP_ clknet_leaf_27_clk
+ net436 _03187_ VSS VSS VDD VDD network.in_period\[18\]\[3\]
+ sky130_fd_sc_hd__edfxtp_1
Xnetwork.in_period\[190\]\[0\]$_DFFE_PP_ clknet_leaf_201_clk
+ net456 _03188_ VSS VSS VDD VDD network.in_period\[190\]\[0\]
+ sky130_fd_sc_hd__edfxtp_1
Xnetwork.in_period\[190\]\[1\]$_DFFE_PP_ clknet_leaf_201_clk
+ net448 _03188_ VSS VSS VDD VDD network.in_period\[190\]\[1\]
+ sky130_fd_sc_hd__edfxtp_1
Xnetwork.in_period\[190\]\[2\]$_DFFE_PP_ clknet_leaf_201_clk
+ net440 _03188_ VSS VSS VDD VDD network.in_period\[190\]\[2\]
+ sky130_fd_sc_hd__edfxtp_1
Xnetwork.in_period\[190\]\[3\]$_DFFE_PP_ clknet_leaf_201_clk
+ net434 _03188_ VSS VSS VDD VDD network.in_period\[190\]\[3\]
+ sky130_fd_sc_hd__edfxtp_1
Xnetwork.in_period\[191\]\[0\]$_DFFE_PP_ clknet_leaf_197_clk
+ net458 _03189_ VSS VSS VDD VDD network.in_period\[191\]\[0\]
+ sky130_fd_sc_hd__edfxtp_1
Xnetwork.in_period\[191\]\[1\]$_DFFE_PP_ clknet_leaf_198_clk
+ net450 _03189_ VSS VSS VDD VDD network.in_period\[191\]\[1\]
+ sky130_fd_sc_hd__edfxtp_1
Xnetwork.in_period\[191\]\[2\]$_DFFE_PP_ clknet_leaf_200_clk
+ net440 _03189_ VSS VSS VDD VDD network.in_period\[191\]\[2\]
+ sky130_fd_sc_hd__edfxtp_1
Xnetwork.in_period\[191\]\[3\]$_DFFE_PP_ clknet_leaf_199_clk
+ net434 _03189_ VSS VSS VDD VDD network.in_period\[191\]\[3\]
+ sky130_fd_sc_hd__edfxtp_1
Xnetwork.in_period\[192\]\[0\]$_DFFE_PP_ clknet_leaf_113_clk
+ net452 _03190_ VSS VSS VDD VDD network.in_period\[192\]\[0\]
+ sky130_fd_sc_hd__edfxtp_1
Xnetwork.in_period\[192\]\[1\]$_DFFE_PP_ clknet_leaf_111_clk
+ net445 _03190_ VSS VSS VDD VDD network.in_period\[192\]\[1\]
+ sky130_fd_sc_hd__edfxtp_1
Xnetwork.in_period\[192\]\[2\]$_DFFE_PP_ clknet_leaf_112_clk
+ net442 _03190_ VSS VSS VDD VDD network.in_period\[192\]\[2\]
+ sky130_fd_sc_hd__edfxtp_1
Xnetwork.in_period\[192\]\[3\]$_DFFE_PP_ clknet_leaf_112_clk
+ net432 _03190_ VSS VSS VDD VDD network.in_period\[192\]\[3\]
+ sky130_fd_sc_hd__edfxtp_1
Xnetwork.in_period\[193\]\[0\]$_DFFE_PP_ clknet_leaf_111_clk
+ net452 _03191_ VSS VSS VDD VDD network.in_period\[193\]\[0\]
+ sky130_fd_sc_hd__edfxtp_1
Xnetwork.in_period\[193\]\[1\]$_DFFE_PP_ clknet_leaf_111_clk
+ net445 _03191_ VSS VSS VDD VDD network.in_period\[193\]\[1\]
+ sky130_fd_sc_hd__edfxtp_1
Xnetwork.in_period\[193\]\[2\]$_DFFE_PP_ clknet_leaf_111_clk
+ net442 _03191_ VSS VSS VDD VDD network.in_period\[193\]\[2\]
+ sky130_fd_sc_hd__edfxtp_1
Xnetwork.in_period\[193\]\[3\]$_DFFE_PP_ clknet_leaf_111_clk
+ net432 _03191_ VSS VSS VDD VDD network.in_period\[193\]\[3\]
+ sky130_fd_sc_hd__edfxtp_1
Xnetwork.in_period\[194\]\[0\]$_DFFE_PP_ clknet_leaf_110_clk
+ net452 _03192_ VSS VSS VDD VDD network.in_period\[194\]\[0\]
+ sky130_fd_sc_hd__edfxtp_1
Xnetwork.in_period\[194\]\[1\]$_DFFE_PP_ clknet_leaf_110_clk
+ net445 _03192_ VSS VSS VDD VDD network.in_period\[194\]\[1\]
+ sky130_fd_sc_hd__edfxtp_1
Xnetwork.in_period\[194\]\[2\]$_DFFE_PP_ clknet_leaf_110_clk
+ net442 _03192_ VSS VSS VDD VDD network.in_period\[194\]\[2\]
+ sky130_fd_sc_hd__edfxtp_1
Xnetwork.in_period\[194\]\[3\]$_DFFE_PP_ clknet_leaf_110_clk
+ net432 _03192_ VSS VSS VDD VDD network.in_period\[194\]\[3\]
+ sky130_fd_sc_hd__edfxtp_1
Xnetwork.in_period\[195\]\[0\]$_DFFE_PP_ clknet_leaf_108_clk
+ net452 _03193_ VSS VSS VDD VDD network.in_period\[195\]\[0\]
+ sky130_fd_sc_hd__edfxtp_1
Xnetwork.in_period\[195\]\[1\]$_DFFE_PP_ clknet_leaf_108_clk
+ net445 _03193_ VSS VSS VDD VDD network.in_period\[195\]\[1\]
+ sky130_fd_sc_hd__edfxtp_1
Xnetwork.in_period\[195\]\[2\]$_DFFE_PP_ clknet_leaf_108_clk
+ net442 _03193_ VSS VSS VDD VDD network.in_period\[195\]\[2\]
+ sky130_fd_sc_hd__edfxtp_1
Xnetwork.in_period\[195\]\[3\]$_DFFE_PP_ clknet_leaf_108_clk
+ net432 _03193_ VSS VSS VDD VDD network.in_period\[195\]\[3\]
+ sky130_fd_sc_hd__edfxtp_1
Xnetwork.in_period\[196\]\[0\]$_DFFE_PP_ clknet_leaf_149_clk
+ net455 _03194_ VSS VSS VDD VDD network.in_period\[196\]\[0\]
+ sky130_fd_sc_hd__edfxtp_1
Xnetwork.in_period\[196\]\[1\]$_DFFE_PP_ clknet_leaf_149_clk
+ net447 _03194_ VSS VSS VDD VDD network.in_period\[196\]\[1\]
+ sky130_fd_sc_hd__edfxtp_1
Xnetwork.in_period\[196\]\[2\]$_DFFE_PP_ clknet_leaf_149_clk
+ net442 _03194_ VSS VSS VDD VDD network.in_period\[196\]\[2\]
+ sky130_fd_sc_hd__edfxtp_1
Xnetwork.in_period\[196\]\[3\]$_DFFE_PP_ clknet_leaf_149_clk
+ net435 _03194_ VSS VSS VDD VDD network.in_period\[196\]\[3\]
+ sky130_fd_sc_hd__edfxtp_1
Xnetwork.in_period\[197\]\[0\]$_DFFE_PP_ clknet_leaf_149_clk
+ net455 _03195_ VSS VSS VDD VDD network.in_period\[197\]\[0\]
+ sky130_fd_sc_hd__edfxtp_1
Xnetwork.in_period\[197\]\[1\]$_DFFE_PP_ clknet_leaf_149_clk
+ net447 _03195_ VSS VSS VDD VDD network.in_period\[197\]\[1\]
+ sky130_fd_sc_hd__edfxtp_1
Xnetwork.in_period\[197\]\[2\]$_DFFE_PP_ clknet_leaf_149_clk
+ net442 _03195_ VSS VSS VDD VDD network.in_period\[197\]\[2\]
+ sky130_fd_sc_hd__edfxtp_1
Xnetwork.in_period\[197\]\[3\]$_DFFE_PP_ clknet_leaf_149_clk
+ net435 _03195_ VSS VSS VDD VDD network.in_period\[197\]\[3\]
+ sky130_fd_sc_hd__edfxtp_1
Xnetwork.in_period\[198\]\[0\]$_DFFE_PP_ clknet_leaf_109_clk
+ net452 _03196_ VSS VSS VDD VDD network.in_period\[198\]\[0\]
+ sky130_fd_sc_hd__edfxtp_1
Xnetwork.in_period\[198\]\[1\]$_DFFE_PP_ clknet_leaf_109_clk
+ net445 _03196_ VSS VSS VDD VDD network.in_period\[198\]\[1\]
+ sky130_fd_sc_hd__edfxtp_1
Xnetwork.in_period\[198\]\[2\]$_DFFE_PP_ clknet_leaf_109_clk
+ net442 _03196_ VSS VSS VDD VDD network.in_period\[198\]\[2\]
+ sky130_fd_sc_hd__edfxtp_1
Xnetwork.in_period\[198\]\[3\]$_DFFE_PP_ clknet_leaf_109_clk
+ net435 _03196_ VSS VSS VDD VDD network.in_period\[198\]\[3\]
+ sky130_fd_sc_hd__edfxtp_1
Xnetwork.in_period\[199\]\[0\]$_DFFE_PP_ clknet_leaf_146_clk
+ net455 _03197_ VSS VSS VDD VDD network.in_period\[199\]\[0\]
+ sky130_fd_sc_hd__edfxtp_1
Xnetwork.in_period\[199\]\[1\]$_DFFE_PP_ clknet_leaf_146_clk
+ net447 _03197_ VSS VSS VDD VDD network.in_period\[199\]\[1\]
+ sky130_fd_sc_hd__edfxtp_1
Xnetwork.in_period\[199\]\[2\]$_DFFE_PP_ clknet_leaf_145_clk
+ net442 _03197_ VSS VSS VDD VDD network.in_period\[199\]\[2\]
+ sky130_fd_sc_hd__edfxtp_1
Xnetwork.in_period\[199\]\[3\]$_DFFE_PP_ clknet_leaf_145_clk
+ net435 _03197_ VSS VSS VDD VDD network.in_period\[199\]\[3\]
+ sky130_fd_sc_hd__edfxtp_1
Xnetwork.in_period\[19\]\[0\]$_DFFE_PP_ clknet_leaf_9_clk
+ net454 _03198_ VSS VSS VDD VDD network.in_period\[19\]\[0\]
+ sky130_fd_sc_hd__edfxtp_1
Xnetwork.in_period\[19\]\[1\]$_DFFE_PP_ clknet_leaf_9_clk
+ net451 _03198_ VSS VSS VDD VDD network.in_period\[19\]\[1\]
+ sky130_fd_sc_hd__edfxtp_1
Xnetwork.in_period\[19\]\[2\]$_DFFE_PP_ clknet_leaf_9_clk
+ net444 _03198_ VSS VSS VDD VDD network.in_period\[19\]\[2\]
+ sky130_fd_sc_hd__edfxtp_1
Xnetwork.in_period\[19\]\[3\]$_DFFE_PP_ clknet_leaf_9_clk
+ net433 _03198_ VSS VSS VDD VDD network.in_period\[19\]\[3\]
+ sky130_fd_sc_hd__edfxtp_1
Xnetwork.in_period\[1\]\[0\]$_DFFE_PP_ clknet_leaf_75_clk
+ net453 _03199_ VSS VSS VDD VDD network.in_period\[1\]\[0\]
+ sky130_fd_sc_hd__edfxtp_1
Xnetwork.in_period\[1\]\[1\]$_DFFE_PP_ clknet_leaf_65_clk
+ net446 _03199_ VSS VSS VDD VDD network.in_period\[1\]\[1\]
+ sky130_fd_sc_hd__edfxtp_1
Xnetwork.in_period\[1\]\[2\]$_DFFE_PP_ clknet_leaf_65_clk
+ net438 _03199_ VSS VSS VDD VDD network.in_period\[1\]\[2\]
+ sky130_fd_sc_hd__edfxtp_1
Xnetwork.in_period\[1\]\[3\]$_DFFE_PP_ clknet_leaf_65_clk
+ net431 _03199_ VSS VSS VDD VDD network.in_period\[1\]\[3\]
+ sky130_fd_sc_hd__edfxtp_1
Xnetwork.in_period\[200\]\[0\]$_DFFE_PP_ clknet_leaf_147_clk
+ net455 _03200_ VSS VSS VDD VDD network.in_period\[200\]\[0\]
+ sky130_fd_sc_hd__edfxtp_1
Xnetwork.in_period\[200\]\[1\]$_DFFE_PP_ clknet_leaf_147_clk
+ net447 _03200_ VSS VSS VDD VDD network.in_period\[200\]\[1\]
+ sky130_fd_sc_hd__edfxtp_1
Xnetwork.in_period\[200\]\[2\]$_DFFE_PP_ clknet_leaf_146_clk
+ net442 _03200_ VSS VSS VDD VDD network.in_period\[200\]\[2\]
+ sky130_fd_sc_hd__edfxtp_1
Xnetwork.in_period\[200\]\[3\]$_DFFE_PP_ clknet_leaf_146_clk
+ net435 _03200_ VSS VSS VDD VDD network.in_period\[200\]\[3\]
+ sky130_fd_sc_hd__edfxtp_1
Xnetwork.in_period\[201\]\[0\]$_DFFE_PP_ clknet_leaf_148_clk
+ net455 _03201_ VSS VSS VDD VDD network.in_period\[201\]\[0\]
+ sky130_fd_sc_hd__edfxtp_1
Xnetwork.in_period\[201\]\[1\]$_DFFE_PP_ clknet_leaf_148_clk
+ net447 _03201_ VSS VSS VDD VDD network.in_period\[201\]\[1\]
+ sky130_fd_sc_hd__edfxtp_1
Xnetwork.in_period\[201\]\[2\]$_DFFE_PP_ clknet_leaf_148_clk
+ net442 _03201_ VSS VSS VDD VDD network.in_period\[201\]\[2\]
+ sky130_fd_sc_hd__edfxtp_1
Xnetwork.in_period\[201\]\[3\]$_DFFE_PP_ clknet_leaf_152_clk
+ net436 _03201_ VSS VSS VDD VDD network.in_period\[201\]\[3\]
+ sky130_fd_sc_hd__edfxtp_1
Xnetwork.in_period\[202\]\[0\]$_DFFE_PP_ clknet_leaf_113_clk
+ net452 _03202_ VSS VSS VDD VDD network.in_period\[202\]\[0\]
+ sky130_fd_sc_hd__edfxtp_1
Xnetwork.in_period\[202\]\[1\]$_DFFE_PP_ clknet_leaf_113_clk
+ net445 _03202_ VSS VSS VDD VDD network.in_period\[202\]\[1\]
+ sky130_fd_sc_hd__edfxtp_1
Xnetwork.in_period\[202\]\[2\]$_DFFE_PP_ clknet_leaf_106_clk
+ net442 _03202_ VSS VSS VDD VDD network.in_period\[202\]\[2\]
+ sky130_fd_sc_hd__edfxtp_1
Xnetwork.in_period\[202\]\[3\]$_DFFE_PP_ clknet_leaf_106_clk
+ net432 _03202_ VSS VSS VDD VDD network.in_period\[202\]\[3\]
+ sky130_fd_sc_hd__edfxtp_1
Xnetwork.in_period\[203\]\[0\]$_DFFE_PP_ clknet_leaf_148_clk
+ net455 _03203_ VSS VSS VDD VDD network.in_period\[203\]\[0\]
+ sky130_fd_sc_hd__edfxtp_1
Xnetwork.in_period\[203\]\[1\]$_DFFE_PP_ clknet_leaf_148_clk
+ net447 _03203_ VSS VSS VDD VDD network.in_period\[203\]\[1\]
+ sky130_fd_sc_hd__edfxtp_1
Xnetwork.in_period\[203\]\[2\]$_DFFE_PP_ clknet_leaf_151_clk
+ net442 _03203_ VSS VSS VDD VDD network.in_period\[203\]\[2\]
+ sky130_fd_sc_hd__edfxtp_1
Xnetwork.in_period\[203\]\[3\]$_DFFE_PP_ clknet_leaf_152_clk
+ net435 _03203_ VSS VSS VDD VDD network.in_period\[203\]\[3\]
+ sky130_fd_sc_hd__edfxtp_1
Xnetwork.in_period\[204\]\[0\]$_DFFE_PP_ clknet_leaf_154_clk
+ net457 _03204_ VSS VSS VDD VDD network.in_period\[204\]\[0\]
+ sky130_fd_sc_hd__edfxtp_1
Xnetwork.in_period\[204\]\[1\]$_DFFE_PP_ clknet_leaf_154_clk
+ net447 _03204_ VSS VSS VDD VDD network.in_period\[204\]\[1\]
+ sky130_fd_sc_hd__edfxtp_1
Xnetwork.in_period\[204\]\[2\]$_DFFE_PP_ clknet_leaf_153_clk
+ net442 _03204_ VSS VSS VDD VDD network.in_period\[204\]\[2\]
+ sky130_fd_sc_hd__edfxtp_1
Xnetwork.in_period\[204\]\[3\]$_DFFE_PP_ clknet_leaf_153_clk
+ net436 _03204_ VSS VSS VDD VDD network.in_period\[204\]\[3\]
+ sky130_fd_sc_hd__edfxtp_1
Xnetwork.in_period\[205\]\[0\]$_DFFE_PP_ clknet_leaf_102_clk
+ net457 _03205_ VSS VSS VDD VDD network.in_period\[205\]\[0\]
+ sky130_fd_sc_hd__edfxtp_1
Xnetwork.in_period\[205\]\[1\]$_DFFE_PP_ clknet_leaf_102_clk
+ net447 _03205_ VSS VSS VDD VDD network.in_period\[205\]\[1\]
+ sky130_fd_sc_hd__edfxtp_1
Xnetwork.in_period\[205\]\[2\]$_DFFE_PP_ clknet_leaf_153_clk
+ net442 _03205_ VSS VSS VDD VDD network.in_period\[205\]\[2\]
+ sky130_fd_sc_hd__edfxtp_1
Xnetwork.in_period\[205\]\[3\]$_DFFE_PP_ clknet_leaf_102_clk
+ net436 _03205_ VSS VSS VDD VDD network.in_period\[205\]\[3\]
+ sky130_fd_sc_hd__edfxtp_1
Xnetwork.in_period\[206\]\[0\]$_DFFE_PP_ clknet_leaf_107_clk
+ net452 _03206_ VSS VSS VDD VDD network.in_period\[206\]\[0\]
+ sky130_fd_sc_hd__edfxtp_1
Xnetwork.in_period\[206\]\[1\]$_DFFE_PP_ clknet_leaf_107_clk
+ net445 _03206_ VSS VSS VDD VDD network.in_period\[206\]\[1\]
+ sky130_fd_sc_hd__edfxtp_1
Xnetwork.in_period\[206\]\[2\]$_DFFE_PP_ clknet_leaf_106_clk
+ net442 _03206_ VSS VSS VDD VDD network.in_period\[206\]\[2\]
+ sky130_fd_sc_hd__edfxtp_1
Xnetwork.in_period\[206\]\[3\]$_DFFE_PP_ clknet_leaf_106_clk
+ net432 _03206_ VSS VSS VDD VDD network.in_period\[206\]\[3\]
+ sky130_fd_sc_hd__edfxtp_1
Xnetwork.in_period\[207\]\[0\]$_DFFE_PP_ clknet_leaf_102_clk
+ net457 _03207_ VSS VSS VDD VDD network.in_period\[207\]\[0\]
+ sky130_fd_sc_hd__edfxtp_1
Xnetwork.in_period\[207\]\[1\]$_DFFE_PP_ clknet_leaf_102_clk
+ net447 _03207_ VSS VSS VDD VDD network.in_period\[207\]\[1\]
+ sky130_fd_sc_hd__edfxtp_1
Xnetwork.in_period\[207\]\[2\]$_DFFE_PP_ clknet_leaf_102_clk
+ net442 _03207_ VSS VSS VDD VDD network.in_period\[207\]\[2\]
+ sky130_fd_sc_hd__edfxtp_1
Xnetwork.in_period\[207\]\[3\]$_DFFE_PP_ clknet_leaf_102_clk
+ net436 _03207_ VSS VSS VDD VDD network.in_period\[207\]\[3\]
+ sky130_fd_sc_hd__edfxtp_1
Xnetwork.in_period\[208\]\[0\]$_DFFE_PP_ clknet_leaf_104_clk
+ net452 _03208_ VSS VSS VDD VDD network.in_period\[208\]\[0\]
+ sky130_fd_sc_hd__edfxtp_1
Xnetwork.in_period\[208\]\[1\]$_DFFE_PP_ clknet_leaf_104_clk
+ net445 _03208_ VSS VSS VDD VDD network.in_period\[208\]\[1\]
+ sky130_fd_sc_hd__edfxtp_1
Xnetwork.in_period\[208\]\[2\]$_DFFE_PP_ clknet_leaf_103_clk
+ net442 _03208_ VSS VSS VDD VDD network.in_period\[208\]\[2\]
+ sky130_fd_sc_hd__edfxtp_1
Xnetwork.in_period\[208\]\[3\]$_DFFE_PP_ clknet_leaf_103_clk
+ net432 _03208_ VSS VSS VDD VDD network.in_period\[208\]\[3\]
+ sky130_fd_sc_hd__edfxtp_1
Xnetwork.in_period\[209\]\[0\]$_DFFE_PP_ clknet_leaf_117_clk
+ net452 _03209_ VSS VSS VDD VDD network.in_period\[209\]\[0\]
+ sky130_fd_sc_hd__edfxtp_1
Xnetwork.in_period\[209\]\[1\]$_DFFE_PP_ clknet_leaf_117_clk
+ net445 _03209_ VSS VSS VDD VDD network.in_period\[209\]\[1\]
+ sky130_fd_sc_hd__edfxtp_1
Xnetwork.in_period\[209\]\[2\]$_DFFE_PP_ clknet_leaf_117_clk
+ net439 _03209_ VSS VSS VDD VDD network.in_period\[209\]\[2\]
+ sky130_fd_sc_hd__edfxtp_1
Xnetwork.in_period\[209\]\[3\]$_DFFE_PP_ clknet_leaf_117_clk
+ net432 _03209_ VSS VSS VDD VDD network.in_period\[209\]\[3\]
+ sky130_fd_sc_hd__edfxtp_1
Xnetwork.in_period\[20\]\[0\]$_DFFE_PP_ clknet_leaf_262_clk
+ net456 _03210_ VSS VSS VDD VDD network.in_period\[20\]\[0\]
+ sky130_fd_sc_hd__edfxtp_1
Xnetwork.in_period\[20\]\[1\]$_DFFE_PP_ clknet_leaf_262_clk
+ net449 _03210_ VSS VSS VDD VDD network.in_period\[20\]\[1\]
+ sky130_fd_sc_hd__edfxtp_1
Xnetwork.in_period\[20\]\[2\]$_DFFE_PP_ clknet_leaf_260_clk
+ net443 _03210_ VSS VSS VDD VDD network.in_period\[20\]\[2\]
+ sky130_fd_sc_hd__edfxtp_1
Xnetwork.in_period\[20\]\[3\]$_DFFE_PP_ clknet_leaf_260_clk
+ net437 _03210_ VSS VSS VDD VDD network.in_period\[20\]\[3\]
+ sky130_fd_sc_hd__edfxtp_1
Xnetwork.in_period\[210\]\[0\]$_DFFE_PP_ clknet_leaf_122_clk
+ net452 _03211_ VSS VSS VDD VDD network.in_period\[210\]\[0\]
+ sky130_fd_sc_hd__edfxtp_1
Xnetwork.in_period\[210\]\[1\]$_DFFE_PP_ clknet_leaf_122_clk
+ net445 _03211_ VSS VSS VDD VDD network.in_period\[210\]\[1\]
+ sky130_fd_sc_hd__edfxtp_1
Xnetwork.in_period\[210\]\[2\]$_DFFE_PP_ clknet_leaf_122_clk
+ net442 _03211_ VSS VSS VDD VDD network.in_period\[210\]\[2\]
+ sky130_fd_sc_hd__edfxtp_1
Xnetwork.in_period\[210\]\[3\]$_DFFE_PP_ clknet_leaf_122_clk
+ net432 _03211_ VSS VSS VDD VDD network.in_period\[210\]\[3\]
+ sky130_fd_sc_hd__edfxtp_1
Xnetwork.in_period\[211\]\[0\]$_DFFE_PP_ clknet_leaf_112_clk
+ net452 _03212_ VSS VSS VDD VDD network.in_period\[211\]\[0\]
+ sky130_fd_sc_hd__edfxtp_1
Xnetwork.in_period\[211\]\[1\]$_DFFE_PP_ clknet_leaf_118_clk
+ net445 _03212_ VSS VSS VDD VDD network.in_period\[211\]\[1\]
+ sky130_fd_sc_hd__edfxtp_1
Xnetwork.in_period\[211\]\[2\]$_DFFE_PP_ clknet_leaf_112_clk
+ net442 _03212_ VSS VSS VDD VDD network.in_period\[211\]\[2\]
+ sky130_fd_sc_hd__edfxtp_1
Xnetwork.in_period\[211\]\[3\]$_DFFE_PP_ clknet_leaf_112_clk
+ net432 _03212_ VSS VSS VDD VDD network.in_period\[211\]\[3\]
+ sky130_fd_sc_hd__edfxtp_1
Xnetwork.in_period\[212\]\[0\]$_DFFE_PP_ clknet_leaf_118_clk
+ net452 _03213_ VSS VSS VDD VDD network.in_period\[212\]\[0\]
+ sky130_fd_sc_hd__edfxtp_1
Xnetwork.in_period\[212\]\[1\]$_DFFE_PP_ clknet_leaf_118_clk
+ net445 _03213_ VSS VSS VDD VDD network.in_period\[212\]\[1\]
+ sky130_fd_sc_hd__edfxtp_1
Xnetwork.in_period\[212\]\[2\]$_DFFE_PP_ clknet_leaf_117_clk
+ net439 _03213_ VSS VSS VDD VDD network.in_period\[212\]\[2\]
+ sky130_fd_sc_hd__edfxtp_1
Xnetwork.in_period\[212\]\[3\]$_DFFE_PP_ clknet_leaf_118_clk
+ net432 _03213_ VSS VSS VDD VDD network.in_period\[212\]\[3\]
+ sky130_fd_sc_hd__edfxtp_1
Xnetwork.in_period\[213\]\[0\]$_DFFE_PP_ clknet_leaf_119_clk
+ net452 _03214_ VSS VSS VDD VDD network.in_period\[213\]\[0\]
+ sky130_fd_sc_hd__edfxtp_1
Xnetwork.in_period\[213\]\[1\]$_DFFE_PP_ clknet_leaf_119_clk
+ net445 _03214_ VSS VSS VDD VDD network.in_period\[213\]\[1\]
+ sky130_fd_sc_hd__edfxtp_1
Xnetwork.in_period\[213\]\[2\]$_DFFE_PP_ clknet_leaf_116_clk
+ net439 _03214_ VSS VSS VDD VDD network.in_period\[213\]\[2\]
+ sky130_fd_sc_hd__edfxtp_1
Xnetwork.in_period\[213\]\[3\]$_DFFE_PP_ clknet_leaf_119_clk
+ net432 _03214_ VSS VSS VDD VDD network.in_period\[213\]\[3\]
+ sky130_fd_sc_hd__edfxtp_1
Xnetwork.in_period\[214\]\[0\]$_DFFE_PP_ clknet_leaf_114_clk
+ net452 _03215_ VSS VSS VDD VDD network.in_period\[214\]\[0\]
+ sky130_fd_sc_hd__edfxtp_1
Xnetwork.in_period\[214\]\[1\]$_DFFE_PP_ clknet_leaf_114_clk
+ net445 _03215_ VSS VSS VDD VDD network.in_period\[214\]\[1\]
+ sky130_fd_sc_hd__edfxtp_1
Xnetwork.in_period\[214\]\[2\]$_DFFE_PP_ clknet_leaf_113_clk
+ net442 _03215_ VSS VSS VDD VDD network.in_period\[214\]\[2\]
+ sky130_fd_sc_hd__edfxtp_1
Xnetwork.in_period\[214\]\[3\]$_DFFE_PP_ clknet_leaf_114_clk
+ net432 _03215_ VSS VSS VDD VDD network.in_period\[214\]\[3\]
+ sky130_fd_sc_hd__edfxtp_1
Xnetwork.in_period\[215\]\[0\]$_DFFE_PP_ clknet_leaf_116_clk
+ net452 _03216_ VSS VSS VDD VDD network.in_period\[215\]\[0\]
+ sky130_fd_sc_hd__edfxtp_1
Xnetwork.in_period\[215\]\[1\]$_DFFE_PP_ clknet_leaf_115_clk
+ net445 _03216_ VSS VSS VDD VDD network.in_period\[215\]\[1\]
+ sky130_fd_sc_hd__edfxtp_1
Xnetwork.in_period\[215\]\[2\]$_DFFE_PP_ clknet_leaf_115_clk
+ net442 _03216_ VSS VSS VDD VDD network.in_period\[215\]\[2\]
+ sky130_fd_sc_hd__edfxtp_1
Xnetwork.in_period\[215\]\[3\]$_DFFE_PP_ clknet_leaf_115_clk
+ net432 _03216_ VSS VSS VDD VDD network.in_period\[215\]\[3\]
+ sky130_fd_sc_hd__edfxtp_1
Xnetwork.in_period\[216\]\[0\]$_DFFE_PP_ clknet_leaf_116_clk
+ net452 _03217_ VSS VSS VDD VDD network.in_period\[216\]\[0\]
+ sky130_fd_sc_hd__edfxtp_1
Xnetwork.in_period\[216\]\[1\]$_DFFE_PP_ clknet_leaf_116_clk
+ net445 _03217_ VSS VSS VDD VDD network.in_period\[216\]\[1\]
+ sky130_fd_sc_hd__edfxtp_1
Xnetwork.in_period\[216\]\[2\]$_DFFE_PP_ clknet_leaf_116_clk
+ net439 _03217_ VSS VSS VDD VDD network.in_period\[216\]\[2\]
+ sky130_fd_sc_hd__edfxtp_1
Xnetwork.in_period\[216\]\[3\]$_DFFE_PP_ clknet_leaf_116_clk
+ net432 _03217_ VSS VSS VDD VDD network.in_period\[216\]\[3\]
+ sky130_fd_sc_hd__edfxtp_1
Xnetwork.in_period\[217\]\[0\]$_DFFE_PP_ clknet_leaf_94_clk
+ net452 _03218_ VSS VSS VDD VDD network.in_period\[217\]\[0\]
+ sky130_fd_sc_hd__edfxtp_1
Xnetwork.in_period\[217\]\[1\]$_DFFE_PP_ clknet_leaf_94_clk
+ net445 _03218_ VSS VSS VDD VDD network.in_period\[217\]\[1\]
+ sky130_fd_sc_hd__edfxtp_1
Xnetwork.in_period\[217\]\[2\]$_DFFE_PP_ clknet_leaf_105_clk
+ net442 _03218_ VSS VSS VDD VDD network.in_period\[217\]\[2\]
+ sky130_fd_sc_hd__edfxtp_1
Xnetwork.in_period\[217\]\[3\]$_DFFE_PP_ clknet_leaf_105_clk
+ net432 _03218_ VSS VSS VDD VDD network.in_period\[217\]\[3\]
+ sky130_fd_sc_hd__edfxtp_1
Xnetwork.in_period\[218\]\[0\]$_DFFE_PP_ clknet_leaf_115_clk
+ net452 _03219_ VSS VSS VDD VDD network.in_period\[218\]\[0\]
+ sky130_fd_sc_hd__edfxtp_1
Xnetwork.in_period\[218\]\[1\]$_DFFE_PP_ clknet_leaf_115_clk
+ net445 _03219_ VSS VSS VDD VDD network.in_period\[218\]\[1\]
+ sky130_fd_sc_hd__edfxtp_1
Xnetwork.in_period\[218\]\[2\]$_DFFE_PP_ clknet_leaf_115_clk
+ net442 _03219_ VSS VSS VDD VDD network.in_period\[218\]\[2\]
+ sky130_fd_sc_hd__edfxtp_1
Xnetwork.in_period\[218\]\[3\]$_DFFE_PP_ clknet_leaf_115_clk
+ net432 _03219_ VSS VSS VDD VDD network.in_period\[218\]\[3\]
+ sky130_fd_sc_hd__edfxtp_1
Xnetwork.in_period\[219\]\[0\]$_DFFE_PP_ clknet_leaf_95_clk
+ net452 _03220_ VSS VSS VDD VDD network.in_period\[219\]\[0\]
+ sky130_fd_sc_hd__edfxtp_1
Xnetwork.in_period\[219\]\[1\]$_DFFE_PP_ clknet_leaf_95_clk
+ net445 _03220_ VSS VSS VDD VDD network.in_period\[219\]\[1\]
+ sky130_fd_sc_hd__edfxtp_1
Xnetwork.in_period\[219\]\[2\]$_DFFE_PP_ clknet_leaf_94_clk
+ net442 _03220_ VSS VSS VDD VDD network.in_period\[219\]\[2\]
+ sky130_fd_sc_hd__edfxtp_1
Xnetwork.in_period\[219\]\[3\]$_DFFE_PP_ clknet_leaf_94_clk
+ net432 _03220_ VSS VSS VDD VDD network.in_period\[219\]\[3\]
+ sky130_fd_sc_hd__edfxtp_1
Xnetwork.in_period\[21\]\[0\]$_DFFE_PP_ clknet_leaf_262_clk
+ net456 _03221_ VSS VSS VDD VDD network.in_period\[21\]\[0\]
+ sky130_fd_sc_hd__edfxtp_1
Xnetwork.in_period\[21\]\[1\]$_DFFE_PP_ clknet_leaf_263_clk
+ net449 _03221_ VSS VSS VDD VDD network.in_period\[21\]\[1\]
+ sky130_fd_sc_hd__edfxtp_1
Xnetwork.in_period\[21\]\[2\]$_DFFE_PP_ clknet_leaf_263_clk
+ net443 _03221_ VSS VSS VDD VDD network.in_period\[21\]\[2\]
+ sky130_fd_sc_hd__edfxtp_1
Xnetwork.in_period\[21\]\[3\]$_DFFE_PP_ clknet_leaf_263_clk
+ net437 _03221_ VSS VSS VDD VDD network.in_period\[21\]\[3\]
+ sky130_fd_sc_hd__edfxtp_1
Xnetwork.in_period\[220\]\[0\]$_DFFE_PP_ clknet_leaf_100_clk
+ net457 _03222_ VSS VSS VDD VDD network.in_period\[220\]\[0\]
+ sky130_fd_sc_hd__edfxtp_1
Xnetwork.in_period\[220\]\[1\]$_DFFE_PP_ clknet_leaf_100_clk
+ net447 _03222_ VSS VSS VDD VDD network.in_period\[220\]\[1\]
+ sky130_fd_sc_hd__edfxtp_1
Xnetwork.in_period\[220\]\[2\]$_DFFE_PP_ clknet_leaf_99_clk
+ net442 _03222_ VSS VSS VDD VDD network.in_period\[220\]\[2\]
+ sky130_fd_sc_hd__edfxtp_1
Xnetwork.in_period\[220\]\[3\]$_DFFE_PP_ clknet_leaf_99_clk
+ net436 _03222_ VSS VSS VDD VDD network.in_period\[220\]\[3\]
+ sky130_fd_sc_hd__edfxtp_1
Xnetwork.in_period\[221\]\[0\]$_DFFE_PP_ clknet_leaf_95_clk
+ net452 _03223_ VSS VSS VDD VDD network.in_period\[221\]\[0\]
+ sky130_fd_sc_hd__edfxtp_1
Xnetwork.in_period\[221\]\[1\]$_DFFE_PP_ clknet_leaf_95_clk
+ net445 _03223_ VSS VSS VDD VDD network.in_period\[221\]\[1\]
+ sky130_fd_sc_hd__edfxtp_1
Xnetwork.in_period\[221\]\[2\]$_DFFE_PP_ clknet_leaf_95_clk
+ net442 _03223_ VSS VSS VDD VDD network.in_period\[221\]\[2\]
+ sky130_fd_sc_hd__edfxtp_1
Xnetwork.in_period\[221\]\[3\]$_DFFE_PP_ clknet_leaf_96_clk
+ net432 _03223_ VSS VSS VDD VDD network.in_period\[221\]\[3\]
+ sky130_fd_sc_hd__edfxtp_1
Xnetwork.in_period\[222\]\[0\]$_DFFE_PP_ clknet_leaf_98_clk
+ net452 _03224_ VSS VSS VDD VDD network.in_period\[222\]\[0\]
+ sky130_fd_sc_hd__edfxtp_1
Xnetwork.in_period\[222\]\[1\]$_DFFE_PP_ clknet_leaf_98_clk
+ net445 _03224_ VSS VSS VDD VDD network.in_period\[222\]\[1\]
+ sky130_fd_sc_hd__edfxtp_1
Xnetwork.in_period\[222\]\[2\]$_DFFE_PP_ clknet_leaf_96_clk
+ net442 _03224_ VSS VSS VDD VDD network.in_period\[222\]\[2\]
+ sky130_fd_sc_hd__edfxtp_1
Xnetwork.in_period\[222\]\[3\]$_DFFE_PP_ clknet_leaf_96_clk
+ net432 _03224_ VSS VSS VDD VDD network.in_period\[222\]\[3\]
+ sky130_fd_sc_hd__edfxtp_1
Xnetwork.in_period\[223\]\[0\]$_DFFE_PP_ clknet_leaf_101_clk
+ net457 _03225_ VSS VSS VDD VDD network.in_period\[223\]\[0\]
+ sky130_fd_sc_hd__edfxtp_1
Xnetwork.in_period\[223\]\[1\]$_DFFE_PP_ clknet_leaf_101_clk
+ net447 _03225_ VSS VSS VDD VDD network.in_period\[223\]\[1\]
+ sky130_fd_sc_hd__edfxtp_1
Xnetwork.in_period\[223\]\[2\]$_DFFE_PP_ clknet_leaf_101_clk
+ net442 _03225_ VSS VSS VDD VDD network.in_period\[223\]\[2\]
+ sky130_fd_sc_hd__edfxtp_1
Xnetwork.in_period\[223\]\[3\]$_DFFE_PP_ clknet_leaf_99_clk
+ net436 _03225_ VSS VSS VDD VDD network.in_period\[223\]\[3\]
+ sky130_fd_sc_hd__edfxtp_1
Xnetwork.in_period\[224\]\[0\]$_DFFE_PP_ clknet_leaf_229_clk
+ net455 _03226_ VSS VSS VDD VDD network.in_period\[224\]\[0\]
+ sky130_fd_sc_hd__edfxtp_1
Xnetwork.in_period\[224\]\[1\]$_DFFE_PP_ clknet_leaf_229_clk
+ net448 _03226_ VSS VSS VDD VDD network.in_period\[224\]\[1\]
+ sky130_fd_sc_hd__edfxtp_1
Xnetwork.in_period\[224\]\[2\]$_DFFE_PP_ clknet_leaf_228_clk
+ net441 _03226_ VSS VSS VDD VDD network.in_period\[224\]\[2\]
+ sky130_fd_sc_hd__edfxtp_1
Xnetwork.in_period\[224\]\[3\]$_DFFE_PP_ clknet_leaf_227_clk
+ net435 _03226_ VSS VSS VDD VDD network.in_period\[224\]\[3\]
+ sky130_fd_sc_hd__edfxtp_1
Xnetwork.in_period\[225\]\[0\]$_DFFE_PP_ clknet_leaf_229_clk
+ net455 _03227_ VSS VSS VDD VDD network.in_period\[225\]\[0\]
+ sky130_fd_sc_hd__edfxtp_1
Xnetwork.in_period\[225\]\[1\]$_DFFE_PP_ clknet_leaf_229_clk
+ net448 _03227_ VSS VSS VDD VDD network.in_period\[225\]\[1\]
+ sky130_fd_sc_hd__edfxtp_1
Xnetwork.in_period\[225\]\[2\]$_DFFE_PP_ clknet_leaf_232_clk
+ net442 _03227_ VSS VSS VDD VDD network.in_period\[225\]\[2\]
+ sky130_fd_sc_hd__edfxtp_1
Xnetwork.in_period\[225\]\[3\]$_DFFE_PP_ clknet_leaf_229_clk
+ net435 _03227_ VSS VSS VDD VDD network.in_period\[225\]\[3\]
+ sky130_fd_sc_hd__edfxtp_1
Xnetwork.in_period\[226\]\[0\]$_DFFE_PP_ clknet_leaf_234_clk
+ net457 _03228_ VSS VSS VDD VDD network.in_period\[226\]\[0\]
+ sky130_fd_sc_hd__edfxtp_1
Xnetwork.in_period\[226\]\[1\]$_DFFE_PP_ clknet_leaf_234_clk
+ net447 _03228_ VSS VSS VDD VDD network.in_period\[226\]\[1\]
+ sky130_fd_sc_hd__edfxtp_1
Xnetwork.in_period\[226\]\[2\]$_DFFE_PP_ clknet_leaf_234_clk
+ net442 _03228_ VSS VSS VDD VDD network.in_period\[226\]\[2\]
+ sky130_fd_sc_hd__edfxtp_1
Xnetwork.in_period\[226\]\[3\]$_DFFE_PP_ clknet_leaf_234_clk
+ net436 _03228_ VSS VSS VDD VDD network.in_period\[226\]\[3\]
+ sky130_fd_sc_hd__edfxtp_1
Xnetwork.in_period\[227\]\[0\]$_DFFE_PP_ clknet_leaf_235_clk
+ net457 _03229_ VSS VSS VDD VDD network.in_period\[227\]\[0\]
+ sky130_fd_sc_hd__edfxtp_1
Xnetwork.in_period\[227\]\[1\]$_DFFE_PP_ clknet_leaf_235_clk
+ net447 _03229_ VSS VSS VDD VDD network.in_period\[227\]\[1\]
+ sky130_fd_sc_hd__edfxtp_1
Xnetwork.in_period\[227\]\[2\]$_DFFE_PP_ clknet_leaf_235_clk
+ net442 _03229_ VSS VSS VDD VDD network.in_period\[227\]\[2\]
+ sky130_fd_sc_hd__edfxtp_1
Xnetwork.in_period\[227\]\[3\]$_DFFE_PP_ clknet_leaf_235_clk
+ net436 _03229_ VSS VSS VDD VDD network.in_period\[227\]\[3\]
+ sky130_fd_sc_hd__edfxtp_1
Xnetwork.in_period\[228\]\[0\]$_DFFE_PP_ clknet_leaf_239_clk
+ net455 _03230_ VSS VSS VDD VDD network.in_period\[228\]\[0\]
+ sky130_fd_sc_hd__edfxtp_1
Xnetwork.in_period\[228\]\[1\]$_DFFE_PP_ clknet_leaf_239_clk
+ net449 _03230_ VSS VSS VDD VDD network.in_period\[228\]\[1\]
+ sky130_fd_sc_hd__edfxtp_1
Xnetwork.in_period\[228\]\[2\]$_DFFE_PP_ clknet_leaf_239_clk
+ net441 _03230_ VSS VSS VDD VDD network.in_period\[228\]\[2\]
+ sky130_fd_sc_hd__edfxtp_1
Xnetwork.in_period\[228\]\[3\]$_DFFE_PP_ clknet_leaf_239_clk
+ net435 _03230_ VSS VSS VDD VDD network.in_period\[228\]\[3\]
+ sky130_fd_sc_hd__edfxtp_1
Xnetwork.in_period\[229\]\[0\]$_DFFE_PP_ clknet_leaf_237_clk
+ net455 _03231_ VSS VSS VDD VDD network.in_period\[229\]\[0\]
+ sky130_fd_sc_hd__edfxtp_1
Xnetwork.in_period\[229\]\[1\]$_DFFE_PP_ clknet_leaf_237_clk
+ net448 _03231_ VSS VSS VDD VDD network.in_period\[229\]\[1\]
+ sky130_fd_sc_hd__edfxtp_1
Xnetwork.in_period\[229\]\[2\]$_DFFE_PP_ clknet_leaf_237_clk
+ net441 _03231_ VSS VSS VDD VDD network.in_period\[229\]\[2\]
+ sky130_fd_sc_hd__edfxtp_1
Xnetwork.in_period\[229\]\[3\]$_DFFE_PP_ clknet_leaf_237_clk
+ net435 _03231_ VSS VSS VDD VDD network.in_period\[229\]\[3\]
+ sky130_fd_sc_hd__edfxtp_1
Xnetwork.in_period\[22\]\[0\]$_DFFE_PP_ clknet_leaf_267_clk
+ net456 _03232_ VSS VSS VDD VDD network.in_period\[22\]\[0\]
+ sky130_fd_sc_hd__edfxtp_1
Xnetwork.in_period\[22\]\[1\]$_DFFE_PP_ clknet_leaf_267_clk
+ net449 _03232_ VSS VSS VDD VDD network.in_period\[22\]\[1\]
+ sky130_fd_sc_hd__edfxtp_1
Xnetwork.in_period\[22\]\[2\]$_DFFE_PP_ clknet_leaf_265_clk
+ net443 _03232_ VSS VSS VDD VDD network.in_period\[22\]\[2\]
+ sky130_fd_sc_hd__edfxtp_1
Xnetwork.in_period\[22\]\[3\]$_DFFE_PP_ clknet_leaf_265_clk
+ net437 _03232_ VSS VSS VDD VDD network.in_period\[22\]\[3\]
+ sky130_fd_sc_hd__edfxtp_1
Xnetwork.in_period\[230\]\[0\]$_DFFE_PP_ clknet_leaf_236_clk
+ net457 _03233_ VSS VSS VDD VDD network.in_period\[230\]\[0\]
+ sky130_fd_sc_hd__edfxtp_1
Xnetwork.in_period\[230\]\[1\]$_DFFE_PP_ clknet_leaf_236_clk
+ net447 _03233_ VSS VSS VDD VDD network.in_period\[230\]\[1\]
+ sky130_fd_sc_hd__edfxtp_1
Xnetwork.in_period\[230\]\[2\]$_DFFE_PP_ clknet_leaf_236_clk
+ net442 _03233_ VSS VSS VDD VDD network.in_period\[230\]\[2\]
+ sky130_fd_sc_hd__edfxtp_1
Xnetwork.in_period\[230\]\[3\]$_DFFE_PP_ clknet_leaf_236_clk
+ net436 _03233_ VSS VSS VDD VDD network.in_period\[230\]\[3\]
+ sky130_fd_sc_hd__edfxtp_1
Xnetwork.in_period\[231\]\[0\]$_DFFE_PP_ clknet_leaf_240_clk
+ net457 _03234_ VSS VSS VDD VDD network.in_period\[231\]\[0\]
+ sky130_fd_sc_hd__edfxtp_1
Xnetwork.in_period\[231\]\[1\]$_DFFE_PP_ clknet_leaf_240_clk
+ net447 _03234_ VSS VSS VDD VDD network.in_period\[231\]\[1\]
+ sky130_fd_sc_hd__edfxtp_1
Xnetwork.in_period\[231\]\[2\]$_DFFE_PP_ clknet_leaf_240_clk
+ net442 _03234_ VSS VSS VDD VDD network.in_period\[231\]\[2\]
+ sky130_fd_sc_hd__edfxtp_1
Xnetwork.in_period\[231\]\[3\]$_DFFE_PP_ clknet_leaf_240_clk
+ net436 _03234_ VSS VSS VDD VDD network.in_period\[231\]\[3\]
+ sky130_fd_sc_hd__edfxtp_1
Xnetwork.in_period\[232\]\[0\]$_DFFE_PP_ clknet_leaf_250_clk
+ net456 _03235_ VSS VSS VDD VDD network.in_period\[232\]\[0\]
+ sky130_fd_sc_hd__edfxtp_1
Xnetwork.in_period\[232\]\[1\]$_DFFE_PP_ clknet_leaf_250_clk
+ net448 _03235_ VSS VSS VDD VDD network.in_period\[232\]\[1\]
+ sky130_fd_sc_hd__edfxtp_1
Xnetwork.in_period\[232\]\[2\]$_DFFE_PP_ clknet_leaf_250_clk
+ net440 _03235_ VSS VSS VDD VDD network.in_period\[232\]\[2\]
+ sky130_fd_sc_hd__edfxtp_1
Xnetwork.in_period\[232\]\[3\]$_DFFE_PP_ clknet_leaf_249_clk
+ net437 _03235_ VSS VSS VDD VDD network.in_period\[232\]\[3\]
+ sky130_fd_sc_hd__edfxtp_1
Xnetwork.in_period\[233\]\[0\]$_DFFE_PP_ clknet_leaf_239_clk
+ net455 _03236_ VSS VSS VDD VDD network.in_period\[233\]\[0\]
+ sky130_fd_sc_hd__edfxtp_1
Xnetwork.in_period\[233\]\[1\]$_DFFE_PP_ clknet_leaf_239_clk
+ net449 _03236_ VSS VSS VDD VDD network.in_period\[233\]\[1\]
+ sky130_fd_sc_hd__edfxtp_1
Xnetwork.in_period\[233\]\[2\]$_DFFE_PP_ clknet_leaf_247_clk
+ net441 _03236_ VSS VSS VDD VDD network.in_period\[233\]\[2\]
+ sky130_fd_sc_hd__edfxtp_1
Xnetwork.in_period\[233\]\[3\]$_DFFE_PP_ clknet_leaf_239_clk
+ net435 _03236_ VSS VSS VDD VDD network.in_period\[233\]\[3\]
+ sky130_fd_sc_hd__edfxtp_1
Xnetwork.in_period\[234\]\[0\]$_DFFE_PP_ clknet_leaf_245_clk
+ net456 _03237_ VSS VSS VDD VDD network.in_period\[234\]\[0\]
+ sky130_fd_sc_hd__edfxtp_1
Xnetwork.in_period\[234\]\[1\]$_DFFE_PP_ clknet_leaf_244_clk
+ net449 _03237_ VSS VSS VDD VDD network.in_period\[234\]\[1\]
+ sky130_fd_sc_hd__edfxtp_1
Xnetwork.in_period\[234\]\[2\]$_DFFE_PP_ clknet_leaf_244_clk
+ net441 _03237_ VSS VSS VDD VDD network.in_period\[234\]\[2\]
+ sky130_fd_sc_hd__edfxtp_1
Xnetwork.in_period\[234\]\[3\]$_DFFE_PP_ clknet_leaf_245_clk
+ net437 _03237_ VSS VSS VDD VDD network.in_period\[234\]\[3\]
+ sky130_fd_sc_hd__edfxtp_1
Xnetwork.in_period\[235\]\[0\]$_DFFE_PP_ clknet_leaf_246_clk
+ net456 _03238_ VSS VSS VDD VDD network.in_period\[235\]\[0\]
+ sky130_fd_sc_hd__edfxtp_1
Xnetwork.in_period\[235\]\[1\]$_DFFE_PP_ clknet_leaf_246_clk
+ net449 _03238_ VSS VSS VDD VDD network.in_period\[235\]\[1\]
+ sky130_fd_sc_hd__edfxtp_1
Xnetwork.in_period\[235\]\[2\]$_DFFE_PP_ clknet_leaf_248_clk
+ net440 _03238_ VSS VSS VDD VDD network.in_period\[235\]\[2\]
+ sky130_fd_sc_hd__edfxtp_1
Xnetwork.in_period\[235\]\[3\]$_DFFE_PP_ clknet_leaf_246_clk
+ net437 _03238_ VSS VSS VDD VDD network.in_period\[235\]\[3\]
+ sky130_fd_sc_hd__edfxtp_1
Xnetwork.in_period\[236\]\[0\]$_DFFE_PP_ clknet_leaf_251_clk
+ net456 _03239_ VSS VSS VDD VDD network.in_period\[236\]\[0\]
+ sky130_fd_sc_hd__edfxtp_1
Xnetwork.in_period\[236\]\[1\]$_DFFE_PP_ clknet_leaf_251_clk
+ net449 _03239_ VSS VSS VDD VDD network.in_period\[236\]\[1\]
+ sky130_fd_sc_hd__edfxtp_1
Xnetwork.in_period\[236\]\[2\]$_DFFE_PP_ clknet_leaf_251_clk
+ net440 _03239_ VSS VSS VDD VDD network.in_period\[236\]\[2\]
+ sky130_fd_sc_hd__edfxtp_1
Xnetwork.in_period\[236\]\[3\]$_DFFE_PP_ clknet_leaf_251_clk
+ net437 _03239_ VSS VSS VDD VDD network.in_period\[236\]\[3\]
+ sky130_fd_sc_hd__edfxtp_1
Xnetwork.in_period\[237\]\[0\]$_DFFE_PP_ clknet_leaf_245_clk
+ net456 _03240_ VSS VSS VDD VDD network.in_period\[237\]\[0\]
+ sky130_fd_sc_hd__edfxtp_1
Xnetwork.in_period\[237\]\[1\]$_DFFE_PP_ clknet_leaf_245_clk
+ net449 _03240_ VSS VSS VDD VDD network.in_period\[237\]\[1\]
+ sky130_fd_sc_hd__edfxtp_1
Xnetwork.in_period\[237\]\[2\]$_DFFE_PP_ clknet_leaf_246_clk
+ net440 _03240_ VSS VSS VDD VDD network.in_period\[237\]\[2\]
+ sky130_fd_sc_hd__edfxtp_1
Xnetwork.in_period\[237\]\[3\]$_DFFE_PP_ clknet_leaf_245_clk
+ net437 _03240_ VSS VSS VDD VDD network.in_period\[237\]\[3\]
+ sky130_fd_sc_hd__edfxtp_1
Xnetwork.in_period\[238\]\[0\]$_DFFE_PP_ clknet_leaf_246_clk
+ net456 _03241_ VSS VSS VDD VDD network.in_period\[238\]\[0\]
+ sky130_fd_sc_hd__edfxtp_1
Xnetwork.in_period\[238\]\[1\]$_DFFE_PP_ clknet_leaf_251_clk
+ net449 _03241_ VSS VSS VDD VDD network.in_period\[238\]\[1\]
+ sky130_fd_sc_hd__edfxtp_1
Xnetwork.in_period\[238\]\[2\]$_DFFE_PP_ clknet_leaf_251_clk
+ net440 _03241_ VSS VSS VDD VDD network.in_period\[238\]\[2\]
+ sky130_fd_sc_hd__edfxtp_1
Xnetwork.in_period\[238\]\[3\]$_DFFE_PP_ clknet_leaf_251_clk
+ net437 _03241_ VSS VSS VDD VDD network.in_period\[238\]\[3\]
+ sky130_fd_sc_hd__edfxtp_1
Xnetwork.in_period\[239\]\[0\]$_DFFE_PP_ clknet_leaf_257_clk
+ net456 _03242_ VSS VSS VDD VDD network.in_period\[239\]\[0\]
+ sky130_fd_sc_hd__edfxtp_1
Xnetwork.in_period\[239\]\[1\]$_DFFE_PP_ clknet_leaf_257_clk
+ net449 _03242_ VSS VSS VDD VDD network.in_period\[239\]\[1\]
+ sky130_fd_sc_hd__edfxtp_1
Xnetwork.in_period\[239\]\[2\]$_DFFE_PP_ clknet_leaf_257_clk
+ net443 _03242_ VSS VSS VDD VDD network.in_period\[239\]\[2\]
+ sky130_fd_sc_hd__edfxtp_1
Xnetwork.in_period\[239\]\[3\]$_DFFE_PP_ clknet_leaf_257_clk
+ net437 _03242_ VSS VSS VDD VDD network.in_period\[239\]\[3\]
+ sky130_fd_sc_hd__edfxtp_1
Xnetwork.in_period\[23\]\[0\]$_DFFE_PP_ clknet_leaf_264_clk
+ net456 _03243_ VSS VSS VDD VDD network.in_period\[23\]\[0\]
+ sky130_fd_sc_hd__edfxtp_1
Xnetwork.in_period\[23\]\[1\]$_DFFE_PP_ clknet_leaf_264_clk
+ net449 _03243_ VSS VSS VDD VDD network.in_period\[23\]\[1\]
+ sky130_fd_sc_hd__edfxtp_1
Xnetwork.in_period\[23\]\[2\]$_DFFE_PP_ clknet_leaf_264_clk
+ net443 _03243_ VSS VSS VDD VDD network.in_period\[23\]\[2\]
+ sky130_fd_sc_hd__edfxtp_1
Xnetwork.in_period\[23\]\[3\]$_DFFE_PP_ clknet_leaf_264_clk
+ net437 _03243_ VSS VSS VDD VDD network.in_period\[23\]\[3\]
+ sky130_fd_sc_hd__edfxtp_1
Xnetwork.in_period\[240\]\[0\]$_DFFE_PP_ clknet_leaf_83_clk
+ net452 _03244_ VSS VSS VDD VDD network.in_period\[240\]\[0\]
+ sky130_fd_sc_hd__edfxtp_1
Xnetwork.in_period\[240\]\[1\]$_DFFE_PP_ clknet_leaf_83_clk
+ net445 _03244_ VSS VSS VDD VDD network.in_period\[240\]\[1\]
+ sky130_fd_sc_hd__edfxtp_1
Xnetwork.in_period\[240\]\[2\]$_DFFE_PP_ clknet_leaf_83_clk
+ net442 _03244_ VSS VSS VDD VDD network.in_period\[240\]\[2\]
+ sky130_fd_sc_hd__edfxtp_1
Xnetwork.in_period\[240\]\[3\]$_DFFE_PP_ clknet_leaf_83_clk
+ net432 _03244_ VSS VSS VDD VDD network.in_period\[240\]\[3\]
+ sky130_fd_sc_hd__edfxtp_1
Xnetwork.in_period\[241\]\[0\]$_DFFE_PP_ clknet_leaf_82_clk
+ net452 _03245_ VSS VSS VDD VDD network.in_period\[241\]\[0\]
+ sky130_fd_sc_hd__edfxtp_1
Xnetwork.in_period\[241\]\[1\]$_DFFE_PP_ clknet_leaf_81_clk
+ net445 _03245_ VSS VSS VDD VDD network.in_period\[241\]\[1\]
+ sky130_fd_sc_hd__edfxtp_1
Xnetwork.in_period\[241\]\[2\]$_DFFE_PP_ clknet_leaf_81_clk
+ net439 _03245_ VSS VSS VDD VDD network.in_period\[241\]\[2\]
+ sky130_fd_sc_hd__edfxtp_1
Xnetwork.in_period\[241\]\[3\]$_DFFE_PP_ clknet_leaf_81_clk
+ net432 _03245_ VSS VSS VDD VDD network.in_period\[241\]\[3\]
+ sky130_fd_sc_hd__edfxtp_1
Xnetwork.in_period\[242\]\[0\]$_DFFE_PP_ clknet_leaf_86_clk
+ net452 _03246_ VSS VSS VDD VDD network.in_period\[242\]\[0\]
+ sky130_fd_sc_hd__edfxtp_1
Xnetwork.in_period\[242\]\[1\]$_DFFE_PP_ clknet_leaf_86_clk
+ net445 _03246_ VSS VSS VDD VDD network.in_period\[242\]\[1\]
+ sky130_fd_sc_hd__edfxtp_1
Xnetwork.in_period\[242\]\[2\]$_DFFE_PP_ clknet_leaf_85_clk
+ net439 _03246_ VSS VSS VDD VDD network.in_period\[242\]\[2\]
+ sky130_fd_sc_hd__edfxtp_1
Xnetwork.in_period\[242\]\[3\]$_DFFE_PP_ clknet_leaf_85_clk
+ net432 _03246_ VSS VSS VDD VDD network.in_period\[242\]\[3\]
+ sky130_fd_sc_hd__edfxtp_1
Xnetwork.in_period\[243\]\[0\]$_DFFE_PP_ clknet_leaf_80_clk
+ net452 _03247_ VSS VSS VDD VDD network.in_period\[243\]\[0\]
+ sky130_fd_sc_hd__edfxtp_1
Xnetwork.in_period\[243\]\[1\]$_DFFE_PP_ clknet_leaf_80_clk
+ net445 _03247_ VSS VSS VDD VDD network.in_period\[243\]\[1\]
+ sky130_fd_sc_hd__edfxtp_1
Xnetwork.in_period\[243\]\[2\]$_DFFE_PP_ clknet_leaf_81_clk
+ net439 _03247_ VSS VSS VDD VDD network.in_period\[243\]\[2\]
+ sky130_fd_sc_hd__edfxtp_1
Xnetwork.in_period\[243\]\[3\]$_DFFE_PP_ clknet_leaf_81_clk
+ net432 _03247_ VSS VSS VDD VDD network.in_period\[243\]\[3\]
+ sky130_fd_sc_hd__edfxtp_1
Xnetwork.in_period\[244\]\[0\]$_DFFE_PP_ clknet_leaf_81_clk
+ net452 _03248_ VSS VSS VDD VDD network.in_period\[244\]\[0\]
+ sky130_fd_sc_hd__edfxtp_1
Xnetwork.in_period\[244\]\[1\]$_DFFE_PP_ clknet_leaf_82_clk
+ net445 _03248_ VSS VSS VDD VDD network.in_period\[244\]\[1\]
+ sky130_fd_sc_hd__edfxtp_1
Xnetwork.in_period\[244\]\[2\]$_DFFE_PP_ clknet_leaf_82_clk
+ net439 _03248_ VSS VSS VDD VDD network.in_period\[244\]\[2\]
+ sky130_fd_sc_hd__edfxtp_1
Xnetwork.in_period\[244\]\[3\]$_DFFE_PP_ clknet_leaf_82_clk
+ net432 _03248_ VSS VSS VDD VDD network.in_period\[244\]\[3\]
+ sky130_fd_sc_hd__edfxtp_1
Xnetwork.in_period\[245\]\[0\]$_DFFE_PP_ clknet_leaf_84_clk
+ net452 _03249_ VSS VSS VDD VDD network.in_period\[245\]\[0\]
+ sky130_fd_sc_hd__edfxtp_1
Xnetwork.in_period\[245\]\[1\]$_DFFE_PP_ clknet_leaf_85_clk
+ net445 _03249_ VSS VSS VDD VDD network.in_period\[245\]\[1\]
+ sky130_fd_sc_hd__edfxtp_1
Xnetwork.in_period\[245\]\[2\]$_DFFE_PP_ clknet_leaf_84_clk
+ net439 _03249_ VSS VSS VDD VDD network.in_period\[245\]\[2\]
+ sky130_fd_sc_hd__edfxtp_1
Xnetwork.in_period\[245\]\[3\]$_DFFE_PP_ clknet_leaf_84_clk
+ net432 _03249_ VSS VSS VDD VDD network.in_period\[245\]\[3\]
+ sky130_fd_sc_hd__edfxtp_1
Xnetwork.in_period\[246\]\[0\]$_DFFE_PP_ clknet_leaf_86_clk
+ net452 _03250_ VSS VSS VDD VDD network.in_period\[246\]\[0\]
+ sky130_fd_sc_hd__edfxtp_1
Xnetwork.in_period\[246\]\[1\]$_DFFE_PP_ clknet_leaf_86_clk
+ net445 _03250_ VSS VSS VDD VDD network.in_period\[246\]\[1\]
+ sky130_fd_sc_hd__edfxtp_1
Xnetwork.in_period\[246\]\[2\]$_DFFE_PP_ clknet_leaf_86_clk
+ net439 _03250_ VSS VSS VDD VDD network.in_period\[246\]\[2\]
+ sky130_fd_sc_hd__edfxtp_1
Xnetwork.in_period\[246\]\[3\]$_DFFE_PP_ clknet_leaf_79_clk
+ net432 _03250_ VSS VSS VDD VDD network.in_period\[246\]\[3\]
+ sky130_fd_sc_hd__edfxtp_1
Xnetwork.in_period\[247\]\[0\]$_DFFE_PP_ clknet_leaf_78_clk
+ net452 _03251_ VSS VSS VDD VDD network.in_period\[247\]\[0\]
+ sky130_fd_sc_hd__edfxtp_1
Xnetwork.in_period\[247\]\[1\]$_DFFE_PP_ clknet_leaf_78_clk
+ net445 _03251_ VSS VSS VDD VDD network.in_period\[247\]\[1\]
+ sky130_fd_sc_hd__edfxtp_1
Xnetwork.in_period\[247\]\[2\]$_DFFE_PP_ clknet_leaf_78_clk
+ net439 _03251_ VSS VSS VDD VDD network.in_period\[247\]\[2\]
+ sky130_fd_sc_hd__edfxtp_1
Xnetwork.in_period\[247\]\[3\]$_DFFE_PP_ clknet_leaf_78_clk
+ net432 _03251_ VSS VSS VDD VDD network.in_period\[247\]\[3\]
+ sky130_fd_sc_hd__edfxtp_1
Xnetwork.in_period\[248\]\[0\]$_DFFE_PP_ clknet_leaf_87_clk
+ net452 _03252_ VSS VSS VDD VDD network.in_period\[248\]\[0\]
+ sky130_fd_sc_hd__edfxtp_1
Xnetwork.in_period\[248\]\[1\]$_DFFE_PP_ clknet_leaf_86_clk
+ net445 _03252_ VSS VSS VDD VDD network.in_period\[248\]\[1\]
+ sky130_fd_sc_hd__edfxtp_1
Xnetwork.in_period\[248\]\[2\]$_DFFE_PP_ clknet_leaf_86_clk
+ net439 _03252_ VSS VSS VDD VDD network.in_period\[248\]\[2\]
+ sky130_fd_sc_hd__edfxtp_1
Xnetwork.in_period\[248\]\[3\]$_DFFE_PP_ clknet_leaf_86_clk
+ net432 _03252_ VSS VSS VDD VDD network.in_period\[248\]\[3\]
+ sky130_fd_sc_hd__edfxtp_1
Xnetwork.in_period\[249\]\[0\]$_DFFE_PP_ clknet_leaf_90_clk
+ net452 _03253_ VSS VSS VDD VDD network.in_period\[249\]\[0\]
+ sky130_fd_sc_hd__edfxtp_1
Xnetwork.in_period\[249\]\[1\]$_DFFE_PP_ clknet_leaf_90_clk
+ net445 _03253_ VSS VSS VDD VDD network.in_period\[249\]\[1\]
+ sky130_fd_sc_hd__edfxtp_1
Xnetwork.in_period\[249\]\[2\]$_DFFE_PP_ clknet_leaf_90_clk
+ net439 _03253_ VSS VSS VDD VDD network.in_period\[249\]\[2\]
+ sky130_fd_sc_hd__edfxtp_1
Xnetwork.in_period\[249\]\[3\]$_DFFE_PP_ clknet_leaf_90_clk
+ net432 _03253_ VSS VSS VDD VDD network.in_period\[249\]\[3\]
+ sky130_fd_sc_hd__edfxtp_1
Xnetwork.in_period\[24\]\[0\]$_DFFE_PP_ clknet_leaf_261_clk
+ net456 _03254_ VSS VSS VDD VDD network.in_period\[24\]\[0\]
+ sky130_fd_sc_hd__edfxtp_1
Xnetwork.in_period\[24\]\[1\]$_DFFE_PP_ clknet_leaf_261_clk
+ net449 _03254_ VSS VSS VDD VDD network.in_period\[24\]\[1\]
+ sky130_fd_sc_hd__edfxtp_1
Xnetwork.in_period\[24\]\[2\]$_DFFE_PP_ clknet_leaf_261_clk
+ net443 _03254_ VSS VSS VDD VDD network.in_period\[24\]\[2\]
+ sky130_fd_sc_hd__edfxtp_1
Xnetwork.in_period\[24\]\[3\]$_DFFE_PP_ clknet_leaf_261_clk
+ net437 _03254_ VSS VSS VDD VDD network.in_period\[24\]\[3\]
+ sky130_fd_sc_hd__edfxtp_1
Xnetwork.in_period\[250\]\[0\]$_DFFE_PP_ clknet_leaf_88_clk
+ net452 _03255_ VSS VSS VDD VDD network.in_period\[250\]\[0\]
+ sky130_fd_sc_hd__edfxtp_1
Xnetwork.in_period\[250\]\[1\]$_DFFE_PP_ clknet_leaf_88_clk
+ net445 _03255_ VSS VSS VDD VDD network.in_period\[250\]\[1\]
+ sky130_fd_sc_hd__edfxtp_1
Xnetwork.in_period\[250\]\[2\]$_DFFE_PP_ clknet_leaf_88_clk
+ net439 _03255_ VSS VSS VDD VDD network.in_period\[250\]\[2\]
+ sky130_fd_sc_hd__edfxtp_1
Xnetwork.in_period\[250\]\[3\]$_DFFE_PP_ clknet_leaf_88_clk
+ net432 _03255_ VSS VSS VDD VDD network.in_period\[250\]\[3\]
+ sky130_fd_sc_hd__edfxtp_1
Xnetwork.in_period\[251\]\[0\]$_DFFE_PP_ clknet_leaf_48_clk
+ net452 _03256_ VSS VSS VDD VDD network.in_period\[251\]\[0\]
+ sky130_fd_sc_hd__edfxtp_1
Xnetwork.in_period\[251\]\[1\]$_DFFE_PP_ clknet_leaf_90_clk
+ net445 _03256_ VSS VSS VDD VDD network.in_period\[251\]\[1\]
+ sky130_fd_sc_hd__edfxtp_1
Xnetwork.in_period\[251\]\[2\]$_DFFE_PP_ clknet_leaf_89_clk
+ net439 _03256_ VSS VSS VDD VDD network.in_period\[251\]\[2\]
+ sky130_fd_sc_hd__edfxtp_1
Xnetwork.in_period\[251\]\[3\]$_DFFE_PP_ clknet_leaf_90_clk
+ net432 _03256_ VSS VSS VDD VDD network.in_period\[251\]\[3\]
+ sky130_fd_sc_hd__edfxtp_1
Xnetwork.in_period\[252\]\[0\]$_DFFE_PP_ clknet_leaf_87_clk
+ net452 _03257_ VSS VSS VDD VDD network.in_period\[252\]\[0\]
+ sky130_fd_sc_hd__edfxtp_1
Xnetwork.in_period\[252\]\[1\]$_DFFE_PP_ clknet_leaf_87_clk
+ net445 _03257_ VSS VSS VDD VDD network.in_period\[252\]\[1\]
+ sky130_fd_sc_hd__edfxtp_1
Xnetwork.in_period\[252\]\[2\]$_DFFE_PP_ clknet_leaf_87_clk
+ net439 _03257_ VSS VSS VDD VDD network.in_period\[252\]\[2\]
+ sky130_fd_sc_hd__edfxtp_1
Xnetwork.in_period\[252\]\[3\]$_DFFE_PP_ clknet_leaf_88_clk
+ net432 _03257_ VSS VSS VDD VDD network.in_period\[252\]\[3\]
+ sky130_fd_sc_hd__edfxtp_1
Xnetwork.in_period\[253\]\[0\]$_DFFE_PP_ clknet_leaf_91_clk
+ net452 _03258_ VSS VSS VDD VDD network.in_period\[253\]\[0\]
+ sky130_fd_sc_hd__edfxtp_1
Xnetwork.in_period\[253\]\[1\]$_DFFE_PP_ clknet_leaf_91_clk
+ net445 _03258_ VSS VSS VDD VDD network.in_period\[253\]\[1\]
+ sky130_fd_sc_hd__edfxtp_1
Xnetwork.in_period\[253\]\[2\]$_DFFE_PP_ clknet_leaf_90_clk
+ net439 _03258_ VSS VSS VDD VDD network.in_period\[253\]\[2\]
+ sky130_fd_sc_hd__edfxtp_1
Xnetwork.in_period\[253\]\[3\]$_DFFE_PP_ clknet_leaf_91_clk
+ net432 _03258_ VSS VSS VDD VDD network.in_period\[253\]\[3\]
+ sky130_fd_sc_hd__edfxtp_1
Xnetwork.in_period\[254\]\[0\]$_DFFE_PP_ clknet_leaf_89_clk
+ net452 _03259_ VSS VSS VDD VDD network.in_period\[254\]\[0\]
+ sky130_fd_sc_hd__edfxtp_1
Xnetwork.in_period\[254\]\[1\]$_DFFE_PP_ clknet_leaf_88_clk
+ net445 _03259_ VSS VSS VDD VDD network.in_period\[254\]\[1\]
+ sky130_fd_sc_hd__edfxtp_1
Xnetwork.in_period\[254\]\[2\]$_DFFE_PP_ clknet_leaf_89_clk
+ net439 _03259_ VSS VSS VDD VDD network.in_period\[254\]\[2\]
+ sky130_fd_sc_hd__edfxtp_1
Xnetwork.in_period\[254\]\[3\]$_DFFE_PP_ clknet_leaf_89_clk
+ net432 _03259_ VSS VSS VDD VDD network.in_period\[254\]\[3\]
+ sky130_fd_sc_hd__edfxtp_1
Xnetwork.in_period\[255\]\[0\]$_DFFE_PP_ clknet_leaf_92_clk
+ net452 _03260_ VSS VSS VDD VDD network.in_period\[255\]\[0\]
+ sky130_fd_sc_hd__edfxtp_1
Xnetwork.in_period\[255\]\[1\]$_DFFE_PP_ clknet_leaf_92_clk
+ net445 _03260_ VSS VSS VDD VDD network.in_period\[255\]\[1\]
+ sky130_fd_sc_hd__edfxtp_1
Xnetwork.in_period\[255\]\[2\]$_DFFE_PP_ clknet_leaf_93_clk
+ net439 _03260_ VSS VSS VDD VDD network.in_period\[255\]\[2\]
+ sky130_fd_sc_hd__edfxtp_1
Xnetwork.in_period\[255\]\[3\]$_DFFE_PP_ clknet_leaf_92_clk
+ net432 _03260_ VSS VSS VDD VDD network.in_period\[255\]\[3\]
+ sky130_fd_sc_hd__edfxtp_1
Xnetwork.in_period\[25\]\[0\]$_DFFE_PP_ clknet_leaf_268_clk
+ net458 _03261_ VSS VSS VDD VDD network.in_period\[25\]\[0\]
+ sky130_fd_sc_hd__edfxtp_1
Xnetwork.in_period\[25\]\[1\]$_DFFE_PP_ clknet_leaf_267_clk
+ net450 _03261_ VSS VSS VDD VDD network.in_period\[25\]\[1\]
+ sky130_fd_sc_hd__edfxtp_1
Xnetwork.in_period\[25\]\[2\]$_DFFE_PP_ clknet_leaf_267_clk
+ net443 _03261_ VSS VSS VDD VDD network.in_period\[25\]\[2\]
+ sky130_fd_sc_hd__edfxtp_1
Xnetwork.in_period\[25\]\[3\]$_DFFE_PP_ clknet_leaf_268_clk
+ net434 _03261_ VSS VSS VDD VDD network.in_period\[25\]\[3\]
+ sky130_fd_sc_hd__edfxtp_1
Xnetwork.in_period\[26\]\[0\]$_DFFE_PP_ clknet_leaf_266_clk
+ net457 _03262_ VSS VSS VDD VDD network.in_period\[26\]\[0\]
+ sky130_fd_sc_hd__edfxtp_1
Xnetwork.in_period\[26\]\[1\]$_DFFE_PP_ clknet_leaf_266_clk
+ net449 _03262_ VSS VSS VDD VDD network.in_period\[26\]\[1\]
+ sky130_fd_sc_hd__edfxtp_1
Xnetwork.in_period\[26\]\[2\]$_DFFE_PP_ clknet_leaf_266_clk
+ net443 _03262_ VSS VSS VDD VDD network.in_period\[26\]\[2\]
+ sky130_fd_sc_hd__edfxtp_1
Xnetwork.in_period\[26\]\[3\]$_DFFE_PP_ clknet_leaf_266_clk
+ net437 _03262_ VSS VSS VDD VDD network.in_period\[26\]\[3\]
+ sky130_fd_sc_hd__edfxtp_1
Xnetwork.in_period\[27\]\[0\]$_DFFE_PP_ clknet_leaf_260_clk
+ net458 _03263_ VSS VSS VDD VDD network.in_period\[27\]\[0\]
+ sky130_fd_sc_hd__edfxtp_1
Xnetwork.in_period\[27\]\[1\]$_DFFE_PP_ clknet_leaf_260_clk
+ net450 _03263_ VSS VSS VDD VDD network.in_period\[27\]\[1\]
+ sky130_fd_sc_hd__edfxtp_1
Xnetwork.in_period\[27\]\[2\]$_DFFE_PP_ clknet_leaf_261_clk
+ net443 _03263_ VSS VSS VDD VDD network.in_period\[27\]\[2\]
+ sky130_fd_sc_hd__edfxtp_1
Xnetwork.in_period\[27\]\[3\]$_DFFE_PP_ clknet_leaf_260_clk
+ net437 _03263_ VSS VSS VDD VDD network.in_period\[27\]\[3\]
+ sky130_fd_sc_hd__edfxtp_1
Xnetwork.in_period\[28\]\[0\]$_DFFE_PP_ clknet_leaf_269_clk
+ net458 _03264_ VSS VSS VDD VDD network.in_period\[28\]\[0\]
+ sky130_fd_sc_hd__edfxtp_1
Xnetwork.in_period\[28\]\[1\]$_DFFE_PP_ clknet_leaf_269_clk
+ net450 _03264_ VSS VSS VDD VDD network.in_period\[28\]\[1\]
+ sky130_fd_sc_hd__edfxtp_1
Xnetwork.in_period\[28\]\[2\]$_DFFE_PP_ clknet_leaf_269_clk
+ net443 _03264_ VSS VSS VDD VDD network.in_period\[28\]\[2\]
+ sky130_fd_sc_hd__edfxtp_1
Xnetwork.in_period\[28\]\[3\]$_DFFE_PP_ clknet_leaf_268_clk
+ net434 _03264_ VSS VSS VDD VDD network.in_period\[28\]\[3\]
+ sky130_fd_sc_hd__edfxtp_1
Xnetwork.in_period\[29\]\[0\]$_DFFE_PP_ clknet_leaf_258_clk
+ net458 _03265_ VSS VSS VDD VDD network.in_period\[29\]\[0\]
+ sky130_fd_sc_hd__edfxtp_1
Xnetwork.in_period\[29\]\[1\]$_DFFE_PP_ clknet_leaf_258_clk
+ net450 _03265_ VSS VSS VDD VDD network.in_period\[29\]\[1\]
+ sky130_fd_sc_hd__edfxtp_1
Xnetwork.in_period\[29\]\[2\]$_DFFE_PP_ clknet_leaf_257_clk
+ net443 _03265_ VSS VSS VDD VDD network.in_period\[29\]\[2\]
+ sky130_fd_sc_hd__edfxtp_1
Xnetwork.in_period\[29\]\[3\]$_DFFE_PP_ clknet_leaf_257_clk
+ net434 _03265_ VSS VSS VDD VDD network.in_period\[29\]\[3\]
+ sky130_fd_sc_hd__edfxtp_1
Xnetwork.in_period\[2\]\[0\]$_DFFE_PP_ clknet_leaf_65_clk
+ net453 _03266_ VSS VSS VDD VDD network.in_period\[2\]\[0\]
+ sky130_fd_sc_hd__edfxtp_1
Xnetwork.in_period\[2\]\[1\]$_DFFE_PP_ clknet_leaf_65_clk
+ net446 _03266_ VSS VSS VDD VDD network.in_period\[2\]\[1\]
+ sky130_fd_sc_hd__edfxtp_1
Xnetwork.in_period\[2\]\[2\]$_DFFE_PP_ clknet_leaf_65_clk
+ net438 _03266_ VSS VSS VDD VDD network.in_period\[2\]\[2\]
+ sky130_fd_sc_hd__edfxtp_1
Xnetwork.in_period\[2\]\[3\]$_DFFE_PP_ clknet_leaf_65_clk
+ net431 _03266_ VSS VSS VDD VDD network.in_period\[2\]\[3\]
+ sky130_fd_sc_hd__edfxtp_1
Xnetwork.in_period\[30\]\[0\]$_DFFE_PP_ clknet_leaf_258_clk
+ net458 _03267_ VSS VSS VDD VDD network.in_period\[30\]\[0\]
+ sky130_fd_sc_hd__edfxtp_1
Xnetwork.in_period\[30\]\[1\]$_DFFE_PP_ clknet_leaf_258_clk
+ net450 _03267_ VSS VSS VDD VDD network.in_period\[30\]\[1\]
+ sky130_fd_sc_hd__edfxtp_1
Xnetwork.in_period\[30\]\[2\]$_DFFE_PP_ clknet_leaf_259_clk
+ net443 _03267_ VSS VSS VDD VDD network.in_period\[30\]\[2\]
+ sky130_fd_sc_hd__edfxtp_1
Xnetwork.in_period\[30\]\[3\]$_DFFE_PP_ clknet_leaf_259_clk
+ net434 _03267_ VSS VSS VDD VDD network.in_period\[30\]\[3\]
+ sky130_fd_sc_hd__edfxtp_1
Xnetwork.in_period\[31\]\[0\]$_DFFE_PP_ clknet_leaf_268_clk
+ net458 _03268_ VSS VSS VDD VDD network.in_period\[31\]\[0\]
+ sky130_fd_sc_hd__edfxtp_1
Xnetwork.in_period\[31\]\[1\]$_DFFE_PP_ clknet_leaf_268_clk
+ net450 _03268_ VSS VSS VDD VDD network.in_period\[31\]\[1\]
+ sky130_fd_sc_hd__edfxtp_1
Xnetwork.in_period\[31\]\[2\]$_DFFE_PP_ clknet_leaf_268_clk
+ net443 _03268_ VSS VSS VDD VDD network.in_period\[31\]\[2\]
+ sky130_fd_sc_hd__edfxtp_1
Xnetwork.in_period\[31\]\[3\]$_DFFE_PP_ clknet_leaf_268_clk
+ net434 _03268_ VSS VSS VDD VDD network.in_period\[31\]\[3\]
+ sky130_fd_sc_hd__edfxtp_1
Xnetwork.in_period\[32\]\[0\]$_DFFE_PP_ clknet_leaf_43_clk
+ net452 _03269_ VSS VSS VDD VDD network.in_period\[32\]\[0\]
+ sky130_fd_sc_hd__edfxtp_1
Xnetwork.in_period\[32\]\[1\]$_DFFE_PP_ clknet_leaf_43_clk
+ net445 _03269_ VSS VSS VDD VDD network.in_period\[32\]\[1\]
+ sky130_fd_sc_hd__edfxtp_1
Xnetwork.in_period\[32\]\[2\]$_DFFE_PP_ clknet_leaf_44_clk
+ net439 _03269_ VSS VSS VDD VDD network.in_period\[32\]\[2\]
+ sky130_fd_sc_hd__edfxtp_1
Xnetwork.in_period\[32\]\[3\]$_DFFE_PP_ clknet_leaf_44_clk
+ net432 _03269_ VSS VSS VDD VDD network.in_period\[32\]\[3\]
+ sky130_fd_sc_hd__edfxtp_1
Xnetwork.in_period\[33\]\[0\]$_DFFE_PP_ clknet_leaf_99_clk
+ net454 _03270_ VSS VSS VDD VDD network.in_period\[33\]\[0\]
+ sky130_fd_sc_hd__edfxtp_1
Xnetwork.in_period\[33\]\[1\]$_DFFE_PP_ clknet_leaf_99_clk
+ net451 _03270_ VSS VSS VDD VDD network.in_period\[33\]\[1\]
+ sky130_fd_sc_hd__edfxtp_1
Xnetwork.in_period\[33\]\[2\]$_DFFE_PP_ clknet_leaf_98_clk
+ net442 _03270_ VSS VSS VDD VDD network.in_period\[33\]\[2\]
+ sky130_fd_sc_hd__edfxtp_1
Xnetwork.in_period\[33\]\[3\]$_DFFE_PP_ clknet_leaf_99_clk
+ net436 _03270_ VSS VSS VDD VDD network.in_period\[33\]\[3\]
+ sky130_fd_sc_hd__edfxtp_1
Xnetwork.in_period\[34\]\[0\]$_DFFE_PP_ clknet_leaf_45_clk
+ net452 _03271_ VSS VSS VDD VDD network.in_period\[34\]\[0\]
+ sky130_fd_sc_hd__edfxtp_1
Xnetwork.in_period\[34\]\[1\]$_DFFE_PP_ clknet_leaf_45_clk
+ net445 _03271_ VSS VSS VDD VDD network.in_period\[34\]\[1\]
+ sky130_fd_sc_hd__edfxtp_1
Xnetwork.in_period\[34\]\[2\]$_DFFE_PP_ clknet_leaf_45_clk
+ net439 _03271_ VSS VSS VDD VDD network.in_period\[34\]\[2\]
+ sky130_fd_sc_hd__edfxtp_1
Xnetwork.in_period\[34\]\[3\]$_DFFE_PP_ clknet_leaf_45_clk
+ net432 _03271_ VSS VSS VDD VDD network.in_period\[34\]\[3\]
+ sky130_fd_sc_hd__edfxtp_1
Xnetwork.in_period\[35\]\[0\]$_DFFE_PP_ clknet_leaf_46_clk
+ net452 _03272_ VSS VSS VDD VDD network.in_period\[35\]\[0\]
+ sky130_fd_sc_hd__edfxtp_1
Xnetwork.in_period\[35\]\[1\]$_DFFE_PP_ clknet_leaf_46_clk
+ net445 _03272_ VSS VSS VDD VDD network.in_period\[35\]\[1\]
+ sky130_fd_sc_hd__edfxtp_1
Xnetwork.in_period\[35\]\[2\]$_DFFE_PP_ clknet_leaf_46_clk
+ net439 _03272_ VSS VSS VDD VDD network.in_period\[35\]\[2\]
+ sky130_fd_sc_hd__edfxtp_1
Xnetwork.in_period\[35\]\[3\]$_DFFE_PP_ clknet_leaf_46_clk
+ net432 _03272_ VSS VSS VDD VDD network.in_period\[35\]\[3\]
+ sky130_fd_sc_hd__edfxtp_1
Xnetwork.in_period\[36\]\[0\]$_DFFE_PP_ clknet_leaf_91_clk
+ net452 _03273_ VSS VSS VDD VDD network.in_period\[36\]\[0\]
+ sky130_fd_sc_hd__edfxtp_1
Xnetwork.in_period\[36\]\[1\]$_DFFE_PP_ clknet_leaf_91_clk
+ net445 _03273_ VSS VSS VDD VDD network.in_period\[36\]\[1\]
+ sky130_fd_sc_hd__edfxtp_1
Xnetwork.in_period\[36\]\[2\]$_DFFE_PP_ clknet_leaf_46_clk
+ net439 _03273_ VSS VSS VDD VDD network.in_period\[36\]\[2\]
+ sky130_fd_sc_hd__edfxtp_1
Xnetwork.in_period\[36\]\[3\]$_DFFE_PP_ clknet_leaf_92_clk
+ net432 _03273_ VSS VSS VDD VDD network.in_period\[36\]\[3\]
+ sky130_fd_sc_hd__edfxtp_1
Xnetwork.in_period\[37\]\[0\]$_DFFE_PP_ clknet_leaf_97_clk
+ net452 _03274_ VSS VSS VDD VDD network.in_period\[37\]\[0\]
+ sky130_fd_sc_hd__edfxtp_1
Xnetwork.in_period\[37\]\[1\]$_DFFE_PP_ clknet_leaf_97_clk
+ net445 _03274_ VSS VSS VDD VDD network.in_period\[37\]\[1\]
+ sky130_fd_sc_hd__edfxtp_1
Xnetwork.in_period\[37\]\[2\]$_DFFE_PP_ clknet_leaf_97_clk
+ net439 _03274_ VSS VSS VDD VDD network.in_period\[37\]\[2\]
+ sky130_fd_sc_hd__edfxtp_1
Xnetwork.in_period\[37\]\[3\]$_DFFE_PP_ clknet_leaf_97_clk
+ net432 _03274_ VSS VSS VDD VDD network.in_period\[37\]\[3\]
+ sky130_fd_sc_hd__edfxtp_1
Xnetwork.in_period\[38\]\[0\]$_DFFE_PP_ clknet_leaf_40_clk
+ net452 _03275_ VSS VSS VDD VDD network.in_period\[38\]\[0\]
+ sky130_fd_sc_hd__edfxtp_1
Xnetwork.in_period\[38\]\[1\]$_DFFE_PP_ clknet_leaf_40_clk
+ net445 _03275_ VSS VSS VDD VDD network.in_period\[38\]\[1\]
+ sky130_fd_sc_hd__edfxtp_1
Xnetwork.in_period\[38\]\[2\]$_DFFE_PP_ clknet_leaf_40_clk
+ net439 _03275_ VSS VSS VDD VDD network.in_period\[38\]\[2\]
+ sky130_fd_sc_hd__edfxtp_1
Xnetwork.in_period\[38\]\[3\]$_DFFE_PP_ clknet_leaf_40_clk
+ net432 _03275_ VSS VSS VDD VDD network.in_period\[38\]\[3\]
+ sky130_fd_sc_hd__edfxtp_1
Xnetwork.in_period\[39\]\[0\]$_DFFE_PP_ clknet_leaf_42_clk
+ net454 _03276_ VSS VSS VDD VDD network.in_period\[39\]\[0\]
+ sky130_fd_sc_hd__edfxtp_1
Xnetwork.in_period\[39\]\[1\]$_DFFE_PP_ clknet_leaf_42_clk
+ net451 _03276_ VSS VSS VDD VDD network.in_period\[39\]\[1\]
+ sky130_fd_sc_hd__edfxtp_1
Xnetwork.in_period\[39\]\[2\]$_DFFE_PP_ clknet_leaf_42_clk
+ net439 _03276_ VSS VSS VDD VDD network.in_period\[39\]\[2\]
+ sky130_fd_sc_hd__edfxtp_1
Xnetwork.in_period\[39\]\[3\]$_DFFE_PP_ clknet_leaf_42_clk
+ net433 _03276_ VSS VSS VDD VDD network.in_period\[39\]\[3\]
+ sky130_fd_sc_hd__edfxtp_1
Xnetwork.in_period\[3\]\[0\]$_DFFE_PP_ clknet_leaf_63_clk
+ net453 _03277_ VSS VSS VDD VDD network.in_period\[3\]\[0\]
+ sky130_fd_sc_hd__edfxtp_1
Xnetwork.in_period\[3\]\[1\]$_DFFE_PP_ clknet_leaf_63_clk
+ net446 _03277_ VSS VSS VDD VDD network.in_period\[3\]\[1\]
+ sky130_fd_sc_hd__edfxtp_1
Xnetwork.in_period\[3\]\[2\]$_DFFE_PP_ clknet_leaf_64_clk
+ net438 _03277_ VSS VSS VDD VDD network.in_period\[3\]\[2\]
+ sky130_fd_sc_hd__edfxtp_1
Xnetwork.in_period\[3\]\[3\]$_DFFE_PP_ clknet_leaf_63_clk
+ net431 _03277_ VSS VSS VDD VDD network.in_period\[3\]\[3\]
+ sky130_fd_sc_hd__edfxtp_1
Xnetwork.in_period\[40\]\[0\]$_DFFE_PP_ clknet_leaf_41_clk
+ net452 _03278_ VSS VSS VDD VDD network.in_period\[40\]\[0\]
+ sky130_fd_sc_hd__edfxtp_1
Xnetwork.in_period\[40\]\[1\]$_DFFE_PP_ clknet_leaf_41_clk
+ net445 _03278_ VSS VSS VDD VDD network.in_period\[40\]\[1\]
+ sky130_fd_sc_hd__edfxtp_1
Xnetwork.in_period\[40\]\[2\]$_DFFE_PP_ clknet_leaf_41_clk
+ net439 _03278_ VSS VSS VDD VDD network.in_period\[40\]\[2\]
+ sky130_fd_sc_hd__edfxtp_1
Xnetwork.in_period\[40\]\[3\]$_DFFE_PP_ clknet_leaf_41_clk
+ net432 _03278_ VSS VSS VDD VDD network.in_period\[40\]\[3\]
+ sky130_fd_sc_hd__edfxtp_1
Xnetwork.in_period\[41\]\[0\]$_DFFE_PP_ clknet_leaf_39_clk
+ net454 _03279_ VSS VSS VDD VDD network.in_period\[41\]\[0\]
+ sky130_fd_sc_hd__edfxtp_1
Xnetwork.in_period\[41\]\[1\]$_DFFE_PP_ clknet_leaf_39_clk
+ net451 _03279_ VSS VSS VDD VDD network.in_period\[41\]\[1\]
+ sky130_fd_sc_hd__edfxtp_1
Xnetwork.in_period\[41\]\[2\]$_DFFE_PP_ clknet_leaf_38_clk
+ net442 _03279_ VSS VSS VDD VDD network.in_period\[41\]\[2\]
+ sky130_fd_sc_hd__edfxtp_1
Xnetwork.in_period\[41\]\[3\]$_DFFE_PP_ clknet_leaf_38_clk
+ net436 _03279_ VSS VSS VDD VDD network.in_period\[41\]\[3\]
+ sky130_fd_sc_hd__edfxtp_1
Xnetwork.in_period\[42\]\[0\]$_DFFE_PP_ clknet_leaf_45_clk
+ net452 _03280_ VSS VSS VDD VDD network.in_period\[42\]\[0\]
+ sky130_fd_sc_hd__edfxtp_1
Xnetwork.in_period\[42\]\[1\]$_DFFE_PP_ clknet_leaf_44_clk
+ net445 _03280_ VSS VSS VDD VDD network.in_period\[42\]\[1\]
+ sky130_fd_sc_hd__edfxtp_1
Xnetwork.in_period\[42\]\[2\]$_DFFE_PP_ clknet_leaf_44_clk
+ net439 _03280_ VSS VSS VDD VDD network.in_period\[42\]\[2\]
+ sky130_fd_sc_hd__edfxtp_1
Xnetwork.in_period\[42\]\[3\]$_DFFE_PP_ clknet_leaf_44_clk
+ net432 _03280_ VSS VSS VDD VDD network.in_period\[42\]\[3\]
+ sky130_fd_sc_hd__edfxtp_1
Xnetwork.in_period\[43\]\[0\]$_DFFE_PP_ clknet_leaf_97_clk
+ net452 _03281_ VSS VSS VDD VDD network.in_period\[43\]\[0\]
+ sky130_fd_sc_hd__edfxtp_1
Xnetwork.in_period\[43\]\[1\]$_DFFE_PP_ clknet_leaf_97_clk
+ net445 _03281_ VSS VSS VDD VDD network.in_period\[43\]\[1\]
+ sky130_fd_sc_hd__edfxtp_1
Xnetwork.in_period\[43\]\[2\]$_DFFE_PP_ clknet_leaf_97_clk
+ net439 _03281_ VSS VSS VDD VDD network.in_period\[43\]\[2\]
+ sky130_fd_sc_hd__edfxtp_1
Xnetwork.in_period\[43\]\[3\]$_DFFE_PP_ clknet_leaf_97_clk
+ net432 _03281_ VSS VSS VDD VDD network.in_period\[43\]\[3\]
+ sky130_fd_sc_hd__edfxtp_1
Xnetwork.in_period\[44\]\[0\]$_DFFE_PP_ clknet_leaf_233_clk
+ net457 _03282_ VSS VSS VDD VDD network.in_period\[44\]\[0\]
+ sky130_fd_sc_hd__edfxtp_1
Xnetwork.in_period\[44\]\[1\]$_DFFE_PP_ clknet_leaf_233_clk
+ net447 _03282_ VSS VSS VDD VDD network.in_period\[44\]\[1\]
+ sky130_fd_sc_hd__edfxtp_1
Xnetwork.in_period\[44\]\[2\]$_DFFE_PP_ clknet_leaf_233_clk
+ net442 _03282_ VSS VSS VDD VDD network.in_period\[44\]\[2\]
+ sky130_fd_sc_hd__edfxtp_1
Xnetwork.in_period\[44\]\[3\]$_DFFE_PP_ clknet_leaf_234_clk
+ net436 _03282_ VSS VSS VDD VDD network.in_period\[44\]\[3\]
+ sky130_fd_sc_hd__edfxtp_1
Xnetwork.in_period\[45\]\[0\]$_DFFE_PP_ clknet_leaf_37_clk
+ net454 _03283_ VSS VSS VDD VDD network.in_period\[45\]\[0\]
+ sky130_fd_sc_hd__edfxtp_1
Xnetwork.in_period\[45\]\[1\]$_DFFE_PP_ clknet_leaf_37_clk
+ net451 _03283_ VSS VSS VDD VDD network.in_period\[45\]\[1\]
+ sky130_fd_sc_hd__edfxtp_1
Xnetwork.in_period\[45\]\[2\]$_DFFE_PP_ clknet_leaf_37_clk
+ net439 _03283_ VSS VSS VDD VDD network.in_period\[45\]\[2\]
+ sky130_fd_sc_hd__edfxtp_1
Xnetwork.in_period\[45\]\[3\]$_DFFE_PP_ clknet_leaf_37_clk
+ net433 _03283_ VSS VSS VDD VDD network.in_period\[45\]\[3\]
+ sky130_fd_sc_hd__edfxtp_1
Xnetwork.in_period\[46\]\[0\]$_DFFE_PP_ clknet_leaf_38_clk
+ net457 _03284_ VSS VSS VDD VDD network.in_period\[46\]\[0\]
+ sky130_fd_sc_hd__edfxtp_1
Xnetwork.in_period\[46\]\[1\]$_DFFE_PP_ clknet_leaf_38_clk
+ net447 _03284_ VSS VSS VDD VDD network.in_period\[46\]\[1\]
+ sky130_fd_sc_hd__edfxtp_1
Xnetwork.in_period\[46\]\[2\]$_DFFE_PP_ clknet_leaf_38_clk
+ net442 _03284_ VSS VSS VDD VDD network.in_period\[46\]\[2\]
+ sky130_fd_sc_hd__edfxtp_1
Xnetwork.in_period\[46\]\[3\]$_DFFE_PP_ clknet_leaf_38_clk
+ net436 _03284_ VSS VSS VDD VDD network.in_period\[46\]\[3\]
+ sky130_fd_sc_hd__edfxtp_1
Xnetwork.in_period\[47\]\[0\]$_DFFE_PP_ clknet_leaf_39_clk
+ net454 _03285_ VSS VSS VDD VDD network.in_period\[47\]\[0\]
+ sky130_fd_sc_hd__edfxtp_1
Xnetwork.in_period\[47\]\[1\]$_DFFE_PP_ clknet_leaf_39_clk
+ net451 _03285_ VSS VSS VDD VDD network.in_period\[47\]\[1\]
+ sky130_fd_sc_hd__edfxtp_1
Xnetwork.in_period\[47\]\[2\]$_DFFE_PP_ clknet_leaf_39_clk
+ net439 _03285_ VSS VSS VDD VDD network.in_period\[47\]\[2\]
+ sky130_fd_sc_hd__edfxtp_1
Xnetwork.in_period\[47\]\[3\]$_DFFE_PP_ clknet_leaf_39_clk
+ net433 _03285_ VSS VSS VDD VDD network.in_period\[47\]\[3\]
+ sky130_fd_sc_hd__edfxtp_1
Xnetwork.in_period\[48\]\[0\]$_DFFE_PP_ clknet_leaf_13_clk
+ net454 _03286_ VSS VSS VDD VDD network.in_period\[48\]\[0\]
+ sky130_fd_sc_hd__edfxtp_1
Xnetwork.in_period\[48\]\[1\]$_DFFE_PP_ clknet_leaf_13_clk
+ net451 _03286_ VSS VSS VDD VDD network.in_period\[48\]\[1\]
+ sky130_fd_sc_hd__edfxtp_1
Xnetwork.in_period\[48\]\[2\]$_DFFE_PP_ clknet_leaf_13_clk
+ net438 _03286_ VSS VSS VDD VDD network.in_period\[48\]\[2\]
+ sky130_fd_sc_hd__edfxtp_1
Xnetwork.in_period\[48\]\[3\]$_DFFE_PP_ clknet_leaf_13_clk
+ net431 _03286_ VSS VSS VDD VDD network.in_period\[48\]\[3\]
+ sky130_fd_sc_hd__edfxtp_1
Xnetwork.in_period\[49\]\[0\]$_DFFE_PP_ clknet_leaf_4_clk
+ net454 _03287_ VSS VSS VDD VDD network.in_period\[49\]\[0\]
+ sky130_fd_sc_hd__edfxtp_1
Xnetwork.in_period\[49\]\[1\]$_DFFE_PP_ clknet_leaf_4_clk
+ net451 _03287_ VSS VSS VDD VDD network.in_period\[49\]\[1\]
+ sky130_fd_sc_hd__edfxtp_1
Xnetwork.in_period\[49\]\[2\]$_DFFE_PP_ clknet_leaf_4_clk
+ net444 _03287_ VSS VSS VDD VDD network.in_period\[49\]\[2\]
+ sky130_fd_sc_hd__edfxtp_1
Xnetwork.in_period\[49\]\[3\]$_DFFE_PP_ clknet_leaf_4_clk
+ net433 _03287_ VSS VSS VDD VDD network.in_period\[49\]\[3\]
+ sky130_fd_sc_hd__edfxtp_1
Xnetwork.in_period\[4\]\[0\]$_DFFE_PP_ clknet_leaf_67_clk
+ net453 _03288_ VSS VSS VDD VDD network.in_period\[4\]\[0\]
+ sky130_fd_sc_hd__edfxtp_1
Xnetwork.in_period\[4\]\[1\]$_DFFE_PP_ clknet_leaf_67_clk
+ net446 _03288_ VSS VSS VDD VDD network.in_period\[4\]\[1\]
+ sky130_fd_sc_hd__edfxtp_1
Xnetwork.in_period\[4\]\[2\]$_DFFE_PP_ clknet_leaf_66_clk
+ net438 _03288_ VSS VSS VDD VDD network.in_period\[4\]\[2\]
+ sky130_fd_sc_hd__edfxtp_1
Xnetwork.in_period\[4\]\[3\]$_DFFE_PP_ clknet_leaf_66_clk
+ net431 _03288_ VSS VSS VDD VDD network.in_period\[4\]\[3\]
+ sky130_fd_sc_hd__edfxtp_1
Xnetwork.in_period\[50\]\[0\]$_DFFE_PP_ clknet_leaf_11_clk
+ net454 _03289_ VSS VSS VDD VDD network.in_period\[50\]\[0\]
+ sky130_fd_sc_hd__edfxtp_1
Xnetwork.in_period\[50\]\[1\]$_DFFE_PP_ clknet_leaf_11_clk
+ net451 _03289_ VSS VSS VDD VDD network.in_period\[50\]\[1\]
+ sky130_fd_sc_hd__edfxtp_1
Xnetwork.in_period\[50\]\[2\]$_DFFE_PP_ clknet_leaf_11_clk
+ net438 _03289_ VSS VSS VDD VDD network.in_period\[50\]\[2\]
+ sky130_fd_sc_hd__edfxtp_1
Xnetwork.in_period\[50\]\[3\]$_DFFE_PP_ clknet_leaf_11_clk
+ net433 _03289_ VSS VSS VDD VDD network.in_period\[50\]\[3\]
+ sky130_fd_sc_hd__edfxtp_1
Xnetwork.in_period\[51\]\[0\]$_DFFE_PP_ clknet_leaf_3_clk
+ net454 _03290_ VSS VSS VDD VDD network.in_period\[51\]\[0\]
+ sky130_fd_sc_hd__edfxtp_1
Xnetwork.in_period\[51\]\[1\]$_DFFE_PP_ clknet_leaf_3_clk
+ net451 _03290_ VSS VSS VDD VDD network.in_period\[51\]\[1\]
+ sky130_fd_sc_hd__edfxtp_1
Xnetwork.in_period\[51\]\[2\]$_DFFE_PP_ clknet_leaf_3_clk
+ net444 _03290_ VSS VSS VDD VDD network.in_period\[51\]\[2\]
+ sky130_fd_sc_hd__edfxtp_1
Xnetwork.in_period\[51\]\[3\]$_DFFE_PP_ clknet_leaf_3_clk
+ net433 _03290_ VSS VSS VDD VDD network.in_period\[51\]\[3\]
+ sky130_fd_sc_hd__edfxtp_1
Xnetwork.in_period\[52\]\[0\]$_DFFE_PP_ clknet_leaf_11_clk
+ net454 _03291_ VSS VSS VDD VDD network.in_period\[52\]\[0\]
+ sky130_fd_sc_hd__edfxtp_1
Xnetwork.in_period\[52\]\[1\]$_DFFE_PP_ clknet_leaf_11_clk
+ net451 _03291_ VSS VSS VDD VDD network.in_period\[52\]\[1\]
+ sky130_fd_sc_hd__edfxtp_1
Xnetwork.in_period\[52\]\[2\]$_DFFE_PP_ clknet_leaf_11_clk
+ net444 _03291_ VSS VSS VDD VDD network.in_period\[52\]\[2\]
+ sky130_fd_sc_hd__edfxtp_1
Xnetwork.in_period\[52\]\[3\]$_DFFE_PP_ clknet_leaf_11_clk
+ net433 _03291_ VSS VSS VDD VDD network.in_period\[52\]\[3\]
+ sky130_fd_sc_hd__edfxtp_1
Xnetwork.in_period\[53\]\[0\]$_DFFE_PP_ clknet_leaf_7_clk
+ net457 _03292_ VSS VSS VDD VDD network.in_period\[53\]\[0\]
+ sky130_fd_sc_hd__edfxtp_1
Xnetwork.in_period\[53\]\[1\]$_DFFE_PP_ clknet_leaf_7_clk
+ net449 _03292_ VSS VSS VDD VDD network.in_period\[53\]\[1\]
+ sky130_fd_sc_hd__edfxtp_1
Xnetwork.in_period\[53\]\[2\]$_DFFE_PP_ clknet_leaf_7_clk
+ net441 _03292_ VSS VSS VDD VDD network.in_period\[53\]\[2\]
+ sky130_fd_sc_hd__edfxtp_1
Xnetwork.in_period\[53\]\[3\]$_DFFE_PP_ clknet_leaf_7_clk
+ net436 _03292_ VSS VSS VDD VDD network.in_period\[53\]\[3\]
+ sky130_fd_sc_hd__edfxtp_1
Xnetwork.in_period\[54\]\[0\]$_DFFE_PP_ clknet_leaf_2_clk
+ net454 _03293_ VSS VSS VDD VDD network.in_period\[54\]\[0\]
+ sky130_fd_sc_hd__edfxtp_1
Xnetwork.in_period\[54\]\[1\]$_DFFE_PP_ clknet_leaf_2_clk
+ net451 _03293_ VSS VSS VDD VDD network.in_period\[54\]\[1\]
+ sky130_fd_sc_hd__edfxtp_1
Xnetwork.in_period\[54\]\[2\]$_DFFE_PP_ clknet_leaf_2_clk
+ net438 _03293_ VSS VSS VDD VDD network.in_period\[54\]\[2\]
+ sky130_fd_sc_hd__edfxtp_1
Xnetwork.in_period\[54\]\[3\]$_DFFE_PP_ clknet_leaf_12_clk
+ net431 _03293_ VSS VSS VDD VDD network.in_period\[54\]\[3\]
+ sky130_fd_sc_hd__edfxtp_1
Xnetwork.in_period\[55\]\[0\]$_DFFE_PP_ clknet_leaf_3_clk
+ net454 _03294_ VSS VSS VDD VDD network.in_period\[55\]\[0\]
+ sky130_fd_sc_hd__edfxtp_1
Xnetwork.in_period\[55\]\[1\]$_DFFE_PP_ clknet_leaf_3_clk
+ net451 _03294_ VSS VSS VDD VDD network.in_period\[55\]\[1\]
+ sky130_fd_sc_hd__edfxtp_1
Xnetwork.in_period\[55\]\[2\]$_DFFE_PP_ clknet_leaf_3_clk
+ net444 _03294_ VSS VSS VDD VDD network.in_period\[55\]\[2\]
+ sky130_fd_sc_hd__edfxtp_1
Xnetwork.in_period\[55\]\[3\]$_DFFE_PP_ clknet_leaf_3_clk
+ net433 _03294_ VSS VSS VDD VDD network.in_period\[55\]\[3\]
+ sky130_fd_sc_hd__edfxtp_1
Xnetwork.in_period\[56\]\[0\]$_DFFE_PP_ clknet_leaf_0_clk
+ net458 _03295_ VSS VSS VDD VDD network.in_period\[56\]\[0\]
+ sky130_fd_sc_hd__edfxtp_1
Xnetwork.in_period\[56\]\[1\]$_DFFE_PP_ clknet_leaf_0_clk
+ net450 _03295_ VSS VSS VDD VDD network.in_period\[56\]\[1\]
+ sky130_fd_sc_hd__edfxtp_1
Xnetwork.in_period\[56\]\[2\]$_DFFE_PP_ clknet_leaf_0_clk
+ net443 _03295_ VSS VSS VDD VDD network.in_period\[56\]\[2\]
+ sky130_fd_sc_hd__edfxtp_1
Xnetwork.in_period\[56\]\[3\]$_DFFE_PP_ clknet_leaf_0_clk
+ net437 _03295_ VSS VSS VDD VDD network.in_period\[56\]\[3\]
+ sky130_fd_sc_hd__edfxtp_1
Xnetwork.in_period\[57\]\[0\]$_DFFE_PP_ clknet_leaf_1_clk
+ net454 _03296_ VSS VSS VDD VDD network.in_period\[57\]\[0\]
+ sky130_fd_sc_hd__edfxtp_1
Xnetwork.in_period\[57\]\[1\]$_DFFE_PP_ clknet_leaf_1_clk
+ net451 _03296_ VSS VSS VDD VDD network.in_period\[57\]\[1\]
+ sky130_fd_sc_hd__edfxtp_1
Xnetwork.in_period\[57\]\[2\]$_DFFE_PP_ clknet_leaf_2_clk
+ net438 _03296_ VSS VSS VDD VDD network.in_period\[57\]\[2\]
+ sky130_fd_sc_hd__edfxtp_1
Xnetwork.in_period\[57\]\[3\]$_DFFE_PP_ clknet_leaf_2_clk
+ net433 _03296_ VSS VSS VDD VDD network.in_period\[57\]\[3\]
+ sky130_fd_sc_hd__edfxtp_1
Xnetwork.in_period\[58\]\[0\]$_DFFE_PP_ clknet_leaf_271_clk
+ net458 _03297_ VSS VSS VDD VDD network.in_period\[58\]\[0\]
+ sky130_fd_sc_hd__edfxtp_1
Xnetwork.in_period\[58\]\[1\]$_DFFE_PP_ clknet_leaf_271_clk
+ net450 _03297_ VSS VSS VDD VDD network.in_period\[58\]\[1\]
+ sky130_fd_sc_hd__edfxtp_1
Xnetwork.in_period\[58\]\[2\]$_DFFE_PP_ clknet_leaf_271_clk
+ net444 _03297_ VSS VSS VDD VDD network.in_period\[58\]\[2\]
+ sky130_fd_sc_hd__edfxtp_1
Xnetwork.in_period\[58\]\[3\]$_DFFE_PP_ clknet_leaf_271_clk
+ net437 _03297_ VSS VSS VDD VDD network.in_period\[58\]\[3\]
+ sky130_fd_sc_hd__edfxtp_1
Xnetwork.in_period\[59\]\[0\]$_DFFE_PP_ clknet_leaf_1_clk
+ net454 _03298_ VSS VSS VDD VDD network.in_period\[59\]\[0\]
+ sky130_fd_sc_hd__edfxtp_1
Xnetwork.in_period\[59\]\[1\]$_DFFE_PP_ clknet_leaf_1_clk
+ net451 _03298_ VSS VSS VDD VDD network.in_period\[59\]\[1\]
+ sky130_fd_sc_hd__edfxtp_1
Xnetwork.in_period\[59\]\[2\]$_DFFE_PP_ clknet_leaf_1_clk
+ net444 _03298_ VSS VSS VDD VDD network.in_period\[59\]\[2\]
+ sky130_fd_sc_hd__edfxtp_1
Xnetwork.in_period\[59\]\[3\]$_DFFE_PP_ clknet_leaf_1_clk
+ net433 _03298_ VSS VSS VDD VDD network.in_period\[59\]\[3\]
+ sky130_fd_sc_hd__edfxtp_1
Xnetwork.in_period\[5\]\[0\]$_DFFE_PP_ clknet_leaf_67_clk
+ net453 _03299_ VSS VSS VDD VDD network.in_period\[5\]\[0\]
+ sky130_fd_sc_hd__edfxtp_1
Xnetwork.in_period\[5\]\[1\]$_DFFE_PP_ clknet_leaf_67_clk
+ net446 _03299_ VSS VSS VDD VDD network.in_period\[5\]\[1\]
+ sky130_fd_sc_hd__edfxtp_1
Xnetwork.in_period\[5\]\[2\]$_DFFE_PP_ clknet_leaf_62_clk
+ net438 _03299_ VSS VSS VDD VDD network.in_period\[5\]\[2\]
+ sky130_fd_sc_hd__edfxtp_1
Xnetwork.in_period\[5\]\[3\]$_DFFE_PP_ clknet_leaf_63_clk
+ net431 _03299_ VSS VSS VDD VDD network.in_period\[5\]\[3\]
+ sky130_fd_sc_hd__edfxtp_1
Xnetwork.in_period\[60\]\[0\]$_DFFE_PP_ clknet_leaf_266_clk
+ net458 _03300_ VSS VSS VDD VDD network.in_period\[60\]\[0\]
+ sky130_fd_sc_hd__edfxtp_1
Xnetwork.in_period\[60\]\[1\]$_DFFE_PP_ clknet_leaf_270_clk
+ net450 _03300_ VSS VSS VDD VDD network.in_period\[60\]\[1\]
+ sky130_fd_sc_hd__edfxtp_1
Xnetwork.in_period\[60\]\[2\]$_DFFE_PP_ clknet_leaf_266_clk
+ net443 _03300_ VSS VSS VDD VDD network.in_period\[60\]\[2\]
+ sky130_fd_sc_hd__edfxtp_1
Xnetwork.in_period\[60\]\[3\]$_DFFE_PP_ clknet_leaf_270_clk
+ net437 _03300_ VSS VSS VDD VDD network.in_period\[60\]\[3\]
+ sky130_fd_sc_hd__edfxtp_1
Xnetwork.in_period\[61\]\[0\]$_DFFE_PP_ clknet_leaf_266_clk
+ net457 _03301_ VSS VSS VDD VDD network.in_period\[61\]\[0\]
+ sky130_fd_sc_hd__edfxtp_1
Xnetwork.in_period\[61\]\[1\]$_DFFE_PP_ clknet_leaf_266_clk
+ net449 _03301_ VSS VSS VDD VDD network.in_period\[61\]\[1\]
+ sky130_fd_sc_hd__edfxtp_1
Xnetwork.in_period\[61\]\[2\]$_DFFE_PP_ clknet_leaf_6_clk
+ net441 _03301_ VSS VSS VDD VDD network.in_period\[61\]\[2\]
+ sky130_fd_sc_hd__edfxtp_1
Xnetwork.in_period\[61\]\[3\]$_DFFE_PP_ clknet_leaf_6_clk
+ net436 _03301_ VSS VSS VDD VDD network.in_period\[61\]\[3\]
+ sky130_fd_sc_hd__edfxtp_1
Xnetwork.in_period\[62\]\[0\]$_DFFE_PP_ clknet_leaf_266_clk
+ net458 _03302_ VSS VSS VDD VDD network.in_period\[62\]\[0\]
+ sky130_fd_sc_hd__edfxtp_1
Xnetwork.in_period\[62\]\[1\]$_DFFE_PP_ clknet_leaf_5_clk
+ net450 _03302_ VSS VSS VDD VDD network.in_period\[62\]\[1\]
+ sky130_fd_sc_hd__edfxtp_1
Xnetwork.in_period\[62\]\[2\]$_DFFE_PP_ clknet_leaf_5_clk
+ net443 _03302_ VSS VSS VDD VDD network.in_period\[62\]\[2\]
+ sky130_fd_sc_hd__edfxtp_1
Xnetwork.in_period\[62\]\[3\]$_DFFE_PP_ clknet_leaf_5_clk
+ net437 _03302_ VSS VSS VDD VDD network.in_period\[62\]\[3\]
+ sky130_fd_sc_hd__edfxtp_1
Xnetwork.in_period\[63\]\[0\]$_DFFE_PP_ clknet_leaf_270_clk
+ net458 _03303_ VSS VSS VDD VDD network.in_period\[63\]\[0\]
+ sky130_fd_sc_hd__edfxtp_1
Xnetwork.in_period\[63\]\[1\]$_DFFE_PP_ clknet_leaf_270_clk
+ net450 _03303_ VSS VSS VDD VDD network.in_period\[63\]\[1\]
+ sky130_fd_sc_hd__edfxtp_1
Xnetwork.in_period\[63\]\[2\]$_DFFE_PP_ clknet_leaf_270_clk
+ net443 _03303_ VSS VSS VDD VDD network.in_period\[63\]\[2\]
+ sky130_fd_sc_hd__edfxtp_1
Xnetwork.in_period\[63\]\[3\]$_DFFE_PP_ clknet_leaf_271_clk
+ net437 _03303_ VSS VSS VDD VDD network.in_period\[63\]\[3\]
+ sky130_fd_sc_hd__edfxtp_1
Xnetwork.in_period\[64\]\[0\]$_DFFE_PP_ clknet_leaf_51_clk
+ net452 _03304_ VSS VSS VDD VDD network.in_period\[64\]\[0\]
+ sky130_fd_sc_hd__edfxtp_1
Xnetwork.in_period\[64\]\[1\]$_DFFE_PP_ clknet_leaf_52_clk
+ net445 _03304_ VSS VSS VDD VDD network.in_period\[64\]\[1\]
+ sky130_fd_sc_hd__edfxtp_1
Xnetwork.in_period\[64\]\[2\]$_DFFE_PP_ clknet_leaf_52_clk
+ net439 _03304_ VSS VSS VDD VDD network.in_period\[64\]\[2\]
+ sky130_fd_sc_hd__edfxtp_1
Xnetwork.in_period\[64\]\[3\]$_DFFE_PP_ clknet_leaf_52_clk
+ net433 _03304_ VSS VSS VDD VDD network.in_period\[64\]\[3\]
+ sky130_fd_sc_hd__edfxtp_1
Xnetwork.in_period\[65\]\[0\]$_DFFE_PP_ clknet_leaf_52_clk
+ net452 _03305_ VSS VSS VDD VDD network.in_period\[65\]\[0\]
+ sky130_fd_sc_hd__edfxtp_1
Xnetwork.in_period\[65\]\[1\]$_DFFE_PP_ clknet_leaf_49_clk
+ net445 _03305_ VSS VSS VDD VDD network.in_period\[65\]\[1\]
+ sky130_fd_sc_hd__edfxtp_1
Xnetwork.in_period\[65\]\[2\]$_DFFE_PP_ clknet_leaf_47_clk
+ net439 _03305_ VSS VSS VDD VDD network.in_period\[65\]\[2\]
+ sky130_fd_sc_hd__edfxtp_1
Xnetwork.in_period\[65\]\[3\]$_DFFE_PP_ clknet_leaf_47_clk
+ net433 _03305_ VSS VSS VDD VDD network.in_period\[65\]\[3\]
+ sky130_fd_sc_hd__edfxtp_1
Xnetwork.in_period\[66\]\[0\]$_DFFE_PP_ clknet_leaf_76_clk
+ net453 _03306_ VSS VSS VDD VDD network.in_period\[66\]\[0\]
+ sky130_fd_sc_hd__edfxtp_1
Xnetwork.in_period\[66\]\[1\]$_DFFE_PP_ clknet_leaf_76_clk
+ net446 _03306_ VSS VSS VDD VDD network.in_period\[66\]\[1\]
+ sky130_fd_sc_hd__edfxtp_1
Xnetwork.in_period\[66\]\[2\]$_DFFE_PP_ clknet_leaf_76_clk
+ net438 _03306_ VSS VSS VDD VDD network.in_period\[66\]\[2\]
+ sky130_fd_sc_hd__edfxtp_1
Xnetwork.in_period\[66\]\[3\]$_DFFE_PP_ clknet_leaf_76_clk
+ net431 _03306_ VSS VSS VDD VDD network.in_period\[66\]\[3\]
+ sky130_fd_sc_hd__edfxtp_1
Xnetwork.in_period\[67\]\[0\]$_DFFE_PP_ clknet_leaf_75_clk
+ net453 _03307_ VSS VSS VDD VDD network.in_period\[67\]\[0\]
+ sky130_fd_sc_hd__edfxtp_1
Xnetwork.in_period\[67\]\[1\]$_DFFE_PP_ clknet_leaf_75_clk
+ net446 _03307_ VSS VSS VDD VDD network.in_period\[67\]\[1\]
+ sky130_fd_sc_hd__edfxtp_1
Xnetwork.in_period\[67\]\[2\]$_DFFE_PP_ clknet_leaf_75_clk
+ net438 _03307_ VSS VSS VDD VDD network.in_period\[67\]\[2\]
+ sky130_fd_sc_hd__edfxtp_1
Xnetwork.in_period\[67\]\[3\]$_DFFE_PP_ clknet_leaf_75_clk
+ net431 _03307_ VSS VSS VDD VDD network.in_period\[67\]\[3\]
+ sky130_fd_sc_hd__edfxtp_1
Xnetwork.in_period\[68\]\[0\]$_DFFE_PP_ clknet_leaf_76_clk
+ net453 _03308_ VSS VSS VDD VDD network.in_period\[68\]\[0\]
+ sky130_fd_sc_hd__edfxtp_1
Xnetwork.in_period\[68\]\[1\]$_DFFE_PP_ clknet_leaf_77_clk
+ net446 _03308_ VSS VSS VDD VDD network.in_period\[68\]\[1\]
+ sky130_fd_sc_hd__edfxtp_1
Xnetwork.in_period\[68\]\[2\]$_DFFE_PP_ clknet_leaf_76_clk
+ net438 _03308_ VSS VSS VDD VDD network.in_period\[68\]\[2\]
+ sky130_fd_sc_hd__edfxtp_1
Xnetwork.in_period\[68\]\[3\]$_DFFE_PP_ clknet_leaf_76_clk
+ net431 _03308_ VSS VSS VDD VDD network.in_period\[68\]\[3\]
+ sky130_fd_sc_hd__edfxtp_1
Xnetwork.in_period\[69\]\[0\]$_DFFE_PP_ clknet_leaf_47_clk
+ net452 _03309_ VSS VSS VDD VDD network.in_period\[69\]\[0\]
+ sky130_fd_sc_hd__edfxtp_1
Xnetwork.in_period\[69\]\[1\]$_DFFE_PP_ clknet_leaf_47_clk
+ net445 _03309_ VSS VSS VDD VDD network.in_period\[69\]\[1\]
+ sky130_fd_sc_hd__edfxtp_1
Xnetwork.in_period\[69\]\[2\]$_DFFE_PP_ clknet_leaf_48_clk
+ net439 _03309_ VSS VSS VDD VDD network.in_period\[69\]\[2\]
+ sky130_fd_sc_hd__edfxtp_1
Xnetwork.in_period\[69\]\[3\]$_DFFE_PP_ clknet_leaf_47_clk
+ net433 _03309_ VSS VSS VDD VDD network.in_period\[69\]\[3\]
+ sky130_fd_sc_hd__edfxtp_1
Xnetwork.in_period\[6\]\[0\]$_DFFE_PP_ clknet_leaf_50_clk
+ net453 _03310_ VSS VSS VDD VDD network.in_period\[6\]\[0\]
+ sky130_fd_sc_hd__edfxtp_1
Xnetwork.in_period\[6\]\[1\]$_DFFE_PP_ clknet_leaf_50_clk
+ net446 _03310_ VSS VSS VDD VDD network.in_period\[6\]\[1\]
+ sky130_fd_sc_hd__edfxtp_1
Xnetwork.in_period\[6\]\[2\]$_DFFE_PP_ clknet_leaf_50_clk
+ net438 _03310_ VSS VSS VDD VDD network.in_period\[6\]\[2\]
+ sky130_fd_sc_hd__edfxtp_1
Xnetwork.in_period\[6\]\[3\]$_DFFE_PP_ clknet_leaf_68_clk
+ net431 _03310_ VSS VSS VDD VDD network.in_period\[6\]\[3\]
+ sky130_fd_sc_hd__edfxtp_1
Xnetwork.in_period\[70\]\[0\]$_DFFE_PP_ clknet_leaf_77_clk
+ net453 _03311_ VSS VSS VDD VDD network.in_period\[70\]\[0\]
+ sky130_fd_sc_hd__edfxtp_1
Xnetwork.in_period\[70\]\[1\]$_DFFE_PP_ clknet_leaf_77_clk
+ net446 _03311_ VSS VSS VDD VDD network.in_period\[70\]\[1\]
+ sky130_fd_sc_hd__edfxtp_1
Xnetwork.in_period\[70\]\[2\]$_DFFE_PP_ clknet_leaf_77_clk
+ net438 _03311_ VSS VSS VDD VDD network.in_period\[70\]\[2\]
+ sky130_fd_sc_hd__edfxtp_1
Xnetwork.in_period\[70\]\[3\]$_DFFE_PP_ clknet_leaf_77_clk
+ net431 _03311_ VSS VSS VDD VDD network.in_period\[70\]\[3\]
+ sky130_fd_sc_hd__edfxtp_1
Xnetwork.in_period\[71\]\[0\]$_DFFE_PP_ clknet_leaf_71_clk
+ net453 _03312_ VSS VSS VDD VDD network.in_period\[71\]\[0\]
+ sky130_fd_sc_hd__edfxtp_1
Xnetwork.in_period\[71\]\[1\]$_DFFE_PP_ clknet_leaf_71_clk
+ net446 _03312_ VSS VSS VDD VDD network.in_period\[71\]\[1\]
+ sky130_fd_sc_hd__edfxtp_1
Xnetwork.in_period\[71\]\[2\]$_DFFE_PP_ clknet_leaf_71_clk
+ net438 _03312_ VSS VSS VDD VDD network.in_period\[71\]\[2\]
+ sky130_fd_sc_hd__edfxtp_1
Xnetwork.in_period\[71\]\[3\]$_DFFE_PP_ clknet_leaf_71_clk
+ net431 _03312_ VSS VSS VDD VDD network.in_period\[71\]\[3\]
+ sky130_fd_sc_hd__edfxtp_1
Xnetwork.in_period\[72\]\[0\]$_DFFE_PP_ clknet_leaf_72_clk
+ net453 _03313_ VSS VSS VDD VDD network.in_period\[72\]\[0\]
+ sky130_fd_sc_hd__edfxtp_1
Xnetwork.in_period\[72\]\[1\]$_DFFE_PP_ clknet_leaf_73_clk
+ net446 _03313_ VSS VSS VDD VDD network.in_period\[72\]\[1\]
+ sky130_fd_sc_hd__edfxtp_1
Xnetwork.in_period\[72\]\[2\]$_DFFE_PP_ clknet_leaf_72_clk
+ net438 _03313_ VSS VSS VDD VDD network.in_period\[72\]\[2\]
+ sky130_fd_sc_hd__edfxtp_1
Xnetwork.in_period\[72\]\[3\]$_DFFE_PP_ clknet_leaf_72_clk
+ net431 _03313_ VSS VSS VDD VDD network.in_period\[72\]\[3\]
+ sky130_fd_sc_hd__edfxtp_1
Xnetwork.in_period\[73\]\[0\]$_DFFE_PP_ clknet_leaf_66_clk
+ net453 _03314_ VSS VSS VDD VDD network.in_period\[73\]\[0\]
+ sky130_fd_sc_hd__edfxtp_1
Xnetwork.in_period\[73\]\[1\]$_DFFE_PP_ clknet_leaf_66_clk
+ net446 _03314_ VSS VSS VDD VDD network.in_period\[73\]\[1\]
+ sky130_fd_sc_hd__edfxtp_1
Xnetwork.in_period\[73\]\[2\]$_DFFE_PP_ clknet_leaf_66_clk
+ net438 _03314_ VSS VSS VDD VDD network.in_period\[73\]\[2\]
+ sky130_fd_sc_hd__edfxtp_1
Xnetwork.in_period\[73\]\[3\]$_DFFE_PP_ clknet_leaf_66_clk
+ net431 _03314_ VSS VSS VDD VDD network.in_period\[73\]\[3\]
+ sky130_fd_sc_hd__edfxtp_1
Xnetwork.in_period\[74\]\[0\]$_DFFE_PP_ clknet_leaf_73_clk
+ net453 _03315_ VSS VSS VDD VDD network.in_period\[74\]\[0\]
+ sky130_fd_sc_hd__edfxtp_1
Xnetwork.in_period\[74\]\[1\]$_DFFE_PP_ clknet_leaf_73_clk
+ net446 _03315_ VSS VSS VDD VDD network.in_period\[74\]\[1\]
+ sky130_fd_sc_hd__edfxtp_1
Xnetwork.in_period\[74\]\[2\]$_DFFE_PP_ clknet_leaf_74_clk
+ net438 _03315_ VSS VSS VDD VDD network.in_period\[74\]\[2\]
+ sky130_fd_sc_hd__edfxtp_1
Xnetwork.in_period\[74\]\[3\]$_DFFE_PP_ clknet_leaf_74_clk
+ net431 _03315_ VSS VSS VDD VDD network.in_period\[74\]\[3\]
+ sky130_fd_sc_hd__edfxtp_1
Xnetwork.in_period\[75\]\[0\]$_DFFE_PP_ clknet_leaf_72_clk
+ net453 _03316_ VSS VSS VDD VDD network.in_period\[75\]\[0\]
+ sky130_fd_sc_hd__edfxtp_1
Xnetwork.in_period\[75\]\[1\]$_DFFE_PP_ clknet_leaf_72_clk
+ net446 _03316_ VSS VSS VDD VDD network.in_period\[75\]\[1\]
+ sky130_fd_sc_hd__edfxtp_1
Xnetwork.in_period\[75\]\[2\]$_DFFE_PP_ clknet_leaf_72_clk
+ net438 _03316_ VSS VSS VDD VDD network.in_period\[75\]\[2\]
+ sky130_fd_sc_hd__edfxtp_1
Xnetwork.in_period\[75\]\[3\]$_DFFE_PP_ clknet_leaf_72_clk
+ net431 _03316_ VSS VSS VDD VDD network.in_period\[75\]\[3\]
+ sky130_fd_sc_hd__edfxtp_1
Xnetwork.in_period\[76\]\[0\]$_DFFE_PP_ clknet_leaf_51_clk
+ net453 _03317_ VSS VSS VDD VDD network.in_period\[76\]\[0\]
+ sky130_fd_sc_hd__edfxtp_1
Xnetwork.in_period\[76\]\[1\]$_DFFE_PP_ clknet_leaf_51_clk
+ net446 _03317_ VSS VSS VDD VDD network.in_period\[76\]\[1\]
+ sky130_fd_sc_hd__edfxtp_1
Xnetwork.in_period\[76\]\[2\]$_DFFE_PP_ clknet_leaf_49_clk
+ net438 _03317_ VSS VSS VDD VDD network.in_period\[76\]\[2\]
+ sky130_fd_sc_hd__edfxtp_1
Xnetwork.in_period\[76\]\[3\]$_DFFE_PP_ clknet_leaf_49_clk
+ net431 _03317_ VSS VSS VDD VDD network.in_period\[76\]\[3\]
+ sky130_fd_sc_hd__edfxtp_1
Xnetwork.in_period\[77\]\[0\]$_DFFE_PP_ clknet_leaf_71_clk
+ net453 _03318_ VSS VSS VDD VDD network.in_period\[77\]\[0\]
+ sky130_fd_sc_hd__edfxtp_1
Xnetwork.in_period\[77\]\[1\]$_DFFE_PP_ clknet_leaf_70_clk
+ net446 _03318_ VSS VSS VDD VDD network.in_period\[77\]\[1\]
+ sky130_fd_sc_hd__edfxtp_1
Xnetwork.in_period\[77\]\[2\]$_DFFE_PP_ clknet_leaf_70_clk
+ net438 _03318_ VSS VSS VDD VDD network.in_period\[77\]\[2\]
+ sky130_fd_sc_hd__edfxtp_1
Xnetwork.in_period\[77\]\[3\]$_DFFE_PP_ clknet_leaf_70_clk
+ net431 _03318_ VSS VSS VDD VDD network.in_period\[77\]\[3\]
+ sky130_fd_sc_hd__edfxtp_1
Xnetwork.in_period\[78\]\[0\]$_DFFE_PP_ clknet_leaf_74_clk
+ net453 _03319_ VSS VSS VDD VDD network.in_period\[78\]\[0\]
+ sky130_fd_sc_hd__edfxtp_1
Xnetwork.in_period\[78\]\[1\]$_DFFE_PP_ clknet_leaf_74_clk
+ net446 _03319_ VSS VSS VDD VDD network.in_period\[78\]\[1\]
+ sky130_fd_sc_hd__edfxtp_1
Xnetwork.in_period\[78\]\[2\]$_DFFE_PP_ clknet_leaf_74_clk
+ net438 _03319_ VSS VSS VDD VDD network.in_period\[78\]\[2\]
+ sky130_fd_sc_hd__edfxtp_1
Xnetwork.in_period\[78\]\[3\]$_DFFE_PP_ clknet_leaf_74_clk
+ net431 _03319_ VSS VSS VDD VDD network.in_period\[78\]\[3\]
+ sky130_fd_sc_hd__edfxtp_1
Xnetwork.in_period\[79\]\[0\]$_DFFE_PP_ clknet_leaf_49_clk
+ net453 _03320_ VSS VSS VDD VDD network.in_period\[79\]\[0\]
+ sky130_fd_sc_hd__edfxtp_1
Xnetwork.in_period\[79\]\[1\]$_DFFE_PP_ clknet_leaf_49_clk
+ net446 _03320_ VSS VSS VDD VDD network.in_period\[79\]\[1\]
+ sky130_fd_sc_hd__edfxtp_1
Xnetwork.in_period\[79\]\[2\]$_DFFE_PP_ clknet_leaf_69_clk
+ net438 _03320_ VSS VSS VDD VDD network.in_period\[79\]\[2\]
+ sky130_fd_sc_hd__edfxtp_1
Xnetwork.in_period\[79\]\[3\]$_DFFE_PP_ clknet_leaf_68_clk
+ net431 _03320_ VSS VSS VDD VDD network.in_period\[79\]\[3\]
+ sky130_fd_sc_hd__edfxtp_1
Xnetwork.in_period\[7\]\[0\]$_DFFE_PP_ clknet_leaf_62_clk
+ net453 _03321_ VSS VSS VDD VDD network.in_period\[7\]\[0\]
+ sky130_fd_sc_hd__edfxtp_1
Xnetwork.in_period\[7\]\[1\]$_DFFE_PP_ clknet_leaf_62_clk
+ net446 _03321_ VSS VSS VDD VDD network.in_period\[7\]\[1\]
+ sky130_fd_sc_hd__edfxtp_1
Xnetwork.in_period\[7\]\[2\]$_DFFE_PP_ clknet_leaf_62_clk
+ net438 _03321_ VSS VSS VDD VDD network.in_period\[7\]\[2\]
+ sky130_fd_sc_hd__edfxtp_1
Xnetwork.in_period\[7\]\[3\]$_DFFE_PP_ clknet_leaf_62_clk
+ net431 _03321_ VSS VSS VDD VDD network.in_period\[7\]\[3\]
+ sky130_fd_sc_hd__edfxtp_1
Xnetwork.in_period\[80\]\[0\]$_DFFE_PP_ clknet_leaf_60_clk
+ net453 _03322_ VSS VSS VDD VDD network.in_period\[80\]\[0\]
+ sky130_fd_sc_hd__edfxtp_1
Xnetwork.in_period\[80\]\[1\]$_DFFE_PP_ clknet_leaf_60_clk
+ net446 _03322_ VSS VSS VDD VDD network.in_period\[80\]\[1\]
+ sky130_fd_sc_hd__edfxtp_1
Xnetwork.in_period\[80\]\[2\]$_DFFE_PP_ clknet_leaf_59_clk
+ net438 _03322_ VSS VSS VDD VDD network.in_period\[80\]\[2\]
+ sky130_fd_sc_hd__edfxtp_1
Xnetwork.in_period\[80\]\[3\]$_DFFE_PP_ clknet_leaf_60_clk
+ net431 _03322_ VSS VSS VDD VDD network.in_period\[80\]\[3\]
+ sky130_fd_sc_hd__edfxtp_1
Xnetwork.in_period\[81\]\[0\]$_DFFE_PP_ clknet_leaf_51_clk
+ net453 _03323_ VSS VSS VDD VDD network.in_period\[81\]\[0\]
+ sky130_fd_sc_hd__edfxtp_1
Xnetwork.in_period\[81\]\[1\]$_DFFE_PP_ clknet_leaf_55_clk
+ net446 _03323_ VSS VSS VDD VDD network.in_period\[81\]\[1\]
+ sky130_fd_sc_hd__edfxtp_1
Xnetwork.in_period\[81\]\[2\]$_DFFE_PP_ clknet_leaf_50_clk
+ net438 _03323_ VSS VSS VDD VDD network.in_period\[81\]\[2\]
+ sky130_fd_sc_hd__edfxtp_1
Xnetwork.in_period\[81\]\[3\]$_DFFE_PP_ clknet_leaf_51_clk
+ net431 _03323_ VSS VSS VDD VDD network.in_period\[81\]\[3\]
+ sky130_fd_sc_hd__edfxtp_1
Xnetwork.in_period\[82\]\[0\]$_DFFE_PP_ clknet_leaf_54_clk
+ net453 _03324_ VSS VSS VDD VDD network.in_period\[82\]\[0\]
+ sky130_fd_sc_hd__edfxtp_1
Xnetwork.in_period\[82\]\[1\]$_DFFE_PP_ clknet_leaf_54_clk
+ net446 _03324_ VSS VSS VDD VDD network.in_period\[82\]\[1\]
+ sky130_fd_sc_hd__edfxtp_1
Xnetwork.in_period\[82\]\[2\]$_DFFE_PP_ clknet_leaf_54_clk
+ net438 _03324_ VSS VSS VDD VDD network.in_period\[82\]\[2\]
+ sky130_fd_sc_hd__edfxtp_1
Xnetwork.in_period\[82\]\[3\]$_DFFE_PP_ clknet_leaf_54_clk
+ net431 _03324_ VSS VSS VDD VDD network.in_period\[82\]\[3\]
+ sky130_fd_sc_hd__edfxtp_1
Xnetwork.in_period\[83\]\[0\]$_DFFE_PP_ clknet_leaf_53_clk
+ net453 _03325_ VSS VSS VDD VDD network.in_period\[83\]\[0\]
+ sky130_fd_sc_hd__edfxtp_1
Xnetwork.in_period\[83\]\[1\]$_DFFE_PP_ clknet_leaf_53_clk
+ net446 _03325_ VSS VSS VDD VDD network.in_period\[83\]\[1\]
+ sky130_fd_sc_hd__edfxtp_1
Xnetwork.in_period\[83\]\[2\]$_DFFE_PP_ clknet_leaf_53_clk
+ net439 _03325_ VSS VSS VDD VDD network.in_period\[83\]\[2\]
+ sky130_fd_sc_hd__edfxtp_1
Xnetwork.in_period\[83\]\[3\]$_DFFE_PP_ clknet_leaf_53_clk
+ net433 _03325_ VSS VSS VDD VDD network.in_period\[83\]\[3\]
+ sky130_fd_sc_hd__edfxtp_1
Xnetwork.in_period\[84\]\[0\]$_DFFE_PP_ clknet_leaf_56_clk
+ net453 _03326_ VSS VSS VDD VDD network.in_period\[84\]\[0\]
+ sky130_fd_sc_hd__edfxtp_1
Xnetwork.in_period\[84\]\[1\]$_DFFE_PP_ clknet_leaf_56_clk
+ net446 _03326_ VSS VSS VDD VDD network.in_period\[84\]\[1\]
+ sky130_fd_sc_hd__edfxtp_1
Xnetwork.in_period\[84\]\[2\]$_DFFE_PP_ clknet_leaf_56_clk
+ net438 _03326_ VSS VSS VDD VDD network.in_period\[84\]\[2\]
+ sky130_fd_sc_hd__edfxtp_1
Xnetwork.in_period\[84\]\[3\]$_DFFE_PP_ clknet_leaf_56_clk
+ net431 _03326_ VSS VSS VDD VDD network.in_period\[84\]\[3\]
+ sky130_fd_sc_hd__edfxtp_1
Xnetwork.in_period\[85\]\[0\]$_DFFE_PP_ clknet_leaf_59_clk
+ net453 _03327_ VSS VSS VDD VDD network.in_period\[85\]\[0\]
+ sky130_fd_sc_hd__edfxtp_1
Xnetwork.in_period\[85\]\[1\]$_DFFE_PP_ clknet_leaf_59_clk
+ net446 _03327_ VSS VSS VDD VDD network.in_period\[85\]\[1\]
+ sky130_fd_sc_hd__edfxtp_1
Xnetwork.in_period\[85\]\[2\]$_DFFE_PP_ clknet_leaf_59_clk
+ net438 _03327_ VSS VSS VDD VDD network.in_period\[85\]\[2\]
+ sky130_fd_sc_hd__edfxtp_1
Xnetwork.in_period\[85\]\[3\]$_DFFE_PP_ clknet_leaf_59_clk
+ net431 _03327_ VSS VSS VDD VDD network.in_period\[85\]\[3\]
+ sky130_fd_sc_hd__edfxtp_1
Xnetwork.in_period\[86\]\[0\]$_DFFE_PP_ clknet_leaf_58_clk
+ net453 _03328_ VSS VSS VDD VDD network.in_period\[86\]\[0\]
+ sky130_fd_sc_hd__edfxtp_1
Xnetwork.in_period\[86\]\[1\]$_DFFE_PP_ clknet_leaf_58_clk
+ net446 _03328_ VSS VSS VDD VDD network.in_period\[86\]\[1\]
+ sky130_fd_sc_hd__edfxtp_1
Xnetwork.in_period\[86\]\[2\]$_DFFE_PP_ clknet_leaf_18_clk
+ net438 _03328_ VSS VSS VDD VDD network.in_period\[86\]\[2\]
+ sky130_fd_sc_hd__edfxtp_1
Xnetwork.in_period\[86\]\[3\]$_DFFE_PP_ clknet_leaf_18_clk
+ net431 _03328_ VSS VSS VDD VDD network.in_period\[86\]\[3\]
+ sky130_fd_sc_hd__edfxtp_1
Xnetwork.in_period\[87\]\[0\]$_DFFE_PP_ clknet_leaf_18_clk
+ net454 _03329_ VSS VSS VDD VDD network.in_period\[87\]\[0\]
+ sky130_fd_sc_hd__edfxtp_1
Xnetwork.in_period\[87\]\[1\]$_DFFE_PP_ clknet_leaf_18_clk
+ net446 _03329_ VSS VSS VDD VDD network.in_period\[87\]\[1\]
+ sky130_fd_sc_hd__edfxtp_1
Xnetwork.in_period\[87\]\[2\]$_DFFE_PP_ clknet_leaf_18_clk
+ net438 _03329_ VSS VSS VDD VDD network.in_period\[87\]\[2\]
+ sky130_fd_sc_hd__edfxtp_1
Xnetwork.in_period\[87\]\[3\]$_DFFE_PP_ clknet_leaf_18_clk
+ net431 _03329_ VSS VSS VDD VDD network.in_period\[87\]\[3\]
+ sky130_fd_sc_hd__edfxtp_1
Xnetwork.in_period\[88\]\[0\]$_DFFE_PP_ clknet_leaf_17_clk
+ net454 _03330_ VSS VSS VDD VDD network.in_period\[88\]\[0\]
+ sky130_fd_sc_hd__edfxtp_1
Xnetwork.in_period\[88\]\[1\]$_DFFE_PP_ clknet_leaf_16_clk
+ net446 _03330_ VSS VSS VDD VDD network.in_period\[88\]\[1\]
+ sky130_fd_sc_hd__edfxtp_1
Xnetwork.in_period\[88\]\[2\]$_DFFE_PP_ clknet_leaf_17_clk
+ net438 _03330_ VSS VSS VDD VDD network.in_period\[88\]\[2\]
+ sky130_fd_sc_hd__edfxtp_1
Xnetwork.in_period\[88\]\[3\]$_DFFE_PP_ clknet_leaf_17_clk
+ net431 _03330_ VSS VSS VDD VDD network.in_period\[88\]\[3\]
+ sky130_fd_sc_hd__edfxtp_1
Xnetwork.in_period\[89\]\[0\]$_DFFE_PP_ clknet_leaf_10_clk
+ net454 _03331_ VSS VSS VDD VDD network.in_period\[89\]\[0\]
+ sky130_fd_sc_hd__edfxtp_1
Xnetwork.in_period\[89\]\[1\]$_DFFE_PP_ clknet_leaf_10_clk
+ net451 _03331_ VSS VSS VDD VDD network.in_period\[89\]\[1\]
+ sky130_fd_sc_hd__edfxtp_1
Xnetwork.in_period\[89\]\[2\]$_DFFE_PP_ clknet_leaf_10_clk
+ net444 _03331_ VSS VSS VDD VDD network.in_period\[89\]\[2\]
+ sky130_fd_sc_hd__edfxtp_1
Xnetwork.in_period\[89\]\[3\]$_DFFE_PP_ clknet_leaf_10_clk
+ net433 _03331_ VSS VSS VDD VDD network.in_period\[89\]\[3\]
+ sky130_fd_sc_hd__edfxtp_1
Xnetwork.in_period\[8\]\[0\]$_DFFE_PP_ clknet_leaf_57_clk
+ net453 _03332_ VSS VSS VDD VDD network.in_period\[8\]\[0\]
+ sky130_fd_sc_hd__edfxtp_1
Xnetwork.in_period\[8\]\[1\]$_DFFE_PP_ clknet_leaf_57_clk
+ net446 _03332_ VSS VSS VDD VDD network.in_period\[8\]\[1\]
+ sky130_fd_sc_hd__edfxtp_1
Xnetwork.in_period\[8\]\[2\]$_DFFE_PP_ clknet_leaf_58_clk
+ net438 _03332_ VSS VSS VDD VDD network.in_period\[8\]\[2\]
+ sky130_fd_sc_hd__edfxtp_1
Xnetwork.in_period\[8\]\[3\]$_DFFE_PP_ clknet_leaf_57_clk
+ net431 _03332_ VSS VSS VDD VDD network.in_period\[8\]\[3\]
+ sky130_fd_sc_hd__edfxtp_1
Xnetwork.in_period\[90\]\[0\]$_DFFE_PP_ clknet_leaf_17_clk
+ net454 _03333_ VSS VSS VDD VDD network.in_period\[90\]\[0\]
+ sky130_fd_sc_hd__edfxtp_1
Xnetwork.in_period\[90\]\[1\]$_DFFE_PP_ clknet_leaf_17_clk
+ net446 _03333_ VSS VSS VDD VDD network.in_period\[90\]\[1\]
+ sky130_fd_sc_hd__edfxtp_1
Xnetwork.in_period\[90\]\[2\]$_DFFE_PP_ clknet_leaf_16_clk
+ net438 _03333_ VSS VSS VDD VDD network.in_period\[90\]\[2\]
+ sky130_fd_sc_hd__edfxtp_1
Xnetwork.in_period\[90\]\[3\]$_DFFE_PP_ clknet_leaf_16_clk
+ net431 _03333_ VSS VSS VDD VDD network.in_period\[90\]\[3\]
+ sky130_fd_sc_hd__edfxtp_1
Xnetwork.in_period\[91\]\[0\]$_DFFE_PP_ clknet_leaf_18_clk
+ net454 _03334_ VSS VSS VDD VDD network.in_period\[91\]\[0\]
+ sky130_fd_sc_hd__edfxtp_1
Xnetwork.in_period\[91\]\[1\]$_DFFE_PP_ clknet_leaf_17_clk
+ net446 _03334_ VSS VSS VDD VDD network.in_period\[91\]\[1\]
+ sky130_fd_sc_hd__edfxtp_1
Xnetwork.in_period\[91\]\[2\]$_DFFE_PP_ clknet_leaf_18_clk
+ net438 _03334_ VSS VSS VDD VDD network.in_period\[91\]\[2\]
+ sky130_fd_sc_hd__edfxtp_1
Xnetwork.in_period\[91\]\[3\]$_DFFE_PP_ clknet_leaf_18_clk
+ net431 _03334_ VSS VSS VDD VDD network.in_period\[91\]\[3\]
+ sky130_fd_sc_hd__edfxtp_1
Xnetwork.in_period\[92\]\[0\]$_DFFE_PP_ clknet_leaf_15_clk
+ net454 _03335_ VSS VSS VDD VDD network.in_period\[92\]\[0\]
+ sky130_fd_sc_hd__edfxtp_1
Xnetwork.in_period\[92\]\[1\]$_DFFE_PP_ clknet_leaf_15_clk
+ net446 _03335_ VSS VSS VDD VDD network.in_period\[92\]\[1\]
+ sky130_fd_sc_hd__edfxtp_1
Xnetwork.in_period\[92\]\[2\]$_DFFE_PP_ clknet_leaf_15_clk
+ net438 _03335_ VSS VSS VDD VDD network.in_period\[92\]\[2\]
+ sky130_fd_sc_hd__edfxtp_1
Xnetwork.in_period\[92\]\[3\]$_DFFE_PP_ clknet_leaf_15_clk
+ net431 _03335_ VSS VSS VDD VDD network.in_period\[92\]\[3\]
+ sky130_fd_sc_hd__edfxtp_1
Xnetwork.in_period\[93\]\[0\]$_DFFE_PP_ clknet_leaf_14_clk
+ net454 _03336_ VSS VSS VDD VDD network.in_period\[93\]\[0\]
+ sky130_fd_sc_hd__edfxtp_1
Xnetwork.in_period\[93\]\[1\]$_DFFE_PP_ clknet_leaf_14_clk
+ net446 _03336_ VSS VSS VDD VDD network.in_period\[93\]\[1\]
+ sky130_fd_sc_hd__edfxtp_1
Xnetwork.in_period\[93\]\[2\]$_DFFE_PP_ clknet_leaf_14_clk
+ net438 _03336_ VSS VSS VDD VDD network.in_period\[93\]\[2\]
+ sky130_fd_sc_hd__edfxtp_1
Xnetwork.in_period\[93\]\[3\]$_DFFE_PP_ clknet_leaf_14_clk
+ net431 _03336_ VSS VSS VDD VDD network.in_period\[93\]\[3\]
+ sky130_fd_sc_hd__edfxtp_1
Xnetwork.in_period\[94\]\[0\]$_DFFE_PP_ clknet_leaf_15_clk
+ net454 _03337_ VSS VSS VDD VDD network.in_period\[94\]\[0\]
+ sky130_fd_sc_hd__edfxtp_1
Xnetwork.in_period\[94\]\[1\]$_DFFE_PP_ clknet_leaf_15_clk
+ net446 _03337_ VSS VSS VDD VDD network.in_period\[94\]\[1\]
+ sky130_fd_sc_hd__edfxtp_1
Xnetwork.in_period\[94\]\[2\]$_DFFE_PP_ clknet_leaf_15_clk
+ net438 _03337_ VSS VSS VDD VDD network.in_period\[94\]\[2\]
+ sky130_fd_sc_hd__edfxtp_1
Xnetwork.in_period\[94\]\[3\]$_DFFE_PP_ clknet_leaf_15_clk
+ net431 _03337_ VSS VSS VDD VDD network.in_period\[94\]\[3\]
+ sky130_fd_sc_hd__edfxtp_1
Xnetwork.in_period\[95\]\[0\]$_DFFE_PP_ clknet_leaf_16_clk
+ net454 _03338_ VSS VSS VDD VDD network.in_period\[95\]\[0\]
+ sky130_fd_sc_hd__edfxtp_1
Xnetwork.in_period\[95\]\[1\]$_DFFE_PP_ clknet_leaf_16_clk
+ net446 _03338_ VSS VSS VDD VDD network.in_period\[95\]\[1\]
+ sky130_fd_sc_hd__edfxtp_1
Xnetwork.in_period\[95\]\[2\]$_DFFE_PP_ clknet_leaf_14_clk
+ net438 _03338_ VSS VSS VDD VDD network.in_period\[95\]\[2\]
+ sky130_fd_sc_hd__edfxtp_1
Xnetwork.in_period\[95\]\[3\]$_DFFE_PP_ clknet_leaf_14_clk
+ net431 _03338_ VSS VSS VDD VDD network.in_period\[95\]\[3\]
+ sky130_fd_sc_hd__edfxtp_1
Xnetwork.in_period\[96\]\[0\]$_DFFE_PP_ clknet_leaf_23_clk
+ net454 _03339_ VSS VSS VDD VDD network.in_period\[96\]\[0\]
+ sky130_fd_sc_hd__edfxtp_1
Xnetwork.in_period\[96\]\[1\]$_DFFE_PP_ clknet_leaf_23_clk
+ net451 _03339_ VSS VSS VDD VDD network.in_period\[96\]\[1\]
+ sky130_fd_sc_hd__edfxtp_1
Xnetwork.in_period\[96\]\[2\]$_DFFE_PP_ clknet_leaf_23_clk
+ net439 _03339_ VSS VSS VDD VDD network.in_period\[96\]\[2\]
+ sky130_fd_sc_hd__edfxtp_1
Xnetwork.in_period\[96\]\[3\]$_DFFE_PP_ clknet_leaf_23_clk
+ net433 _03339_ VSS VSS VDD VDD network.in_period\[96\]\[3\]
+ sky130_fd_sc_hd__edfxtp_1
Xnetwork.in_period\[97\]\[0\]$_DFFE_PP_ clknet_leaf_32_clk
+ net454 _03340_ VSS VSS VDD VDD network.in_period\[97\]\[0\]
+ sky130_fd_sc_hd__edfxtp_1
Xnetwork.in_period\[97\]\[1\]$_DFFE_PP_ clknet_leaf_32_clk
+ net451 _03340_ VSS VSS VDD VDD network.in_period\[97\]\[1\]
+ sky130_fd_sc_hd__edfxtp_1
Xnetwork.in_period\[97\]\[2\]$_DFFE_PP_ clknet_leaf_32_clk
+ net439 _03340_ VSS VSS VDD VDD network.in_period\[97\]\[2\]
+ sky130_fd_sc_hd__edfxtp_1
Xnetwork.in_period\[97\]\[3\]$_DFFE_PP_ clknet_leaf_32_clk
+ net433 _03340_ VSS VSS VDD VDD network.in_period\[97\]\[3\]
+ sky130_fd_sc_hd__edfxtp_1
Xnetwork.in_period\[98\]\[0\]$_DFFE_PP_ clknet_leaf_23_clk
+ net454 _03341_ VSS VSS VDD VDD network.in_period\[98\]\[0\]
+ sky130_fd_sc_hd__edfxtp_1
Xnetwork.in_period\[98\]\[1\]$_DFFE_PP_ clknet_leaf_23_clk
+ net451 _03341_ VSS VSS VDD VDD network.in_period\[98\]\[1\]
+ sky130_fd_sc_hd__edfxtp_1
Xnetwork.in_period\[98\]\[2\]$_DFFE_PP_ clknet_leaf_24_clk
+ net439 _03341_ VSS VSS VDD VDD network.in_period\[98\]\[2\]
+ sky130_fd_sc_hd__edfxtp_1
Xnetwork.in_period\[98\]\[3\]$_DFFE_PP_ clknet_leaf_23_clk
+ net433 _03341_ VSS VSS VDD VDD network.in_period\[98\]\[3\]
+ sky130_fd_sc_hd__edfxtp_1
Xnetwork.in_period\[99\]\[0\]$_DFFE_PP_ clknet_leaf_24_clk
+ net454 _03342_ VSS VSS VDD VDD network.in_period\[99\]\[0\]
+ sky130_fd_sc_hd__edfxtp_1
Xnetwork.in_period\[99\]\[1\]$_DFFE_PP_ clknet_leaf_24_clk
+ net451 _03342_ VSS VSS VDD VDD network.in_period\[99\]\[1\]
+ sky130_fd_sc_hd__edfxtp_1
Xnetwork.in_period\[99\]\[2\]$_DFFE_PP_ clknet_leaf_24_clk
+ net444 _03342_ VSS VSS VDD VDD network.in_period\[99\]\[2\]
+ sky130_fd_sc_hd__edfxtp_1
Xnetwork.in_period\[99\]\[3\]$_DFFE_PP_ clknet_leaf_31_clk
+ net433 _03342_ VSS VSS VDD VDD network.in_period\[99\]\[3\]
+ sky130_fd_sc_hd__edfxtp_1
Xnetwork.in_period\[9\]\[0\]$_DFFE_PP_ clknet_leaf_61_clk
+ net453 _03343_ VSS VSS VDD VDD network.in_period\[9\]\[0\]
+ sky130_fd_sc_hd__edfxtp_1
Xnetwork.in_period\[9\]\[1\]$_DFFE_PP_ clknet_leaf_61_clk
+ net446 _03343_ VSS VSS VDD VDD network.in_period\[9\]\[1\]
+ sky130_fd_sc_hd__edfxtp_1
Xnetwork.in_period\[9\]\[2\]$_DFFE_PP_ clknet_leaf_61_clk
+ net438 _03343_ VSS VSS VDD VDD network.in_period\[9\]\[2\]
+ sky130_fd_sc_hd__edfxtp_1
Xnetwork.in_period\[9\]\[3\]$_DFFE_PP_ clknet_leaf_61_clk
+ net431 _03343_ VSS VSS VDD VDD network.in_period\[9\]\[3\]
+ sky130_fd_sc_hd__edfxtp_1
Xnetwork.neuron_hid0.IF0.membrane_potential\[0\]$_SDFF_PP0_
+ clknet_leaf_121_clk _01723_ VSS VSS VDD VDD network.neuron_hid0.IF0.membrane_potential\[0\]
+ sky130_fd_sc_hd__dfxtp_1
Xnetwork.neuron_hid0.IF0.membrane_potential\[10\]$_SDFF_PP0_
+ clknet_leaf_120_clk _01903_ VSS VSS VDD VDD network.neuron_hid0.IF0.membrane_potential\[10\]
+ sky130_fd_sc_hd__dfxtp_1
Xnetwork.neuron_hid0.IF0.membrane_potential\[1\]$_SDFF_PP0_
+ clknet_leaf_121_clk _01722_ VSS VSS VDD VDD network.neuron_hid0.IF0.membrane_potential\[1\]
+ sky130_fd_sc_hd__dfxtp_1
Xnetwork.neuron_hid0.IF0.membrane_potential\[2\]$_SDFF_PP0_
+ clknet_leaf_120_clk _01721_ VSS VSS VDD VDD network.neuron_hid0.IF0.membrane_potential\[2\]
+ sky130_fd_sc_hd__dfxtp_1
Xnetwork.neuron_hid0.IF0.membrane_potential\[3\]$_SDFF_PP0_
+ clknet_leaf_120_clk _01720_ VSS VSS VDD VDD network.neuron_hid0.IF0.membrane_potential\[3\]
+ sky130_fd_sc_hd__dfxtp_1
Xnetwork.neuron_hid0.IF0.membrane_potential\[4\]$_SDFF_PP0_
+ clknet_leaf_121_clk _01719_ VSS VSS VDD VDD network.neuron_hid0.IF0.membrane_potential\[4\]
+ sky130_fd_sc_hd__dfxtp_1
Xnetwork.neuron_hid0.IF0.membrane_potential\[5\]$_SDFF_PP0_
+ clknet_leaf_120_clk _01718_ VSS VSS VDD VDD network.neuron_hid0.IF0.membrane_potential\[5\]
+ sky130_fd_sc_hd__dfxtp_1
Xnetwork.neuron_hid0.IF0.membrane_potential\[6\]$_SDFF_PP0_
+ clknet_leaf_120_clk _01717_ VSS VSS VDD VDD network.neuron_hid0.IF0.membrane_potential\[6\]
+ sky130_fd_sc_hd__dfxtp_1
Xnetwork.neuron_hid0.IF0.membrane_potential\[7\]$_SDFF_PP0_
+ clknet_leaf_120_clk _01716_ VSS VSS VDD VDD network.neuron_hid0.IF0.membrane_potential\[7\]
+ sky130_fd_sc_hd__dfxtp_1
Xnetwork.neuron_hid0.IF0.membrane_potential\[8\]$_SDFF_PP0_
+ clknet_leaf_120_clk _01715_ VSS VSS VDD VDD network.neuron_hid0.IF0.membrane_potential\[8\]
+ sky130_fd_sc_hd__dfxtp_1
Xnetwork.neuron_hid0.IF0.membrane_potential\[9\]$_SDFF_PP0_
+ clknet_leaf_120_clk _01714_ VSS VSS VDD VDD network.neuron_hid0.IF0.membrane_potential\[9\]
+ sky130_fd_sc_hd__dfxtp_1
Xnetwork.neuron_hid0.IF0.ref_counter\[0\]$_SDFFE_PP0P_ clknet_leaf_122_clk
+ _01713_ VSS VSS VDD VDD network.neuron_hid0.IF0.ref_counter\[0\]
+ sky130_fd_sc_hd__dfxtp_1
Xnetwork.neuron_hid0.IF0.ref_counter\[1\]$_SDFFE_PP0P_ clknet_leaf_121_clk
+ _01907_ VSS VSS VDD VDD network.neuron_hid0.IF0.ref_counter\[1\]
+ sky130_fd_sc_hd__dfxtp_1
Xnetwork.neuron_hid0.IF_in\[0\]$_SDFF_PP0_ clknet_leaf_121_clk
+ _01551_ VSS VSS VDD VDD network.neuron_hid0.IF0.input_current\[0\]
+ sky130_fd_sc_hd__dfxtp_1
Xnetwork.neuron_hid0.IF_in\[1\]$_SDFF_PP0_ clknet_leaf_123_clk
+ _01550_ VSS VSS VDD VDD network.neuron_hid0.IF0.input_current\[1\]
+ sky130_fd_sc_hd__dfxtp_1
Xnetwork.neuron_hid0.IF_in\[2\]$_SDFF_PP0_ clknet_leaf_121_clk
+ _01549_ VSS VSS VDD VDD network.neuron_hid0.IF0.input_current\[2\]
+ sky130_fd_sc_hd__dfxtp_1
Xnetwork.neuron_hid0.IF_in\[3\]$_SDFF_PP0_ clknet_leaf_121_clk
+ _01548_ VSS VSS VDD VDD network.neuron_hid0.IF0.input_current\[3\]
+ sky130_fd_sc_hd__dfxtp_1
Xnetwork.neuron_hid0.IF_in\[4\]$_SDFF_PP0_ clknet_leaf_121_clk
+ _01769_ VSS VSS VDD VDD network.neuron_hid0.IF0.input_current\[4\]
+ sky130_fd_sc_hd__dfxtp_1
Xnetwork.neuron_hid0.ROM_address\[0\]$_SDFF_PP0_ clknet_leaf_109_clk
+ _01712_ VSS VSS VDD VDD network.neuron_hid0.ROM0.address\[0\]
+ sky130_fd_sc_hd__dfxtp_1
Xnetwork.neuron_hid0.ROM_address\[1\]$_SDFF_PP0_ clknet_leaf_146_clk
+ _01711_ VSS VSS VDD VDD network.neuron_hid0.ROM0.address\[1\]
+ sky130_fd_sc_hd__dfxtp_1
Xnetwork.neuron_hid0.ROM_address\[2\]$_SDFF_PP0_ clknet_leaf_109_clk
+ _01710_ VSS VSS VDD VDD network.neuron_hid0.ROM0.address\[2\]
+ sky130_fd_sc_hd__dfxtp_1
Xnetwork.neuron_hid0.ROM_address\[3\]$_SDFF_PP0_ clknet_leaf_108_clk
+ _01709_ VSS VSS VDD VDD network.neuron_hid0.ROM0.address\[3\]
+ sky130_fd_sc_hd__dfxtp_1
Xnetwork.neuron_hid0.ROM_address\[4\]$_SDFF_PP0_ clknet_leaf_145_clk
+ _01708_ VSS VSS VDD VDD network.neuron_hid0.ROM0.address\[4\]
+ sky130_fd_sc_hd__dfxtp_1
Xnetwork.neuron_hid0.ROM_address\[5\]$_SDFF_PP0_ clknet_leaf_153_clk
+ _01707_ VSS VSS VDD VDD network.neuron_hid0.ROM0.address\[5\]
+ sky130_fd_sc_hd__dfxtp_1
Xnetwork.neuron_hid0.ROM_address\[6\]$_SDFF_PP0_ clknet_leaf_145_clk
+ _01706_ VSS VSS VDD VDD network.neuron_hid0.ROM0.address\[6\]
+ sky130_fd_sc_hd__dfxtp_1
Xnetwork.neuron_hid0.ROM_address\[7\]$_SDFF_PP0_ clknet_leaf_146_clk
+ _01911_ VSS VSS VDD VDD network.neuron_hid0.ROM0.address\[7\]
+ sky130_fd_sc_hd__dfxtp_1
Xnetwork.neuron_hid0.enable$_SDFF_PP0_ clknet_leaf_145_clk
+ _01908_ VSS VSS VDD VDD network.neuron_hid0.ROM0.read_en sky130_fd_sc_hd__dfxtp_1
Xnetwork.neuron_hid0.spike_out$_SDFFE_PP0P_ clknet_leaf_136_clk
+ _01906_ VSS VSS VDD VDD network.hid_spk0 sky130_fd_sc_hd__dfxtp_1
Xnetwork.neuron_hid1.IF0.membrane_potential\[0\]$_SDFF_PP0_
+ clknet_leaf_124_clk _01705_ VSS VSS VDD VDD network.neuron_hid1.IF0.membrane_potential\[0\]
+ sky130_fd_sc_hd__dfxtp_1
Xnetwork.neuron_hid1.IF0.membrane_potential\[10\]$_SDFF_PP0_
+ clknet_leaf_125_clk _01910_ VSS VSS VDD VDD network.neuron_hid1.IF0.membrane_potential\[10\]
+ sky130_fd_sc_hd__dfxtp_1
Xnetwork.neuron_hid1.IF0.membrane_potential\[1\]$_SDFF_PP0_
+ clknet_leaf_124_clk _01704_ VSS VSS VDD VDD network.neuron_hid1.IF0.membrane_potential\[1\]
+ sky130_fd_sc_hd__dfxtp_1
Xnetwork.neuron_hid1.IF0.membrane_potential\[2\]$_SDFF_PP0_
+ clknet_leaf_124_clk _01703_ VSS VSS VDD VDD network.neuron_hid1.IF0.membrane_potential\[2\]
+ sky130_fd_sc_hd__dfxtp_1
Xnetwork.neuron_hid1.IF0.membrane_potential\[3\]$_SDFF_PP0_
+ clknet_leaf_124_clk _01702_ VSS VSS VDD VDD network.neuron_hid1.IF0.membrane_potential\[3\]
+ sky130_fd_sc_hd__dfxtp_1
Xnetwork.neuron_hid1.IF0.membrane_potential\[4\]$_SDFF_PP0_
+ clknet_leaf_125_clk _01701_ VSS VSS VDD VDD network.neuron_hid1.IF0.membrane_potential\[4\]
+ sky130_fd_sc_hd__dfxtp_1
Xnetwork.neuron_hid1.IF0.membrane_potential\[5\]$_SDFF_PP0_
+ clknet_leaf_125_clk _01700_ VSS VSS VDD VDD network.neuron_hid1.IF0.membrane_potential\[5\]
+ sky130_fd_sc_hd__dfxtp_1
Xnetwork.neuron_hid1.IF0.membrane_potential\[6\]$_SDFF_PP0_
+ clknet_leaf_125_clk _01699_ VSS VSS VDD VDD network.neuron_hid1.IF0.membrane_potential\[6\]
+ sky130_fd_sc_hd__dfxtp_1
Xnetwork.neuron_hid1.IF0.membrane_potential\[7\]$_SDFF_PP0_
+ clknet_leaf_124_clk _01698_ VSS VSS VDD VDD network.neuron_hid1.IF0.membrane_potential\[7\]
+ sky130_fd_sc_hd__dfxtp_1
Xnetwork.neuron_hid1.IF0.membrane_potential\[8\]$_SDFF_PP0_
+ clknet_leaf_125_clk _01697_ VSS VSS VDD VDD network.neuron_hid1.IF0.membrane_potential\[8\]
+ sky130_fd_sc_hd__dfxtp_1
Xnetwork.neuron_hid1.IF0.membrane_potential\[9\]$_SDFF_PP0_
+ clknet_leaf_125_clk _01696_ VSS VSS VDD VDD network.neuron_hid1.IF0.membrane_potential\[9\]
+ sky130_fd_sc_hd__dfxtp_1
Xnetwork.neuron_hid1.IF0.ref_counter\[0\]$_SDFFE_PP0P_ clknet_leaf_125_clk
+ _01695_ VSS VSS VDD VDD network.neuron_hid1.IF0.ref_counter\[0\]
+ sky130_fd_sc_hd__dfxtp_1
Xnetwork.neuron_hid1.IF0.ref_counter\[1\]$_SDFFE_PP0P_ clknet_leaf_125_clk
+ _01914_ VSS VSS VDD VDD network.neuron_hid1.IF0.ref_counter\[1\]
+ sky130_fd_sc_hd__dfxtp_1
Xnetwork.neuron_hid1.IF_in\[0\]$_SDFF_PP0_ clknet_leaf_124_clk
+ _01509_ VSS VSS VDD VDD network.neuron_hid1.IF0.input_current\[0\]
+ sky130_fd_sc_hd__dfxtp_1
Xnetwork.neuron_hid1.IF_in\[1\]$_SDFF_PP0_ clknet_leaf_124_clk
+ _01511_ VSS VSS VDD VDD network.neuron_hid1.IF0.input_current\[1\]
+ sky130_fd_sc_hd__dfxtp_1
Xnetwork.neuron_hid1.IF_in\[2\]$_SDFF_PP0_ clknet_leaf_124_clk
+ _01510_ VSS VSS VDD VDD network.neuron_hid1.IF0.input_current\[2\]
+ sky130_fd_sc_hd__dfxtp_1
Xnetwork.neuron_hid1.IF_in\[3\]$_SDFF_PP0_ clknet_leaf_124_clk
+ _01508_ VSS VSS VDD VDD network.neuron_hid1.IF0.input_current\[3\]
+ sky130_fd_sc_hd__dfxtp_1
Xnetwork.neuron_hid1.IF_in\[4\]$_SDFF_PP0_ clknet_leaf_124_clk
+ _01766_ VSS VSS VDD VDD network.neuron_hid1.IF0.input_current\[4\]
+ sky130_fd_sc_hd__dfxtp_1
Xnetwork.neuron_hid1.spike_out$_SDFFE_PP0P_ clknet_leaf_135_clk
+ _01912_ VSS VSS VDD VDD network.hid_spk1 sky130_fd_sc_hd__dfxtp_1
Xnetwork.neuron_hid2.IF0.membrane_potential\[0\]$_SDFF_PP0_
+ clknet_leaf_131_clk _01694_ VSS VSS VDD VDD network.neuron_hid2.IF0.membrane_potential\[0\]
+ sky130_fd_sc_hd__dfxtp_1
Xnetwork.neuron_hid2.IF0.membrane_potential\[10\]$_SDFF_PP0_
+ clknet_leaf_136_clk _01915_ VSS VSS VDD VDD network.neuron_hid2.IF0.membrane_potential\[10\]
+ sky130_fd_sc_hd__dfxtp_1
Xnetwork.neuron_hid2.IF0.membrane_potential\[1\]$_SDFF_PP0_
+ clknet_leaf_131_clk _01693_ VSS VSS VDD VDD network.neuron_hid2.IF0.membrane_potential\[1\]
+ sky130_fd_sc_hd__dfxtp_1
Xnetwork.neuron_hid2.IF0.membrane_potential\[2\]$_SDFF_PP0_
+ clknet_leaf_132_clk _01692_ VSS VSS VDD VDD network.neuron_hid2.IF0.membrane_potential\[2\]
+ sky130_fd_sc_hd__dfxtp_1
Xnetwork.neuron_hid2.IF0.membrane_potential\[3\]$_SDFF_PP0_
+ clknet_leaf_132_clk _01691_ VSS VSS VDD VDD network.neuron_hid2.IF0.membrane_potential\[3\]
+ sky130_fd_sc_hd__dfxtp_1
Xnetwork.neuron_hid2.IF0.membrane_potential\[4\]$_SDFF_PP0_
+ clknet_leaf_131_clk _01690_ VSS VSS VDD VDD network.neuron_hid2.IF0.membrane_potential\[4\]
+ sky130_fd_sc_hd__dfxtp_1
Xnetwork.neuron_hid2.IF0.membrane_potential\[5\]$_SDFF_PP0_
+ clknet_leaf_132_clk _01689_ VSS VSS VDD VDD network.neuron_hid2.IF0.membrane_potential\[5\]
+ sky130_fd_sc_hd__dfxtp_1
Xnetwork.neuron_hid2.IF0.membrane_potential\[6\]$_SDFF_PP0_
+ clknet_leaf_132_clk _01688_ VSS VSS VDD VDD network.neuron_hid2.IF0.membrane_potential\[6\]
+ sky130_fd_sc_hd__dfxtp_1
Xnetwork.neuron_hid2.IF0.membrane_potential\[7\]$_SDFF_PP0_
+ clknet_leaf_132_clk _01687_ VSS VSS VDD VDD network.neuron_hid2.IF0.membrane_potential\[7\]
+ sky130_fd_sc_hd__dfxtp_1
Xnetwork.neuron_hid2.IF0.membrane_potential\[8\]$_SDFF_PP0_
+ clknet_leaf_136_clk _01686_ VSS VSS VDD VDD network.neuron_hid2.IF0.membrane_potential\[8\]
+ sky130_fd_sc_hd__dfxtp_1
Xnetwork.neuron_hid2.IF0.membrane_potential\[9\]$_SDFF_PP0_
+ clknet_leaf_136_clk _01685_ VSS VSS VDD VDD network.neuron_hid2.IF0.membrane_potential\[9\]
+ sky130_fd_sc_hd__dfxtp_1
Xnetwork.neuron_hid2.IF0.ref_counter\[0\]$_SDFFE_PP0P_ clknet_leaf_133_clk
+ _01684_ VSS VSS VDD VDD network.neuron_hid2.IF0.ref_counter\[0\]
+ sky130_fd_sc_hd__dfxtp_1
Xnetwork.neuron_hid2.IF0.ref_counter\[1\]$_SDFFE_PP0P_ clknet_leaf_133_clk
+ _01919_ VSS VSS VDD VDD network.neuron_hid2.IF0.ref_counter\[1\]
+ sky130_fd_sc_hd__dfxtp_1
Xnetwork.neuron_hid2.IF_in\[0\]$_SDFF_PP0_ clknet_leaf_128_clk
+ _01751_ VSS VSS VDD VDD network.neuron_hid2.IF0.input_current\[0\]
+ sky130_fd_sc_hd__dfxtp_1
Xnetwork.neuron_hid2.IF_in\[1\]$_SDFF_PP0_ clknet_leaf_128_clk
+ _01750_ VSS VSS VDD VDD network.neuron_hid2.IF0.input_current\[1\]
+ sky130_fd_sc_hd__dfxtp_1
Xnetwork.neuron_hid2.IF_in\[2\]$_SDFF_PP0_ clknet_leaf_131_clk
+ _01749_ VSS VSS VDD VDD network.neuron_hid2.IF0.input_current\[2\]
+ sky130_fd_sc_hd__dfxtp_1
Xnetwork.neuron_hid2.IF_in\[3\]$_SDFF_PP0_ clknet_leaf_128_clk
+ _01748_ VSS VSS VDD VDD network.neuron_hid2.IF0.input_current\[3\]
+ sky130_fd_sc_hd__dfxtp_1
Xnetwork.neuron_hid2.spike_out$_SDFFE_PP0P_ clknet_leaf_136_clk
+ _01917_ VSS VSS VDD VDD network.hid_spk2 sky130_fd_sc_hd__dfxtp_1
Xnetwork.neuron_hid3.IF0.membrane_potential\[0\]$_SDFF_PP0_
+ clknet_leaf_131_clk _01683_ VSS VSS VDD VDD network.neuron_hid3.IF0.membrane_potential\[0\]
+ sky130_fd_sc_hd__dfxtp_1
Xnetwork.neuron_hid3.IF0.membrane_potential\[10\]$_SDFF_PP0_
+ clknet_leaf_133_clk _01921_ VSS VSS VDD VDD network.neuron_hid3.IF0.membrane_potential\[10\]
+ sky130_fd_sc_hd__dfxtp_1
Xnetwork.neuron_hid3.IF0.membrane_potential\[1\]$_SDFF_PP0_
+ clknet_leaf_130_clk _01682_ VSS VSS VDD VDD network.neuron_hid3.IF0.membrane_potential\[1\]
+ sky130_fd_sc_hd__dfxtp_1
Xnetwork.neuron_hid3.IF0.membrane_potential\[2\]$_SDFF_PP0_
+ clknet_leaf_130_clk _01681_ VSS VSS VDD VDD network.neuron_hid3.IF0.membrane_potential\[2\]
+ sky130_fd_sc_hd__dfxtp_1
Xnetwork.neuron_hid3.IF0.membrane_potential\[3\]$_SDFF_PP0_
+ clknet_leaf_130_clk _01680_ VSS VSS VDD VDD network.neuron_hid3.IF0.membrane_potential\[3\]
+ sky130_fd_sc_hd__dfxtp_1
Xnetwork.neuron_hid3.IF0.membrane_potential\[4\]$_SDFF_PP0_
+ clknet_leaf_130_clk _01679_ VSS VSS VDD VDD network.neuron_hid3.IF0.membrane_potential\[4\]
+ sky130_fd_sc_hd__dfxtp_1
Xnetwork.neuron_hid3.IF0.membrane_potential\[5\]$_SDFF_PP0_
+ clknet_leaf_130_clk _01678_ VSS VSS VDD VDD network.neuron_hid3.IF0.membrane_potential\[5\]
+ sky130_fd_sc_hd__dfxtp_1
Xnetwork.neuron_hid3.IF0.membrane_potential\[6\]$_SDFF_PP0_
+ clknet_leaf_132_clk _01677_ VSS VSS VDD VDD network.neuron_hid3.IF0.membrane_potential\[6\]
+ sky130_fd_sc_hd__dfxtp_1
Xnetwork.neuron_hid3.IF0.membrane_potential\[7\]$_SDFF_PP0_
+ clknet_leaf_132_clk _01676_ VSS VSS VDD VDD network.neuron_hid3.IF0.membrane_potential\[7\]
+ sky130_fd_sc_hd__dfxtp_1
Xnetwork.neuron_hid3.IF0.membrane_potential\[8\]$_SDFF_PP0_
+ clknet_leaf_132_clk _01675_ VSS VSS VDD VDD network.neuron_hid3.IF0.membrane_potential\[8\]
+ sky130_fd_sc_hd__dfxtp_1
Xnetwork.neuron_hid3.IF0.membrane_potential\[9\]$_SDFF_PP0_
+ clknet_leaf_132_clk _01674_ VSS VSS VDD VDD network.neuron_hid3.IF0.membrane_potential\[9\]
+ sky130_fd_sc_hd__dfxtp_1
Xnetwork.neuron_hid3.IF0.ref_counter\[0\]$_SDFFE_PP0P_ clknet_leaf_133_clk
+ _01673_ VSS VSS VDD VDD network.neuron_hid3.IF0.ref_counter\[0\]
+ sky130_fd_sc_hd__dfxtp_1
Xnetwork.neuron_hid3.IF0.ref_counter\[1\]$_SDFFE_PP0P_ clknet_leaf_133_clk
+ _01920_ VSS VSS VDD VDD network.neuron_hid3.IF0.ref_counter\[1\]
+ sky130_fd_sc_hd__dfxtp_1
Xnetwork.neuron_hid3.IF_in\[0\]$_SDFF_PP0_ clknet_leaf_129_clk
+ _01754_ VSS VSS VDD VDD network.neuron_hid3.IF0.input_current\[0\]
+ sky130_fd_sc_hd__dfxtp_1
Xnetwork.neuron_hid3.IF_in\[1\]$_SDFF_PP0_ clknet_leaf_128_clk
+ _01753_ VSS VSS VDD VDD network.neuron_hid3.IF0.input_current\[1\]
+ sky130_fd_sc_hd__dfxtp_1
Xnetwork.neuron_hid3.IF_in\[2\]$_SDFF_PP0_ clknet_leaf_131_clk
+ _01752_ VSS VSS VDD VDD network.neuron_hid3.IF0.input_current\[2\]
+ sky130_fd_sc_hd__dfxtp_1
Xnetwork.neuron_hid3.IF_in\[5\]$_SDFF_PP0_ clknet_leaf_128_clk
+ _01758_ VSS VSS VDD VDD network.neuron_hid2.IF0.input_current\[5\]
+ sky130_fd_sc_hd__dfxtp_1
Xnetwork.neuron_hid3.spike_out$_SDFFE_PP0P_ clknet_leaf_135_clk
+ _01924_ VSS VSS VDD VDD network.hid_spk3 sky130_fd_sc_hd__dfxtp_1
Xnetwork.neuron_hid4.IF0.membrane_potential\[0\]$_SDFF_PP0_
+ clknet_leaf_143_clk _01672_ VSS VSS VDD VDD network.neuron_hid4.IF0.membrane_potential\[0\]
+ sky130_fd_sc_hd__dfxtp_1
Xnetwork.neuron_hid4.IF0.membrane_potential\[10\]$_SDFF_PP0_
+ clknet_leaf_138_clk _01922_ VSS VSS VDD VDD network.neuron_hid4.IF0.membrane_potential\[10\]
+ sky130_fd_sc_hd__dfxtp_1
Xnetwork.neuron_hid4.IF0.membrane_potential\[1\]$_SDFF_PP0_
+ clknet_leaf_137_clk _01671_ VSS VSS VDD VDD network.neuron_hid4.IF0.membrane_potential\[1\]
+ sky130_fd_sc_hd__dfxtp_1
Xnetwork.neuron_hid4.IF0.membrane_potential\[2\]$_SDFF_PP0_
+ clknet_leaf_137_clk _01670_ VSS VSS VDD VDD network.neuron_hid4.IF0.membrane_potential\[2\]
+ sky130_fd_sc_hd__dfxtp_1
Xnetwork.neuron_hid4.IF0.membrane_potential\[3\]$_SDFF_PP0_
+ clknet_leaf_142_clk _01669_ VSS VSS VDD VDD network.neuron_hid4.IF0.membrane_potential\[3\]
+ sky130_fd_sc_hd__dfxtp_1
Xnetwork.neuron_hid4.IF0.membrane_potential\[4\]$_SDFF_PP0_
+ clknet_leaf_142_clk _01668_ VSS VSS VDD VDD network.neuron_hid4.IF0.membrane_potential\[4\]
+ sky130_fd_sc_hd__dfxtp_1
Xnetwork.neuron_hid4.IF0.membrane_potential\[5\]$_SDFF_PP0_
+ clknet_leaf_142_clk _01667_ VSS VSS VDD VDD network.neuron_hid4.IF0.membrane_potential\[5\]
+ sky130_fd_sc_hd__dfxtp_1
Xnetwork.neuron_hid4.IF0.membrane_potential\[6\]$_SDFF_PP0_
+ clknet_leaf_137_clk _01666_ VSS VSS VDD VDD network.neuron_hid4.IF0.membrane_potential\[6\]
+ sky130_fd_sc_hd__dfxtp_1
Xnetwork.neuron_hid4.IF0.membrane_potential\[7\]$_SDFF_PP0_
+ clknet_leaf_141_clk _01665_ VSS VSS VDD VDD network.neuron_hid4.IF0.membrane_potential\[7\]
+ sky130_fd_sc_hd__dfxtp_1
Xnetwork.neuron_hid4.IF0.membrane_potential\[8\]$_SDFF_PP0_
+ clknet_leaf_141_clk _01664_ VSS VSS VDD VDD network.neuron_hid4.IF0.membrane_potential\[8\]
+ sky130_fd_sc_hd__dfxtp_1
Xnetwork.neuron_hid4.IF0.membrane_potential\[9\]$_SDFF_PP0_
+ clknet_leaf_138_clk _01663_ VSS VSS VDD VDD network.neuron_hid4.IF0.membrane_potential\[9\]
+ sky130_fd_sc_hd__dfxtp_1
Xnetwork.neuron_hid4.IF0.ref_counter\[0\]$_SDFFE_PP0P_ clknet_leaf_138_clk
+ _01662_ VSS VSS VDD VDD network.neuron_hid4.IF0.ref_counter\[0\]
+ sky130_fd_sc_hd__dfxtp_1
Xnetwork.neuron_hid4.IF0.ref_counter\[1\]$_SDFFE_PP0P_ clknet_leaf_138_clk
+ _01926_ VSS VSS VDD VDD network.neuron_hid4.IF0.ref_counter\[1\]
+ sky130_fd_sc_hd__dfxtp_1
Xnetwork.neuron_hid4.IF_in\[0\]$_SDFF_PP0_ clknet_leaf_127_clk
+ _01519_ VSS VSS VDD VDD network.neuron_hid4.IF0.input_current\[0\]
+ sky130_fd_sc_hd__dfxtp_1
Xnetwork.neuron_hid4.IF_in\[1\]$_SDFF_PP0_ clknet_leaf_144_clk
+ _01518_ VSS VSS VDD VDD network.neuron_hid4.IF0.input_current\[1\]
+ sky130_fd_sc_hd__dfxtp_1
Xnetwork.neuron_hid4.IF_in\[2\]$_SDFF_PP0_ clknet_leaf_127_clk
+ _01517_ VSS VSS VDD VDD network.neuron_hid4.IF0.input_current\[2\]
+ sky130_fd_sc_hd__dfxtp_1
Xnetwork.neuron_hid4.IF_in\[3\]$_SDFF_PP0_ clknet_leaf_127_clk
+ _01516_ VSS VSS VDD VDD network.neuron_hid4.IF0.input_current\[3\]
+ sky130_fd_sc_hd__dfxtp_1
Xnetwork.neuron_hid4.IF_in\[4\]$_SDFF_PP0_ clknet_leaf_127_clk
+ _01757_ VSS VSS VDD VDD network.neuron_hid4.IF0.input_current\[4\]
+ sky130_fd_sc_hd__dfxtp_1
Xnetwork.neuron_hid4.spike_out$_SDFFE_PP0P_ clknet_leaf_136_clk
+ _01925_ VSS VSS VDD VDD network.hid_spk4 sky130_fd_sc_hd__dfxtp_1
Xnetwork.neuron_hid5.IF0.membrane_potential\[0\]$_SDFF_PP0_
+ clknet_leaf_127_clk _01661_ VSS VSS VDD VDD network.neuron_hid5.IF0.membrane_potential\[0\]
+ sky130_fd_sc_hd__dfxtp_1
Xnetwork.neuron_hid5.IF0.membrane_potential\[10\]$_SDFF_PP0_
+ clknet_leaf_142_clk _01927_ VSS VSS VDD VDD network.neuron_hid5.IF0.membrane_potential\[10\]
+ sky130_fd_sc_hd__dfxtp_1
Xnetwork.neuron_hid5.IF0.membrane_potential\[1\]$_SDFF_PP0_
+ clknet_leaf_127_clk _01660_ VSS VSS VDD VDD network.neuron_hid5.IF0.membrane_potential\[1\]
+ sky130_fd_sc_hd__dfxtp_1
Xnetwork.neuron_hid5.IF0.membrane_potential\[2\]$_SDFF_PP0_
+ clknet_leaf_143_clk _01659_ VSS VSS VDD VDD network.neuron_hid5.IF0.membrane_potential\[2\]
+ sky130_fd_sc_hd__dfxtp_1
Xnetwork.neuron_hid5.IF0.membrane_potential\[3\]$_SDFF_PP0_
+ clknet_leaf_143_clk _01658_ VSS VSS VDD VDD network.neuron_hid5.IF0.membrane_potential\[3\]
+ sky130_fd_sc_hd__dfxtp_1
Xnetwork.neuron_hid5.IF0.membrane_potential\[4\]$_SDFF_PP0_
+ clknet_leaf_144_clk _01657_ VSS VSS VDD VDD network.neuron_hid5.IF0.membrane_potential\[4\]
+ sky130_fd_sc_hd__dfxtp_1
Xnetwork.neuron_hid5.IF0.membrane_potential\[5\]$_SDFF_PP0_
+ clknet_leaf_143_clk _01656_ VSS VSS VDD VDD network.neuron_hid5.IF0.membrane_potential\[5\]
+ sky130_fd_sc_hd__dfxtp_1
Xnetwork.neuron_hid5.IF0.membrane_potential\[6\]$_SDFF_PP0_
+ clknet_leaf_143_clk _01655_ VSS VSS VDD VDD network.neuron_hid5.IF0.membrane_potential\[6\]
+ sky130_fd_sc_hd__dfxtp_1
Xnetwork.neuron_hid5.IF0.membrane_potential\[7\]$_SDFF_PP0_
+ clknet_leaf_143_clk _01654_ VSS VSS VDD VDD network.neuron_hid5.IF0.membrane_potential\[7\]
+ sky130_fd_sc_hd__dfxtp_1
Xnetwork.neuron_hid5.IF0.membrane_potential\[8\]$_SDFF_PP0_
+ clknet_leaf_143_clk _01653_ VSS VSS VDD VDD network.neuron_hid5.IF0.membrane_potential\[8\]
+ sky130_fd_sc_hd__dfxtp_1
Xnetwork.neuron_hid5.IF0.membrane_potential\[9\]$_SDFF_PP0_
+ clknet_leaf_142_clk _01652_ VSS VSS VDD VDD network.neuron_hid5.IF0.membrane_potential\[9\]
+ sky130_fd_sc_hd__dfxtp_1
Xnetwork.neuron_hid5.IF0.ref_counter\[0\]$_SDFFE_PP0P_ clknet_leaf_141_clk
+ _01651_ VSS VSS VDD VDD network.neuron_hid5.IF0.ref_counter\[0\]
+ sky130_fd_sc_hd__dfxtp_1
Xnetwork.neuron_hid5.IF0.ref_counter\[1\]$_SDFFE_PP0P_ clknet_leaf_142_clk
+ _01930_ VSS VSS VDD VDD network.neuron_hid5.IF0.ref_counter\[1\]
+ sky130_fd_sc_hd__dfxtp_1
Xnetwork.neuron_hid5.IF_in\[0\]$_SDFF_PP0_ clknet_leaf_144_clk
+ _01515_ VSS VSS VDD VDD network.neuron_hid5.IF0.input_current\[0\]
+ sky130_fd_sc_hd__dfxtp_1
Xnetwork.neuron_hid5.IF_in\[1\]$_SDFF_PP0_ clknet_leaf_127_clk
+ _01514_ VSS VSS VDD VDD network.neuron_hid5.IF0.input_current\[1\]
+ sky130_fd_sc_hd__dfxtp_1
Xnetwork.neuron_hid5.IF_in\[2\]$_SDFF_PP0_ clknet_leaf_127_clk
+ _01513_ VSS VSS VDD VDD network.neuron_hid5.IF0.input_current\[2\]
+ sky130_fd_sc_hd__dfxtp_1
Xnetwork.neuron_hid5.IF_in\[3\]$_SDFF_PP0_ clknet_leaf_144_clk
+ _01512_ VSS VSS VDD VDD network.neuron_hid5.IF0.input_current\[3\]
+ sky130_fd_sc_hd__dfxtp_1
Xnetwork.neuron_hid5.IF_in\[4\]$_SDFF_PP0_ clknet_leaf_144_clk
+ _01755_ VSS VSS VDD VDD network.neuron_hid5.IF0.input_current\[4\]
+ sky130_fd_sc_hd__dfxtp_1
Xnetwork.neuron_hid5.spike_out$_SDFFE_PP0P_ clknet_leaf_136_clk
+ _01929_ VSS VSS VDD VDD network.hid_spk5 sky130_fd_sc_hd__dfxtp_1
Xnetwork.neuron_hid6.IF0.membrane_potential\[0\]$_SDFF_PP0_
+ clknet_leaf_129_clk _01650_ VSS VSS VDD VDD network.neuron_hid6.IF0.membrane_potential\[0\]
+ sky130_fd_sc_hd__dfxtp_1
Xnetwork.neuron_hid6.IF0.membrane_potential\[10\]$_SDFF_PP0_
+ clknet_leaf_130_clk _01931_ VSS VSS VDD VDD network.neuron_hid6.IF0.membrane_potential\[10\]
+ sky130_fd_sc_hd__dfxtp_1
Xnetwork.neuron_hid6.IF0.membrane_potential\[1\]$_SDFF_PP0_
+ clknet_leaf_129_clk _01649_ VSS VSS VDD VDD network.neuron_hid6.IF0.membrane_potential\[1\]
+ sky130_fd_sc_hd__dfxtp_1
Xnetwork.neuron_hid6.IF0.membrane_potential\[2\]$_SDFF_PP0_
+ clknet_leaf_129_clk _01648_ VSS VSS VDD VDD network.neuron_hid6.IF0.membrane_potential\[2\]
+ sky130_fd_sc_hd__dfxtp_1
Xnetwork.neuron_hid6.IF0.membrane_potential\[3\]$_SDFF_PP0_
+ clknet_leaf_129_clk _01647_ VSS VSS VDD VDD network.neuron_hid6.IF0.membrane_potential\[3\]
+ sky130_fd_sc_hd__dfxtp_1
Xnetwork.neuron_hid6.IF0.membrane_potential\[4\]$_SDFF_PP0_
+ clknet_leaf_129_clk _01646_ VSS VSS VDD VDD network.neuron_hid6.IF0.membrane_potential\[4\]
+ sky130_fd_sc_hd__dfxtp_1
Xnetwork.neuron_hid6.IF0.membrane_potential\[5\]$_SDFF_PP0_
+ clknet_leaf_129_clk _01645_ VSS VSS VDD VDD network.neuron_hid6.IF0.membrane_potential\[5\]
+ sky130_fd_sc_hd__dfxtp_1
Xnetwork.neuron_hid6.IF0.membrane_potential\[6\]$_SDFF_PP0_
+ clknet_leaf_129_clk _01644_ VSS VSS VDD VDD network.neuron_hid6.IF0.membrane_potential\[6\]
+ sky130_fd_sc_hd__dfxtp_1
Xnetwork.neuron_hid6.IF0.membrane_potential\[7\]$_SDFF_PP0_
+ clknet_leaf_130_clk _01643_ VSS VSS VDD VDD network.neuron_hid6.IF0.membrane_potential\[7\]
+ sky130_fd_sc_hd__dfxtp_1
Xnetwork.neuron_hid6.IF0.membrane_potential\[8\]$_SDFF_PP0_
+ clknet_leaf_130_clk _01642_ VSS VSS VDD VDD network.neuron_hid6.IF0.membrane_potential\[8\]
+ sky130_fd_sc_hd__dfxtp_1
Xnetwork.neuron_hid6.IF0.membrane_potential\[9\]$_SDFF_PP0_
+ clknet_leaf_129_clk _01641_ VSS VSS VDD VDD network.neuron_hid6.IF0.membrane_potential\[9\]
+ sky130_fd_sc_hd__dfxtp_1
Xnetwork.neuron_hid6.IF0.ref_counter\[0\]$_SDFFE_PP0P_ clknet_leaf_130_clk
+ _01640_ VSS VSS VDD VDD network.neuron_hid6.IF0.ref_counter\[0\]
+ sky130_fd_sc_hd__dfxtp_1
Xnetwork.neuron_hid6.IF0.ref_counter\[1\]$_SDFFE_PP0P_ clknet_leaf_130_clk
+ _01935_ VSS VSS VDD VDD network.neuron_hid6.IF0.ref_counter\[1\]
+ sky130_fd_sc_hd__dfxtp_1
Xnetwork.neuron_hid6.IF_in\[0\]$_SDFF_PP0_ clknet_leaf_126_clk
+ _01523_ VSS VSS VDD VDD network.neuron_hid6.IF0.input_current\[0\]
+ sky130_fd_sc_hd__dfxtp_1
Xnetwork.neuron_hid6.IF_in\[1\]$_SDFF_PP0_ clknet_leaf_126_clk
+ _01522_ VSS VSS VDD VDD network.neuron_hid6.IF0.input_current\[1\]
+ sky130_fd_sc_hd__dfxtp_1
Xnetwork.neuron_hid6.IF_in\[2\]$_SDFF_PP0_ clknet_leaf_126_clk
+ _01521_ VSS VSS VDD VDD network.neuron_hid6.IF0.input_current\[2\]
+ sky130_fd_sc_hd__dfxtp_1
Xnetwork.neuron_hid6.IF_in\[3\]$_SDFF_PP0_ clknet_leaf_129_clk
+ _01520_ VSS VSS VDD VDD network.neuron_hid6.IF0.input_current\[3\]
+ sky130_fd_sc_hd__dfxtp_1
Xnetwork.neuron_hid6.IF_in\[4\]$_SDFF_PP0_ clknet_leaf_126_clk
+ _01762_ VSS VSS VDD VDD network.neuron_hid6.IF0.input_current\[4\]
+ sky130_fd_sc_hd__dfxtp_1
Xnetwork.neuron_hid6.spike_out$_SDFFE_PP0P_ clknet_leaf_135_clk
+ _01934_ VSS VSS VDD VDD network.hid_spk6 sky130_fd_sc_hd__dfxtp_1
Xnetwork.neuron_hid7.IF0.membrane_potential\[0\]$_SDFF_PP0_
+ clknet_leaf_127_clk _01639_ VSS VSS VDD VDD network.neuron_hid7.IF0.membrane_potential\[0\]
+ sky130_fd_sc_hd__dfxtp_1
Xnetwork.neuron_hid7.IF0.membrane_potential\[10\]$_SDFF_PP0_
+ clknet_leaf_137_clk _01936_ VSS VSS VDD VDD network.neuron_hid7.IF0.membrane_potential\[10\]
+ sky130_fd_sc_hd__dfxtp_1
Xnetwork.neuron_hid7.IF0.membrane_potential\[1\]$_SDFF_PP0_
+ clknet_leaf_131_clk _01638_ VSS VSS VDD VDD network.neuron_hid7.IF0.membrane_potential\[1\]
+ sky130_fd_sc_hd__dfxtp_1
Xnetwork.neuron_hid7.IF0.membrane_potential\[2\]$_SDFF_PP0_
+ clknet_leaf_143_clk _01637_ VSS VSS VDD VDD network.neuron_hid7.IF0.membrane_potential\[2\]
+ sky130_fd_sc_hd__dfxtp_1
Xnetwork.neuron_hid7.IF0.membrane_potential\[3\]$_SDFF_PP0_
+ clknet_leaf_128_clk _01636_ VSS VSS VDD VDD network.neuron_hid7.IF0.membrane_potential\[3\]
+ sky130_fd_sc_hd__dfxtp_1
Xnetwork.neuron_hid7.IF0.membrane_potential\[4\]$_SDFF_PP0_
+ clknet_leaf_137_clk _01635_ VSS VSS VDD VDD network.neuron_hid7.IF0.membrane_potential\[4\]
+ sky130_fd_sc_hd__dfxtp_1
Xnetwork.neuron_hid7.IF0.membrane_potential\[5\]$_SDFF_PP0_
+ clknet_leaf_131_clk _01634_ VSS VSS VDD VDD network.neuron_hid7.IF0.membrane_potential\[5\]
+ sky130_fd_sc_hd__dfxtp_1
Xnetwork.neuron_hid7.IF0.membrane_potential\[6\]$_SDFF_PP0_
+ clknet_leaf_137_clk _01633_ VSS VSS VDD VDD network.neuron_hid7.IF0.membrane_potential\[6\]
+ sky130_fd_sc_hd__dfxtp_1
Xnetwork.neuron_hid7.IF0.membrane_potential\[7\]$_SDFF_PP0_
+ clknet_leaf_136_clk _01632_ VSS VSS VDD VDD network.neuron_hid7.IF0.membrane_potential\[7\]
+ sky130_fd_sc_hd__dfxtp_1
Xnetwork.neuron_hid7.IF0.membrane_potential\[8\]$_SDFF_PP0_
+ clknet_leaf_137_clk _01631_ VSS VSS VDD VDD network.neuron_hid7.IF0.membrane_potential\[8\]
+ sky130_fd_sc_hd__dfxtp_1
Xnetwork.neuron_hid7.IF0.membrane_potential\[9\]$_SDFF_PP0_
+ clknet_leaf_137_clk _01630_ VSS VSS VDD VDD network.neuron_hid7.IF0.membrane_potential\[9\]
+ sky130_fd_sc_hd__dfxtp_1
Xnetwork.neuron_hid7.IF0.ref_counter\[0\]$_SDFFE_PP0P_ clknet_leaf_136_clk
+ _01629_ VSS VSS VDD VDD network.neuron_hid7.IF0.ref_counter\[0\]
+ sky130_fd_sc_hd__dfxtp_1
Xnetwork.neuron_hid7.IF0.ref_counter\[1\]$_SDFFE_PP0P_ clknet_leaf_138_clk
+ _01939_ VSS VSS VDD VDD network.neuron_hid7.IF0.ref_counter\[1\]
+ sky130_fd_sc_hd__dfxtp_1
Xnetwork.neuron_hid7.IF_in\[0\]$_SDFF_PP0_ clknet_leaf_127_clk
+ _01747_ VSS VSS VDD VDD network.neuron_hid7.IF0.input_current\[0\]
+ sky130_fd_sc_hd__dfxtp_1
Xnetwork.neuron_hid7.IF_in\[1\]$_SDFF_PP0_ clknet_leaf_128_clk
+ _01746_ VSS VSS VDD VDD network.neuron_hid7.IF0.input_current\[1\]
+ sky130_fd_sc_hd__dfxtp_1
Xnetwork.neuron_hid7.IF_in\[2\]$_SDFF_PP0_ clknet_leaf_128_clk
+ _01745_ VSS VSS VDD VDD network.neuron_hid7.IF0.input_current\[2\]
+ sky130_fd_sc_hd__dfxtp_1
Xnetwork.neuron_hid7.IF_in\[3\]$_SDFF_PP0_ clknet_leaf_131_clk
+ _01744_ VSS VSS VDD VDD network.neuron_hid7.IF0.input_current\[3\]
+ sky130_fd_sc_hd__dfxtp_1
Xnetwork.neuron_hid7.IF_in\[4\]$_SDFF_PP0_ clknet_leaf_127_clk
+ _01761_ VSS VSS VDD VDD network.neuron_hid2.IF0.input_current\[4\]
+ sky130_fd_sc_hd__dfxtp_1
Xnetwork.neuron_hid7.IF_in\[6\]$_SDFF_PP0_ clknet_leaf_128_clk
+ _01759_ VSS VSS VDD VDD network.neuron_hid2.IF0.input_current\[6\]
+ sky130_fd_sc_hd__dfxtp_1
Xnetwork.neuron_hid7.IF_in\[7\]$_SDFF_PP0_ clknet_leaf_128_clk
+ _01756_ VSS VSS VDD VDD network.neuron_hid2.IF0.input_current\[7\]
+ sky130_fd_sc_hd__dfxtp_1
Xnetwork.neuron_hid7.spike_out$_SDFFE_PP0P_ clknet_leaf_136_clk
+ _01938_ VSS VSS VDD VDD network.hid_spk7 sky130_fd_sc_hd__dfxtp_1
Xnetwork.neuron_in000.counter\[0\]$_DFFE_PP_ clknet_leaf_64_clk
+ _02064_ _01507_ VSS VSS VDD VDD network.neuron_in000.counter\[0\]
+ sky130_fd_sc_hd__edfxtp_1
Xnetwork.neuron_in000.counter\[1\]$_DFFE_PP_ clknet_leaf_64_clk
+ _02065_ _01507_ VSS VSS VDD VDD network.neuron_in000.counter\[1\]
+ sky130_fd_sc_hd__edfxtp_1
Xnetwork.neuron_in000.counter\[2\]$_DFFE_PP_ clknet_leaf_64_clk
+ _02066_ _01507_ VSS VSS VDD VDD network.neuron_in000.counter\[2\]
+ sky130_fd_sc_hd__edfxtp_1
Xnetwork.neuron_in000.counter\[3\]$_DFFE_PP_ clknet_leaf_64_clk
+ _02067_ _01507_ VSS VSS VDD VDD network.neuron_in000.counter\[3\]
+ sky130_fd_sc_hd__edfxtp_1
Xnetwork.neuron_in000.spike$_SDFFE_PP0P_ clknet_leaf_67_clk
+ _01867_ VSS VSS VDD VDD network.in_spk00_00 sky130_fd_sc_hd__dfxtp_1
Xnetwork.neuron_in001.counter\[0\]$_DFFE_PP_ clknet_leaf_74_clk
+ _02068_ _01506_ VSS VSS VDD VDD network.neuron_in001.counter\[0\]
+ sky130_fd_sc_hd__edfxtp_1
Xnetwork.neuron_in001.counter\[1\]$_DFFE_PP_ clknet_leaf_74_clk
+ _02069_ _01506_ VSS VSS VDD VDD network.neuron_in001.counter\[1\]
+ sky130_fd_sc_hd__edfxtp_1
Xnetwork.neuron_in001.counter\[2\]$_DFFE_PP_ clknet_leaf_74_clk
+ _02070_ _01506_ VSS VSS VDD VDD network.neuron_in001.counter\[2\]
+ sky130_fd_sc_hd__edfxtp_1
Xnetwork.neuron_in001.counter\[3\]$_DFFE_PP_ clknet_leaf_74_clk
+ _02071_ _01506_ VSS VSS VDD VDD network.neuron_in001.counter\[3\]
+ sky130_fd_sc_hd__edfxtp_1
Xnetwork.neuron_in001.spike$_SDFFE_PP0P_ clknet_leaf_68_clk
+ _01866_ VSS VSS VDD VDD network.in_spk01_00 sky130_fd_sc_hd__dfxtp_1
Xnetwork.neuron_in002.counter\[0\]$_DFFE_PP_ clknet_leaf_66_clk
+ _02072_ _01505_ VSS VSS VDD VDD network.neuron_in002.counter\[0\]
+ sky130_fd_sc_hd__edfxtp_1
Xnetwork.neuron_in002.counter\[1\]$_DFFE_PP_ clknet_leaf_65_clk
+ _02073_ _01505_ VSS VSS VDD VDD network.neuron_in002.counter\[1\]
+ sky130_fd_sc_hd__edfxtp_1
Xnetwork.neuron_in002.counter\[2\]$_DFFE_PP_ clknet_leaf_65_clk
+ _02074_ _01505_ VSS VSS VDD VDD network.neuron_in002.counter\[2\]
+ sky130_fd_sc_hd__edfxtp_1
Xnetwork.neuron_in002.counter\[3\]$_DFFE_PP_ clknet_leaf_65_clk
+ _02075_ _01505_ VSS VSS VDD VDD network.neuron_in002.counter\[3\]
+ sky130_fd_sc_hd__edfxtp_1
Xnetwork.neuron_in002.spike$_SDFFE_PP0P_ clknet_leaf_68_clk
+ _01865_ VSS VSS VDD VDD network.in_spk02_00 sky130_fd_sc_hd__dfxtp_1
Xnetwork.neuron_in003.counter\[0\]$_DFFE_PP_ clknet_leaf_63_clk
+ _02076_ _01504_ VSS VSS VDD VDD network.neuron_in003.counter\[0\]
+ sky130_fd_sc_hd__edfxtp_1
Xnetwork.neuron_in003.counter\[1\]$_DFFE_PP_ clknet_leaf_63_clk
+ _02077_ _01504_ VSS VSS VDD VDD network.neuron_in003.counter\[1\]
+ sky130_fd_sc_hd__edfxtp_1
Xnetwork.neuron_in003.counter\[2\]$_DFFE_PP_ clknet_leaf_63_clk
+ _02078_ _01504_ VSS VSS VDD VDD network.neuron_in003.counter\[2\]
+ sky130_fd_sc_hd__edfxtp_1
Xnetwork.neuron_in003.counter\[3\]$_DFFE_PP_ clknet_leaf_64_clk
+ _02079_ _01504_ VSS VSS VDD VDD network.neuron_in003.counter\[3\]
+ sky130_fd_sc_hd__edfxtp_1
Xnetwork.neuron_in003.spike$_SDFFE_PP0P_ clknet_leaf_50_clk
+ _01864_ VSS VSS VDD VDD network.in_spk03_00 sky130_fd_sc_hd__dfxtp_1
Xnetwork.neuron_in004.counter\[0\]$_DFFE_PP_ clknet_leaf_68_clk
+ _02080_ _01503_ VSS VSS VDD VDD network.neuron_in004.counter\[0\]
+ sky130_fd_sc_hd__edfxtp_1
Xnetwork.neuron_in004.counter\[1\]$_DFFE_PP_ clknet_leaf_68_clk
+ _02081_ _01503_ VSS VSS VDD VDD network.neuron_in004.counter\[1\]
+ sky130_fd_sc_hd__edfxtp_1
Xnetwork.neuron_in004.counter\[2\]$_DFFE_PP_ clknet_leaf_68_clk
+ _02082_ _01503_ VSS VSS VDD VDD network.neuron_in004.counter\[2\]
+ sky130_fd_sc_hd__edfxtp_1
Xnetwork.neuron_in004.counter\[3\]$_DFFE_PP_ clknet_leaf_68_clk
+ _02083_ _01503_ VSS VSS VDD VDD network.neuron_in004.counter\[3\]
+ sky130_fd_sc_hd__edfxtp_1
Xnetwork.neuron_in004.spike$_SDFFE_PP0P_ clknet_leaf_50_clk
+ _01863_ VSS VSS VDD VDD network.in_spk04_00 sky130_fd_sc_hd__dfxtp_1
Xnetwork.neuron_in005.counter\[0\]$_DFFE_PP_ clknet_leaf_67_clk
+ _02084_ _01502_ VSS VSS VDD VDD network.neuron_in005.counter\[0\]
+ sky130_fd_sc_hd__edfxtp_1
Xnetwork.neuron_in005.counter\[1\]$_DFFE_PP_ clknet_leaf_67_clk
+ _02085_ _01502_ VSS VSS VDD VDD network.neuron_in005.counter\[1\]
+ sky130_fd_sc_hd__edfxtp_1
Xnetwork.neuron_in005.counter\[2\]$_DFFE_PP_ clknet_leaf_67_clk
+ _02086_ _01502_ VSS VSS VDD VDD network.neuron_in005.counter\[2\]
+ sky130_fd_sc_hd__edfxtp_1
Xnetwork.neuron_in005.counter\[3\]$_DFFE_PP_ clknet_leaf_67_clk
+ _02087_ _01502_ VSS VSS VDD VDD network.neuron_in005.counter\[3\]
+ sky130_fd_sc_hd__edfxtp_1
Xnetwork.neuron_in005.spike$_SDFFE_PP0P_ clknet_leaf_50_clk
+ _01862_ VSS VSS VDD VDD network.in_spk05_00 sky130_fd_sc_hd__dfxtp_1
Xnetwork.neuron_in006.counter\[0\]$_DFFE_PP_ clknet_leaf_50_clk
+ _02088_ _01501_ VSS VSS VDD VDD network.neuron_in006.counter\[0\]
+ sky130_fd_sc_hd__edfxtp_1
Xnetwork.neuron_in006.counter\[1\]$_DFFE_PP_ clknet_leaf_50_clk
+ _02089_ _01501_ VSS VSS VDD VDD network.neuron_in006.counter\[1\]
+ sky130_fd_sc_hd__edfxtp_1
Xnetwork.neuron_in006.counter\[2\]$_DFFE_PP_ clknet_leaf_50_clk
+ _02090_ _01501_ VSS VSS VDD VDD network.neuron_in006.counter\[2\]
+ sky130_fd_sc_hd__edfxtp_1
Xnetwork.neuron_in006.counter\[3\]$_DFFE_PP_ clknet_leaf_49_clk
+ _02091_ _01501_ VSS VSS VDD VDD network.neuron_in006.counter\[3\]
+ sky130_fd_sc_hd__edfxtp_1
Xnetwork.neuron_in006.spike$_SDFFE_PP0P_ clknet_leaf_55_clk
+ _01861_ VSS VSS VDD VDD network.in_spk06_00 sky130_fd_sc_hd__dfxtp_1
Xnetwork.neuron_in007.counter\[0\]$_DFFE_PP_ clknet_leaf_62_clk
+ _02092_ _01500_ VSS VSS VDD VDD network.neuron_in007.counter\[0\]
+ sky130_fd_sc_hd__edfxtp_1
Xnetwork.neuron_in007.counter\[1\]$_DFFE_PP_ clknet_leaf_62_clk
+ _02093_ _01500_ VSS VSS VDD VDD network.neuron_in007.counter\[1\]
+ sky130_fd_sc_hd__edfxtp_1
Xnetwork.neuron_in007.counter\[2\]$_DFFE_PP_ clknet_leaf_62_clk
+ _02094_ _01500_ VSS VSS VDD VDD network.neuron_in007.counter\[2\]
+ sky130_fd_sc_hd__edfxtp_1
Xnetwork.neuron_in007.counter\[3\]$_DFFE_PP_ clknet_leaf_62_clk
+ _02095_ _01500_ VSS VSS VDD VDD network.neuron_in007.counter\[3\]
+ sky130_fd_sc_hd__edfxtp_1
Xnetwork.neuron_in007.spike$_SDFFE_PP0P_ clknet_leaf_55_clk
+ _01860_ VSS VSS VDD VDD network.in_spk07_00 sky130_fd_sc_hd__dfxtp_1
Xnetwork.neuron_in008.counter\[0\]$_DFFE_PP_ clknet_leaf_57_clk
+ _02096_ _01499_ VSS VSS VDD VDD network.neuron_in008.counter\[0\]
+ sky130_fd_sc_hd__edfxtp_1
Xnetwork.neuron_in008.counter\[1\]$_DFFE_PP_ clknet_leaf_57_clk
+ _02097_ _01499_ VSS VSS VDD VDD network.neuron_in008.counter\[1\]
+ sky130_fd_sc_hd__edfxtp_1
Xnetwork.neuron_in008.counter\[2\]$_DFFE_PP_ clknet_leaf_56_clk
+ _02098_ _01499_ VSS VSS VDD VDD network.neuron_in008.counter\[2\]
+ sky130_fd_sc_hd__edfxtp_1
Xnetwork.neuron_in008.counter\[3\]$_DFFE_PP_ clknet_leaf_56_clk
+ _02099_ _01499_ VSS VSS VDD VDD network.neuron_in008.counter\[3\]
+ sky130_fd_sc_hd__edfxtp_1
Xnetwork.neuron_in008.spike$_SDFFE_PP0P_ clknet_leaf_57_clk
+ _01859_ VSS VSS VDD VDD network.in_spk08_00 sky130_fd_sc_hd__dfxtp_1
Xnetwork.neuron_in009.counter\[0\]$_DFFE_PP_ clknet_leaf_56_clk
+ _02100_ _01498_ VSS VSS VDD VDD network.neuron_in009.counter\[0\]
+ sky130_fd_sc_hd__edfxtp_1
Xnetwork.neuron_in009.counter\[1\]$_DFFE_PP_ clknet_leaf_62_clk
+ _02101_ _01498_ VSS VSS VDD VDD network.neuron_in009.counter\[1\]
+ sky130_fd_sc_hd__edfxtp_1
Xnetwork.neuron_in009.counter\[2\]$_DFFE_PP_ clknet_leaf_55_clk
+ _02102_ _01498_ VSS VSS VDD VDD network.neuron_in009.counter\[2\]
+ sky130_fd_sc_hd__edfxtp_1
Xnetwork.neuron_in009.counter\[3\]$_DFFE_PP_ clknet_leaf_56_clk
+ _02103_ _01498_ VSS VSS VDD VDD network.neuron_in009.counter\[3\]
+ sky130_fd_sc_hd__edfxtp_1
Xnetwork.neuron_in009.spike$_SDFFE_PP0P_ clknet_leaf_54_clk
+ _01858_ VSS VSS VDD VDD network.in_spk09_00 sky130_fd_sc_hd__dfxtp_1
Xnetwork.neuron_in010.counter\[0\]$_DFFE_PP_ clknet_leaf_63_clk
+ _02104_ _01497_ VSS VSS VDD VDD network.neuron_in010.counter\[0\]
+ sky130_fd_sc_hd__edfxtp_1
Xnetwork.neuron_in010.counter\[1\]$_DFFE_PP_ clknet_leaf_63_clk
+ _02105_ _01497_ VSS VSS VDD VDD network.neuron_in010.counter\[1\]
+ sky130_fd_sc_hd__edfxtp_1
Xnetwork.neuron_in010.counter\[2\]$_DFFE_PP_ clknet_leaf_61_clk
+ _02106_ _01497_ VSS VSS VDD VDD network.neuron_in010.counter\[2\]
+ sky130_fd_sc_hd__edfxtp_1
Xnetwork.neuron_in010.counter\[3\]$_DFFE_PP_ clknet_leaf_61_clk
+ _02107_ _01497_ VSS VSS VDD VDD network.neuron_in010.counter\[3\]
+ sky130_fd_sc_hd__edfxtp_1
Xnetwork.neuron_in010.spike$_SDFFE_PP0P_ clknet_leaf_54_clk
+ _01857_ VSS VSS VDD VDD network.in_spk10_00 sky130_fd_sc_hd__dfxtp_1
Xnetwork.neuron_in011.counter\[0\]$_DFFE_PP_ clknet_leaf_56_clk
+ _02108_ _01496_ VSS VSS VDD VDD network.neuron_in011.counter\[0\]
+ sky130_fd_sc_hd__edfxtp_1
Xnetwork.neuron_in011.counter\[1\]$_DFFE_PP_ clknet_leaf_58_clk
+ _02109_ _01496_ VSS VSS VDD VDD network.neuron_in011.counter\[1\]
+ sky130_fd_sc_hd__edfxtp_1
Xnetwork.neuron_in011.counter\[2\]$_DFFE_PP_ clknet_leaf_61_clk
+ _02110_ _01496_ VSS VSS VDD VDD network.neuron_in011.counter\[2\]
+ sky130_fd_sc_hd__edfxtp_1
Xnetwork.neuron_in011.counter\[3\]$_DFFE_PP_ clknet_leaf_61_clk
+ _02111_ _01496_ VSS VSS VDD VDD network.neuron_in011.counter\[3\]
+ sky130_fd_sc_hd__edfxtp_1
Xnetwork.neuron_in011.spike$_SDFFE_PP0P_ clknet_leaf_54_clk
+ _01856_ VSS VSS VDD VDD network.in_spk11_00 sky130_fd_sc_hd__dfxtp_1
Xnetwork.neuron_in012.counter\[0\]$_DFFE_PP_ clknet_leaf_19_clk
+ _02112_ _01495_ VSS VSS VDD VDD network.neuron_in012.counter\[0\]
+ sky130_fd_sc_hd__edfxtp_1
Xnetwork.neuron_in012.counter\[1\]$_DFFE_PP_ clknet_leaf_54_clk
+ _02113_ _01495_ VSS VSS VDD VDD network.neuron_in012.counter\[1\]
+ sky130_fd_sc_hd__edfxtp_1
Xnetwork.neuron_in012.counter\[2\]$_DFFE_PP_ clknet_leaf_22_clk
+ _02114_ _01495_ VSS VSS VDD VDD network.neuron_in012.counter\[2\]
+ sky130_fd_sc_hd__edfxtp_1
Xnetwork.neuron_in012.counter\[3\]$_DFFE_PP_ clknet_leaf_57_clk
+ _02115_ _01495_ VSS VSS VDD VDD network.neuron_in012.counter\[3\]
+ sky130_fd_sc_hd__edfxtp_1
Xnetwork.neuron_in012.spike$_SDFFE_PP0P_ clknet_leaf_54_clk
+ _01855_ VSS VSS VDD VDD network.in_spk12_00 sky130_fd_sc_hd__dfxtp_1
Xnetwork.neuron_in013.counter\[0\]$_DFFE_PP_ clknet_leaf_20_clk
+ _02116_ _01494_ VSS VSS VDD VDD network.neuron_in013.counter\[0\]
+ sky130_fd_sc_hd__edfxtp_1
Xnetwork.neuron_in013.counter\[1\]$_DFFE_PP_ clknet_leaf_21_clk
+ _02117_ _01494_ VSS VSS VDD VDD network.neuron_in013.counter\[1\]
+ sky130_fd_sc_hd__edfxtp_1
Xnetwork.neuron_in013.counter\[2\]$_DFFE_PP_ clknet_leaf_20_clk
+ _02118_ _01494_ VSS VSS VDD VDD network.neuron_in013.counter\[2\]
+ sky130_fd_sc_hd__edfxtp_1
Xnetwork.neuron_in013.counter\[3\]$_DFFE_PP_ clknet_leaf_20_clk
+ _02119_ _01494_ VSS VSS VDD VDD network.neuron_in013.counter\[3\]
+ sky130_fd_sc_hd__edfxtp_1
Xnetwork.neuron_in013.spike$_SDFFE_PP0P_ clknet_leaf_22_clk
+ _01854_ VSS VSS VDD VDD network.in_spk13_00 sky130_fd_sc_hd__dfxtp_1
Xnetwork.neuron_in014.counter\[0\]$_DFFE_PP_ clknet_leaf_53_clk
+ _02120_ _01493_ VSS VSS VDD VDD network.neuron_in014.counter\[0\]
+ sky130_fd_sc_hd__edfxtp_1
Xnetwork.neuron_in014.counter\[1\]$_DFFE_PP_ clknet_leaf_43_clk
+ _02121_ _01493_ VSS VSS VDD VDD network.neuron_in014.counter\[1\]
+ sky130_fd_sc_hd__edfxtp_1
Xnetwork.neuron_in014.counter\[2\]$_DFFE_PP_ clknet_leaf_43_clk
+ _02122_ _01493_ VSS VSS VDD VDD network.neuron_in014.counter\[2\]
+ sky130_fd_sc_hd__edfxtp_1
Xnetwork.neuron_in014.counter\[3\]$_DFFE_PP_ clknet_leaf_43_clk
+ _02123_ _01493_ VSS VSS VDD VDD network.neuron_in014.counter\[3\]
+ sky130_fd_sc_hd__edfxtp_1
Xnetwork.neuron_in014.spike$_SDFFE_PP0P_ clknet_leaf_23_clk
+ _01853_ VSS VSS VDD VDD network.in_spk14_00 sky130_fd_sc_hd__dfxtp_1
Xnetwork.neuron_in015.counter\[0\]$_DFFE_PP_ clknet_leaf_21_clk
+ _02124_ _01492_ VSS VSS VDD VDD network.neuron_in015.counter\[0\]
+ sky130_fd_sc_hd__edfxtp_1
Xnetwork.neuron_in015.counter\[1\]$_DFFE_PP_ clknet_leaf_21_clk
+ _02125_ _01492_ VSS VSS VDD VDD network.neuron_in015.counter\[1\]
+ sky130_fd_sc_hd__edfxtp_1
Xnetwork.neuron_in015.counter\[2\]$_DFFE_PP_ clknet_leaf_21_clk
+ _02126_ _01492_ VSS VSS VDD VDD network.neuron_in015.counter\[2\]
+ sky130_fd_sc_hd__edfxtp_1
Xnetwork.neuron_in015.counter\[3\]$_DFFE_PP_ clknet_leaf_21_clk
+ _02127_ _01492_ VSS VSS VDD VDD network.neuron_in015.counter\[3\]
+ sky130_fd_sc_hd__edfxtp_1
Xnetwork.neuron_in015.spike$_SDFFE_PP0P_ clknet_leaf_22_clk
+ _01852_ VSS VSS VDD VDD network.in_spk15_00 sky130_fd_sc_hd__dfxtp_1
Xnetwork.neuron_in016.counter\[0\]$_DFFE_PP_ clknet_leaf_27_clk
+ _02128_ _01491_ VSS VSS VDD VDD network.neuron_in016.counter\[0\]
+ sky130_fd_sc_hd__edfxtp_1
Xnetwork.neuron_in016.counter\[1\]$_DFFE_PP_ clknet_leaf_27_clk
+ _02129_ _01491_ VSS VSS VDD VDD network.neuron_in016.counter\[1\]
+ sky130_fd_sc_hd__edfxtp_1
Xnetwork.neuron_in016.counter\[2\]$_DFFE_PP_ clknet_leaf_27_clk
+ _02130_ _01491_ VSS VSS VDD VDD network.neuron_in016.counter\[2\]
+ sky130_fd_sc_hd__edfxtp_1
Xnetwork.neuron_in016.counter\[3\]$_DFFE_PP_ clknet_leaf_27_clk
+ _02131_ _01491_ VSS VSS VDD VDD network.neuron_in016.counter\[3\]
+ sky130_fd_sc_hd__edfxtp_1
Xnetwork.neuron_in016.spike$_SDFFE_PP0P_ clknet_leaf_26_clk
+ _01851_ VSS VSS VDD VDD network.in_spk00_01 sky130_fd_sc_hd__dfxtp_1
Xnetwork.neuron_in017.counter\[0\]$_DFFE_PP_ clknet_leaf_26_clk
+ _02132_ _01490_ VSS VSS VDD VDD network.neuron_in017.counter\[0\]
+ sky130_fd_sc_hd__edfxtp_1
Xnetwork.neuron_in017.counter\[1\]$_DFFE_PP_ clknet_leaf_25_clk
+ _02133_ _01490_ VSS VSS VDD VDD network.neuron_in017.counter\[1\]
+ sky130_fd_sc_hd__edfxtp_1
Xnetwork.neuron_in017.counter\[2\]$_DFFE_PP_ clknet_leaf_24_clk
+ _02134_ _01490_ VSS VSS VDD VDD network.neuron_in017.counter\[2\]
+ sky130_fd_sc_hd__edfxtp_1
Xnetwork.neuron_in017.counter\[3\]$_DFFE_PP_ clknet_leaf_25_clk
+ _02135_ _01490_ VSS VSS VDD VDD network.neuron_in017.counter\[3\]
+ sky130_fd_sc_hd__edfxtp_1
Xnetwork.neuron_in017.spike$_SDFFE_PP0P_ clknet_leaf_27_clk
+ _01850_ VSS VSS VDD VDD network.in_spk01_01 sky130_fd_sc_hd__dfxtp_1
Xnetwork.neuron_in018.counter\[0\]$_DFFE_PP_ clknet_leaf_28_clk
+ _02136_ _01489_ VSS VSS VDD VDD network.neuron_in018.counter\[0\]
+ sky130_fd_sc_hd__edfxtp_1
Xnetwork.neuron_in018.counter\[1\]$_DFFE_PP_ clknet_leaf_28_clk
+ _02137_ _01489_ VSS VSS VDD VDD network.neuron_in018.counter\[1\]
+ sky130_fd_sc_hd__edfxtp_1
Xnetwork.neuron_in018.counter\[2\]$_DFFE_PP_ clknet_leaf_29_clk
+ _02138_ _01489_ VSS VSS VDD VDD network.neuron_in018.counter\[2\]
+ sky130_fd_sc_hd__edfxtp_1
Xnetwork.neuron_in018.counter\[3\]$_DFFE_PP_ clknet_leaf_29_clk
+ _02139_ _01489_ VSS VSS VDD VDD network.neuron_in018.counter\[3\]
+ sky130_fd_sc_hd__edfxtp_1
Xnetwork.neuron_in018.spike$_SDFFE_PP0P_ clknet_leaf_27_clk
+ _01849_ VSS VSS VDD VDD network.in_spk02_01 sky130_fd_sc_hd__dfxtp_1
Xnetwork.neuron_in019.counter\[0\]$_DFFE_PP_ clknet_leaf_8_clk
+ _02140_ _01488_ VSS VSS VDD VDD network.neuron_in019.counter\[0\]
+ sky130_fd_sc_hd__edfxtp_1
Xnetwork.neuron_in019.counter\[1\]$_DFFE_PP_ clknet_leaf_8_clk
+ _02141_ _01488_ VSS VSS VDD VDD network.neuron_in019.counter\[1\]
+ sky130_fd_sc_hd__edfxtp_1
Xnetwork.neuron_in019.counter\[2\]$_DFFE_PP_ clknet_leaf_26_clk
+ _02142_ _01488_ VSS VSS VDD VDD network.neuron_in019.counter\[2\]
+ sky130_fd_sc_hd__edfxtp_1
Xnetwork.neuron_in019.counter\[3\]$_DFFE_PP_ clknet_leaf_26_clk
+ _02143_ _01488_ VSS VSS VDD VDD network.neuron_in019.counter\[3\]
+ sky130_fd_sc_hd__edfxtp_1
Xnetwork.neuron_in019.spike$_SDFFE_PP0P_ clknet_leaf_27_clk
+ _01848_ VSS VSS VDD VDD network.in_spk03_01 sky130_fd_sc_hd__dfxtp_1
Xnetwork.neuron_in020.counter\[0\]$_DFFE_PP_ clknet_leaf_262_clk
+ _02144_ _01487_ VSS VSS VDD VDD network.neuron_in020.counter\[0\]
+ sky130_fd_sc_hd__edfxtp_1
Xnetwork.neuron_in020.counter\[1\]$_DFFE_PP_ clknet_leaf_262_clk
+ _02145_ _01487_ VSS VSS VDD VDD network.neuron_in020.counter\[1\]
+ sky130_fd_sc_hd__edfxtp_1
Xnetwork.neuron_in020.counter\[2\]$_DFFE_PP_ clknet_leaf_262_clk
+ _02146_ _01487_ VSS VSS VDD VDD network.neuron_in020.counter\[2\]
+ sky130_fd_sc_hd__edfxtp_1
Xnetwork.neuron_in020.counter\[3\]$_DFFE_PP_ clknet_leaf_261_clk
+ _02147_ _01487_ VSS VSS VDD VDD network.neuron_in020.counter\[3\]
+ sky130_fd_sc_hd__edfxtp_1
Xnetwork.neuron_in020.spike$_SDFFE_PP0P_ clknet_leaf_28_clk
+ _01847_ VSS VSS VDD VDD network.in_spk04_01 sky130_fd_sc_hd__dfxtp_1
Xnetwork.neuron_in021.counter\[0\]$_DFFE_PP_ clknet_leaf_262_clk
+ _02148_ _01486_ VSS VSS VDD VDD network.neuron_in021.counter\[0\]
+ sky130_fd_sc_hd__edfxtp_1
Xnetwork.neuron_in021.counter\[1\]$_DFFE_PP_ clknet_leaf_262_clk
+ _02149_ _01486_ VSS VSS VDD VDD network.neuron_in021.counter\[1\]
+ sky130_fd_sc_hd__edfxtp_1
Xnetwork.neuron_in021.counter\[2\]$_DFFE_PP_ clknet_leaf_245_clk
+ _02150_ _01486_ VSS VSS VDD VDD network.neuron_in021.counter\[2\]
+ sky130_fd_sc_hd__edfxtp_1
Xnetwork.neuron_in021.counter\[3\]$_DFFE_PP_ clknet_leaf_262_clk
+ _02151_ _01486_ VSS VSS VDD VDD network.neuron_in021.counter\[3\]
+ sky130_fd_sc_hd__edfxtp_1
Xnetwork.neuron_in021.spike$_SDFFE_PP0P_ clknet_leaf_28_clk
+ _01846_ VSS VSS VDD VDD network.in_spk05_01 sky130_fd_sc_hd__dfxtp_1
Xnetwork.neuron_in022.counter\[0\]$_DFFE_PP_ clknet_leaf_260_clk
+ _02152_ _01485_ VSS VSS VDD VDD network.neuron_in022.counter\[0\]
+ sky130_fd_sc_hd__edfxtp_1
Xnetwork.neuron_in022.counter\[1\]$_DFFE_PP_ clknet_leaf_260_clk
+ _02153_ _01485_ VSS VSS VDD VDD network.neuron_in022.counter\[1\]
+ sky130_fd_sc_hd__edfxtp_1
Xnetwork.neuron_in022.counter\[2\]$_DFFE_PP_ clknet_leaf_263_clk
+ _02154_ _01485_ VSS VSS VDD VDD network.neuron_in022.counter\[2\]
+ sky130_fd_sc_hd__edfxtp_1
Xnetwork.neuron_in022.counter\[3\]$_DFFE_PP_ clknet_leaf_263_clk
+ _02155_ _01485_ VSS VSS VDD VDD network.neuron_in022.counter\[3\]
+ sky130_fd_sc_hd__edfxtp_1
Xnetwork.neuron_in022.spike$_SDFFE_PP0P_ clknet_leaf_28_clk
+ _01845_ VSS VSS VDD VDD network.in_spk06_01 sky130_fd_sc_hd__dfxtp_1
Xnetwork.neuron_in023.counter\[0\]$_DFFE_PP_ clknet_leaf_264_clk
+ _02156_ _01484_ VSS VSS VDD VDD network.neuron_in023.counter\[0\]
+ sky130_fd_sc_hd__edfxtp_1
Xnetwork.neuron_in023.counter\[1\]$_DFFE_PP_ clknet_leaf_264_clk
+ _02157_ _01484_ VSS VSS VDD VDD network.neuron_in023.counter\[1\]
+ sky130_fd_sc_hd__edfxtp_1
Xnetwork.neuron_in023.counter\[2\]$_DFFE_PP_ clknet_leaf_243_clk
+ _02158_ _01484_ VSS VSS VDD VDD network.neuron_in023.counter\[2\]
+ sky130_fd_sc_hd__edfxtp_1
Xnetwork.neuron_in023.counter\[3\]$_DFFE_PP_ clknet_leaf_243_clk
+ _02159_ _01484_ VSS VSS VDD VDD network.neuron_in023.counter\[3\]
+ sky130_fd_sc_hd__edfxtp_1
Xnetwork.neuron_in023.spike$_SDFFE_PP0P_ clknet_leaf_8_clk
+ _01844_ VSS VSS VDD VDD network.in_spk07_01 sky130_fd_sc_hd__dfxtp_1
Xnetwork.neuron_in024.counter\[0\]$_DFFE_PP_ clknet_leaf_261_clk
+ _02160_ _01483_ VSS VSS VDD VDD network.neuron_in024.counter\[0\]
+ sky130_fd_sc_hd__edfxtp_1
Xnetwork.neuron_in024.counter\[1\]$_DFFE_PP_ clknet_leaf_245_clk
+ _02161_ _01483_ VSS VSS VDD VDD network.neuron_in024.counter\[1\]
+ sky130_fd_sc_hd__edfxtp_1
Xnetwork.neuron_in024.counter\[2\]$_DFFE_PP_ clknet_leaf_257_clk
+ _02162_ _01483_ VSS VSS VDD VDD network.neuron_in024.counter\[2\]
+ sky130_fd_sc_hd__edfxtp_1
Xnetwork.neuron_in024.counter\[3\]$_DFFE_PP_ clknet_leaf_261_clk
+ _02163_ _01483_ VSS VSS VDD VDD network.neuron_in024.counter\[3\]
+ sky130_fd_sc_hd__edfxtp_1
Xnetwork.neuron_in024.spike$_SDFFE_PP0P_ clknet_leaf_265_clk
+ _01843_ VSS VSS VDD VDD network.in_spk08_01 sky130_fd_sc_hd__dfxtp_1
Xnetwork.neuron_in025.counter\[0\]$_DFFE_PP_ clknet_leaf_268_clk
+ _02164_ _01482_ VSS VSS VDD VDD network.neuron_in025.counter\[0\]
+ sky130_fd_sc_hd__edfxtp_1
Xnetwork.neuron_in025.counter\[1\]$_DFFE_PP_ clknet_leaf_267_clk
+ _02165_ _01482_ VSS VSS VDD VDD network.neuron_in025.counter\[1\]
+ sky130_fd_sc_hd__edfxtp_1
Xnetwork.neuron_in025.counter\[2\]$_DFFE_PP_ clknet_leaf_268_clk
+ _02166_ _01482_ VSS VSS VDD VDD network.neuron_in025.counter\[2\]
+ sky130_fd_sc_hd__edfxtp_1
Xnetwork.neuron_in025.counter\[3\]$_DFFE_PP_ clknet_leaf_268_clk
+ _02167_ _01482_ VSS VSS VDD VDD network.neuron_in025.counter\[3\]
+ sky130_fd_sc_hd__edfxtp_1
Xnetwork.neuron_in025.spike$_SDFFE_PP0P_ clknet_leaf_265_clk
+ _01842_ VSS VSS VDD VDD network.in_spk09_01 sky130_fd_sc_hd__dfxtp_1
Xnetwork.neuron_in026.counter\[0\]$_DFFE_PP_ clknet_leaf_267_clk
+ _02168_ _01481_ VSS VSS VDD VDD network.neuron_in026.counter\[0\]
+ sky130_fd_sc_hd__edfxtp_1
Xnetwork.neuron_in026.counter\[1\]$_DFFE_PP_ clknet_leaf_267_clk
+ _02169_ _01481_ VSS VSS VDD VDD network.neuron_in026.counter\[1\]
+ sky130_fd_sc_hd__edfxtp_1
Xnetwork.neuron_in026.counter\[2\]$_DFFE_PP_ clknet_leaf_265_clk
+ _02170_ _01481_ VSS VSS VDD VDD network.neuron_in026.counter\[2\]
+ sky130_fd_sc_hd__edfxtp_1
Xnetwork.neuron_in026.counter\[3\]$_DFFE_PP_ clknet_leaf_265_clk
+ _02171_ _01481_ VSS VSS VDD VDD network.neuron_in026.counter\[3\]
+ sky130_fd_sc_hd__edfxtp_1
Xnetwork.neuron_in026.spike$_SDFFE_PP0P_ clknet_leaf_265_clk
+ _01841_ VSS VSS VDD VDD network.in_spk10_01 sky130_fd_sc_hd__dfxtp_1
Xnetwork.neuron_in027.counter\[0\]$_DFFE_PP_ clknet_leaf_261_clk
+ _02172_ _01480_ VSS VSS VDD VDD network.neuron_in027.counter\[0\]
+ sky130_fd_sc_hd__edfxtp_1
Xnetwork.neuron_in027.counter\[1\]$_DFFE_PP_ clknet_leaf_261_clk
+ _02173_ _01480_ VSS VSS VDD VDD network.neuron_in027.counter\[1\]
+ sky130_fd_sc_hd__edfxtp_1
Xnetwork.neuron_in027.counter\[2\]$_DFFE_PP_ clknet_leaf_257_clk
+ _02174_ _01480_ VSS VSS VDD VDD network.neuron_in027.counter\[2\]
+ sky130_fd_sc_hd__edfxtp_1
Xnetwork.neuron_in027.counter\[3\]$_DFFE_PP_ clknet_leaf_261_clk
+ _02175_ _01480_ VSS VSS VDD VDD network.neuron_in027.counter\[3\]
+ sky130_fd_sc_hd__edfxtp_1
Xnetwork.neuron_in027.spike$_SDFFE_PP0P_ clknet_leaf_265_clk
+ _01840_ VSS VSS VDD VDD network.in_spk11_01 sky130_fd_sc_hd__dfxtp_1
Xnetwork.neuron_in028.counter\[0\]$_DFFE_PP_ clknet_leaf_269_clk
+ _02176_ _01479_ VSS VSS VDD VDD network.neuron_in028.counter\[0\]
+ sky130_fd_sc_hd__edfxtp_1
Xnetwork.neuron_in028.counter\[1\]$_DFFE_PP_ clknet_leaf_269_clk
+ _02177_ _01479_ VSS VSS VDD VDD network.neuron_in028.counter\[1\]
+ sky130_fd_sc_hd__edfxtp_1
Xnetwork.neuron_in028.counter\[2\]$_DFFE_PP_ clknet_leaf_259_clk
+ _02178_ _01479_ VSS VSS VDD VDD network.neuron_in028.counter\[2\]
+ sky130_fd_sc_hd__edfxtp_1
Xnetwork.neuron_in028.counter\[3\]$_DFFE_PP_ clknet_leaf_259_clk
+ _02179_ _01479_ VSS VSS VDD VDD network.neuron_in028.counter\[3\]
+ sky130_fd_sc_hd__edfxtp_1
Xnetwork.neuron_in028.spike$_SDFFE_PP0P_ clknet_leaf_263_clk
+ _01839_ VSS VSS VDD VDD network.in_spk12_01 sky130_fd_sc_hd__dfxtp_1
Xnetwork.neuron_in029.counter\[0\]$_DFFE_PP_ clknet_leaf_258_clk
+ _02180_ _01478_ VSS VSS VDD VDD network.neuron_in029.counter\[0\]
+ sky130_fd_sc_hd__edfxtp_1
Xnetwork.neuron_in029.counter\[1\]$_DFFE_PP_ clknet_leaf_258_clk
+ _02181_ _01478_ VSS VSS VDD VDD network.neuron_in029.counter\[1\]
+ sky130_fd_sc_hd__edfxtp_1
Xnetwork.neuron_in029.counter\[2\]$_DFFE_PP_ clknet_leaf_257_clk
+ _02182_ _01478_ VSS VSS VDD VDD network.neuron_in029.counter\[2\]
+ sky130_fd_sc_hd__edfxtp_1
Xnetwork.neuron_in029.counter\[3\]$_DFFE_PP_ clknet_leaf_257_clk
+ _02183_ _01478_ VSS VSS VDD VDD network.neuron_in029.counter\[3\]
+ sky130_fd_sc_hd__edfxtp_1
Xnetwork.neuron_in029.spike$_SDFFE_PP0P_ clknet_leaf_263_clk
+ _01838_ VSS VSS VDD VDD network.in_spk13_01 sky130_fd_sc_hd__dfxtp_1
Xnetwork.neuron_in030.counter\[0\]$_DFFE_PP_ clknet_leaf_258_clk
+ _02184_ _01477_ VSS VSS VDD VDD network.neuron_in030.counter\[0\]
+ sky130_fd_sc_hd__edfxtp_1
Xnetwork.neuron_in030.counter\[1\]$_DFFE_PP_ clknet_leaf_258_clk
+ _02185_ _01477_ VSS VSS VDD VDD network.neuron_in030.counter\[1\]
+ sky130_fd_sc_hd__edfxtp_1
Xnetwork.neuron_in030.counter\[2\]$_DFFE_PP_ clknet_leaf_259_clk
+ _02186_ _01477_ VSS VSS VDD VDD network.neuron_in030.counter\[2\]
+ sky130_fd_sc_hd__edfxtp_1
Xnetwork.neuron_in030.counter\[3\]$_DFFE_PP_ clknet_leaf_258_clk
+ _02187_ _01477_ VSS VSS VDD VDD network.neuron_in030.counter\[3\]
+ sky130_fd_sc_hd__edfxtp_1
Xnetwork.neuron_in030.spike$_SDFFE_PP0P_ clknet_leaf_263_clk
+ _01837_ VSS VSS VDD VDD network.in_spk14_01 sky130_fd_sc_hd__dfxtp_1
Xnetwork.neuron_in031.counter\[0\]$_DFFE_PP_ clknet_leaf_259_clk
+ _02188_ _01476_ VSS VSS VDD VDD network.neuron_in031.counter\[0\]
+ sky130_fd_sc_hd__edfxtp_1
Xnetwork.neuron_in031.counter\[1\]$_DFFE_PP_ clknet_leaf_259_clk
+ _02189_ _01476_ VSS VSS VDD VDD network.neuron_in031.counter\[1\]
+ sky130_fd_sc_hd__edfxtp_1
Xnetwork.neuron_in031.counter\[2\]$_DFFE_PP_ clknet_leaf_260_clk
+ _02190_ _01476_ VSS VSS VDD VDD network.neuron_in031.counter\[2\]
+ sky130_fd_sc_hd__edfxtp_1
Xnetwork.neuron_in031.counter\[3\]$_DFFE_PP_ clknet_leaf_259_clk
+ _02191_ _01476_ VSS VSS VDD VDD network.neuron_in031.counter\[3\]
+ sky130_fd_sc_hd__edfxtp_1
Xnetwork.neuron_in031.spike$_SDFFE_PP0P_ clknet_leaf_263_clk
+ _01836_ VSS VSS VDD VDD network.in_spk15_01 sky130_fd_sc_hd__dfxtp_1
Xnetwork.neuron_in032.counter\[0\]$_DFFE_PP_ clknet_leaf_43_clk
+ _02192_ _01475_ VSS VSS VDD VDD network.neuron_in032.counter\[0\]
+ sky130_fd_sc_hd__edfxtp_1
Xnetwork.neuron_in032.counter\[1\]$_DFFE_PP_ clknet_leaf_43_clk
+ _02193_ _01475_ VSS VSS VDD VDD network.neuron_in032.counter\[1\]
+ sky130_fd_sc_hd__edfxtp_1
Xnetwork.neuron_in032.counter\[2\]$_DFFE_PP_ clknet_leaf_44_clk
+ _02194_ _01475_ VSS VSS VDD VDD network.neuron_in032.counter\[2\]
+ sky130_fd_sc_hd__edfxtp_1
Xnetwork.neuron_in032.counter\[3\]$_DFFE_PP_ clknet_leaf_42_clk
+ _02195_ _01475_ VSS VSS VDD VDD network.neuron_in032.counter\[3\]
+ sky130_fd_sc_hd__edfxtp_1
Xnetwork.neuron_in032.spike$_SDFFE_PP0P_ clknet_leaf_41_clk
+ _01835_ VSS VSS VDD VDD network.in_spk00_02 sky130_fd_sc_hd__dfxtp_1
Xnetwork.neuron_in033.counter\[0\]$_DFFE_PP_ clknet_leaf_98_clk
+ _02196_ _01474_ VSS VSS VDD VDD network.neuron_in033.counter\[0\]
+ sky130_fd_sc_hd__edfxtp_1
Xnetwork.neuron_in033.counter\[1\]$_DFFE_PP_ clknet_leaf_98_clk
+ _02197_ _01474_ VSS VSS VDD VDD network.neuron_in033.counter\[1\]
+ sky130_fd_sc_hd__edfxtp_1
Xnetwork.neuron_in033.counter\[2\]$_DFFE_PP_ clknet_leaf_99_clk
+ _02198_ _01474_ VSS VSS VDD VDD network.neuron_in033.counter\[2\]
+ sky130_fd_sc_hd__edfxtp_1
Xnetwork.neuron_in033.counter\[3\]$_DFFE_PP_ clknet_leaf_99_clk
+ _02199_ _01474_ VSS VSS VDD VDD network.neuron_in033.counter\[3\]
+ sky130_fd_sc_hd__edfxtp_1
Xnetwork.neuron_in033.spike$_SDFFE_PP0P_ clknet_leaf_39_clk
+ _01834_ VSS VSS VDD VDD network.in_spk01_02 sky130_fd_sc_hd__dfxtp_1
Xnetwork.neuron_in034.counter\[0\]$_DFFE_PP_ clknet_leaf_40_clk
+ _02200_ _01473_ VSS VSS VDD VDD network.neuron_in034.counter\[0\]
+ sky130_fd_sc_hd__edfxtp_1
Xnetwork.neuron_in034.counter\[1\]$_DFFE_PP_ clknet_leaf_40_clk
+ _02201_ _01473_ VSS VSS VDD VDD network.neuron_in034.counter\[1\]
+ sky130_fd_sc_hd__edfxtp_1
Xnetwork.neuron_in034.counter\[2\]$_DFFE_PP_ clknet_leaf_40_clk
+ _02202_ _01473_ VSS VSS VDD VDD network.neuron_in034.counter\[2\]
+ sky130_fd_sc_hd__edfxtp_1
Xnetwork.neuron_in034.counter\[3\]$_DFFE_PP_ clknet_leaf_40_clk
+ _02203_ _01473_ VSS VSS VDD VDD network.neuron_in034.counter\[3\]
+ sky130_fd_sc_hd__edfxtp_1
Xnetwork.neuron_in034.spike$_SDFFE_PP0P_ clknet_leaf_41_clk
+ _01833_ VSS VSS VDD VDD network.in_spk02_02 sky130_fd_sc_hd__dfxtp_1
Xnetwork.neuron_in035.counter\[0\]$_DFFE_PP_ clknet_leaf_46_clk
+ _02204_ _01472_ VSS VSS VDD VDD network.neuron_in035.counter\[0\]
+ sky130_fd_sc_hd__edfxtp_1
Xnetwork.neuron_in035.counter\[1\]$_DFFE_PP_ clknet_leaf_91_clk
+ _02205_ _01472_ VSS VSS VDD VDD network.neuron_in035.counter\[1\]
+ sky130_fd_sc_hd__edfxtp_1
Xnetwork.neuron_in035.counter\[2\]$_DFFE_PP_ clknet_leaf_91_clk
+ _02206_ _01472_ VSS VSS VDD VDD network.neuron_in035.counter\[2\]
+ sky130_fd_sc_hd__edfxtp_1
Xnetwork.neuron_in035.counter\[3\]$_DFFE_PP_ clknet_leaf_46_clk
+ _02207_ _01472_ VSS VSS VDD VDD network.neuron_in035.counter\[3\]
+ sky130_fd_sc_hd__edfxtp_1
Xnetwork.neuron_in035.spike$_SDFFE_PP0P_ clknet_leaf_41_clk
+ _01832_ VSS VSS VDD VDD network.in_spk03_02 sky130_fd_sc_hd__dfxtp_1
Xnetwork.neuron_in036.counter\[0\]$_DFFE_PP_ clknet_leaf_92_clk
+ _02208_ _01471_ VSS VSS VDD VDD network.neuron_in036.counter\[0\]
+ sky130_fd_sc_hd__edfxtp_1
Xnetwork.neuron_in036.counter\[1\]$_DFFE_PP_ clknet_leaf_92_clk
+ _02209_ _01471_ VSS VSS VDD VDD network.neuron_in036.counter\[1\]
+ sky130_fd_sc_hd__edfxtp_1
Xnetwork.neuron_in036.counter\[2\]$_DFFE_PP_ clknet_leaf_92_clk
+ _02210_ _01471_ VSS VSS VDD VDD network.neuron_in036.counter\[2\]
+ sky130_fd_sc_hd__edfxtp_1
Xnetwork.neuron_in036.counter\[3\]$_DFFE_PP_ clknet_leaf_97_clk
+ _02211_ _01471_ VSS VSS VDD VDD network.neuron_in036.counter\[3\]
+ sky130_fd_sc_hd__edfxtp_1
Xnetwork.neuron_in036.spike$_SDFFE_PP0P_ clknet_leaf_40_clk
+ _01831_ VSS VSS VDD VDD network.in_spk04_02 sky130_fd_sc_hd__dfxtp_1
Xnetwork.neuron_in037.counter\[0\]$_DFFE_PP_ clknet_leaf_96_clk
+ _02212_ _01470_ VSS VSS VDD VDD network.neuron_in037.counter\[0\]
+ sky130_fd_sc_hd__edfxtp_1
Xnetwork.neuron_in037.counter\[1\]$_DFFE_PP_ clknet_leaf_96_clk
+ _02213_ _01470_ VSS VSS VDD VDD network.neuron_in037.counter\[1\]
+ sky130_fd_sc_hd__edfxtp_1
Xnetwork.neuron_in037.counter\[2\]$_DFFE_PP_ clknet_leaf_96_clk
+ _02214_ _01470_ VSS VSS VDD VDD network.neuron_in037.counter\[2\]
+ sky130_fd_sc_hd__edfxtp_1
Xnetwork.neuron_in037.counter\[3\]$_DFFE_PP_ clknet_leaf_96_clk
+ _02215_ _01470_ VSS VSS VDD VDD network.neuron_in037.counter\[3\]
+ sky130_fd_sc_hd__edfxtp_1
Xnetwork.neuron_in037.spike$_SDFFE_PP0P_ clknet_leaf_39_clk
+ _01830_ VSS VSS VDD VDD network.in_spk05_02 sky130_fd_sc_hd__dfxtp_1
Xnetwork.neuron_in038.counter\[0\]$_DFFE_PP_ clknet_leaf_98_clk
+ _02216_ _01469_ VSS VSS VDD VDD network.neuron_in038.counter\[0\]
+ sky130_fd_sc_hd__edfxtp_1
Xnetwork.neuron_in038.counter\[1\]$_DFFE_PP_ clknet_leaf_97_clk
+ _02217_ _01469_ VSS VSS VDD VDD network.neuron_in038.counter\[1\]
+ sky130_fd_sc_hd__edfxtp_1
Xnetwork.neuron_in038.counter\[2\]$_DFFE_PP_ clknet_leaf_40_clk
+ _02218_ _01469_ VSS VSS VDD VDD network.neuron_in038.counter\[2\]
+ sky130_fd_sc_hd__edfxtp_1
Xnetwork.neuron_in038.counter\[3\]$_DFFE_PP_ clknet_leaf_40_clk
+ _02219_ _01469_ VSS VSS VDD VDD network.neuron_in038.counter\[3\]
+ sky130_fd_sc_hd__edfxtp_1
Xnetwork.neuron_in038.spike$_SDFFE_PP0P_ clknet_leaf_39_clk
+ _01829_ VSS VSS VDD VDD network.in_spk06_02 sky130_fd_sc_hd__dfxtp_1
Xnetwork.neuron_in039.counter\[0\]$_DFFE_PP_ clknet_leaf_33_clk
+ _02220_ _01468_ VSS VSS VDD VDD network.neuron_in039.counter\[0\]
+ sky130_fd_sc_hd__edfxtp_1
Xnetwork.neuron_in039.counter\[1\]$_DFFE_PP_ clknet_leaf_33_clk
+ _02221_ _01468_ VSS VSS VDD VDD network.neuron_in039.counter\[1\]
+ sky130_fd_sc_hd__edfxtp_1
Xnetwork.neuron_in039.counter\[2\]$_DFFE_PP_ clknet_leaf_42_clk
+ _02222_ _01468_ VSS VSS VDD VDD network.neuron_in039.counter\[2\]
+ sky130_fd_sc_hd__edfxtp_1
Xnetwork.neuron_in039.counter\[3\]$_DFFE_PP_ clknet_leaf_42_clk
+ _02223_ _01468_ VSS VSS VDD VDD network.neuron_in039.counter\[3\]
+ sky130_fd_sc_hd__edfxtp_1
Xnetwork.neuron_in039.spike$_SDFFE_PP0P_ clknet_leaf_42_clk
+ _01828_ VSS VSS VDD VDD network.in_spk07_02 sky130_fd_sc_hd__dfxtp_1
Xnetwork.neuron_in040.counter\[0\]$_DFFE_PP_ clknet_leaf_41_clk
+ _02224_ _01467_ VSS VSS VDD VDD network.neuron_in040.counter\[0\]
+ sky130_fd_sc_hd__edfxtp_1
Xnetwork.neuron_in040.counter\[1\]$_DFFE_PP_ clknet_leaf_41_clk
+ _02225_ _01467_ VSS VSS VDD VDD network.neuron_in040.counter\[1\]
+ sky130_fd_sc_hd__edfxtp_1
Xnetwork.neuron_in040.counter\[2\]$_DFFE_PP_ clknet_leaf_41_clk
+ _02226_ _01467_ VSS VSS VDD VDD network.neuron_in040.counter\[2\]
+ sky130_fd_sc_hd__edfxtp_1
Xnetwork.neuron_in040.counter\[3\]$_DFFE_PP_ clknet_leaf_41_clk
+ _02227_ _01467_ VSS VSS VDD VDD network.neuron_in040.counter\[3\]
+ sky130_fd_sc_hd__edfxtp_1
Xnetwork.neuron_in040.spike$_SDFFE_PP0P_ clknet_leaf_42_clk
+ _01827_ VSS VSS VDD VDD network.in_spk08_02 sky130_fd_sc_hd__dfxtp_1
Xnetwork.neuron_in041.counter\[0\]$_DFFE_PP_ clknet_leaf_99_clk
+ _02228_ _01466_ VSS VSS VDD VDD network.neuron_in041.counter\[0\]
+ sky130_fd_sc_hd__edfxtp_1
Xnetwork.neuron_in041.counter\[1\]$_DFFE_PP_ clknet_leaf_99_clk
+ _02229_ _01466_ VSS VSS VDD VDD network.neuron_in041.counter\[1\]
+ sky130_fd_sc_hd__edfxtp_1
Xnetwork.neuron_in041.counter\[2\]$_DFFE_PP_ clknet_leaf_38_clk
+ _02230_ _01466_ VSS VSS VDD VDD network.neuron_in041.counter\[2\]
+ sky130_fd_sc_hd__edfxtp_1
Xnetwork.neuron_in041.counter\[3\]$_DFFE_PP_ clknet_leaf_38_clk
+ _02231_ _01466_ VSS VSS VDD VDD network.neuron_in041.counter\[3\]
+ sky130_fd_sc_hd__edfxtp_1
Xnetwork.neuron_in041.spike$_SDFFE_PP0P_ clknet_leaf_39_clk
+ _01826_ VSS VSS VDD VDD network.in_spk09_02 sky130_fd_sc_hd__dfxtp_1
Xnetwork.neuron_in042.counter\[0\]$_DFFE_PP_ clknet_leaf_45_clk
+ _02232_ _01465_ VSS VSS VDD VDD network.neuron_in042.counter\[0\]
+ sky130_fd_sc_hd__edfxtp_1
Xnetwork.neuron_in042.counter\[1\]$_DFFE_PP_ clknet_leaf_45_clk
+ _02233_ _01465_ VSS VSS VDD VDD network.neuron_in042.counter\[1\]
+ sky130_fd_sc_hd__edfxtp_1
Xnetwork.neuron_in042.counter\[2\]$_DFFE_PP_ clknet_leaf_45_clk
+ _02234_ _01465_ VSS VSS VDD VDD network.neuron_in042.counter\[2\]
+ sky130_fd_sc_hd__edfxtp_1
Xnetwork.neuron_in042.counter\[3\]$_DFFE_PP_ clknet_leaf_45_clk
+ _02235_ _01465_ VSS VSS VDD VDD network.neuron_in042.counter\[3\]
+ sky130_fd_sc_hd__edfxtp_1
Xnetwork.neuron_in042.spike$_SDFFE_PP0P_ clknet_leaf_42_clk
+ _01825_ VSS VSS VDD VDD network.in_spk10_02 sky130_fd_sc_hd__dfxtp_1
Xnetwork.neuron_in043.counter\[0\]$_DFFE_PP_ clknet_leaf_97_clk
+ _02236_ _01464_ VSS VSS VDD VDD network.neuron_in043.counter\[0\]
+ sky130_fd_sc_hd__edfxtp_1
Xnetwork.neuron_in043.counter\[1\]$_DFFE_PP_ clknet_leaf_96_clk
+ _02237_ _01464_ VSS VSS VDD VDD network.neuron_in043.counter\[1\]
+ sky130_fd_sc_hd__edfxtp_1
Xnetwork.neuron_in043.counter\[2\]$_DFFE_PP_ clknet_leaf_98_clk
+ _02238_ _01464_ VSS VSS VDD VDD network.neuron_in043.counter\[2\]
+ sky130_fd_sc_hd__edfxtp_1
Xnetwork.neuron_in043.counter\[3\]$_DFFE_PP_ clknet_leaf_98_clk
+ _02239_ _01464_ VSS VSS VDD VDD network.neuron_in043.counter\[3\]
+ sky130_fd_sc_hd__edfxtp_1
Xnetwork.neuron_in043.spike$_SDFFE_PP0P_ clknet_leaf_39_clk
+ _01824_ VSS VSS VDD VDD network.in_spk11_02 sky130_fd_sc_hd__dfxtp_1
Xnetwork.neuron_in044.counter\[0\]$_DFFE_PP_ clknet_leaf_233_clk
+ _02240_ _01463_ VSS VSS VDD VDD network.neuron_in044.counter\[0\]
+ sky130_fd_sc_hd__edfxtp_1
Xnetwork.neuron_in044.counter\[1\]$_DFFE_PP_ clknet_leaf_233_clk
+ _02241_ _01463_ VSS VSS VDD VDD network.neuron_in044.counter\[1\]
+ sky130_fd_sc_hd__edfxtp_1
Xnetwork.neuron_in044.counter\[2\]$_DFFE_PP_ clknet_leaf_233_clk
+ _02242_ _01463_ VSS VSS VDD VDD network.neuron_in044.counter\[2\]
+ sky130_fd_sc_hd__edfxtp_1
Xnetwork.neuron_in044.counter\[3\]$_DFFE_PP_ clknet_leaf_234_clk
+ _02243_ _01463_ VSS VSS VDD VDD network.neuron_in044.counter\[3\]
+ sky130_fd_sc_hd__edfxtp_1
Xnetwork.neuron_in044.spike$_SDFFE_PP0P_ clknet_leaf_36_clk
+ _01823_ VSS VSS VDD VDD network.in_spk12_02 sky130_fd_sc_hd__dfxtp_1
Xnetwork.neuron_in045.counter\[0\]$_DFFE_PP_ clknet_leaf_234_clk
+ _02244_ _01462_ VSS VSS VDD VDD network.neuron_in045.counter\[0\]
+ sky130_fd_sc_hd__edfxtp_1
Xnetwork.neuron_in045.counter\[1\]$_DFFE_PP_ clknet_leaf_37_clk
+ _02245_ _01462_ VSS VSS VDD VDD network.neuron_in045.counter\[1\]
+ sky130_fd_sc_hd__edfxtp_1
Xnetwork.neuron_in045.counter\[2\]$_DFFE_PP_ clknet_leaf_37_clk
+ _02246_ _01462_ VSS VSS VDD VDD network.neuron_in045.counter\[2\]
+ sky130_fd_sc_hd__edfxtp_1
Xnetwork.neuron_in045.counter\[3\]$_DFFE_PP_ clknet_leaf_37_clk
+ _02247_ _01462_ VSS VSS VDD VDD network.neuron_in045.counter\[3\]
+ sky130_fd_sc_hd__edfxtp_1
Xnetwork.neuron_in045.spike$_SDFFE_PP0P_ clknet_leaf_37_clk
+ _01822_ VSS VSS VDD VDD network.in_spk13_02 sky130_fd_sc_hd__dfxtp_1
Xnetwork.neuron_in046.counter\[0\]$_DFFE_PP_ clknet_leaf_100_clk
+ _02248_ _01461_ VSS VSS VDD VDD network.neuron_in046.counter\[0\]
+ sky130_fd_sc_hd__edfxtp_1
Xnetwork.neuron_in046.counter\[1\]$_DFFE_PP_ clknet_leaf_100_clk
+ _02249_ _01461_ VSS VSS VDD VDD network.neuron_in046.counter\[1\]
+ sky130_fd_sc_hd__edfxtp_1
Xnetwork.neuron_in046.counter\[2\]$_DFFE_PP_ clknet_leaf_233_clk
+ _02250_ _01461_ VSS VSS VDD VDD network.neuron_in046.counter\[2\]
+ sky130_fd_sc_hd__edfxtp_1
Xnetwork.neuron_in046.counter\[3\]$_DFFE_PP_ clknet_leaf_233_clk
+ _02251_ _01461_ VSS VSS VDD VDD network.neuron_in046.counter\[3\]
+ sky130_fd_sc_hd__edfxtp_1
Xnetwork.neuron_in046.spike$_SDFFE_PP0P_ clknet_leaf_37_clk
+ _01821_ VSS VSS VDD VDD network.in_spk14_02 sky130_fd_sc_hd__dfxtp_1
Xnetwork.neuron_in047.counter\[0\]$_DFFE_PP_ clknet_leaf_38_clk
+ _02252_ _01460_ VSS VSS VDD VDD network.neuron_in047.counter\[0\]
+ sky130_fd_sc_hd__edfxtp_1
Xnetwork.neuron_in047.counter\[1\]$_DFFE_PP_ clknet_leaf_38_clk
+ _02253_ _01460_ VSS VSS VDD VDD network.neuron_in047.counter\[1\]
+ sky130_fd_sc_hd__edfxtp_1
Xnetwork.neuron_in047.counter\[2\]$_DFFE_PP_ clknet_leaf_37_clk
+ _02254_ _01460_ VSS VSS VDD VDD network.neuron_in047.counter\[2\]
+ sky130_fd_sc_hd__edfxtp_1
Xnetwork.neuron_in047.counter\[3\]$_DFFE_PP_ clknet_leaf_38_clk
+ _02255_ _01460_ VSS VSS VDD VDD network.neuron_in047.counter\[3\]
+ sky130_fd_sc_hd__edfxtp_1
Xnetwork.neuron_in047.spike$_SDFFE_PP0P_ clknet_leaf_37_clk
+ _01820_ VSS VSS VDD VDD network.in_spk15_02 sky130_fd_sc_hd__dfxtp_1
Xnetwork.neuron_in048.counter\[0\]$_DFFE_PP_ clknet_leaf_12_clk
+ _02256_ _01459_ VSS VSS VDD VDD network.neuron_in048.counter\[0\]
+ sky130_fd_sc_hd__edfxtp_1
Xnetwork.neuron_in048.counter\[1\]$_DFFE_PP_ clknet_leaf_13_clk
+ _02257_ _01459_ VSS VSS VDD VDD network.neuron_in048.counter\[1\]
+ sky130_fd_sc_hd__edfxtp_1
Xnetwork.neuron_in048.counter\[2\]$_DFFE_PP_ clknet_leaf_12_clk
+ _02258_ _01459_ VSS VSS VDD VDD network.neuron_in048.counter\[2\]
+ sky130_fd_sc_hd__edfxtp_1
Xnetwork.neuron_in048.counter\[3\]$_DFFE_PP_ clknet_leaf_12_clk
+ _02259_ _01459_ VSS VSS VDD VDD network.neuron_in048.counter\[3\]
+ sky130_fd_sc_hd__edfxtp_1
Xnetwork.neuron_in048.spike$_SDFFE_PP0P_ clknet_leaf_12_clk
+ _01819_ VSS VSS VDD VDD network.in_spk00_03 sky130_fd_sc_hd__dfxtp_1
Xnetwork.neuron_in049.counter\[0\]$_DFFE_PP_ clknet_leaf_6_clk
+ _02260_ _01458_ VSS VSS VDD VDD network.neuron_in049.counter\[0\]
+ sky130_fd_sc_hd__edfxtp_1
Xnetwork.neuron_in049.counter\[1\]$_DFFE_PP_ clknet_leaf_6_clk
+ _02261_ _01458_ VSS VSS VDD VDD network.neuron_in049.counter\[1\]
+ sky130_fd_sc_hd__edfxtp_1
Xnetwork.neuron_in049.counter\[2\]$_DFFE_PP_ clknet_leaf_5_clk
+ _02262_ _01458_ VSS VSS VDD VDD network.neuron_in049.counter\[2\]
+ sky130_fd_sc_hd__edfxtp_1
Xnetwork.neuron_in049.counter\[3\]$_DFFE_PP_ clknet_leaf_5_clk
+ _02263_ _01458_ VSS VSS VDD VDD network.neuron_in049.counter\[3\]
+ sky130_fd_sc_hd__edfxtp_1
Xnetwork.neuron_in049.spike$_SDFFE_PP0P_ clknet_leaf_9_clk
+ _01818_ VSS VSS VDD VDD network.in_spk01_03 sky130_fd_sc_hd__dfxtp_1
Xnetwork.neuron_in050.counter\[0\]$_DFFE_PP_ clknet_leaf_13_clk
+ _02264_ _01457_ VSS VSS VDD VDD network.neuron_in050.counter\[0\]
+ sky130_fd_sc_hd__edfxtp_1
Xnetwork.neuron_in050.counter\[1\]$_DFFE_PP_ clknet_leaf_13_clk
+ _02265_ _01457_ VSS VSS VDD VDD network.neuron_in050.counter\[1\]
+ sky130_fd_sc_hd__edfxtp_1
Xnetwork.neuron_in050.counter\[2\]$_DFFE_PP_ clknet_leaf_11_clk
+ _02266_ _01457_ VSS VSS VDD VDD network.neuron_in050.counter\[2\]
+ sky130_fd_sc_hd__edfxtp_1
Xnetwork.neuron_in050.counter\[3\]$_DFFE_PP_ clknet_leaf_13_clk
+ _02267_ _01457_ VSS VSS VDD VDD network.neuron_in050.counter\[3\]
+ sky130_fd_sc_hd__edfxtp_1
Xnetwork.neuron_in050.spike$_SDFFE_PP0P_ clknet_leaf_9_clk
+ _01817_ VSS VSS VDD VDD network.in_spk02_03 sky130_fd_sc_hd__dfxtp_1
Xnetwork.neuron_in051.counter\[0\]$_DFFE_PP_ clknet_leaf_4_clk
+ _02268_ _01456_ VSS VSS VDD VDD network.neuron_in051.counter\[0\]
+ sky130_fd_sc_hd__edfxtp_1
Xnetwork.neuron_in051.counter\[1\]$_DFFE_PP_ clknet_leaf_4_clk
+ _02269_ _01456_ VSS VSS VDD VDD network.neuron_in051.counter\[1\]
+ sky130_fd_sc_hd__edfxtp_1
Xnetwork.neuron_in051.counter\[2\]$_DFFE_PP_ clknet_leaf_12_clk
+ _02270_ _01456_ VSS VSS VDD VDD network.neuron_in051.counter\[2\]
+ sky130_fd_sc_hd__edfxtp_1
Xnetwork.neuron_in051.counter\[3\]$_DFFE_PP_ clknet_leaf_12_clk
+ _02271_ _01456_ VSS VSS VDD VDD network.neuron_in051.counter\[3\]
+ sky130_fd_sc_hd__edfxtp_1
Xnetwork.neuron_in051.spike$_SDFFE_PP0P_ clknet_leaf_9_clk
+ _01816_ VSS VSS VDD VDD network.in_spk03_03 sky130_fd_sc_hd__dfxtp_1
Xnetwork.neuron_in052.counter\[0\]$_DFFE_PP_ clknet_leaf_10_clk
+ _02272_ _01455_ VSS VSS VDD VDD network.neuron_in052.counter\[0\]
+ sky130_fd_sc_hd__edfxtp_1
Xnetwork.neuron_in052.counter\[1\]$_DFFE_PP_ clknet_leaf_10_clk
+ _02273_ _01455_ VSS VSS VDD VDD network.neuron_in052.counter\[1\]
+ sky130_fd_sc_hd__edfxtp_1
Xnetwork.neuron_in052.counter\[2\]$_DFFE_PP_ clknet_leaf_9_clk
+ _02274_ _01455_ VSS VSS VDD VDD network.neuron_in052.counter\[2\]
+ sky130_fd_sc_hd__edfxtp_1
Xnetwork.neuron_in052.counter\[3\]$_DFFE_PP_ clknet_leaf_11_clk
+ _02275_ _01455_ VSS VSS VDD VDD network.neuron_in052.counter\[3\]
+ sky130_fd_sc_hd__edfxtp_1
Xnetwork.neuron_in052.spike$_SDFFE_PP0P_ clknet_leaf_9_clk
+ _01815_ VSS VSS VDD VDD network.in_spk04_03 sky130_fd_sc_hd__dfxtp_1
Xnetwork.neuron_in053.counter\[0\]$_DFFE_PP_ clknet_leaf_7_clk
+ _02276_ _01454_ VSS VSS VDD VDD network.neuron_in053.counter\[0\]
+ sky130_fd_sc_hd__edfxtp_1
Xnetwork.neuron_in053.counter\[1\]$_DFFE_PP_ clknet_leaf_7_clk
+ _02277_ _01454_ VSS VSS VDD VDD network.neuron_in053.counter\[1\]
+ sky130_fd_sc_hd__edfxtp_1
Xnetwork.neuron_in053.counter\[2\]$_DFFE_PP_ clknet_leaf_7_clk
+ _02278_ _01454_ VSS VSS VDD VDD network.neuron_in053.counter\[2\]
+ sky130_fd_sc_hd__edfxtp_1
Xnetwork.neuron_in053.counter\[3\]$_DFFE_PP_ clknet_leaf_7_clk
+ _02279_ _01454_ VSS VSS VDD VDD network.neuron_in053.counter\[3\]
+ sky130_fd_sc_hd__edfxtp_1
Xnetwork.neuron_in053.spike$_SDFFE_PP0P_ clknet_leaf_8_clk
+ _01814_ VSS VSS VDD VDD network.in_spk05_03 sky130_fd_sc_hd__dfxtp_1
Xnetwork.neuron_in054.counter\[0\]$_DFFE_PP_ clknet_leaf_2_clk
+ _02280_ _01453_ VSS VSS VDD VDD network.neuron_in054.counter\[0\]
+ sky130_fd_sc_hd__edfxtp_1
Xnetwork.neuron_in054.counter\[1\]$_DFFE_PP_ clknet_leaf_2_clk
+ _02281_ _01453_ VSS VSS VDD VDD network.neuron_in054.counter\[1\]
+ sky130_fd_sc_hd__edfxtp_1
Xnetwork.neuron_in054.counter\[2\]$_DFFE_PP_ clknet_leaf_12_clk
+ _02282_ _01453_ VSS VSS VDD VDD network.neuron_in054.counter\[2\]
+ sky130_fd_sc_hd__edfxtp_1
Xnetwork.neuron_in054.counter\[3\]$_DFFE_PP_ clknet_leaf_3_clk
+ _02283_ _01453_ VSS VSS VDD VDD network.neuron_in054.counter\[3\]
+ sky130_fd_sc_hd__edfxtp_1
Xnetwork.neuron_in054.spike$_SDFFE_PP0P_ clknet_leaf_8_clk
+ _01813_ VSS VSS VDD VDD network.in_spk06_03 sky130_fd_sc_hd__dfxtp_1
Xnetwork.neuron_in055.counter\[0\]$_DFFE_PP_ clknet_leaf_3_clk
+ _02284_ _01452_ VSS VSS VDD VDD network.neuron_in055.counter\[0\]
+ sky130_fd_sc_hd__edfxtp_1
Xnetwork.neuron_in055.counter\[1\]$_DFFE_PP_ clknet_leaf_4_clk
+ _02285_ _01452_ VSS VSS VDD VDD network.neuron_in055.counter\[1\]
+ sky130_fd_sc_hd__edfxtp_1
Xnetwork.neuron_in055.counter\[2\]$_DFFE_PP_ clknet_leaf_0_clk
+ _02286_ _01452_ VSS VSS VDD VDD network.neuron_in055.counter\[2\]
+ sky130_fd_sc_hd__edfxtp_1
Xnetwork.neuron_in055.counter\[3\]$_DFFE_PP_ clknet_leaf_5_clk
+ _02287_ _01452_ VSS VSS VDD VDD network.neuron_in055.counter\[3\]
+ sky130_fd_sc_hd__edfxtp_1
Xnetwork.neuron_in055.spike$_SDFFE_PP0P_ clknet_leaf_8_clk
+ _01812_ VSS VSS VDD VDD network.in_spk07_03 sky130_fd_sc_hd__dfxtp_1
Xnetwork.neuron_in056.counter\[0\]$_DFFE_PP_ clknet_leaf_270_clk
+ _02288_ _01451_ VSS VSS VDD VDD network.neuron_in056.counter\[0\]
+ sky130_fd_sc_hd__edfxtp_1
Xnetwork.neuron_in056.counter\[1\]$_DFFE_PP_ clknet_leaf_0_clk
+ _02289_ _01451_ VSS VSS VDD VDD network.neuron_in056.counter\[1\]
+ sky130_fd_sc_hd__edfxtp_1
Xnetwork.neuron_in056.counter\[2\]$_DFFE_PP_ clknet_leaf_5_clk
+ _02290_ _01451_ VSS VSS VDD VDD network.neuron_in056.counter\[2\]
+ sky130_fd_sc_hd__edfxtp_1
Xnetwork.neuron_in056.counter\[3\]$_DFFE_PP_ clknet_leaf_0_clk
+ _02291_ _01451_ VSS VSS VDD VDD network.neuron_in056.counter\[3\]
+ sky130_fd_sc_hd__edfxtp_1
Xnetwork.neuron_in056.spike$_SDFFE_PP0P_ clknet_leaf_4_clk
+ _01811_ VSS VSS VDD VDD network.in_spk08_03 sky130_fd_sc_hd__dfxtp_1
Xnetwork.neuron_in057.counter\[0\]$_DFFE_PP_ clknet_leaf_1_clk
+ _02292_ _01450_ VSS VSS VDD VDD network.neuron_in057.counter\[0\]
+ sky130_fd_sc_hd__edfxtp_1
Xnetwork.neuron_in057.counter\[1\]$_DFFE_PP_ clknet_leaf_2_clk
+ _02293_ _01450_ VSS VSS VDD VDD network.neuron_in057.counter\[1\]
+ sky130_fd_sc_hd__edfxtp_1
Xnetwork.neuron_in057.counter\[2\]$_DFFE_PP_ clknet_leaf_2_clk
+ _02294_ _01450_ VSS VSS VDD VDD network.neuron_in057.counter\[2\]
+ sky130_fd_sc_hd__edfxtp_1
Xnetwork.neuron_in057.counter\[3\]$_DFFE_PP_ clknet_leaf_2_clk
+ _02295_ _01450_ VSS VSS VDD VDD network.neuron_in057.counter\[3\]
+ sky130_fd_sc_hd__edfxtp_1
Xnetwork.neuron_in057.spike$_SDFFE_PP0P_ clknet_leaf_6_clk
+ _01810_ VSS VSS VDD VDD network.in_spk09_03 sky130_fd_sc_hd__dfxtp_1
Xnetwork.neuron_in058.counter\[0\]$_DFFE_PP_ clknet_leaf_271_clk
+ _02296_ _01449_ VSS VSS VDD VDD network.neuron_in058.counter\[0\]
+ sky130_fd_sc_hd__edfxtp_1
Xnetwork.neuron_in058.counter\[1\]$_DFFE_PP_ clknet_leaf_271_clk
+ _02297_ _01449_ VSS VSS VDD VDD network.neuron_in058.counter\[1\]
+ sky130_fd_sc_hd__edfxtp_1
Xnetwork.neuron_in058.counter\[2\]$_DFFE_PP_ clknet_leaf_0_clk
+ _02298_ _01449_ VSS VSS VDD VDD network.neuron_in058.counter\[2\]
+ sky130_fd_sc_hd__edfxtp_1
Xnetwork.neuron_in058.counter\[3\]$_DFFE_PP_ clknet_leaf_0_clk
+ _02299_ _01449_ VSS VSS VDD VDD network.neuron_in058.counter\[3\]
+ sky130_fd_sc_hd__edfxtp_1
Xnetwork.neuron_in058.spike$_SDFFE_PP0P_ clknet_leaf_4_clk
+ _01809_ VSS VSS VDD VDD network.in_spk10_03 sky130_fd_sc_hd__dfxtp_1
Xnetwork.neuron_in059.counter\[0\]$_DFFE_PP_ clknet_leaf_1_clk
+ _02300_ _01448_ VSS VSS VDD VDD network.neuron_in059.counter\[0\]
+ sky130_fd_sc_hd__edfxtp_1
Xnetwork.neuron_in059.counter\[1\]$_DFFE_PP_ clknet_leaf_1_clk
+ _02301_ _01448_ VSS VSS VDD VDD network.neuron_in059.counter\[1\]
+ sky130_fd_sc_hd__edfxtp_1
Xnetwork.neuron_in059.counter\[2\]$_DFFE_PP_ clknet_leaf_0_clk
+ _02302_ _01448_ VSS VSS VDD VDD network.neuron_in059.counter\[2\]
+ sky130_fd_sc_hd__edfxtp_1
Xnetwork.neuron_in059.counter\[3\]$_DFFE_PP_ clknet_leaf_1_clk
+ _02303_ _01448_ VSS VSS VDD VDD network.neuron_in059.counter\[3\]
+ sky130_fd_sc_hd__edfxtp_1
Xnetwork.neuron_in059.spike$_SDFFE_PP0P_ clknet_leaf_6_clk
+ _01808_ VSS VSS VDD VDD network.in_spk11_03 sky130_fd_sc_hd__dfxtp_1
Xnetwork.neuron_in060.counter\[0\]$_DFFE_PP_ clknet_leaf_269_clk
+ _02304_ _01447_ VSS VSS VDD VDD network.neuron_in060.counter\[0\]
+ sky130_fd_sc_hd__edfxtp_1
Xnetwork.neuron_in060.counter\[1\]$_DFFE_PP_ clknet_leaf_269_clk
+ _02305_ _01447_ VSS VSS VDD VDD network.neuron_in060.counter\[1\]
+ sky130_fd_sc_hd__edfxtp_1
Xnetwork.neuron_in060.counter\[2\]$_DFFE_PP_ clknet_leaf_267_clk
+ _02306_ _01447_ VSS VSS VDD VDD network.neuron_in060.counter\[2\]
+ sky130_fd_sc_hd__edfxtp_1
Xnetwork.neuron_in060.counter\[3\]$_DFFE_PP_ clknet_leaf_267_clk
+ _02307_ _01447_ VSS VSS VDD VDD network.neuron_in060.counter\[3\]
+ sky130_fd_sc_hd__edfxtp_1
Xnetwork.neuron_in060.spike$_SDFFE_PP0P_ clknet_leaf_6_clk
+ _01807_ VSS VSS VDD VDD network.in_spk12_03 sky130_fd_sc_hd__dfxtp_1
Xnetwork.neuron_in061.counter\[0\]$_DFFE_PP_ clknet_leaf_265_clk
+ _02308_ _01446_ VSS VSS VDD VDD network.neuron_in061.counter\[0\]
+ sky130_fd_sc_hd__edfxtp_1
Xnetwork.neuron_in061.counter\[1\]$_DFFE_PP_ clknet_leaf_265_clk
+ _02309_ _01446_ VSS VSS VDD VDD network.neuron_in061.counter\[1\]
+ sky130_fd_sc_hd__edfxtp_1
Xnetwork.neuron_in061.counter\[2\]$_DFFE_PP_ clknet_leaf_7_clk
+ _02310_ _01446_ VSS VSS VDD VDD network.neuron_in061.counter\[2\]
+ sky130_fd_sc_hd__edfxtp_1
Xnetwork.neuron_in061.counter\[3\]$_DFFE_PP_ clknet_leaf_265_clk
+ _02311_ _01446_ VSS VSS VDD VDD network.neuron_in061.counter\[3\]
+ sky130_fd_sc_hd__edfxtp_1
Xnetwork.neuron_in061.spike$_SDFFE_PP0P_ clknet_leaf_7_clk
+ _01806_ VSS VSS VDD VDD network.in_spk13_03 sky130_fd_sc_hd__dfxtp_1
Xnetwork.neuron_in062.counter\[0\]$_DFFE_PP_ clknet_leaf_266_clk
+ _02312_ _01445_ VSS VSS VDD VDD network.neuron_in062.counter\[0\]
+ sky130_fd_sc_hd__edfxtp_1
Xnetwork.neuron_in062.counter\[1\]$_DFFE_PP_ clknet_leaf_266_clk
+ _02313_ _01445_ VSS VSS VDD VDD network.neuron_in062.counter\[1\]
+ sky130_fd_sc_hd__edfxtp_1
Xnetwork.neuron_in062.counter\[2\]$_DFFE_PP_ clknet_leaf_5_clk
+ _02314_ _01445_ VSS VSS VDD VDD network.neuron_in062.counter\[2\]
+ sky130_fd_sc_hd__edfxtp_1
Xnetwork.neuron_in062.counter\[3\]$_DFFE_PP_ clknet_leaf_5_clk
+ _02315_ _01445_ VSS VSS VDD VDD network.neuron_in062.counter\[3\]
+ sky130_fd_sc_hd__edfxtp_1
Xnetwork.neuron_in062.spike$_SDFFE_PP0P_ clknet_leaf_5_clk
+ _01805_ VSS VSS VDD VDD network.in_spk14_03 sky130_fd_sc_hd__dfxtp_1
Xnetwork.neuron_in063.counter\[0\]$_DFFE_PP_ clknet_leaf_270_clk
+ _02316_ _01444_ VSS VSS VDD VDD network.neuron_in063.counter\[0\]
+ sky130_fd_sc_hd__edfxtp_1
Xnetwork.neuron_in063.counter\[1\]$_DFFE_PP_ clknet_leaf_270_clk
+ _02317_ _01444_ VSS VSS VDD VDD network.neuron_in063.counter\[1\]
+ sky130_fd_sc_hd__edfxtp_1
Xnetwork.neuron_in063.counter\[2\]$_DFFE_PP_ clknet_leaf_270_clk
+ _02318_ _01444_ VSS VSS VDD VDD network.neuron_in063.counter\[2\]
+ sky130_fd_sc_hd__edfxtp_1
Xnetwork.neuron_in063.counter\[3\]$_DFFE_PP_ clknet_leaf_270_clk
+ _02319_ _01444_ VSS VSS VDD VDD network.neuron_in063.counter\[3\]
+ sky130_fd_sc_hd__edfxtp_1
Xnetwork.neuron_in063.spike$_SDFFE_PP0P_ clknet_leaf_6_clk
+ _01804_ VSS VSS VDD VDD network.in_spk15_03 sky130_fd_sc_hd__dfxtp_1
Xnetwork.neuron_in064.counter\[0\]$_DFFE_PP_ clknet_leaf_44_clk
+ _02320_ _01443_ VSS VSS VDD VDD network.neuron_in064.counter\[0\]
+ sky130_fd_sc_hd__edfxtp_1
Xnetwork.neuron_in064.counter\[1\]$_DFFE_PP_ clknet_leaf_44_clk
+ _02321_ _01443_ VSS VSS VDD VDD network.neuron_in064.counter\[1\]
+ sky130_fd_sc_hd__edfxtp_1
Xnetwork.neuron_in064.counter\[2\]$_DFFE_PP_ clknet_leaf_44_clk
+ _02322_ _01443_ VSS VSS VDD VDD network.neuron_in064.counter\[2\]
+ sky130_fd_sc_hd__edfxtp_1
Xnetwork.neuron_in064.counter\[3\]$_DFFE_PP_ clknet_leaf_44_clk
+ _02323_ _01443_ VSS VSS VDD VDD network.neuron_in064.counter\[3\]
+ sky130_fd_sc_hd__edfxtp_1
Xnetwork.neuron_in064.spike$_SDFFE_PP0P_ clknet_leaf_48_clk
+ _01803_ VSS VSS VDD VDD network.in_spk00_04 sky130_fd_sc_hd__dfxtp_1
Xnetwork.neuron_in065.counter\[0\]$_DFFE_PP_ clknet_leaf_47_clk
+ _02324_ _01442_ VSS VSS VDD VDD network.neuron_in065.counter\[0\]
+ sky130_fd_sc_hd__edfxtp_1
Xnetwork.neuron_in065.counter\[1\]$_DFFE_PP_ clknet_leaf_44_clk
+ _02325_ _01442_ VSS VSS VDD VDD network.neuron_in065.counter\[1\]
+ sky130_fd_sc_hd__edfxtp_1
Xnetwork.neuron_in065.counter\[2\]$_DFFE_PP_ clknet_leaf_46_clk
+ _02326_ _01442_ VSS VSS VDD VDD network.neuron_in065.counter\[2\]
+ sky130_fd_sc_hd__edfxtp_1
Xnetwork.neuron_in065.counter\[3\]$_DFFE_PP_ clknet_leaf_46_clk
+ _02327_ _01442_ VSS VSS VDD VDD network.neuron_in065.counter\[3\]
+ sky130_fd_sc_hd__edfxtp_1
Xnetwork.neuron_in065.spike$_SDFFE_PP0P_ clknet_leaf_48_clk
+ _01802_ VSS VSS VDD VDD network.in_spk01_04 sky130_fd_sc_hd__dfxtp_1
Xnetwork.neuron_in066.counter\[0\]$_DFFE_PP_ clknet_leaf_78_clk
+ _02328_ _01441_ VSS VSS VDD VDD network.neuron_in066.counter\[0\]
+ sky130_fd_sc_hd__edfxtp_1
Xnetwork.neuron_in066.counter\[1\]$_DFFE_PP_ clknet_leaf_78_clk
+ _02329_ _01441_ VSS VSS VDD VDD network.neuron_in066.counter\[1\]
+ sky130_fd_sc_hd__edfxtp_1
Xnetwork.neuron_in066.counter\[2\]$_DFFE_PP_ clknet_leaf_78_clk
+ _02330_ _01441_ VSS VSS VDD VDD network.neuron_in066.counter\[2\]
+ sky130_fd_sc_hd__edfxtp_1
Xnetwork.neuron_in066.counter\[3\]$_DFFE_PP_ clknet_leaf_78_clk
+ _02331_ _01441_ VSS VSS VDD VDD network.neuron_in066.counter\[3\]
+ sky130_fd_sc_hd__edfxtp_1
Xnetwork.neuron_in066.spike$_SDFFE_PP0P_ clknet_leaf_89_clk
+ _01801_ VSS VSS VDD VDD network.in_spk02_04 sky130_fd_sc_hd__dfxtp_1
Xnetwork.neuron_in067.counter\[0\]$_DFFE_PP_ clknet_leaf_76_clk
+ _02332_ _01440_ VSS VSS VDD VDD network.neuron_in067.counter\[0\]
+ sky130_fd_sc_hd__edfxtp_1
Xnetwork.neuron_in067.counter\[1\]$_DFFE_PP_ clknet_leaf_76_clk
+ _02333_ _01440_ VSS VSS VDD VDD network.neuron_in067.counter\[1\]
+ sky130_fd_sc_hd__edfxtp_1
Xnetwork.neuron_in067.counter\[2\]$_DFFE_PP_ clknet_leaf_75_clk
+ _02334_ _01440_ VSS VSS VDD VDD network.neuron_in067.counter\[2\]
+ sky130_fd_sc_hd__edfxtp_1
Xnetwork.neuron_in067.counter\[3\]$_DFFE_PP_ clknet_leaf_75_clk
+ _02335_ _01440_ VSS VSS VDD VDD network.neuron_in067.counter\[3\]
+ sky130_fd_sc_hd__edfxtp_1
Xnetwork.neuron_in067.spike$_SDFFE_PP0P_ clknet_leaf_89_clk
+ _01800_ VSS VSS VDD VDD network.in_spk03_04 sky130_fd_sc_hd__dfxtp_1
Xnetwork.neuron_in068.counter\[0\]$_DFFE_PP_ clknet_leaf_77_clk
+ _02336_ _01439_ VSS VSS VDD VDD network.neuron_in068.counter\[0\]
+ sky130_fd_sc_hd__edfxtp_1
Xnetwork.neuron_in068.counter\[1\]$_DFFE_PP_ clknet_leaf_77_clk
+ _02337_ _01439_ VSS VSS VDD VDD network.neuron_in068.counter\[1\]
+ sky130_fd_sc_hd__edfxtp_1
Xnetwork.neuron_in068.counter\[2\]$_DFFE_PP_ clknet_leaf_78_clk
+ _02338_ _01439_ VSS VSS VDD VDD network.neuron_in068.counter\[2\]
+ sky130_fd_sc_hd__edfxtp_1
Xnetwork.neuron_in068.counter\[3\]$_DFFE_PP_ clknet_leaf_78_clk
+ _02339_ _01439_ VSS VSS VDD VDD network.neuron_in068.counter\[3\]
+ sky130_fd_sc_hd__edfxtp_1
Xnetwork.neuron_in068.spike$_SDFFE_PP0P_ clknet_leaf_89_clk
+ _01799_ VSS VSS VDD VDD network.in_spk04_04 sky130_fd_sc_hd__dfxtp_1
Xnetwork.neuron_in069.counter\[0\]$_DFFE_PP_ clknet_leaf_47_clk
+ _02340_ _01438_ VSS VSS VDD VDD network.neuron_in069.counter\[0\]
+ sky130_fd_sc_hd__edfxtp_1
Xnetwork.neuron_in069.counter\[1\]$_DFFE_PP_ clknet_leaf_47_clk
+ _02341_ _01438_ VSS VSS VDD VDD network.neuron_in069.counter\[1\]
+ sky130_fd_sc_hd__edfxtp_1
Xnetwork.neuron_in069.counter\[2\]$_DFFE_PP_ clknet_leaf_47_clk
+ _02342_ _01438_ VSS VSS VDD VDD network.neuron_in069.counter\[2\]
+ sky130_fd_sc_hd__edfxtp_1
Xnetwork.neuron_in069.counter\[3\]$_DFFE_PP_ clknet_leaf_47_clk
+ _02343_ _01438_ VSS VSS VDD VDD network.neuron_in069.counter\[3\]
+ sky130_fd_sc_hd__edfxtp_1
Xnetwork.neuron_in069.spike$_SDFFE_PP0P_ clknet_leaf_89_clk
+ _01798_ VSS VSS VDD VDD network.in_spk05_04 sky130_fd_sc_hd__dfxtp_1
Xnetwork.neuron_in070.counter\[0\]$_DFFE_PP_ clknet_leaf_77_clk
+ _02344_ _01437_ VSS VSS VDD VDD network.neuron_in070.counter\[0\]
+ sky130_fd_sc_hd__edfxtp_1
Xnetwork.neuron_in070.counter\[1\]$_DFFE_PP_ clknet_leaf_88_clk
+ _02345_ _01437_ VSS VSS VDD VDD network.neuron_in070.counter\[1\]
+ sky130_fd_sc_hd__edfxtp_1
Xnetwork.neuron_in070.counter\[2\]$_DFFE_PP_ clknet_leaf_88_clk
+ _02346_ _01437_ VSS VSS VDD VDD network.neuron_in070.counter\[2\]
+ sky130_fd_sc_hd__edfxtp_1
Xnetwork.neuron_in070.counter\[3\]$_DFFE_PP_ clknet_leaf_89_clk
+ _02347_ _01437_ VSS VSS VDD VDD network.neuron_in070.counter\[3\]
+ sky130_fd_sc_hd__edfxtp_1
Xnetwork.neuron_in070.spike$_SDFFE_PP0P_ clknet_leaf_89_clk
+ _01797_ VSS VSS VDD VDD network.in_spk06_04 sky130_fd_sc_hd__dfxtp_1
Xnetwork.neuron_in071.counter\[0\]$_DFFE_PP_ clknet_leaf_71_clk
+ _02348_ _01436_ VSS VSS VDD VDD network.neuron_in071.counter\[0\]
+ sky130_fd_sc_hd__edfxtp_1
Xnetwork.neuron_in071.counter\[1\]$_DFFE_PP_ clknet_leaf_71_clk
+ _02349_ _01436_ VSS VSS VDD VDD network.neuron_in071.counter\[1\]
+ sky130_fd_sc_hd__edfxtp_1
Xnetwork.neuron_in071.counter\[2\]$_DFFE_PP_ clknet_leaf_76_clk
+ _02350_ _01436_ VSS VSS VDD VDD network.neuron_in071.counter\[2\]
+ sky130_fd_sc_hd__edfxtp_1
Xnetwork.neuron_in071.counter\[3\]$_DFFE_PP_ clknet_leaf_76_clk
+ _02351_ _01436_ VSS VSS VDD VDD network.neuron_in071.counter\[3\]
+ sky130_fd_sc_hd__edfxtp_1
Xnetwork.neuron_in071.spike$_SDFFE_PP0P_ clknet_leaf_70_clk
+ _01796_ VSS VSS VDD VDD network.in_spk07_04 sky130_fd_sc_hd__dfxtp_1
Xnetwork.neuron_in072.counter\[0\]$_DFFE_PP_ clknet_leaf_72_clk
+ _02352_ _01435_ VSS VSS VDD VDD network.neuron_in072.counter\[0\]
+ sky130_fd_sc_hd__edfxtp_1
Xnetwork.neuron_in072.counter\[1\]$_DFFE_PP_ clknet_leaf_72_clk
+ _02353_ _01435_ VSS VSS VDD VDD network.neuron_in072.counter\[1\]
+ sky130_fd_sc_hd__edfxtp_1
Xnetwork.neuron_in072.counter\[2\]$_DFFE_PP_ clknet_leaf_73_clk
+ _02354_ _01435_ VSS VSS VDD VDD network.neuron_in072.counter\[2\]
+ sky130_fd_sc_hd__edfxtp_1
Xnetwork.neuron_in072.counter\[3\]$_DFFE_PP_ clknet_leaf_72_clk
+ _02355_ _01435_ VSS VSS VDD VDD network.neuron_in072.counter\[3\]
+ sky130_fd_sc_hd__edfxtp_1
Xnetwork.neuron_in072.spike$_SDFFE_PP0P_ clknet_leaf_69_clk
+ _01795_ VSS VSS VDD VDD network.in_spk08_04 sky130_fd_sc_hd__dfxtp_1
Xnetwork.neuron_in073.counter\[0\]$_DFFE_PP_ clknet_leaf_69_clk
+ _02356_ _01434_ VSS VSS VDD VDD network.neuron_in073.counter\[0\]
+ sky130_fd_sc_hd__edfxtp_1
Xnetwork.neuron_in073.counter\[1\]$_DFFE_PP_ clknet_leaf_69_clk
+ _02357_ _01434_ VSS VSS VDD VDD network.neuron_in073.counter\[1\]
+ sky130_fd_sc_hd__edfxtp_1
Xnetwork.neuron_in073.counter\[2\]$_DFFE_PP_ clknet_leaf_69_clk
+ _02358_ _01434_ VSS VSS VDD VDD network.neuron_in073.counter\[2\]
+ sky130_fd_sc_hd__edfxtp_1
Xnetwork.neuron_in073.counter\[3\]$_DFFE_PP_ clknet_leaf_69_clk
+ _02359_ _01434_ VSS VSS VDD VDD network.neuron_in073.counter\[3\]
+ sky130_fd_sc_hd__edfxtp_1
Xnetwork.neuron_in073.spike$_SDFFE_PP0P_ clknet_leaf_69_clk
+ _01794_ VSS VSS VDD VDD network.in_spk09_04 sky130_fd_sc_hd__dfxtp_1
Xnetwork.neuron_in074.counter\[0\]$_DFFE_PP_ clknet_leaf_73_clk
+ _02360_ _01433_ VSS VSS VDD VDD network.neuron_in074.counter\[0\]
+ sky130_fd_sc_hd__edfxtp_1
Xnetwork.neuron_in074.counter\[1\]$_DFFE_PP_ clknet_leaf_73_clk
+ _02361_ _01433_ VSS VSS VDD VDD network.neuron_in074.counter\[1\]
+ sky130_fd_sc_hd__edfxtp_1
Xnetwork.neuron_in074.counter\[2\]$_DFFE_PP_ clknet_leaf_73_clk
+ _02362_ _01433_ VSS VSS VDD VDD network.neuron_in074.counter\[2\]
+ sky130_fd_sc_hd__edfxtp_1
Xnetwork.neuron_in074.counter\[3\]$_DFFE_PP_ clknet_leaf_73_clk
+ _02363_ _01433_ VSS VSS VDD VDD network.neuron_in074.counter\[3\]
+ sky130_fd_sc_hd__edfxtp_1
Xnetwork.neuron_in074.spike$_SDFFE_PP0P_ clknet_leaf_69_clk
+ _01793_ VSS VSS VDD VDD network.in_spk10_04 sky130_fd_sc_hd__dfxtp_1
Xnetwork.neuron_in075.counter\[0\]$_DFFE_PP_ clknet_leaf_69_clk
+ _02364_ _01432_ VSS VSS VDD VDD network.neuron_in075.counter\[0\]
+ sky130_fd_sc_hd__edfxtp_1
Xnetwork.neuron_in075.counter\[1\]$_DFFE_PP_ clknet_leaf_71_clk
+ _02365_ _01432_ VSS VSS VDD VDD network.neuron_in075.counter\[1\]
+ sky130_fd_sc_hd__edfxtp_1
Xnetwork.neuron_in075.counter\[2\]$_DFFE_PP_ clknet_leaf_71_clk
+ _02366_ _01432_ VSS VSS VDD VDD network.neuron_in075.counter\[2\]
+ sky130_fd_sc_hd__edfxtp_1
Xnetwork.neuron_in075.counter\[3\]$_DFFE_PP_ clknet_leaf_71_clk
+ _02367_ _01432_ VSS VSS VDD VDD network.neuron_in075.counter\[3\]
+ sky130_fd_sc_hd__edfxtp_1
Xnetwork.neuron_in075.spike$_SDFFE_PP0P_ clknet_leaf_70_clk
+ _01792_ VSS VSS VDD VDD network.in_spk11_04 sky130_fd_sc_hd__dfxtp_1
Xnetwork.neuron_in076.counter\[0\]$_DFFE_PP_ clknet_leaf_51_clk
+ _02368_ _01431_ VSS VSS VDD VDD network.neuron_in076.counter\[0\]
+ sky130_fd_sc_hd__edfxtp_1
Xnetwork.neuron_in076.counter\[1\]$_DFFE_PP_ clknet_leaf_51_clk
+ _02369_ _01431_ VSS VSS VDD VDD network.neuron_in076.counter\[1\]
+ sky130_fd_sc_hd__edfxtp_1
Xnetwork.neuron_in076.counter\[2\]$_DFFE_PP_ clknet_leaf_48_clk
+ _02370_ _01431_ VSS VSS VDD VDD network.neuron_in076.counter\[2\]
+ sky130_fd_sc_hd__edfxtp_1
Xnetwork.neuron_in076.counter\[3\]$_DFFE_PP_ clknet_leaf_49_clk
+ _02371_ _01431_ VSS VSS VDD VDD network.neuron_in076.counter\[3\]
+ sky130_fd_sc_hd__edfxtp_1
Xnetwork.neuron_in076.spike$_SDFFE_PP0P_ clknet_leaf_48_clk
+ _01791_ VSS VSS VDD VDD network.in_spk12_04 sky130_fd_sc_hd__dfxtp_1
Xnetwork.neuron_in077.counter\[0\]$_DFFE_PP_ clknet_leaf_70_clk
+ _02372_ _01430_ VSS VSS VDD VDD network.neuron_in077.counter\[0\]
+ sky130_fd_sc_hd__edfxtp_1
Xnetwork.neuron_in077.counter\[1\]$_DFFE_PP_ clknet_leaf_70_clk
+ _02373_ _01430_ VSS VSS VDD VDD network.neuron_in077.counter\[1\]
+ sky130_fd_sc_hd__edfxtp_1
Xnetwork.neuron_in077.counter\[2\]$_DFFE_PP_ clknet_leaf_70_clk
+ _02374_ _01430_ VSS VSS VDD VDD network.neuron_in077.counter\[2\]
+ sky130_fd_sc_hd__edfxtp_1
Xnetwork.neuron_in077.counter\[3\]$_DFFE_PP_ clknet_leaf_70_clk
+ _02375_ _01430_ VSS VSS VDD VDD network.neuron_in077.counter\[3\]
+ sky130_fd_sc_hd__edfxtp_1
Xnetwork.neuron_in077.spike$_SDFFE_PP0P_ clknet_leaf_70_clk
+ _01790_ VSS VSS VDD VDD network.in_spk13_04 sky130_fd_sc_hd__dfxtp_1
Xnetwork.neuron_in078.counter\[0\]$_DFFE_PP_ clknet_leaf_73_clk
+ _02376_ _01429_ VSS VSS VDD VDD network.neuron_in078.counter\[0\]
+ sky130_fd_sc_hd__edfxtp_1
Xnetwork.neuron_in078.counter\[1\]$_DFFE_PP_ clknet_leaf_73_clk
+ _02377_ _01429_ VSS VSS VDD VDD network.neuron_in078.counter\[1\]
+ sky130_fd_sc_hd__edfxtp_1
Xnetwork.neuron_in078.counter\[2\]$_DFFE_PP_ clknet_leaf_66_clk
+ _02378_ _01429_ VSS VSS VDD VDD network.neuron_in078.counter\[2\]
+ sky130_fd_sc_hd__edfxtp_1
Xnetwork.neuron_in078.counter\[3\]$_DFFE_PP_ clknet_leaf_66_clk
+ _02379_ _01429_ VSS VSS VDD VDD network.neuron_in078.counter\[3\]
+ sky130_fd_sc_hd__edfxtp_1
Xnetwork.neuron_in078.spike$_SDFFE_PP0P_ clknet_leaf_70_clk
+ _01789_ VSS VSS VDD VDD network.in_spk14_04 sky130_fd_sc_hd__dfxtp_1
Xnetwork.neuron_in079.counter\[0\]$_DFFE_PP_ clknet_leaf_49_clk
+ _02380_ _01428_ VSS VSS VDD VDD network.neuron_in079.counter\[0\]
+ sky130_fd_sc_hd__edfxtp_1
Xnetwork.neuron_in079.counter\[1\]$_DFFE_PP_ clknet_leaf_49_clk
+ _02381_ _01428_ VSS VSS VDD VDD network.neuron_in079.counter\[1\]
+ sky130_fd_sc_hd__edfxtp_1
Xnetwork.neuron_in079.counter\[2\]$_DFFE_PP_ clknet_leaf_48_clk
+ _02382_ _01428_ VSS VSS VDD VDD network.neuron_in079.counter\[2\]
+ sky130_fd_sc_hd__edfxtp_1
Xnetwork.neuron_in079.counter\[3\]$_DFFE_PP_ clknet_leaf_48_clk
+ _02383_ _01428_ VSS VSS VDD VDD network.neuron_in079.counter\[3\]
+ sky130_fd_sc_hd__edfxtp_1
Xnetwork.neuron_in079.spike$_SDFFE_PP0P_ clknet_leaf_70_clk
+ _01788_ VSS VSS VDD VDD network.in_spk15_04 sky130_fd_sc_hd__dfxtp_1
Xnetwork.neuron_in080.counter\[0\]$_DFFE_PP_ clknet_leaf_60_clk
+ _02384_ _01427_ VSS VSS VDD VDD network.neuron_in080.counter\[0\]
+ sky130_fd_sc_hd__edfxtp_1
Xnetwork.neuron_in080.counter\[1\]$_DFFE_PP_ clknet_leaf_60_clk
+ _02385_ _01427_ VSS VSS VDD VDD network.neuron_in080.counter\[1\]
+ sky130_fd_sc_hd__edfxtp_1
Xnetwork.neuron_in080.counter\[2\]$_DFFE_PP_ clknet_leaf_61_clk
+ _02386_ _01427_ VSS VSS VDD VDD network.neuron_in080.counter\[2\]
+ sky130_fd_sc_hd__edfxtp_1
Xnetwork.neuron_in080.counter\[3\]$_DFFE_PP_ clknet_leaf_60_clk
+ _02387_ _01427_ VSS VSS VDD VDD network.neuron_in080.counter\[3\]
+ sky130_fd_sc_hd__edfxtp_1
Xnetwork.neuron_in080.spike$_SDFFE_PP0P_ clknet_leaf_22_clk
+ _01787_ VSS VSS VDD VDD network.in_spk00_05 sky130_fd_sc_hd__dfxtp_1
Xnetwork.neuron_in081.counter\[0\]$_DFFE_PP_ clknet_leaf_52_clk
+ _02388_ _01426_ VSS VSS VDD VDD network.neuron_in081.counter\[0\]
+ sky130_fd_sc_hd__edfxtp_1
Xnetwork.neuron_in081.counter\[1\]$_DFFE_PP_ clknet_leaf_52_clk
+ _02389_ _01426_ VSS VSS VDD VDD network.neuron_in081.counter\[1\]
+ sky130_fd_sc_hd__edfxtp_1
Xnetwork.neuron_in081.counter\[2\]$_DFFE_PP_ clknet_leaf_51_clk
+ _02390_ _01426_ VSS VSS VDD VDD network.neuron_in081.counter\[2\]
+ sky130_fd_sc_hd__edfxtp_1
Xnetwork.neuron_in081.counter\[3\]$_DFFE_PP_ clknet_leaf_51_clk
+ _02391_ _01426_ VSS VSS VDD VDD network.neuron_in081.counter\[3\]
+ sky130_fd_sc_hd__edfxtp_1
Xnetwork.neuron_in081.spike$_SDFFE_PP0P_ clknet_leaf_23_clk
+ _01786_ VSS VSS VDD VDD network.in_spk01_05 sky130_fd_sc_hd__dfxtp_1
Xnetwork.neuron_in082.counter\[0\]$_DFFE_PP_ clknet_leaf_54_clk
+ _02392_ _01425_ VSS VSS VDD VDD network.neuron_in082.counter\[0\]
+ sky130_fd_sc_hd__edfxtp_1
Xnetwork.neuron_in082.counter\[1\]$_DFFE_PP_ clknet_leaf_54_clk
+ _02393_ _01425_ VSS VSS VDD VDD network.neuron_in082.counter\[1\]
+ sky130_fd_sc_hd__edfxtp_1
Xnetwork.neuron_in082.counter\[2\]$_DFFE_PP_ clknet_leaf_55_clk
+ _02394_ _01425_ VSS VSS VDD VDD network.neuron_in082.counter\[2\]
+ sky130_fd_sc_hd__edfxtp_1
Xnetwork.neuron_in082.counter\[3\]$_DFFE_PP_ clknet_leaf_53_clk
+ _02395_ _01425_ VSS VSS VDD VDD network.neuron_in082.counter\[3\]
+ sky130_fd_sc_hd__edfxtp_1
Xnetwork.neuron_in082.spike$_SDFFE_PP0P_ clknet_leaf_22_clk
+ _01785_ VSS VSS VDD VDD network.in_spk02_05 sky130_fd_sc_hd__dfxtp_1
Xnetwork.neuron_in083.counter\[0\]$_DFFE_PP_ clknet_leaf_53_clk
+ _02396_ _01424_ VSS VSS VDD VDD network.neuron_in083.counter\[0\]
+ sky130_fd_sc_hd__edfxtp_1
Xnetwork.neuron_in083.counter\[1\]$_DFFE_PP_ clknet_leaf_53_clk
+ _02397_ _01424_ VSS VSS VDD VDD network.neuron_in083.counter\[1\]
+ sky130_fd_sc_hd__edfxtp_1
Xnetwork.neuron_in083.counter\[2\]$_DFFE_PP_ clknet_leaf_53_clk
+ _02398_ _01424_ VSS VSS VDD VDD network.neuron_in083.counter\[2\]
+ sky130_fd_sc_hd__edfxtp_1
Xnetwork.neuron_in083.counter\[3\]$_DFFE_PP_ clknet_leaf_53_clk
+ _02399_ _01424_ VSS VSS VDD VDD network.neuron_in083.counter\[3\]
+ sky130_fd_sc_hd__edfxtp_1
Xnetwork.neuron_in083.spike$_SDFFE_PP0P_ clknet_leaf_23_clk
+ _01784_ VSS VSS VDD VDD network.in_spk03_05 sky130_fd_sc_hd__dfxtp_1
Xnetwork.neuron_in084.counter\[0\]$_DFFE_PP_ clknet_leaf_56_clk
+ _02400_ _01423_ VSS VSS VDD VDD network.neuron_in084.counter\[0\]
+ sky130_fd_sc_hd__edfxtp_1
Xnetwork.neuron_in084.counter\[1\]$_DFFE_PP_ clknet_leaf_54_clk
+ _02401_ _01423_ VSS VSS VDD VDD network.neuron_in084.counter\[1\]
+ sky130_fd_sc_hd__edfxtp_1
Xnetwork.neuron_in084.counter\[2\]$_DFFE_PP_ clknet_leaf_55_clk
+ _02402_ _01423_ VSS VSS VDD VDD network.neuron_in084.counter\[2\]
+ sky130_fd_sc_hd__edfxtp_1
Xnetwork.neuron_in084.counter\[3\]$_DFFE_PP_ clknet_leaf_55_clk
+ _02403_ _01423_ VSS VSS VDD VDD network.neuron_in084.counter\[3\]
+ sky130_fd_sc_hd__edfxtp_1
Xnetwork.neuron_in084.spike$_SDFFE_PP0P_ clknet_leaf_22_clk
+ _01783_ VSS VSS VDD VDD network.in_spk04_05 sky130_fd_sc_hd__dfxtp_1
Xnetwork.neuron_in085.counter\[0\]$_DFFE_PP_ clknet_leaf_59_clk
+ _02404_ _01422_ VSS VSS VDD VDD network.neuron_in085.counter\[0\]
+ sky130_fd_sc_hd__edfxtp_1
Xnetwork.neuron_in085.counter\[1\]$_DFFE_PP_ clknet_leaf_59_clk
+ _02405_ _01422_ VSS VSS VDD VDD network.neuron_in085.counter\[1\]
+ sky130_fd_sc_hd__edfxtp_1
Xnetwork.neuron_in085.counter\[2\]$_DFFE_PP_ clknet_leaf_58_clk
+ _02406_ _01422_ VSS VSS VDD VDD network.neuron_in085.counter\[2\]
+ sky130_fd_sc_hd__edfxtp_1
Xnetwork.neuron_in085.counter\[3\]$_DFFE_PP_ clknet_leaf_58_clk
+ _02407_ _01422_ VSS VSS VDD VDD network.neuron_in085.counter\[3\]
+ sky130_fd_sc_hd__edfxtp_1
Xnetwork.neuron_in085.spike$_SDFFE_PP0P_ clknet_leaf_22_clk
+ _01782_ VSS VSS VDD VDD network.in_spk05_05 sky130_fd_sc_hd__dfxtp_1
Xnetwork.neuron_in086.counter\[0\]$_DFFE_PP_ clknet_leaf_18_clk
+ _02408_ _01421_ VSS VSS VDD VDD network.neuron_in086.counter\[0\]
+ sky130_fd_sc_hd__edfxtp_1
Xnetwork.neuron_in086.counter\[1\]$_DFFE_PP_ clknet_leaf_18_clk
+ _02409_ _01421_ VSS VSS VDD VDD network.neuron_in086.counter\[1\]
+ sky130_fd_sc_hd__edfxtp_1
Xnetwork.neuron_in086.counter\[2\]$_DFFE_PP_ clknet_leaf_58_clk
+ _02410_ _01421_ VSS VSS VDD VDD network.neuron_in086.counter\[2\]
+ sky130_fd_sc_hd__edfxtp_1
Xnetwork.neuron_in086.counter\[3\]$_DFFE_PP_ clknet_leaf_58_clk
+ _02411_ _01421_ VSS VSS VDD VDD network.neuron_in086.counter\[3\]
+ sky130_fd_sc_hd__edfxtp_1
Xnetwork.neuron_in086.spike$_SDFFE_PP0P_ clknet_leaf_22_clk
+ _01781_ VSS VSS VDD VDD network.in_spk06_05 sky130_fd_sc_hd__dfxtp_1
Xnetwork.neuron_in087.counter\[0\]$_DFFE_PP_ clknet_leaf_19_clk
+ _02412_ _01420_ VSS VSS VDD VDD network.neuron_in087.counter\[0\]
+ sky130_fd_sc_hd__edfxtp_1
Xnetwork.neuron_in087.counter\[1\]$_DFFE_PP_ clknet_leaf_19_clk
+ _02413_ _01420_ VSS VSS VDD VDD network.neuron_in087.counter\[1\]
+ sky130_fd_sc_hd__edfxtp_1
Xnetwork.neuron_in087.counter\[2\]$_DFFE_PP_ clknet_leaf_57_clk
+ _02414_ _01420_ VSS VSS VDD VDD network.neuron_in087.counter\[2\]
+ sky130_fd_sc_hd__edfxtp_1
Xnetwork.neuron_in087.counter\[3\]$_DFFE_PP_ clknet_leaf_57_clk
+ _02415_ _01420_ VSS VSS VDD VDD network.neuron_in087.counter\[3\]
+ sky130_fd_sc_hd__edfxtp_1
Xnetwork.neuron_in087.spike$_SDFFE_PP0P_ clknet_leaf_21_clk
+ _01780_ VSS VSS VDD VDD network.in_spk07_05 sky130_fd_sc_hd__dfxtp_1
Xnetwork.neuron_in088.counter\[0\]$_DFFE_PP_ clknet_leaf_16_clk
+ _02416_ _01419_ VSS VSS VDD VDD network.neuron_in088.counter\[0\]
+ sky130_fd_sc_hd__edfxtp_1
Xnetwork.neuron_in088.counter\[1\]$_DFFE_PP_ clknet_leaf_16_clk
+ _02417_ _01419_ VSS VSS VDD VDD network.neuron_in088.counter\[1\]
+ sky130_fd_sc_hd__edfxtp_1
Xnetwork.neuron_in088.counter\[2\]$_DFFE_PP_ clknet_leaf_19_clk
+ _02418_ _01419_ VSS VSS VDD VDD network.neuron_in088.counter\[2\]
+ sky130_fd_sc_hd__edfxtp_1
Xnetwork.neuron_in088.counter\[3\]$_DFFE_PP_ clknet_leaf_19_clk
+ _02419_ _01419_ VSS VSS VDD VDD network.neuron_in088.counter\[3\]
+ sky130_fd_sc_hd__edfxtp_1
Xnetwork.neuron_in088.spike$_SDFFE_PP0P_ clknet_leaf_21_clk
+ _01779_ VSS VSS VDD VDD network.in_spk08_05 sky130_fd_sc_hd__dfxtp_1
Xnetwork.neuron_in089.counter\[0\]$_DFFE_PP_ clknet_leaf_10_clk
+ _02420_ _01418_ VSS VSS VDD VDD network.neuron_in089.counter\[0\]
+ sky130_fd_sc_hd__edfxtp_1
Xnetwork.neuron_in089.counter\[1\]$_DFFE_PP_ clknet_leaf_25_clk
+ _02421_ _01418_ VSS VSS VDD VDD network.neuron_in089.counter\[1\]
+ sky130_fd_sc_hd__edfxtp_1
Xnetwork.neuron_in089.counter\[2\]$_DFFE_PP_ clknet_leaf_25_clk
+ _02422_ _01418_ VSS VSS VDD VDD network.neuron_in089.counter\[2\]
+ sky130_fd_sc_hd__edfxtp_1
Xnetwork.neuron_in089.counter\[3\]$_DFFE_PP_ clknet_leaf_10_clk
+ _02423_ _01418_ VSS VSS VDD VDD network.neuron_in089.counter\[3\]
+ sky130_fd_sc_hd__edfxtp_1
Xnetwork.neuron_in089.spike$_SDFFE_PP0P_ clknet_leaf_21_clk
+ _01778_ VSS VSS VDD VDD network.in_spk09_05 sky130_fd_sc_hd__dfxtp_1
Xnetwork.neuron_in090.counter\[0\]$_DFFE_PP_ clknet_leaf_17_clk
+ _02424_ _01417_ VSS VSS VDD VDD network.neuron_in090.counter\[0\]
+ sky130_fd_sc_hd__edfxtp_1
Xnetwork.neuron_in090.counter\[1\]$_DFFE_PP_ clknet_leaf_17_clk
+ _02425_ _01417_ VSS VSS VDD VDD network.neuron_in090.counter\[1\]
+ sky130_fd_sc_hd__edfxtp_1
Xnetwork.neuron_in090.counter\[2\]$_DFFE_PP_ clknet_leaf_16_clk
+ _02426_ _01417_ VSS VSS VDD VDD network.neuron_in090.counter\[2\]
+ sky130_fd_sc_hd__edfxtp_1
Xnetwork.neuron_in090.counter\[3\]$_DFFE_PP_ clknet_leaf_16_clk
+ _02427_ _01417_ VSS VSS VDD VDD network.neuron_in090.counter\[3\]
+ sky130_fd_sc_hd__edfxtp_1
Xnetwork.neuron_in090.spike$_SDFFE_PP0P_ clknet_leaf_21_clk
+ _01777_ VSS VSS VDD VDD network.in_spk10_05 sky130_fd_sc_hd__dfxtp_1
Xnetwork.neuron_in091.counter\[0\]$_DFFE_PP_ clknet_leaf_17_clk
+ _02428_ _01416_ VSS VSS VDD VDD network.neuron_in091.counter\[0\]
+ sky130_fd_sc_hd__edfxtp_1
Xnetwork.neuron_in091.counter\[1\]$_DFFE_PP_ clknet_leaf_17_clk
+ _02429_ _01416_ VSS VSS VDD VDD network.neuron_in091.counter\[1\]
+ sky130_fd_sc_hd__edfxtp_1
Xnetwork.neuron_in091.counter\[2\]$_DFFE_PP_ clknet_leaf_17_clk
+ _02430_ _01416_ VSS VSS VDD VDD network.neuron_in091.counter\[2\]
+ sky130_fd_sc_hd__edfxtp_1
Xnetwork.neuron_in091.counter\[3\]$_DFFE_PP_ clknet_leaf_17_clk
+ _02431_ _01416_ VSS VSS VDD VDD network.neuron_in091.counter\[3\]
+ sky130_fd_sc_hd__edfxtp_1
Xnetwork.neuron_in091.spike$_SDFFE_PP0P_ clknet_leaf_21_clk
+ _01776_ VSS VSS VDD VDD network.in_spk11_05 sky130_fd_sc_hd__dfxtp_1
Xnetwork.neuron_in092.counter\[0\]$_DFFE_PP_ clknet_leaf_15_clk
+ _02432_ _01415_ VSS VSS VDD VDD network.neuron_in092.counter\[0\]
+ sky130_fd_sc_hd__edfxtp_1
Xnetwork.neuron_in092.counter\[1\]$_DFFE_PP_ clknet_leaf_15_clk
+ _02433_ _01415_ VSS VSS VDD VDD network.neuron_in092.counter\[1\]
+ sky130_fd_sc_hd__edfxtp_1
Xnetwork.neuron_in092.counter\[2\]$_DFFE_PP_ clknet_leaf_11_clk
+ _02434_ _01415_ VSS VSS VDD VDD network.neuron_in092.counter\[2\]
+ sky130_fd_sc_hd__edfxtp_1
Xnetwork.neuron_in092.counter\[3\]$_DFFE_PP_ clknet_leaf_11_clk
+ _02435_ _01415_ VSS VSS VDD VDD network.neuron_in092.counter\[3\]
+ sky130_fd_sc_hd__edfxtp_1
Xnetwork.neuron_in092.spike$_SDFFE_PP0P_ clknet_leaf_25_clk
+ _01775_ VSS VSS VDD VDD network.in_spk12_05 sky130_fd_sc_hd__dfxtp_1
Xnetwork.neuron_in093.counter\[0\]$_DFFE_PP_ clknet_leaf_13_clk
+ _02436_ _01414_ VSS VSS VDD VDD network.neuron_in093.counter\[0\]
+ sky130_fd_sc_hd__edfxtp_1
Xnetwork.neuron_in093.counter\[1\]$_DFFE_PP_ clknet_leaf_14_clk
+ _02437_ _01414_ VSS VSS VDD VDD network.neuron_in093.counter\[1\]
+ sky130_fd_sc_hd__edfxtp_1
Xnetwork.neuron_in093.counter\[2\]$_DFFE_PP_ clknet_leaf_14_clk
+ _02438_ _01414_ VSS VSS VDD VDD network.neuron_in093.counter\[2\]
+ sky130_fd_sc_hd__edfxtp_1
Xnetwork.neuron_in093.counter\[3\]$_DFFE_PP_ clknet_leaf_13_clk
+ _02439_ _01414_ VSS VSS VDD VDD network.neuron_in093.counter\[3\]
+ sky130_fd_sc_hd__edfxtp_1
Xnetwork.neuron_in093.spike$_SDFFE_PP0P_ clknet_leaf_25_clk
+ _01774_ VSS VSS VDD VDD network.in_spk13_05 sky130_fd_sc_hd__dfxtp_1
Xnetwork.neuron_in094.counter\[0\]$_DFFE_PP_ clknet_leaf_16_clk
+ _02440_ _01413_ VSS VSS VDD VDD network.neuron_in094.counter\[0\]
+ sky130_fd_sc_hd__edfxtp_1
Xnetwork.neuron_in094.counter\[1\]$_DFFE_PP_ clknet_leaf_15_clk
+ _02441_ _01413_ VSS VSS VDD VDD network.neuron_in094.counter\[1\]
+ sky130_fd_sc_hd__edfxtp_1
Xnetwork.neuron_in094.counter\[2\]$_DFFE_PP_ clknet_leaf_20_clk
+ _02442_ _01413_ VSS VSS VDD VDD network.neuron_in094.counter\[2\]
+ sky130_fd_sc_hd__edfxtp_1
Xnetwork.neuron_in094.counter\[3\]$_DFFE_PP_ clknet_leaf_15_clk
+ _02443_ _01413_ VSS VSS VDD VDD network.neuron_in094.counter\[3\]
+ sky130_fd_sc_hd__edfxtp_1
Xnetwork.neuron_in094.spike$_SDFFE_PP0P_ clknet_leaf_25_clk
+ _01773_ VSS VSS VDD VDD network.in_spk14_05 sky130_fd_sc_hd__dfxtp_1
Xnetwork.neuron_in095.counter\[0\]$_DFFE_PP_ clknet_leaf_16_clk
+ _02444_ _01412_ VSS VSS VDD VDD network.neuron_in095.counter\[0\]
+ sky130_fd_sc_hd__edfxtp_1
Xnetwork.neuron_in095.counter\[1\]$_DFFE_PP_ clknet_leaf_14_clk
+ _02445_ _01412_ VSS VSS VDD VDD network.neuron_in095.counter\[1\]
+ sky130_fd_sc_hd__edfxtp_1
Xnetwork.neuron_in095.counter\[2\]$_DFFE_PP_ clknet_leaf_14_clk
+ _02446_ _01412_ VSS VSS VDD VDD network.neuron_in095.counter\[2\]
+ sky130_fd_sc_hd__edfxtp_1
Xnetwork.neuron_in095.counter\[3\]$_DFFE_PP_ clknet_leaf_14_clk
+ _02447_ _01412_ VSS VSS VDD VDD network.neuron_in095.counter\[3\]
+ sky130_fd_sc_hd__edfxtp_1
Xnetwork.neuron_in095.spike$_SDFFE_PP0P_ clknet_leaf_25_clk
+ _01772_ VSS VSS VDD VDD network.in_spk15_05 sky130_fd_sc_hd__dfxtp_1
Xnetwork.neuron_in096.counter\[0\]$_DFFE_PP_ clknet_leaf_32_clk
+ _02448_ _01411_ VSS VSS VDD VDD network.neuron_in096.counter\[0\]
+ sky130_fd_sc_hd__edfxtp_1
Xnetwork.neuron_in096.counter\[1\]$_DFFE_PP_ clknet_leaf_32_clk
+ _02449_ _01411_ VSS VSS VDD VDD network.neuron_in096.counter\[1\]
+ sky130_fd_sc_hd__edfxtp_1
Xnetwork.neuron_in096.counter\[2\]$_DFFE_PP_ clknet_leaf_43_clk
+ _02450_ _01411_ VSS VSS VDD VDD network.neuron_in096.counter\[2\]
+ sky130_fd_sc_hd__edfxtp_1
Xnetwork.neuron_in096.counter\[3\]$_DFFE_PP_ clknet_leaf_43_clk
+ _02451_ _01411_ VSS VSS VDD VDD network.neuron_in096.counter\[3\]
+ sky130_fd_sc_hd__edfxtp_1
Xnetwork.neuron_in096.spike$_SDFFE_PP0P_ clknet_leaf_31_clk
+ _01771_ VSS VSS VDD VDD network.in_spk00_06 sky130_fd_sc_hd__dfxtp_1
Xnetwork.neuron_in097.counter\[0\]$_DFFE_PP_ clknet_leaf_33_clk
+ _02452_ _01410_ VSS VSS VDD VDD network.neuron_in097.counter\[0\]
+ sky130_fd_sc_hd__edfxtp_1
Xnetwork.neuron_in097.counter\[1\]$_DFFE_PP_ clknet_leaf_33_clk
+ _02453_ _01410_ VSS VSS VDD VDD network.neuron_in097.counter\[1\]
+ sky130_fd_sc_hd__edfxtp_1
Xnetwork.neuron_in097.counter\[2\]$_DFFE_PP_ clknet_leaf_33_clk
+ _02454_ _01410_ VSS VSS VDD VDD network.neuron_in097.counter\[2\]
+ sky130_fd_sc_hd__edfxtp_1
Xnetwork.neuron_in097.counter\[3\]$_DFFE_PP_ clknet_leaf_32_clk
+ _02455_ _01410_ VSS VSS VDD VDD network.neuron_in097.counter\[3\]
+ sky130_fd_sc_hd__edfxtp_1
Xnetwork.neuron_in097.spike$_SDFFE_PP0P_ clknet_leaf_32_clk
+ _01770_ VSS VSS VDD VDD network.in_spk01_06 sky130_fd_sc_hd__dfxtp_1
Xnetwork.neuron_in098.counter\[0\]$_DFFE_PP_ clknet_leaf_24_clk
+ _02456_ _01409_ VSS VSS VDD VDD network.neuron_in098.counter\[0\]
+ sky130_fd_sc_hd__edfxtp_1
Xnetwork.neuron_in098.counter\[1\]$_DFFE_PP_ clknet_leaf_32_clk
+ _02457_ _01409_ VSS VSS VDD VDD network.neuron_in098.counter\[1\]
+ sky130_fd_sc_hd__edfxtp_1
Xnetwork.neuron_in098.counter\[2\]$_DFFE_PP_ clknet_leaf_31_clk
+ _02458_ _01409_ VSS VSS VDD VDD network.neuron_in098.counter\[2\]
+ sky130_fd_sc_hd__edfxtp_1
Xnetwork.neuron_in098.counter\[3\]$_DFFE_PP_ clknet_leaf_32_clk
+ _02459_ _01409_ VSS VSS VDD VDD network.neuron_in098.counter\[3\]
+ sky130_fd_sc_hd__edfxtp_1
Xnetwork.neuron_in098.spike$_SDFFE_PP0P_ clknet_leaf_31_clk
+ _02063_ VSS VSS VDD VDD network.in_spk02_06 sky130_fd_sc_hd__dfxtp_1
Xnetwork.neuron_in099.counter\[0\]$_DFFE_PP_ clknet_leaf_31_clk
+ _02460_ _01408_ VSS VSS VDD VDD network.neuron_in099.counter\[0\]
+ sky130_fd_sc_hd__edfxtp_1
Xnetwork.neuron_in099.counter\[1\]$_DFFE_PP_ clknet_leaf_31_clk
+ _02461_ _01408_ VSS VSS VDD VDD network.neuron_in099.counter\[1\]
+ sky130_fd_sc_hd__edfxtp_1
Xnetwork.neuron_in099.counter\[2\]$_DFFE_PP_ clknet_leaf_31_clk
+ _02462_ _01408_ VSS VSS VDD VDD network.neuron_in099.counter\[2\]
+ sky130_fd_sc_hd__edfxtp_1
Xnetwork.neuron_in099.counter\[3\]$_DFFE_PP_ clknet_leaf_31_clk
+ _02463_ _01408_ VSS VSS VDD VDD network.neuron_in099.counter\[3\]
+ sky130_fd_sc_hd__edfxtp_1
Xnetwork.neuron_in099.spike$_SDFFE_PP0P_ clknet_leaf_31_clk
+ _02062_ VSS VSS VDD VDD network.in_spk03_06 sky130_fd_sc_hd__dfxtp_1
Xnetwork.neuron_in100.counter\[0\]$_DFFE_PP_ clknet_leaf_33_clk
+ _02464_ _01407_ VSS VSS VDD VDD network.neuron_in100.counter\[0\]
+ sky130_fd_sc_hd__edfxtp_1
Xnetwork.neuron_in100.counter\[1\]$_DFFE_PP_ clknet_leaf_33_clk
+ _02465_ _01407_ VSS VSS VDD VDD network.neuron_in100.counter\[1\]
+ sky130_fd_sc_hd__edfxtp_1
Xnetwork.neuron_in100.counter\[2\]$_DFFE_PP_ clknet_leaf_34_clk
+ _02466_ _01407_ VSS VSS VDD VDD network.neuron_in100.counter\[2\]
+ sky130_fd_sc_hd__edfxtp_1
Xnetwork.neuron_in100.counter\[3\]$_DFFE_PP_ clknet_leaf_34_clk
+ _02467_ _01407_ VSS VSS VDD VDD network.neuron_in100.counter\[3\]
+ sky130_fd_sc_hd__edfxtp_1
Xnetwork.neuron_in100.spike$_SDFFE_PP0P_ clknet_leaf_34_clk
+ _02061_ VSS VSS VDD VDD network.in_spk04_06 sky130_fd_sc_hd__dfxtp_1
Xnetwork.neuron_in101.counter\[0\]$_DFFE_PP_ clknet_leaf_36_clk
+ _02468_ _01406_ VSS VSS VDD VDD network.neuron_in101.counter\[0\]
+ sky130_fd_sc_hd__edfxtp_1
Xnetwork.neuron_in101.counter\[1\]$_DFFE_PP_ clknet_leaf_235_clk
+ _02469_ _01406_ VSS VSS VDD VDD network.neuron_in101.counter\[1\]
+ sky130_fd_sc_hd__edfxtp_1
Xnetwork.neuron_in101.counter\[2\]$_DFFE_PP_ clknet_leaf_235_clk
+ _02470_ _01406_ VSS VSS VDD VDD network.neuron_in101.counter\[2\]
+ sky130_fd_sc_hd__edfxtp_1
Xnetwork.neuron_in101.counter\[3\]$_DFFE_PP_ clknet_leaf_235_clk
+ _02471_ _01406_ VSS VSS VDD VDD network.neuron_in101.counter\[3\]
+ sky130_fd_sc_hd__edfxtp_1
Xnetwork.neuron_in101.spike$_SDFFE_PP0P_ clknet_leaf_34_clk
+ _02060_ VSS VSS VDD VDD network.in_spk05_06 sky130_fd_sc_hd__dfxtp_1
Xnetwork.neuron_in102.counter\[0\]$_DFFE_PP_ clknet_leaf_236_clk
+ _02472_ _01405_ VSS VSS VDD VDD network.neuron_in102.counter\[0\]
+ sky130_fd_sc_hd__edfxtp_1
Xnetwork.neuron_in102.counter\[1\]$_DFFE_PP_ clknet_leaf_236_clk
+ _02473_ _01405_ VSS VSS VDD VDD network.neuron_in102.counter\[1\]
+ sky130_fd_sc_hd__edfxtp_1
Xnetwork.neuron_in102.counter\[2\]$_DFFE_PP_ clknet_leaf_235_clk
+ _02474_ _01405_ VSS VSS VDD VDD network.neuron_in102.counter\[2\]
+ sky130_fd_sc_hd__edfxtp_1
Xnetwork.neuron_in102.counter\[3\]$_DFFE_PP_ clknet_leaf_35_clk
+ _02475_ _01405_ VSS VSS VDD VDD network.neuron_in102.counter\[3\]
+ sky130_fd_sc_hd__edfxtp_1
Xnetwork.neuron_in102.spike$_SDFFE_PP0P_ clknet_leaf_35_clk
+ _02059_ VSS VSS VDD VDD network.in_spk06_06 sky130_fd_sc_hd__dfxtp_1
Xnetwork.neuron_in103.counter\[0\]$_DFFE_PP_ clknet_leaf_35_clk
+ _02476_ _01404_ VSS VSS VDD VDD network.neuron_in103.counter\[0\]
+ sky130_fd_sc_hd__edfxtp_1
Xnetwork.neuron_in103.counter\[1\]$_DFFE_PP_ clknet_leaf_35_clk
+ _02477_ _01404_ VSS VSS VDD VDD network.neuron_in103.counter\[1\]
+ sky130_fd_sc_hd__edfxtp_1
Xnetwork.neuron_in103.counter\[2\]$_DFFE_PP_ clknet_leaf_35_clk
+ _02478_ _01404_ VSS VSS VDD VDD network.neuron_in103.counter\[2\]
+ sky130_fd_sc_hd__edfxtp_1
Xnetwork.neuron_in103.counter\[3\]$_DFFE_PP_ clknet_leaf_35_clk
+ _02479_ _01404_ VSS VSS VDD VDD network.neuron_in103.counter\[3\]
+ sky130_fd_sc_hd__edfxtp_1
Xnetwork.neuron_in103.spike$_SDFFE_PP0P_ clknet_leaf_35_clk
+ _02058_ VSS VSS VDD VDD network.in_spk07_06 sky130_fd_sc_hd__dfxtp_1
Xnetwork.neuron_in104.counter\[0\]$_DFFE_PP_ clknet_leaf_241_clk
+ _02480_ _01403_ VSS VSS VDD VDD network.neuron_in104.counter\[0\]
+ sky130_fd_sc_hd__edfxtp_1
Xnetwork.neuron_in104.counter\[1\]$_DFFE_PP_ clknet_leaf_240_clk
+ _02481_ _01403_ VSS VSS VDD VDD network.neuron_in104.counter\[1\]
+ sky130_fd_sc_hd__edfxtp_1
Xnetwork.neuron_in104.counter\[2\]$_DFFE_PP_ clknet_leaf_240_clk
+ _02482_ _01403_ VSS VSS VDD VDD network.neuron_in104.counter\[2\]
+ sky130_fd_sc_hd__edfxtp_1
Xnetwork.neuron_in104.counter\[3\]$_DFFE_PP_ clknet_leaf_241_clk
+ _02483_ _01403_ VSS VSS VDD VDD network.neuron_in104.counter\[3\]
+ sky130_fd_sc_hd__edfxtp_1
Xnetwork.neuron_in104.spike$_SDFFE_PP0P_ clknet_leaf_30_clk
+ _02057_ VSS VSS VDD VDD network.in_spk08_06 sky130_fd_sc_hd__dfxtp_1
Xnetwork.neuron_in105.counter\[0\]$_DFFE_PP_ clknet_leaf_239_clk
+ _02484_ _01402_ VSS VSS VDD VDD network.neuron_in105.counter\[0\]
+ sky130_fd_sc_hd__edfxtp_1
Xnetwork.neuron_in105.counter\[1\]$_DFFE_PP_ clknet_leaf_239_clk
+ _02485_ _01402_ VSS VSS VDD VDD network.neuron_in105.counter\[1\]
+ sky130_fd_sc_hd__edfxtp_1
Xnetwork.neuron_in105.counter\[2\]$_DFFE_PP_ clknet_leaf_240_clk
+ _02486_ _01402_ VSS VSS VDD VDD network.neuron_in105.counter\[2\]
+ sky130_fd_sc_hd__edfxtp_1
Xnetwork.neuron_in105.counter\[3\]$_DFFE_PP_ clknet_leaf_239_clk
+ _02487_ _01402_ VSS VSS VDD VDD network.neuron_in105.counter\[3\]
+ sky130_fd_sc_hd__edfxtp_1
Xnetwork.neuron_in105.spike$_SDFFE_PP0P_ clknet_leaf_30_clk
+ _02056_ VSS VSS VDD VDD network.in_spk09_06 sky130_fd_sc_hd__dfxtp_1
Xnetwork.neuron_in106.counter\[0\]$_DFFE_PP_ clknet_leaf_241_clk
+ _02488_ _01401_ VSS VSS VDD VDD network.neuron_in106.counter\[0\]
+ sky130_fd_sc_hd__edfxtp_1
Xnetwork.neuron_in106.counter\[1\]$_DFFE_PP_ clknet_leaf_241_clk
+ _02489_ _01401_ VSS VSS VDD VDD network.neuron_in106.counter\[1\]
+ sky130_fd_sc_hd__edfxtp_1
Xnetwork.neuron_in106.counter\[2\]$_DFFE_PP_ clknet_leaf_242_clk
+ _02490_ _01401_ VSS VSS VDD VDD network.neuron_in106.counter\[2\]
+ sky130_fd_sc_hd__edfxtp_1
Xnetwork.neuron_in106.counter\[3\]$_DFFE_PP_ clknet_leaf_242_clk
+ _02491_ _01401_ VSS VSS VDD VDD network.neuron_in106.counter\[3\]
+ sky130_fd_sc_hd__edfxtp_1
Xnetwork.neuron_in106.spike$_SDFFE_PP0P_ clknet_leaf_30_clk
+ _02055_ VSS VSS VDD VDD network.in_spk10_06 sky130_fd_sc_hd__dfxtp_1
Xnetwork.neuron_in107.counter\[0\]$_DFFE_PP_ clknet_leaf_29_clk
+ _02492_ _01400_ VSS VSS VDD VDD network.neuron_in107.counter\[0\]
+ sky130_fd_sc_hd__edfxtp_1
Xnetwork.neuron_in107.counter\[1\]$_DFFE_PP_ clknet_leaf_29_clk
+ _02493_ _01400_ VSS VSS VDD VDD network.neuron_in107.counter\[1\]
+ sky130_fd_sc_hd__edfxtp_1
Xnetwork.neuron_in107.counter\[2\]$_DFFE_PP_ clknet_leaf_31_clk
+ _02494_ _01400_ VSS VSS VDD VDD network.neuron_in107.counter\[2\]
+ sky130_fd_sc_hd__edfxtp_1
Xnetwork.neuron_in107.counter\[3\]$_DFFE_PP_ clknet_leaf_29_clk
+ _02495_ _01400_ VSS VSS VDD VDD network.neuron_in107.counter\[3\]
+ sky130_fd_sc_hd__edfxtp_1
Xnetwork.neuron_in107.spike$_SDFFE_PP0P_ clknet_leaf_30_clk
+ _02054_ VSS VSS VDD VDD network.in_spk11_06 sky130_fd_sc_hd__dfxtp_1
Xnetwork.neuron_in108.counter\[0\]$_DFFE_PP_ clknet_leaf_264_clk
+ _02496_ _01399_ VSS VSS VDD VDD network.neuron_in108.counter\[0\]
+ sky130_fd_sc_hd__edfxtp_1
Xnetwork.neuron_in108.counter\[1\]$_DFFE_PP_ clknet_leaf_264_clk
+ _02497_ _01399_ VSS VSS VDD VDD network.neuron_in108.counter\[1\]
+ sky130_fd_sc_hd__edfxtp_1
Xnetwork.neuron_in108.counter\[2\]$_DFFE_PP_ clknet_leaf_264_clk
+ _02498_ _01399_ VSS VSS VDD VDD network.neuron_in108.counter\[2\]
+ sky130_fd_sc_hd__edfxtp_1
Xnetwork.neuron_in108.counter\[3\]$_DFFE_PP_ clknet_leaf_264_clk
+ _02499_ _01399_ VSS VSS VDD VDD network.neuron_in108.counter\[3\]
+ sky130_fd_sc_hd__edfxtp_1
Xnetwork.neuron_in108.spike$_SDFFE_PP0P_ clknet_leaf_30_clk
+ _02053_ VSS VSS VDD VDD network.in_spk12_06 sky130_fd_sc_hd__dfxtp_1
Xnetwork.neuron_in109.counter\[0\]$_DFFE_PP_ clknet_leaf_242_clk
+ _02500_ _01398_ VSS VSS VDD VDD network.neuron_in109.counter\[0\]
+ sky130_fd_sc_hd__edfxtp_1
Xnetwork.neuron_in109.counter\[1\]$_DFFE_PP_ clknet_leaf_244_clk
+ _02501_ _01398_ VSS VSS VDD VDD network.neuron_in109.counter\[1\]
+ sky130_fd_sc_hd__edfxtp_1
Xnetwork.neuron_in109.counter\[2\]$_DFFE_PP_ clknet_leaf_242_clk
+ _02502_ _01398_ VSS VSS VDD VDD network.neuron_in109.counter\[2\]
+ sky130_fd_sc_hd__edfxtp_1
Xnetwork.neuron_in109.counter\[3\]$_DFFE_PP_ clknet_leaf_242_clk
+ _02503_ _01398_ VSS VSS VDD VDD network.neuron_in109.counter\[3\]
+ sky130_fd_sc_hd__edfxtp_1
Xnetwork.neuron_in109.spike$_SDFFE_PP0P_ clknet_leaf_241_clk
+ _02052_ VSS VSS VDD VDD network.in_spk13_06 sky130_fd_sc_hd__dfxtp_1
Xnetwork.neuron_in110.counter\[0\]$_DFFE_PP_ clknet_leaf_243_clk
+ _02504_ _01397_ VSS VSS VDD VDD network.neuron_in110.counter\[0\]
+ sky130_fd_sc_hd__edfxtp_1
Xnetwork.neuron_in110.counter\[1\]$_DFFE_PP_ clknet_leaf_28_clk
+ _02505_ _01397_ VSS VSS VDD VDD network.neuron_in110.counter\[1\]
+ sky130_fd_sc_hd__edfxtp_1
Xnetwork.neuron_in110.counter\[2\]$_DFFE_PP_ clknet_leaf_243_clk
+ _02506_ _01397_ VSS VSS VDD VDD network.neuron_in110.counter\[2\]
+ sky130_fd_sc_hd__edfxtp_1
Xnetwork.neuron_in110.counter\[3\]$_DFFE_PP_ clknet_leaf_243_clk
+ _02507_ _01397_ VSS VSS VDD VDD network.neuron_in110.counter\[3\]
+ sky130_fd_sc_hd__edfxtp_1
Xnetwork.neuron_in110.spike$_SDFFE_PP0P_ clknet_leaf_30_clk
+ _02051_ VSS VSS VDD VDD network.in_spk14_06 sky130_fd_sc_hd__dfxtp_1
Xnetwork.neuron_in111.counter\[0\]$_DFFE_PP_ clknet_leaf_244_clk
+ _02508_ _01396_ VSS VSS VDD VDD network.neuron_in111.counter\[0\]
+ sky130_fd_sc_hd__edfxtp_1
Xnetwork.neuron_in111.counter\[1\]$_DFFE_PP_ clknet_leaf_244_clk
+ _02509_ _01396_ VSS VSS VDD VDD network.neuron_in111.counter\[1\]
+ sky130_fd_sc_hd__edfxtp_1
Xnetwork.neuron_in111.counter\[2\]$_DFFE_PP_ clknet_leaf_244_clk
+ _02510_ _01396_ VSS VSS VDD VDD network.neuron_in111.counter\[2\]
+ sky130_fd_sc_hd__edfxtp_1
Xnetwork.neuron_in111.counter\[3\]$_DFFE_PP_ clknet_leaf_244_clk
+ _02511_ _01396_ VSS VSS VDD VDD network.neuron_in111.counter\[3\]
+ sky130_fd_sc_hd__edfxtp_1
Xnetwork.neuron_in111.spike$_SDFFE_PP0P_ clknet_leaf_30_clk
+ _02050_ VSS VSS VDD VDD network.in_spk15_06 sky130_fd_sc_hd__dfxtp_1
Xnetwork.neuron_in112.counter\[0\]$_DFFE_PP_ clknet_leaf_221_clk
+ _02512_ _01395_ VSS VSS VDD VDD network.neuron_in112.counter\[0\]
+ sky130_fd_sc_hd__edfxtp_1
Xnetwork.neuron_in112.counter\[1\]$_DFFE_PP_ clknet_leaf_221_clk
+ _02513_ _01395_ VSS VSS VDD VDD network.neuron_in112.counter\[1\]
+ sky130_fd_sc_hd__edfxtp_1
Xnetwork.neuron_in112.counter\[2\]$_DFFE_PP_ clknet_leaf_221_clk
+ _02514_ _01395_ VSS VSS VDD VDD network.neuron_in112.counter\[2\]
+ sky130_fd_sc_hd__edfxtp_1
Xnetwork.neuron_in112.counter\[3\]$_DFFE_PP_ clknet_leaf_221_clk
+ _02515_ _01395_ VSS VSS VDD VDD network.neuron_in112.counter\[3\]
+ sky130_fd_sc_hd__edfxtp_1
Xnetwork.neuron_in112.spike$_SDFFE_PP0P_ clknet_leaf_216_clk
+ _02049_ VSS VSS VDD VDD network.in_spk00_07 sky130_fd_sc_hd__dfxtp_1
Xnetwork.neuron_in113.counter\[0\]$_DFFE_PP_ clknet_leaf_211_clk
+ _02516_ _01394_ VSS VSS VDD VDD network.neuron_in113.counter\[0\]
+ sky130_fd_sc_hd__edfxtp_1
Xnetwork.neuron_in113.counter\[1\]$_DFFE_PP_ clknet_leaf_211_clk
+ _02517_ _01394_ VSS VSS VDD VDD network.neuron_in113.counter\[1\]
+ sky130_fd_sc_hd__edfxtp_1
Xnetwork.neuron_in113.counter\[2\]$_DFFE_PP_ clknet_leaf_216_clk
+ _02518_ _01394_ VSS VSS VDD VDD network.neuron_in113.counter\[2\]
+ sky130_fd_sc_hd__edfxtp_1
Xnetwork.neuron_in113.counter\[3\]$_DFFE_PP_ clknet_leaf_211_clk
+ _02519_ _01394_ VSS VSS VDD VDD network.neuron_in113.counter\[3\]
+ sky130_fd_sc_hd__edfxtp_1
Xnetwork.neuron_in113.spike$_SDFFE_PP0P_ clknet_leaf_216_clk
+ _02048_ VSS VSS VDD VDD network.in_spk01_07 sky130_fd_sc_hd__dfxtp_1
Xnetwork.neuron_in114.counter\[0\]$_DFFE_PP_ clknet_leaf_217_clk
+ _02520_ _01393_ VSS VSS VDD VDD network.neuron_in114.counter\[0\]
+ sky130_fd_sc_hd__edfxtp_1
Xnetwork.neuron_in114.counter\[1\]$_DFFE_PP_ clknet_leaf_215_clk
+ _02521_ _01393_ VSS VSS VDD VDD network.neuron_in114.counter\[1\]
+ sky130_fd_sc_hd__edfxtp_1
Xnetwork.neuron_in114.counter\[2\]$_DFFE_PP_ clknet_leaf_216_clk
+ _02522_ _01393_ VSS VSS VDD VDD network.neuron_in114.counter\[2\]
+ sky130_fd_sc_hd__edfxtp_1
Xnetwork.neuron_in114.counter\[3\]$_DFFE_PP_ clknet_leaf_217_clk
+ _02523_ _01393_ VSS VSS VDD VDD network.neuron_in114.counter\[3\]
+ sky130_fd_sc_hd__edfxtp_1
Xnetwork.neuron_in114.spike$_SDFFE_PP0P_ clknet_leaf_215_clk
+ _02047_ VSS VSS VDD VDD network.in_spk02_07 sky130_fd_sc_hd__dfxtp_1
Xnetwork.neuron_in115.counter\[0\]$_DFFE_PP_ clknet_leaf_217_clk
+ _02524_ _01392_ VSS VSS VDD VDD network.neuron_in115.counter\[0\]
+ sky130_fd_sc_hd__edfxtp_1
Xnetwork.neuron_in115.counter\[1\]$_DFFE_PP_ clknet_leaf_215_clk
+ _02525_ _01392_ VSS VSS VDD VDD network.neuron_in115.counter\[1\]
+ sky130_fd_sc_hd__edfxtp_1
Xnetwork.neuron_in115.counter\[2\]$_DFFE_PP_ clknet_leaf_215_clk
+ _02526_ _01392_ VSS VSS VDD VDD network.neuron_in115.counter\[2\]
+ sky130_fd_sc_hd__edfxtp_1
Xnetwork.neuron_in115.counter\[3\]$_DFFE_PP_ clknet_leaf_215_clk
+ _02527_ _01392_ VSS VSS VDD VDD network.neuron_in115.counter\[3\]
+ sky130_fd_sc_hd__edfxtp_1
Xnetwork.neuron_in115.spike$_SDFFE_PP0P_ clknet_leaf_215_clk
+ _02046_ VSS VSS VDD VDD network.in_spk03_07 sky130_fd_sc_hd__dfxtp_1
Xnetwork.neuron_in116.counter\[0\]$_DFFE_PP_ clknet_leaf_210_clk
+ _02528_ _01391_ VSS VSS VDD VDD network.neuron_in116.counter\[0\]
+ sky130_fd_sc_hd__edfxtp_1
Xnetwork.neuron_in116.counter\[1\]$_DFFE_PP_ clknet_leaf_210_clk
+ _02529_ _01391_ VSS VSS VDD VDD network.neuron_in116.counter\[1\]
+ sky130_fd_sc_hd__edfxtp_1
Xnetwork.neuron_in116.counter\[2\]$_DFFE_PP_ clknet_leaf_211_clk
+ _02530_ _01391_ VSS VSS VDD VDD network.neuron_in116.counter\[2\]
+ sky130_fd_sc_hd__edfxtp_1
Xnetwork.neuron_in116.counter\[3\]$_DFFE_PP_ clknet_leaf_211_clk
+ _02531_ _01391_ VSS VSS VDD VDD network.neuron_in116.counter\[3\]
+ sky130_fd_sc_hd__edfxtp_1
Xnetwork.neuron_in116.spike$_SDFFE_PP0P_ clknet_leaf_212_clk
+ _02045_ VSS VSS VDD VDD network.in_spk04_07 sky130_fd_sc_hd__dfxtp_1
Xnetwork.neuron_in117.counter\[0\]$_DFFE_PP_ clknet_leaf_209_clk
+ _02532_ _01390_ VSS VSS VDD VDD network.neuron_in117.counter\[0\]
+ sky130_fd_sc_hd__edfxtp_1
Xnetwork.neuron_in117.counter\[1\]$_DFFE_PP_ clknet_leaf_209_clk
+ _02533_ _01390_ VSS VSS VDD VDD network.neuron_in117.counter\[1\]
+ sky130_fd_sc_hd__edfxtp_1
Xnetwork.neuron_in117.counter\[2\]$_DFFE_PP_ clknet_leaf_207_clk
+ _02534_ _01390_ VSS VSS VDD VDD network.neuron_in117.counter\[2\]
+ sky130_fd_sc_hd__edfxtp_1
Xnetwork.neuron_in117.counter\[3\]$_DFFE_PP_ clknet_leaf_208_clk
+ _02535_ _01390_ VSS VSS VDD VDD network.neuron_in117.counter\[3\]
+ sky130_fd_sc_hd__edfxtp_1
Xnetwork.neuron_in117.spike$_SDFFE_PP0P_ clknet_leaf_211_clk
+ _02044_ VSS VSS VDD VDD network.in_spk05_07 sky130_fd_sc_hd__dfxtp_1
Xnetwork.neuron_in118.counter\[0\]$_DFFE_PP_ clknet_leaf_209_clk
+ _02536_ _01389_ VSS VSS VDD VDD network.neuron_in118.counter\[0\]
+ sky130_fd_sc_hd__edfxtp_1
Xnetwork.neuron_in118.counter\[1\]$_DFFE_PP_ clknet_leaf_209_clk
+ _02537_ _01389_ VSS VSS VDD VDD network.neuron_in118.counter\[1\]
+ sky130_fd_sc_hd__edfxtp_1
Xnetwork.neuron_in118.counter\[2\]$_DFFE_PP_ clknet_leaf_209_clk
+ _02538_ _01389_ VSS VSS VDD VDD network.neuron_in118.counter\[2\]
+ sky130_fd_sc_hd__edfxtp_1
Xnetwork.neuron_in118.counter\[3\]$_DFFE_PP_ clknet_leaf_209_clk
+ _02539_ _01389_ VSS VSS VDD VDD network.neuron_in118.counter\[3\]
+ sky130_fd_sc_hd__edfxtp_1
Xnetwork.neuron_in118.spike$_SDFFE_PP0P_ clknet_leaf_212_clk
+ _02043_ VSS VSS VDD VDD network.in_spk06_07 sky130_fd_sc_hd__dfxtp_1
Xnetwork.neuron_in119.counter\[0\]$_DFFE_PP_ clknet_leaf_210_clk
+ _02540_ _01388_ VSS VSS VDD VDD network.neuron_in119.counter\[0\]
+ sky130_fd_sc_hd__edfxtp_1
Xnetwork.neuron_in119.counter\[1\]$_DFFE_PP_ clknet_leaf_210_clk
+ _02541_ _01388_ VSS VSS VDD VDD network.neuron_in119.counter\[1\]
+ sky130_fd_sc_hd__edfxtp_1
Xnetwork.neuron_in119.counter\[2\]$_DFFE_PP_ clknet_leaf_209_clk
+ _02542_ _01388_ VSS VSS VDD VDD network.neuron_in119.counter\[2\]
+ sky130_fd_sc_hd__edfxtp_1
Xnetwork.neuron_in119.counter\[3\]$_DFFE_PP_ clknet_leaf_209_clk
+ _02543_ _01388_ VSS VSS VDD VDD network.neuron_in119.counter\[3\]
+ sky130_fd_sc_hd__edfxtp_1
Xnetwork.neuron_in119.spike$_SDFFE_PP0P_ clknet_leaf_212_clk
+ _02042_ VSS VSS VDD VDD network.in_spk07_07 sky130_fd_sc_hd__dfxtp_1
Xnetwork.neuron_in120.counter\[0\]$_DFFE_PP_ clknet_leaf_253_clk
+ _02544_ _01387_ VSS VSS VDD VDD network.neuron_in120.counter\[0\]
+ sky130_fd_sc_hd__edfxtp_1
Xnetwork.neuron_in120.counter\[1\]$_DFFE_PP_ clknet_leaf_253_clk
+ _02545_ _01387_ VSS VSS VDD VDD network.neuron_in120.counter\[1\]
+ sky130_fd_sc_hd__edfxtp_1
Xnetwork.neuron_in120.counter\[2\]$_DFFE_PP_ clknet_leaf_254_clk
+ _02546_ _01387_ VSS VSS VDD VDD network.neuron_in120.counter\[2\]
+ sky130_fd_sc_hd__edfxtp_1
Xnetwork.neuron_in120.counter\[3\]$_DFFE_PP_ clknet_leaf_214_clk
+ _02547_ _01387_ VSS VSS VDD VDD network.neuron_in120.counter\[3\]
+ sky130_fd_sc_hd__edfxtp_1
Xnetwork.neuron_in120.spike$_SDFFE_PP0P_ clknet_leaf_214_clk
+ _02041_ VSS VSS VDD VDD network.in_spk08_07 sky130_fd_sc_hd__dfxtp_1
Xnetwork.neuron_in121.counter\[0\]$_DFFE_PP_ clknet_leaf_250_clk
+ _02548_ _01386_ VSS VSS VDD VDD network.neuron_in121.counter\[0\]
+ sky130_fd_sc_hd__edfxtp_1
Xnetwork.neuron_in121.counter\[1\]$_DFFE_PP_ clknet_leaf_250_clk
+ _02549_ _01386_ VSS VSS VDD VDD network.neuron_in121.counter\[1\]
+ sky130_fd_sc_hd__edfxtp_1
Xnetwork.neuron_in121.counter\[2\]$_DFFE_PP_ clknet_leaf_253_clk
+ _02550_ _01386_ VSS VSS VDD VDD network.neuron_in121.counter\[2\]
+ sky130_fd_sc_hd__edfxtp_1
Xnetwork.neuron_in121.counter\[3\]$_DFFE_PP_ clknet_leaf_253_clk
+ _02551_ _01386_ VSS VSS VDD VDD network.neuron_in121.counter\[3\]
+ sky130_fd_sc_hd__edfxtp_1
Xnetwork.neuron_in121.spike$_SDFFE_PP0P_ clknet_leaf_215_clk
+ _02040_ VSS VSS VDD VDD network.in_spk09_07 sky130_fd_sc_hd__dfxtp_1
Xnetwork.neuron_in122.counter\[0\]$_DFFE_PP_ clknet_leaf_252_clk
+ _02552_ _01385_ VSS VSS VDD VDD network.neuron_in122.counter\[0\]
+ sky130_fd_sc_hd__edfxtp_1
Xnetwork.neuron_in122.counter\[1\]$_DFFE_PP_ clknet_leaf_252_clk
+ _02553_ _01385_ VSS VSS VDD VDD network.neuron_in122.counter\[1\]
+ sky130_fd_sc_hd__edfxtp_1
Xnetwork.neuron_in122.counter\[2\]$_DFFE_PP_ clknet_leaf_253_clk
+ _02554_ _01385_ VSS VSS VDD VDD network.neuron_in122.counter\[2\]
+ sky130_fd_sc_hd__edfxtp_1
Xnetwork.neuron_in122.counter\[3\]$_DFFE_PP_ clknet_leaf_252_clk
+ _02555_ _01385_ VSS VSS VDD VDD network.neuron_in122.counter\[3\]
+ sky130_fd_sc_hd__edfxtp_1
Xnetwork.neuron_in122.spike$_SDFFE_PP0P_ clknet_leaf_214_clk
+ _02039_ VSS VSS VDD VDD network.in_spk10_07 sky130_fd_sc_hd__dfxtp_1
Xnetwork.neuron_in123.counter\[0\]$_DFFE_PP_ clknet_leaf_256_clk
+ _02556_ _01384_ VSS VSS VDD VDD network.neuron_in123.counter\[0\]
+ sky130_fd_sc_hd__edfxtp_1
Xnetwork.neuron_in123.counter\[1\]$_DFFE_PP_ clknet_leaf_255_clk
+ _02557_ _01384_ VSS VSS VDD VDD network.neuron_in123.counter\[1\]
+ sky130_fd_sc_hd__edfxtp_1
Xnetwork.neuron_in123.counter\[2\]$_DFFE_PP_ clknet_leaf_253_clk
+ _02558_ _01384_ VSS VSS VDD VDD network.neuron_in123.counter\[2\]
+ sky130_fd_sc_hd__edfxtp_1
Xnetwork.neuron_in123.counter\[3\]$_DFFE_PP_ clknet_leaf_255_clk
+ _02559_ _01384_ VSS VSS VDD VDD network.neuron_in123.counter\[3\]
+ sky130_fd_sc_hd__edfxtp_1
Xnetwork.neuron_in123.spike$_SDFFE_PP0P_ clknet_leaf_214_clk
+ _02038_ VSS VSS VDD VDD network.in_spk11_07 sky130_fd_sc_hd__dfxtp_1
Xnetwork.neuron_in124.counter\[0\]$_DFFE_PP_ clknet_leaf_254_clk
+ _02560_ _01383_ VSS VSS VDD VDD network.neuron_in124.counter\[0\]
+ sky130_fd_sc_hd__edfxtp_1
Xnetwork.neuron_in124.counter\[1\]$_DFFE_PP_ clknet_leaf_254_clk
+ _02561_ _01383_ VSS VSS VDD VDD network.neuron_in124.counter\[1\]
+ sky130_fd_sc_hd__edfxtp_1
Xnetwork.neuron_in124.counter\[2\]$_DFFE_PP_ clknet_leaf_254_clk
+ _02562_ _01383_ VSS VSS VDD VDD network.neuron_in124.counter\[2\]
+ sky130_fd_sc_hd__edfxtp_1
Xnetwork.neuron_in124.counter\[3\]$_DFFE_PP_ clknet_leaf_254_clk
+ _02563_ _01383_ VSS VSS VDD VDD network.neuron_in124.counter\[3\]
+ sky130_fd_sc_hd__edfxtp_1
Xnetwork.neuron_in124.spike$_SDFFE_PP0P_ clknet_leaf_214_clk
+ _02037_ VSS VSS VDD VDD network.in_spk12_07 sky130_fd_sc_hd__dfxtp_1
Xnetwork.neuron_in125.counter\[0\]$_DFFE_PP_ clknet_leaf_255_clk
+ _02564_ _01382_ VSS VSS VDD VDD network.neuron_in125.counter\[0\]
+ sky130_fd_sc_hd__edfxtp_1
Xnetwork.neuron_in125.counter\[1\]$_DFFE_PP_ clknet_leaf_255_clk
+ _02565_ _01382_ VSS VSS VDD VDD network.neuron_in125.counter\[1\]
+ sky130_fd_sc_hd__edfxtp_1
Xnetwork.neuron_in125.counter\[2\]$_DFFE_PP_ clknet_leaf_254_clk
+ _02566_ _01382_ VSS VSS VDD VDD network.neuron_in125.counter\[2\]
+ sky130_fd_sc_hd__edfxtp_1
Xnetwork.neuron_in125.counter\[3\]$_DFFE_PP_ clknet_leaf_254_clk
+ _02567_ _01382_ VSS VSS VDD VDD network.neuron_in125.counter\[3\]
+ sky130_fd_sc_hd__edfxtp_1
Xnetwork.neuron_in125.spike$_SDFFE_PP0P_ clknet_leaf_214_clk
+ _02036_ VSS VSS VDD VDD network.in_spk13_07 sky130_fd_sc_hd__dfxtp_1
Xnetwork.neuron_in126.counter\[0\]$_DFFE_PP_ clknet_leaf_213_clk
+ _02568_ _01381_ VSS VSS VDD VDD network.neuron_in126.counter\[0\]
+ sky130_fd_sc_hd__edfxtp_1
Xnetwork.neuron_in126.counter\[1\]$_DFFE_PP_ clknet_leaf_213_clk
+ _02569_ _01381_ VSS VSS VDD VDD network.neuron_in126.counter\[1\]
+ sky130_fd_sc_hd__edfxtp_1
Xnetwork.neuron_in126.counter\[2\]$_DFFE_PP_ clknet_leaf_212_clk
+ _02570_ _01381_ VSS VSS VDD VDD network.neuron_in126.counter\[2\]
+ sky130_fd_sc_hd__edfxtp_1
Xnetwork.neuron_in126.counter\[3\]$_DFFE_PP_ clknet_leaf_212_clk
+ _02571_ _01381_ VSS VSS VDD VDD network.neuron_in126.counter\[3\]
+ sky130_fd_sc_hd__edfxtp_1
Xnetwork.neuron_in126.spike$_SDFFE_PP0P_ clknet_leaf_212_clk
+ _02035_ VSS VSS VDD VDD network.in_spk14_07 sky130_fd_sc_hd__dfxtp_1
Xnetwork.neuron_in127.counter\[0\]$_DFFE_PP_ clknet_leaf_213_clk
+ _02572_ _01380_ VSS VSS VDD VDD network.neuron_in127.counter\[0\]
+ sky130_fd_sc_hd__edfxtp_1
Xnetwork.neuron_in127.counter\[1\]$_DFFE_PP_ clknet_leaf_214_clk
+ _02573_ _01380_ VSS VSS VDD VDD network.neuron_in127.counter\[1\]
+ sky130_fd_sc_hd__edfxtp_1
Xnetwork.neuron_in127.counter\[2\]$_DFFE_PP_ clknet_leaf_213_clk
+ _02574_ _01380_ VSS VSS VDD VDD network.neuron_in127.counter\[2\]
+ sky130_fd_sc_hd__edfxtp_1
Xnetwork.neuron_in127.counter\[3\]$_DFFE_PP_ clknet_leaf_213_clk
+ _02575_ _01380_ VSS VSS VDD VDD network.neuron_in127.counter\[3\]
+ sky130_fd_sc_hd__edfxtp_1
Xnetwork.neuron_in127.spike$_SDFFE_PP0P_ clknet_leaf_213_clk
+ _02034_ VSS VSS VDD VDD network.in_spk15_07 sky130_fd_sc_hd__dfxtp_1
Xnetwork.neuron_in128.counter\[0\]$_DFFE_PP_ clknet_leaf_225_clk
+ _02576_ _01379_ VSS VSS VDD VDD network.neuron_in128.counter\[0\]
+ sky130_fd_sc_hd__edfxtp_1
Xnetwork.neuron_in128.counter\[1\]$_DFFE_PP_ clknet_leaf_225_clk
+ _02577_ _01379_ VSS VSS VDD VDD network.neuron_in128.counter\[1\]
+ sky130_fd_sc_hd__edfxtp_1
Xnetwork.neuron_in128.counter\[2\]$_DFFE_PP_ clknet_leaf_224_clk
+ _02578_ _01379_ VSS VSS VDD VDD network.neuron_in128.counter\[2\]
+ sky130_fd_sc_hd__edfxtp_1
Xnetwork.neuron_in128.counter\[3\]$_DFFE_PP_ clknet_leaf_224_clk
+ _02579_ _01379_ VSS VSS VDD VDD network.neuron_in128.counter\[3\]
+ sky130_fd_sc_hd__edfxtp_1
Xnetwork.neuron_in128.spike$_SDFFE_PP0P_ clknet_leaf_225_clk
+ _02033_ VSS VSS VDD VDD network.in_spk00_08 sky130_fd_sc_hd__dfxtp_1
Xnetwork.neuron_in129.counter\[0\]$_DFFE_PP_ clknet_leaf_224_clk
+ _02580_ _01378_ VSS VSS VDD VDD network.neuron_in129.counter\[0\]
+ sky130_fd_sc_hd__edfxtp_1
Xnetwork.neuron_in129.counter\[1\]$_DFFE_PP_ clknet_leaf_224_clk
+ _02581_ _01378_ VSS VSS VDD VDD network.neuron_in129.counter\[1\]
+ sky130_fd_sc_hd__edfxtp_1
Xnetwork.neuron_in129.counter\[2\]$_DFFE_PP_ clknet_leaf_165_clk
+ _02582_ _01378_ VSS VSS VDD VDD network.neuron_in129.counter\[2\]
+ sky130_fd_sc_hd__edfxtp_1
Xnetwork.neuron_in129.counter\[3\]$_DFFE_PP_ clknet_leaf_165_clk
+ _02583_ _01378_ VSS VSS VDD VDD network.neuron_in129.counter\[3\]
+ sky130_fd_sc_hd__edfxtp_1
Xnetwork.neuron_in129.spike$_SDFFE_PP0P_ clknet_leaf_224_clk
+ _02032_ VSS VSS VDD VDD network.in_spk01_08 sky130_fd_sc_hd__dfxtp_1
Xnetwork.neuron_in130.counter\[0\]$_DFFE_PP_ clknet_leaf_226_clk
+ _02584_ _01377_ VSS VSS VDD VDD network.neuron_in130.counter\[0\]
+ sky130_fd_sc_hd__edfxtp_1
Xnetwork.neuron_in130.counter\[1\]$_DFFE_PP_ clknet_leaf_227_clk
+ _02585_ _01377_ VSS VSS VDD VDD network.neuron_in130.counter\[1\]
+ sky130_fd_sc_hd__edfxtp_1
Xnetwork.neuron_in130.counter\[2\]$_DFFE_PP_ clknet_leaf_227_clk
+ _02586_ _01377_ VSS VSS VDD VDD network.neuron_in130.counter\[2\]
+ sky130_fd_sc_hd__edfxtp_1
Xnetwork.neuron_in130.counter\[3\]$_DFFE_PP_ clknet_leaf_226_clk
+ _02587_ _01377_ VSS VSS VDD VDD network.neuron_in130.counter\[3\]
+ sky130_fd_sc_hd__edfxtp_1
Xnetwork.neuron_in130.spike$_SDFFE_PP0P_ clknet_leaf_225_clk
+ _02031_ VSS VSS VDD VDD network.in_spk02_08 sky130_fd_sc_hd__dfxtp_1
Xnetwork.neuron_in131.counter\[0\]$_DFFE_PP_ clknet_leaf_204_clk
+ _02588_ _01376_ VSS VSS VDD VDD network.neuron_in131.counter\[0\]
+ sky130_fd_sc_hd__edfxtp_1
Xnetwork.neuron_in131.counter\[1\]$_DFFE_PP_ clknet_leaf_204_clk
+ _02589_ _01376_ VSS VSS VDD VDD network.neuron_in131.counter\[1\]
+ sky130_fd_sc_hd__edfxtp_1
Xnetwork.neuron_in131.counter\[2\]$_DFFE_PP_ clknet_leaf_223_clk
+ _02590_ _01376_ VSS VSS VDD VDD network.neuron_in131.counter\[2\]
+ sky130_fd_sc_hd__edfxtp_1
Xnetwork.neuron_in131.counter\[3\]$_DFFE_PP_ clknet_leaf_223_clk
+ _02591_ _01376_ VSS VSS VDD VDD network.neuron_in131.counter\[3\]
+ sky130_fd_sc_hd__edfxtp_1
Xnetwork.neuron_in131.spike$_SDFFE_PP0P_ clknet_leaf_224_clk
+ _02030_ VSS VSS VDD VDD network.in_spk03_08 sky130_fd_sc_hd__dfxtp_1
Xnetwork.neuron_in132.counter\[0\]$_DFFE_PP_ clknet_leaf_207_clk
+ _02592_ _01375_ VSS VSS VDD VDD network.neuron_in132.counter\[0\]
+ sky130_fd_sc_hd__edfxtp_1
Xnetwork.neuron_in132.counter\[1\]$_DFFE_PP_ clknet_leaf_207_clk
+ _02593_ _01375_ VSS VSS VDD VDD network.neuron_in132.counter\[1\]
+ sky130_fd_sc_hd__edfxtp_1
Xnetwork.neuron_in132.counter\[2\]$_DFFE_PP_ clknet_leaf_207_clk
+ _02594_ _01375_ VSS VSS VDD VDD network.neuron_in132.counter\[2\]
+ sky130_fd_sc_hd__edfxtp_1
Xnetwork.neuron_in132.counter\[3\]$_DFFE_PP_ clknet_leaf_207_clk
+ _02595_ _01375_ VSS VSS VDD VDD network.neuron_in132.counter\[3\]
+ sky130_fd_sc_hd__edfxtp_1
Xnetwork.neuron_in132.spike$_SDFFE_PP0P_ clknet_leaf_223_clk
+ _02029_ VSS VSS VDD VDD network.in_spk04_08 sky130_fd_sc_hd__dfxtp_1
Xnetwork.neuron_in133.counter\[0\]$_DFFE_PP_ clknet_leaf_205_clk
+ _02596_ _01374_ VSS VSS VDD VDD network.neuron_in133.counter\[0\]
+ sky130_fd_sc_hd__edfxtp_1
Xnetwork.neuron_in133.counter\[1\]$_DFFE_PP_ clknet_leaf_205_clk
+ _02597_ _01374_ VSS VSS VDD VDD network.neuron_in133.counter\[1\]
+ sky130_fd_sc_hd__edfxtp_1
Xnetwork.neuron_in133.counter\[2\]$_DFFE_PP_ clknet_leaf_202_clk
+ _02598_ _01374_ VSS VSS VDD VDD network.neuron_in133.counter\[2\]
+ sky130_fd_sc_hd__edfxtp_1
Xnetwork.neuron_in133.counter\[3\]$_DFFE_PP_ clknet_leaf_204_clk
+ _02599_ _01374_ VSS VSS VDD VDD network.neuron_in133.counter\[3\]
+ sky130_fd_sc_hd__edfxtp_1
Xnetwork.neuron_in133.spike$_SDFFE_PP0P_ clknet_leaf_223_clk
+ _02028_ VSS VSS VDD VDD network.in_spk05_08 sky130_fd_sc_hd__dfxtp_1
Xnetwork.neuron_in134.counter\[0\]$_DFFE_PP_ clknet_leaf_204_clk
+ _02600_ _01373_ VSS VSS VDD VDD network.neuron_in134.counter\[0\]
+ sky130_fd_sc_hd__edfxtp_1
Xnetwork.neuron_in134.counter\[1\]$_DFFE_PP_ clknet_leaf_204_clk
+ _02601_ _01373_ VSS VSS VDD VDD network.neuron_in134.counter\[1\]
+ sky130_fd_sc_hd__edfxtp_1
Xnetwork.neuron_in134.counter\[2\]$_DFFE_PP_ clknet_leaf_204_clk
+ _02602_ _01373_ VSS VSS VDD VDD network.neuron_in134.counter\[2\]
+ sky130_fd_sc_hd__edfxtp_1
Xnetwork.neuron_in134.counter\[3\]$_DFFE_PP_ clknet_leaf_202_clk
+ _02603_ _01373_ VSS VSS VDD VDD network.neuron_in134.counter\[3\]
+ sky130_fd_sc_hd__edfxtp_1
Xnetwork.neuron_in134.spike$_SDFFE_PP0P_ clknet_leaf_223_clk
+ _02027_ VSS VSS VDD VDD network.in_spk06_08 sky130_fd_sc_hd__dfxtp_1
Xnetwork.neuron_in135.counter\[0\]$_DFFE_PP_ clknet_leaf_220_clk
+ _02604_ _01372_ VSS VSS VDD VDD network.neuron_in135.counter\[0\]
+ sky130_fd_sc_hd__edfxtp_1
Xnetwork.neuron_in135.counter\[1\]$_DFFE_PP_ clknet_leaf_220_clk
+ _02605_ _01372_ VSS VSS VDD VDD network.neuron_in135.counter\[1\]
+ sky130_fd_sc_hd__edfxtp_1
Xnetwork.neuron_in135.counter\[2\]$_DFFE_PP_ clknet_leaf_220_clk
+ _02606_ _01372_ VSS VSS VDD VDD network.neuron_in135.counter\[2\]
+ sky130_fd_sc_hd__edfxtp_1
Xnetwork.neuron_in135.counter\[3\]$_DFFE_PP_ clknet_leaf_221_clk
+ _02607_ _01372_ VSS VSS VDD VDD network.neuron_in135.counter\[3\]
+ sky130_fd_sc_hd__edfxtp_1
Xnetwork.neuron_in135.spike$_SDFFE_PP0P_ clknet_leaf_220_clk
+ _02026_ VSS VSS VDD VDD network.in_spk07_08 sky130_fd_sc_hd__dfxtp_1
Xnetwork.neuron_in136.counter\[0\]$_DFFE_PP_ clknet_leaf_206_clk
+ _02608_ _01371_ VSS VSS VDD VDD network.neuron_in136.counter\[0\]
+ sky130_fd_sc_hd__edfxtp_1
Xnetwork.neuron_in136.counter\[1\]$_DFFE_PP_ clknet_leaf_206_clk
+ _02609_ _01371_ VSS VSS VDD VDD network.neuron_in136.counter\[1\]
+ sky130_fd_sc_hd__edfxtp_1
Xnetwork.neuron_in136.counter\[2\]$_DFFE_PP_ clknet_leaf_206_clk
+ _02610_ _01371_ VSS VSS VDD VDD network.neuron_in136.counter\[2\]
+ sky130_fd_sc_hd__edfxtp_1
Xnetwork.neuron_in136.counter\[3\]$_DFFE_PP_ clknet_leaf_205_clk
+ _02611_ _01371_ VSS VSS VDD VDD network.neuron_in136.counter\[3\]
+ sky130_fd_sc_hd__edfxtp_1
Xnetwork.neuron_in136.spike$_SDFFE_PP0P_ clknet_leaf_222_clk
+ _02025_ VSS VSS VDD VDD network.in_spk08_08 sky130_fd_sc_hd__dfxtp_1
Xnetwork.neuron_in137.counter\[0\]$_DFFE_PP_ clknet_leaf_205_clk
+ _02612_ _01370_ VSS VSS VDD VDD network.neuron_in137.counter\[0\]
+ sky130_fd_sc_hd__edfxtp_1
Xnetwork.neuron_in137.counter\[1\]$_DFFE_PP_ clknet_leaf_205_clk
+ _02613_ _01370_ VSS VSS VDD VDD network.neuron_in137.counter\[1\]
+ sky130_fd_sc_hd__edfxtp_1
Xnetwork.neuron_in137.counter\[2\]$_DFFE_PP_ clknet_leaf_205_clk
+ _02614_ _01370_ VSS VSS VDD VDD network.neuron_in137.counter\[2\]
+ sky130_fd_sc_hd__edfxtp_1
Xnetwork.neuron_in137.counter\[3\]$_DFFE_PP_ clknet_leaf_205_clk
+ _02615_ _01370_ VSS VSS VDD VDD network.neuron_in137.counter\[3\]
+ sky130_fd_sc_hd__edfxtp_1
Xnetwork.neuron_in137.spike$_SDFFE_PP0P_ clknet_leaf_223_clk
+ _02024_ VSS VSS VDD VDD network.in_spk09_08 sky130_fd_sc_hd__dfxtp_1
Xnetwork.neuron_in138.counter\[0\]$_DFFE_PP_ clknet_leaf_228_clk
+ _02616_ _01369_ VSS VSS VDD VDD network.neuron_in138.counter\[0\]
+ sky130_fd_sc_hd__edfxtp_1
Xnetwork.neuron_in138.counter\[1\]$_DFFE_PP_ clknet_leaf_228_clk
+ _02617_ _01369_ VSS VSS VDD VDD network.neuron_in138.counter\[1\]
+ sky130_fd_sc_hd__edfxtp_1
Xnetwork.neuron_in138.counter\[2\]$_DFFE_PP_ clknet_leaf_219_clk
+ _02618_ _01369_ VSS VSS VDD VDD network.neuron_in138.counter\[2\]
+ sky130_fd_sc_hd__edfxtp_1
Xnetwork.neuron_in138.counter\[3\]$_DFFE_PP_ clknet_leaf_228_clk
+ _02619_ _01369_ VSS VSS VDD VDD network.neuron_in138.counter\[3\]
+ sky130_fd_sc_hd__edfxtp_1
Xnetwork.neuron_in138.spike$_SDFFE_PP0P_ clknet_leaf_220_clk
+ _02023_ VSS VSS VDD VDD network.in_spk10_08 sky130_fd_sc_hd__dfxtp_1
Xnetwork.neuron_in139.counter\[0\]$_DFFE_PP_ clknet_leaf_222_clk
+ _02620_ _01368_ VSS VSS VDD VDD network.neuron_in139.counter\[0\]
+ sky130_fd_sc_hd__edfxtp_1
Xnetwork.neuron_in139.counter\[1\]$_DFFE_PP_ clknet_leaf_222_clk
+ _02621_ _01368_ VSS VSS VDD VDD network.neuron_in139.counter\[1\]
+ sky130_fd_sc_hd__edfxtp_1
Xnetwork.neuron_in139.counter\[2\]$_DFFE_PP_ clknet_leaf_222_clk
+ _02622_ _01368_ VSS VSS VDD VDD network.neuron_in139.counter\[2\]
+ sky130_fd_sc_hd__edfxtp_1
Xnetwork.neuron_in139.counter\[3\]$_DFFE_PP_ clknet_leaf_222_clk
+ _02623_ _01368_ VSS VSS VDD VDD network.neuron_in139.counter\[3\]
+ sky130_fd_sc_hd__edfxtp_1
Xnetwork.neuron_in139.spike$_SDFFE_PP0P_ clknet_leaf_222_clk
+ _02022_ VSS VSS VDD VDD network.in_spk11_08 sky130_fd_sc_hd__dfxtp_1
Xnetwork.neuron_in140.counter\[0\]$_DFFE_PP_ clknet_leaf_218_clk
+ _02624_ _01367_ VSS VSS VDD VDD network.neuron_in140.counter\[0\]
+ sky130_fd_sc_hd__edfxtp_1
Xnetwork.neuron_in140.counter\[1\]$_DFFE_PP_ clknet_leaf_218_clk
+ _02625_ _01367_ VSS VSS VDD VDD network.neuron_in140.counter\[1\]
+ sky130_fd_sc_hd__edfxtp_1
Xnetwork.neuron_in140.counter\[2\]$_DFFE_PP_ clknet_leaf_217_clk
+ _02626_ _01367_ VSS VSS VDD VDD network.neuron_in140.counter\[2\]
+ sky130_fd_sc_hd__edfxtp_1
Xnetwork.neuron_in140.counter\[3\]$_DFFE_PP_ clknet_leaf_217_clk
+ _02627_ _01367_ VSS VSS VDD VDD network.neuron_in140.counter\[3\]
+ sky130_fd_sc_hd__edfxtp_1
Xnetwork.neuron_in140.spike$_SDFFE_PP0P_ clknet_leaf_220_clk
+ _02021_ VSS VSS VDD VDD network.in_spk12_08 sky130_fd_sc_hd__dfxtp_1
Xnetwork.neuron_in141.counter\[0\]$_DFFE_PP_ clknet_leaf_218_clk
+ _02628_ _01366_ VSS VSS VDD VDD network.neuron_in141.counter\[0\]
+ sky130_fd_sc_hd__edfxtp_1
Xnetwork.neuron_in141.counter\[1\]$_DFFE_PP_ clknet_leaf_218_clk
+ _02629_ _01366_ VSS VSS VDD VDD network.neuron_in141.counter\[1\]
+ sky130_fd_sc_hd__edfxtp_1
Xnetwork.neuron_in141.counter\[2\]$_DFFE_PP_ clknet_leaf_219_clk
+ _02630_ _01366_ VSS VSS VDD VDD network.neuron_in141.counter\[2\]
+ sky130_fd_sc_hd__edfxtp_1
Xnetwork.neuron_in141.counter\[3\]$_DFFE_PP_ clknet_leaf_219_clk
+ _02631_ _01366_ VSS VSS VDD VDD network.neuron_in141.counter\[3\]
+ sky130_fd_sc_hd__edfxtp_1
Xnetwork.neuron_in141.spike$_SDFFE_PP0P_ clknet_leaf_220_clk
+ _02020_ VSS VSS VDD VDD network.in_spk13_08 sky130_fd_sc_hd__dfxtp_1
Xnetwork.neuron_in142.counter\[0\]$_DFFE_PP_ clknet_leaf_219_clk
+ _02632_ _01365_ VSS VSS VDD VDD network.neuron_in142.counter\[0\]
+ sky130_fd_sc_hd__edfxtp_1
Xnetwork.neuron_in142.counter\[1\]$_DFFE_PP_ clknet_leaf_219_clk
+ _02633_ _01365_ VSS VSS VDD VDD network.neuron_in142.counter\[1\]
+ sky130_fd_sc_hd__edfxtp_1
Xnetwork.neuron_in142.counter\[2\]$_DFFE_PP_ clknet_leaf_219_clk
+ _02634_ _01365_ VSS VSS VDD VDD network.neuron_in142.counter\[2\]
+ sky130_fd_sc_hd__edfxtp_1
Xnetwork.neuron_in142.counter\[3\]$_DFFE_PP_ clknet_leaf_219_clk
+ _02635_ _01365_ VSS VSS VDD VDD network.neuron_in142.counter\[3\]
+ sky130_fd_sc_hd__edfxtp_1
Xnetwork.neuron_in142.spike$_SDFFE_PP0P_ clknet_leaf_220_clk
+ _02019_ VSS VSS VDD VDD network.in_spk14_08 sky130_fd_sc_hd__dfxtp_1
Xnetwork.neuron_in143.counter\[0\]$_DFFE_PP_ clknet_leaf_228_clk
+ _02636_ _01364_ VSS VSS VDD VDD network.neuron_in143.counter\[0\]
+ sky130_fd_sc_hd__edfxtp_1
Xnetwork.neuron_in143.counter\[1\]$_DFFE_PP_ clknet_leaf_228_clk
+ _02637_ _01364_ VSS VSS VDD VDD network.neuron_in143.counter\[1\]
+ sky130_fd_sc_hd__edfxtp_1
Xnetwork.neuron_in143.counter\[2\]$_DFFE_PP_ clknet_leaf_228_clk
+ _02638_ _01364_ VSS VSS VDD VDD network.neuron_in143.counter\[2\]
+ sky130_fd_sc_hd__edfxtp_1
Xnetwork.neuron_in143.counter\[3\]$_DFFE_PP_ clknet_leaf_227_clk
+ _02639_ _01364_ VSS VSS VDD VDD network.neuron_in143.counter\[3\]
+ sky130_fd_sc_hd__edfxtp_1
Xnetwork.neuron_in143.spike$_SDFFE_PP0P_ clknet_leaf_227_clk
+ _02018_ VSS VSS VDD VDD network.in_spk15_08 sky130_fd_sc_hd__dfxtp_1
Xnetwork.neuron_in144.counter\[0\]$_DFFE_PP_ clknet_leaf_232_clk
+ _02640_ _01363_ VSS VSS VDD VDD network.neuron_in144.counter\[0\]
+ sky130_fd_sc_hd__edfxtp_1
Xnetwork.neuron_in144.counter\[1\]$_DFFE_PP_ clknet_leaf_231_clk
+ _02641_ _01363_ VSS VSS VDD VDD network.neuron_in144.counter\[1\]
+ sky130_fd_sc_hd__edfxtp_1
Xnetwork.neuron_in144.counter\[2\]$_DFFE_PP_ clknet_leaf_157_clk
+ _02642_ _01363_ VSS VSS VDD VDD network.neuron_in144.counter\[2\]
+ sky130_fd_sc_hd__edfxtp_1
Xnetwork.neuron_in144.counter\[3\]$_DFFE_PP_ clknet_leaf_157_clk
+ _02643_ _01363_ VSS VSS VDD VDD network.neuron_in144.counter\[3\]
+ sky130_fd_sc_hd__edfxtp_1
Xnetwork.neuron_in144.spike$_SDFFE_PP0P_ clknet_leaf_157_clk
+ _02017_ VSS VSS VDD VDD network.in_spk00_09 sky130_fd_sc_hd__dfxtp_1
Xnetwork.neuron_in145.counter\[0\]$_DFFE_PP_ clknet_leaf_155_clk
+ _02644_ _01362_ VSS VSS VDD VDD network.neuron_in145.counter\[0\]
+ sky130_fd_sc_hd__edfxtp_1
Xnetwork.neuron_in145.counter\[1\]$_DFFE_PP_ clknet_leaf_155_clk
+ _02645_ _01362_ VSS VSS VDD VDD network.neuron_in145.counter\[1\]
+ sky130_fd_sc_hd__edfxtp_1
Xnetwork.neuron_in145.counter\[2\]$_DFFE_PP_ clknet_leaf_155_clk
+ _02646_ _01362_ VSS VSS VDD VDD network.neuron_in145.counter\[2\]
+ sky130_fd_sc_hd__edfxtp_1
Xnetwork.neuron_in145.counter\[3\]$_DFFE_PP_ clknet_leaf_155_clk
+ _02647_ _01362_ VSS VSS VDD VDD network.neuron_in145.counter\[3\]
+ sky130_fd_sc_hd__edfxtp_1
Xnetwork.neuron_in145.spike$_SDFFE_PP0P_ clknet_leaf_156_clk
+ _02016_ VSS VSS VDD VDD network.in_spk01_09 sky130_fd_sc_hd__dfxtp_1
Xnetwork.neuron_in146.counter\[0\]$_DFFE_PP_ clknet_leaf_160_clk
+ _02648_ _01361_ VSS VSS VDD VDD network.neuron_in146.counter\[0\]
+ sky130_fd_sc_hd__edfxtp_1
Xnetwork.neuron_in146.counter\[1\]$_DFFE_PP_ clknet_leaf_159_clk
+ _02649_ _01361_ VSS VSS VDD VDD network.neuron_in146.counter\[1\]
+ sky130_fd_sc_hd__edfxtp_1
Xnetwork.neuron_in146.counter\[2\]$_DFFE_PP_ clknet_leaf_159_clk
+ _02650_ _01361_ VSS VSS VDD VDD network.neuron_in146.counter\[2\]
+ sky130_fd_sc_hd__edfxtp_1
Xnetwork.neuron_in146.counter\[3\]$_DFFE_PP_ clknet_leaf_159_clk
+ _02651_ _01361_ VSS VSS VDD VDD network.neuron_in146.counter\[3\]
+ sky130_fd_sc_hd__edfxtp_1
Xnetwork.neuron_in146.spike$_SDFFE_PP0P_ clknet_leaf_158_clk
+ _02015_ VSS VSS VDD VDD network.in_spk02_09 sky130_fd_sc_hd__dfxtp_1
Xnetwork.neuron_in147.counter\[0\]$_DFFE_PP_ clknet_leaf_150_clk
+ _02652_ _01360_ VSS VSS VDD VDD network.neuron_in147.counter\[0\]
+ sky130_fd_sc_hd__edfxtp_1
Xnetwork.neuron_in147.counter\[1\]$_DFFE_PP_ clknet_leaf_150_clk
+ _02653_ _01360_ VSS VSS VDD VDD network.neuron_in147.counter\[1\]
+ sky130_fd_sc_hd__edfxtp_1
Xnetwork.neuron_in147.counter\[2\]$_DFFE_PP_ clknet_leaf_150_clk
+ _02654_ _01360_ VSS VSS VDD VDD network.neuron_in147.counter\[2\]
+ sky130_fd_sc_hd__edfxtp_1
Xnetwork.neuron_in147.counter\[3\]$_DFFE_PP_ clknet_leaf_150_clk
+ _02655_ _01360_ VSS VSS VDD VDD network.neuron_in147.counter\[3\]
+ sky130_fd_sc_hd__edfxtp_1
Xnetwork.neuron_in147.spike$_SDFFE_PP0P_ clknet_leaf_159_clk
+ _02014_ VSS VSS VDD VDD network.in_spk03_09 sky130_fd_sc_hd__dfxtp_1
Xnetwork.neuron_in148.counter\[0\]$_DFFE_PP_ clknet_leaf_152_clk
+ _02656_ _01359_ VSS VSS VDD VDD network.neuron_in148.counter\[0\]
+ sky130_fd_sc_hd__edfxtp_1
Xnetwork.neuron_in148.counter\[1\]$_DFFE_PP_ clknet_leaf_152_clk
+ _02657_ _01359_ VSS VSS VDD VDD network.neuron_in148.counter\[1\]
+ sky130_fd_sc_hd__edfxtp_1
Xnetwork.neuron_in148.counter\[2\]$_DFFE_PP_ clknet_leaf_150_clk
+ _02658_ _01359_ VSS VSS VDD VDD network.neuron_in148.counter\[2\]
+ sky130_fd_sc_hd__edfxtp_1
Xnetwork.neuron_in148.counter\[3\]$_DFFE_PP_ clknet_leaf_151_clk
+ _02659_ _01359_ VSS VSS VDD VDD network.neuron_in148.counter\[3\]
+ sky130_fd_sc_hd__edfxtp_1
Xnetwork.neuron_in148.spike$_SDFFE_PP0P_ clknet_leaf_159_clk
+ _02013_ VSS VSS VDD VDD network.in_spk04_09 sky130_fd_sc_hd__dfxtp_1
Xnetwork.neuron_in149.counter\[0\]$_DFFE_PP_ clknet_leaf_151_clk
+ _02660_ _01358_ VSS VSS VDD VDD network.neuron_in149.counter\[0\]
+ sky130_fd_sc_hd__edfxtp_1
Xnetwork.neuron_in149.counter\[1\]$_DFFE_PP_ clknet_leaf_151_clk
+ _02661_ _01358_ VSS VSS VDD VDD network.neuron_in149.counter\[1\]
+ sky130_fd_sc_hd__edfxtp_1
Xnetwork.neuron_in149.counter\[2\]$_DFFE_PP_ clknet_leaf_151_clk
+ _02662_ _01358_ VSS VSS VDD VDD network.neuron_in149.counter\[2\]
+ sky130_fd_sc_hd__edfxtp_1
Xnetwork.neuron_in149.counter\[3\]$_DFFE_PP_ clknet_leaf_151_clk
+ _02663_ _01358_ VSS VSS VDD VDD network.neuron_in149.counter\[3\]
+ sky130_fd_sc_hd__edfxtp_1
Xnetwork.neuron_in149.spike$_SDFFE_PP0P_ clknet_leaf_157_clk
+ _02012_ VSS VSS VDD VDD network.in_spk05_09 sky130_fd_sc_hd__dfxtp_1
Xnetwork.neuron_in150.counter\[0\]$_DFFE_PP_ clknet_leaf_160_clk
+ _02664_ _01357_ VSS VSS VDD VDD network.neuron_in150.counter\[0\]
+ sky130_fd_sc_hd__edfxtp_1
Xnetwork.neuron_in150.counter\[1\]$_DFFE_PP_ clknet_leaf_160_clk
+ _02665_ _01357_ VSS VSS VDD VDD network.neuron_in150.counter\[1\]
+ sky130_fd_sc_hd__edfxtp_1
Xnetwork.neuron_in150.counter\[2\]$_DFFE_PP_ clknet_leaf_160_clk
+ _02666_ _01357_ VSS VSS VDD VDD network.neuron_in150.counter\[2\]
+ sky130_fd_sc_hd__edfxtp_1
Xnetwork.neuron_in150.counter\[3\]$_DFFE_PP_ clknet_leaf_160_clk
+ _02667_ _01357_ VSS VSS VDD VDD network.neuron_in150.counter\[3\]
+ sky130_fd_sc_hd__edfxtp_1
Xnetwork.neuron_in150.spike$_SDFFE_PP0P_ clknet_leaf_159_clk
+ _02011_ VSS VSS VDD VDD network.in_spk06_09 sky130_fd_sc_hd__dfxtp_1
Xnetwork.neuron_in151.counter\[0\]$_DFFE_PP_ clknet_leaf_156_clk
+ _02668_ _01356_ VSS VSS VDD VDD network.neuron_in151.counter\[0\]
+ sky130_fd_sc_hd__edfxtp_1
Xnetwork.neuron_in151.counter\[1\]$_DFFE_PP_ clknet_leaf_156_clk
+ _02669_ _01356_ VSS VSS VDD VDD network.neuron_in151.counter\[1\]
+ sky130_fd_sc_hd__edfxtp_1
Xnetwork.neuron_in151.counter\[2\]$_DFFE_PP_ clknet_leaf_154_clk
+ _02670_ _01356_ VSS VSS VDD VDD network.neuron_in151.counter\[2\]
+ sky130_fd_sc_hd__edfxtp_1
Xnetwork.neuron_in151.counter\[3\]$_DFFE_PP_ clknet_leaf_154_clk
+ _02671_ _01356_ VSS VSS VDD VDD network.neuron_in151.counter\[3\]
+ sky130_fd_sc_hd__edfxtp_1
Xnetwork.neuron_in151.spike$_SDFFE_PP0P_ clknet_leaf_157_clk
+ _02010_ VSS VSS VDD VDD network.in_spk07_09 sky130_fd_sc_hd__dfxtp_1
Xnetwork.neuron_in152.counter\[0\]$_DFFE_PP_ clknet_leaf_160_clk
+ _02672_ _01355_ VSS VSS VDD VDD network.neuron_in152.counter\[0\]
+ sky130_fd_sc_hd__edfxtp_1
Xnetwork.neuron_in152.counter\[1\]$_DFFE_PP_ clknet_leaf_158_clk
+ _02673_ _01355_ VSS VSS VDD VDD network.neuron_in152.counter\[1\]
+ sky130_fd_sc_hd__edfxtp_1
Xnetwork.neuron_in152.counter\[2\]$_DFFE_PP_ clknet_leaf_162_clk
+ _02674_ _01355_ VSS VSS VDD VDD network.neuron_in152.counter\[2\]
+ sky130_fd_sc_hd__edfxtp_1
Xnetwork.neuron_in152.counter\[3\]$_DFFE_PP_ clknet_leaf_162_clk
+ _02675_ _01355_ VSS VSS VDD VDD network.neuron_in152.counter\[3\]
+ sky130_fd_sc_hd__edfxtp_1
Xnetwork.neuron_in152.spike$_SDFFE_PP0P_ clknet_leaf_158_clk
+ _02009_ VSS VSS VDD VDD network.in_spk08_09 sky130_fd_sc_hd__dfxtp_1
Xnetwork.neuron_in153.counter\[0\]$_DFFE_PP_ clknet_leaf_162_clk
+ _02676_ _01354_ VSS VSS VDD VDD network.neuron_in153.counter\[0\]
+ sky130_fd_sc_hd__edfxtp_1
Xnetwork.neuron_in153.counter\[1\]$_DFFE_PP_ clknet_leaf_162_clk
+ _02677_ _01354_ VSS VSS VDD VDD network.neuron_in153.counter\[1\]
+ sky130_fd_sc_hd__edfxtp_1
Xnetwork.neuron_in153.counter\[2\]$_DFFE_PP_ clknet_leaf_161_clk
+ _02678_ _01354_ VSS VSS VDD VDD network.neuron_in153.counter\[2\]
+ sky130_fd_sc_hd__edfxtp_1
Xnetwork.neuron_in153.counter\[3\]$_DFFE_PP_ clknet_leaf_162_clk
+ _02679_ _01354_ VSS VSS VDD VDD network.neuron_in153.counter\[3\]
+ sky130_fd_sc_hd__edfxtp_1
Xnetwork.neuron_in153.spike$_SDFFE_PP0P_ clknet_leaf_158_clk
+ _02008_ VSS VSS VDD VDD network.in_spk09_09 sky130_fd_sc_hd__dfxtp_1
Xnetwork.neuron_in154.counter\[0\]$_DFFE_PP_ clknet_leaf_231_clk
+ _02680_ _01353_ VSS VSS VDD VDD network.neuron_in154.counter\[0\]
+ sky130_fd_sc_hd__edfxtp_1
Xnetwork.neuron_in154.counter\[1\]$_DFFE_PP_ clknet_leaf_231_clk
+ _02681_ _01353_ VSS VSS VDD VDD network.neuron_in154.counter\[1\]
+ sky130_fd_sc_hd__edfxtp_1
Xnetwork.neuron_in154.counter\[2\]$_DFFE_PP_ clknet_leaf_231_clk
+ _02682_ _01353_ VSS VSS VDD VDD network.neuron_in154.counter\[2\]
+ sky130_fd_sc_hd__edfxtp_1
Xnetwork.neuron_in154.counter\[3\]$_DFFE_PP_ clknet_leaf_231_clk
+ _02683_ _01353_ VSS VSS VDD VDD network.neuron_in154.counter\[3\]
+ sky130_fd_sc_hd__edfxtp_1
Xnetwork.neuron_in154.spike$_SDFFE_PP0P_ clknet_leaf_157_clk
+ _02007_ VSS VSS VDD VDD network.in_spk10_09 sky130_fd_sc_hd__dfxtp_1
Xnetwork.neuron_in155.counter\[0\]$_DFFE_PP_ clknet_leaf_156_clk
+ _02684_ _01352_ VSS VSS VDD VDD network.neuron_in155.counter\[0\]
+ sky130_fd_sc_hd__edfxtp_1
Xnetwork.neuron_in155.counter\[1\]$_DFFE_PP_ clknet_leaf_233_clk
+ _02685_ _01352_ VSS VSS VDD VDD network.neuron_in155.counter\[1\]
+ sky130_fd_sc_hd__edfxtp_1
Xnetwork.neuron_in155.counter\[2\]$_DFFE_PP_ clknet_leaf_156_clk
+ _02686_ _01352_ VSS VSS VDD VDD network.neuron_in155.counter\[2\]
+ sky130_fd_sc_hd__edfxtp_1
Xnetwork.neuron_in155.counter\[3\]$_DFFE_PP_ clknet_leaf_156_clk
+ _02687_ _01352_ VSS VSS VDD VDD network.neuron_in155.counter\[3\]
+ sky130_fd_sc_hd__edfxtp_1
Xnetwork.neuron_in155.spike$_SDFFE_PP0P_ clknet_leaf_157_clk
+ _02006_ VSS VSS VDD VDD network.in_spk11_09 sky130_fd_sc_hd__dfxtp_1
Xnetwork.neuron_in156.counter\[0\]$_DFFE_PP_ clknet_leaf_230_clk
+ _02688_ _01351_ VSS VSS VDD VDD network.neuron_in156.counter\[0\]
+ sky130_fd_sc_hd__edfxtp_1
Xnetwork.neuron_in156.counter\[1\]$_DFFE_PP_ clknet_leaf_230_clk
+ _02689_ _01351_ VSS VSS VDD VDD network.neuron_in156.counter\[1\]
+ sky130_fd_sc_hd__edfxtp_1
Xnetwork.neuron_in156.counter\[2\]$_DFFE_PP_ clknet_leaf_226_clk
+ _02690_ _01351_ VSS VSS VDD VDD network.neuron_in156.counter\[2\]
+ sky130_fd_sc_hd__edfxtp_1
Xnetwork.neuron_in156.counter\[3\]$_DFFE_PP_ clknet_leaf_231_clk
+ _02691_ _01351_ VSS VSS VDD VDD network.neuron_in156.counter\[3\]
+ sky130_fd_sc_hd__edfxtp_1
Xnetwork.neuron_in156.spike$_SDFFE_PP0P_ clknet_leaf_158_clk
+ _02005_ VSS VSS VDD VDD network.in_spk12_09 sky130_fd_sc_hd__dfxtp_1
Xnetwork.neuron_in157.counter\[0\]$_DFFE_PP_ clknet_leaf_163_clk
+ _02692_ _01350_ VSS VSS VDD VDD network.neuron_in157.counter\[0\]
+ sky130_fd_sc_hd__edfxtp_1
Xnetwork.neuron_in157.counter\[1\]$_DFFE_PP_ clknet_leaf_163_clk
+ _02693_ _01350_ VSS VSS VDD VDD network.neuron_in157.counter\[1\]
+ sky130_fd_sc_hd__edfxtp_1
Xnetwork.neuron_in157.counter\[2\]$_DFFE_PP_ clknet_leaf_162_clk
+ _02694_ _01350_ VSS VSS VDD VDD network.neuron_in157.counter\[2\]
+ sky130_fd_sc_hd__edfxtp_1
Xnetwork.neuron_in157.counter\[3\]$_DFFE_PP_ clknet_leaf_163_clk
+ _02695_ _01350_ VSS VSS VDD VDD network.neuron_in157.counter\[3\]
+ sky130_fd_sc_hd__edfxtp_1
Xnetwork.neuron_in157.spike$_SDFFE_PP0P_ clknet_leaf_162_clk
+ _02004_ VSS VSS VDD VDD network.in_spk13_09 sky130_fd_sc_hd__dfxtp_1
Xnetwork.neuron_in158.counter\[0\]$_DFFE_PP_ clknet_leaf_225_clk
+ _02696_ _01349_ VSS VSS VDD VDD network.neuron_in158.counter\[0\]
+ sky130_fd_sc_hd__edfxtp_1
Xnetwork.neuron_in158.counter\[1\]$_DFFE_PP_ clknet_leaf_225_clk
+ _02697_ _01349_ VSS VSS VDD VDD network.neuron_in158.counter\[1\]
+ sky130_fd_sc_hd__edfxtp_1
Xnetwork.neuron_in158.counter\[2\]$_DFFE_PP_ clknet_leaf_226_clk
+ _02698_ _01349_ VSS VSS VDD VDD network.neuron_in158.counter\[2\]
+ sky130_fd_sc_hd__edfxtp_1
Xnetwork.neuron_in158.counter\[3\]$_DFFE_PP_ clknet_leaf_226_clk
+ _02699_ _01349_ VSS VSS VDD VDD network.neuron_in158.counter\[3\]
+ sky130_fd_sc_hd__edfxtp_1
Xnetwork.neuron_in158.spike$_SDFFE_PP0P_ clknet_leaf_158_clk
+ _02003_ VSS VSS VDD VDD network.in_spk14_09 sky130_fd_sc_hd__dfxtp_1
Xnetwork.neuron_in159.counter\[0\]$_DFFE_PP_ clknet_leaf_161_clk
+ _02700_ _01348_ VSS VSS VDD VDD network.neuron_in159.counter\[0\]
+ sky130_fd_sc_hd__edfxtp_1
Xnetwork.neuron_in159.counter\[1\]$_DFFE_PP_ clknet_leaf_160_clk
+ _02701_ _01348_ VSS VSS VDD VDD network.neuron_in159.counter\[1\]
+ sky130_fd_sc_hd__edfxtp_1
Xnetwork.neuron_in159.counter\[2\]$_DFFE_PP_ clknet_leaf_161_clk
+ _02702_ _01348_ VSS VSS VDD VDD network.neuron_in159.counter\[2\]
+ sky130_fd_sc_hd__edfxtp_1
Xnetwork.neuron_in159.counter\[3\]$_DFFE_PP_ clknet_leaf_161_clk
+ _02703_ _01348_ VSS VSS VDD VDD network.neuron_in159.counter\[3\]
+ sky130_fd_sc_hd__edfxtp_1
Xnetwork.neuron_in159.spike$_SDFFE_PP0P_ clknet_leaf_158_clk
+ _02002_ VSS VSS VDD VDD network.in_spk15_09 sky130_fd_sc_hd__dfxtp_1
Xnetwork.neuron_in160.counter\[0\]$_DFFE_PP_ clknet_leaf_139_clk
+ _02704_ _01347_ VSS VSS VDD VDD network.neuron_in160.counter\[0\]
+ sky130_fd_sc_hd__edfxtp_1
Xnetwork.neuron_in160.counter\[1\]$_DFFE_PP_ clknet_leaf_140_clk
+ _02705_ _01347_ VSS VSS VDD VDD network.neuron_in160.counter\[1\]
+ sky130_fd_sc_hd__edfxtp_1
Xnetwork.neuron_in160.counter\[2\]$_DFFE_PP_ clknet_leaf_139_clk
+ _02706_ _01347_ VSS VSS VDD VDD network.neuron_in160.counter\[2\]
+ sky130_fd_sc_hd__edfxtp_1
Xnetwork.neuron_in160.counter\[3\]$_DFFE_PP_ clknet_leaf_139_clk
+ _02707_ _01347_ VSS VSS VDD VDD network.neuron_in160.counter\[3\]
+ sky130_fd_sc_hd__edfxtp_1
Xnetwork.neuron_in160.spike$_SDFFE_PP0P_ clknet_leaf_170_clk
+ _02001_ VSS VSS VDD VDD network.in_spk00_10 sky130_fd_sc_hd__dfxtp_1
Xnetwork.neuron_in161.counter\[0\]$_DFFE_PP_ clknet_leaf_140_clk
+ _02708_ _01346_ VSS VSS VDD VDD network.neuron_in161.counter\[0\]
+ sky130_fd_sc_hd__edfxtp_1
Xnetwork.neuron_in161.counter\[1\]$_DFFE_PP_ clknet_leaf_140_clk
+ _02709_ _01346_ VSS VSS VDD VDD network.neuron_in161.counter\[1\]
+ sky130_fd_sc_hd__edfxtp_1
Xnetwork.neuron_in161.counter\[2\]$_DFFE_PP_ clknet_leaf_140_clk
+ _02710_ _01346_ VSS VSS VDD VDD network.neuron_in161.counter\[2\]
+ sky130_fd_sc_hd__edfxtp_1
Xnetwork.neuron_in161.counter\[3\]$_DFFE_PP_ clknet_leaf_140_clk
+ _02711_ _01346_ VSS VSS VDD VDD network.neuron_in161.counter\[3\]
+ sky130_fd_sc_hd__edfxtp_1
Xnetwork.neuron_in161.spike$_SDFFE_PP0P_ clknet_leaf_170_clk
+ _02000_ VSS VSS VDD VDD network.in_spk01_10 sky130_fd_sc_hd__dfxtp_1
Xnetwork.neuron_in162.counter\[0\]$_DFFE_PP_ clknet_leaf_135_clk
+ _02712_ _01345_ VSS VSS VDD VDD network.neuron_in162.counter\[0\]
+ sky130_fd_sc_hd__edfxtp_1
Xnetwork.neuron_in162.counter\[1\]$_DFFE_PP_ clknet_leaf_174_clk
+ _02713_ _01345_ VSS VSS VDD VDD network.neuron_in162.counter\[1\]
+ sky130_fd_sc_hd__edfxtp_1
Xnetwork.neuron_in162.counter\[2\]$_DFFE_PP_ clknet_leaf_171_clk
+ _02714_ _01345_ VSS VSS VDD VDD network.neuron_in162.counter\[2\]
+ sky130_fd_sc_hd__edfxtp_1
Xnetwork.neuron_in162.counter\[3\]$_DFFE_PP_ clknet_leaf_138_clk
+ _02715_ _01345_ VSS VSS VDD VDD network.neuron_in162.counter\[3\]
+ sky130_fd_sc_hd__edfxtp_1
Xnetwork.neuron_in162.spike$_SDFFE_PP0P_ clknet_leaf_170_clk
+ _01999_ VSS VSS VDD VDD network.in_spk02_10 sky130_fd_sc_hd__dfxtp_1
Xnetwork.neuron_in163.counter\[0\]$_DFFE_PP_ clknet_leaf_170_clk
+ _02716_ _01344_ VSS VSS VDD VDD network.neuron_in163.counter\[0\]
+ sky130_fd_sc_hd__edfxtp_1
Xnetwork.neuron_in163.counter\[1\]$_DFFE_PP_ clknet_leaf_170_clk
+ _02717_ _01344_ VSS VSS VDD VDD network.neuron_in163.counter\[1\]
+ sky130_fd_sc_hd__edfxtp_1
Xnetwork.neuron_in163.counter\[2\]$_DFFE_PP_ clknet_leaf_171_clk
+ _02718_ _01344_ VSS VSS VDD VDD network.neuron_in163.counter\[2\]
+ sky130_fd_sc_hd__edfxtp_1
Xnetwork.neuron_in163.counter\[3\]$_DFFE_PP_ clknet_leaf_170_clk
+ _02719_ _01344_ VSS VSS VDD VDD network.neuron_in163.counter\[3\]
+ sky130_fd_sc_hd__edfxtp_1
Xnetwork.neuron_in163.spike$_SDFFE_PP0P_ clknet_leaf_170_clk
+ _01998_ VSS VSS VDD VDD network.in_spk03_10 sky130_fd_sc_hd__dfxtp_1
Xnetwork.neuron_in164.counter\[0\]$_DFFE_PP_ clknet_leaf_182_clk
+ _02720_ _01343_ VSS VSS VDD VDD network.neuron_in164.counter\[0\]
+ sky130_fd_sc_hd__edfxtp_1
Xnetwork.neuron_in164.counter\[1\]$_DFFE_PP_ clknet_leaf_182_clk
+ _02721_ _01343_ VSS VSS VDD VDD network.neuron_in164.counter\[1\]
+ sky130_fd_sc_hd__edfxtp_1
Xnetwork.neuron_in164.counter\[2\]$_DFFE_PP_ clknet_leaf_182_clk
+ _02722_ _01343_ VSS VSS VDD VDD network.neuron_in164.counter\[2\]
+ sky130_fd_sc_hd__edfxtp_1
Xnetwork.neuron_in164.counter\[3\]$_DFFE_PP_ clknet_leaf_182_clk
+ _02723_ _01343_ VSS VSS VDD VDD network.neuron_in164.counter\[3\]
+ sky130_fd_sc_hd__edfxtp_1
Xnetwork.neuron_in164.spike$_SDFFE_PP0P_ clknet_leaf_172_clk
+ _01997_ VSS VSS VDD VDD network.in_spk04_10 sky130_fd_sc_hd__dfxtp_1
Xnetwork.neuron_in165.counter\[0\]$_DFFE_PP_ clknet_leaf_174_clk
+ _02724_ _01342_ VSS VSS VDD VDD network.neuron_in165.counter\[0\]
+ sky130_fd_sc_hd__edfxtp_1
Xnetwork.neuron_in165.counter\[1\]$_DFFE_PP_ clknet_leaf_173_clk
+ _02725_ _01342_ VSS VSS VDD VDD network.neuron_in165.counter\[1\]
+ sky130_fd_sc_hd__edfxtp_1
Xnetwork.neuron_in165.counter\[2\]$_DFFE_PP_ clknet_leaf_171_clk
+ _02726_ _01342_ VSS VSS VDD VDD network.neuron_in165.counter\[2\]
+ sky130_fd_sc_hd__edfxtp_1
Xnetwork.neuron_in165.counter\[3\]$_DFFE_PP_ clknet_leaf_174_clk
+ _02727_ _01342_ VSS VSS VDD VDD network.neuron_in165.counter\[3\]
+ sky130_fd_sc_hd__edfxtp_1
Xnetwork.neuron_in165.spike$_SDFFE_PP0P_ clknet_leaf_171_clk
+ _01996_ VSS VSS VDD VDD network.in_spk05_10 sky130_fd_sc_hd__dfxtp_1
Xnetwork.neuron_in166.counter\[0\]$_DFFE_PP_ clknet_leaf_173_clk
+ _02728_ _01341_ VSS VSS VDD VDD network.neuron_in166.counter\[0\]
+ sky130_fd_sc_hd__edfxtp_1
Xnetwork.neuron_in166.counter\[1\]$_DFFE_PP_ clknet_leaf_172_clk
+ _02729_ _01341_ VSS VSS VDD VDD network.neuron_in166.counter\[1\]
+ sky130_fd_sc_hd__edfxtp_1
Xnetwork.neuron_in166.counter\[2\]$_DFFE_PP_ clknet_leaf_172_clk
+ _02730_ _01341_ VSS VSS VDD VDD network.neuron_in166.counter\[2\]
+ sky130_fd_sc_hd__edfxtp_1
Xnetwork.neuron_in166.counter\[3\]$_DFFE_PP_ clknet_leaf_172_clk
+ _02731_ _01341_ VSS VSS VDD VDD network.neuron_in166.counter\[3\]
+ sky130_fd_sc_hd__edfxtp_1
Xnetwork.neuron_in166.spike$_SDFFE_PP0P_ clknet_leaf_172_clk
+ _01995_ VSS VSS VDD VDD network.in_spk06_10 sky130_fd_sc_hd__dfxtp_1
Xnetwork.neuron_in167.counter\[0\]$_DFFE_PP_ clknet_leaf_138_clk
+ _02732_ _01340_ VSS VSS VDD VDD network.neuron_in167.counter\[0\]
+ sky130_fd_sc_hd__edfxtp_1
Xnetwork.neuron_in167.counter\[1\]$_DFFE_PP_ clknet_leaf_138_clk
+ _02733_ _01340_ VSS VSS VDD VDD network.neuron_in167.counter\[1\]
+ sky130_fd_sc_hd__edfxtp_1
Xnetwork.neuron_in167.counter\[2\]$_DFFE_PP_ clknet_leaf_135_clk
+ _02734_ _01340_ VSS VSS VDD VDD network.neuron_in167.counter\[2\]
+ sky130_fd_sc_hd__edfxtp_1
Xnetwork.neuron_in167.counter\[3\]$_DFFE_PP_ clknet_leaf_136_clk
+ _02735_ _01340_ VSS VSS VDD VDD network.neuron_in167.counter\[3\]
+ sky130_fd_sc_hd__edfxtp_1
Xnetwork.neuron_in167.spike$_SDFFE_PP0P_ clknet_leaf_171_clk
+ _01994_ VSS VSS VDD VDD network.in_spk07_10 sky130_fd_sc_hd__dfxtp_1
Xnetwork.neuron_in168.counter\[0\]$_DFFE_PP_ clknet_leaf_168_clk
+ _02736_ _01339_ VSS VSS VDD VDD network.neuron_in168.counter\[0\]
+ sky130_fd_sc_hd__edfxtp_1
Xnetwork.neuron_in168.counter\[1\]$_DFFE_PP_ clknet_leaf_177_clk
+ _02737_ _01339_ VSS VSS VDD VDD network.neuron_in168.counter\[1\]
+ sky130_fd_sc_hd__edfxtp_1
Xnetwork.neuron_in168.counter\[2\]$_DFFE_PP_ clknet_leaf_173_clk
+ _02738_ _01339_ VSS VSS VDD VDD network.neuron_in168.counter\[2\]
+ sky130_fd_sc_hd__edfxtp_1
Xnetwork.neuron_in168.counter\[3\]$_DFFE_PP_ clknet_leaf_168_clk
+ _02739_ _01339_ VSS VSS VDD VDD network.neuron_in168.counter\[3\]
+ sky130_fd_sc_hd__edfxtp_1
Xnetwork.neuron_in168.spike$_SDFFE_PP0P_ clknet_leaf_169_clk
+ _01993_ VSS VSS VDD VDD network.in_spk08_10 sky130_fd_sc_hd__dfxtp_1
Xnetwork.neuron_in169.counter\[0\]$_DFFE_PP_ clknet_leaf_169_clk
+ _02740_ _01338_ VSS VSS VDD VDD network.neuron_in169.counter\[0\]
+ sky130_fd_sc_hd__edfxtp_1
Xnetwork.neuron_in169.counter\[1\]$_DFFE_PP_ clknet_leaf_168_clk
+ _02741_ _01338_ VSS VSS VDD VDD network.neuron_in169.counter\[1\]
+ sky130_fd_sc_hd__edfxtp_1
Xnetwork.neuron_in169.counter\[2\]$_DFFE_PP_ clknet_leaf_168_clk
+ _02742_ _01338_ VSS VSS VDD VDD network.neuron_in169.counter\[2\]
+ sky130_fd_sc_hd__edfxtp_1
Xnetwork.neuron_in169.counter\[3\]$_DFFE_PP_ clknet_leaf_168_clk
+ _02743_ _01338_ VSS VSS VDD VDD network.neuron_in169.counter\[3\]
+ sky130_fd_sc_hd__edfxtp_1
Xnetwork.neuron_in169.spike$_SDFFE_PP0P_ clknet_leaf_169_clk
+ _01992_ VSS VSS VDD VDD network.in_spk09_10 sky130_fd_sc_hd__dfxtp_1
Xnetwork.neuron_in170.counter\[0\]$_DFFE_PP_ clknet_leaf_167_clk
+ _02744_ _01337_ VSS VSS VDD VDD network.neuron_in170.counter\[0\]
+ sky130_fd_sc_hd__edfxtp_1
Xnetwork.neuron_in170.counter\[1\]$_DFFE_PP_ clknet_leaf_166_clk
+ _02745_ _01337_ VSS VSS VDD VDD network.neuron_in170.counter\[1\]
+ sky130_fd_sc_hd__edfxtp_1
Xnetwork.neuron_in170.counter\[2\]$_DFFE_PP_ clknet_leaf_167_clk
+ _02746_ _01337_ VSS VSS VDD VDD network.neuron_in170.counter\[2\]
+ sky130_fd_sc_hd__edfxtp_1
Xnetwork.neuron_in170.counter\[3\]$_DFFE_PP_ clknet_leaf_166_clk
+ _02747_ _01337_ VSS VSS VDD VDD network.neuron_in170.counter\[3\]
+ sky130_fd_sc_hd__edfxtp_1
Xnetwork.neuron_in170.spike$_SDFFE_PP0P_ clknet_leaf_169_clk
+ _01991_ VSS VSS VDD VDD network.in_spk10_10 sky130_fd_sc_hd__dfxtp_1
Xnetwork.neuron_in171.counter\[0\]$_DFFE_PP_ clknet_leaf_165_clk
+ _02748_ _01336_ VSS VSS VDD VDD network.neuron_in171.counter\[0\]
+ sky130_fd_sc_hd__edfxtp_1
Xnetwork.neuron_in171.counter\[1\]$_DFFE_PP_ clknet_leaf_184_clk
+ _02749_ _01336_ VSS VSS VDD VDD network.neuron_in171.counter\[1\]
+ sky130_fd_sc_hd__edfxtp_1
Xnetwork.neuron_in171.counter\[2\]$_DFFE_PP_ clknet_leaf_165_clk
+ _02750_ _01336_ VSS VSS VDD VDD network.neuron_in171.counter\[2\]
+ sky130_fd_sc_hd__edfxtp_1
Xnetwork.neuron_in171.counter\[3\]$_DFFE_PP_ clknet_leaf_165_clk
+ _02751_ _01336_ VSS VSS VDD VDD network.neuron_in171.counter\[3\]
+ sky130_fd_sc_hd__edfxtp_1
Xnetwork.neuron_in171.spike$_SDFFE_PP0P_ clknet_leaf_169_clk
+ _01990_ VSS VSS VDD VDD network.in_spk11_10 sky130_fd_sc_hd__dfxtp_1
Xnetwork.neuron_in172.counter\[0\]$_DFFE_PP_ clknet_leaf_167_clk
+ _02752_ _01335_ VSS VSS VDD VDD network.neuron_in172.counter\[0\]
+ sky130_fd_sc_hd__edfxtp_1
Xnetwork.neuron_in172.counter\[1\]$_DFFE_PP_ clknet_leaf_167_clk
+ _02753_ _01335_ VSS VSS VDD VDD network.neuron_in172.counter\[1\]
+ sky130_fd_sc_hd__edfxtp_1
Xnetwork.neuron_in172.counter\[2\]$_DFFE_PP_ clknet_leaf_166_clk
+ _02754_ _01335_ VSS VSS VDD VDD network.neuron_in172.counter\[2\]
+ sky130_fd_sc_hd__edfxtp_1
Xnetwork.neuron_in172.counter\[3\]$_DFFE_PP_ clknet_leaf_166_clk
+ _02755_ _01335_ VSS VSS VDD VDD network.neuron_in172.counter\[3\]
+ sky130_fd_sc_hd__edfxtp_1
Xnetwork.neuron_in172.spike$_SDFFE_PP0P_ clknet_leaf_167_clk
+ _01989_ VSS VSS VDD VDD network.in_spk12_10 sky130_fd_sc_hd__dfxtp_1
Xnetwork.neuron_in173.counter\[0\]$_DFFE_PP_ clknet_leaf_184_clk
+ _02756_ _01334_ VSS VSS VDD VDD network.neuron_in173.counter\[0\]
+ sky130_fd_sc_hd__edfxtp_1
Xnetwork.neuron_in173.counter\[1\]$_DFFE_PP_ clknet_leaf_185_clk
+ _02757_ _01334_ VSS VSS VDD VDD network.neuron_in173.counter\[1\]
+ sky130_fd_sc_hd__edfxtp_1
Xnetwork.neuron_in173.counter\[2\]$_DFFE_PP_ clknet_leaf_183_clk
+ _02758_ _01334_ VSS VSS VDD VDD network.neuron_in173.counter\[2\]
+ sky130_fd_sc_hd__edfxtp_1
Xnetwork.neuron_in173.counter\[3\]$_DFFE_PP_ clknet_leaf_185_clk
+ _02759_ _01334_ VSS VSS VDD VDD network.neuron_in173.counter\[3\]
+ sky130_fd_sc_hd__edfxtp_1
Xnetwork.neuron_in173.spike$_SDFFE_PP0P_ clknet_leaf_167_clk
+ _01988_ VSS VSS VDD VDD network.in_spk13_10 sky130_fd_sc_hd__dfxtp_1
Xnetwork.neuron_in174.counter\[0\]$_DFFE_PP_ clknet_leaf_183_clk
+ _02760_ _01333_ VSS VSS VDD VDD network.neuron_in174.counter\[0\]
+ sky130_fd_sc_hd__edfxtp_1
Xnetwork.neuron_in174.counter\[1\]$_DFFE_PP_ clknet_leaf_183_clk
+ _02761_ _01333_ VSS VSS VDD VDD network.neuron_in174.counter\[1\]
+ sky130_fd_sc_hd__edfxtp_1
Xnetwork.neuron_in174.counter\[2\]$_DFFE_PP_ clknet_leaf_183_clk
+ _02762_ _01333_ VSS VSS VDD VDD network.neuron_in174.counter\[2\]
+ sky130_fd_sc_hd__edfxtp_1
Xnetwork.neuron_in174.counter\[3\]$_DFFE_PP_ clknet_leaf_183_clk
+ _02763_ _01333_ VSS VSS VDD VDD network.neuron_in174.counter\[3\]
+ sky130_fd_sc_hd__edfxtp_1
Xnetwork.neuron_in174.spike$_SDFFE_PP0P_ clknet_leaf_167_clk
+ _01987_ VSS VSS VDD VDD network.in_spk14_10 sky130_fd_sc_hd__dfxtp_1
Xnetwork.neuron_in175.counter\[0\]$_DFFE_PP_ clknet_leaf_183_clk
+ _02764_ _01332_ VSS VSS VDD VDD network.neuron_in175.counter\[0\]
+ sky130_fd_sc_hd__edfxtp_1
Xnetwork.neuron_in175.counter\[1\]$_DFFE_PP_ clknet_leaf_181_clk
+ _02765_ _01332_ VSS VSS VDD VDD network.neuron_in175.counter\[1\]
+ sky130_fd_sc_hd__edfxtp_1
Xnetwork.neuron_in175.counter\[2\]$_DFFE_PP_ clknet_leaf_182_clk
+ _02766_ _01332_ VSS VSS VDD VDD network.neuron_in175.counter\[2\]
+ sky130_fd_sc_hd__edfxtp_1
Xnetwork.neuron_in175.counter\[3\]$_DFFE_PP_ clknet_leaf_181_clk
+ _02767_ _01332_ VSS VSS VDD VDD network.neuron_in175.counter\[3\]
+ sky130_fd_sc_hd__edfxtp_1
Xnetwork.neuron_in175.spike$_SDFFE_PP0P_ clknet_leaf_167_clk
+ _01986_ VSS VSS VDD VDD network.in_spk15_10 sky130_fd_sc_hd__dfxtp_1
Xnetwork.neuron_in176.counter\[0\]$_DFFE_PP_ clknet_leaf_186_clk
+ _02768_ _01331_ VSS VSS VDD VDD network.neuron_in176.counter\[0\]
+ sky130_fd_sc_hd__edfxtp_1
Xnetwork.neuron_in176.counter\[1\]$_DFFE_PP_ clknet_leaf_186_clk
+ _02769_ _01331_ VSS VSS VDD VDD network.neuron_in176.counter\[1\]
+ sky130_fd_sc_hd__edfxtp_1
Xnetwork.neuron_in176.counter\[2\]$_DFFE_PP_ clknet_leaf_186_clk
+ _02770_ _01331_ VSS VSS VDD VDD network.neuron_in176.counter\[2\]
+ sky130_fd_sc_hd__edfxtp_1
Xnetwork.neuron_in176.counter\[3\]$_DFFE_PP_ clknet_leaf_183_clk
+ _02771_ _01331_ VSS VSS VDD VDD network.neuron_in176.counter\[3\]
+ sky130_fd_sc_hd__edfxtp_1
Xnetwork.neuron_in176.spike$_SDFFE_PP0P_ clknet_leaf_187_clk
+ _01985_ VSS VSS VDD VDD network.in_spk00_11 sky130_fd_sc_hd__dfxtp_1
Xnetwork.neuron_in177.counter\[0\]$_DFFE_PP_ clknet_leaf_203_clk
+ _02772_ _01330_ VSS VSS VDD VDD network.neuron_in177.counter\[0\]
+ sky130_fd_sc_hd__edfxtp_1
Xnetwork.neuron_in177.counter\[1\]$_DFFE_PP_ clknet_leaf_224_clk
+ _02773_ _01330_ VSS VSS VDD VDD network.neuron_in177.counter\[1\]
+ sky130_fd_sc_hd__edfxtp_1
Xnetwork.neuron_in177.counter\[2\]$_DFFE_PP_ clknet_leaf_184_clk
+ _02774_ _01330_ VSS VSS VDD VDD network.neuron_in177.counter\[2\]
+ sky130_fd_sc_hd__edfxtp_1
Xnetwork.neuron_in177.counter\[3\]$_DFFE_PP_ clknet_leaf_184_clk
+ _02775_ _01330_ VSS VSS VDD VDD network.neuron_in177.counter\[3\]
+ sky130_fd_sc_hd__edfxtp_1
Xnetwork.neuron_in177.spike$_SDFFE_PP0P_ clknet_leaf_202_clk
+ _01984_ VSS VSS VDD VDD network.in_spk01_11 sky130_fd_sc_hd__dfxtp_1
Xnetwork.neuron_in178.counter\[0\]$_DFFE_PP_ clknet_leaf_186_clk
+ _02776_ _01329_ VSS VSS VDD VDD network.neuron_in178.counter\[0\]
+ sky130_fd_sc_hd__edfxtp_1
Xnetwork.neuron_in178.counter\[1\]$_DFFE_PP_ clknet_leaf_186_clk
+ _02777_ _01329_ VSS VSS VDD VDD network.neuron_in178.counter\[1\]
+ sky130_fd_sc_hd__edfxtp_1
Xnetwork.neuron_in178.counter\[2\]$_DFFE_PP_ clknet_leaf_185_clk
+ _02778_ _01329_ VSS VSS VDD VDD network.neuron_in178.counter\[2\]
+ sky130_fd_sc_hd__edfxtp_1
Xnetwork.neuron_in178.counter\[3\]$_DFFE_PP_ clknet_leaf_185_clk
+ _02779_ _01329_ VSS VSS VDD VDD network.neuron_in178.counter\[3\]
+ sky130_fd_sc_hd__edfxtp_1
Xnetwork.neuron_in178.spike$_SDFFE_PP0P_ clknet_leaf_202_clk
+ _01983_ VSS VSS VDD VDD network.in_spk02_11 sky130_fd_sc_hd__dfxtp_1
Xnetwork.neuron_in179.counter\[0\]$_DFFE_PP_ clknet_leaf_203_clk
+ _02780_ _01328_ VSS VSS VDD VDD network.neuron_in179.counter\[0\]
+ sky130_fd_sc_hd__edfxtp_1
Xnetwork.neuron_in179.counter\[1\]$_DFFE_PP_ clknet_leaf_202_clk
+ _02781_ _01328_ VSS VSS VDD VDD network.neuron_in179.counter\[1\]
+ sky130_fd_sc_hd__edfxtp_1
Xnetwork.neuron_in179.counter\[2\]$_DFFE_PP_ clknet_leaf_184_clk
+ _02782_ _01328_ VSS VSS VDD VDD network.neuron_in179.counter\[2\]
+ sky130_fd_sc_hd__edfxtp_1
Xnetwork.neuron_in179.counter\[3\]$_DFFE_PP_ clknet_leaf_184_clk
+ _02783_ _01328_ VSS VSS VDD VDD network.neuron_in179.counter\[3\]
+ sky130_fd_sc_hd__edfxtp_1
Xnetwork.neuron_in179.spike$_SDFFE_PP0P_ clknet_leaf_202_clk
+ _01982_ VSS VSS VDD VDD network.in_spk03_11 sky130_fd_sc_hd__dfxtp_1
Xnetwork.neuron_in180.counter\[0\]$_DFFE_PP_ clknet_leaf_193_clk
+ _02784_ _01327_ VSS VSS VDD VDD network.neuron_in180.counter\[0\]
+ sky130_fd_sc_hd__edfxtp_1
Xnetwork.neuron_in180.counter\[1\]$_DFFE_PP_ clknet_leaf_193_clk
+ _02785_ _01327_ VSS VSS VDD VDD network.neuron_in180.counter\[1\]
+ sky130_fd_sc_hd__edfxtp_1
Xnetwork.neuron_in180.counter\[2\]$_DFFE_PP_ clknet_leaf_187_clk
+ _02786_ _01327_ VSS VSS VDD VDD network.neuron_in180.counter\[2\]
+ sky130_fd_sc_hd__edfxtp_1
Xnetwork.neuron_in180.counter\[3\]$_DFFE_PP_ clknet_leaf_188_clk
+ _02787_ _01327_ VSS VSS VDD VDD network.neuron_in180.counter\[3\]
+ sky130_fd_sc_hd__edfxtp_1
Xnetwork.neuron_in180.spike$_SDFFE_PP0P_ clknet_leaf_201_clk
+ _01981_ VSS VSS VDD VDD network.in_spk04_11 sky130_fd_sc_hd__dfxtp_1
Xnetwork.neuron_in181.counter\[0\]$_DFFE_PP_ clknet_leaf_186_clk
+ _02788_ _01326_ VSS VSS VDD VDD network.neuron_in181.counter\[0\]
+ sky130_fd_sc_hd__edfxtp_1
Xnetwork.neuron_in181.counter\[1\]$_DFFE_PP_ clknet_leaf_188_clk
+ _02789_ _01326_ VSS VSS VDD VDD network.neuron_in181.counter\[1\]
+ sky130_fd_sc_hd__edfxtp_1
Xnetwork.neuron_in181.counter\[2\]$_DFFE_PP_ clknet_leaf_188_clk
+ _02790_ _01326_ VSS VSS VDD VDD network.neuron_in181.counter\[2\]
+ sky130_fd_sc_hd__edfxtp_1
Xnetwork.neuron_in181.counter\[3\]$_DFFE_PP_ clknet_leaf_187_clk
+ _02791_ _01326_ VSS VSS VDD VDD network.neuron_in181.counter\[3\]
+ sky130_fd_sc_hd__edfxtp_1
Xnetwork.neuron_in181.spike$_SDFFE_PP0P_ clknet_leaf_202_clk
+ _01980_ VSS VSS VDD VDD network.in_spk05_11 sky130_fd_sc_hd__dfxtp_1
Xnetwork.neuron_in182.counter\[0\]$_DFFE_PP_ clknet_leaf_194_clk
+ _02792_ _01325_ VSS VSS VDD VDD network.neuron_in182.counter\[0\]
+ sky130_fd_sc_hd__edfxtp_1
Xnetwork.neuron_in182.counter\[1\]$_DFFE_PP_ clknet_leaf_194_clk
+ _02793_ _01325_ VSS VSS VDD VDD network.neuron_in182.counter\[1\]
+ sky130_fd_sc_hd__edfxtp_1
Xnetwork.neuron_in182.counter\[2\]$_DFFE_PP_ clknet_leaf_194_clk
+ _02794_ _01325_ VSS VSS VDD VDD network.neuron_in182.counter\[2\]
+ sky130_fd_sc_hd__edfxtp_1
Xnetwork.neuron_in182.counter\[3\]$_DFFE_PP_ clknet_leaf_194_clk
+ _02795_ _01325_ VSS VSS VDD VDD network.neuron_in182.counter\[3\]
+ sky130_fd_sc_hd__edfxtp_1
Xnetwork.neuron_in182.spike$_SDFFE_PP0P_ clknet_leaf_201_clk
+ _01979_ VSS VSS VDD VDD network.in_spk06_11 sky130_fd_sc_hd__dfxtp_1
Xnetwork.neuron_in183.counter\[0\]$_DFFE_PP_ clknet_leaf_193_clk
+ _02796_ _01324_ VSS VSS VDD VDD network.neuron_in183.counter\[0\]
+ sky130_fd_sc_hd__edfxtp_1
Xnetwork.neuron_in183.counter\[1\]$_DFFE_PP_ clknet_leaf_193_clk
+ _02797_ _01324_ VSS VSS VDD VDD network.neuron_in183.counter\[1\]
+ sky130_fd_sc_hd__edfxtp_1
Xnetwork.neuron_in183.counter\[2\]$_DFFE_PP_ clknet_leaf_193_clk
+ _02798_ _01324_ VSS VSS VDD VDD network.neuron_in183.counter\[2\]
+ sky130_fd_sc_hd__edfxtp_1
Xnetwork.neuron_in183.counter\[3\]$_DFFE_PP_ clknet_leaf_193_clk
+ _02799_ _01324_ VSS VSS VDD VDD network.neuron_in183.counter\[3\]
+ sky130_fd_sc_hd__edfxtp_1
Xnetwork.neuron_in183.spike$_SDFFE_PP0P_ clknet_leaf_202_clk
+ _01978_ VSS VSS VDD VDD network.in_spk07_11 sky130_fd_sc_hd__dfxtp_1
Xnetwork.neuron_in184.counter\[0\]$_DFFE_PP_ clknet_leaf_196_clk
+ _02800_ _01323_ VSS VSS VDD VDD network.neuron_in184.counter\[0\]
+ sky130_fd_sc_hd__edfxtp_1
Xnetwork.neuron_in184.counter\[1\]$_DFFE_PP_ clknet_leaf_196_clk
+ _02801_ _01323_ VSS VSS VDD VDD network.neuron_in184.counter\[1\]
+ sky130_fd_sc_hd__edfxtp_1
Xnetwork.neuron_in184.counter\[2\]$_DFFE_PP_ clknet_leaf_194_clk
+ _02802_ _01323_ VSS VSS VDD VDD network.neuron_in184.counter\[2\]
+ sky130_fd_sc_hd__edfxtp_1
Xnetwork.neuron_in184.counter\[3\]$_DFFE_PP_ clknet_leaf_194_clk
+ _02803_ _01323_ VSS VSS VDD VDD network.neuron_in184.counter\[3\]
+ sky130_fd_sc_hd__edfxtp_1
Xnetwork.neuron_in184.spike$_SDFFE_PP0P_ clknet_leaf_199_clk
+ _01977_ VSS VSS VDD VDD network.in_spk08_11 sky130_fd_sc_hd__dfxtp_1
Xnetwork.neuron_in185.counter\[0\]$_DFFE_PP_ clknet_leaf_197_clk
+ _02804_ _01322_ VSS VSS VDD VDD network.neuron_in185.counter\[0\]
+ sky130_fd_sc_hd__edfxtp_1
Xnetwork.neuron_in185.counter\[1\]$_DFFE_PP_ clknet_leaf_197_clk
+ _02805_ _01322_ VSS VSS VDD VDD network.neuron_in185.counter\[1\]
+ sky130_fd_sc_hd__edfxtp_1
Xnetwork.neuron_in185.counter\[2\]$_DFFE_PP_ clknet_leaf_197_clk
+ _02806_ _01322_ VSS VSS VDD VDD network.neuron_in185.counter\[2\]
+ sky130_fd_sc_hd__edfxtp_1
Xnetwork.neuron_in185.counter\[3\]$_DFFE_PP_ clknet_leaf_196_clk
+ _02807_ _01322_ VSS VSS VDD VDD network.neuron_in185.counter\[3\]
+ sky130_fd_sc_hd__edfxtp_1
Xnetwork.neuron_in185.spike$_SDFFE_PP0P_ clknet_leaf_200_clk
+ _01976_ VSS VSS VDD VDD network.in_spk09_11 sky130_fd_sc_hd__dfxtp_1
Xnetwork.neuron_in186.counter\[0\]$_DFFE_PP_ clknet_leaf_207_clk
+ _02808_ _01321_ VSS VSS VDD VDD network.neuron_in186.counter\[0\]
+ sky130_fd_sc_hd__edfxtp_1
Xnetwork.neuron_in186.counter\[1\]$_DFFE_PP_ clknet_leaf_199_clk
+ _02809_ _01321_ VSS VSS VDD VDD network.neuron_in186.counter\[1\]
+ sky130_fd_sc_hd__edfxtp_1
Xnetwork.neuron_in186.counter\[2\]$_DFFE_PP_ clknet_leaf_199_clk
+ _02810_ _01321_ VSS VSS VDD VDD network.neuron_in186.counter\[2\]
+ sky130_fd_sc_hd__edfxtp_1
Xnetwork.neuron_in186.counter\[3\]$_DFFE_PP_ clknet_leaf_199_clk
+ _02811_ _01321_ VSS VSS VDD VDD network.neuron_in186.counter\[3\]
+ sky130_fd_sc_hd__edfxtp_1
Xnetwork.neuron_in186.spike$_SDFFE_PP0P_ clknet_leaf_199_clk
+ _01975_ VSS VSS VDD VDD network.in_spk10_11 sky130_fd_sc_hd__dfxtp_1
Xnetwork.neuron_in187.counter\[0\]$_DFFE_PP_ clknet_leaf_195_clk
+ _02812_ _01320_ VSS VSS VDD VDD network.neuron_in187.counter\[0\]
+ sky130_fd_sc_hd__edfxtp_1
Xnetwork.neuron_in187.counter\[1\]$_DFFE_PP_ clknet_leaf_195_clk
+ _02813_ _01320_ VSS VSS VDD VDD network.neuron_in187.counter\[1\]
+ sky130_fd_sc_hd__edfxtp_1
Xnetwork.neuron_in187.counter\[2\]$_DFFE_PP_ clknet_leaf_194_clk
+ _02814_ _01320_ VSS VSS VDD VDD network.neuron_in187.counter\[2\]
+ sky130_fd_sc_hd__edfxtp_1
Xnetwork.neuron_in187.counter\[3\]$_DFFE_PP_ clknet_leaf_194_clk
+ _02815_ _01320_ VSS VSS VDD VDD network.neuron_in187.counter\[3\]
+ sky130_fd_sc_hd__edfxtp_1
Xnetwork.neuron_in187.spike$_SDFFE_PP0P_ clknet_leaf_199_clk
+ _01974_ VSS VSS VDD VDD network.in_spk11_11 sky130_fd_sc_hd__dfxtp_1
Xnetwork.neuron_in188.counter\[0\]$_DFFE_PP_ clknet_leaf_208_clk
+ _02816_ _01319_ VSS VSS VDD VDD network.neuron_in188.counter\[0\]
+ sky130_fd_sc_hd__edfxtp_1
Xnetwork.neuron_in188.counter\[1\]$_DFFE_PP_ clknet_leaf_208_clk
+ _02817_ _01319_ VSS VSS VDD VDD network.neuron_in188.counter\[1\]
+ sky130_fd_sc_hd__edfxtp_1
Xnetwork.neuron_in188.counter\[2\]$_DFFE_PP_ clknet_leaf_208_clk
+ _02818_ _01319_ VSS VSS VDD VDD network.neuron_in188.counter\[2\]
+ sky130_fd_sc_hd__edfxtp_1
Xnetwork.neuron_in188.counter\[3\]$_DFFE_PP_ clknet_leaf_198_clk
+ _02819_ _01319_ VSS VSS VDD VDD network.neuron_in188.counter\[3\]
+ sky130_fd_sc_hd__edfxtp_1
Xnetwork.neuron_in188.spike$_SDFFE_PP0P_ clknet_leaf_199_clk
+ _01973_ VSS VSS VDD VDD network.in_spk12_11 sky130_fd_sc_hd__dfxtp_1
Xnetwork.neuron_in189.counter\[0\]$_DFFE_PP_ clknet_leaf_197_clk
+ _02820_ _01318_ VSS VSS VDD VDD network.neuron_in189.counter\[0\]
+ sky130_fd_sc_hd__edfxtp_1
Xnetwork.neuron_in189.counter\[1\]$_DFFE_PP_ clknet_leaf_198_clk
+ _02821_ _01318_ VSS VSS VDD VDD network.neuron_in189.counter\[1\]
+ sky130_fd_sc_hd__edfxtp_1
Xnetwork.neuron_in189.counter\[2\]$_DFFE_PP_ clknet_leaf_198_clk
+ _02822_ _01318_ VSS VSS VDD VDD network.neuron_in189.counter\[2\]
+ sky130_fd_sc_hd__edfxtp_1
Xnetwork.neuron_in189.counter\[3\]$_DFFE_PP_ clknet_leaf_197_clk
+ _02823_ _01318_ VSS VSS VDD VDD network.neuron_in189.counter\[3\]
+ sky130_fd_sc_hd__edfxtp_1
Xnetwork.neuron_in189.spike$_SDFFE_PP0P_ clknet_leaf_199_clk
+ _01972_ VSS VSS VDD VDD network.in_spk13_11 sky130_fd_sc_hd__dfxtp_1
Xnetwork.neuron_in190.counter\[0\]$_DFFE_PP_ clknet_leaf_200_clk
+ _02824_ _01317_ VSS VSS VDD VDD network.neuron_in190.counter\[0\]
+ sky130_fd_sc_hd__edfxtp_1
Xnetwork.neuron_in190.counter\[1\]$_DFFE_PP_ clknet_leaf_200_clk
+ _02825_ _01317_ VSS VSS VDD VDD network.neuron_in190.counter\[1\]
+ sky130_fd_sc_hd__edfxtp_1
Xnetwork.neuron_in190.counter\[2\]$_DFFE_PP_ clknet_leaf_201_clk
+ _02826_ _01317_ VSS VSS VDD VDD network.neuron_in190.counter\[2\]
+ sky130_fd_sc_hd__edfxtp_1
Xnetwork.neuron_in190.counter\[3\]$_DFFE_PP_ clknet_leaf_200_clk
+ _02827_ _01317_ VSS VSS VDD VDD network.neuron_in190.counter\[3\]
+ sky130_fd_sc_hd__edfxtp_1
Xnetwork.neuron_in190.spike$_SDFFE_PP0P_ clknet_leaf_199_clk
+ _01971_ VSS VSS VDD VDD network.in_spk14_11 sky130_fd_sc_hd__dfxtp_1
Xnetwork.neuron_in191.counter\[0\]$_DFFE_PP_ clknet_leaf_197_clk
+ _02828_ _01316_ VSS VSS VDD VDD network.neuron_in191.counter\[0\]
+ sky130_fd_sc_hd__edfxtp_1
Xnetwork.neuron_in191.counter\[1\]$_DFFE_PP_ clknet_leaf_196_clk
+ _02829_ _01316_ VSS VSS VDD VDD network.neuron_in191.counter\[1\]
+ sky130_fd_sc_hd__edfxtp_1
Xnetwork.neuron_in191.counter\[2\]$_DFFE_PP_ clknet_leaf_195_clk
+ _02830_ _01316_ VSS VSS VDD VDD network.neuron_in191.counter\[2\]
+ sky130_fd_sc_hd__edfxtp_1
Xnetwork.neuron_in191.counter\[3\]$_DFFE_PP_ clknet_leaf_200_clk
+ _02831_ _01316_ VSS VSS VDD VDD network.neuron_in191.counter\[3\]
+ sky130_fd_sc_hd__edfxtp_1
Xnetwork.neuron_in191.spike$_SDFFE_PP0P_ clknet_leaf_200_clk
+ _01970_ VSS VSS VDD VDD network.in_spk15_11 sky130_fd_sc_hd__dfxtp_1
Xnetwork.neuron_in192.counter\[0\]$_DFFE_PP_ clknet_leaf_111_clk
+ _02832_ _01315_ VSS VSS VDD VDD network.neuron_in192.counter\[0\]
+ sky130_fd_sc_hd__edfxtp_1
Xnetwork.neuron_in192.counter\[1\]$_DFFE_PP_ clknet_leaf_111_clk
+ _02833_ _01315_ VSS VSS VDD VDD network.neuron_in192.counter\[1\]
+ sky130_fd_sc_hd__edfxtp_1
Xnetwork.neuron_in192.counter\[2\]$_DFFE_PP_ clknet_leaf_112_clk
+ _02834_ _01315_ VSS VSS VDD VDD network.neuron_in192.counter\[2\]
+ sky130_fd_sc_hd__edfxtp_1
Xnetwork.neuron_in192.counter\[3\]$_DFFE_PP_ clknet_leaf_112_clk
+ _02835_ _01315_ VSS VSS VDD VDD network.neuron_in192.counter\[3\]
+ sky130_fd_sc_hd__edfxtp_1
Xnetwork.neuron_in192.spike$_SDFFE_PP0P_ clknet_leaf_108_clk
+ _01969_ VSS VSS VDD VDD network.in_spk00_12 sky130_fd_sc_hd__dfxtp_1
Xnetwork.neuron_in193.counter\[0\]$_DFFE_PP_ clknet_leaf_110_clk
+ _02836_ _01314_ VSS VSS VDD VDD network.neuron_in193.counter\[0\]
+ sky130_fd_sc_hd__edfxtp_1
Xnetwork.neuron_in193.counter\[1\]$_DFFE_PP_ clknet_leaf_110_clk
+ _02837_ _01314_ VSS VSS VDD VDD network.neuron_in193.counter\[1\]
+ sky130_fd_sc_hd__edfxtp_1
Xnetwork.neuron_in193.counter\[2\]$_DFFE_PP_ clknet_leaf_123_clk
+ _02838_ _01314_ VSS VSS VDD VDD network.neuron_in193.counter\[2\]
+ sky130_fd_sc_hd__edfxtp_1
Xnetwork.neuron_in193.counter\[3\]$_DFFE_PP_ clknet_leaf_123_clk
+ _02839_ _01314_ VSS VSS VDD VDD network.neuron_in193.counter\[3\]
+ sky130_fd_sc_hd__edfxtp_1
Xnetwork.neuron_in193.spike$_SDFFE_PP0P_ clknet_leaf_108_clk
+ _01968_ VSS VSS VDD VDD network.in_spk01_12 sky130_fd_sc_hd__dfxtp_1
Xnetwork.neuron_in194.counter\[0\]$_DFFE_PP_ clknet_leaf_110_clk
+ _02840_ _01313_ VSS VSS VDD VDD network.neuron_in194.counter\[0\]
+ sky130_fd_sc_hd__edfxtp_1
Xnetwork.neuron_in194.counter\[1\]$_DFFE_PP_ clknet_leaf_110_clk
+ _02841_ _01313_ VSS VSS VDD VDD network.neuron_in194.counter\[1\]
+ sky130_fd_sc_hd__edfxtp_1
Xnetwork.neuron_in194.counter\[2\]$_DFFE_PP_ clknet_leaf_109_clk
+ _02842_ _01313_ VSS VSS VDD VDD network.neuron_in194.counter\[2\]
+ sky130_fd_sc_hd__edfxtp_1
Xnetwork.neuron_in194.counter\[3\]$_DFFE_PP_ clknet_leaf_110_clk
+ _02843_ _01313_ VSS VSS VDD VDD network.neuron_in194.counter\[3\]
+ sky130_fd_sc_hd__edfxtp_1
Xnetwork.neuron_in194.spike$_SDFFE_PP0P_ clknet_leaf_107_clk
+ _01967_ VSS VSS VDD VDD network.in_spk02_12 sky130_fd_sc_hd__dfxtp_1
Xnetwork.neuron_in195.counter\[0\]$_DFFE_PP_ clknet_leaf_109_clk
+ _02844_ _01312_ VSS VSS VDD VDD network.neuron_in195.counter\[0\]
+ sky130_fd_sc_hd__edfxtp_1
Xnetwork.neuron_in195.counter\[1\]$_DFFE_PP_ clknet_leaf_109_clk
+ _02845_ _01312_ VSS VSS VDD VDD network.neuron_in195.counter\[1\]
+ sky130_fd_sc_hd__edfxtp_1
Xnetwork.neuron_in195.counter\[2\]$_DFFE_PP_ clknet_leaf_108_clk
+ _02846_ _01312_ VSS VSS VDD VDD network.neuron_in195.counter\[2\]
+ sky130_fd_sc_hd__edfxtp_1
Xnetwork.neuron_in195.counter\[3\]$_DFFE_PP_ clknet_leaf_108_clk
+ _02847_ _01312_ VSS VSS VDD VDD network.neuron_in195.counter\[3\]
+ sky130_fd_sc_hd__edfxtp_1
Xnetwork.neuron_in195.spike$_SDFFE_PP0P_ clknet_leaf_147_clk
+ _01966_ VSS VSS VDD VDD network.in_spk03_12 sky130_fd_sc_hd__dfxtp_1
Xnetwork.neuron_in196.counter\[0\]$_DFFE_PP_ clknet_leaf_141_clk
+ _02848_ _01311_ VSS VSS VDD VDD network.neuron_in196.counter\[0\]
+ sky130_fd_sc_hd__edfxtp_1
Xnetwork.neuron_in196.counter\[1\]$_DFFE_PP_ clknet_leaf_141_clk
+ _02849_ _01311_ VSS VSS VDD VDD network.neuron_in196.counter\[1\]
+ sky130_fd_sc_hd__edfxtp_1
Xnetwork.neuron_in196.counter\[2\]$_DFFE_PP_ clknet_leaf_141_clk
+ _02850_ _01311_ VSS VSS VDD VDD network.neuron_in196.counter\[2\]
+ sky130_fd_sc_hd__edfxtp_1
Xnetwork.neuron_in196.counter\[3\]$_DFFE_PP_ clknet_leaf_146_clk
+ _02851_ _01311_ VSS VSS VDD VDD network.neuron_in196.counter\[3\]
+ sky130_fd_sc_hd__edfxtp_1
Xnetwork.neuron_in196.spike$_SDFFE_PP0P_ clknet_leaf_147_clk
+ _01965_ VSS VSS VDD VDD network.in_spk04_12 sky130_fd_sc_hd__dfxtp_1
Xnetwork.neuron_in197.counter\[0\]$_DFFE_PP_ clknet_leaf_141_clk
+ _02852_ _01310_ VSS VSS VDD VDD network.neuron_in197.counter\[0\]
+ sky130_fd_sc_hd__edfxtp_1
Xnetwork.neuron_in197.counter\[1\]$_DFFE_PP_ clknet_leaf_141_clk
+ _02853_ _01310_ VSS VSS VDD VDD network.neuron_in197.counter\[1\]
+ sky130_fd_sc_hd__edfxtp_1
Xnetwork.neuron_in197.counter\[2\]$_DFFE_PP_ clknet_leaf_141_clk
+ _02854_ _01310_ VSS VSS VDD VDD network.neuron_in197.counter\[2\]
+ sky130_fd_sc_hd__edfxtp_1
Xnetwork.neuron_in197.counter\[3\]$_DFFE_PP_ clknet_leaf_141_clk
+ _02855_ _01310_ VSS VSS VDD VDD network.neuron_in197.counter\[3\]
+ sky130_fd_sc_hd__edfxtp_1
Xnetwork.neuron_in197.spike$_SDFFE_PP0P_ clknet_leaf_147_clk
+ _01964_ VSS VSS VDD VDD network.in_spk05_12 sky130_fd_sc_hd__dfxtp_1
Xnetwork.neuron_in198.counter\[0\]$_DFFE_PP_ clknet_leaf_145_clk
+ _02856_ _01309_ VSS VSS VDD VDD network.neuron_in198.counter\[0\]
+ sky130_fd_sc_hd__edfxtp_1
Xnetwork.neuron_in198.counter\[1\]$_DFFE_PP_ clknet_leaf_145_clk
+ _02857_ _01309_ VSS VSS VDD VDD network.neuron_in198.counter\[1\]
+ sky130_fd_sc_hd__edfxtp_1
Xnetwork.neuron_in198.counter\[2\]$_DFFE_PP_ clknet_leaf_145_clk
+ _02858_ _01309_ VSS VSS VDD VDD network.neuron_in198.counter\[2\]
+ sky130_fd_sc_hd__edfxtp_1
Xnetwork.neuron_in198.counter\[3\]$_DFFE_PP_ clknet_leaf_145_clk
+ _02859_ _01309_ VSS VSS VDD VDD network.neuron_in198.counter\[3\]
+ sky130_fd_sc_hd__edfxtp_1
Xnetwork.neuron_in198.spike$_SDFFE_PP0P_ clknet_leaf_147_clk
+ _01963_ VSS VSS VDD VDD network.in_spk06_12 sky130_fd_sc_hd__dfxtp_1
Xnetwork.neuron_in199.counter\[0\]$_DFFE_PP_ clknet_leaf_144_clk
+ _02860_ _01308_ VSS VSS VDD VDD network.neuron_in199.counter\[0\]
+ sky130_fd_sc_hd__edfxtp_1
Xnetwork.neuron_in199.counter\[1\]$_DFFE_PP_ clknet_leaf_144_clk
+ _02861_ _01308_ VSS VSS VDD VDD network.neuron_in199.counter\[1\]
+ sky130_fd_sc_hd__edfxtp_1
Xnetwork.neuron_in199.counter\[2\]$_DFFE_PP_ clknet_leaf_144_clk
+ _02862_ _01308_ VSS VSS VDD VDD network.neuron_in199.counter\[2\]
+ sky130_fd_sc_hd__edfxtp_1
Xnetwork.neuron_in199.counter\[3\]$_DFFE_PP_ clknet_leaf_145_clk
+ _02863_ _01308_ VSS VSS VDD VDD network.neuron_in199.counter\[3\]
+ sky130_fd_sc_hd__edfxtp_1
Xnetwork.neuron_in199.spike$_SDFFE_PP0P_ clknet_leaf_147_clk
+ _01962_ VSS VSS VDD VDD network.in_spk07_12 sky130_fd_sc_hd__dfxtp_1
Xnetwork.neuron_in200.counter\[0\]$_DFFE_PP_ clknet_leaf_149_clk
+ _02864_ _01307_ VSS VSS VDD VDD network.neuron_in200.counter\[0\]
+ sky130_fd_sc_hd__edfxtp_1
Xnetwork.neuron_in200.counter\[1\]$_DFFE_PP_ clknet_leaf_149_clk
+ _02865_ _01307_ VSS VSS VDD VDD network.neuron_in200.counter\[1\]
+ sky130_fd_sc_hd__edfxtp_1
Xnetwork.neuron_in200.counter\[2\]$_DFFE_PP_ clknet_leaf_146_clk
+ _02866_ _01307_ VSS VSS VDD VDD network.neuron_in200.counter\[2\]
+ sky130_fd_sc_hd__edfxtp_1
Xnetwork.neuron_in200.counter\[3\]$_DFFE_PP_ clknet_leaf_146_clk
+ _02867_ _01307_ VSS VSS VDD VDD network.neuron_in200.counter\[3\]
+ sky130_fd_sc_hd__edfxtp_1
Xnetwork.neuron_in200.spike$_SDFFE_PP0P_ clknet_leaf_147_clk
+ _01961_ VSS VSS VDD VDD network.in_spk08_12 sky130_fd_sc_hd__dfxtp_1
Xnetwork.neuron_in201.counter\[0\]$_DFFE_PP_ clknet_leaf_148_clk
+ _02868_ _01306_ VSS VSS VDD VDD network.neuron_in201.counter\[0\]
+ sky130_fd_sc_hd__edfxtp_1
Xnetwork.neuron_in201.counter\[1\]$_DFFE_PP_ clknet_leaf_148_clk
+ _02869_ _01306_ VSS VSS VDD VDD network.neuron_in201.counter\[1\]
+ sky130_fd_sc_hd__edfxtp_1
Xnetwork.neuron_in201.counter\[2\]$_DFFE_PP_ clknet_leaf_148_clk
+ _02870_ _01306_ VSS VSS VDD VDD network.neuron_in201.counter\[2\]
+ sky130_fd_sc_hd__edfxtp_1
Xnetwork.neuron_in201.counter\[3\]$_DFFE_PP_ clknet_leaf_148_clk
+ _02871_ _01306_ VSS VSS VDD VDD network.neuron_in201.counter\[3\]
+ sky130_fd_sc_hd__edfxtp_1
Xnetwork.neuron_in201.spike$_SDFFE_PP0P_ clknet_leaf_147_clk
+ _01960_ VSS VSS VDD VDD network.in_spk09_12 sky130_fd_sc_hd__dfxtp_1
Xnetwork.neuron_in202.counter\[0\]$_DFFE_PP_ clknet_leaf_111_clk
+ _02872_ _01305_ VSS VSS VDD VDD network.neuron_in202.counter\[0\]
+ sky130_fd_sc_hd__edfxtp_1
Xnetwork.neuron_in202.counter\[1\]$_DFFE_PP_ clknet_leaf_111_clk
+ _02873_ _01305_ VSS VSS VDD VDD network.neuron_in202.counter\[1\]
+ sky130_fd_sc_hd__edfxtp_1
Xnetwork.neuron_in202.counter\[2\]$_DFFE_PP_ clknet_leaf_108_clk
+ _02874_ _01305_ VSS VSS VDD VDD network.neuron_in202.counter\[2\]
+ sky130_fd_sc_hd__edfxtp_1
Xnetwork.neuron_in202.counter\[3\]$_DFFE_PP_ clknet_leaf_111_clk
+ _02875_ _01305_ VSS VSS VDD VDD network.neuron_in202.counter\[3\]
+ sky130_fd_sc_hd__edfxtp_1
Xnetwork.neuron_in202.spike$_SDFFE_PP0P_ clknet_leaf_147_clk
+ _01959_ VSS VSS VDD VDD network.in_spk10_12 sky130_fd_sc_hd__dfxtp_1
Xnetwork.neuron_in203.counter\[0\]$_DFFE_PP_ clknet_leaf_149_clk
+ _02876_ _01304_ VSS VSS VDD VDD network.neuron_in203.counter\[0\]
+ sky130_fd_sc_hd__edfxtp_1
Xnetwork.neuron_in203.counter\[1\]$_DFFE_PP_ clknet_leaf_149_clk
+ _02877_ _01304_ VSS VSS VDD VDD network.neuron_in203.counter\[1\]
+ sky130_fd_sc_hd__edfxtp_1
Xnetwork.neuron_in203.counter\[2\]$_DFFE_PP_ clknet_leaf_150_clk
+ _02878_ _01304_ VSS VSS VDD VDD network.neuron_in203.counter\[2\]
+ sky130_fd_sc_hd__edfxtp_1
Xnetwork.neuron_in203.counter\[3\]$_DFFE_PP_ clknet_leaf_150_clk
+ _02879_ _01304_ VSS VSS VDD VDD network.neuron_in203.counter\[3\]
+ sky130_fd_sc_hd__edfxtp_1
Xnetwork.neuron_in203.spike$_SDFFE_PP0P_ clknet_leaf_153_clk
+ _01957_ VSS VSS VDD VDD network.in_spk11_12 sky130_fd_sc_hd__dfxtp_1
Xnetwork.neuron_in204.counter\[0\]$_DFFE_PP_ clknet_leaf_152_clk
+ _02880_ _01303_ VSS VSS VDD VDD network.neuron_in204.counter\[0\]
+ sky130_fd_sc_hd__edfxtp_1
Xnetwork.neuron_in204.counter\[1\]$_DFFE_PP_ clknet_leaf_152_clk
+ _02881_ _01303_ VSS VSS VDD VDD network.neuron_in204.counter\[1\]
+ sky130_fd_sc_hd__edfxtp_1
Xnetwork.neuron_in204.counter\[2\]$_DFFE_PP_ clknet_leaf_152_clk
+ _02882_ _01303_ VSS VSS VDD VDD network.neuron_in204.counter\[2\]
+ sky130_fd_sc_hd__edfxtp_1
Xnetwork.neuron_in204.counter\[3\]$_DFFE_PP_ clknet_leaf_152_clk
+ _02883_ _01303_ VSS VSS VDD VDD network.neuron_in204.counter\[3\]
+ sky130_fd_sc_hd__edfxtp_1
Xnetwork.neuron_in204.spike$_SDFFE_PP0P_ clknet_leaf_153_clk
+ _01953_ VSS VSS VDD VDD network.in_spk12_12 sky130_fd_sc_hd__dfxtp_1
Xnetwork.neuron_in205.counter\[0\]$_DFFE_PP_ clknet_leaf_102_clk
+ _02884_ _01302_ VSS VSS VDD VDD network.neuron_in205.counter\[0\]
+ sky130_fd_sc_hd__edfxtp_1
Xnetwork.neuron_in205.counter\[1\]$_DFFE_PP_ clknet_leaf_153_clk
+ _02885_ _01302_ VSS VSS VDD VDD network.neuron_in205.counter\[1\]
+ sky130_fd_sc_hd__edfxtp_1
Xnetwork.neuron_in205.counter\[2\]$_DFFE_PP_ clknet_leaf_153_clk
+ _02886_ _01302_ VSS VSS VDD VDD network.neuron_in205.counter\[2\]
+ sky130_fd_sc_hd__edfxtp_1
Xnetwork.neuron_in205.counter\[3\]$_DFFE_PP_ clknet_leaf_153_clk
+ _02887_ _01302_ VSS VSS VDD VDD network.neuron_in205.counter\[3\]
+ sky130_fd_sc_hd__edfxtp_1
Xnetwork.neuron_in205.spike$_SDFFE_PP0P_ clknet_leaf_103_clk
+ _01949_ VSS VSS VDD VDD network.in_spk13_12 sky130_fd_sc_hd__dfxtp_1
Xnetwork.neuron_in206.counter\[0\]$_DFFE_PP_ clknet_leaf_107_clk
+ _02888_ _01301_ VSS VSS VDD VDD network.neuron_in206.counter\[0\]
+ sky130_fd_sc_hd__edfxtp_1
Xnetwork.neuron_in206.counter\[1\]$_DFFE_PP_ clknet_leaf_106_clk
+ _02889_ _01301_ VSS VSS VDD VDD network.neuron_in206.counter\[1\]
+ sky130_fd_sc_hd__edfxtp_1
Xnetwork.neuron_in206.counter\[2\]$_DFFE_PP_ clknet_leaf_106_clk
+ _02890_ _01301_ VSS VSS VDD VDD network.neuron_in206.counter\[2\]
+ sky130_fd_sc_hd__edfxtp_1
Xnetwork.neuron_in206.counter\[3\]$_DFFE_PP_ clknet_leaf_106_clk
+ _02891_ _01301_ VSS VSS VDD VDD network.neuron_in206.counter\[3\]
+ sky130_fd_sc_hd__edfxtp_1
Xnetwork.neuron_in206.spike$_SDFFE_PP0P_ clknet_leaf_107_clk
+ _01946_ VSS VSS VDD VDD network.in_spk14_12 sky130_fd_sc_hd__dfxtp_1
Xnetwork.neuron_in207.counter\[0\]$_DFFE_PP_ clknet_leaf_103_clk
+ _02892_ _01300_ VSS VSS VDD VDD network.neuron_in207.counter\[0\]
+ sky130_fd_sc_hd__edfxtp_1
Xnetwork.neuron_in207.counter\[1\]$_DFFE_PP_ clknet_leaf_103_clk
+ _02893_ _01300_ VSS VSS VDD VDD network.neuron_in207.counter\[1\]
+ sky130_fd_sc_hd__edfxtp_1
Xnetwork.neuron_in207.counter\[2\]$_DFFE_PP_ clknet_leaf_102_clk
+ _02894_ _01300_ VSS VSS VDD VDD network.neuron_in207.counter\[2\]
+ sky130_fd_sc_hd__edfxtp_1
Xnetwork.neuron_in207.counter\[3\]$_DFFE_PP_ clknet_leaf_102_clk
+ _02895_ _01300_ VSS VSS VDD VDD network.neuron_in207.counter\[3\]
+ sky130_fd_sc_hd__edfxtp_1
Xnetwork.neuron_in207.spike$_SDFFE_PP0P_ clknet_leaf_103_clk
+ _01944_ VSS VSS VDD VDD network.in_spk15_12 sky130_fd_sc_hd__dfxtp_1
Xnetwork.neuron_in208.counter\[0\]$_DFFE_PP_ clknet_leaf_103_clk
+ _02896_ _01299_ VSS VSS VDD VDD network.neuron_in208.counter\[0\]
+ sky130_fd_sc_hd__edfxtp_1
Xnetwork.neuron_in208.counter\[1\]$_DFFE_PP_ clknet_leaf_103_clk
+ _02897_ _01299_ VSS VSS VDD VDD network.neuron_in208.counter\[1\]
+ sky130_fd_sc_hd__edfxtp_1
Xnetwork.neuron_in208.counter\[2\]$_DFFE_PP_ clknet_leaf_103_clk
+ _02898_ _01299_ VSS VSS VDD VDD network.neuron_in208.counter\[2\]
+ sky130_fd_sc_hd__edfxtp_1
Xnetwork.neuron_in208.counter\[3\]$_DFFE_PP_ clknet_leaf_103_clk
+ _02899_ _01299_ VSS VSS VDD VDD network.neuron_in208.counter\[3\]
+ sky130_fd_sc_hd__edfxtp_1
Xnetwork.neuron_in208.spike$_SDFFE_PP0P_ clknet_leaf_107_clk
+ _01941_ VSS VSS VDD VDD network.in_spk00_13 sky130_fd_sc_hd__dfxtp_1
Xnetwork.neuron_in209.counter\[0\]$_DFFE_PP_ clknet_leaf_117_clk
+ _02900_ _01298_ VSS VSS VDD VDD network.neuron_in209.counter\[0\]
+ sky130_fd_sc_hd__edfxtp_1
Xnetwork.neuron_in209.counter\[1\]$_DFFE_PP_ clknet_leaf_117_clk
+ _02901_ _01298_ VSS VSS VDD VDD network.neuron_in209.counter\[1\]
+ sky130_fd_sc_hd__edfxtp_1
Xnetwork.neuron_in209.counter\[2\]$_DFFE_PP_ clknet_leaf_112_clk
+ _02902_ _01298_ VSS VSS VDD VDD network.neuron_in209.counter\[2\]
+ sky130_fd_sc_hd__edfxtp_1
Xnetwork.neuron_in209.counter\[3\]$_DFFE_PP_ clknet_leaf_117_clk
+ _02903_ _01298_ VSS VSS VDD VDD network.neuron_in209.counter\[3\]
+ sky130_fd_sc_hd__edfxtp_1
Xnetwork.neuron_in209.spike$_SDFFE_PP0P_ clknet_leaf_106_clk
+ _01937_ VSS VSS VDD VDD network.in_spk01_13 sky130_fd_sc_hd__dfxtp_1
Xnetwork.neuron_in210.counter\[0\]$_DFFE_PP_ clknet_leaf_122_clk
+ _02904_ _01297_ VSS VSS VDD VDD network.neuron_in210.counter\[0\]
+ sky130_fd_sc_hd__edfxtp_1
Xnetwork.neuron_in210.counter\[1\]$_DFFE_PP_ clknet_leaf_122_clk
+ _02905_ _01297_ VSS VSS VDD VDD network.neuron_in210.counter\[1\]
+ sky130_fd_sc_hd__edfxtp_1
Xnetwork.neuron_in210.counter\[2\]$_DFFE_PP_ clknet_leaf_122_clk
+ _02906_ _01297_ VSS VSS VDD VDD network.neuron_in210.counter\[2\]
+ sky130_fd_sc_hd__edfxtp_1
Xnetwork.neuron_in210.counter\[3\]$_DFFE_PP_ clknet_leaf_122_clk
+ _02907_ _01297_ VSS VSS VDD VDD network.neuron_in210.counter\[3\]
+ sky130_fd_sc_hd__edfxtp_1
Xnetwork.neuron_in210.spike$_SDFFE_PP0P_ clknet_leaf_106_clk
+ _01932_ VSS VSS VDD VDD network.in_spk02_13 sky130_fd_sc_hd__dfxtp_1
Xnetwork.neuron_in211.counter\[0\]$_DFFE_PP_ clknet_leaf_119_clk
+ _02908_ _01296_ VSS VSS VDD VDD network.neuron_in211.counter\[0\]
+ sky130_fd_sc_hd__edfxtp_1
Xnetwork.neuron_in211.counter\[1\]$_DFFE_PP_ clknet_leaf_119_clk
+ _02909_ _01296_ VSS VSS VDD VDD network.neuron_in211.counter\[1\]
+ sky130_fd_sc_hd__edfxtp_1
Xnetwork.neuron_in211.counter\[2\]$_DFFE_PP_ clknet_leaf_122_clk
+ _02910_ _01296_ VSS VSS VDD VDD network.neuron_in211.counter\[2\]
+ sky130_fd_sc_hd__edfxtp_1
Xnetwork.neuron_in211.counter\[3\]$_DFFE_PP_ clknet_leaf_122_clk
+ _02911_ _01296_ VSS VSS VDD VDD network.neuron_in211.counter\[3\]
+ sky130_fd_sc_hd__edfxtp_1
Xnetwork.neuron_in211.spike$_SDFFE_PP0P_ clknet_leaf_106_clk
+ _01928_ VSS VSS VDD VDD network.in_spk03_13 sky130_fd_sc_hd__dfxtp_1
Xnetwork.neuron_in212.counter\[0\]$_DFFE_PP_ clknet_leaf_118_clk
+ _02912_ _01295_ VSS VSS VDD VDD network.neuron_in212.counter\[0\]
+ sky130_fd_sc_hd__edfxtp_1
Xnetwork.neuron_in212.counter\[1\]$_DFFE_PP_ clknet_leaf_119_clk
+ _02913_ _01295_ VSS VSS VDD VDD network.neuron_in212.counter\[1\]
+ sky130_fd_sc_hd__edfxtp_1
Xnetwork.neuron_in212.counter\[2\]$_DFFE_PP_ clknet_leaf_118_clk
+ _02914_ _01295_ VSS VSS VDD VDD network.neuron_in212.counter\[2\]
+ sky130_fd_sc_hd__edfxtp_1
Xnetwork.neuron_in212.counter\[3\]$_DFFE_PP_ clknet_leaf_119_clk
+ _02915_ _01295_ VSS VSS VDD VDD network.neuron_in212.counter\[3\]
+ sky130_fd_sc_hd__edfxtp_1
Xnetwork.neuron_in212.spike$_SDFFE_PP0P_ clknet_leaf_113_clk
+ _01923_ VSS VSS VDD VDD network.in_spk04_13 sky130_fd_sc_hd__dfxtp_1
Xnetwork.neuron_in213.counter\[0\]$_DFFE_PP_ clknet_leaf_118_clk
+ _02916_ _01294_ VSS VSS VDD VDD network.neuron_in213.counter\[0\]
+ sky130_fd_sc_hd__edfxtp_1
Xnetwork.neuron_in213.counter\[1\]$_DFFE_PP_ clknet_leaf_118_clk
+ _02917_ _01294_ VSS VSS VDD VDD network.neuron_in213.counter\[1\]
+ sky130_fd_sc_hd__edfxtp_1
Xnetwork.neuron_in213.counter\[2\]$_DFFE_PP_ clknet_leaf_118_clk
+ _02918_ _01294_ VSS VSS VDD VDD network.neuron_in213.counter\[2\]
+ sky130_fd_sc_hd__edfxtp_1
Xnetwork.neuron_in213.counter\[3\]$_DFFE_PP_ clknet_leaf_118_clk
+ _02919_ _01294_ VSS VSS VDD VDD network.neuron_in213.counter\[3\]
+ sky130_fd_sc_hd__edfxtp_1
Xnetwork.neuron_in213.spike$_SDFFE_PP0P_ clknet_leaf_114_clk
+ _01918_ VSS VSS VDD VDD network.in_spk05_13 sky130_fd_sc_hd__dfxtp_1
Xnetwork.neuron_in214.counter\[0\]$_DFFE_PP_ clknet_leaf_112_clk
+ _02920_ _01293_ VSS VSS VDD VDD network.neuron_in214.counter\[0\]
+ sky130_fd_sc_hd__edfxtp_1
Xnetwork.neuron_in214.counter\[1\]$_DFFE_PP_ clknet_leaf_113_clk
+ _02921_ _01293_ VSS VSS VDD VDD network.neuron_in214.counter\[1\]
+ sky130_fd_sc_hd__edfxtp_1
Xnetwork.neuron_in214.counter\[2\]$_DFFE_PP_ clknet_leaf_113_clk
+ _02922_ _01293_ VSS VSS VDD VDD network.neuron_in214.counter\[2\]
+ sky130_fd_sc_hd__edfxtp_1
Xnetwork.neuron_in214.counter\[3\]$_DFFE_PP_ clknet_leaf_113_clk
+ _02923_ _01293_ VSS VSS VDD VDD network.neuron_in214.counter\[3\]
+ sky130_fd_sc_hd__edfxtp_1
Xnetwork.neuron_in214.spike$_SDFFE_PP0P_ clknet_leaf_106_clk
+ _01913_ VSS VSS VDD VDD network.in_spk06_13 sky130_fd_sc_hd__dfxtp_1
Xnetwork.neuron_in215.counter\[0\]$_DFFE_PP_ clknet_leaf_117_clk
+ _02924_ _01292_ VSS VSS VDD VDD network.neuron_in215.counter\[0\]
+ sky130_fd_sc_hd__edfxtp_1
Xnetwork.neuron_in215.counter\[1\]$_DFFE_PP_ clknet_leaf_113_clk
+ _02925_ _01292_ VSS VSS VDD VDD network.neuron_in215.counter\[1\]
+ sky130_fd_sc_hd__edfxtp_1
Xnetwork.neuron_in215.counter\[2\]$_DFFE_PP_ clknet_leaf_114_clk
+ _02926_ _01292_ VSS VSS VDD VDD network.neuron_in215.counter\[2\]
+ sky130_fd_sc_hd__edfxtp_1
Xnetwork.neuron_in215.counter\[3\]$_DFFE_PP_ clknet_leaf_113_clk
+ _02927_ _01292_ VSS VSS VDD VDD network.neuron_in215.counter\[3\]
+ sky130_fd_sc_hd__edfxtp_1
Xnetwork.neuron_in215.spike$_SDFFE_PP0P_ clknet_leaf_105_clk
+ _01909_ VSS VSS VDD VDD network.in_spk07_13 sky130_fd_sc_hd__dfxtp_1
Xnetwork.neuron_in216.counter\[0\]$_DFFE_PP_ clknet_leaf_116_clk
+ _02928_ _01291_ VSS VSS VDD VDD network.neuron_in216.counter\[0\]
+ sky130_fd_sc_hd__edfxtp_1
Xnetwork.neuron_in216.counter\[1\]$_DFFE_PP_ clknet_leaf_116_clk
+ _02929_ _01291_ VSS VSS VDD VDD network.neuron_in216.counter\[1\]
+ sky130_fd_sc_hd__edfxtp_1
Xnetwork.neuron_in216.counter\[2\]$_DFFE_PP_ clknet_leaf_116_clk
+ _02930_ _01291_ VSS VSS VDD VDD network.neuron_in216.counter\[2\]
+ sky130_fd_sc_hd__edfxtp_1
Xnetwork.neuron_in216.counter\[3\]$_DFFE_PP_ clknet_leaf_116_clk
+ _02931_ _01291_ VSS VSS VDD VDD network.neuron_in216.counter\[3\]
+ sky130_fd_sc_hd__edfxtp_1
Xnetwork.neuron_in216.spike$_SDFFE_PP0P_ clknet_leaf_105_clk
+ _01904_ VSS VSS VDD VDD network.in_spk08_13 sky130_fd_sc_hd__dfxtp_1
Xnetwork.neuron_in217.counter\[0\]$_DFFE_PP_ clknet_leaf_105_clk
+ _02932_ _01290_ VSS VSS VDD VDD network.neuron_in217.counter\[0\]
+ sky130_fd_sc_hd__edfxtp_1
Xnetwork.neuron_in217.counter\[1\]$_DFFE_PP_ clknet_leaf_105_clk
+ _02933_ _01290_ VSS VSS VDD VDD network.neuron_in217.counter\[1\]
+ sky130_fd_sc_hd__edfxtp_1
Xnetwork.neuron_in217.counter\[2\]$_DFFE_PP_ clknet_leaf_104_clk
+ _02934_ _01290_ VSS VSS VDD VDD network.neuron_in217.counter\[2\]
+ sky130_fd_sc_hd__edfxtp_1
Xnetwork.neuron_in217.counter\[3\]$_DFFE_PP_ clknet_leaf_104_clk
+ _02935_ _01290_ VSS VSS VDD VDD network.neuron_in217.counter\[3\]
+ sky130_fd_sc_hd__edfxtp_1
Xnetwork.neuron_in217.spike$_SDFFE_PP0P_ clknet_leaf_105_clk
+ _01899_ VSS VSS VDD VDD network.in_spk09_13 sky130_fd_sc_hd__dfxtp_1
Xnetwork.neuron_in218.counter\[0\]$_DFFE_PP_ clknet_leaf_114_clk
+ _02936_ _01289_ VSS VSS VDD VDD network.neuron_in218.counter\[0\]
+ sky130_fd_sc_hd__edfxtp_1
Xnetwork.neuron_in218.counter\[1\]$_DFFE_PP_ clknet_leaf_114_clk
+ _02937_ _01289_ VSS VSS VDD VDD network.neuron_in218.counter\[1\]
+ sky130_fd_sc_hd__edfxtp_1
Xnetwork.neuron_in218.counter\[2\]$_DFFE_PP_ clknet_leaf_114_clk
+ _02938_ _01289_ VSS VSS VDD VDD network.neuron_in218.counter\[2\]
+ sky130_fd_sc_hd__edfxtp_1
Xnetwork.neuron_in218.counter\[3\]$_DFFE_PP_ clknet_leaf_114_clk
+ _02939_ _01289_ VSS VSS VDD VDD network.neuron_in218.counter\[3\]
+ sky130_fd_sc_hd__edfxtp_1
Xnetwork.neuron_in218.spike$_SDFFE_PP0P_ clknet_leaf_105_clk
+ _01896_ VSS VSS VDD VDD network.in_spk10_13 sky130_fd_sc_hd__dfxtp_1
Xnetwork.neuron_in219.counter\[0\]$_DFFE_PP_ clknet_leaf_95_clk
+ _02940_ _01288_ VSS VSS VDD VDD network.neuron_in219.counter\[0\]
+ sky130_fd_sc_hd__edfxtp_1
Xnetwork.neuron_in219.counter\[1\]$_DFFE_PP_ clknet_leaf_95_clk
+ _02941_ _01288_ VSS VSS VDD VDD network.neuron_in219.counter\[1\]
+ sky130_fd_sc_hd__edfxtp_1
Xnetwork.neuron_in219.counter\[2\]$_DFFE_PP_ clknet_leaf_94_clk
+ _02942_ _01288_ VSS VSS VDD VDD network.neuron_in219.counter\[2\]
+ sky130_fd_sc_hd__edfxtp_1
Xnetwork.neuron_in219.counter\[3\]$_DFFE_PP_ clknet_leaf_94_clk
+ _02943_ _01288_ VSS VSS VDD VDD network.neuron_in219.counter\[3\]
+ sky130_fd_sc_hd__edfxtp_1
Xnetwork.neuron_in219.spike$_SDFFE_PP0P_ clknet_leaf_105_clk
+ _01893_ VSS VSS VDD VDD network.in_spk11_13 sky130_fd_sc_hd__dfxtp_1
Xnetwork.neuron_in220.counter\[0\]$_DFFE_PP_ clknet_leaf_100_clk
+ _02944_ _01287_ VSS VSS VDD VDD network.neuron_in220.counter\[0\]
+ sky130_fd_sc_hd__edfxtp_1
Xnetwork.neuron_in220.counter\[1\]$_DFFE_PP_ clknet_leaf_100_clk
+ _02945_ _01287_ VSS VSS VDD VDD network.neuron_in220.counter\[1\]
+ sky130_fd_sc_hd__edfxtp_1
Xnetwork.neuron_in220.counter\[2\]$_DFFE_PP_ clknet_leaf_101_clk
+ _02946_ _01287_ VSS VSS VDD VDD network.neuron_in220.counter\[2\]
+ sky130_fd_sc_hd__edfxtp_1
Xnetwork.neuron_in220.counter\[3\]$_DFFE_PP_ clknet_leaf_101_clk
+ _02947_ _01287_ VSS VSS VDD VDD network.neuron_in220.counter\[3\]
+ sky130_fd_sc_hd__edfxtp_1
Xnetwork.neuron_in220.spike$_SDFFE_PP0P_ clknet_leaf_104_clk
+ _01890_ VSS VSS VDD VDD network.in_spk12_13 sky130_fd_sc_hd__dfxtp_1
Xnetwork.neuron_in221.counter\[0\]$_DFFE_PP_ clknet_leaf_95_clk
+ _02948_ _01286_ VSS VSS VDD VDD network.neuron_in221.counter\[0\]
+ sky130_fd_sc_hd__edfxtp_1
Xnetwork.neuron_in221.counter\[1\]$_DFFE_PP_ clknet_leaf_95_clk
+ _02949_ _01286_ VSS VSS VDD VDD network.neuron_in221.counter\[1\]
+ sky130_fd_sc_hd__edfxtp_1
Xnetwork.neuron_in221.counter\[2\]$_DFFE_PP_ clknet_leaf_95_clk
+ _02950_ _01286_ VSS VSS VDD VDD network.neuron_in221.counter\[2\]
+ sky130_fd_sc_hd__edfxtp_1
Xnetwork.neuron_in221.counter\[3\]$_DFFE_PP_ clknet_leaf_95_clk
+ _02951_ _01286_ VSS VSS VDD VDD network.neuron_in221.counter\[3\]
+ sky130_fd_sc_hd__edfxtp_1
Xnetwork.neuron_in221.spike$_SDFFE_PP0P_ clknet_leaf_104_clk
+ _01887_ VSS VSS VDD VDD network.in_spk13_13 sky130_fd_sc_hd__dfxtp_1
Xnetwork.neuron_in222.counter\[0\]$_DFFE_PP_ clknet_leaf_98_clk
+ _02952_ _01285_ VSS VSS VDD VDD network.neuron_in222.counter\[0\]
+ sky130_fd_sc_hd__edfxtp_1
Xnetwork.neuron_in222.counter\[1\]$_DFFE_PP_ clknet_leaf_99_clk
+ _02953_ _01285_ VSS VSS VDD VDD network.neuron_in222.counter\[1\]
+ sky130_fd_sc_hd__edfxtp_1
Xnetwork.neuron_in222.counter\[2\]$_DFFE_PP_ clknet_leaf_96_clk
+ _02954_ _01285_ VSS VSS VDD VDD network.neuron_in222.counter\[2\]
+ sky130_fd_sc_hd__edfxtp_1
Xnetwork.neuron_in222.counter\[3\]$_DFFE_PP_ clknet_leaf_104_clk
+ _02955_ _01285_ VSS VSS VDD VDD network.neuron_in222.counter\[3\]
+ sky130_fd_sc_hd__edfxtp_1
Xnetwork.neuron_in222.spike$_SDFFE_PP0P_ clknet_leaf_104_clk
+ _01884_ VSS VSS VDD VDD network.in_spk14_13 sky130_fd_sc_hd__dfxtp_1
Xnetwork.neuron_in223.counter\[0\]$_DFFE_PP_ clknet_leaf_101_clk
+ _02956_ _01284_ VSS VSS VDD VDD network.neuron_in223.counter\[0\]
+ sky130_fd_sc_hd__edfxtp_1
Xnetwork.neuron_in223.counter\[1\]$_DFFE_PP_ clknet_leaf_102_clk
+ _02957_ _01284_ VSS VSS VDD VDD network.neuron_in223.counter\[1\]
+ sky130_fd_sc_hd__edfxtp_1
Xnetwork.neuron_in223.counter\[2\]$_DFFE_PP_ clknet_leaf_104_clk
+ _02958_ _01284_ VSS VSS VDD VDD network.neuron_in223.counter\[2\]
+ sky130_fd_sc_hd__edfxtp_1
Xnetwork.neuron_in223.counter\[3\]$_DFFE_PP_ clknet_leaf_101_clk
+ _02959_ _01284_ VSS VSS VDD VDD network.neuron_in223.counter\[3\]
+ sky130_fd_sc_hd__edfxtp_1
Xnetwork.neuron_in223.spike$_SDFFE_PP0P_ clknet_leaf_104_clk
+ _01881_ VSS VSS VDD VDD network.in_spk15_13 sky130_fd_sc_hd__dfxtp_1
Xnetwork.neuron_in224.counter\[0\]$_DFFE_PP_ clknet_leaf_229_clk
+ _02960_ _01283_ VSS VSS VDD VDD network.neuron_in224.counter\[0\]
+ sky130_fd_sc_hd__edfxtp_1
Xnetwork.neuron_in224.counter\[1\]$_DFFE_PP_ clknet_leaf_230_clk
+ _02961_ _01283_ VSS VSS VDD VDD network.neuron_in224.counter\[1\]
+ sky130_fd_sc_hd__edfxtp_1
Xnetwork.neuron_in224.counter\[2\]$_DFFE_PP_ clknet_leaf_226_clk
+ _02962_ _01283_ VSS VSS VDD VDD network.neuron_in224.counter\[2\]
+ sky130_fd_sc_hd__edfxtp_1
Xnetwork.neuron_in224.counter\[3\]$_DFFE_PP_ clknet_leaf_226_clk
+ _02963_ _01283_ VSS VSS VDD VDD network.neuron_in224.counter\[3\]
+ sky130_fd_sc_hd__edfxtp_1
Xnetwork.neuron_in224.spike$_SDFFE_PP0P_ clknet_leaf_229_clk
+ _01878_ VSS VSS VDD VDD network.in_spk00_14 sky130_fd_sc_hd__dfxtp_1
Xnetwork.neuron_in225.counter\[0\]$_DFFE_PP_ clknet_leaf_230_clk
+ _02964_ _01282_ VSS VSS VDD VDD network.neuron_in225.counter\[0\]
+ sky130_fd_sc_hd__edfxtp_1
Xnetwork.neuron_in225.counter\[1\]$_DFFE_PP_ clknet_leaf_230_clk
+ _02965_ _01282_ VSS VSS VDD VDD network.neuron_in225.counter\[1\]
+ sky130_fd_sc_hd__edfxtp_1
Xnetwork.neuron_in225.counter\[2\]$_DFFE_PP_ clknet_leaf_230_clk
+ _02966_ _01282_ VSS VSS VDD VDD network.neuron_in225.counter\[2\]
+ sky130_fd_sc_hd__edfxtp_1
Xnetwork.neuron_in225.counter\[3\]$_DFFE_PP_ clknet_leaf_231_clk
+ _02967_ _01282_ VSS VSS VDD VDD network.neuron_in225.counter\[3\]
+ sky130_fd_sc_hd__edfxtp_1
Xnetwork.neuron_in225.spike$_SDFFE_PP0P_ clknet_leaf_229_clk
+ _01875_ VSS VSS VDD VDD network.in_spk01_14 sky130_fd_sc_hd__dfxtp_1
Xnetwork.neuron_in226.counter\[0\]$_DFFE_PP_ clknet_leaf_232_clk
+ _02968_ _01281_ VSS VSS VDD VDD network.neuron_in226.counter\[0\]
+ sky130_fd_sc_hd__edfxtp_1
Xnetwork.neuron_in226.counter\[1\]$_DFFE_PP_ clknet_leaf_232_clk
+ _02969_ _01281_ VSS VSS VDD VDD network.neuron_in226.counter\[1\]
+ sky130_fd_sc_hd__edfxtp_1
Xnetwork.neuron_in226.counter\[2\]$_DFFE_PP_ clknet_leaf_232_clk
+ _02970_ _01281_ VSS VSS VDD VDD network.neuron_in226.counter\[2\]
+ sky130_fd_sc_hd__edfxtp_1
Xnetwork.neuron_in226.counter\[3\]$_DFFE_PP_ clknet_leaf_232_clk
+ _02971_ _01281_ VSS VSS VDD VDD network.neuron_in226.counter\[3\]
+ sky130_fd_sc_hd__edfxtp_1
Xnetwork.neuron_in226.spike$_SDFFE_PP0P_ clknet_leaf_229_clk
+ _01948_ VSS VSS VDD VDD network.in_spk02_14 sky130_fd_sc_hd__dfxtp_1
Xnetwork.neuron_in227.counter\[0\]$_DFFE_PP_ clknet_leaf_235_clk
+ _02972_ _01280_ VSS VSS VDD VDD network.neuron_in227.counter\[0\]
+ sky130_fd_sc_hd__edfxtp_1
Xnetwork.neuron_in227.counter\[1\]$_DFFE_PP_ clknet_leaf_235_clk
+ _02973_ _01280_ VSS VSS VDD VDD network.neuron_in227.counter\[1\]
+ sky130_fd_sc_hd__edfxtp_1
Xnetwork.neuron_in227.counter\[2\]$_DFFE_PP_ clknet_leaf_234_clk
+ _02974_ _01280_ VSS VSS VDD VDD network.neuron_in227.counter\[2\]
+ sky130_fd_sc_hd__edfxtp_1
Xnetwork.neuron_in227.counter\[3\]$_DFFE_PP_ clknet_leaf_234_clk
+ _02975_ _01280_ VSS VSS VDD VDD network.neuron_in227.counter\[3\]
+ sky130_fd_sc_hd__edfxtp_1
Xnetwork.neuron_in227.spike$_SDFFE_PP0P_ clknet_leaf_237_clk
+ _01943_ VSS VSS VDD VDD network.in_spk03_14 sky130_fd_sc_hd__dfxtp_1
Xnetwork.neuron_in228.counter\[0\]$_DFFE_PP_ clknet_leaf_238_clk
+ _02976_ _01279_ VSS VSS VDD VDD network.neuron_in228.counter\[0\]
+ sky130_fd_sc_hd__edfxtp_1
Xnetwork.neuron_in228.counter\[1\]$_DFFE_PP_ clknet_leaf_238_clk
+ _02977_ _01279_ VSS VSS VDD VDD network.neuron_in228.counter\[1\]
+ sky130_fd_sc_hd__edfxtp_1
Xnetwork.neuron_in228.counter\[2\]$_DFFE_PP_ clknet_leaf_237_clk
+ _02978_ _01279_ VSS VSS VDD VDD network.neuron_in228.counter\[2\]
+ sky130_fd_sc_hd__edfxtp_1
Xnetwork.neuron_in228.counter\[3\]$_DFFE_PP_ clknet_leaf_238_clk
+ _02979_ _01279_ VSS VSS VDD VDD network.neuron_in228.counter\[3\]
+ sky130_fd_sc_hd__edfxtp_1
Xnetwork.neuron_in228.spike$_SDFFE_PP0P_ clknet_leaf_237_clk
+ _01947_ VSS VSS VDD VDD network.in_spk04_14 sky130_fd_sc_hd__dfxtp_1
Xnetwork.neuron_in229.counter\[0\]$_DFFE_PP_ clknet_leaf_228_clk
+ _02980_ _01278_ VSS VSS VDD VDD network.neuron_in229.counter\[0\]
+ sky130_fd_sc_hd__edfxtp_1
Xnetwork.neuron_in229.counter\[1\]$_DFFE_PP_ clknet_leaf_228_clk
+ _02981_ _01278_ VSS VSS VDD VDD network.neuron_in229.counter\[1\]
+ sky130_fd_sc_hd__edfxtp_1
Xnetwork.neuron_in229.counter\[2\]$_DFFE_PP_ clknet_leaf_229_clk
+ _02982_ _01278_ VSS VSS VDD VDD network.neuron_in229.counter\[2\]
+ sky130_fd_sc_hd__edfxtp_1
Xnetwork.neuron_in229.counter\[3\]$_DFFE_PP_ clknet_leaf_229_clk
+ _02983_ _01278_ VSS VSS VDD VDD network.neuron_in229.counter\[3\]
+ sky130_fd_sc_hd__edfxtp_1
Xnetwork.neuron_in229.spike$_SDFFE_PP0P_ clknet_leaf_237_clk
+ _01945_ VSS VSS VDD VDD network.in_spk05_14 sky130_fd_sc_hd__dfxtp_1
Xnetwork.neuron_in230.counter\[0\]$_DFFE_PP_ clknet_leaf_236_clk
+ _02984_ _01277_ VSS VSS VDD VDD network.neuron_in230.counter\[0\]
+ sky130_fd_sc_hd__edfxtp_1
Xnetwork.neuron_in230.counter\[1\]$_DFFE_PP_ clknet_leaf_236_clk
+ _02985_ _01277_ VSS VSS VDD VDD network.neuron_in230.counter\[1\]
+ sky130_fd_sc_hd__edfxtp_1
Xnetwork.neuron_in230.counter\[2\]$_DFFE_PP_ clknet_leaf_236_clk
+ _02986_ _01277_ VSS VSS VDD VDD network.neuron_in230.counter\[2\]
+ sky130_fd_sc_hd__edfxtp_1
Xnetwork.neuron_in230.counter\[3\]$_DFFE_PP_ clknet_leaf_236_clk
+ _02987_ _01277_ VSS VSS VDD VDD network.neuron_in230.counter\[3\]
+ sky130_fd_sc_hd__edfxtp_1
Xnetwork.neuron_in230.spike$_SDFFE_PP0P_ clknet_leaf_237_clk
+ _01933_ VSS VSS VDD VDD network.in_spk06_14 sky130_fd_sc_hd__dfxtp_1
Xnetwork.neuron_in231.counter\[0\]$_DFFE_PP_ clknet_leaf_236_clk
+ _02988_ _01276_ VSS VSS VDD VDD network.neuron_in231.counter\[0\]
+ sky130_fd_sc_hd__edfxtp_1
Xnetwork.neuron_in231.counter\[1\]$_DFFE_PP_ clknet_leaf_236_clk
+ _02989_ _01276_ VSS VSS VDD VDD network.neuron_in231.counter\[1\]
+ sky130_fd_sc_hd__edfxtp_1
Xnetwork.neuron_in231.counter\[2\]$_DFFE_PP_ clknet_leaf_240_clk
+ _02990_ _01276_ VSS VSS VDD VDD network.neuron_in231.counter\[2\]
+ sky130_fd_sc_hd__edfxtp_1
Xnetwork.neuron_in231.counter\[3\]$_DFFE_PP_ clknet_leaf_239_clk
+ _02991_ _01276_ VSS VSS VDD VDD network.neuron_in231.counter\[3\]
+ sky130_fd_sc_hd__edfxtp_1
Xnetwork.neuron_in231.spike$_SDFFE_PP0P_ clknet_leaf_237_clk
+ _01916_ VSS VSS VDD VDD network.in_spk07_14 sky130_fd_sc_hd__dfxtp_1
Xnetwork.neuron_in232.counter\[0\]$_DFFE_PP_ clknet_leaf_249_clk
+ _02992_ _01275_ VSS VSS VDD VDD network.neuron_in232.counter\[0\]
+ sky130_fd_sc_hd__edfxtp_1
Xnetwork.neuron_in232.counter\[1\]$_DFFE_PP_ clknet_leaf_249_clk
+ _02993_ _01275_ VSS VSS VDD VDD network.neuron_in232.counter\[1\]
+ sky130_fd_sc_hd__edfxtp_1
Xnetwork.neuron_in232.counter\[2\]$_DFFE_PP_ clknet_leaf_249_clk
+ _02994_ _01275_ VSS VSS VDD VDD network.neuron_in232.counter\[2\]
+ sky130_fd_sc_hd__edfxtp_1
Xnetwork.neuron_in232.counter\[3\]$_DFFE_PP_ clknet_leaf_249_clk
+ _02995_ _01275_ VSS VSS VDD VDD network.neuron_in232.counter\[3\]
+ sky130_fd_sc_hd__edfxtp_1
Xnetwork.neuron_in232.spike$_SDFFE_PP0P_ clknet_leaf_248_clk
+ _01870_ VSS VSS VDD VDD network.in_spk08_14 sky130_fd_sc_hd__dfxtp_1
Xnetwork.neuron_in233.counter\[0\]$_DFFE_PP_ clknet_leaf_247_clk
+ _02996_ _01274_ VSS VSS VDD VDD network.neuron_in233.counter\[0\]
+ sky130_fd_sc_hd__edfxtp_1
Xnetwork.neuron_in233.counter\[1\]$_DFFE_PP_ clknet_leaf_239_clk
+ _02997_ _01274_ VSS VSS VDD VDD network.neuron_in233.counter\[1\]
+ sky130_fd_sc_hd__edfxtp_1
Xnetwork.neuron_in233.counter\[2\]$_DFFE_PP_ clknet_leaf_247_clk
+ _02998_ _01274_ VSS VSS VDD VDD network.neuron_in233.counter\[2\]
+ sky130_fd_sc_hd__edfxtp_1
Xnetwork.neuron_in233.counter\[3\]$_DFFE_PP_ clknet_leaf_247_clk
+ _02999_ _01274_ VSS VSS VDD VDD network.neuron_in233.counter\[3\]
+ sky130_fd_sc_hd__edfxtp_1
Xnetwork.neuron_in233.spike$_SDFFE_PP0P_ clknet_leaf_248_clk
+ _01871_ VSS VSS VDD VDD network.in_spk09_14 sky130_fd_sc_hd__dfxtp_1
Xnetwork.neuron_in234.counter\[0\]$_DFFE_PP_ clknet_leaf_246_clk
+ _03000_ _01273_ VSS VSS VDD VDD network.neuron_in234.counter\[0\]
+ sky130_fd_sc_hd__edfxtp_1
Xnetwork.neuron_in234.counter\[1\]$_DFFE_PP_ clknet_leaf_247_clk
+ _03001_ _01273_ VSS VSS VDD VDD network.neuron_in234.counter\[1\]
+ sky130_fd_sc_hd__edfxtp_1
Xnetwork.neuron_in234.counter\[2\]$_DFFE_PP_ clknet_leaf_247_clk
+ _03002_ _01273_ VSS VSS VDD VDD network.neuron_in234.counter\[2\]
+ sky130_fd_sc_hd__edfxtp_1
Xnetwork.neuron_in234.counter\[3\]$_DFFE_PP_ clknet_leaf_247_clk
+ _03003_ _01273_ VSS VSS VDD VDD network.neuron_in234.counter\[3\]
+ sky130_fd_sc_hd__edfxtp_1
Xnetwork.neuron_in234.spike$_SDFFE_PP0P_ clknet_leaf_248_clk
+ _01872_ VSS VSS VDD VDD network.in_spk10_14 sky130_fd_sc_hd__dfxtp_1
Xnetwork.neuron_in235.counter\[0\]$_DFFE_PP_ clknet_leaf_246_clk
+ _03004_ _01272_ VSS VSS VDD VDD network.neuron_in235.counter\[0\]
+ sky130_fd_sc_hd__edfxtp_1
Xnetwork.neuron_in235.counter\[1\]$_DFFE_PP_ clknet_leaf_249_clk
+ _03005_ _01272_ VSS VSS VDD VDD network.neuron_in235.counter\[1\]
+ sky130_fd_sc_hd__edfxtp_1
Xnetwork.neuron_in235.counter\[2\]$_DFFE_PP_ clknet_leaf_249_clk
+ _03006_ _01272_ VSS VSS VDD VDD network.neuron_in235.counter\[2\]
+ sky130_fd_sc_hd__edfxtp_1
Xnetwork.neuron_in235.counter\[3\]$_DFFE_PP_ clknet_leaf_248_clk
+ _03007_ _01272_ VSS VSS VDD VDD network.neuron_in235.counter\[3\]
+ sky130_fd_sc_hd__edfxtp_1
Xnetwork.neuron_in235.spike$_SDFFE_PP0P_ clknet_leaf_248_clk
+ _01873_ VSS VSS VDD VDD network.in_spk11_14 sky130_fd_sc_hd__dfxtp_1
Xnetwork.neuron_in236.counter\[0\]$_DFFE_PP_ clknet_leaf_251_clk
+ _03008_ _01271_ VSS VSS VDD VDD network.neuron_in236.counter\[0\]
+ sky130_fd_sc_hd__edfxtp_1
Xnetwork.neuron_in236.counter\[1\]$_DFFE_PP_ clknet_leaf_251_clk
+ _03009_ _01271_ VSS VSS VDD VDD network.neuron_in236.counter\[1\]
+ sky130_fd_sc_hd__edfxtp_1
Xnetwork.neuron_in236.counter\[2\]$_DFFE_PP_ clknet_leaf_251_clk
+ _03010_ _01271_ VSS VSS VDD VDD network.neuron_in236.counter\[2\]
+ sky130_fd_sc_hd__edfxtp_1
Xnetwork.neuron_in236.counter\[3\]$_DFFE_PP_ clknet_leaf_251_clk
+ _03011_ _01271_ VSS VSS VDD VDD network.neuron_in236.counter\[3\]
+ sky130_fd_sc_hd__edfxtp_1
Xnetwork.neuron_in236.spike$_SDFFE_PP0P_ clknet_leaf_247_clk
+ _01869_ VSS VSS VDD VDD network.in_spk12_14 sky130_fd_sc_hd__dfxtp_1
Xnetwork.neuron_in237.counter\[0\]$_DFFE_PP_ clknet_leaf_245_clk
+ _03012_ _01270_ VSS VSS VDD VDD network.neuron_in237.counter\[0\]
+ sky130_fd_sc_hd__edfxtp_1
Xnetwork.neuron_in237.counter\[1\]$_DFFE_PP_ clknet_leaf_245_clk
+ _03013_ _01270_ VSS VSS VDD VDD network.neuron_in237.counter\[1\]
+ sky130_fd_sc_hd__edfxtp_1
Xnetwork.neuron_in237.counter\[2\]$_DFFE_PP_ clknet_leaf_246_clk
+ _03014_ _01270_ VSS VSS VDD VDD network.neuron_in237.counter\[2\]
+ sky130_fd_sc_hd__edfxtp_1
Xnetwork.neuron_in237.counter\[3\]$_DFFE_PP_ clknet_leaf_246_clk
+ _03015_ _01270_ VSS VSS VDD VDD network.neuron_in237.counter\[3\]
+ sky130_fd_sc_hd__edfxtp_1
Xnetwork.neuron_in237.spike$_SDFFE_PP0P_ clknet_leaf_247_clk
+ _01874_ VSS VSS VDD VDD network.in_spk13_14 sky130_fd_sc_hd__dfxtp_1
Xnetwork.neuron_in238.counter\[0\]$_DFFE_PP_ clknet_leaf_246_clk
+ _03016_ _01269_ VSS VSS VDD VDD network.neuron_in238.counter\[0\]
+ sky130_fd_sc_hd__edfxtp_1
Xnetwork.neuron_in238.counter\[1\]$_DFFE_PP_ clknet_leaf_246_clk
+ _03017_ _01269_ VSS VSS VDD VDD network.neuron_in238.counter\[1\]
+ sky130_fd_sc_hd__edfxtp_1
Xnetwork.neuron_in238.counter\[2\]$_DFFE_PP_ clknet_leaf_250_clk
+ _03018_ _01269_ VSS VSS VDD VDD network.neuron_in238.counter\[2\]
+ sky130_fd_sc_hd__edfxtp_1
Xnetwork.neuron_in238.counter\[3\]$_DFFE_PP_ clknet_leaf_251_clk
+ _03019_ _01269_ VSS VSS VDD VDD network.neuron_in238.counter\[3\]
+ sky130_fd_sc_hd__edfxtp_1
Xnetwork.neuron_in238.spike$_SDFFE_PP0P_ clknet_leaf_248_clk
+ _01876_ VSS VSS VDD VDD network.in_spk14_14 sky130_fd_sc_hd__dfxtp_1
Xnetwork.neuron_in239.counter\[0\]$_DFFE_PP_ clknet_leaf_256_clk
+ _03020_ _01268_ VSS VSS VDD VDD network.neuron_in239.counter\[0\]
+ sky130_fd_sc_hd__edfxtp_1
Xnetwork.neuron_in239.counter\[1\]$_DFFE_PP_ clknet_leaf_256_clk
+ _03021_ _01268_ VSS VSS VDD VDD network.neuron_in239.counter\[1\]
+ sky130_fd_sc_hd__edfxtp_1
Xnetwork.neuron_in239.counter\[2\]$_DFFE_PP_ clknet_leaf_256_clk
+ _03022_ _01268_ VSS VSS VDD VDD network.neuron_in239.counter\[2\]
+ sky130_fd_sc_hd__edfxtp_1
Xnetwork.neuron_in239.counter\[3\]$_DFFE_PP_ clknet_leaf_256_clk
+ _03023_ _01268_ VSS VSS VDD VDD network.neuron_in239.counter\[3\]
+ sky130_fd_sc_hd__edfxtp_1
Xnetwork.neuron_in239.spike$_SDFFE_PP0P_ clknet_leaf_248_clk
+ _01877_ VSS VSS VDD VDD network.in_spk15_14 sky130_fd_sc_hd__dfxtp_1
Xnetwork.neuron_in240.counter\[0\]$_DFFE_PP_ clknet_leaf_83_clk
+ _03024_ _01267_ VSS VSS VDD VDD network.neuron_in240.counter\[0\]
+ sky130_fd_sc_hd__edfxtp_1
Xnetwork.neuron_in240.counter\[1\]$_DFFE_PP_ clknet_leaf_115_clk
+ _03025_ _01267_ VSS VSS VDD VDD network.neuron_in240.counter\[1\]
+ sky130_fd_sc_hd__edfxtp_1
Xnetwork.neuron_in240.counter\[2\]$_DFFE_PP_ clknet_leaf_83_clk
+ _03026_ _01267_ VSS VSS VDD VDD network.neuron_in240.counter\[2\]
+ sky130_fd_sc_hd__edfxtp_1
Xnetwork.neuron_in240.counter\[3\]$_DFFE_PP_ clknet_leaf_115_clk
+ _03027_ _01267_ VSS VSS VDD VDD network.neuron_in240.counter\[3\]
+ sky130_fd_sc_hd__edfxtp_1
Xnetwork.neuron_in240.spike$_SDFFE_PP0P_ clknet_leaf_83_clk
+ _01879_ VSS VSS VDD VDD network.in_spk00_15 sky130_fd_sc_hd__dfxtp_1
Xnetwork.neuron_in241.counter\[0\]$_DFFE_PP_ clknet_leaf_80_clk
+ _03028_ _01266_ VSS VSS VDD VDD network.neuron_in241.counter\[0\]
+ sky130_fd_sc_hd__edfxtp_1
Xnetwork.neuron_in241.counter\[1\]$_DFFE_PP_ clknet_leaf_80_clk
+ _03029_ _01266_ VSS VSS VDD VDD network.neuron_in241.counter\[1\]
+ sky130_fd_sc_hd__edfxtp_1
Xnetwork.neuron_in241.counter\[2\]$_DFFE_PP_ clknet_leaf_82_clk
+ _03030_ _01266_ VSS VSS VDD VDD network.neuron_in241.counter\[2\]
+ sky130_fd_sc_hd__edfxtp_1
Xnetwork.neuron_in241.counter\[3\]$_DFFE_PP_ clknet_leaf_80_clk
+ _03031_ _01266_ VSS VSS VDD VDD network.neuron_in241.counter\[3\]
+ sky130_fd_sc_hd__edfxtp_1
Xnetwork.neuron_in241.spike$_SDFFE_PP0P_ clknet_leaf_83_clk
+ _01880_ VSS VSS VDD VDD network.in_spk01_15 sky130_fd_sc_hd__dfxtp_1
Xnetwork.neuron_in242.counter\[0\]$_DFFE_PP_ clknet_leaf_79_clk
+ _03032_ _01265_ VSS VSS VDD VDD network.neuron_in242.counter\[0\]
+ sky130_fd_sc_hd__edfxtp_1
Xnetwork.neuron_in242.counter\[1\]$_DFFE_PP_ clknet_leaf_79_clk
+ _03033_ _01265_ VSS VSS VDD VDD network.neuron_in242.counter\[1\]
+ sky130_fd_sc_hd__edfxtp_1
Xnetwork.neuron_in242.counter\[2\]$_DFFE_PP_ clknet_leaf_80_clk
+ _03034_ _01265_ VSS VSS VDD VDD network.neuron_in242.counter\[2\]
+ sky130_fd_sc_hd__edfxtp_1
Xnetwork.neuron_in242.counter\[3\]$_DFFE_PP_ clknet_leaf_80_clk
+ _03035_ _01265_ VSS VSS VDD VDD network.neuron_in242.counter\[3\]
+ sky130_fd_sc_hd__edfxtp_1
Xnetwork.neuron_in242.spike$_SDFFE_PP0P_ clknet_leaf_81_clk
+ _01882_ VSS VSS VDD VDD network.in_spk02_15 sky130_fd_sc_hd__dfxtp_1
Xnetwork.neuron_in243.counter\[0\]$_DFFE_PP_ clknet_leaf_81_clk
+ _03036_ _01264_ VSS VSS VDD VDD network.neuron_in243.counter\[0\]
+ sky130_fd_sc_hd__edfxtp_1
Xnetwork.neuron_in243.counter\[1\]$_DFFE_PP_ clknet_leaf_80_clk
+ _03037_ _01264_ VSS VSS VDD VDD network.neuron_in243.counter\[1\]
+ sky130_fd_sc_hd__edfxtp_1
Xnetwork.neuron_in243.counter\[2\]$_DFFE_PP_ clknet_leaf_80_clk
+ _03038_ _01264_ VSS VSS VDD VDD network.neuron_in243.counter\[2\]
+ sky130_fd_sc_hd__edfxtp_1
Xnetwork.neuron_in243.counter\[3\]$_DFFE_PP_ clknet_leaf_81_clk
+ _03039_ _01264_ VSS VSS VDD VDD network.neuron_in243.counter\[3\]
+ sky130_fd_sc_hd__edfxtp_1
Xnetwork.neuron_in243.spike$_SDFFE_PP0P_ clknet_leaf_81_clk
+ _01883_ VSS VSS VDD VDD network.in_spk03_15 sky130_fd_sc_hd__dfxtp_1
Xnetwork.neuron_in244.counter\[0\]$_DFFE_PP_ clknet_leaf_82_clk
+ _03040_ _01263_ VSS VSS VDD VDD network.neuron_in244.counter\[0\]
+ sky130_fd_sc_hd__edfxtp_1
Xnetwork.neuron_in244.counter\[1\]$_DFFE_PP_ clknet_leaf_82_clk
+ _03041_ _01263_ VSS VSS VDD VDD network.neuron_in244.counter\[1\]
+ sky130_fd_sc_hd__edfxtp_1
Xnetwork.neuron_in244.counter\[2\]$_DFFE_PP_ clknet_leaf_82_clk
+ _03042_ _01263_ VSS VSS VDD VDD network.neuron_in244.counter\[2\]
+ sky130_fd_sc_hd__edfxtp_1
Xnetwork.neuron_in244.counter\[3\]$_DFFE_PP_ clknet_leaf_82_clk
+ _03043_ _01263_ VSS VSS VDD VDD network.neuron_in244.counter\[3\]
+ sky130_fd_sc_hd__edfxtp_1
Xnetwork.neuron_in244.spike$_SDFFE_PP0P_ clknet_leaf_83_clk
+ _01885_ VSS VSS VDD VDD network.in_spk04_15 sky130_fd_sc_hd__dfxtp_1
Xnetwork.neuron_in245.counter\[0\]$_DFFE_PP_ clknet_leaf_85_clk
+ _03044_ _01262_ VSS VSS VDD VDD network.neuron_in245.counter\[0\]
+ sky130_fd_sc_hd__edfxtp_1
Xnetwork.neuron_in245.counter\[1\]$_DFFE_PP_ clknet_leaf_85_clk
+ _03045_ _01262_ VSS VSS VDD VDD network.neuron_in245.counter\[1\]
+ sky130_fd_sc_hd__edfxtp_1
Xnetwork.neuron_in245.counter\[2\]$_DFFE_PP_ clknet_leaf_84_clk
+ _03046_ _01262_ VSS VSS VDD VDD network.neuron_in245.counter\[2\]
+ sky130_fd_sc_hd__edfxtp_1
Xnetwork.neuron_in245.counter\[3\]$_DFFE_PP_ clknet_leaf_85_clk
+ _03047_ _01262_ VSS VSS VDD VDD network.neuron_in245.counter\[3\]
+ sky130_fd_sc_hd__edfxtp_1
Xnetwork.neuron_in245.spike$_SDFFE_PP0P_ clknet_leaf_84_clk
+ _01886_ VSS VSS VDD VDD network.in_spk05_15 sky130_fd_sc_hd__dfxtp_1
Xnetwork.neuron_in246.counter\[0\]$_DFFE_PP_ clknet_leaf_86_clk
+ _03048_ _01261_ VSS VSS VDD VDD network.neuron_in246.counter\[0\]
+ sky130_fd_sc_hd__edfxtp_1
Xnetwork.neuron_in246.counter\[1\]$_DFFE_PP_ clknet_leaf_86_clk
+ _03049_ _01261_ VSS VSS VDD VDD network.neuron_in246.counter\[1\]
+ sky130_fd_sc_hd__edfxtp_1
Xnetwork.neuron_in246.counter\[2\]$_DFFE_PP_ clknet_leaf_79_clk
+ _03050_ _01261_ VSS VSS VDD VDD network.neuron_in246.counter\[2\]
+ sky130_fd_sc_hd__edfxtp_1
Xnetwork.neuron_in246.counter\[3\]$_DFFE_PP_ clknet_leaf_79_clk
+ _03051_ _01261_ VSS VSS VDD VDD network.neuron_in246.counter\[3\]
+ sky130_fd_sc_hd__edfxtp_1
Xnetwork.neuron_in246.spike$_SDFFE_PP0P_ clknet_leaf_83_clk
+ _01888_ VSS VSS VDD VDD network.in_spk06_15 sky130_fd_sc_hd__dfxtp_1
Xnetwork.neuron_in247.counter\[0\]$_DFFE_PP_ clknet_leaf_79_clk
+ _03052_ _01260_ VSS VSS VDD VDD network.neuron_in247.counter\[0\]
+ sky130_fd_sc_hd__edfxtp_1
Xnetwork.neuron_in247.counter\[1\]$_DFFE_PP_ clknet_leaf_78_clk
+ _03053_ _01260_ VSS VSS VDD VDD network.neuron_in247.counter\[1\]
+ sky130_fd_sc_hd__edfxtp_1
Xnetwork.neuron_in247.counter\[2\]$_DFFE_PP_ clknet_leaf_79_clk
+ _03054_ _01260_ VSS VSS VDD VDD network.neuron_in247.counter\[2\]
+ sky130_fd_sc_hd__edfxtp_1
Xnetwork.neuron_in247.counter\[3\]$_DFFE_PP_ clknet_leaf_79_clk
+ _03055_ _01260_ VSS VSS VDD VDD network.neuron_in247.counter\[3\]
+ sky130_fd_sc_hd__edfxtp_1
Xnetwork.neuron_in247.spike$_SDFFE_PP0P_ clknet_leaf_84_clk
+ _01889_ VSS VSS VDD VDD network.in_spk07_15 sky130_fd_sc_hd__dfxtp_1
Xnetwork.neuron_in248.counter\[0\]$_DFFE_PP_ clknet_leaf_85_clk
+ _03056_ _01259_ VSS VSS VDD VDD network.neuron_in248.counter\[0\]
+ sky130_fd_sc_hd__edfxtp_1
Xnetwork.neuron_in248.counter\[1\]$_DFFE_PP_ clknet_leaf_85_clk
+ _03057_ _01259_ VSS VSS VDD VDD network.neuron_in248.counter\[1\]
+ sky130_fd_sc_hd__edfxtp_1
Xnetwork.neuron_in248.counter\[2\]$_DFFE_PP_ clknet_leaf_85_clk
+ _03058_ _01259_ VSS VSS VDD VDD network.neuron_in248.counter\[2\]
+ sky130_fd_sc_hd__edfxtp_1
Xnetwork.neuron_in248.counter\[3\]$_DFFE_PP_ clknet_leaf_81_clk
+ _03059_ _01259_ VSS VSS VDD VDD network.neuron_in248.counter\[3\]
+ sky130_fd_sc_hd__edfxtp_1
Xnetwork.neuron_in248.spike$_SDFFE_PP0P_ clknet_leaf_84_clk
+ _01891_ VSS VSS VDD VDD network.in_spk08_15 sky130_fd_sc_hd__dfxtp_1
Xnetwork.neuron_in249.counter\[0\]$_DFFE_PP_ clknet_leaf_93_clk
+ _03060_ _01258_ VSS VSS VDD VDD network.neuron_in249.counter\[0\]
+ sky130_fd_sc_hd__edfxtp_1
Xnetwork.neuron_in249.counter\[1\]$_DFFE_PP_ clknet_leaf_93_clk
+ _03061_ _01258_ VSS VSS VDD VDD network.neuron_in249.counter\[1\]
+ sky130_fd_sc_hd__edfxtp_1
Xnetwork.neuron_in249.counter\[2\]$_DFFE_PP_ clknet_leaf_84_clk
+ _03062_ _01258_ VSS VSS VDD VDD network.neuron_in249.counter\[2\]
+ sky130_fd_sc_hd__edfxtp_1
Xnetwork.neuron_in249.counter\[3\]$_DFFE_PP_ clknet_leaf_93_clk
+ _03063_ _01258_ VSS VSS VDD VDD network.neuron_in249.counter\[3\]
+ sky130_fd_sc_hd__edfxtp_1
Xnetwork.neuron_in249.spike$_SDFFE_PP0P_ clknet_leaf_84_clk
+ _01892_ VSS VSS VDD VDD network.in_spk09_15 sky130_fd_sc_hd__dfxtp_1
Xnetwork.neuron_in250.counter\[0\]$_DFFE_PP_ clknet_leaf_78_clk
+ _03064_ _01257_ VSS VSS VDD VDD network.neuron_in250.counter\[0\]
+ sky130_fd_sc_hd__edfxtp_1
Xnetwork.neuron_in250.counter\[1\]$_DFFE_PP_ clknet_leaf_87_clk
+ _03065_ _01257_ VSS VSS VDD VDD network.neuron_in250.counter\[1\]
+ sky130_fd_sc_hd__edfxtp_1
Xnetwork.neuron_in250.counter\[2\]$_DFFE_PP_ clknet_leaf_87_clk
+ _03066_ _01257_ VSS VSS VDD VDD network.neuron_in250.counter\[2\]
+ sky130_fd_sc_hd__edfxtp_1
Xnetwork.neuron_in250.counter\[3\]$_DFFE_PP_ clknet_leaf_87_clk
+ _03067_ _01257_ VSS VSS VDD VDD network.neuron_in250.counter\[3\]
+ sky130_fd_sc_hd__edfxtp_1
Xnetwork.neuron_in250.spike$_SDFFE_PP0P_ clknet_leaf_84_clk
+ _01894_ VSS VSS VDD VDD network.in_spk10_15 sky130_fd_sc_hd__dfxtp_1
Xnetwork.neuron_in251.counter\[0\]$_DFFE_PP_ clknet_leaf_91_clk
+ _03068_ _01256_ VSS VSS VDD VDD network.neuron_in251.counter\[0\]
+ sky130_fd_sc_hd__edfxtp_1
Xnetwork.neuron_in251.counter\[1\]$_DFFE_PP_ clknet_leaf_91_clk
+ _03069_ _01256_ VSS VSS VDD VDD network.neuron_in251.counter\[1\]
+ sky130_fd_sc_hd__edfxtp_1
Xnetwork.neuron_in251.counter\[2\]$_DFFE_PP_ clknet_leaf_90_clk
+ _03070_ _01256_ VSS VSS VDD VDD network.neuron_in251.counter\[2\]
+ sky130_fd_sc_hd__edfxtp_1
Xnetwork.neuron_in251.counter\[3\]$_DFFE_PP_ clknet_leaf_90_clk
+ _03071_ _01256_ VSS VSS VDD VDD network.neuron_in251.counter\[3\]
+ sky130_fd_sc_hd__edfxtp_1
Xnetwork.neuron_in251.spike$_SDFFE_PP0P_ clknet_leaf_94_clk
+ _01895_ VSS VSS VDD VDD network.in_spk11_15 sky130_fd_sc_hd__dfxtp_1
Xnetwork.neuron_in252.counter\[0\]$_DFFE_PP_ clknet_leaf_87_clk
+ _03072_ _01255_ VSS VSS VDD VDD network.neuron_in252.counter\[0\]
+ sky130_fd_sc_hd__edfxtp_1
Xnetwork.neuron_in252.counter\[1\]$_DFFE_PP_ clknet_leaf_87_clk
+ _03073_ _01255_ VSS VSS VDD VDD network.neuron_in252.counter\[1\]
+ sky130_fd_sc_hd__edfxtp_1
Xnetwork.neuron_in252.counter\[2\]$_DFFE_PP_ clknet_leaf_87_clk
+ _03074_ _01255_ VSS VSS VDD VDD network.neuron_in252.counter\[2\]
+ sky130_fd_sc_hd__edfxtp_1
Xnetwork.neuron_in252.counter\[3\]$_DFFE_PP_ clknet_leaf_87_clk
+ _03075_ _01255_ VSS VSS VDD VDD network.neuron_in252.counter\[3\]
+ sky130_fd_sc_hd__edfxtp_1
Xnetwork.neuron_in252.spike$_SDFFE_PP0P_ clknet_leaf_93_clk
+ _01897_ VSS VSS VDD VDD network.in_spk12_15 sky130_fd_sc_hd__dfxtp_1
Xnetwork.neuron_in253.counter\[0\]$_DFFE_PP_ clknet_leaf_92_clk
+ _03076_ _01254_ VSS VSS VDD VDD network.neuron_in253.counter\[0\]
+ sky130_fd_sc_hd__edfxtp_1
Xnetwork.neuron_in253.counter\[1\]$_DFFE_PP_ clknet_leaf_92_clk
+ _03077_ _01254_ VSS VSS VDD VDD network.neuron_in253.counter\[1\]
+ sky130_fd_sc_hd__edfxtp_1
Xnetwork.neuron_in253.counter\[2\]$_DFFE_PP_ clknet_leaf_93_clk
+ _03078_ _01254_ VSS VSS VDD VDD network.neuron_in253.counter\[2\]
+ sky130_fd_sc_hd__edfxtp_1
Xnetwork.neuron_in253.counter\[3\]$_DFFE_PP_ clknet_leaf_92_clk
+ _03079_ _01254_ VSS VSS VDD VDD network.neuron_in253.counter\[3\]
+ sky130_fd_sc_hd__edfxtp_1
Xnetwork.neuron_in253.spike$_SDFFE_PP0P_ clknet_leaf_93_clk
+ _01898_ VSS VSS VDD VDD network.in_spk13_15 sky130_fd_sc_hd__dfxtp_1
Xnetwork.neuron_in254.counter\[0\]$_DFFE_PP_ clknet_leaf_88_clk
+ _03080_ _01253_ VSS VSS VDD VDD network.neuron_in254.counter\[0\]
+ sky130_fd_sc_hd__edfxtp_1
Xnetwork.neuron_in254.counter\[1\]$_DFFE_PP_ clknet_leaf_88_clk
+ _03081_ _01253_ VSS VSS VDD VDD network.neuron_in254.counter\[1\]
+ sky130_fd_sc_hd__edfxtp_1
Xnetwork.neuron_in254.counter\[2\]$_DFFE_PP_ clknet_leaf_90_clk
+ _03082_ _01253_ VSS VSS VDD VDD network.neuron_in254.counter\[2\]
+ sky130_fd_sc_hd__edfxtp_1
Xnetwork.neuron_in254.counter\[3\]$_DFFE_PP_ clknet_leaf_88_clk
+ _03083_ _01253_ VSS VSS VDD VDD network.neuron_in254.counter\[3\]
+ sky130_fd_sc_hd__edfxtp_1
Xnetwork.neuron_in254.spike$_SDFFE_PP0P_ clknet_leaf_93_clk
+ _01900_ VSS VSS VDD VDD network.in_spk14_15 sky130_fd_sc_hd__dfxtp_1
Xnetwork.neuron_in255.counter\[0\]$_DFFE_PP_ clknet_leaf_96_clk
+ _03084_ _01252_ VSS VSS VDD VDD network.neuron_in255.counter\[0\]
+ sky130_fd_sc_hd__edfxtp_1
Xnetwork.neuron_in255.counter\[1\]$_DFFE_PP_ clknet_leaf_93_clk
+ _03085_ _01252_ VSS VSS VDD VDD network.neuron_in255.counter\[1\]
+ sky130_fd_sc_hd__edfxtp_1
Xnetwork.neuron_in255.counter\[2\]$_DFFE_PP_ clknet_leaf_94_clk
+ _03086_ _01252_ VSS VSS VDD VDD network.neuron_in255.counter\[2\]
+ sky130_fd_sc_hd__edfxtp_1
Xnetwork.neuron_in255.counter\[3\]$_DFFE_PP_ clknet_leaf_93_clk
+ _03087_ _01252_ VSS VSS VDD VDD network.neuron_in255.counter\[3\]
+ sky130_fd_sc_hd__edfxtp_1
Xnetwork.neuron_in255.spike$_SDFFE_PP0P_ clknet_leaf_94_clk
+ _01902_ VSS VSS VDD VDD network.in_spk15_15 sky130_fd_sc_hd__dfxtp_1
Xnetwork.neuron_out0.IF0.membrane_potential\[0\]$_SDFF_PP0_
+ clknet_leaf_176_clk _01626_ VSS VSS VDD VDD network.neuron_out0.IF0.membrane_potential\[0\]
+ sky130_fd_sc_hd__dfxtp_1
Xnetwork.neuron_out0.IF0.membrane_potential\[10\]$_SDFF_PP0_
+ clknet_leaf_175_clk net VSS VSS VDD VDD network.neuron_out0.IF0.membrane_potential\[10\]
+ sky130_fd_sc_hd__dfxtp_1
Xnetwork.neuron_out0.IF0.membrane_potential\[1\]$_SDFF_PP0_
+ clknet_leaf_176_clk _01625_ VSS VSS VDD VDD network.neuron_out0.IF0.membrane_potential\[1\]
+ sky130_fd_sc_hd__dfxtp_1
Xnetwork.neuron_out0.IF0.membrane_potential\[2\]$_SDFF_PP0_
+ clknet_leaf_176_clk _01624_ VSS VSS VDD VDD network.neuron_out0.IF0.membrane_potential\[2\]
+ sky130_fd_sc_hd__dfxtp_1
Xnetwork.neuron_out0.IF0.membrane_potential\[3\]$_SDFF_PP0_
+ clknet_leaf_175_clk _01623_ VSS VSS VDD VDD network.neuron_out0.IF0.membrane_potential\[3\]
+ sky130_fd_sc_hd__dfxtp_1
Xnetwork.neuron_out0.IF0.membrane_potential\[4\]$_SDFF_PP0_
+ clknet_leaf_175_clk _01622_ VSS VSS VDD VDD network.neuron_out0.IF0.membrane_potential\[4\]
+ sky130_fd_sc_hd__dfxtp_1
Xnetwork.neuron_out0.IF0.membrane_potential\[5\]$_SDFF_PP0_
+ clknet_leaf_175_clk _01621_ VSS VSS VDD VDD network.neuron_out0.IF0.membrane_potential\[5\]
+ sky130_fd_sc_hd__dfxtp_1
Xnetwork.neuron_out0.IF0.membrane_potential\[6\]$_SDFF_PP0_
+ clknet_leaf_175_clk _01620_ VSS VSS VDD VDD network.neuron_out0.IF0.membrane_potential\[6\]
+ sky130_fd_sc_hd__dfxtp_1
Xnetwork.neuron_out0.IF0.membrane_potential\[7\]$_SDFF_PP0_
+ clknet_leaf_175_clk _01619_ VSS VSS VDD VDD network.neuron_out0.IF0.membrane_potential\[7\]
+ sky130_fd_sc_hd__dfxtp_1
Xnetwork.neuron_out0.IF0.membrane_potential\[8\]$_SDFF_PP0_
+ clknet_leaf_175_clk net1 VSS VSS VDD VDD network.neuron_out0.IF0.membrane_potential\[8\]
+ sky130_fd_sc_hd__dfxtp_1
Xnetwork.neuron_out0.IF0.membrane_potential\[9\]$_SDFF_PP0_
+ clknet_leaf_175_clk net2 VSS VSS VDD VDD network.neuron_out0.IF0.membrane_potential\[9\]
+ sky130_fd_sc_hd__dfxtp_1
Xnetwork.neuron_out0.IF_in\[0\]$_SDFF_PP0_ clknet_leaf_177_clk
+ _01528_ VSS VSS VDD VDD network.neuron_out0.IF0.input_current\[0\]
+ sky130_fd_sc_hd__dfxtp_1
Xnetwork.neuron_out0.IF_in\[1\]$_SDFF_PP0_ clknet_leaf_176_clk
+ _01527_ VSS VSS VDD VDD network.neuron_out0.IF0.input_current\[1\]
+ sky130_fd_sc_hd__dfxtp_1
Xnetwork.neuron_out0.IF_in\[2\]$_SDFF_PP0_ clknet_leaf_176_clk
+ _01526_ VSS VSS VDD VDD network.neuron_out0.IF0.input_current\[2\]
+ sky130_fd_sc_hd__dfxtp_1
Xnetwork.neuron_out0.IF_in\[3\]$_SDFF_PP0_ clknet_leaf_177_clk
+ _01525_ VSS VSS VDD VDD network.neuron_out0.IF0.input_current\[3\]
+ sky130_fd_sc_hd__dfxtp_1
Xnetwork.neuron_out0.IF_in\[4\]$_SDFF_PP0_ clknet_leaf_174_clk
+ _01524_ VSS VSS VDD VDD network.neuron_out0.IF0.input_current\[4\]
+ sky130_fd_sc_hd__dfxtp_1
Xnetwork.neuron_out0.IF_in\[5\]$_SDFF_PP0_ clknet_leaf_174_clk
+ _01768_ VSS VSS VDD VDD network.neuron_out0.IF0.input_current\[5\]
+ sky130_fd_sc_hd__dfxtp_1
Xnetwork.neuron_out1.IF0.membrane_potential\[0\]$_SDFF_PP0_
+ clknet_leaf_191_clk _01618_ VSS VSS VDD VDD network.neuron_out1.IF0.membrane_potential\[0\]
+ sky130_fd_sc_hd__dfxtp_1
Xnetwork.neuron_out1.IF0.membrane_potential\[10\]$_SDFF_PP0_
+ clknet_leaf_192_clk net3 VSS VSS VDD VDD network.neuron_out1.IF0.membrane_potential\[10\]
+ sky130_fd_sc_hd__dfxtp_1
Xnetwork.neuron_out1.IF0.membrane_potential\[1\]$_SDFF_PP0_
+ clknet_leaf_190_clk _01617_ VSS VSS VDD VDD network.neuron_out1.IF0.membrane_potential\[1\]
+ sky130_fd_sc_hd__dfxtp_1
Xnetwork.neuron_out1.IF0.membrane_potential\[2\]$_SDFF_PP0_
+ clknet_leaf_191_clk _01616_ VSS VSS VDD VDD network.neuron_out1.IF0.membrane_potential\[2\]
+ sky130_fd_sc_hd__dfxtp_1
Xnetwork.neuron_out1.IF0.membrane_potential\[3\]$_SDFF_PP0_
+ clknet_leaf_191_clk _01615_ VSS VSS VDD VDD network.neuron_out1.IF0.membrane_potential\[3\]
+ sky130_fd_sc_hd__dfxtp_1
Xnetwork.neuron_out1.IF0.membrane_potential\[4\]$_SDFF_PP0_
+ clknet_leaf_191_clk _01614_ VSS VSS VDD VDD network.neuron_out1.IF0.membrane_potential\[4\]
+ sky130_fd_sc_hd__dfxtp_1
Xnetwork.neuron_out1.IF0.membrane_potential\[5\]$_SDFF_PP0_
+ clknet_leaf_191_clk _01613_ VSS VSS VDD VDD network.neuron_out1.IF0.membrane_potential\[5\]
+ sky130_fd_sc_hd__dfxtp_1
Xnetwork.neuron_out1.IF0.membrane_potential\[6\]$_SDFF_PP0_
+ clknet_leaf_191_clk _01612_ VSS VSS VDD VDD network.neuron_out1.IF0.membrane_potential\[6\]
+ sky130_fd_sc_hd__dfxtp_1
Xnetwork.neuron_out1.IF0.membrane_potential\[7\]$_SDFF_PP0_
+ clknet_leaf_192_clk _01611_ VSS VSS VDD VDD network.neuron_out1.IF0.membrane_potential\[7\]
+ sky130_fd_sc_hd__dfxtp_1
Xnetwork.neuron_out1.IF0.membrane_potential\[8\]$_SDFF_PP0_
+ clknet_leaf_192_clk net4 VSS VSS VDD VDD network.neuron_out1.IF0.membrane_potential\[8\]
+ sky130_fd_sc_hd__dfxtp_1
Xnetwork.neuron_out1.IF0.membrane_potential\[9\]$_SDFF_PP0_
+ clknet_leaf_192_clk net5 VSS VSS VDD VDD network.neuron_out1.IF0.membrane_potential\[9\]
+ sky130_fd_sc_hd__dfxtp_1
Xnetwork.neuron_out1.IF_in\[0\]$_SDFF_PP0_ clknet_leaf_190_clk
+ _01532_ VSS VSS VDD VDD network.neuron_out1.IF0.input_current\[0\]
+ sky130_fd_sc_hd__dfxtp_1
Xnetwork.neuron_out1.IF_in\[1\]$_SDFF_PP0_ clknet_leaf_190_clk
+ _01531_ VSS VSS VDD VDD network.neuron_out1.IF0.input_current\[1\]
+ sky130_fd_sc_hd__dfxtp_1
Xnetwork.neuron_out1.IF_in\[2\]$_SDFF_PP0_ clknet_leaf_189_clk
+ _01530_ VSS VSS VDD VDD network.neuron_out1.IF0.input_current\[2\]
+ sky130_fd_sc_hd__dfxtp_1
Xnetwork.neuron_out1.IF_in\[3\]$_SDFF_PP0_ clknet_leaf_189_clk
+ _01529_ VSS VSS VDD VDD network.neuron_out1.IF0.input_current\[3\]
+ sky130_fd_sc_hd__dfxtp_1
Xnetwork.neuron_out1.IF_in\[4\]$_SDFF_PP0_ clknet_leaf_192_clk
+ _01767_ VSS VSS VDD VDD network.neuron_out1.IF0.input_current\[4\]
+ sky130_fd_sc_hd__dfxtp_1
Xnetwork.neuron_out2.IF0.membrane_potential\[0\]$_SDFF_PP0_
+ clknet_leaf_179_clk _01610_ VSS VSS VDD VDD network.neuron_out2.IF0.membrane_potential\[0\]
+ sky130_fd_sc_hd__dfxtp_1
Xnetwork.neuron_out2.IF0.membrane_potential\[10\]$_SDFF_PP0_
+ clknet_leaf_190_clk net6 VSS VSS VDD VDD network.neuron_out2.IF0.membrane_potential\[10\]
+ sky130_fd_sc_hd__dfxtp_1
Xnetwork.neuron_out2.IF0.membrane_potential\[1\]$_SDFF_PP0_
+ clknet_leaf_179_clk _01609_ VSS VSS VDD VDD network.neuron_out2.IF0.membrane_potential\[1\]
+ sky130_fd_sc_hd__dfxtp_1
Xnetwork.neuron_out2.IF0.membrane_potential\[2\]$_SDFF_PP0_
+ clknet_leaf_180_clk _01608_ VSS VSS VDD VDD network.neuron_out2.IF0.membrane_potential\[2\]
+ sky130_fd_sc_hd__dfxtp_1
Xnetwork.neuron_out2.IF0.membrane_potential\[3\]$_SDFF_PP0_
+ clknet_leaf_180_clk _01607_ VSS VSS VDD VDD network.neuron_out2.IF0.membrane_potential\[3\]
+ sky130_fd_sc_hd__dfxtp_1
Xnetwork.neuron_out2.IF0.membrane_potential\[4\]$_SDFF_PP0_
+ clknet_leaf_190_clk _01606_ VSS VSS VDD VDD network.neuron_out2.IF0.membrane_potential\[4\]
+ sky130_fd_sc_hd__dfxtp_1
Xnetwork.neuron_out2.IF0.membrane_potential\[5\]$_SDFF_PP0_
+ clknet_leaf_190_clk _01605_ VSS VSS VDD VDD network.neuron_out2.IF0.membrane_potential\[5\]
+ sky130_fd_sc_hd__dfxtp_1
Xnetwork.neuron_out2.IF0.membrane_potential\[6\]$_SDFF_PP0_
+ clknet_leaf_190_clk _01604_ VSS VSS VDD VDD network.neuron_out2.IF0.membrane_potential\[6\]
+ sky130_fd_sc_hd__dfxtp_1
Xnetwork.neuron_out2.IF0.membrane_potential\[7\]$_SDFF_PP0_
+ clknet_leaf_190_clk _01603_ VSS VSS VDD VDD network.neuron_out2.IF0.membrane_potential\[7\]
+ sky130_fd_sc_hd__dfxtp_1
Xnetwork.neuron_out2.IF0.membrane_potential\[8\]$_SDFF_PP0_
+ clknet_leaf_190_clk net7 VSS VSS VDD VDD network.neuron_out2.IF0.membrane_potential\[8\]
+ sky130_fd_sc_hd__dfxtp_1
Xnetwork.neuron_out2.IF0.membrane_potential\[9\]$_SDFF_PP0_
+ clknet_leaf_190_clk net8 VSS VSS VDD VDD network.neuron_out2.IF0.membrane_potential\[9\]
+ sky130_fd_sc_hd__dfxtp_1
Xnetwork.neuron_out2.IF_in\[0\]$_SDFF_PP0_ clknet_leaf_179_clk
+ _01536_ VSS VSS VDD VDD network.neuron_out2.IF0.input_current\[0\]
+ sky130_fd_sc_hd__dfxtp_1
Xnetwork.neuron_out2.IF_in\[1\]$_SDFF_PP0_ clknet_leaf_180_clk
+ _01535_ VSS VSS VDD VDD network.neuron_out2.IF0.input_current\[1\]
+ sky130_fd_sc_hd__dfxtp_1
Xnetwork.neuron_out2.IF_in\[2\]$_SDFF_PP0_ clknet_leaf_180_clk
+ _01534_ VSS VSS VDD VDD network.neuron_out2.IF0.input_current\[2\]
+ sky130_fd_sc_hd__dfxtp_1
Xnetwork.neuron_out2.IF_in\[3\]$_SDFF_PP0_ clknet_leaf_180_clk
+ _01533_ VSS VSS VDD VDD network.neuron_out2.IF0.input_current\[3\]
+ sky130_fd_sc_hd__dfxtp_1
Xnetwork.neuron_out2.IF_in\[4\]$_SDFF_PP0_ clknet_leaf_180_clk
+ _01765_ VSS VSS VDD VDD network.neuron_out2.IF0.input_current\[4\]
+ sky130_fd_sc_hd__dfxtp_1
Xnetwork.neuron_out3.IF0.membrane_potential\[0\]$_SDFF_PP0_
+ clknet_leaf_189_clk _01602_ VSS VSS VDD VDD network.neuron_out3.IF0.membrane_potential\[0\]
+ sky130_fd_sc_hd__dfxtp_1
Xnetwork.neuron_out3.IF0.membrane_potential\[10\]$_SDFF_PP0_
+ clknet_leaf_189_clk net9 VSS VSS VDD VDD network.neuron_out3.IF0.membrane_potential\[10\]
+ sky130_fd_sc_hd__dfxtp_1
Xnetwork.neuron_out3.IF0.membrane_potential\[1\]$_SDFF_PP0_
+ clknet_leaf_189_clk _01601_ VSS VSS VDD VDD network.neuron_out3.IF0.membrane_potential\[1\]
+ sky130_fd_sc_hd__dfxtp_1
Xnetwork.neuron_out3.IF0.membrane_potential\[2\]$_SDFF_PP0_
+ clknet_leaf_180_clk _01600_ VSS VSS VDD VDD network.neuron_out3.IF0.membrane_potential\[2\]
+ sky130_fd_sc_hd__dfxtp_1
Xnetwork.neuron_out3.IF0.membrane_potential\[3\]$_SDFF_PP0_
+ clknet_leaf_181_clk _01599_ VSS VSS VDD VDD network.neuron_out3.IF0.membrane_potential\[3\]
+ sky130_fd_sc_hd__dfxtp_1
Xnetwork.neuron_out3.IF0.membrane_potential\[4\]$_SDFF_PP0_
+ clknet_leaf_189_clk _01598_ VSS VSS VDD VDD network.neuron_out3.IF0.membrane_potential\[4\]
+ sky130_fd_sc_hd__dfxtp_1
Xnetwork.neuron_out3.IF0.membrane_potential\[5\]$_SDFF_PP0_
+ clknet_leaf_189_clk _01597_ VSS VSS VDD VDD network.neuron_out3.IF0.membrane_potential\[5\]
+ sky130_fd_sc_hd__dfxtp_1
Xnetwork.neuron_out3.IF0.membrane_potential\[6\]$_SDFF_PP0_
+ clknet_leaf_189_clk _01596_ VSS VSS VDD VDD network.neuron_out3.IF0.membrane_potential\[6\]
+ sky130_fd_sc_hd__dfxtp_1
Xnetwork.neuron_out3.IF0.membrane_potential\[7\]$_SDFF_PP0_
+ clknet_leaf_189_clk _01595_ VSS VSS VDD VDD network.neuron_out3.IF0.membrane_potential\[7\]
+ sky130_fd_sc_hd__dfxtp_1
Xnetwork.neuron_out3.IF0.membrane_potential\[8\]$_SDFF_PP0_
+ clknet_leaf_188_clk net10 VSS VSS VDD VDD network.neuron_out3.IF0.membrane_potential\[8\]
+ sky130_fd_sc_hd__dfxtp_1
Xnetwork.neuron_out3.IF0.membrane_potential\[9\]$_SDFF_PP0_
+ clknet_leaf_188_clk net11 VSS VSS VDD VDD network.neuron_out3.IF0.membrane_potential\[9\]
+ sky130_fd_sc_hd__dfxtp_1
Xnetwork.neuron_out3.IF_in\[0\]$_SDFF_PP0_ clknet_leaf_180_clk
+ _01540_ VSS VSS VDD VDD network.neuron_out3.IF0.input_current\[0\]
+ sky130_fd_sc_hd__dfxtp_1
Xnetwork.neuron_out3.IF_in\[1\]$_SDFF_PP0_ clknet_leaf_180_clk
+ _01539_ VSS VSS VDD VDD network.neuron_out3.IF0.input_current\[1\]
+ sky130_fd_sc_hd__dfxtp_1
Xnetwork.neuron_out3.IF_in\[2\]$_SDFF_PP0_ clknet_leaf_181_clk
+ _01538_ VSS VSS VDD VDD network.neuron_out3.IF0.input_current\[2\]
+ sky130_fd_sc_hd__dfxtp_1
Xnetwork.neuron_out3.IF_in\[3\]$_SDFF_PP0_ clknet_leaf_180_clk
+ _01537_ VSS VSS VDD VDD network.neuron_out3.IF0.input_current\[3\]
+ sky130_fd_sc_hd__dfxtp_1
Xnetwork.neuron_out3.IF_in\[4\]$_SDFF_PP0_ clknet_leaf_181_clk
+ _01764_ VSS VSS VDD VDD network.neuron_out3.IF0.input_current\[4\]
+ sky130_fd_sc_hd__dfxtp_1
Xnetwork.neuron_out4.IF0.membrane_potential\[0\]$_SDFF_PP0_
+ clknet_leaf_188_clk _01594_ VSS VSS VDD VDD network.neuron_out4.IF0.membrane_potential\[0\]
+ sky130_fd_sc_hd__dfxtp_1
Xnetwork.neuron_out4.IF0.membrane_potential\[10\]$_SDFF_PP0_
+ clknet_leaf_193_clk net12 VSS VSS VDD VDD network.neuron_out4.IF0.membrane_potential\[10\]
+ sky130_fd_sc_hd__dfxtp_1
Xnetwork.neuron_out4.IF0.membrane_potential\[1\]$_SDFF_PP0_
+ clknet_leaf_191_clk _01593_ VSS VSS VDD VDD network.neuron_out4.IF0.membrane_potential\[1\]
+ sky130_fd_sc_hd__dfxtp_1
Xnetwork.neuron_out4.IF0.membrane_potential\[2\]$_SDFF_PP0_
+ clknet_leaf_191_clk _01592_ VSS VSS VDD VDD network.neuron_out4.IF0.membrane_potential\[2\]
+ sky130_fd_sc_hd__dfxtp_1
Xnetwork.neuron_out4.IF0.membrane_potential\[3\]$_SDFF_PP0_
+ clknet_leaf_193_clk _01591_ VSS VSS VDD VDD network.neuron_out4.IF0.membrane_potential\[3\]
+ sky130_fd_sc_hd__dfxtp_1
Xnetwork.neuron_out4.IF0.membrane_potential\[4\]$_SDFF_PP0_
+ clknet_leaf_193_clk _01590_ VSS VSS VDD VDD network.neuron_out4.IF0.membrane_potential\[4\]
+ sky130_fd_sc_hd__dfxtp_1
Xnetwork.neuron_out4.IF0.membrane_potential\[5\]$_SDFF_PP0_
+ clknet_leaf_192_clk _01589_ VSS VSS VDD VDD network.neuron_out4.IF0.membrane_potential\[5\]
+ sky130_fd_sc_hd__dfxtp_1
Xnetwork.neuron_out4.IF0.membrane_potential\[6\]$_SDFF_PP0_
+ clknet_leaf_193_clk _01588_ VSS VSS VDD VDD network.neuron_out4.IF0.membrane_potential\[6\]
+ sky130_fd_sc_hd__dfxtp_1
Xnetwork.neuron_out4.IF0.membrane_potential\[7\]$_SDFF_PP0_
+ clknet_leaf_192_clk _01587_ VSS VSS VDD VDD network.neuron_out4.IF0.membrane_potential\[7\]
+ sky130_fd_sc_hd__dfxtp_1
Xnetwork.neuron_out4.IF0.membrane_potential\[8\]$_SDFF_PP0_
+ clknet_leaf_192_clk net13 VSS VSS VDD VDD network.neuron_out4.IF0.membrane_potential\[8\]
+ sky130_fd_sc_hd__dfxtp_1
Xnetwork.neuron_out4.IF0.membrane_potential\[9\]$_SDFF_PP0_
+ clknet_leaf_194_clk net14 VSS VSS VDD VDD network.neuron_out4.IF0.membrane_potential\[9\]
+ sky130_fd_sc_hd__dfxtp_1
Xnetwork.neuron_out4.IF_in\[1\]$_SDFF_PP0_ clknet_leaf_189_clk
+ _01542_ VSS VSS VDD VDD network.neuron_out4.IF0.input_current\[1\]
+ sky130_fd_sc_hd__dfxtp_1
Xnetwork.neuron_out4.IF_in\[3\]$_SDFF_PP0_ clknet_leaf_188_clk
+ _01541_ VSS VSS VDD VDD network.neuron_out4.IF0.input_current\[0\]
+ sky130_fd_sc_hd__dfxtp_1
Xnetwork.neuron_out4.IF_in\[4\]$_SDFF_PP0_ clknet_leaf_189_clk
+ _01763_ VSS VSS VDD VDD network.neuron_out4.IF0.input_current\[4\]
+ sky130_fd_sc_hd__dfxtp_1
Xnetwork.neuron_out5.IF0.membrane_potential\[0\]$_SDFF_PP0_
+ clknet_leaf_177_clk _01586_ VSS VSS VDD VDD network.neuron_out5.IF0.membrane_potential\[0\]
+ sky130_fd_sc_hd__dfxtp_1
Xnetwork.neuron_out5.IF0.membrane_potential\[10\]$_SDFF_PP0_
+ clknet_leaf_174_clk net15 VSS VSS VDD VDD network.neuron_out5.IF0.membrane_potential\[10\]
+ sky130_fd_sc_hd__dfxtp_1
Xnetwork.neuron_out5.IF0.membrane_potential\[1\]$_SDFF_PP0_
+ clknet_leaf_178_clk _01585_ VSS VSS VDD VDD network.neuron_out5.IF0.membrane_potential\[1\]
+ sky130_fd_sc_hd__dfxtp_1
Xnetwork.neuron_out5.IF0.membrane_potential\[2\]$_SDFF_PP0_
+ clknet_leaf_177_clk _01584_ VSS VSS VDD VDD network.neuron_out5.IF0.membrane_potential\[2\]
+ sky130_fd_sc_hd__dfxtp_1
Xnetwork.neuron_out5.IF0.membrane_potential\[3\]$_SDFF_PP0_
+ clknet_leaf_177_clk _01583_ VSS VSS VDD VDD network.neuron_out5.IF0.membrane_potential\[3\]
+ sky130_fd_sc_hd__dfxtp_1
Xnetwork.neuron_out5.IF0.membrane_potential\[4\]$_SDFF_PP0_
+ clknet_leaf_177_clk _01582_ VSS VSS VDD VDD network.neuron_out5.IF0.membrane_potential\[4\]
+ sky130_fd_sc_hd__dfxtp_1
Xnetwork.neuron_out5.IF0.membrane_potential\[5\]$_SDFF_PP0_
+ clknet_leaf_173_clk _01581_ VSS VSS VDD VDD network.neuron_out5.IF0.membrane_potential\[5\]
+ sky130_fd_sc_hd__dfxtp_1
Xnetwork.neuron_out5.IF0.membrane_potential\[6\]$_SDFF_PP0_
+ clknet_leaf_173_clk _01580_ VSS VSS VDD VDD network.neuron_out5.IF0.membrane_potential\[6\]
+ sky130_fd_sc_hd__dfxtp_1
Xnetwork.neuron_out5.IF0.membrane_potential\[7\]$_SDFF_PP0_
+ clknet_leaf_173_clk _01579_ VSS VSS VDD VDD network.neuron_out5.IF0.membrane_potential\[7\]
+ sky130_fd_sc_hd__dfxtp_1
Xnetwork.neuron_out5.IF0.membrane_potential\[8\]$_SDFF_PP0_
+ clknet_leaf_174_clk net16 VSS VSS VDD VDD network.neuron_out5.IF0.membrane_potential\[8\]
+ sky130_fd_sc_hd__dfxtp_1
Xnetwork.neuron_out5.IF0.membrane_potential\[9\]$_SDFF_PP0_
+ clknet_leaf_173_clk net17 VSS VSS VDD VDD network.neuron_out5.IF0.membrane_potential\[9\]
+ sky130_fd_sc_hd__dfxtp_1
Xnetwork.neuron_out5.IF_in\[0\]$_SDFF_PP0_ clknet_leaf_178_clk
+ _01547_ VSS VSS VDD VDD network.neuron_out5.IF0.input_current\[0\]
+ sky130_fd_sc_hd__dfxtp_1
Xnetwork.neuron_out5.IF_in\[1\]$_SDFF_PP0_ clknet_leaf_181_clk
+ _01546_ VSS VSS VDD VDD network.neuron_out5.IF0.input_current\[1\]
+ sky130_fd_sc_hd__dfxtp_1
Xnetwork.neuron_out5.IF_in\[3\]$_SDFF_PP0_ clknet_leaf_181_clk
+ _01545_ VSS VSS VDD VDD network.neuron_out5.IF0.input_current\[3\]
+ sky130_fd_sc_hd__dfxtp_1
Xnetwork.neuron_out5.IF_in\[4\]$_SDFF_PP0_ clknet_leaf_181_clk
+ _01544_ VSS VSS VDD VDD network.neuron_out5.IF0.input_current\[4\]
+ sky130_fd_sc_hd__dfxtp_1
Xnetwork.neuron_out5.IF_in\[5\]$_SDFF_PP0_ clknet_leaf_177_clk
+ _01543_ VSS VSS VDD VDD network.neuron_out5.IF0.input_current\[5\]
+ sky130_fd_sc_hd__dfxtp_1
Xnetwork.neuron_out5.IF_in\[6\]$_SDFF_PP0_ clknet_leaf_173_clk
+ _01760_ VSS VSS VDD VDD network.neuron_out5.IF0.input_current\[6\]
+ sky130_fd_sc_hd__dfxtp_1
Xnetwork.out_controller.addr_out\[0\]$_SDFF_PP0_ clknet_leaf_135_clk
+ _01628_ VSS VSS VDD VDD network.neuron_out0.ROM0.address\[0\]
+ sky130_fd_sc_hd__dfxtp_1
Xnetwork.out_controller.addr_out\[1\]$_SDFF_PP0_ clknet_leaf_174_clk
+ _01627_ VSS VSS VDD VDD network.neuron_out0.ROM0.address\[1\]
+ sky130_fd_sc_hd__dfxtp_1
Xnetwork.out_controller.addr_out\[2\]$_SDFF_PP0_ clknet_leaf_135_clk
+ _01942_ VSS VSS VDD VDD network.neuron_out0.ROM0.address\[2\]
+ sky130_fd_sc_hd__dfxtp_1
Xnetwork.out_controller.spike_out$_SDFF_PP0_ clknet_leaf_135_clk
+ _01940_ VSS VSS VDD VDD network.neuron_out0.ROM0.read_en sky130_fd_sc_hd__dfxtp_1
Xno_spike$_SDFFE_PP0P_ clknet_leaf_176_clk _01952_ VSS VSS
+ VDD VDD net45 sky130_fd_sc_hd__dfxtp_1
Xresult_class\[0\]$_SDFFE_PP1P_ clknet_leaf_178_clk _01552_
+ VSS VSS VDD VDD net46 sky130_fd_sc_hd__dfxtp_1
Xresult_class\[1\]$_SDFFE_PP1P_ clknet_leaf_178_clk _01956_
+ VSS VSS VDD VDD net47 sky130_fd_sc_hd__dfxtp_1
Xstate\[0\]$_DFF_P_ clknet_leaf_178_clk _01250_ VSS VSS VDD
+ VDD state\[0\] sky130_fd_sc_hd__dfxtp_1
Xstate\[1\]$_DFF_P_ clknet_leaf_181_clk _01251_ VSS VSS VDD
+ VDD state\[1\] sky130_fd_sc_hd__dfxtp_1
Xstate\[2\]$_DFF_P_ clknet_leaf_167_clk _01249_ VSS VSS VDD
+ VDD state\[2\] sky130_fd_sc_hd__dfxtp_1
Xnetwork.neuron_out0.IF0.membrane_potential\[10\]$_SDFF_PP0__1
+ VSS VSS VDD VDD _unconnected_0 net sky130_fd_sc_hd__conb_1
Xnetwork.neuron_out0.IF0.membrane_potential\[8\]$_SDFF_PP0__2
+ VSS VSS VDD VDD _unconnected_1 net1 sky130_fd_sc_hd__conb_1
Xnetwork.neuron_out0.IF0.membrane_potential\[9\]$_SDFF_PP0__3
+ VSS VSS VDD VDD _unconnected_2 net2 sky130_fd_sc_hd__conb_1
Xnetwork.neuron_out1.IF0.membrane_potential\[10\]$_SDFF_PP0__4
+ VSS VSS VDD VDD _unconnected_3 net3 sky130_fd_sc_hd__conb_1
Xnetwork.neuron_out1.IF0.membrane_potential\[8\]$_SDFF_PP0__5
+ VSS VSS VDD VDD _unconnected_4 net4 sky130_fd_sc_hd__conb_1
Xnetwork.neuron_out1.IF0.membrane_potential\[9\]$_SDFF_PP0__6
+ VSS VSS VDD VDD _unconnected_5 net5 sky130_fd_sc_hd__conb_1
Xnetwork.neuron_out2.IF0.membrane_potential\[10\]$_SDFF_PP0__7
+ VSS VSS VDD VDD _unconnected_6 net6 sky130_fd_sc_hd__conb_1
Xnetwork.neuron_out2.IF0.membrane_potential\[8\]$_SDFF_PP0__8
+ VSS VSS VDD VDD _unconnected_7 net7 sky130_fd_sc_hd__conb_1
Xnetwork.neuron_out2.IF0.membrane_potential\[9\]$_SDFF_PP0__9
+ VSS VSS VDD VDD _unconnected_8 net8 sky130_fd_sc_hd__conb_1
Xnetwork.neuron_out3.IF0.membrane_potential\[10\]$_SDFF_PP0__10
+ VSS VSS VDD VDD _unconnected_9 net9 sky130_fd_sc_hd__conb_1
Xnetwork.neuron_out3.IF0.membrane_potential\[8\]$_SDFF_PP0__11
+ VSS VSS VDD VDD _unconnected_10 net10 sky130_fd_sc_hd__conb_1
Xnetwork.neuron_out3.IF0.membrane_potential\[9\]$_SDFF_PP0__12
+ VSS VSS VDD VDD _unconnected_11 net11 sky130_fd_sc_hd__conb_1
Xnetwork.neuron_out4.IF0.membrane_potential\[10\]$_SDFF_PP0__13
+ VSS VSS VDD VDD _unconnected_12 net12 sky130_fd_sc_hd__conb_1
Xnetwork.neuron_out4.IF0.membrane_potential\[8\]$_SDFF_PP0__14
+ VSS VSS VDD VDD _unconnected_13 net13 sky130_fd_sc_hd__conb_1
Xnetwork.neuron_out4.IF0.membrane_potential\[9\]$_SDFF_PP0__15
+ VSS VSS VDD VDD _unconnected_14 net14 sky130_fd_sc_hd__conb_1
Xnetwork.neuron_out5.IF0.membrane_potential\[10\]$_SDFF_PP0__16
+ VSS VSS VDD VDD _unconnected_15 net15 sky130_fd_sc_hd__conb_1
Xnetwork.neuron_out5.IF0.membrane_potential\[8\]$_SDFF_PP0__17
+ VSS VSS VDD VDD _unconnected_16 net16 sky130_fd_sc_hd__conb_1
Xnetwork.neuron_out5.IF0.membrane_potential\[9\]$_SDFF_PP0__18
+ VSS VSS VDD VDD _unconnected_17 net17 sky130_fd_sc_hd__conb_1
XTAP_TAPCELL_ROW_0_1 VSS VDD sky130_fd_sc_hd__tapvpwrvgnd_1
XTAP_TAPCELL_ROW_0_2 VSS VDD sky130_fd_sc_hd__tapvpwrvgnd_1
XTAP_TAPCELL_ROW_0_3 VSS VDD sky130_fd_sc_hd__tapvpwrvgnd_1
XTAP_TAPCELL_ROW_0_4 VSS VDD sky130_fd_sc_hd__tapvpwrvgnd_1
XTAP_TAPCELL_ROW_0_5 VSS VDD sky130_fd_sc_hd__tapvpwrvgnd_1
XTAP_TAPCELL_ROW_0_6 VSS VDD sky130_fd_sc_hd__tapvpwrvgnd_1
XTAP_TAPCELL_ROW_0_7 VSS VDD sky130_fd_sc_hd__tapvpwrvgnd_1
XTAP_TAPCELL_ROW_0_8 VSS VDD sky130_fd_sc_hd__tapvpwrvgnd_1
XTAP_TAPCELL_ROW_0_9 VSS VDD sky130_fd_sc_hd__tapvpwrvgnd_1
XTAP_TAPCELL_ROW_0_10 VSS VDD sky130_fd_sc_hd__tapvpwrvgnd_1
XTAP_TAPCELL_ROW_0_11 VSS VDD sky130_fd_sc_hd__tapvpwrvgnd_1
XTAP_TAPCELL_ROW_0_12 VSS VDD sky130_fd_sc_hd__tapvpwrvgnd_1
XTAP_TAPCELL_ROW_0_13 VSS VDD sky130_fd_sc_hd__tapvpwrvgnd_1
XTAP_TAPCELL_ROW_0_14 VSS VDD sky130_fd_sc_hd__tapvpwrvgnd_1
XTAP_TAPCELL_ROW_0_15 VSS VDD sky130_fd_sc_hd__tapvpwrvgnd_1
XTAP_TAPCELL_ROW_0_16 VSS VDD sky130_fd_sc_hd__tapvpwrvgnd_1
XTAP_TAPCELL_ROW_0_17 VSS VDD sky130_fd_sc_hd__tapvpwrvgnd_1
XTAP_TAPCELL_ROW_0_18 VSS VDD sky130_fd_sc_hd__tapvpwrvgnd_1
XTAP_TAPCELL_ROW_0_19 VSS VDD sky130_fd_sc_hd__tapvpwrvgnd_1
XTAP_TAPCELL_ROW_0_20 VSS VDD sky130_fd_sc_hd__tapvpwrvgnd_1
XTAP_TAPCELL_ROW_0_21 VSS VDD sky130_fd_sc_hd__tapvpwrvgnd_1
XTAP_TAPCELL_ROW_0_22 VSS VDD sky130_fd_sc_hd__tapvpwrvgnd_1
XTAP_TAPCELL_ROW_0_23 VSS VDD sky130_fd_sc_hd__tapvpwrvgnd_1
XTAP_TAPCELL_ROW_0_24 VSS VDD sky130_fd_sc_hd__tapvpwrvgnd_1
XTAP_TAPCELL_ROW_0_25 VSS VDD sky130_fd_sc_hd__tapvpwrvgnd_1
XTAP_TAPCELL_ROW_0_26 VSS VDD sky130_fd_sc_hd__tapvpwrvgnd_1
XTAP_TAPCELL_ROW_0_27 VSS VDD sky130_fd_sc_hd__tapvpwrvgnd_1
XTAP_TAPCELL_ROW_0_28 VSS VDD sky130_fd_sc_hd__tapvpwrvgnd_1
XTAP_TAPCELL_ROW_0_29 VSS VDD sky130_fd_sc_hd__tapvpwrvgnd_1
XTAP_TAPCELL_ROW_0_30 VSS VDD sky130_fd_sc_hd__tapvpwrvgnd_1
XTAP_TAPCELL_ROW_0_31 VSS VDD sky130_fd_sc_hd__tapvpwrvgnd_1
XTAP_TAPCELL_ROW_0_32 VSS VDD sky130_fd_sc_hd__tapvpwrvgnd_1
XTAP_TAPCELL_ROW_0_33 VSS VDD sky130_fd_sc_hd__tapvpwrvgnd_1
XTAP_TAPCELL_ROW_0_34 VSS VDD sky130_fd_sc_hd__tapvpwrvgnd_1
XTAP_TAPCELL_ROW_0_35 VSS VDD sky130_fd_sc_hd__tapvpwrvgnd_1
XTAP_TAPCELL_ROW_0_36 VSS VDD sky130_fd_sc_hd__tapvpwrvgnd_1
XTAP_TAPCELL_ROW_0_37 VSS VDD sky130_fd_sc_hd__tapvpwrvgnd_1
XTAP_TAPCELL_ROW_0_38 VSS VDD sky130_fd_sc_hd__tapvpwrvgnd_1
XTAP_TAPCELL_ROW_0_39 VSS VDD sky130_fd_sc_hd__tapvpwrvgnd_1
XTAP_TAPCELL_ROW_0_40 VSS VDD sky130_fd_sc_hd__tapvpwrvgnd_1
XTAP_TAPCELL_ROW_0_41 VSS VDD sky130_fd_sc_hd__tapvpwrvgnd_1
XTAP_TAPCELL_ROW_1_42 VSS VDD sky130_fd_sc_hd__tapvpwrvgnd_1
XTAP_TAPCELL_ROW_1_43 VSS VDD sky130_fd_sc_hd__tapvpwrvgnd_1
XTAP_TAPCELL_ROW_1_44 VSS VDD sky130_fd_sc_hd__tapvpwrvgnd_1
XTAP_TAPCELL_ROW_1_45 VSS VDD sky130_fd_sc_hd__tapvpwrvgnd_1
XTAP_TAPCELL_ROW_1_46 VSS VDD sky130_fd_sc_hd__tapvpwrvgnd_1
XTAP_TAPCELL_ROW_1_47 VSS VDD sky130_fd_sc_hd__tapvpwrvgnd_1
XTAP_TAPCELL_ROW_1_48 VSS VDD sky130_fd_sc_hd__tapvpwrvgnd_1
XTAP_TAPCELL_ROW_1_49 VSS VDD sky130_fd_sc_hd__tapvpwrvgnd_1
XTAP_TAPCELL_ROW_1_50 VSS VDD sky130_fd_sc_hd__tapvpwrvgnd_1
XTAP_TAPCELL_ROW_1_51 VSS VDD sky130_fd_sc_hd__tapvpwrvgnd_1
XTAP_TAPCELL_ROW_1_52 VSS VDD sky130_fd_sc_hd__tapvpwrvgnd_1
XTAP_TAPCELL_ROW_1_53 VSS VDD sky130_fd_sc_hd__tapvpwrvgnd_1
XTAP_TAPCELL_ROW_1_54 VSS VDD sky130_fd_sc_hd__tapvpwrvgnd_1
XTAP_TAPCELL_ROW_1_55 VSS VDD sky130_fd_sc_hd__tapvpwrvgnd_1
XTAP_TAPCELL_ROW_1_56 VSS VDD sky130_fd_sc_hd__tapvpwrvgnd_1
XTAP_TAPCELL_ROW_1_57 VSS VDD sky130_fd_sc_hd__tapvpwrvgnd_1
XTAP_TAPCELL_ROW_1_58 VSS VDD sky130_fd_sc_hd__tapvpwrvgnd_1
XTAP_TAPCELL_ROW_1_59 VSS VDD sky130_fd_sc_hd__tapvpwrvgnd_1
XTAP_TAPCELL_ROW_1_60 VSS VDD sky130_fd_sc_hd__tapvpwrvgnd_1
XTAP_TAPCELL_ROW_1_61 VSS VDD sky130_fd_sc_hd__tapvpwrvgnd_1
XTAP_TAPCELL_ROW_1_62 VSS VDD sky130_fd_sc_hd__tapvpwrvgnd_1
XTAP_TAPCELL_ROW_2_63 VSS VDD sky130_fd_sc_hd__tapvpwrvgnd_1
XTAP_TAPCELL_ROW_2_64 VSS VDD sky130_fd_sc_hd__tapvpwrvgnd_1
XTAP_TAPCELL_ROW_2_65 VSS VDD sky130_fd_sc_hd__tapvpwrvgnd_1
XTAP_TAPCELL_ROW_2_66 VSS VDD sky130_fd_sc_hd__tapvpwrvgnd_1
XTAP_TAPCELL_ROW_2_67 VSS VDD sky130_fd_sc_hd__tapvpwrvgnd_1
XTAP_TAPCELL_ROW_2_68 VSS VDD sky130_fd_sc_hd__tapvpwrvgnd_1
XTAP_TAPCELL_ROW_2_69 VSS VDD sky130_fd_sc_hd__tapvpwrvgnd_1
XTAP_TAPCELL_ROW_2_70 VSS VDD sky130_fd_sc_hd__tapvpwrvgnd_1
XTAP_TAPCELL_ROW_2_71 VSS VDD sky130_fd_sc_hd__tapvpwrvgnd_1
XTAP_TAPCELL_ROW_2_72 VSS VDD sky130_fd_sc_hd__tapvpwrvgnd_1
XTAP_TAPCELL_ROW_2_73 VSS VDD sky130_fd_sc_hd__tapvpwrvgnd_1
XTAP_TAPCELL_ROW_2_74 VSS VDD sky130_fd_sc_hd__tapvpwrvgnd_1
XTAP_TAPCELL_ROW_2_75 VSS VDD sky130_fd_sc_hd__tapvpwrvgnd_1
XTAP_TAPCELL_ROW_2_76 VSS VDD sky130_fd_sc_hd__tapvpwrvgnd_1
XTAP_TAPCELL_ROW_2_77 VSS VDD sky130_fd_sc_hd__tapvpwrvgnd_1
XTAP_TAPCELL_ROW_2_78 VSS VDD sky130_fd_sc_hd__tapvpwrvgnd_1
XTAP_TAPCELL_ROW_2_79 VSS VDD sky130_fd_sc_hd__tapvpwrvgnd_1
XTAP_TAPCELL_ROW_2_80 VSS VDD sky130_fd_sc_hd__tapvpwrvgnd_1
XTAP_TAPCELL_ROW_2_81 VSS VDD sky130_fd_sc_hd__tapvpwrvgnd_1
XTAP_TAPCELL_ROW_2_82 VSS VDD sky130_fd_sc_hd__tapvpwrvgnd_1
XTAP_TAPCELL_ROW_2_83 VSS VDD sky130_fd_sc_hd__tapvpwrvgnd_1
XTAP_TAPCELL_ROW_3_84 VSS VDD sky130_fd_sc_hd__tapvpwrvgnd_1
XTAP_TAPCELL_ROW_3_85 VSS VDD sky130_fd_sc_hd__tapvpwrvgnd_1
XTAP_TAPCELL_ROW_3_86 VSS VDD sky130_fd_sc_hd__tapvpwrvgnd_1
XTAP_TAPCELL_ROW_3_87 VSS VDD sky130_fd_sc_hd__tapvpwrvgnd_1
XTAP_TAPCELL_ROW_3_88 VSS VDD sky130_fd_sc_hd__tapvpwrvgnd_1
XTAP_TAPCELL_ROW_3_89 VSS VDD sky130_fd_sc_hd__tapvpwrvgnd_1
XTAP_TAPCELL_ROW_3_90 VSS VDD sky130_fd_sc_hd__tapvpwrvgnd_1
XTAP_TAPCELL_ROW_3_91 VSS VDD sky130_fd_sc_hd__tapvpwrvgnd_1
XTAP_TAPCELL_ROW_3_92 VSS VDD sky130_fd_sc_hd__tapvpwrvgnd_1
XTAP_TAPCELL_ROW_3_93 VSS VDD sky130_fd_sc_hd__tapvpwrvgnd_1
XTAP_TAPCELL_ROW_3_94 VSS VDD sky130_fd_sc_hd__tapvpwrvgnd_1
XTAP_TAPCELL_ROW_3_95 VSS VDD sky130_fd_sc_hd__tapvpwrvgnd_1
XTAP_TAPCELL_ROW_3_96 VSS VDD sky130_fd_sc_hd__tapvpwrvgnd_1
XTAP_TAPCELL_ROW_3_97 VSS VDD sky130_fd_sc_hd__tapvpwrvgnd_1
XTAP_TAPCELL_ROW_3_98 VSS VDD sky130_fd_sc_hd__tapvpwrvgnd_1
XTAP_TAPCELL_ROW_3_99 VSS VDD sky130_fd_sc_hd__tapvpwrvgnd_1
XTAP_TAPCELL_ROW_3_100 VSS VDD sky130_fd_sc_hd__tapvpwrvgnd_1
XTAP_TAPCELL_ROW_3_101 VSS VDD sky130_fd_sc_hd__tapvpwrvgnd_1
XTAP_TAPCELL_ROW_3_102 VSS VDD sky130_fd_sc_hd__tapvpwrvgnd_1
XTAP_TAPCELL_ROW_3_103 VSS VDD sky130_fd_sc_hd__tapvpwrvgnd_1
XTAP_TAPCELL_ROW_3_104 VSS VDD sky130_fd_sc_hd__tapvpwrvgnd_1
XTAP_TAPCELL_ROW_4_105 VSS VDD sky130_fd_sc_hd__tapvpwrvgnd_1
XTAP_TAPCELL_ROW_4_106 VSS VDD sky130_fd_sc_hd__tapvpwrvgnd_1
XTAP_TAPCELL_ROW_4_107 VSS VDD sky130_fd_sc_hd__tapvpwrvgnd_1
XTAP_TAPCELL_ROW_4_108 VSS VDD sky130_fd_sc_hd__tapvpwrvgnd_1
XTAP_TAPCELL_ROW_4_109 VSS VDD sky130_fd_sc_hd__tapvpwrvgnd_1
XTAP_TAPCELL_ROW_4_110 VSS VDD sky130_fd_sc_hd__tapvpwrvgnd_1
XTAP_TAPCELL_ROW_4_111 VSS VDD sky130_fd_sc_hd__tapvpwrvgnd_1
XTAP_TAPCELL_ROW_4_112 VSS VDD sky130_fd_sc_hd__tapvpwrvgnd_1
XTAP_TAPCELL_ROW_4_113 VSS VDD sky130_fd_sc_hd__tapvpwrvgnd_1
XTAP_TAPCELL_ROW_4_114 VSS VDD sky130_fd_sc_hd__tapvpwrvgnd_1
XTAP_TAPCELL_ROW_4_115 VSS VDD sky130_fd_sc_hd__tapvpwrvgnd_1
XTAP_TAPCELL_ROW_4_116 VSS VDD sky130_fd_sc_hd__tapvpwrvgnd_1
XTAP_TAPCELL_ROW_4_117 VSS VDD sky130_fd_sc_hd__tapvpwrvgnd_1
XTAP_TAPCELL_ROW_4_118 VSS VDD sky130_fd_sc_hd__tapvpwrvgnd_1
XTAP_TAPCELL_ROW_4_119 VSS VDD sky130_fd_sc_hd__tapvpwrvgnd_1
XTAP_TAPCELL_ROW_4_120 VSS VDD sky130_fd_sc_hd__tapvpwrvgnd_1
XTAP_TAPCELL_ROW_4_121 VSS VDD sky130_fd_sc_hd__tapvpwrvgnd_1
XTAP_TAPCELL_ROW_4_122 VSS VDD sky130_fd_sc_hd__tapvpwrvgnd_1
XTAP_TAPCELL_ROW_4_123 VSS VDD sky130_fd_sc_hd__tapvpwrvgnd_1
XTAP_TAPCELL_ROW_4_124 VSS VDD sky130_fd_sc_hd__tapvpwrvgnd_1
XTAP_TAPCELL_ROW_4_125 VSS VDD sky130_fd_sc_hd__tapvpwrvgnd_1
XTAP_TAPCELL_ROW_5_126 VSS VDD sky130_fd_sc_hd__tapvpwrvgnd_1
XTAP_TAPCELL_ROW_5_127 VSS VDD sky130_fd_sc_hd__tapvpwrvgnd_1
XTAP_TAPCELL_ROW_5_128 VSS VDD sky130_fd_sc_hd__tapvpwrvgnd_1
XTAP_TAPCELL_ROW_5_129 VSS VDD sky130_fd_sc_hd__tapvpwrvgnd_1
XTAP_TAPCELL_ROW_5_130 VSS VDD sky130_fd_sc_hd__tapvpwrvgnd_1
XTAP_TAPCELL_ROW_5_131 VSS VDD sky130_fd_sc_hd__tapvpwrvgnd_1
XTAP_TAPCELL_ROW_5_132 VSS VDD sky130_fd_sc_hd__tapvpwrvgnd_1
XTAP_TAPCELL_ROW_5_133 VSS VDD sky130_fd_sc_hd__tapvpwrvgnd_1
XTAP_TAPCELL_ROW_5_134 VSS VDD sky130_fd_sc_hd__tapvpwrvgnd_1
XTAP_TAPCELL_ROW_5_135 VSS VDD sky130_fd_sc_hd__tapvpwrvgnd_1
XTAP_TAPCELL_ROW_5_136 VSS VDD sky130_fd_sc_hd__tapvpwrvgnd_1
XTAP_TAPCELL_ROW_5_137 VSS VDD sky130_fd_sc_hd__tapvpwrvgnd_1
XTAP_TAPCELL_ROW_5_138 VSS VDD sky130_fd_sc_hd__tapvpwrvgnd_1
XTAP_TAPCELL_ROW_5_139 VSS VDD sky130_fd_sc_hd__tapvpwrvgnd_1
XTAP_TAPCELL_ROW_5_140 VSS VDD sky130_fd_sc_hd__tapvpwrvgnd_1
XTAP_TAPCELL_ROW_5_141 VSS VDD sky130_fd_sc_hd__tapvpwrvgnd_1
XTAP_TAPCELL_ROW_5_142 VSS VDD sky130_fd_sc_hd__tapvpwrvgnd_1
XTAP_TAPCELL_ROW_5_143 VSS VDD sky130_fd_sc_hd__tapvpwrvgnd_1
XTAP_TAPCELL_ROW_5_144 VSS VDD sky130_fd_sc_hd__tapvpwrvgnd_1
XTAP_TAPCELL_ROW_5_145 VSS VDD sky130_fd_sc_hd__tapvpwrvgnd_1
XTAP_TAPCELL_ROW_5_146 VSS VDD sky130_fd_sc_hd__tapvpwrvgnd_1
XTAP_TAPCELL_ROW_6_147 VSS VDD sky130_fd_sc_hd__tapvpwrvgnd_1
XTAP_TAPCELL_ROW_6_148 VSS VDD sky130_fd_sc_hd__tapvpwrvgnd_1
XTAP_TAPCELL_ROW_6_149 VSS VDD sky130_fd_sc_hd__tapvpwrvgnd_1
XTAP_TAPCELL_ROW_6_150 VSS VDD sky130_fd_sc_hd__tapvpwrvgnd_1
XTAP_TAPCELL_ROW_6_151 VSS VDD sky130_fd_sc_hd__tapvpwrvgnd_1
XTAP_TAPCELL_ROW_6_152 VSS VDD sky130_fd_sc_hd__tapvpwrvgnd_1
XTAP_TAPCELL_ROW_6_153 VSS VDD sky130_fd_sc_hd__tapvpwrvgnd_1
XTAP_TAPCELL_ROW_6_154 VSS VDD sky130_fd_sc_hd__tapvpwrvgnd_1
XTAP_TAPCELL_ROW_6_155 VSS VDD sky130_fd_sc_hd__tapvpwrvgnd_1
XTAP_TAPCELL_ROW_6_156 VSS VDD sky130_fd_sc_hd__tapvpwrvgnd_1
XTAP_TAPCELL_ROW_6_157 VSS VDD sky130_fd_sc_hd__tapvpwrvgnd_1
XTAP_TAPCELL_ROW_6_158 VSS VDD sky130_fd_sc_hd__tapvpwrvgnd_1
XTAP_TAPCELL_ROW_6_159 VSS VDD sky130_fd_sc_hd__tapvpwrvgnd_1
XTAP_TAPCELL_ROW_6_160 VSS VDD sky130_fd_sc_hd__tapvpwrvgnd_1
XTAP_TAPCELL_ROW_6_161 VSS VDD sky130_fd_sc_hd__tapvpwrvgnd_1
XTAP_TAPCELL_ROW_6_162 VSS VDD sky130_fd_sc_hd__tapvpwrvgnd_1
XTAP_TAPCELL_ROW_6_163 VSS VDD sky130_fd_sc_hd__tapvpwrvgnd_1
XTAP_TAPCELL_ROW_6_164 VSS VDD sky130_fd_sc_hd__tapvpwrvgnd_1
XTAP_TAPCELL_ROW_6_165 VSS VDD sky130_fd_sc_hd__tapvpwrvgnd_1
XTAP_TAPCELL_ROW_6_166 VSS VDD sky130_fd_sc_hd__tapvpwrvgnd_1
XTAP_TAPCELL_ROW_6_167 VSS VDD sky130_fd_sc_hd__tapvpwrvgnd_1
XTAP_TAPCELL_ROW_7_168 VSS VDD sky130_fd_sc_hd__tapvpwrvgnd_1
XTAP_TAPCELL_ROW_7_169 VSS VDD sky130_fd_sc_hd__tapvpwrvgnd_1
XTAP_TAPCELL_ROW_7_170 VSS VDD sky130_fd_sc_hd__tapvpwrvgnd_1
XTAP_TAPCELL_ROW_7_171 VSS VDD sky130_fd_sc_hd__tapvpwrvgnd_1
XTAP_TAPCELL_ROW_7_172 VSS VDD sky130_fd_sc_hd__tapvpwrvgnd_1
XTAP_TAPCELL_ROW_7_173 VSS VDD sky130_fd_sc_hd__tapvpwrvgnd_1
XTAP_TAPCELL_ROW_7_174 VSS VDD sky130_fd_sc_hd__tapvpwrvgnd_1
XTAP_TAPCELL_ROW_7_175 VSS VDD sky130_fd_sc_hd__tapvpwrvgnd_1
XTAP_TAPCELL_ROW_7_176 VSS VDD sky130_fd_sc_hd__tapvpwrvgnd_1
XTAP_TAPCELL_ROW_7_177 VSS VDD sky130_fd_sc_hd__tapvpwrvgnd_1
XTAP_TAPCELL_ROW_7_178 VSS VDD sky130_fd_sc_hd__tapvpwrvgnd_1
XTAP_TAPCELL_ROW_7_179 VSS VDD sky130_fd_sc_hd__tapvpwrvgnd_1
XTAP_TAPCELL_ROW_7_180 VSS VDD sky130_fd_sc_hd__tapvpwrvgnd_1
XTAP_TAPCELL_ROW_7_181 VSS VDD sky130_fd_sc_hd__tapvpwrvgnd_1
XTAP_TAPCELL_ROW_7_182 VSS VDD sky130_fd_sc_hd__tapvpwrvgnd_1
XTAP_TAPCELL_ROW_7_183 VSS VDD sky130_fd_sc_hd__tapvpwrvgnd_1
XTAP_TAPCELL_ROW_7_184 VSS VDD sky130_fd_sc_hd__tapvpwrvgnd_1
XTAP_TAPCELL_ROW_7_185 VSS VDD sky130_fd_sc_hd__tapvpwrvgnd_1
XTAP_TAPCELL_ROW_7_186 VSS VDD sky130_fd_sc_hd__tapvpwrvgnd_1
XTAP_TAPCELL_ROW_7_187 VSS VDD sky130_fd_sc_hd__tapvpwrvgnd_1
XTAP_TAPCELL_ROW_7_188 VSS VDD sky130_fd_sc_hd__tapvpwrvgnd_1
XTAP_TAPCELL_ROW_8_189 VSS VDD sky130_fd_sc_hd__tapvpwrvgnd_1
XTAP_TAPCELL_ROW_8_190 VSS VDD sky130_fd_sc_hd__tapvpwrvgnd_1
XTAP_TAPCELL_ROW_8_191 VSS VDD sky130_fd_sc_hd__tapvpwrvgnd_1
XTAP_TAPCELL_ROW_8_192 VSS VDD sky130_fd_sc_hd__tapvpwrvgnd_1
XTAP_TAPCELL_ROW_8_193 VSS VDD sky130_fd_sc_hd__tapvpwrvgnd_1
XTAP_TAPCELL_ROW_8_194 VSS VDD sky130_fd_sc_hd__tapvpwrvgnd_1
XTAP_TAPCELL_ROW_8_195 VSS VDD sky130_fd_sc_hd__tapvpwrvgnd_1
XTAP_TAPCELL_ROW_8_196 VSS VDD sky130_fd_sc_hd__tapvpwrvgnd_1
XTAP_TAPCELL_ROW_8_197 VSS VDD sky130_fd_sc_hd__tapvpwrvgnd_1
XTAP_TAPCELL_ROW_8_198 VSS VDD sky130_fd_sc_hd__tapvpwrvgnd_1
XTAP_TAPCELL_ROW_8_199 VSS VDD sky130_fd_sc_hd__tapvpwrvgnd_1
XTAP_TAPCELL_ROW_8_200 VSS VDD sky130_fd_sc_hd__tapvpwrvgnd_1
XTAP_TAPCELL_ROW_8_201 VSS VDD sky130_fd_sc_hd__tapvpwrvgnd_1
XTAP_TAPCELL_ROW_8_202 VSS VDD sky130_fd_sc_hd__tapvpwrvgnd_1
XTAP_TAPCELL_ROW_8_203 VSS VDD sky130_fd_sc_hd__tapvpwrvgnd_1
XTAP_TAPCELL_ROW_8_204 VSS VDD sky130_fd_sc_hd__tapvpwrvgnd_1
XTAP_TAPCELL_ROW_8_205 VSS VDD sky130_fd_sc_hd__tapvpwrvgnd_1
XTAP_TAPCELL_ROW_8_206 VSS VDD sky130_fd_sc_hd__tapvpwrvgnd_1
XTAP_TAPCELL_ROW_8_207 VSS VDD sky130_fd_sc_hd__tapvpwrvgnd_1
XTAP_TAPCELL_ROW_8_208 VSS VDD sky130_fd_sc_hd__tapvpwrvgnd_1
XTAP_TAPCELL_ROW_8_209 VSS VDD sky130_fd_sc_hd__tapvpwrvgnd_1
XTAP_TAPCELL_ROW_9_210 VSS VDD sky130_fd_sc_hd__tapvpwrvgnd_1
XTAP_TAPCELL_ROW_9_211 VSS VDD sky130_fd_sc_hd__tapvpwrvgnd_1
XTAP_TAPCELL_ROW_9_212 VSS VDD sky130_fd_sc_hd__tapvpwrvgnd_1
XTAP_TAPCELL_ROW_9_213 VSS VDD sky130_fd_sc_hd__tapvpwrvgnd_1
XTAP_TAPCELL_ROW_9_214 VSS VDD sky130_fd_sc_hd__tapvpwrvgnd_1
XTAP_TAPCELL_ROW_9_215 VSS VDD sky130_fd_sc_hd__tapvpwrvgnd_1
XTAP_TAPCELL_ROW_9_216 VSS VDD sky130_fd_sc_hd__tapvpwrvgnd_1
XTAP_TAPCELL_ROW_9_217 VSS VDD sky130_fd_sc_hd__tapvpwrvgnd_1
XTAP_TAPCELL_ROW_9_218 VSS VDD sky130_fd_sc_hd__tapvpwrvgnd_1
XTAP_TAPCELL_ROW_9_219 VSS VDD sky130_fd_sc_hd__tapvpwrvgnd_1
XTAP_TAPCELL_ROW_9_220 VSS VDD sky130_fd_sc_hd__tapvpwrvgnd_1
XTAP_TAPCELL_ROW_9_221 VSS VDD sky130_fd_sc_hd__tapvpwrvgnd_1
XTAP_TAPCELL_ROW_9_222 VSS VDD sky130_fd_sc_hd__tapvpwrvgnd_1
XTAP_TAPCELL_ROW_9_223 VSS VDD sky130_fd_sc_hd__tapvpwrvgnd_1
XTAP_TAPCELL_ROW_9_224 VSS VDD sky130_fd_sc_hd__tapvpwrvgnd_1
XTAP_TAPCELL_ROW_9_225 VSS VDD sky130_fd_sc_hd__tapvpwrvgnd_1
XTAP_TAPCELL_ROW_9_226 VSS VDD sky130_fd_sc_hd__tapvpwrvgnd_1
XTAP_TAPCELL_ROW_9_227 VSS VDD sky130_fd_sc_hd__tapvpwrvgnd_1
XTAP_TAPCELL_ROW_9_228 VSS VDD sky130_fd_sc_hd__tapvpwrvgnd_1
XTAP_TAPCELL_ROW_9_229 VSS VDD sky130_fd_sc_hd__tapvpwrvgnd_1
XTAP_TAPCELL_ROW_9_230 VSS VDD sky130_fd_sc_hd__tapvpwrvgnd_1
XTAP_TAPCELL_ROW_10_231 VSS VDD sky130_fd_sc_hd__tapvpwrvgnd_1
XTAP_TAPCELL_ROW_10_232 VSS VDD sky130_fd_sc_hd__tapvpwrvgnd_1
XTAP_TAPCELL_ROW_10_233 VSS VDD sky130_fd_sc_hd__tapvpwrvgnd_1
XTAP_TAPCELL_ROW_10_234 VSS VDD sky130_fd_sc_hd__tapvpwrvgnd_1
XTAP_TAPCELL_ROW_10_235 VSS VDD sky130_fd_sc_hd__tapvpwrvgnd_1
XTAP_TAPCELL_ROW_10_236 VSS VDD sky130_fd_sc_hd__tapvpwrvgnd_1
XTAP_TAPCELL_ROW_10_237 VSS VDD sky130_fd_sc_hd__tapvpwrvgnd_1
XTAP_TAPCELL_ROW_10_238 VSS VDD sky130_fd_sc_hd__tapvpwrvgnd_1
XTAP_TAPCELL_ROW_10_239 VSS VDD sky130_fd_sc_hd__tapvpwrvgnd_1
XTAP_TAPCELL_ROW_10_240 VSS VDD sky130_fd_sc_hd__tapvpwrvgnd_1
XTAP_TAPCELL_ROW_10_241 VSS VDD sky130_fd_sc_hd__tapvpwrvgnd_1
XTAP_TAPCELL_ROW_10_242 VSS VDD sky130_fd_sc_hd__tapvpwrvgnd_1
XTAP_TAPCELL_ROW_10_243 VSS VDD sky130_fd_sc_hd__tapvpwrvgnd_1
XTAP_TAPCELL_ROW_10_244 VSS VDD sky130_fd_sc_hd__tapvpwrvgnd_1
XTAP_TAPCELL_ROW_10_245 VSS VDD sky130_fd_sc_hd__tapvpwrvgnd_1
XTAP_TAPCELL_ROW_10_246 VSS VDD sky130_fd_sc_hd__tapvpwrvgnd_1
XTAP_TAPCELL_ROW_10_247 VSS VDD sky130_fd_sc_hd__tapvpwrvgnd_1
XTAP_TAPCELL_ROW_10_248 VSS VDD sky130_fd_sc_hd__tapvpwrvgnd_1
XTAP_TAPCELL_ROW_10_249 VSS VDD sky130_fd_sc_hd__tapvpwrvgnd_1
XTAP_TAPCELL_ROW_10_250 VSS VDD sky130_fd_sc_hd__tapvpwrvgnd_1
XTAP_TAPCELL_ROW_10_251 VSS VDD sky130_fd_sc_hd__tapvpwrvgnd_1
XTAP_TAPCELL_ROW_11_252 VSS VDD sky130_fd_sc_hd__tapvpwrvgnd_1
XTAP_TAPCELL_ROW_11_253 VSS VDD sky130_fd_sc_hd__tapvpwrvgnd_1
XTAP_TAPCELL_ROW_11_254 VSS VDD sky130_fd_sc_hd__tapvpwrvgnd_1
XTAP_TAPCELL_ROW_11_255 VSS VDD sky130_fd_sc_hd__tapvpwrvgnd_1
XTAP_TAPCELL_ROW_11_256 VSS VDD sky130_fd_sc_hd__tapvpwrvgnd_1
XTAP_TAPCELL_ROW_11_257 VSS VDD sky130_fd_sc_hd__tapvpwrvgnd_1
XTAP_TAPCELL_ROW_11_258 VSS VDD sky130_fd_sc_hd__tapvpwrvgnd_1
XTAP_TAPCELL_ROW_11_259 VSS VDD sky130_fd_sc_hd__tapvpwrvgnd_1
XTAP_TAPCELL_ROW_11_260 VSS VDD sky130_fd_sc_hd__tapvpwrvgnd_1
XTAP_TAPCELL_ROW_11_261 VSS VDD sky130_fd_sc_hd__tapvpwrvgnd_1
XTAP_TAPCELL_ROW_11_262 VSS VDD sky130_fd_sc_hd__tapvpwrvgnd_1
XTAP_TAPCELL_ROW_11_263 VSS VDD sky130_fd_sc_hd__tapvpwrvgnd_1
XTAP_TAPCELL_ROW_11_264 VSS VDD sky130_fd_sc_hd__tapvpwrvgnd_1
XTAP_TAPCELL_ROW_11_265 VSS VDD sky130_fd_sc_hd__tapvpwrvgnd_1
XTAP_TAPCELL_ROW_11_266 VSS VDD sky130_fd_sc_hd__tapvpwrvgnd_1
XTAP_TAPCELL_ROW_11_267 VSS VDD sky130_fd_sc_hd__tapvpwrvgnd_1
XTAP_TAPCELL_ROW_11_268 VSS VDD sky130_fd_sc_hd__tapvpwrvgnd_1
XTAP_TAPCELL_ROW_11_269 VSS VDD sky130_fd_sc_hd__tapvpwrvgnd_1
XTAP_TAPCELL_ROW_11_270 VSS VDD sky130_fd_sc_hd__tapvpwrvgnd_1
XTAP_TAPCELL_ROW_11_271 VSS VDD sky130_fd_sc_hd__tapvpwrvgnd_1
XTAP_TAPCELL_ROW_11_272 VSS VDD sky130_fd_sc_hd__tapvpwrvgnd_1
XTAP_TAPCELL_ROW_12_273 VSS VDD sky130_fd_sc_hd__tapvpwrvgnd_1
XTAP_TAPCELL_ROW_12_274 VSS VDD sky130_fd_sc_hd__tapvpwrvgnd_1
XTAP_TAPCELL_ROW_12_275 VSS VDD sky130_fd_sc_hd__tapvpwrvgnd_1
XTAP_TAPCELL_ROW_12_276 VSS VDD sky130_fd_sc_hd__tapvpwrvgnd_1
XTAP_TAPCELL_ROW_12_277 VSS VDD sky130_fd_sc_hd__tapvpwrvgnd_1
XTAP_TAPCELL_ROW_12_278 VSS VDD sky130_fd_sc_hd__tapvpwrvgnd_1
XTAP_TAPCELL_ROW_12_279 VSS VDD sky130_fd_sc_hd__tapvpwrvgnd_1
XTAP_TAPCELL_ROW_12_280 VSS VDD sky130_fd_sc_hd__tapvpwrvgnd_1
XTAP_TAPCELL_ROW_12_281 VSS VDD sky130_fd_sc_hd__tapvpwrvgnd_1
XTAP_TAPCELL_ROW_12_282 VSS VDD sky130_fd_sc_hd__tapvpwrvgnd_1
XTAP_TAPCELL_ROW_12_283 VSS VDD sky130_fd_sc_hd__tapvpwrvgnd_1
XTAP_TAPCELL_ROW_12_284 VSS VDD sky130_fd_sc_hd__tapvpwrvgnd_1
XTAP_TAPCELL_ROW_12_285 VSS VDD sky130_fd_sc_hd__tapvpwrvgnd_1
XTAP_TAPCELL_ROW_12_286 VSS VDD sky130_fd_sc_hd__tapvpwrvgnd_1
XTAP_TAPCELL_ROW_12_287 VSS VDD sky130_fd_sc_hd__tapvpwrvgnd_1
XTAP_TAPCELL_ROW_12_288 VSS VDD sky130_fd_sc_hd__tapvpwrvgnd_1
XTAP_TAPCELL_ROW_12_289 VSS VDD sky130_fd_sc_hd__tapvpwrvgnd_1
XTAP_TAPCELL_ROW_12_290 VSS VDD sky130_fd_sc_hd__tapvpwrvgnd_1
XTAP_TAPCELL_ROW_12_291 VSS VDD sky130_fd_sc_hd__tapvpwrvgnd_1
XTAP_TAPCELL_ROW_12_292 VSS VDD sky130_fd_sc_hd__tapvpwrvgnd_1
XTAP_TAPCELL_ROW_12_293 VSS VDD sky130_fd_sc_hd__tapvpwrvgnd_1
XTAP_TAPCELL_ROW_13_294 VSS VDD sky130_fd_sc_hd__tapvpwrvgnd_1
XTAP_TAPCELL_ROW_13_295 VSS VDD sky130_fd_sc_hd__tapvpwrvgnd_1
XTAP_TAPCELL_ROW_13_296 VSS VDD sky130_fd_sc_hd__tapvpwrvgnd_1
XTAP_TAPCELL_ROW_13_297 VSS VDD sky130_fd_sc_hd__tapvpwrvgnd_1
XTAP_TAPCELL_ROW_13_298 VSS VDD sky130_fd_sc_hd__tapvpwrvgnd_1
XTAP_TAPCELL_ROW_13_299 VSS VDD sky130_fd_sc_hd__tapvpwrvgnd_1
XTAP_TAPCELL_ROW_13_300 VSS VDD sky130_fd_sc_hd__tapvpwrvgnd_1
XTAP_TAPCELL_ROW_13_301 VSS VDD sky130_fd_sc_hd__tapvpwrvgnd_1
XTAP_TAPCELL_ROW_13_302 VSS VDD sky130_fd_sc_hd__tapvpwrvgnd_1
XTAP_TAPCELL_ROW_13_303 VSS VDD sky130_fd_sc_hd__tapvpwrvgnd_1
XTAP_TAPCELL_ROW_13_304 VSS VDD sky130_fd_sc_hd__tapvpwrvgnd_1
XTAP_TAPCELL_ROW_13_305 VSS VDD sky130_fd_sc_hd__tapvpwrvgnd_1
XTAP_TAPCELL_ROW_13_306 VSS VDD sky130_fd_sc_hd__tapvpwrvgnd_1
XTAP_TAPCELL_ROW_13_307 VSS VDD sky130_fd_sc_hd__tapvpwrvgnd_1
XTAP_TAPCELL_ROW_13_308 VSS VDD sky130_fd_sc_hd__tapvpwrvgnd_1
XTAP_TAPCELL_ROW_13_309 VSS VDD sky130_fd_sc_hd__tapvpwrvgnd_1
XTAP_TAPCELL_ROW_13_310 VSS VDD sky130_fd_sc_hd__tapvpwrvgnd_1
XTAP_TAPCELL_ROW_13_311 VSS VDD sky130_fd_sc_hd__tapvpwrvgnd_1
XTAP_TAPCELL_ROW_13_312 VSS VDD sky130_fd_sc_hd__tapvpwrvgnd_1
XTAP_TAPCELL_ROW_13_313 VSS VDD sky130_fd_sc_hd__tapvpwrvgnd_1
XTAP_TAPCELL_ROW_13_314 VSS VDD sky130_fd_sc_hd__tapvpwrvgnd_1
XTAP_TAPCELL_ROW_14_315 VSS VDD sky130_fd_sc_hd__tapvpwrvgnd_1
XTAP_TAPCELL_ROW_14_316 VSS VDD sky130_fd_sc_hd__tapvpwrvgnd_1
XTAP_TAPCELL_ROW_14_317 VSS VDD sky130_fd_sc_hd__tapvpwrvgnd_1
XTAP_TAPCELL_ROW_14_318 VSS VDD sky130_fd_sc_hd__tapvpwrvgnd_1
XTAP_TAPCELL_ROW_14_319 VSS VDD sky130_fd_sc_hd__tapvpwrvgnd_1
XTAP_TAPCELL_ROW_14_320 VSS VDD sky130_fd_sc_hd__tapvpwrvgnd_1
XTAP_TAPCELL_ROW_14_321 VSS VDD sky130_fd_sc_hd__tapvpwrvgnd_1
XTAP_TAPCELL_ROW_14_322 VSS VDD sky130_fd_sc_hd__tapvpwrvgnd_1
XTAP_TAPCELL_ROW_14_323 VSS VDD sky130_fd_sc_hd__tapvpwrvgnd_1
XTAP_TAPCELL_ROW_14_324 VSS VDD sky130_fd_sc_hd__tapvpwrvgnd_1
XTAP_TAPCELL_ROW_14_325 VSS VDD sky130_fd_sc_hd__tapvpwrvgnd_1
XTAP_TAPCELL_ROW_14_326 VSS VDD sky130_fd_sc_hd__tapvpwrvgnd_1
XTAP_TAPCELL_ROW_14_327 VSS VDD sky130_fd_sc_hd__tapvpwrvgnd_1
XTAP_TAPCELL_ROW_14_328 VSS VDD sky130_fd_sc_hd__tapvpwrvgnd_1
XTAP_TAPCELL_ROW_14_329 VSS VDD sky130_fd_sc_hd__tapvpwrvgnd_1
XTAP_TAPCELL_ROW_14_330 VSS VDD sky130_fd_sc_hd__tapvpwrvgnd_1
XTAP_TAPCELL_ROW_14_331 VSS VDD sky130_fd_sc_hd__tapvpwrvgnd_1
XTAP_TAPCELL_ROW_14_332 VSS VDD sky130_fd_sc_hd__tapvpwrvgnd_1
XTAP_TAPCELL_ROW_14_333 VSS VDD sky130_fd_sc_hd__tapvpwrvgnd_1
XTAP_TAPCELL_ROW_14_334 VSS VDD sky130_fd_sc_hd__tapvpwrvgnd_1
XTAP_TAPCELL_ROW_14_335 VSS VDD sky130_fd_sc_hd__tapvpwrvgnd_1
XTAP_TAPCELL_ROW_15_336 VSS VDD sky130_fd_sc_hd__tapvpwrvgnd_1
XTAP_TAPCELL_ROW_15_337 VSS VDD sky130_fd_sc_hd__tapvpwrvgnd_1
XTAP_TAPCELL_ROW_15_338 VSS VDD sky130_fd_sc_hd__tapvpwrvgnd_1
XTAP_TAPCELL_ROW_15_339 VSS VDD sky130_fd_sc_hd__tapvpwrvgnd_1
XTAP_TAPCELL_ROW_15_340 VSS VDD sky130_fd_sc_hd__tapvpwrvgnd_1
XTAP_TAPCELL_ROW_15_341 VSS VDD sky130_fd_sc_hd__tapvpwrvgnd_1
XTAP_TAPCELL_ROW_15_342 VSS VDD sky130_fd_sc_hd__tapvpwrvgnd_1
XTAP_TAPCELL_ROW_15_343 VSS VDD sky130_fd_sc_hd__tapvpwrvgnd_1
XTAP_TAPCELL_ROW_15_344 VSS VDD sky130_fd_sc_hd__tapvpwrvgnd_1
XTAP_TAPCELL_ROW_15_345 VSS VDD sky130_fd_sc_hd__tapvpwrvgnd_1
XTAP_TAPCELL_ROW_15_346 VSS VDD sky130_fd_sc_hd__tapvpwrvgnd_1
XTAP_TAPCELL_ROW_15_347 VSS VDD sky130_fd_sc_hd__tapvpwrvgnd_1
XTAP_TAPCELL_ROW_15_348 VSS VDD sky130_fd_sc_hd__tapvpwrvgnd_1
XTAP_TAPCELL_ROW_15_349 VSS VDD sky130_fd_sc_hd__tapvpwrvgnd_1
XTAP_TAPCELL_ROW_15_350 VSS VDD sky130_fd_sc_hd__tapvpwrvgnd_1
XTAP_TAPCELL_ROW_15_351 VSS VDD sky130_fd_sc_hd__tapvpwrvgnd_1
XTAP_TAPCELL_ROW_15_352 VSS VDD sky130_fd_sc_hd__tapvpwrvgnd_1
XTAP_TAPCELL_ROW_15_353 VSS VDD sky130_fd_sc_hd__tapvpwrvgnd_1
XTAP_TAPCELL_ROW_15_354 VSS VDD sky130_fd_sc_hd__tapvpwrvgnd_1
XTAP_TAPCELL_ROW_15_355 VSS VDD sky130_fd_sc_hd__tapvpwrvgnd_1
XTAP_TAPCELL_ROW_15_356 VSS VDD sky130_fd_sc_hd__tapvpwrvgnd_1
XTAP_TAPCELL_ROW_16_357 VSS VDD sky130_fd_sc_hd__tapvpwrvgnd_1
XTAP_TAPCELL_ROW_16_358 VSS VDD sky130_fd_sc_hd__tapvpwrvgnd_1
XTAP_TAPCELL_ROW_16_359 VSS VDD sky130_fd_sc_hd__tapvpwrvgnd_1
XTAP_TAPCELL_ROW_16_360 VSS VDD sky130_fd_sc_hd__tapvpwrvgnd_1
XTAP_TAPCELL_ROW_16_361 VSS VDD sky130_fd_sc_hd__tapvpwrvgnd_1
XTAP_TAPCELL_ROW_16_362 VSS VDD sky130_fd_sc_hd__tapvpwrvgnd_1
XTAP_TAPCELL_ROW_16_363 VSS VDD sky130_fd_sc_hd__tapvpwrvgnd_1
XTAP_TAPCELL_ROW_16_364 VSS VDD sky130_fd_sc_hd__tapvpwrvgnd_1
XTAP_TAPCELL_ROW_16_365 VSS VDD sky130_fd_sc_hd__tapvpwrvgnd_1
XTAP_TAPCELL_ROW_16_366 VSS VDD sky130_fd_sc_hd__tapvpwrvgnd_1
XTAP_TAPCELL_ROW_16_367 VSS VDD sky130_fd_sc_hd__tapvpwrvgnd_1
XTAP_TAPCELL_ROW_16_368 VSS VDD sky130_fd_sc_hd__tapvpwrvgnd_1
XTAP_TAPCELL_ROW_16_369 VSS VDD sky130_fd_sc_hd__tapvpwrvgnd_1
XTAP_TAPCELL_ROW_16_370 VSS VDD sky130_fd_sc_hd__tapvpwrvgnd_1
XTAP_TAPCELL_ROW_16_371 VSS VDD sky130_fd_sc_hd__tapvpwrvgnd_1
XTAP_TAPCELL_ROW_16_372 VSS VDD sky130_fd_sc_hd__tapvpwrvgnd_1
XTAP_TAPCELL_ROW_16_373 VSS VDD sky130_fd_sc_hd__tapvpwrvgnd_1
XTAP_TAPCELL_ROW_16_374 VSS VDD sky130_fd_sc_hd__tapvpwrvgnd_1
XTAP_TAPCELL_ROW_16_375 VSS VDD sky130_fd_sc_hd__tapvpwrvgnd_1
XTAP_TAPCELL_ROW_16_376 VSS VDD sky130_fd_sc_hd__tapvpwrvgnd_1
XTAP_TAPCELL_ROW_16_377 VSS VDD sky130_fd_sc_hd__tapvpwrvgnd_1
XTAP_TAPCELL_ROW_17_378 VSS VDD sky130_fd_sc_hd__tapvpwrvgnd_1
XTAP_TAPCELL_ROW_17_379 VSS VDD sky130_fd_sc_hd__tapvpwrvgnd_1
XTAP_TAPCELL_ROW_17_380 VSS VDD sky130_fd_sc_hd__tapvpwrvgnd_1
XTAP_TAPCELL_ROW_17_381 VSS VDD sky130_fd_sc_hd__tapvpwrvgnd_1
XTAP_TAPCELL_ROW_17_382 VSS VDD sky130_fd_sc_hd__tapvpwrvgnd_1
XTAP_TAPCELL_ROW_17_383 VSS VDD sky130_fd_sc_hd__tapvpwrvgnd_1
XTAP_TAPCELL_ROW_17_384 VSS VDD sky130_fd_sc_hd__tapvpwrvgnd_1
XTAP_TAPCELL_ROW_17_385 VSS VDD sky130_fd_sc_hd__tapvpwrvgnd_1
XTAP_TAPCELL_ROW_17_386 VSS VDD sky130_fd_sc_hd__tapvpwrvgnd_1
XTAP_TAPCELL_ROW_17_387 VSS VDD sky130_fd_sc_hd__tapvpwrvgnd_1
XTAP_TAPCELL_ROW_17_388 VSS VDD sky130_fd_sc_hd__tapvpwrvgnd_1
XTAP_TAPCELL_ROW_17_389 VSS VDD sky130_fd_sc_hd__tapvpwrvgnd_1
XTAP_TAPCELL_ROW_17_390 VSS VDD sky130_fd_sc_hd__tapvpwrvgnd_1
XTAP_TAPCELL_ROW_17_391 VSS VDD sky130_fd_sc_hd__tapvpwrvgnd_1
XTAP_TAPCELL_ROW_17_392 VSS VDD sky130_fd_sc_hd__tapvpwrvgnd_1
XTAP_TAPCELL_ROW_17_393 VSS VDD sky130_fd_sc_hd__tapvpwrvgnd_1
XTAP_TAPCELL_ROW_17_394 VSS VDD sky130_fd_sc_hd__tapvpwrvgnd_1
XTAP_TAPCELL_ROW_17_395 VSS VDD sky130_fd_sc_hd__tapvpwrvgnd_1
XTAP_TAPCELL_ROW_17_396 VSS VDD sky130_fd_sc_hd__tapvpwrvgnd_1
XTAP_TAPCELL_ROW_17_397 VSS VDD sky130_fd_sc_hd__tapvpwrvgnd_1
XTAP_TAPCELL_ROW_17_398 VSS VDD sky130_fd_sc_hd__tapvpwrvgnd_1
XTAP_TAPCELL_ROW_18_399 VSS VDD sky130_fd_sc_hd__tapvpwrvgnd_1
XTAP_TAPCELL_ROW_18_400 VSS VDD sky130_fd_sc_hd__tapvpwrvgnd_1
XTAP_TAPCELL_ROW_18_401 VSS VDD sky130_fd_sc_hd__tapvpwrvgnd_1
XTAP_TAPCELL_ROW_18_402 VSS VDD sky130_fd_sc_hd__tapvpwrvgnd_1
XTAP_TAPCELL_ROW_18_403 VSS VDD sky130_fd_sc_hd__tapvpwrvgnd_1
XTAP_TAPCELL_ROW_18_404 VSS VDD sky130_fd_sc_hd__tapvpwrvgnd_1
XTAP_TAPCELL_ROW_18_405 VSS VDD sky130_fd_sc_hd__tapvpwrvgnd_1
XTAP_TAPCELL_ROW_18_406 VSS VDD sky130_fd_sc_hd__tapvpwrvgnd_1
XTAP_TAPCELL_ROW_18_407 VSS VDD sky130_fd_sc_hd__tapvpwrvgnd_1
XTAP_TAPCELL_ROW_18_408 VSS VDD sky130_fd_sc_hd__tapvpwrvgnd_1
XTAP_TAPCELL_ROW_18_409 VSS VDD sky130_fd_sc_hd__tapvpwrvgnd_1
XTAP_TAPCELL_ROW_18_410 VSS VDD sky130_fd_sc_hd__tapvpwrvgnd_1
XTAP_TAPCELL_ROW_18_411 VSS VDD sky130_fd_sc_hd__tapvpwrvgnd_1
XTAP_TAPCELL_ROW_18_412 VSS VDD sky130_fd_sc_hd__tapvpwrvgnd_1
XTAP_TAPCELL_ROW_18_413 VSS VDD sky130_fd_sc_hd__tapvpwrvgnd_1
XTAP_TAPCELL_ROW_18_414 VSS VDD sky130_fd_sc_hd__tapvpwrvgnd_1
XTAP_TAPCELL_ROW_18_415 VSS VDD sky130_fd_sc_hd__tapvpwrvgnd_1
XTAP_TAPCELL_ROW_18_416 VSS VDD sky130_fd_sc_hd__tapvpwrvgnd_1
XTAP_TAPCELL_ROW_18_417 VSS VDD sky130_fd_sc_hd__tapvpwrvgnd_1
XTAP_TAPCELL_ROW_18_418 VSS VDD sky130_fd_sc_hd__tapvpwrvgnd_1
XTAP_TAPCELL_ROW_18_419 VSS VDD sky130_fd_sc_hd__tapvpwrvgnd_1
XTAP_TAPCELL_ROW_19_420 VSS VDD sky130_fd_sc_hd__tapvpwrvgnd_1
XTAP_TAPCELL_ROW_19_421 VSS VDD sky130_fd_sc_hd__tapvpwrvgnd_1
XTAP_TAPCELL_ROW_19_422 VSS VDD sky130_fd_sc_hd__tapvpwrvgnd_1
XTAP_TAPCELL_ROW_19_423 VSS VDD sky130_fd_sc_hd__tapvpwrvgnd_1
XTAP_TAPCELL_ROW_19_424 VSS VDD sky130_fd_sc_hd__tapvpwrvgnd_1
XTAP_TAPCELL_ROW_19_425 VSS VDD sky130_fd_sc_hd__tapvpwrvgnd_1
XTAP_TAPCELL_ROW_19_426 VSS VDD sky130_fd_sc_hd__tapvpwrvgnd_1
XTAP_TAPCELL_ROW_19_427 VSS VDD sky130_fd_sc_hd__tapvpwrvgnd_1
XTAP_TAPCELL_ROW_19_428 VSS VDD sky130_fd_sc_hd__tapvpwrvgnd_1
XTAP_TAPCELL_ROW_19_429 VSS VDD sky130_fd_sc_hd__tapvpwrvgnd_1
XTAP_TAPCELL_ROW_19_430 VSS VDD sky130_fd_sc_hd__tapvpwrvgnd_1
XTAP_TAPCELL_ROW_19_431 VSS VDD sky130_fd_sc_hd__tapvpwrvgnd_1
XTAP_TAPCELL_ROW_19_432 VSS VDD sky130_fd_sc_hd__tapvpwrvgnd_1
XTAP_TAPCELL_ROW_19_433 VSS VDD sky130_fd_sc_hd__tapvpwrvgnd_1
XTAP_TAPCELL_ROW_19_434 VSS VDD sky130_fd_sc_hd__tapvpwrvgnd_1
XTAP_TAPCELL_ROW_19_435 VSS VDD sky130_fd_sc_hd__tapvpwrvgnd_1
XTAP_TAPCELL_ROW_19_436 VSS VDD sky130_fd_sc_hd__tapvpwrvgnd_1
XTAP_TAPCELL_ROW_19_437 VSS VDD sky130_fd_sc_hd__tapvpwrvgnd_1
XTAP_TAPCELL_ROW_19_438 VSS VDD sky130_fd_sc_hd__tapvpwrvgnd_1
XTAP_TAPCELL_ROW_19_439 VSS VDD sky130_fd_sc_hd__tapvpwrvgnd_1
XTAP_TAPCELL_ROW_19_440 VSS VDD sky130_fd_sc_hd__tapvpwrvgnd_1
XTAP_TAPCELL_ROW_20_441 VSS VDD sky130_fd_sc_hd__tapvpwrvgnd_1
XTAP_TAPCELL_ROW_20_442 VSS VDD sky130_fd_sc_hd__tapvpwrvgnd_1
XTAP_TAPCELL_ROW_20_443 VSS VDD sky130_fd_sc_hd__tapvpwrvgnd_1
XTAP_TAPCELL_ROW_20_444 VSS VDD sky130_fd_sc_hd__tapvpwrvgnd_1
XTAP_TAPCELL_ROW_20_445 VSS VDD sky130_fd_sc_hd__tapvpwrvgnd_1
XTAP_TAPCELL_ROW_20_446 VSS VDD sky130_fd_sc_hd__tapvpwrvgnd_1
XTAP_TAPCELL_ROW_20_447 VSS VDD sky130_fd_sc_hd__tapvpwrvgnd_1
XTAP_TAPCELL_ROW_20_448 VSS VDD sky130_fd_sc_hd__tapvpwrvgnd_1
XTAP_TAPCELL_ROW_20_449 VSS VDD sky130_fd_sc_hd__tapvpwrvgnd_1
XTAP_TAPCELL_ROW_20_450 VSS VDD sky130_fd_sc_hd__tapvpwrvgnd_1
XTAP_TAPCELL_ROW_20_451 VSS VDD sky130_fd_sc_hd__tapvpwrvgnd_1
XTAP_TAPCELL_ROW_20_452 VSS VDD sky130_fd_sc_hd__tapvpwrvgnd_1
XTAP_TAPCELL_ROW_20_453 VSS VDD sky130_fd_sc_hd__tapvpwrvgnd_1
XTAP_TAPCELL_ROW_20_454 VSS VDD sky130_fd_sc_hd__tapvpwrvgnd_1
XTAP_TAPCELL_ROW_20_455 VSS VDD sky130_fd_sc_hd__tapvpwrvgnd_1
XTAP_TAPCELL_ROW_20_456 VSS VDD sky130_fd_sc_hd__tapvpwrvgnd_1
XTAP_TAPCELL_ROW_20_457 VSS VDD sky130_fd_sc_hd__tapvpwrvgnd_1
XTAP_TAPCELL_ROW_20_458 VSS VDD sky130_fd_sc_hd__tapvpwrvgnd_1
XTAP_TAPCELL_ROW_20_459 VSS VDD sky130_fd_sc_hd__tapvpwrvgnd_1
XTAP_TAPCELL_ROW_20_460 VSS VDD sky130_fd_sc_hd__tapvpwrvgnd_1
XTAP_TAPCELL_ROW_20_461 VSS VDD sky130_fd_sc_hd__tapvpwrvgnd_1
XTAP_TAPCELL_ROW_21_462 VSS VDD sky130_fd_sc_hd__tapvpwrvgnd_1
XTAP_TAPCELL_ROW_21_463 VSS VDD sky130_fd_sc_hd__tapvpwrvgnd_1
XTAP_TAPCELL_ROW_21_464 VSS VDD sky130_fd_sc_hd__tapvpwrvgnd_1
XTAP_TAPCELL_ROW_21_465 VSS VDD sky130_fd_sc_hd__tapvpwrvgnd_1
XTAP_TAPCELL_ROW_21_466 VSS VDD sky130_fd_sc_hd__tapvpwrvgnd_1
XTAP_TAPCELL_ROW_21_467 VSS VDD sky130_fd_sc_hd__tapvpwrvgnd_1
XTAP_TAPCELL_ROW_21_468 VSS VDD sky130_fd_sc_hd__tapvpwrvgnd_1
XTAP_TAPCELL_ROW_21_469 VSS VDD sky130_fd_sc_hd__tapvpwrvgnd_1
XTAP_TAPCELL_ROW_21_470 VSS VDD sky130_fd_sc_hd__tapvpwrvgnd_1
XTAP_TAPCELL_ROW_21_471 VSS VDD sky130_fd_sc_hd__tapvpwrvgnd_1
XTAP_TAPCELL_ROW_21_472 VSS VDD sky130_fd_sc_hd__tapvpwrvgnd_1
XTAP_TAPCELL_ROW_21_473 VSS VDD sky130_fd_sc_hd__tapvpwrvgnd_1
XTAP_TAPCELL_ROW_21_474 VSS VDD sky130_fd_sc_hd__tapvpwrvgnd_1
XTAP_TAPCELL_ROW_21_475 VSS VDD sky130_fd_sc_hd__tapvpwrvgnd_1
XTAP_TAPCELL_ROW_21_476 VSS VDD sky130_fd_sc_hd__tapvpwrvgnd_1
XTAP_TAPCELL_ROW_21_477 VSS VDD sky130_fd_sc_hd__tapvpwrvgnd_1
XTAP_TAPCELL_ROW_21_478 VSS VDD sky130_fd_sc_hd__tapvpwrvgnd_1
XTAP_TAPCELL_ROW_21_479 VSS VDD sky130_fd_sc_hd__tapvpwrvgnd_1
XTAP_TAPCELL_ROW_21_480 VSS VDD sky130_fd_sc_hd__tapvpwrvgnd_1
XTAP_TAPCELL_ROW_21_481 VSS VDD sky130_fd_sc_hd__tapvpwrvgnd_1
XTAP_TAPCELL_ROW_21_482 VSS VDD sky130_fd_sc_hd__tapvpwrvgnd_1
XTAP_TAPCELL_ROW_22_483 VSS VDD sky130_fd_sc_hd__tapvpwrvgnd_1
XTAP_TAPCELL_ROW_22_484 VSS VDD sky130_fd_sc_hd__tapvpwrvgnd_1
XTAP_TAPCELL_ROW_22_485 VSS VDD sky130_fd_sc_hd__tapvpwrvgnd_1
XTAP_TAPCELL_ROW_22_486 VSS VDD sky130_fd_sc_hd__tapvpwrvgnd_1
XTAP_TAPCELL_ROW_22_487 VSS VDD sky130_fd_sc_hd__tapvpwrvgnd_1
XTAP_TAPCELL_ROW_22_488 VSS VDD sky130_fd_sc_hd__tapvpwrvgnd_1
XTAP_TAPCELL_ROW_22_489 VSS VDD sky130_fd_sc_hd__tapvpwrvgnd_1
XTAP_TAPCELL_ROW_22_490 VSS VDD sky130_fd_sc_hd__tapvpwrvgnd_1
XTAP_TAPCELL_ROW_22_491 VSS VDD sky130_fd_sc_hd__tapvpwrvgnd_1
XTAP_TAPCELL_ROW_22_492 VSS VDD sky130_fd_sc_hd__tapvpwrvgnd_1
XTAP_TAPCELL_ROW_22_493 VSS VDD sky130_fd_sc_hd__tapvpwrvgnd_1
XTAP_TAPCELL_ROW_22_494 VSS VDD sky130_fd_sc_hd__tapvpwrvgnd_1
XTAP_TAPCELL_ROW_22_495 VSS VDD sky130_fd_sc_hd__tapvpwrvgnd_1
XTAP_TAPCELL_ROW_22_496 VSS VDD sky130_fd_sc_hd__tapvpwrvgnd_1
XTAP_TAPCELL_ROW_22_497 VSS VDD sky130_fd_sc_hd__tapvpwrvgnd_1
XTAP_TAPCELL_ROW_22_498 VSS VDD sky130_fd_sc_hd__tapvpwrvgnd_1
XTAP_TAPCELL_ROW_22_499 VSS VDD sky130_fd_sc_hd__tapvpwrvgnd_1
XTAP_TAPCELL_ROW_22_500 VSS VDD sky130_fd_sc_hd__tapvpwrvgnd_1
XTAP_TAPCELL_ROW_22_501 VSS VDD sky130_fd_sc_hd__tapvpwrvgnd_1
XTAP_TAPCELL_ROW_22_502 VSS VDD sky130_fd_sc_hd__tapvpwrvgnd_1
XTAP_TAPCELL_ROW_22_503 VSS VDD sky130_fd_sc_hd__tapvpwrvgnd_1
XTAP_TAPCELL_ROW_23_504 VSS VDD sky130_fd_sc_hd__tapvpwrvgnd_1
XTAP_TAPCELL_ROW_23_505 VSS VDD sky130_fd_sc_hd__tapvpwrvgnd_1
XTAP_TAPCELL_ROW_23_506 VSS VDD sky130_fd_sc_hd__tapvpwrvgnd_1
XTAP_TAPCELL_ROW_23_507 VSS VDD sky130_fd_sc_hd__tapvpwrvgnd_1
XTAP_TAPCELL_ROW_23_508 VSS VDD sky130_fd_sc_hd__tapvpwrvgnd_1
XTAP_TAPCELL_ROW_23_509 VSS VDD sky130_fd_sc_hd__tapvpwrvgnd_1
XTAP_TAPCELL_ROW_23_510 VSS VDD sky130_fd_sc_hd__tapvpwrvgnd_1
XTAP_TAPCELL_ROW_23_511 VSS VDD sky130_fd_sc_hd__tapvpwrvgnd_1
XTAP_TAPCELL_ROW_23_512 VSS VDD sky130_fd_sc_hd__tapvpwrvgnd_1
XTAP_TAPCELL_ROW_23_513 VSS VDD sky130_fd_sc_hd__tapvpwrvgnd_1
XTAP_TAPCELL_ROW_23_514 VSS VDD sky130_fd_sc_hd__tapvpwrvgnd_1
XTAP_TAPCELL_ROW_23_515 VSS VDD sky130_fd_sc_hd__tapvpwrvgnd_1
XTAP_TAPCELL_ROW_23_516 VSS VDD sky130_fd_sc_hd__tapvpwrvgnd_1
XTAP_TAPCELL_ROW_23_517 VSS VDD sky130_fd_sc_hd__tapvpwrvgnd_1
XTAP_TAPCELL_ROW_23_518 VSS VDD sky130_fd_sc_hd__tapvpwrvgnd_1
XTAP_TAPCELL_ROW_23_519 VSS VDD sky130_fd_sc_hd__tapvpwrvgnd_1
XTAP_TAPCELL_ROW_23_520 VSS VDD sky130_fd_sc_hd__tapvpwrvgnd_1
XTAP_TAPCELL_ROW_23_521 VSS VDD sky130_fd_sc_hd__tapvpwrvgnd_1
XTAP_TAPCELL_ROW_23_522 VSS VDD sky130_fd_sc_hd__tapvpwrvgnd_1
XTAP_TAPCELL_ROW_23_523 VSS VDD sky130_fd_sc_hd__tapvpwrvgnd_1
XTAP_TAPCELL_ROW_23_524 VSS VDD sky130_fd_sc_hd__tapvpwrvgnd_1
XTAP_TAPCELL_ROW_24_525 VSS VDD sky130_fd_sc_hd__tapvpwrvgnd_1
XTAP_TAPCELL_ROW_24_526 VSS VDD sky130_fd_sc_hd__tapvpwrvgnd_1
XTAP_TAPCELL_ROW_24_527 VSS VDD sky130_fd_sc_hd__tapvpwrvgnd_1
XTAP_TAPCELL_ROW_24_528 VSS VDD sky130_fd_sc_hd__tapvpwrvgnd_1
XTAP_TAPCELL_ROW_24_529 VSS VDD sky130_fd_sc_hd__tapvpwrvgnd_1
XTAP_TAPCELL_ROW_24_530 VSS VDD sky130_fd_sc_hd__tapvpwrvgnd_1
XTAP_TAPCELL_ROW_24_531 VSS VDD sky130_fd_sc_hd__tapvpwrvgnd_1
XTAP_TAPCELL_ROW_24_532 VSS VDD sky130_fd_sc_hd__tapvpwrvgnd_1
XTAP_TAPCELL_ROW_24_533 VSS VDD sky130_fd_sc_hd__tapvpwrvgnd_1
XTAP_TAPCELL_ROW_24_534 VSS VDD sky130_fd_sc_hd__tapvpwrvgnd_1
XTAP_TAPCELL_ROW_24_535 VSS VDD sky130_fd_sc_hd__tapvpwrvgnd_1
XTAP_TAPCELL_ROW_24_536 VSS VDD sky130_fd_sc_hd__tapvpwrvgnd_1
XTAP_TAPCELL_ROW_24_537 VSS VDD sky130_fd_sc_hd__tapvpwrvgnd_1
XTAP_TAPCELL_ROW_24_538 VSS VDD sky130_fd_sc_hd__tapvpwrvgnd_1
XTAP_TAPCELL_ROW_24_539 VSS VDD sky130_fd_sc_hd__tapvpwrvgnd_1
XTAP_TAPCELL_ROW_24_540 VSS VDD sky130_fd_sc_hd__tapvpwrvgnd_1
XTAP_TAPCELL_ROW_24_541 VSS VDD sky130_fd_sc_hd__tapvpwrvgnd_1
XTAP_TAPCELL_ROW_24_542 VSS VDD sky130_fd_sc_hd__tapvpwrvgnd_1
XTAP_TAPCELL_ROW_24_543 VSS VDD sky130_fd_sc_hd__tapvpwrvgnd_1
XTAP_TAPCELL_ROW_24_544 VSS VDD sky130_fd_sc_hd__tapvpwrvgnd_1
XTAP_TAPCELL_ROW_24_545 VSS VDD sky130_fd_sc_hd__tapvpwrvgnd_1
XTAP_TAPCELL_ROW_25_546 VSS VDD sky130_fd_sc_hd__tapvpwrvgnd_1
XTAP_TAPCELL_ROW_25_547 VSS VDD sky130_fd_sc_hd__tapvpwrvgnd_1
XTAP_TAPCELL_ROW_25_548 VSS VDD sky130_fd_sc_hd__tapvpwrvgnd_1
XTAP_TAPCELL_ROW_25_549 VSS VDD sky130_fd_sc_hd__tapvpwrvgnd_1
XTAP_TAPCELL_ROW_25_550 VSS VDD sky130_fd_sc_hd__tapvpwrvgnd_1
XTAP_TAPCELL_ROW_25_551 VSS VDD sky130_fd_sc_hd__tapvpwrvgnd_1
XTAP_TAPCELL_ROW_25_552 VSS VDD sky130_fd_sc_hd__tapvpwrvgnd_1
XTAP_TAPCELL_ROW_25_553 VSS VDD sky130_fd_sc_hd__tapvpwrvgnd_1
XTAP_TAPCELL_ROW_25_554 VSS VDD sky130_fd_sc_hd__tapvpwrvgnd_1
XTAP_TAPCELL_ROW_25_555 VSS VDD sky130_fd_sc_hd__tapvpwrvgnd_1
XTAP_TAPCELL_ROW_25_556 VSS VDD sky130_fd_sc_hd__tapvpwrvgnd_1
XTAP_TAPCELL_ROW_25_557 VSS VDD sky130_fd_sc_hd__tapvpwrvgnd_1
XTAP_TAPCELL_ROW_25_558 VSS VDD sky130_fd_sc_hd__tapvpwrvgnd_1
XTAP_TAPCELL_ROW_25_559 VSS VDD sky130_fd_sc_hd__tapvpwrvgnd_1
XTAP_TAPCELL_ROW_25_560 VSS VDD sky130_fd_sc_hd__tapvpwrvgnd_1
XTAP_TAPCELL_ROW_25_561 VSS VDD sky130_fd_sc_hd__tapvpwrvgnd_1
XTAP_TAPCELL_ROW_25_562 VSS VDD sky130_fd_sc_hd__tapvpwrvgnd_1
XTAP_TAPCELL_ROW_25_563 VSS VDD sky130_fd_sc_hd__tapvpwrvgnd_1
XTAP_TAPCELL_ROW_25_564 VSS VDD sky130_fd_sc_hd__tapvpwrvgnd_1
XTAP_TAPCELL_ROW_25_565 VSS VDD sky130_fd_sc_hd__tapvpwrvgnd_1
XTAP_TAPCELL_ROW_25_566 VSS VDD sky130_fd_sc_hd__tapvpwrvgnd_1
XTAP_TAPCELL_ROW_26_567 VSS VDD sky130_fd_sc_hd__tapvpwrvgnd_1
XTAP_TAPCELL_ROW_26_568 VSS VDD sky130_fd_sc_hd__tapvpwrvgnd_1
XTAP_TAPCELL_ROW_26_569 VSS VDD sky130_fd_sc_hd__tapvpwrvgnd_1
XTAP_TAPCELL_ROW_26_570 VSS VDD sky130_fd_sc_hd__tapvpwrvgnd_1
XTAP_TAPCELL_ROW_26_571 VSS VDD sky130_fd_sc_hd__tapvpwrvgnd_1
XTAP_TAPCELL_ROW_26_572 VSS VDD sky130_fd_sc_hd__tapvpwrvgnd_1
XTAP_TAPCELL_ROW_26_573 VSS VDD sky130_fd_sc_hd__tapvpwrvgnd_1
XTAP_TAPCELL_ROW_26_574 VSS VDD sky130_fd_sc_hd__tapvpwrvgnd_1
XTAP_TAPCELL_ROW_26_575 VSS VDD sky130_fd_sc_hd__tapvpwrvgnd_1
XTAP_TAPCELL_ROW_26_576 VSS VDD sky130_fd_sc_hd__tapvpwrvgnd_1
XTAP_TAPCELL_ROW_26_577 VSS VDD sky130_fd_sc_hd__tapvpwrvgnd_1
XTAP_TAPCELL_ROW_26_578 VSS VDD sky130_fd_sc_hd__tapvpwrvgnd_1
XTAP_TAPCELL_ROW_26_579 VSS VDD sky130_fd_sc_hd__tapvpwrvgnd_1
XTAP_TAPCELL_ROW_26_580 VSS VDD sky130_fd_sc_hd__tapvpwrvgnd_1
XTAP_TAPCELL_ROW_26_581 VSS VDD sky130_fd_sc_hd__tapvpwrvgnd_1
XTAP_TAPCELL_ROW_26_582 VSS VDD sky130_fd_sc_hd__tapvpwrvgnd_1
XTAP_TAPCELL_ROW_26_583 VSS VDD sky130_fd_sc_hd__tapvpwrvgnd_1
XTAP_TAPCELL_ROW_26_584 VSS VDD sky130_fd_sc_hd__tapvpwrvgnd_1
XTAP_TAPCELL_ROW_26_585 VSS VDD sky130_fd_sc_hd__tapvpwrvgnd_1
XTAP_TAPCELL_ROW_26_586 VSS VDD sky130_fd_sc_hd__tapvpwrvgnd_1
XTAP_TAPCELL_ROW_26_587 VSS VDD sky130_fd_sc_hd__tapvpwrvgnd_1
XTAP_TAPCELL_ROW_27_588 VSS VDD sky130_fd_sc_hd__tapvpwrvgnd_1
XTAP_TAPCELL_ROW_27_589 VSS VDD sky130_fd_sc_hd__tapvpwrvgnd_1
XTAP_TAPCELL_ROW_27_590 VSS VDD sky130_fd_sc_hd__tapvpwrvgnd_1
XTAP_TAPCELL_ROW_27_591 VSS VDD sky130_fd_sc_hd__tapvpwrvgnd_1
XTAP_TAPCELL_ROW_27_592 VSS VDD sky130_fd_sc_hd__tapvpwrvgnd_1
XTAP_TAPCELL_ROW_27_593 VSS VDD sky130_fd_sc_hd__tapvpwrvgnd_1
XTAP_TAPCELL_ROW_27_594 VSS VDD sky130_fd_sc_hd__tapvpwrvgnd_1
XTAP_TAPCELL_ROW_27_595 VSS VDD sky130_fd_sc_hd__tapvpwrvgnd_1
XTAP_TAPCELL_ROW_27_596 VSS VDD sky130_fd_sc_hd__tapvpwrvgnd_1
XTAP_TAPCELL_ROW_27_597 VSS VDD sky130_fd_sc_hd__tapvpwrvgnd_1
XTAP_TAPCELL_ROW_27_598 VSS VDD sky130_fd_sc_hd__tapvpwrvgnd_1
XTAP_TAPCELL_ROW_27_599 VSS VDD sky130_fd_sc_hd__tapvpwrvgnd_1
XTAP_TAPCELL_ROW_27_600 VSS VDD sky130_fd_sc_hd__tapvpwrvgnd_1
XTAP_TAPCELL_ROW_27_601 VSS VDD sky130_fd_sc_hd__tapvpwrvgnd_1
XTAP_TAPCELL_ROW_27_602 VSS VDD sky130_fd_sc_hd__tapvpwrvgnd_1
XTAP_TAPCELL_ROW_27_603 VSS VDD sky130_fd_sc_hd__tapvpwrvgnd_1
XTAP_TAPCELL_ROW_27_604 VSS VDD sky130_fd_sc_hd__tapvpwrvgnd_1
XTAP_TAPCELL_ROW_27_605 VSS VDD sky130_fd_sc_hd__tapvpwrvgnd_1
XTAP_TAPCELL_ROW_27_606 VSS VDD sky130_fd_sc_hd__tapvpwrvgnd_1
XTAP_TAPCELL_ROW_27_607 VSS VDD sky130_fd_sc_hd__tapvpwrvgnd_1
XTAP_TAPCELL_ROW_27_608 VSS VDD sky130_fd_sc_hd__tapvpwrvgnd_1
XTAP_TAPCELL_ROW_28_609 VSS VDD sky130_fd_sc_hd__tapvpwrvgnd_1
XTAP_TAPCELL_ROW_28_610 VSS VDD sky130_fd_sc_hd__tapvpwrvgnd_1
XTAP_TAPCELL_ROW_28_611 VSS VDD sky130_fd_sc_hd__tapvpwrvgnd_1
XTAP_TAPCELL_ROW_28_612 VSS VDD sky130_fd_sc_hd__tapvpwrvgnd_1
XTAP_TAPCELL_ROW_28_613 VSS VDD sky130_fd_sc_hd__tapvpwrvgnd_1
XTAP_TAPCELL_ROW_28_614 VSS VDD sky130_fd_sc_hd__tapvpwrvgnd_1
XTAP_TAPCELL_ROW_28_615 VSS VDD sky130_fd_sc_hd__tapvpwrvgnd_1
XTAP_TAPCELL_ROW_28_616 VSS VDD sky130_fd_sc_hd__tapvpwrvgnd_1
XTAP_TAPCELL_ROW_28_617 VSS VDD sky130_fd_sc_hd__tapvpwrvgnd_1
XTAP_TAPCELL_ROW_28_618 VSS VDD sky130_fd_sc_hd__tapvpwrvgnd_1
XTAP_TAPCELL_ROW_28_619 VSS VDD sky130_fd_sc_hd__tapvpwrvgnd_1
XTAP_TAPCELL_ROW_28_620 VSS VDD sky130_fd_sc_hd__tapvpwrvgnd_1
XTAP_TAPCELL_ROW_28_621 VSS VDD sky130_fd_sc_hd__tapvpwrvgnd_1
XTAP_TAPCELL_ROW_28_622 VSS VDD sky130_fd_sc_hd__tapvpwrvgnd_1
XTAP_TAPCELL_ROW_28_623 VSS VDD sky130_fd_sc_hd__tapvpwrvgnd_1
XTAP_TAPCELL_ROW_28_624 VSS VDD sky130_fd_sc_hd__tapvpwrvgnd_1
XTAP_TAPCELL_ROW_28_625 VSS VDD sky130_fd_sc_hd__tapvpwrvgnd_1
XTAP_TAPCELL_ROW_28_626 VSS VDD sky130_fd_sc_hd__tapvpwrvgnd_1
XTAP_TAPCELL_ROW_28_627 VSS VDD sky130_fd_sc_hd__tapvpwrvgnd_1
XTAP_TAPCELL_ROW_28_628 VSS VDD sky130_fd_sc_hd__tapvpwrvgnd_1
XTAP_TAPCELL_ROW_28_629 VSS VDD sky130_fd_sc_hd__tapvpwrvgnd_1
XTAP_TAPCELL_ROW_29_630 VSS VDD sky130_fd_sc_hd__tapvpwrvgnd_1
XTAP_TAPCELL_ROW_29_631 VSS VDD sky130_fd_sc_hd__tapvpwrvgnd_1
XTAP_TAPCELL_ROW_29_632 VSS VDD sky130_fd_sc_hd__tapvpwrvgnd_1
XTAP_TAPCELL_ROW_29_633 VSS VDD sky130_fd_sc_hd__tapvpwrvgnd_1
XTAP_TAPCELL_ROW_29_634 VSS VDD sky130_fd_sc_hd__tapvpwrvgnd_1
XTAP_TAPCELL_ROW_29_635 VSS VDD sky130_fd_sc_hd__tapvpwrvgnd_1
XTAP_TAPCELL_ROW_29_636 VSS VDD sky130_fd_sc_hd__tapvpwrvgnd_1
XTAP_TAPCELL_ROW_29_637 VSS VDD sky130_fd_sc_hd__tapvpwrvgnd_1
XTAP_TAPCELL_ROW_29_638 VSS VDD sky130_fd_sc_hd__tapvpwrvgnd_1
XTAP_TAPCELL_ROW_29_639 VSS VDD sky130_fd_sc_hd__tapvpwrvgnd_1
XTAP_TAPCELL_ROW_29_640 VSS VDD sky130_fd_sc_hd__tapvpwrvgnd_1
XTAP_TAPCELL_ROW_29_641 VSS VDD sky130_fd_sc_hd__tapvpwrvgnd_1
XTAP_TAPCELL_ROW_29_642 VSS VDD sky130_fd_sc_hd__tapvpwrvgnd_1
XTAP_TAPCELL_ROW_29_643 VSS VDD sky130_fd_sc_hd__tapvpwrvgnd_1
XTAP_TAPCELL_ROW_29_644 VSS VDD sky130_fd_sc_hd__tapvpwrvgnd_1
XTAP_TAPCELL_ROW_29_645 VSS VDD sky130_fd_sc_hd__tapvpwrvgnd_1
XTAP_TAPCELL_ROW_29_646 VSS VDD sky130_fd_sc_hd__tapvpwrvgnd_1
XTAP_TAPCELL_ROW_29_647 VSS VDD sky130_fd_sc_hd__tapvpwrvgnd_1
XTAP_TAPCELL_ROW_29_648 VSS VDD sky130_fd_sc_hd__tapvpwrvgnd_1
XTAP_TAPCELL_ROW_29_649 VSS VDD sky130_fd_sc_hd__tapvpwrvgnd_1
XTAP_TAPCELL_ROW_29_650 VSS VDD sky130_fd_sc_hd__tapvpwrvgnd_1
XTAP_TAPCELL_ROW_30_651 VSS VDD sky130_fd_sc_hd__tapvpwrvgnd_1
XTAP_TAPCELL_ROW_30_652 VSS VDD sky130_fd_sc_hd__tapvpwrvgnd_1
XTAP_TAPCELL_ROW_30_653 VSS VDD sky130_fd_sc_hd__tapvpwrvgnd_1
XTAP_TAPCELL_ROW_30_654 VSS VDD sky130_fd_sc_hd__tapvpwrvgnd_1
XTAP_TAPCELL_ROW_30_655 VSS VDD sky130_fd_sc_hd__tapvpwrvgnd_1
XTAP_TAPCELL_ROW_30_656 VSS VDD sky130_fd_sc_hd__tapvpwrvgnd_1
XTAP_TAPCELL_ROW_30_657 VSS VDD sky130_fd_sc_hd__tapvpwrvgnd_1
XTAP_TAPCELL_ROW_30_658 VSS VDD sky130_fd_sc_hd__tapvpwrvgnd_1
XTAP_TAPCELL_ROW_30_659 VSS VDD sky130_fd_sc_hd__tapvpwrvgnd_1
XTAP_TAPCELL_ROW_30_660 VSS VDD sky130_fd_sc_hd__tapvpwrvgnd_1
XTAP_TAPCELL_ROW_30_661 VSS VDD sky130_fd_sc_hd__tapvpwrvgnd_1
XTAP_TAPCELL_ROW_30_662 VSS VDD sky130_fd_sc_hd__tapvpwrvgnd_1
XTAP_TAPCELL_ROW_30_663 VSS VDD sky130_fd_sc_hd__tapvpwrvgnd_1
XTAP_TAPCELL_ROW_30_664 VSS VDD sky130_fd_sc_hd__tapvpwrvgnd_1
XTAP_TAPCELL_ROW_30_665 VSS VDD sky130_fd_sc_hd__tapvpwrvgnd_1
XTAP_TAPCELL_ROW_30_666 VSS VDD sky130_fd_sc_hd__tapvpwrvgnd_1
XTAP_TAPCELL_ROW_30_667 VSS VDD sky130_fd_sc_hd__tapvpwrvgnd_1
XTAP_TAPCELL_ROW_30_668 VSS VDD sky130_fd_sc_hd__tapvpwrvgnd_1
XTAP_TAPCELL_ROW_30_669 VSS VDD sky130_fd_sc_hd__tapvpwrvgnd_1
XTAP_TAPCELL_ROW_30_670 VSS VDD sky130_fd_sc_hd__tapvpwrvgnd_1
XTAP_TAPCELL_ROW_30_671 VSS VDD sky130_fd_sc_hd__tapvpwrvgnd_1
XTAP_TAPCELL_ROW_31_672 VSS VDD sky130_fd_sc_hd__tapvpwrvgnd_1
XTAP_TAPCELL_ROW_31_673 VSS VDD sky130_fd_sc_hd__tapvpwrvgnd_1
XTAP_TAPCELL_ROW_31_674 VSS VDD sky130_fd_sc_hd__tapvpwrvgnd_1
XTAP_TAPCELL_ROW_31_675 VSS VDD sky130_fd_sc_hd__tapvpwrvgnd_1
XTAP_TAPCELL_ROW_31_676 VSS VDD sky130_fd_sc_hd__tapvpwrvgnd_1
XTAP_TAPCELL_ROW_31_677 VSS VDD sky130_fd_sc_hd__tapvpwrvgnd_1
XTAP_TAPCELL_ROW_31_678 VSS VDD sky130_fd_sc_hd__tapvpwrvgnd_1
XTAP_TAPCELL_ROW_31_679 VSS VDD sky130_fd_sc_hd__tapvpwrvgnd_1
XTAP_TAPCELL_ROW_31_680 VSS VDD sky130_fd_sc_hd__tapvpwrvgnd_1
XTAP_TAPCELL_ROW_31_681 VSS VDD sky130_fd_sc_hd__tapvpwrvgnd_1
XTAP_TAPCELL_ROW_31_682 VSS VDD sky130_fd_sc_hd__tapvpwrvgnd_1
XTAP_TAPCELL_ROW_31_683 VSS VDD sky130_fd_sc_hd__tapvpwrvgnd_1
XTAP_TAPCELL_ROW_31_684 VSS VDD sky130_fd_sc_hd__tapvpwrvgnd_1
XTAP_TAPCELL_ROW_31_685 VSS VDD sky130_fd_sc_hd__tapvpwrvgnd_1
XTAP_TAPCELL_ROW_31_686 VSS VDD sky130_fd_sc_hd__tapvpwrvgnd_1
XTAP_TAPCELL_ROW_31_687 VSS VDD sky130_fd_sc_hd__tapvpwrvgnd_1
XTAP_TAPCELL_ROW_31_688 VSS VDD sky130_fd_sc_hd__tapvpwrvgnd_1
XTAP_TAPCELL_ROW_31_689 VSS VDD sky130_fd_sc_hd__tapvpwrvgnd_1
XTAP_TAPCELL_ROW_31_690 VSS VDD sky130_fd_sc_hd__tapvpwrvgnd_1
XTAP_TAPCELL_ROW_31_691 VSS VDD sky130_fd_sc_hd__tapvpwrvgnd_1
XTAP_TAPCELL_ROW_31_692 VSS VDD sky130_fd_sc_hd__tapvpwrvgnd_1
XTAP_TAPCELL_ROW_32_693 VSS VDD sky130_fd_sc_hd__tapvpwrvgnd_1
XTAP_TAPCELL_ROW_32_694 VSS VDD sky130_fd_sc_hd__tapvpwrvgnd_1
XTAP_TAPCELL_ROW_32_695 VSS VDD sky130_fd_sc_hd__tapvpwrvgnd_1
XTAP_TAPCELL_ROW_32_696 VSS VDD sky130_fd_sc_hd__tapvpwrvgnd_1
XTAP_TAPCELL_ROW_32_697 VSS VDD sky130_fd_sc_hd__tapvpwrvgnd_1
XTAP_TAPCELL_ROW_32_698 VSS VDD sky130_fd_sc_hd__tapvpwrvgnd_1
XTAP_TAPCELL_ROW_32_699 VSS VDD sky130_fd_sc_hd__tapvpwrvgnd_1
XTAP_TAPCELL_ROW_32_700 VSS VDD sky130_fd_sc_hd__tapvpwrvgnd_1
XTAP_TAPCELL_ROW_32_701 VSS VDD sky130_fd_sc_hd__tapvpwrvgnd_1
XTAP_TAPCELL_ROW_32_702 VSS VDD sky130_fd_sc_hd__tapvpwrvgnd_1
XTAP_TAPCELL_ROW_32_703 VSS VDD sky130_fd_sc_hd__tapvpwrvgnd_1
XTAP_TAPCELL_ROW_32_704 VSS VDD sky130_fd_sc_hd__tapvpwrvgnd_1
XTAP_TAPCELL_ROW_32_705 VSS VDD sky130_fd_sc_hd__tapvpwrvgnd_1
XTAP_TAPCELL_ROW_32_706 VSS VDD sky130_fd_sc_hd__tapvpwrvgnd_1
XTAP_TAPCELL_ROW_32_707 VSS VDD sky130_fd_sc_hd__tapvpwrvgnd_1
XTAP_TAPCELL_ROW_32_708 VSS VDD sky130_fd_sc_hd__tapvpwrvgnd_1
XTAP_TAPCELL_ROW_32_709 VSS VDD sky130_fd_sc_hd__tapvpwrvgnd_1
XTAP_TAPCELL_ROW_32_710 VSS VDD sky130_fd_sc_hd__tapvpwrvgnd_1
XTAP_TAPCELL_ROW_32_711 VSS VDD sky130_fd_sc_hd__tapvpwrvgnd_1
XTAP_TAPCELL_ROW_32_712 VSS VDD sky130_fd_sc_hd__tapvpwrvgnd_1
XTAP_TAPCELL_ROW_32_713 VSS VDD sky130_fd_sc_hd__tapvpwrvgnd_1
XTAP_TAPCELL_ROW_33_714 VSS VDD sky130_fd_sc_hd__tapvpwrvgnd_1
XTAP_TAPCELL_ROW_33_715 VSS VDD sky130_fd_sc_hd__tapvpwrvgnd_1
XTAP_TAPCELL_ROW_33_716 VSS VDD sky130_fd_sc_hd__tapvpwrvgnd_1
XTAP_TAPCELL_ROW_33_717 VSS VDD sky130_fd_sc_hd__tapvpwrvgnd_1
XTAP_TAPCELL_ROW_33_718 VSS VDD sky130_fd_sc_hd__tapvpwrvgnd_1
XTAP_TAPCELL_ROW_33_719 VSS VDD sky130_fd_sc_hd__tapvpwrvgnd_1
XTAP_TAPCELL_ROW_33_720 VSS VDD sky130_fd_sc_hd__tapvpwrvgnd_1
XTAP_TAPCELL_ROW_33_721 VSS VDD sky130_fd_sc_hd__tapvpwrvgnd_1
XTAP_TAPCELL_ROW_33_722 VSS VDD sky130_fd_sc_hd__tapvpwrvgnd_1
XTAP_TAPCELL_ROW_33_723 VSS VDD sky130_fd_sc_hd__tapvpwrvgnd_1
XTAP_TAPCELL_ROW_33_724 VSS VDD sky130_fd_sc_hd__tapvpwrvgnd_1
XTAP_TAPCELL_ROW_33_725 VSS VDD sky130_fd_sc_hd__tapvpwrvgnd_1
XTAP_TAPCELL_ROW_33_726 VSS VDD sky130_fd_sc_hd__tapvpwrvgnd_1
XTAP_TAPCELL_ROW_33_727 VSS VDD sky130_fd_sc_hd__tapvpwrvgnd_1
XTAP_TAPCELL_ROW_33_728 VSS VDD sky130_fd_sc_hd__tapvpwrvgnd_1
XTAP_TAPCELL_ROW_33_729 VSS VDD sky130_fd_sc_hd__tapvpwrvgnd_1
XTAP_TAPCELL_ROW_33_730 VSS VDD sky130_fd_sc_hd__tapvpwrvgnd_1
XTAP_TAPCELL_ROW_33_731 VSS VDD sky130_fd_sc_hd__tapvpwrvgnd_1
XTAP_TAPCELL_ROW_33_732 VSS VDD sky130_fd_sc_hd__tapvpwrvgnd_1
XTAP_TAPCELL_ROW_33_733 VSS VDD sky130_fd_sc_hd__tapvpwrvgnd_1
XTAP_TAPCELL_ROW_33_734 VSS VDD sky130_fd_sc_hd__tapvpwrvgnd_1
XTAP_TAPCELL_ROW_34_735 VSS VDD sky130_fd_sc_hd__tapvpwrvgnd_1
XTAP_TAPCELL_ROW_34_736 VSS VDD sky130_fd_sc_hd__tapvpwrvgnd_1
XTAP_TAPCELL_ROW_34_737 VSS VDD sky130_fd_sc_hd__tapvpwrvgnd_1
XTAP_TAPCELL_ROW_34_738 VSS VDD sky130_fd_sc_hd__tapvpwrvgnd_1
XTAP_TAPCELL_ROW_34_739 VSS VDD sky130_fd_sc_hd__tapvpwrvgnd_1
XTAP_TAPCELL_ROW_34_740 VSS VDD sky130_fd_sc_hd__tapvpwrvgnd_1
XTAP_TAPCELL_ROW_34_741 VSS VDD sky130_fd_sc_hd__tapvpwrvgnd_1
XTAP_TAPCELL_ROW_34_742 VSS VDD sky130_fd_sc_hd__tapvpwrvgnd_1
XTAP_TAPCELL_ROW_34_743 VSS VDD sky130_fd_sc_hd__tapvpwrvgnd_1
XTAP_TAPCELL_ROW_34_744 VSS VDD sky130_fd_sc_hd__tapvpwrvgnd_1
XTAP_TAPCELL_ROW_34_745 VSS VDD sky130_fd_sc_hd__tapvpwrvgnd_1
XTAP_TAPCELL_ROW_34_746 VSS VDD sky130_fd_sc_hd__tapvpwrvgnd_1
XTAP_TAPCELL_ROW_34_747 VSS VDD sky130_fd_sc_hd__tapvpwrvgnd_1
XTAP_TAPCELL_ROW_34_748 VSS VDD sky130_fd_sc_hd__tapvpwrvgnd_1
XTAP_TAPCELL_ROW_34_749 VSS VDD sky130_fd_sc_hd__tapvpwrvgnd_1
XTAP_TAPCELL_ROW_34_750 VSS VDD sky130_fd_sc_hd__tapvpwrvgnd_1
XTAP_TAPCELL_ROW_34_751 VSS VDD sky130_fd_sc_hd__tapvpwrvgnd_1
XTAP_TAPCELL_ROW_34_752 VSS VDD sky130_fd_sc_hd__tapvpwrvgnd_1
XTAP_TAPCELL_ROW_34_753 VSS VDD sky130_fd_sc_hd__tapvpwrvgnd_1
XTAP_TAPCELL_ROW_34_754 VSS VDD sky130_fd_sc_hd__tapvpwrvgnd_1
XTAP_TAPCELL_ROW_34_755 VSS VDD sky130_fd_sc_hd__tapvpwrvgnd_1
XTAP_TAPCELL_ROW_35_756 VSS VDD sky130_fd_sc_hd__tapvpwrvgnd_1
XTAP_TAPCELL_ROW_35_757 VSS VDD sky130_fd_sc_hd__tapvpwrvgnd_1
XTAP_TAPCELL_ROW_35_758 VSS VDD sky130_fd_sc_hd__tapvpwrvgnd_1
XTAP_TAPCELL_ROW_35_759 VSS VDD sky130_fd_sc_hd__tapvpwrvgnd_1
XTAP_TAPCELL_ROW_35_760 VSS VDD sky130_fd_sc_hd__tapvpwrvgnd_1
XTAP_TAPCELL_ROW_35_761 VSS VDD sky130_fd_sc_hd__tapvpwrvgnd_1
XTAP_TAPCELL_ROW_35_762 VSS VDD sky130_fd_sc_hd__tapvpwrvgnd_1
XTAP_TAPCELL_ROW_35_763 VSS VDD sky130_fd_sc_hd__tapvpwrvgnd_1
XTAP_TAPCELL_ROW_35_764 VSS VDD sky130_fd_sc_hd__tapvpwrvgnd_1
XTAP_TAPCELL_ROW_35_765 VSS VDD sky130_fd_sc_hd__tapvpwrvgnd_1
XTAP_TAPCELL_ROW_35_766 VSS VDD sky130_fd_sc_hd__tapvpwrvgnd_1
XTAP_TAPCELL_ROW_35_767 VSS VDD sky130_fd_sc_hd__tapvpwrvgnd_1
XTAP_TAPCELL_ROW_35_768 VSS VDD sky130_fd_sc_hd__tapvpwrvgnd_1
XTAP_TAPCELL_ROW_35_769 VSS VDD sky130_fd_sc_hd__tapvpwrvgnd_1
XTAP_TAPCELL_ROW_35_770 VSS VDD sky130_fd_sc_hd__tapvpwrvgnd_1
XTAP_TAPCELL_ROW_35_771 VSS VDD sky130_fd_sc_hd__tapvpwrvgnd_1
XTAP_TAPCELL_ROW_35_772 VSS VDD sky130_fd_sc_hd__tapvpwrvgnd_1
XTAP_TAPCELL_ROW_35_773 VSS VDD sky130_fd_sc_hd__tapvpwrvgnd_1
XTAP_TAPCELL_ROW_35_774 VSS VDD sky130_fd_sc_hd__tapvpwrvgnd_1
XTAP_TAPCELL_ROW_35_775 VSS VDD sky130_fd_sc_hd__tapvpwrvgnd_1
XTAP_TAPCELL_ROW_35_776 VSS VDD sky130_fd_sc_hd__tapvpwrvgnd_1
XTAP_TAPCELL_ROW_36_777 VSS VDD sky130_fd_sc_hd__tapvpwrvgnd_1
XTAP_TAPCELL_ROW_36_778 VSS VDD sky130_fd_sc_hd__tapvpwrvgnd_1
XTAP_TAPCELL_ROW_36_779 VSS VDD sky130_fd_sc_hd__tapvpwrvgnd_1
XTAP_TAPCELL_ROW_36_780 VSS VDD sky130_fd_sc_hd__tapvpwrvgnd_1
XTAP_TAPCELL_ROW_36_781 VSS VDD sky130_fd_sc_hd__tapvpwrvgnd_1
XTAP_TAPCELL_ROW_36_782 VSS VDD sky130_fd_sc_hd__tapvpwrvgnd_1
XTAP_TAPCELL_ROW_36_783 VSS VDD sky130_fd_sc_hd__tapvpwrvgnd_1
XTAP_TAPCELL_ROW_36_784 VSS VDD sky130_fd_sc_hd__tapvpwrvgnd_1
XTAP_TAPCELL_ROW_36_785 VSS VDD sky130_fd_sc_hd__tapvpwrvgnd_1
XTAP_TAPCELL_ROW_36_786 VSS VDD sky130_fd_sc_hd__tapvpwrvgnd_1
XTAP_TAPCELL_ROW_36_787 VSS VDD sky130_fd_sc_hd__tapvpwrvgnd_1
XTAP_TAPCELL_ROW_36_788 VSS VDD sky130_fd_sc_hd__tapvpwrvgnd_1
XTAP_TAPCELL_ROW_36_789 VSS VDD sky130_fd_sc_hd__tapvpwrvgnd_1
XTAP_TAPCELL_ROW_36_790 VSS VDD sky130_fd_sc_hd__tapvpwrvgnd_1
XTAP_TAPCELL_ROW_36_791 VSS VDD sky130_fd_sc_hd__tapvpwrvgnd_1
XTAP_TAPCELL_ROW_36_792 VSS VDD sky130_fd_sc_hd__tapvpwrvgnd_1
XTAP_TAPCELL_ROW_36_793 VSS VDD sky130_fd_sc_hd__tapvpwrvgnd_1
XTAP_TAPCELL_ROW_36_794 VSS VDD sky130_fd_sc_hd__tapvpwrvgnd_1
XTAP_TAPCELL_ROW_36_795 VSS VDD sky130_fd_sc_hd__tapvpwrvgnd_1
XTAP_TAPCELL_ROW_36_796 VSS VDD sky130_fd_sc_hd__tapvpwrvgnd_1
XTAP_TAPCELL_ROW_36_797 VSS VDD sky130_fd_sc_hd__tapvpwrvgnd_1
XTAP_TAPCELL_ROW_37_798 VSS VDD sky130_fd_sc_hd__tapvpwrvgnd_1
XTAP_TAPCELL_ROW_37_799 VSS VDD sky130_fd_sc_hd__tapvpwrvgnd_1
XTAP_TAPCELL_ROW_37_800 VSS VDD sky130_fd_sc_hd__tapvpwrvgnd_1
XTAP_TAPCELL_ROW_37_801 VSS VDD sky130_fd_sc_hd__tapvpwrvgnd_1
XTAP_TAPCELL_ROW_37_802 VSS VDD sky130_fd_sc_hd__tapvpwrvgnd_1
XTAP_TAPCELL_ROW_37_803 VSS VDD sky130_fd_sc_hd__tapvpwrvgnd_1
XTAP_TAPCELL_ROW_37_804 VSS VDD sky130_fd_sc_hd__tapvpwrvgnd_1
XTAP_TAPCELL_ROW_37_805 VSS VDD sky130_fd_sc_hd__tapvpwrvgnd_1
XTAP_TAPCELL_ROW_37_806 VSS VDD sky130_fd_sc_hd__tapvpwrvgnd_1
XTAP_TAPCELL_ROW_37_807 VSS VDD sky130_fd_sc_hd__tapvpwrvgnd_1
XTAP_TAPCELL_ROW_37_808 VSS VDD sky130_fd_sc_hd__tapvpwrvgnd_1
XTAP_TAPCELL_ROW_37_809 VSS VDD sky130_fd_sc_hd__tapvpwrvgnd_1
XTAP_TAPCELL_ROW_37_810 VSS VDD sky130_fd_sc_hd__tapvpwrvgnd_1
XTAP_TAPCELL_ROW_37_811 VSS VDD sky130_fd_sc_hd__tapvpwrvgnd_1
XTAP_TAPCELL_ROW_37_812 VSS VDD sky130_fd_sc_hd__tapvpwrvgnd_1
XTAP_TAPCELL_ROW_37_813 VSS VDD sky130_fd_sc_hd__tapvpwrvgnd_1
XTAP_TAPCELL_ROW_37_814 VSS VDD sky130_fd_sc_hd__tapvpwrvgnd_1
XTAP_TAPCELL_ROW_37_815 VSS VDD sky130_fd_sc_hd__tapvpwrvgnd_1
XTAP_TAPCELL_ROW_37_816 VSS VDD sky130_fd_sc_hd__tapvpwrvgnd_1
XTAP_TAPCELL_ROW_37_817 VSS VDD sky130_fd_sc_hd__tapvpwrvgnd_1
XTAP_TAPCELL_ROW_37_818 VSS VDD sky130_fd_sc_hd__tapvpwrvgnd_1
XTAP_TAPCELL_ROW_38_819 VSS VDD sky130_fd_sc_hd__tapvpwrvgnd_1
XTAP_TAPCELL_ROW_38_820 VSS VDD sky130_fd_sc_hd__tapvpwrvgnd_1
XTAP_TAPCELL_ROW_38_821 VSS VDD sky130_fd_sc_hd__tapvpwrvgnd_1
XTAP_TAPCELL_ROW_38_822 VSS VDD sky130_fd_sc_hd__tapvpwrvgnd_1
XTAP_TAPCELL_ROW_38_823 VSS VDD sky130_fd_sc_hd__tapvpwrvgnd_1
XTAP_TAPCELL_ROW_38_824 VSS VDD sky130_fd_sc_hd__tapvpwrvgnd_1
XTAP_TAPCELL_ROW_38_825 VSS VDD sky130_fd_sc_hd__tapvpwrvgnd_1
XTAP_TAPCELL_ROW_38_826 VSS VDD sky130_fd_sc_hd__tapvpwrvgnd_1
XTAP_TAPCELL_ROW_38_827 VSS VDD sky130_fd_sc_hd__tapvpwrvgnd_1
XTAP_TAPCELL_ROW_38_828 VSS VDD sky130_fd_sc_hd__tapvpwrvgnd_1
XTAP_TAPCELL_ROW_38_829 VSS VDD sky130_fd_sc_hd__tapvpwrvgnd_1
XTAP_TAPCELL_ROW_38_830 VSS VDD sky130_fd_sc_hd__tapvpwrvgnd_1
XTAP_TAPCELL_ROW_38_831 VSS VDD sky130_fd_sc_hd__tapvpwrvgnd_1
XTAP_TAPCELL_ROW_38_832 VSS VDD sky130_fd_sc_hd__tapvpwrvgnd_1
XTAP_TAPCELL_ROW_38_833 VSS VDD sky130_fd_sc_hd__tapvpwrvgnd_1
XTAP_TAPCELL_ROW_38_834 VSS VDD sky130_fd_sc_hd__tapvpwrvgnd_1
XTAP_TAPCELL_ROW_38_835 VSS VDD sky130_fd_sc_hd__tapvpwrvgnd_1
XTAP_TAPCELL_ROW_38_836 VSS VDD sky130_fd_sc_hd__tapvpwrvgnd_1
XTAP_TAPCELL_ROW_38_837 VSS VDD sky130_fd_sc_hd__tapvpwrvgnd_1
XTAP_TAPCELL_ROW_38_838 VSS VDD sky130_fd_sc_hd__tapvpwrvgnd_1
XTAP_TAPCELL_ROW_38_839 VSS VDD sky130_fd_sc_hd__tapvpwrvgnd_1
XTAP_TAPCELL_ROW_39_840 VSS VDD sky130_fd_sc_hd__tapvpwrvgnd_1
XTAP_TAPCELL_ROW_39_841 VSS VDD sky130_fd_sc_hd__tapvpwrvgnd_1
XTAP_TAPCELL_ROW_39_842 VSS VDD sky130_fd_sc_hd__tapvpwrvgnd_1
XTAP_TAPCELL_ROW_39_843 VSS VDD sky130_fd_sc_hd__tapvpwrvgnd_1
XTAP_TAPCELL_ROW_39_844 VSS VDD sky130_fd_sc_hd__tapvpwrvgnd_1
XTAP_TAPCELL_ROW_39_845 VSS VDD sky130_fd_sc_hd__tapvpwrvgnd_1
XTAP_TAPCELL_ROW_39_846 VSS VDD sky130_fd_sc_hd__tapvpwrvgnd_1
XTAP_TAPCELL_ROW_39_847 VSS VDD sky130_fd_sc_hd__tapvpwrvgnd_1
XTAP_TAPCELL_ROW_39_848 VSS VDD sky130_fd_sc_hd__tapvpwrvgnd_1
XTAP_TAPCELL_ROW_39_849 VSS VDD sky130_fd_sc_hd__tapvpwrvgnd_1
XTAP_TAPCELL_ROW_39_850 VSS VDD sky130_fd_sc_hd__tapvpwrvgnd_1
XTAP_TAPCELL_ROW_39_851 VSS VDD sky130_fd_sc_hd__tapvpwrvgnd_1
XTAP_TAPCELL_ROW_39_852 VSS VDD sky130_fd_sc_hd__tapvpwrvgnd_1
XTAP_TAPCELL_ROW_39_853 VSS VDD sky130_fd_sc_hd__tapvpwrvgnd_1
XTAP_TAPCELL_ROW_39_854 VSS VDD sky130_fd_sc_hd__tapvpwrvgnd_1
XTAP_TAPCELL_ROW_39_855 VSS VDD sky130_fd_sc_hd__tapvpwrvgnd_1
XTAP_TAPCELL_ROW_39_856 VSS VDD sky130_fd_sc_hd__tapvpwrvgnd_1
XTAP_TAPCELL_ROW_39_857 VSS VDD sky130_fd_sc_hd__tapvpwrvgnd_1
XTAP_TAPCELL_ROW_39_858 VSS VDD sky130_fd_sc_hd__tapvpwrvgnd_1
XTAP_TAPCELL_ROW_39_859 VSS VDD sky130_fd_sc_hd__tapvpwrvgnd_1
XTAP_TAPCELL_ROW_39_860 VSS VDD sky130_fd_sc_hd__tapvpwrvgnd_1
XTAP_TAPCELL_ROW_40_861 VSS VDD sky130_fd_sc_hd__tapvpwrvgnd_1
XTAP_TAPCELL_ROW_40_862 VSS VDD sky130_fd_sc_hd__tapvpwrvgnd_1
XTAP_TAPCELL_ROW_40_863 VSS VDD sky130_fd_sc_hd__tapvpwrvgnd_1
XTAP_TAPCELL_ROW_40_864 VSS VDD sky130_fd_sc_hd__tapvpwrvgnd_1
XTAP_TAPCELL_ROW_40_865 VSS VDD sky130_fd_sc_hd__tapvpwrvgnd_1
XTAP_TAPCELL_ROW_40_866 VSS VDD sky130_fd_sc_hd__tapvpwrvgnd_1
XTAP_TAPCELL_ROW_40_867 VSS VDD sky130_fd_sc_hd__tapvpwrvgnd_1
XTAP_TAPCELL_ROW_40_868 VSS VDD sky130_fd_sc_hd__tapvpwrvgnd_1
XTAP_TAPCELL_ROW_40_869 VSS VDD sky130_fd_sc_hd__tapvpwrvgnd_1
XTAP_TAPCELL_ROW_40_870 VSS VDD sky130_fd_sc_hd__tapvpwrvgnd_1
XTAP_TAPCELL_ROW_40_871 VSS VDD sky130_fd_sc_hd__tapvpwrvgnd_1
XTAP_TAPCELL_ROW_40_872 VSS VDD sky130_fd_sc_hd__tapvpwrvgnd_1
XTAP_TAPCELL_ROW_40_873 VSS VDD sky130_fd_sc_hd__tapvpwrvgnd_1
XTAP_TAPCELL_ROW_40_874 VSS VDD sky130_fd_sc_hd__tapvpwrvgnd_1
XTAP_TAPCELL_ROW_40_875 VSS VDD sky130_fd_sc_hd__tapvpwrvgnd_1
XTAP_TAPCELL_ROW_40_876 VSS VDD sky130_fd_sc_hd__tapvpwrvgnd_1
XTAP_TAPCELL_ROW_40_877 VSS VDD sky130_fd_sc_hd__tapvpwrvgnd_1
XTAP_TAPCELL_ROW_40_878 VSS VDD sky130_fd_sc_hd__tapvpwrvgnd_1
XTAP_TAPCELL_ROW_40_879 VSS VDD sky130_fd_sc_hd__tapvpwrvgnd_1
XTAP_TAPCELL_ROW_40_880 VSS VDD sky130_fd_sc_hd__tapvpwrvgnd_1
XTAP_TAPCELL_ROW_40_881 VSS VDD sky130_fd_sc_hd__tapvpwrvgnd_1
XTAP_TAPCELL_ROW_41_882 VSS VDD sky130_fd_sc_hd__tapvpwrvgnd_1
XTAP_TAPCELL_ROW_41_883 VSS VDD sky130_fd_sc_hd__tapvpwrvgnd_1
XTAP_TAPCELL_ROW_41_884 VSS VDD sky130_fd_sc_hd__tapvpwrvgnd_1
XTAP_TAPCELL_ROW_41_885 VSS VDD sky130_fd_sc_hd__tapvpwrvgnd_1
XTAP_TAPCELL_ROW_41_886 VSS VDD sky130_fd_sc_hd__tapvpwrvgnd_1
XTAP_TAPCELL_ROW_41_887 VSS VDD sky130_fd_sc_hd__tapvpwrvgnd_1
XTAP_TAPCELL_ROW_41_888 VSS VDD sky130_fd_sc_hd__tapvpwrvgnd_1
XTAP_TAPCELL_ROW_41_889 VSS VDD sky130_fd_sc_hd__tapvpwrvgnd_1
XTAP_TAPCELL_ROW_41_890 VSS VDD sky130_fd_sc_hd__tapvpwrvgnd_1
XTAP_TAPCELL_ROW_41_891 VSS VDD sky130_fd_sc_hd__tapvpwrvgnd_1
XTAP_TAPCELL_ROW_41_892 VSS VDD sky130_fd_sc_hd__tapvpwrvgnd_1
XTAP_TAPCELL_ROW_41_893 VSS VDD sky130_fd_sc_hd__tapvpwrvgnd_1
XTAP_TAPCELL_ROW_41_894 VSS VDD sky130_fd_sc_hd__tapvpwrvgnd_1
XTAP_TAPCELL_ROW_41_895 VSS VDD sky130_fd_sc_hd__tapvpwrvgnd_1
XTAP_TAPCELL_ROW_41_896 VSS VDD sky130_fd_sc_hd__tapvpwrvgnd_1
XTAP_TAPCELL_ROW_41_897 VSS VDD sky130_fd_sc_hd__tapvpwrvgnd_1
XTAP_TAPCELL_ROW_41_898 VSS VDD sky130_fd_sc_hd__tapvpwrvgnd_1
XTAP_TAPCELL_ROW_41_899 VSS VDD sky130_fd_sc_hd__tapvpwrvgnd_1
XTAP_TAPCELL_ROW_41_900 VSS VDD sky130_fd_sc_hd__tapvpwrvgnd_1
XTAP_TAPCELL_ROW_41_901 VSS VDD sky130_fd_sc_hd__tapvpwrvgnd_1
XTAP_TAPCELL_ROW_41_902 VSS VDD sky130_fd_sc_hd__tapvpwrvgnd_1
XTAP_TAPCELL_ROW_42_903 VSS VDD sky130_fd_sc_hd__tapvpwrvgnd_1
XTAP_TAPCELL_ROW_42_904 VSS VDD sky130_fd_sc_hd__tapvpwrvgnd_1
XTAP_TAPCELL_ROW_42_905 VSS VDD sky130_fd_sc_hd__tapvpwrvgnd_1
XTAP_TAPCELL_ROW_42_906 VSS VDD sky130_fd_sc_hd__tapvpwrvgnd_1
XTAP_TAPCELL_ROW_42_907 VSS VDD sky130_fd_sc_hd__tapvpwrvgnd_1
XTAP_TAPCELL_ROW_42_908 VSS VDD sky130_fd_sc_hd__tapvpwrvgnd_1
XTAP_TAPCELL_ROW_42_909 VSS VDD sky130_fd_sc_hd__tapvpwrvgnd_1
XTAP_TAPCELL_ROW_42_910 VSS VDD sky130_fd_sc_hd__tapvpwrvgnd_1
XTAP_TAPCELL_ROW_42_911 VSS VDD sky130_fd_sc_hd__tapvpwrvgnd_1
XTAP_TAPCELL_ROW_42_912 VSS VDD sky130_fd_sc_hd__tapvpwrvgnd_1
XTAP_TAPCELL_ROW_42_913 VSS VDD sky130_fd_sc_hd__tapvpwrvgnd_1
XTAP_TAPCELL_ROW_42_914 VSS VDD sky130_fd_sc_hd__tapvpwrvgnd_1
XTAP_TAPCELL_ROW_42_915 VSS VDD sky130_fd_sc_hd__tapvpwrvgnd_1
XTAP_TAPCELL_ROW_42_916 VSS VDD sky130_fd_sc_hd__tapvpwrvgnd_1
XTAP_TAPCELL_ROW_42_917 VSS VDD sky130_fd_sc_hd__tapvpwrvgnd_1
XTAP_TAPCELL_ROW_42_918 VSS VDD sky130_fd_sc_hd__tapvpwrvgnd_1
XTAP_TAPCELL_ROW_42_919 VSS VDD sky130_fd_sc_hd__tapvpwrvgnd_1
XTAP_TAPCELL_ROW_42_920 VSS VDD sky130_fd_sc_hd__tapvpwrvgnd_1
XTAP_TAPCELL_ROW_42_921 VSS VDD sky130_fd_sc_hd__tapvpwrvgnd_1
XTAP_TAPCELL_ROW_42_922 VSS VDD sky130_fd_sc_hd__tapvpwrvgnd_1
XTAP_TAPCELL_ROW_42_923 VSS VDD sky130_fd_sc_hd__tapvpwrvgnd_1
XTAP_TAPCELL_ROW_43_924 VSS VDD sky130_fd_sc_hd__tapvpwrvgnd_1
XTAP_TAPCELL_ROW_43_925 VSS VDD sky130_fd_sc_hd__tapvpwrvgnd_1
XTAP_TAPCELL_ROW_43_926 VSS VDD sky130_fd_sc_hd__tapvpwrvgnd_1
XTAP_TAPCELL_ROW_43_927 VSS VDD sky130_fd_sc_hd__tapvpwrvgnd_1
XTAP_TAPCELL_ROW_43_928 VSS VDD sky130_fd_sc_hd__tapvpwrvgnd_1
XTAP_TAPCELL_ROW_43_929 VSS VDD sky130_fd_sc_hd__tapvpwrvgnd_1
XTAP_TAPCELL_ROW_43_930 VSS VDD sky130_fd_sc_hd__tapvpwrvgnd_1
XTAP_TAPCELL_ROW_43_931 VSS VDD sky130_fd_sc_hd__tapvpwrvgnd_1
XTAP_TAPCELL_ROW_43_932 VSS VDD sky130_fd_sc_hd__tapvpwrvgnd_1
XTAP_TAPCELL_ROW_43_933 VSS VDD sky130_fd_sc_hd__tapvpwrvgnd_1
XTAP_TAPCELL_ROW_43_934 VSS VDD sky130_fd_sc_hd__tapvpwrvgnd_1
XTAP_TAPCELL_ROW_43_935 VSS VDD sky130_fd_sc_hd__tapvpwrvgnd_1
XTAP_TAPCELL_ROW_43_936 VSS VDD sky130_fd_sc_hd__tapvpwrvgnd_1
XTAP_TAPCELL_ROW_43_937 VSS VDD sky130_fd_sc_hd__tapvpwrvgnd_1
XTAP_TAPCELL_ROW_43_938 VSS VDD sky130_fd_sc_hd__tapvpwrvgnd_1
XTAP_TAPCELL_ROW_43_939 VSS VDD sky130_fd_sc_hd__tapvpwrvgnd_1
XTAP_TAPCELL_ROW_43_940 VSS VDD sky130_fd_sc_hd__tapvpwrvgnd_1
XTAP_TAPCELL_ROW_43_941 VSS VDD sky130_fd_sc_hd__tapvpwrvgnd_1
XTAP_TAPCELL_ROW_43_942 VSS VDD sky130_fd_sc_hd__tapvpwrvgnd_1
XTAP_TAPCELL_ROW_43_943 VSS VDD sky130_fd_sc_hd__tapvpwrvgnd_1
XTAP_TAPCELL_ROW_43_944 VSS VDD sky130_fd_sc_hd__tapvpwrvgnd_1
XTAP_TAPCELL_ROW_44_945 VSS VDD sky130_fd_sc_hd__tapvpwrvgnd_1
XTAP_TAPCELL_ROW_44_946 VSS VDD sky130_fd_sc_hd__tapvpwrvgnd_1
XTAP_TAPCELL_ROW_44_947 VSS VDD sky130_fd_sc_hd__tapvpwrvgnd_1
XTAP_TAPCELL_ROW_44_948 VSS VDD sky130_fd_sc_hd__tapvpwrvgnd_1
XTAP_TAPCELL_ROW_44_949 VSS VDD sky130_fd_sc_hd__tapvpwrvgnd_1
XTAP_TAPCELL_ROW_44_950 VSS VDD sky130_fd_sc_hd__tapvpwrvgnd_1
XTAP_TAPCELL_ROW_44_951 VSS VDD sky130_fd_sc_hd__tapvpwrvgnd_1
XTAP_TAPCELL_ROW_44_952 VSS VDD sky130_fd_sc_hd__tapvpwrvgnd_1
XTAP_TAPCELL_ROW_44_953 VSS VDD sky130_fd_sc_hd__tapvpwrvgnd_1
XTAP_TAPCELL_ROW_44_954 VSS VDD sky130_fd_sc_hd__tapvpwrvgnd_1
XTAP_TAPCELL_ROW_44_955 VSS VDD sky130_fd_sc_hd__tapvpwrvgnd_1
XTAP_TAPCELL_ROW_44_956 VSS VDD sky130_fd_sc_hd__tapvpwrvgnd_1
XTAP_TAPCELL_ROW_44_957 VSS VDD sky130_fd_sc_hd__tapvpwrvgnd_1
XTAP_TAPCELL_ROW_44_958 VSS VDD sky130_fd_sc_hd__tapvpwrvgnd_1
XTAP_TAPCELL_ROW_44_959 VSS VDD sky130_fd_sc_hd__tapvpwrvgnd_1
XTAP_TAPCELL_ROW_44_960 VSS VDD sky130_fd_sc_hd__tapvpwrvgnd_1
XTAP_TAPCELL_ROW_44_961 VSS VDD sky130_fd_sc_hd__tapvpwrvgnd_1
XTAP_TAPCELL_ROW_44_962 VSS VDD sky130_fd_sc_hd__tapvpwrvgnd_1
XTAP_TAPCELL_ROW_44_963 VSS VDD sky130_fd_sc_hd__tapvpwrvgnd_1
XTAP_TAPCELL_ROW_44_964 VSS VDD sky130_fd_sc_hd__tapvpwrvgnd_1
XTAP_TAPCELL_ROW_44_965 VSS VDD sky130_fd_sc_hd__tapvpwrvgnd_1
XTAP_TAPCELL_ROW_45_966 VSS VDD sky130_fd_sc_hd__tapvpwrvgnd_1
XTAP_TAPCELL_ROW_45_967 VSS VDD sky130_fd_sc_hd__tapvpwrvgnd_1
XTAP_TAPCELL_ROW_45_968 VSS VDD sky130_fd_sc_hd__tapvpwrvgnd_1
XTAP_TAPCELL_ROW_45_969 VSS VDD sky130_fd_sc_hd__tapvpwrvgnd_1
XTAP_TAPCELL_ROW_45_970 VSS VDD sky130_fd_sc_hd__tapvpwrvgnd_1
XTAP_TAPCELL_ROW_45_971 VSS VDD sky130_fd_sc_hd__tapvpwrvgnd_1
XTAP_TAPCELL_ROW_45_972 VSS VDD sky130_fd_sc_hd__tapvpwrvgnd_1
XTAP_TAPCELL_ROW_45_973 VSS VDD sky130_fd_sc_hd__tapvpwrvgnd_1
XTAP_TAPCELL_ROW_45_974 VSS VDD sky130_fd_sc_hd__tapvpwrvgnd_1
XTAP_TAPCELL_ROW_45_975 VSS VDD sky130_fd_sc_hd__tapvpwrvgnd_1
XTAP_TAPCELL_ROW_45_976 VSS VDD sky130_fd_sc_hd__tapvpwrvgnd_1
XTAP_TAPCELL_ROW_45_977 VSS VDD sky130_fd_sc_hd__tapvpwrvgnd_1
XTAP_TAPCELL_ROW_45_978 VSS VDD sky130_fd_sc_hd__tapvpwrvgnd_1
XTAP_TAPCELL_ROW_45_979 VSS VDD sky130_fd_sc_hd__tapvpwrvgnd_1
XTAP_TAPCELL_ROW_45_980 VSS VDD sky130_fd_sc_hd__tapvpwrvgnd_1
XTAP_TAPCELL_ROW_45_981 VSS VDD sky130_fd_sc_hd__tapvpwrvgnd_1
XTAP_TAPCELL_ROW_45_982 VSS VDD sky130_fd_sc_hd__tapvpwrvgnd_1
XTAP_TAPCELL_ROW_45_983 VSS VDD sky130_fd_sc_hd__tapvpwrvgnd_1
XTAP_TAPCELL_ROW_45_984 VSS VDD sky130_fd_sc_hd__tapvpwrvgnd_1
XTAP_TAPCELL_ROW_45_985 VSS VDD sky130_fd_sc_hd__tapvpwrvgnd_1
XTAP_TAPCELL_ROW_45_986 VSS VDD sky130_fd_sc_hd__tapvpwrvgnd_1
XTAP_TAPCELL_ROW_46_987 VSS VDD sky130_fd_sc_hd__tapvpwrvgnd_1
XTAP_TAPCELL_ROW_46_988 VSS VDD sky130_fd_sc_hd__tapvpwrvgnd_1
XTAP_TAPCELL_ROW_46_989 VSS VDD sky130_fd_sc_hd__tapvpwrvgnd_1
XTAP_TAPCELL_ROW_46_990 VSS VDD sky130_fd_sc_hd__tapvpwrvgnd_1
XTAP_TAPCELL_ROW_46_991 VSS VDD sky130_fd_sc_hd__tapvpwrvgnd_1
XTAP_TAPCELL_ROW_46_992 VSS VDD sky130_fd_sc_hd__tapvpwrvgnd_1
XTAP_TAPCELL_ROW_46_993 VSS VDD sky130_fd_sc_hd__tapvpwrvgnd_1
XTAP_TAPCELL_ROW_46_994 VSS VDD sky130_fd_sc_hd__tapvpwrvgnd_1
XTAP_TAPCELL_ROW_46_995 VSS VDD sky130_fd_sc_hd__tapvpwrvgnd_1
XTAP_TAPCELL_ROW_46_996 VSS VDD sky130_fd_sc_hd__tapvpwrvgnd_1
XTAP_TAPCELL_ROW_46_997 VSS VDD sky130_fd_sc_hd__tapvpwrvgnd_1
XTAP_TAPCELL_ROW_46_998 VSS VDD sky130_fd_sc_hd__tapvpwrvgnd_1
XTAP_TAPCELL_ROW_46_999 VSS VDD sky130_fd_sc_hd__tapvpwrvgnd_1
XTAP_TAPCELL_ROW_46_1000 VSS VDD sky130_fd_sc_hd__tapvpwrvgnd_1
XTAP_TAPCELL_ROW_46_1001 VSS VDD sky130_fd_sc_hd__tapvpwrvgnd_1
XTAP_TAPCELL_ROW_46_1002 VSS VDD sky130_fd_sc_hd__tapvpwrvgnd_1
XTAP_TAPCELL_ROW_46_1003 VSS VDD sky130_fd_sc_hd__tapvpwrvgnd_1
XTAP_TAPCELL_ROW_46_1004 VSS VDD sky130_fd_sc_hd__tapvpwrvgnd_1
XTAP_TAPCELL_ROW_46_1005 VSS VDD sky130_fd_sc_hd__tapvpwrvgnd_1
XTAP_TAPCELL_ROW_46_1006 VSS VDD sky130_fd_sc_hd__tapvpwrvgnd_1
XTAP_TAPCELL_ROW_46_1007 VSS VDD sky130_fd_sc_hd__tapvpwrvgnd_1
XTAP_TAPCELL_ROW_47_1008 VSS VDD sky130_fd_sc_hd__tapvpwrvgnd_1
XTAP_TAPCELL_ROW_47_1009 VSS VDD sky130_fd_sc_hd__tapvpwrvgnd_1
XTAP_TAPCELL_ROW_47_1010 VSS VDD sky130_fd_sc_hd__tapvpwrvgnd_1
XTAP_TAPCELL_ROW_47_1011 VSS VDD sky130_fd_sc_hd__tapvpwrvgnd_1
XTAP_TAPCELL_ROW_47_1012 VSS VDD sky130_fd_sc_hd__tapvpwrvgnd_1
XTAP_TAPCELL_ROW_47_1013 VSS VDD sky130_fd_sc_hd__tapvpwrvgnd_1
XTAP_TAPCELL_ROW_47_1014 VSS VDD sky130_fd_sc_hd__tapvpwrvgnd_1
XTAP_TAPCELL_ROW_47_1015 VSS VDD sky130_fd_sc_hd__tapvpwrvgnd_1
XTAP_TAPCELL_ROW_47_1016 VSS VDD sky130_fd_sc_hd__tapvpwrvgnd_1
XTAP_TAPCELL_ROW_47_1017 VSS VDD sky130_fd_sc_hd__tapvpwrvgnd_1
XTAP_TAPCELL_ROW_47_1018 VSS VDD sky130_fd_sc_hd__tapvpwrvgnd_1
XTAP_TAPCELL_ROW_47_1019 VSS VDD sky130_fd_sc_hd__tapvpwrvgnd_1
XTAP_TAPCELL_ROW_47_1020 VSS VDD sky130_fd_sc_hd__tapvpwrvgnd_1
XTAP_TAPCELL_ROW_47_1021 VSS VDD sky130_fd_sc_hd__tapvpwrvgnd_1
XTAP_TAPCELL_ROW_47_1022 VSS VDD sky130_fd_sc_hd__tapvpwrvgnd_1
XTAP_TAPCELL_ROW_47_1023 VSS VDD sky130_fd_sc_hd__tapvpwrvgnd_1
XTAP_TAPCELL_ROW_47_1024 VSS VDD sky130_fd_sc_hd__tapvpwrvgnd_1
XTAP_TAPCELL_ROW_47_1025 VSS VDD sky130_fd_sc_hd__tapvpwrvgnd_1
XTAP_TAPCELL_ROW_47_1026 VSS VDD sky130_fd_sc_hd__tapvpwrvgnd_1
XTAP_TAPCELL_ROW_47_1027 VSS VDD sky130_fd_sc_hd__tapvpwrvgnd_1
XTAP_TAPCELL_ROW_47_1028 VSS VDD sky130_fd_sc_hd__tapvpwrvgnd_1
XTAP_TAPCELL_ROW_48_1029 VSS VDD sky130_fd_sc_hd__tapvpwrvgnd_1
XTAP_TAPCELL_ROW_48_1030 VSS VDD sky130_fd_sc_hd__tapvpwrvgnd_1
XTAP_TAPCELL_ROW_48_1031 VSS VDD sky130_fd_sc_hd__tapvpwrvgnd_1
XTAP_TAPCELL_ROW_48_1032 VSS VDD sky130_fd_sc_hd__tapvpwrvgnd_1
XTAP_TAPCELL_ROW_48_1033 VSS VDD sky130_fd_sc_hd__tapvpwrvgnd_1
XTAP_TAPCELL_ROW_48_1034 VSS VDD sky130_fd_sc_hd__tapvpwrvgnd_1
XTAP_TAPCELL_ROW_48_1035 VSS VDD sky130_fd_sc_hd__tapvpwrvgnd_1
XTAP_TAPCELL_ROW_48_1036 VSS VDD sky130_fd_sc_hd__tapvpwrvgnd_1
XTAP_TAPCELL_ROW_48_1037 VSS VDD sky130_fd_sc_hd__tapvpwrvgnd_1
XTAP_TAPCELL_ROW_48_1038 VSS VDD sky130_fd_sc_hd__tapvpwrvgnd_1
XTAP_TAPCELL_ROW_48_1039 VSS VDD sky130_fd_sc_hd__tapvpwrvgnd_1
XTAP_TAPCELL_ROW_48_1040 VSS VDD sky130_fd_sc_hd__tapvpwrvgnd_1
XTAP_TAPCELL_ROW_48_1041 VSS VDD sky130_fd_sc_hd__tapvpwrvgnd_1
XTAP_TAPCELL_ROW_48_1042 VSS VDD sky130_fd_sc_hd__tapvpwrvgnd_1
XTAP_TAPCELL_ROW_48_1043 VSS VDD sky130_fd_sc_hd__tapvpwrvgnd_1
XTAP_TAPCELL_ROW_48_1044 VSS VDD sky130_fd_sc_hd__tapvpwrvgnd_1
XTAP_TAPCELL_ROW_48_1045 VSS VDD sky130_fd_sc_hd__tapvpwrvgnd_1
XTAP_TAPCELL_ROW_48_1046 VSS VDD sky130_fd_sc_hd__tapvpwrvgnd_1
XTAP_TAPCELL_ROW_48_1047 VSS VDD sky130_fd_sc_hd__tapvpwrvgnd_1
XTAP_TAPCELL_ROW_48_1048 VSS VDD sky130_fd_sc_hd__tapvpwrvgnd_1
XTAP_TAPCELL_ROW_48_1049 VSS VDD sky130_fd_sc_hd__tapvpwrvgnd_1
XTAP_TAPCELL_ROW_49_1050 VSS VDD sky130_fd_sc_hd__tapvpwrvgnd_1
XTAP_TAPCELL_ROW_49_1051 VSS VDD sky130_fd_sc_hd__tapvpwrvgnd_1
XTAP_TAPCELL_ROW_49_1052 VSS VDD sky130_fd_sc_hd__tapvpwrvgnd_1
XTAP_TAPCELL_ROW_49_1053 VSS VDD sky130_fd_sc_hd__tapvpwrvgnd_1
XTAP_TAPCELL_ROW_49_1054 VSS VDD sky130_fd_sc_hd__tapvpwrvgnd_1
XTAP_TAPCELL_ROW_49_1055 VSS VDD sky130_fd_sc_hd__tapvpwrvgnd_1
XTAP_TAPCELL_ROW_49_1056 VSS VDD sky130_fd_sc_hd__tapvpwrvgnd_1
XTAP_TAPCELL_ROW_49_1057 VSS VDD sky130_fd_sc_hd__tapvpwrvgnd_1
XTAP_TAPCELL_ROW_49_1058 VSS VDD sky130_fd_sc_hd__tapvpwrvgnd_1
XTAP_TAPCELL_ROW_49_1059 VSS VDD sky130_fd_sc_hd__tapvpwrvgnd_1
XTAP_TAPCELL_ROW_49_1060 VSS VDD sky130_fd_sc_hd__tapvpwrvgnd_1
XTAP_TAPCELL_ROW_49_1061 VSS VDD sky130_fd_sc_hd__tapvpwrvgnd_1
XTAP_TAPCELL_ROW_49_1062 VSS VDD sky130_fd_sc_hd__tapvpwrvgnd_1
XTAP_TAPCELL_ROW_49_1063 VSS VDD sky130_fd_sc_hd__tapvpwrvgnd_1
XTAP_TAPCELL_ROW_49_1064 VSS VDD sky130_fd_sc_hd__tapvpwrvgnd_1
XTAP_TAPCELL_ROW_49_1065 VSS VDD sky130_fd_sc_hd__tapvpwrvgnd_1
XTAP_TAPCELL_ROW_49_1066 VSS VDD sky130_fd_sc_hd__tapvpwrvgnd_1
XTAP_TAPCELL_ROW_49_1067 VSS VDD sky130_fd_sc_hd__tapvpwrvgnd_1
XTAP_TAPCELL_ROW_49_1068 VSS VDD sky130_fd_sc_hd__tapvpwrvgnd_1
XTAP_TAPCELL_ROW_49_1069 VSS VDD sky130_fd_sc_hd__tapvpwrvgnd_1
XTAP_TAPCELL_ROW_49_1070 VSS VDD sky130_fd_sc_hd__tapvpwrvgnd_1
XTAP_TAPCELL_ROW_50_1071 VSS VDD sky130_fd_sc_hd__tapvpwrvgnd_1
XTAP_TAPCELL_ROW_50_1072 VSS VDD sky130_fd_sc_hd__tapvpwrvgnd_1
XTAP_TAPCELL_ROW_50_1073 VSS VDD sky130_fd_sc_hd__tapvpwrvgnd_1
XTAP_TAPCELL_ROW_50_1074 VSS VDD sky130_fd_sc_hd__tapvpwrvgnd_1
XTAP_TAPCELL_ROW_50_1075 VSS VDD sky130_fd_sc_hd__tapvpwrvgnd_1
XTAP_TAPCELL_ROW_50_1076 VSS VDD sky130_fd_sc_hd__tapvpwrvgnd_1
XTAP_TAPCELL_ROW_50_1077 VSS VDD sky130_fd_sc_hd__tapvpwrvgnd_1
XTAP_TAPCELL_ROW_50_1078 VSS VDD sky130_fd_sc_hd__tapvpwrvgnd_1
XTAP_TAPCELL_ROW_50_1079 VSS VDD sky130_fd_sc_hd__tapvpwrvgnd_1
XTAP_TAPCELL_ROW_50_1080 VSS VDD sky130_fd_sc_hd__tapvpwrvgnd_1
XTAP_TAPCELL_ROW_50_1081 VSS VDD sky130_fd_sc_hd__tapvpwrvgnd_1
XTAP_TAPCELL_ROW_50_1082 VSS VDD sky130_fd_sc_hd__tapvpwrvgnd_1
XTAP_TAPCELL_ROW_50_1083 VSS VDD sky130_fd_sc_hd__tapvpwrvgnd_1
XTAP_TAPCELL_ROW_50_1084 VSS VDD sky130_fd_sc_hd__tapvpwrvgnd_1
XTAP_TAPCELL_ROW_50_1085 VSS VDD sky130_fd_sc_hd__tapvpwrvgnd_1
XTAP_TAPCELL_ROW_50_1086 VSS VDD sky130_fd_sc_hd__tapvpwrvgnd_1
XTAP_TAPCELL_ROW_50_1087 VSS VDD sky130_fd_sc_hd__tapvpwrvgnd_1
XTAP_TAPCELL_ROW_50_1088 VSS VDD sky130_fd_sc_hd__tapvpwrvgnd_1
XTAP_TAPCELL_ROW_50_1089 VSS VDD sky130_fd_sc_hd__tapvpwrvgnd_1
XTAP_TAPCELL_ROW_50_1090 VSS VDD sky130_fd_sc_hd__tapvpwrvgnd_1
XTAP_TAPCELL_ROW_50_1091 VSS VDD sky130_fd_sc_hd__tapvpwrvgnd_1
XTAP_TAPCELL_ROW_51_1092 VSS VDD sky130_fd_sc_hd__tapvpwrvgnd_1
XTAP_TAPCELL_ROW_51_1093 VSS VDD sky130_fd_sc_hd__tapvpwrvgnd_1
XTAP_TAPCELL_ROW_51_1094 VSS VDD sky130_fd_sc_hd__tapvpwrvgnd_1
XTAP_TAPCELL_ROW_51_1095 VSS VDD sky130_fd_sc_hd__tapvpwrvgnd_1
XTAP_TAPCELL_ROW_51_1096 VSS VDD sky130_fd_sc_hd__tapvpwrvgnd_1
XTAP_TAPCELL_ROW_51_1097 VSS VDD sky130_fd_sc_hd__tapvpwrvgnd_1
XTAP_TAPCELL_ROW_51_1098 VSS VDD sky130_fd_sc_hd__tapvpwrvgnd_1
XTAP_TAPCELL_ROW_51_1099 VSS VDD sky130_fd_sc_hd__tapvpwrvgnd_1
XTAP_TAPCELL_ROW_51_1100 VSS VDD sky130_fd_sc_hd__tapvpwrvgnd_1
XTAP_TAPCELL_ROW_51_1101 VSS VDD sky130_fd_sc_hd__tapvpwrvgnd_1
XTAP_TAPCELL_ROW_51_1102 VSS VDD sky130_fd_sc_hd__tapvpwrvgnd_1
XTAP_TAPCELL_ROW_51_1103 VSS VDD sky130_fd_sc_hd__tapvpwrvgnd_1
XTAP_TAPCELL_ROW_51_1104 VSS VDD sky130_fd_sc_hd__tapvpwrvgnd_1
XTAP_TAPCELL_ROW_51_1105 VSS VDD sky130_fd_sc_hd__tapvpwrvgnd_1
XTAP_TAPCELL_ROW_51_1106 VSS VDD sky130_fd_sc_hd__tapvpwrvgnd_1
XTAP_TAPCELL_ROW_51_1107 VSS VDD sky130_fd_sc_hd__tapvpwrvgnd_1
XTAP_TAPCELL_ROW_51_1108 VSS VDD sky130_fd_sc_hd__tapvpwrvgnd_1
XTAP_TAPCELL_ROW_51_1109 VSS VDD sky130_fd_sc_hd__tapvpwrvgnd_1
XTAP_TAPCELL_ROW_51_1110 VSS VDD sky130_fd_sc_hd__tapvpwrvgnd_1
XTAP_TAPCELL_ROW_51_1111 VSS VDD sky130_fd_sc_hd__tapvpwrvgnd_1
XTAP_TAPCELL_ROW_51_1112 VSS VDD sky130_fd_sc_hd__tapvpwrvgnd_1
XTAP_TAPCELL_ROW_52_1113 VSS VDD sky130_fd_sc_hd__tapvpwrvgnd_1
XTAP_TAPCELL_ROW_52_1114 VSS VDD sky130_fd_sc_hd__tapvpwrvgnd_1
XTAP_TAPCELL_ROW_52_1115 VSS VDD sky130_fd_sc_hd__tapvpwrvgnd_1
XTAP_TAPCELL_ROW_52_1116 VSS VDD sky130_fd_sc_hd__tapvpwrvgnd_1
XTAP_TAPCELL_ROW_52_1117 VSS VDD sky130_fd_sc_hd__tapvpwrvgnd_1
XTAP_TAPCELL_ROW_52_1118 VSS VDD sky130_fd_sc_hd__tapvpwrvgnd_1
XTAP_TAPCELL_ROW_52_1119 VSS VDD sky130_fd_sc_hd__tapvpwrvgnd_1
XTAP_TAPCELL_ROW_52_1120 VSS VDD sky130_fd_sc_hd__tapvpwrvgnd_1
XTAP_TAPCELL_ROW_52_1121 VSS VDD sky130_fd_sc_hd__tapvpwrvgnd_1
XTAP_TAPCELL_ROW_52_1122 VSS VDD sky130_fd_sc_hd__tapvpwrvgnd_1
XTAP_TAPCELL_ROW_52_1123 VSS VDD sky130_fd_sc_hd__tapvpwrvgnd_1
XTAP_TAPCELL_ROW_52_1124 VSS VDD sky130_fd_sc_hd__tapvpwrvgnd_1
XTAP_TAPCELL_ROW_52_1125 VSS VDD sky130_fd_sc_hd__tapvpwrvgnd_1
XTAP_TAPCELL_ROW_52_1126 VSS VDD sky130_fd_sc_hd__tapvpwrvgnd_1
XTAP_TAPCELL_ROW_52_1127 VSS VDD sky130_fd_sc_hd__tapvpwrvgnd_1
XTAP_TAPCELL_ROW_52_1128 VSS VDD sky130_fd_sc_hd__tapvpwrvgnd_1
XTAP_TAPCELL_ROW_52_1129 VSS VDD sky130_fd_sc_hd__tapvpwrvgnd_1
XTAP_TAPCELL_ROW_52_1130 VSS VDD sky130_fd_sc_hd__tapvpwrvgnd_1
XTAP_TAPCELL_ROW_52_1131 VSS VDD sky130_fd_sc_hd__tapvpwrvgnd_1
XTAP_TAPCELL_ROW_52_1132 VSS VDD sky130_fd_sc_hd__tapvpwrvgnd_1
XTAP_TAPCELL_ROW_52_1133 VSS VDD sky130_fd_sc_hd__tapvpwrvgnd_1
XTAP_TAPCELL_ROW_53_1134 VSS VDD sky130_fd_sc_hd__tapvpwrvgnd_1
XTAP_TAPCELL_ROW_53_1135 VSS VDD sky130_fd_sc_hd__tapvpwrvgnd_1
XTAP_TAPCELL_ROW_53_1136 VSS VDD sky130_fd_sc_hd__tapvpwrvgnd_1
XTAP_TAPCELL_ROW_53_1137 VSS VDD sky130_fd_sc_hd__tapvpwrvgnd_1
XTAP_TAPCELL_ROW_53_1138 VSS VDD sky130_fd_sc_hd__tapvpwrvgnd_1
XTAP_TAPCELL_ROW_53_1139 VSS VDD sky130_fd_sc_hd__tapvpwrvgnd_1
XTAP_TAPCELL_ROW_53_1140 VSS VDD sky130_fd_sc_hd__tapvpwrvgnd_1
XTAP_TAPCELL_ROW_53_1141 VSS VDD sky130_fd_sc_hd__tapvpwrvgnd_1
XTAP_TAPCELL_ROW_53_1142 VSS VDD sky130_fd_sc_hd__tapvpwrvgnd_1
XTAP_TAPCELL_ROW_53_1143 VSS VDD sky130_fd_sc_hd__tapvpwrvgnd_1
XTAP_TAPCELL_ROW_53_1144 VSS VDD sky130_fd_sc_hd__tapvpwrvgnd_1
XTAP_TAPCELL_ROW_53_1145 VSS VDD sky130_fd_sc_hd__tapvpwrvgnd_1
XTAP_TAPCELL_ROW_53_1146 VSS VDD sky130_fd_sc_hd__tapvpwrvgnd_1
XTAP_TAPCELL_ROW_53_1147 VSS VDD sky130_fd_sc_hd__tapvpwrvgnd_1
XTAP_TAPCELL_ROW_53_1148 VSS VDD sky130_fd_sc_hd__tapvpwrvgnd_1
XTAP_TAPCELL_ROW_53_1149 VSS VDD sky130_fd_sc_hd__tapvpwrvgnd_1
XTAP_TAPCELL_ROW_53_1150 VSS VDD sky130_fd_sc_hd__tapvpwrvgnd_1
XTAP_TAPCELL_ROW_53_1151 VSS VDD sky130_fd_sc_hd__tapvpwrvgnd_1
XTAP_TAPCELL_ROW_53_1152 VSS VDD sky130_fd_sc_hd__tapvpwrvgnd_1
XTAP_TAPCELL_ROW_53_1153 VSS VDD sky130_fd_sc_hd__tapvpwrvgnd_1
XTAP_TAPCELL_ROW_53_1154 VSS VDD sky130_fd_sc_hd__tapvpwrvgnd_1
XTAP_TAPCELL_ROW_54_1155 VSS VDD sky130_fd_sc_hd__tapvpwrvgnd_1
XTAP_TAPCELL_ROW_54_1156 VSS VDD sky130_fd_sc_hd__tapvpwrvgnd_1
XTAP_TAPCELL_ROW_54_1157 VSS VDD sky130_fd_sc_hd__tapvpwrvgnd_1
XTAP_TAPCELL_ROW_54_1158 VSS VDD sky130_fd_sc_hd__tapvpwrvgnd_1
XTAP_TAPCELL_ROW_54_1159 VSS VDD sky130_fd_sc_hd__tapvpwrvgnd_1
XTAP_TAPCELL_ROW_54_1160 VSS VDD sky130_fd_sc_hd__tapvpwrvgnd_1
XTAP_TAPCELL_ROW_54_1161 VSS VDD sky130_fd_sc_hd__tapvpwrvgnd_1
XTAP_TAPCELL_ROW_54_1162 VSS VDD sky130_fd_sc_hd__tapvpwrvgnd_1
XTAP_TAPCELL_ROW_54_1163 VSS VDD sky130_fd_sc_hd__tapvpwrvgnd_1
XTAP_TAPCELL_ROW_54_1164 VSS VDD sky130_fd_sc_hd__tapvpwrvgnd_1
XTAP_TAPCELL_ROW_54_1165 VSS VDD sky130_fd_sc_hd__tapvpwrvgnd_1
XTAP_TAPCELL_ROW_54_1166 VSS VDD sky130_fd_sc_hd__tapvpwrvgnd_1
XTAP_TAPCELL_ROW_54_1167 VSS VDD sky130_fd_sc_hd__tapvpwrvgnd_1
XTAP_TAPCELL_ROW_54_1168 VSS VDD sky130_fd_sc_hd__tapvpwrvgnd_1
XTAP_TAPCELL_ROW_54_1169 VSS VDD sky130_fd_sc_hd__tapvpwrvgnd_1
XTAP_TAPCELL_ROW_54_1170 VSS VDD sky130_fd_sc_hd__tapvpwrvgnd_1
XTAP_TAPCELL_ROW_54_1171 VSS VDD sky130_fd_sc_hd__tapvpwrvgnd_1
XTAP_TAPCELL_ROW_54_1172 VSS VDD sky130_fd_sc_hd__tapvpwrvgnd_1
XTAP_TAPCELL_ROW_54_1173 VSS VDD sky130_fd_sc_hd__tapvpwrvgnd_1
XTAP_TAPCELL_ROW_54_1174 VSS VDD sky130_fd_sc_hd__tapvpwrvgnd_1
XTAP_TAPCELL_ROW_54_1175 VSS VDD sky130_fd_sc_hd__tapvpwrvgnd_1
XTAP_TAPCELL_ROW_55_1176 VSS VDD sky130_fd_sc_hd__tapvpwrvgnd_1
XTAP_TAPCELL_ROW_55_1177 VSS VDD sky130_fd_sc_hd__tapvpwrvgnd_1
XTAP_TAPCELL_ROW_55_1178 VSS VDD sky130_fd_sc_hd__tapvpwrvgnd_1
XTAP_TAPCELL_ROW_55_1179 VSS VDD sky130_fd_sc_hd__tapvpwrvgnd_1
XTAP_TAPCELL_ROW_55_1180 VSS VDD sky130_fd_sc_hd__tapvpwrvgnd_1
XTAP_TAPCELL_ROW_55_1181 VSS VDD sky130_fd_sc_hd__tapvpwrvgnd_1
XTAP_TAPCELL_ROW_55_1182 VSS VDD sky130_fd_sc_hd__tapvpwrvgnd_1
XTAP_TAPCELL_ROW_55_1183 VSS VDD sky130_fd_sc_hd__tapvpwrvgnd_1
XTAP_TAPCELL_ROW_55_1184 VSS VDD sky130_fd_sc_hd__tapvpwrvgnd_1
XTAP_TAPCELL_ROW_55_1185 VSS VDD sky130_fd_sc_hd__tapvpwrvgnd_1
XTAP_TAPCELL_ROW_55_1186 VSS VDD sky130_fd_sc_hd__tapvpwrvgnd_1
XTAP_TAPCELL_ROW_55_1187 VSS VDD sky130_fd_sc_hd__tapvpwrvgnd_1
XTAP_TAPCELL_ROW_55_1188 VSS VDD sky130_fd_sc_hd__tapvpwrvgnd_1
XTAP_TAPCELL_ROW_55_1189 VSS VDD sky130_fd_sc_hd__tapvpwrvgnd_1
XTAP_TAPCELL_ROW_55_1190 VSS VDD sky130_fd_sc_hd__tapvpwrvgnd_1
XTAP_TAPCELL_ROW_55_1191 VSS VDD sky130_fd_sc_hd__tapvpwrvgnd_1
XTAP_TAPCELL_ROW_55_1192 VSS VDD sky130_fd_sc_hd__tapvpwrvgnd_1
XTAP_TAPCELL_ROW_55_1193 VSS VDD sky130_fd_sc_hd__tapvpwrvgnd_1
XTAP_TAPCELL_ROW_55_1194 VSS VDD sky130_fd_sc_hd__tapvpwrvgnd_1
XTAP_TAPCELL_ROW_55_1195 VSS VDD sky130_fd_sc_hd__tapvpwrvgnd_1
XTAP_TAPCELL_ROW_55_1196 VSS VDD sky130_fd_sc_hd__tapvpwrvgnd_1
XTAP_TAPCELL_ROW_56_1197 VSS VDD sky130_fd_sc_hd__tapvpwrvgnd_1
XTAP_TAPCELL_ROW_56_1198 VSS VDD sky130_fd_sc_hd__tapvpwrvgnd_1
XTAP_TAPCELL_ROW_56_1199 VSS VDD sky130_fd_sc_hd__tapvpwrvgnd_1
XTAP_TAPCELL_ROW_56_1200 VSS VDD sky130_fd_sc_hd__tapvpwrvgnd_1
XTAP_TAPCELL_ROW_56_1201 VSS VDD sky130_fd_sc_hd__tapvpwrvgnd_1
XTAP_TAPCELL_ROW_56_1202 VSS VDD sky130_fd_sc_hd__tapvpwrvgnd_1
XTAP_TAPCELL_ROW_56_1203 VSS VDD sky130_fd_sc_hd__tapvpwrvgnd_1
XTAP_TAPCELL_ROW_56_1204 VSS VDD sky130_fd_sc_hd__tapvpwrvgnd_1
XTAP_TAPCELL_ROW_56_1205 VSS VDD sky130_fd_sc_hd__tapvpwrvgnd_1
XTAP_TAPCELL_ROW_56_1206 VSS VDD sky130_fd_sc_hd__tapvpwrvgnd_1
XTAP_TAPCELL_ROW_56_1207 VSS VDD sky130_fd_sc_hd__tapvpwrvgnd_1
XTAP_TAPCELL_ROW_56_1208 VSS VDD sky130_fd_sc_hd__tapvpwrvgnd_1
XTAP_TAPCELL_ROW_56_1209 VSS VDD sky130_fd_sc_hd__tapvpwrvgnd_1
XTAP_TAPCELL_ROW_56_1210 VSS VDD sky130_fd_sc_hd__tapvpwrvgnd_1
XTAP_TAPCELL_ROW_56_1211 VSS VDD sky130_fd_sc_hd__tapvpwrvgnd_1
XTAP_TAPCELL_ROW_56_1212 VSS VDD sky130_fd_sc_hd__tapvpwrvgnd_1
XTAP_TAPCELL_ROW_56_1213 VSS VDD sky130_fd_sc_hd__tapvpwrvgnd_1
XTAP_TAPCELL_ROW_56_1214 VSS VDD sky130_fd_sc_hd__tapvpwrvgnd_1
XTAP_TAPCELL_ROW_56_1215 VSS VDD sky130_fd_sc_hd__tapvpwrvgnd_1
XTAP_TAPCELL_ROW_56_1216 VSS VDD sky130_fd_sc_hd__tapvpwrvgnd_1
XTAP_TAPCELL_ROW_56_1217 VSS VDD sky130_fd_sc_hd__tapvpwrvgnd_1
XTAP_TAPCELL_ROW_57_1218 VSS VDD sky130_fd_sc_hd__tapvpwrvgnd_1
XTAP_TAPCELL_ROW_57_1219 VSS VDD sky130_fd_sc_hd__tapvpwrvgnd_1
XTAP_TAPCELL_ROW_57_1220 VSS VDD sky130_fd_sc_hd__tapvpwrvgnd_1
XTAP_TAPCELL_ROW_57_1221 VSS VDD sky130_fd_sc_hd__tapvpwrvgnd_1
XTAP_TAPCELL_ROW_57_1222 VSS VDD sky130_fd_sc_hd__tapvpwrvgnd_1
XTAP_TAPCELL_ROW_57_1223 VSS VDD sky130_fd_sc_hd__tapvpwrvgnd_1
XTAP_TAPCELL_ROW_57_1224 VSS VDD sky130_fd_sc_hd__tapvpwrvgnd_1
XTAP_TAPCELL_ROW_57_1225 VSS VDD sky130_fd_sc_hd__tapvpwrvgnd_1
XTAP_TAPCELL_ROW_57_1226 VSS VDD sky130_fd_sc_hd__tapvpwrvgnd_1
XTAP_TAPCELL_ROW_57_1227 VSS VDD sky130_fd_sc_hd__tapvpwrvgnd_1
XTAP_TAPCELL_ROW_57_1228 VSS VDD sky130_fd_sc_hd__tapvpwrvgnd_1
XTAP_TAPCELL_ROW_57_1229 VSS VDD sky130_fd_sc_hd__tapvpwrvgnd_1
XTAP_TAPCELL_ROW_57_1230 VSS VDD sky130_fd_sc_hd__tapvpwrvgnd_1
XTAP_TAPCELL_ROW_57_1231 VSS VDD sky130_fd_sc_hd__tapvpwrvgnd_1
XTAP_TAPCELL_ROW_57_1232 VSS VDD sky130_fd_sc_hd__tapvpwrvgnd_1
XTAP_TAPCELL_ROW_57_1233 VSS VDD sky130_fd_sc_hd__tapvpwrvgnd_1
XTAP_TAPCELL_ROW_57_1234 VSS VDD sky130_fd_sc_hd__tapvpwrvgnd_1
XTAP_TAPCELL_ROW_57_1235 VSS VDD sky130_fd_sc_hd__tapvpwrvgnd_1
XTAP_TAPCELL_ROW_57_1236 VSS VDD sky130_fd_sc_hd__tapvpwrvgnd_1
XTAP_TAPCELL_ROW_57_1237 VSS VDD sky130_fd_sc_hd__tapvpwrvgnd_1
XTAP_TAPCELL_ROW_57_1238 VSS VDD sky130_fd_sc_hd__tapvpwrvgnd_1
XTAP_TAPCELL_ROW_58_1239 VSS VDD sky130_fd_sc_hd__tapvpwrvgnd_1
XTAP_TAPCELL_ROW_58_1240 VSS VDD sky130_fd_sc_hd__tapvpwrvgnd_1
XTAP_TAPCELL_ROW_58_1241 VSS VDD sky130_fd_sc_hd__tapvpwrvgnd_1
XTAP_TAPCELL_ROW_58_1242 VSS VDD sky130_fd_sc_hd__tapvpwrvgnd_1
XTAP_TAPCELL_ROW_58_1243 VSS VDD sky130_fd_sc_hd__tapvpwrvgnd_1
XTAP_TAPCELL_ROW_58_1244 VSS VDD sky130_fd_sc_hd__tapvpwrvgnd_1
XTAP_TAPCELL_ROW_58_1245 VSS VDD sky130_fd_sc_hd__tapvpwrvgnd_1
XTAP_TAPCELL_ROW_58_1246 VSS VDD sky130_fd_sc_hd__tapvpwrvgnd_1
XTAP_TAPCELL_ROW_58_1247 VSS VDD sky130_fd_sc_hd__tapvpwrvgnd_1
XTAP_TAPCELL_ROW_58_1248 VSS VDD sky130_fd_sc_hd__tapvpwrvgnd_1
XTAP_TAPCELL_ROW_58_1249 VSS VDD sky130_fd_sc_hd__tapvpwrvgnd_1
XTAP_TAPCELL_ROW_58_1250 VSS VDD sky130_fd_sc_hd__tapvpwrvgnd_1
XTAP_TAPCELL_ROW_58_1251 VSS VDD sky130_fd_sc_hd__tapvpwrvgnd_1
XTAP_TAPCELL_ROW_58_1252 VSS VDD sky130_fd_sc_hd__tapvpwrvgnd_1
XTAP_TAPCELL_ROW_58_1253 VSS VDD sky130_fd_sc_hd__tapvpwrvgnd_1
XTAP_TAPCELL_ROW_58_1254 VSS VDD sky130_fd_sc_hd__tapvpwrvgnd_1
XTAP_TAPCELL_ROW_58_1255 VSS VDD sky130_fd_sc_hd__tapvpwrvgnd_1
XTAP_TAPCELL_ROW_58_1256 VSS VDD sky130_fd_sc_hd__tapvpwrvgnd_1
XTAP_TAPCELL_ROW_58_1257 VSS VDD sky130_fd_sc_hd__tapvpwrvgnd_1
XTAP_TAPCELL_ROW_58_1258 VSS VDD sky130_fd_sc_hd__tapvpwrvgnd_1
XTAP_TAPCELL_ROW_58_1259 VSS VDD sky130_fd_sc_hd__tapvpwrvgnd_1
XTAP_TAPCELL_ROW_59_1260 VSS VDD sky130_fd_sc_hd__tapvpwrvgnd_1
XTAP_TAPCELL_ROW_59_1261 VSS VDD sky130_fd_sc_hd__tapvpwrvgnd_1
XTAP_TAPCELL_ROW_59_1262 VSS VDD sky130_fd_sc_hd__tapvpwrvgnd_1
XTAP_TAPCELL_ROW_59_1263 VSS VDD sky130_fd_sc_hd__tapvpwrvgnd_1
XTAP_TAPCELL_ROW_59_1264 VSS VDD sky130_fd_sc_hd__tapvpwrvgnd_1
XTAP_TAPCELL_ROW_59_1265 VSS VDD sky130_fd_sc_hd__tapvpwrvgnd_1
XTAP_TAPCELL_ROW_59_1266 VSS VDD sky130_fd_sc_hd__tapvpwrvgnd_1
XTAP_TAPCELL_ROW_59_1267 VSS VDD sky130_fd_sc_hd__tapvpwrvgnd_1
XTAP_TAPCELL_ROW_59_1268 VSS VDD sky130_fd_sc_hd__tapvpwrvgnd_1
XTAP_TAPCELL_ROW_59_1269 VSS VDD sky130_fd_sc_hd__tapvpwrvgnd_1
XTAP_TAPCELL_ROW_59_1270 VSS VDD sky130_fd_sc_hd__tapvpwrvgnd_1
XTAP_TAPCELL_ROW_59_1271 VSS VDD sky130_fd_sc_hd__tapvpwrvgnd_1
XTAP_TAPCELL_ROW_59_1272 VSS VDD sky130_fd_sc_hd__tapvpwrvgnd_1
XTAP_TAPCELL_ROW_59_1273 VSS VDD sky130_fd_sc_hd__tapvpwrvgnd_1
XTAP_TAPCELL_ROW_59_1274 VSS VDD sky130_fd_sc_hd__tapvpwrvgnd_1
XTAP_TAPCELL_ROW_59_1275 VSS VDD sky130_fd_sc_hd__tapvpwrvgnd_1
XTAP_TAPCELL_ROW_59_1276 VSS VDD sky130_fd_sc_hd__tapvpwrvgnd_1
XTAP_TAPCELL_ROW_59_1277 VSS VDD sky130_fd_sc_hd__tapvpwrvgnd_1
XTAP_TAPCELL_ROW_59_1278 VSS VDD sky130_fd_sc_hd__tapvpwrvgnd_1
XTAP_TAPCELL_ROW_59_1279 VSS VDD sky130_fd_sc_hd__tapvpwrvgnd_1
XTAP_TAPCELL_ROW_59_1280 VSS VDD sky130_fd_sc_hd__tapvpwrvgnd_1
XTAP_TAPCELL_ROW_60_1281 VSS VDD sky130_fd_sc_hd__tapvpwrvgnd_1
XTAP_TAPCELL_ROW_60_1282 VSS VDD sky130_fd_sc_hd__tapvpwrvgnd_1
XTAP_TAPCELL_ROW_60_1283 VSS VDD sky130_fd_sc_hd__tapvpwrvgnd_1
XTAP_TAPCELL_ROW_60_1284 VSS VDD sky130_fd_sc_hd__tapvpwrvgnd_1
XTAP_TAPCELL_ROW_60_1285 VSS VDD sky130_fd_sc_hd__tapvpwrvgnd_1
XTAP_TAPCELL_ROW_60_1286 VSS VDD sky130_fd_sc_hd__tapvpwrvgnd_1
XTAP_TAPCELL_ROW_60_1287 VSS VDD sky130_fd_sc_hd__tapvpwrvgnd_1
XTAP_TAPCELL_ROW_60_1288 VSS VDD sky130_fd_sc_hd__tapvpwrvgnd_1
XTAP_TAPCELL_ROW_60_1289 VSS VDD sky130_fd_sc_hd__tapvpwrvgnd_1
XTAP_TAPCELL_ROW_60_1290 VSS VDD sky130_fd_sc_hd__tapvpwrvgnd_1
XTAP_TAPCELL_ROW_60_1291 VSS VDD sky130_fd_sc_hd__tapvpwrvgnd_1
XTAP_TAPCELL_ROW_60_1292 VSS VDD sky130_fd_sc_hd__tapvpwrvgnd_1
XTAP_TAPCELL_ROW_60_1293 VSS VDD sky130_fd_sc_hd__tapvpwrvgnd_1
XTAP_TAPCELL_ROW_60_1294 VSS VDD sky130_fd_sc_hd__tapvpwrvgnd_1
XTAP_TAPCELL_ROW_60_1295 VSS VDD sky130_fd_sc_hd__tapvpwrvgnd_1
XTAP_TAPCELL_ROW_60_1296 VSS VDD sky130_fd_sc_hd__tapvpwrvgnd_1
XTAP_TAPCELL_ROW_60_1297 VSS VDD sky130_fd_sc_hd__tapvpwrvgnd_1
XTAP_TAPCELL_ROW_60_1298 VSS VDD sky130_fd_sc_hd__tapvpwrvgnd_1
XTAP_TAPCELL_ROW_60_1299 VSS VDD sky130_fd_sc_hd__tapvpwrvgnd_1
XTAP_TAPCELL_ROW_60_1300 VSS VDD sky130_fd_sc_hd__tapvpwrvgnd_1
XTAP_TAPCELL_ROW_60_1301 VSS VDD sky130_fd_sc_hd__tapvpwrvgnd_1
XTAP_TAPCELL_ROW_61_1302 VSS VDD sky130_fd_sc_hd__tapvpwrvgnd_1
XTAP_TAPCELL_ROW_61_1303 VSS VDD sky130_fd_sc_hd__tapvpwrvgnd_1
XTAP_TAPCELL_ROW_61_1304 VSS VDD sky130_fd_sc_hd__tapvpwrvgnd_1
XTAP_TAPCELL_ROW_61_1305 VSS VDD sky130_fd_sc_hd__tapvpwrvgnd_1
XTAP_TAPCELL_ROW_61_1306 VSS VDD sky130_fd_sc_hd__tapvpwrvgnd_1
XTAP_TAPCELL_ROW_61_1307 VSS VDD sky130_fd_sc_hd__tapvpwrvgnd_1
XTAP_TAPCELL_ROW_61_1308 VSS VDD sky130_fd_sc_hd__tapvpwrvgnd_1
XTAP_TAPCELL_ROW_61_1309 VSS VDD sky130_fd_sc_hd__tapvpwrvgnd_1
XTAP_TAPCELL_ROW_61_1310 VSS VDD sky130_fd_sc_hd__tapvpwrvgnd_1
XTAP_TAPCELL_ROW_61_1311 VSS VDD sky130_fd_sc_hd__tapvpwrvgnd_1
XTAP_TAPCELL_ROW_61_1312 VSS VDD sky130_fd_sc_hd__tapvpwrvgnd_1
XTAP_TAPCELL_ROW_61_1313 VSS VDD sky130_fd_sc_hd__tapvpwrvgnd_1
XTAP_TAPCELL_ROW_61_1314 VSS VDD sky130_fd_sc_hd__tapvpwrvgnd_1
XTAP_TAPCELL_ROW_61_1315 VSS VDD sky130_fd_sc_hd__tapvpwrvgnd_1
XTAP_TAPCELL_ROW_61_1316 VSS VDD sky130_fd_sc_hd__tapvpwrvgnd_1
XTAP_TAPCELL_ROW_61_1317 VSS VDD sky130_fd_sc_hd__tapvpwrvgnd_1
XTAP_TAPCELL_ROW_61_1318 VSS VDD sky130_fd_sc_hd__tapvpwrvgnd_1
XTAP_TAPCELL_ROW_61_1319 VSS VDD sky130_fd_sc_hd__tapvpwrvgnd_1
XTAP_TAPCELL_ROW_61_1320 VSS VDD sky130_fd_sc_hd__tapvpwrvgnd_1
XTAP_TAPCELL_ROW_61_1321 VSS VDD sky130_fd_sc_hd__tapvpwrvgnd_1
XTAP_TAPCELL_ROW_61_1322 VSS VDD sky130_fd_sc_hd__tapvpwrvgnd_1
XTAP_TAPCELL_ROW_62_1323 VSS VDD sky130_fd_sc_hd__tapvpwrvgnd_1
XTAP_TAPCELL_ROW_62_1324 VSS VDD sky130_fd_sc_hd__tapvpwrvgnd_1
XTAP_TAPCELL_ROW_62_1325 VSS VDD sky130_fd_sc_hd__tapvpwrvgnd_1
XTAP_TAPCELL_ROW_62_1326 VSS VDD sky130_fd_sc_hd__tapvpwrvgnd_1
XTAP_TAPCELL_ROW_62_1327 VSS VDD sky130_fd_sc_hd__tapvpwrvgnd_1
XTAP_TAPCELL_ROW_62_1328 VSS VDD sky130_fd_sc_hd__tapvpwrvgnd_1
XTAP_TAPCELL_ROW_62_1329 VSS VDD sky130_fd_sc_hd__tapvpwrvgnd_1
XTAP_TAPCELL_ROW_62_1330 VSS VDD sky130_fd_sc_hd__tapvpwrvgnd_1
XTAP_TAPCELL_ROW_62_1331 VSS VDD sky130_fd_sc_hd__tapvpwrvgnd_1
XTAP_TAPCELL_ROW_62_1332 VSS VDD sky130_fd_sc_hd__tapvpwrvgnd_1
XTAP_TAPCELL_ROW_62_1333 VSS VDD sky130_fd_sc_hd__tapvpwrvgnd_1
XTAP_TAPCELL_ROW_62_1334 VSS VDD sky130_fd_sc_hd__tapvpwrvgnd_1
XTAP_TAPCELL_ROW_62_1335 VSS VDD sky130_fd_sc_hd__tapvpwrvgnd_1
XTAP_TAPCELL_ROW_62_1336 VSS VDD sky130_fd_sc_hd__tapvpwrvgnd_1
XTAP_TAPCELL_ROW_62_1337 VSS VDD sky130_fd_sc_hd__tapvpwrvgnd_1
XTAP_TAPCELL_ROW_62_1338 VSS VDD sky130_fd_sc_hd__tapvpwrvgnd_1
XTAP_TAPCELL_ROW_62_1339 VSS VDD sky130_fd_sc_hd__tapvpwrvgnd_1
XTAP_TAPCELL_ROW_62_1340 VSS VDD sky130_fd_sc_hd__tapvpwrvgnd_1
XTAP_TAPCELL_ROW_62_1341 VSS VDD sky130_fd_sc_hd__tapvpwrvgnd_1
XTAP_TAPCELL_ROW_62_1342 VSS VDD sky130_fd_sc_hd__tapvpwrvgnd_1
XTAP_TAPCELL_ROW_62_1343 VSS VDD sky130_fd_sc_hd__tapvpwrvgnd_1
XTAP_TAPCELL_ROW_63_1344 VSS VDD sky130_fd_sc_hd__tapvpwrvgnd_1
XTAP_TAPCELL_ROW_63_1345 VSS VDD sky130_fd_sc_hd__tapvpwrvgnd_1
XTAP_TAPCELL_ROW_63_1346 VSS VDD sky130_fd_sc_hd__tapvpwrvgnd_1
XTAP_TAPCELL_ROW_63_1347 VSS VDD sky130_fd_sc_hd__tapvpwrvgnd_1
XTAP_TAPCELL_ROW_63_1348 VSS VDD sky130_fd_sc_hd__tapvpwrvgnd_1
XTAP_TAPCELL_ROW_63_1349 VSS VDD sky130_fd_sc_hd__tapvpwrvgnd_1
XTAP_TAPCELL_ROW_63_1350 VSS VDD sky130_fd_sc_hd__tapvpwrvgnd_1
XTAP_TAPCELL_ROW_63_1351 VSS VDD sky130_fd_sc_hd__tapvpwrvgnd_1
XTAP_TAPCELL_ROW_63_1352 VSS VDD sky130_fd_sc_hd__tapvpwrvgnd_1
XTAP_TAPCELL_ROW_63_1353 VSS VDD sky130_fd_sc_hd__tapvpwrvgnd_1
XTAP_TAPCELL_ROW_63_1354 VSS VDD sky130_fd_sc_hd__tapvpwrvgnd_1
XTAP_TAPCELL_ROW_63_1355 VSS VDD sky130_fd_sc_hd__tapvpwrvgnd_1
XTAP_TAPCELL_ROW_63_1356 VSS VDD sky130_fd_sc_hd__tapvpwrvgnd_1
XTAP_TAPCELL_ROW_63_1357 VSS VDD sky130_fd_sc_hd__tapvpwrvgnd_1
XTAP_TAPCELL_ROW_63_1358 VSS VDD sky130_fd_sc_hd__tapvpwrvgnd_1
XTAP_TAPCELL_ROW_63_1359 VSS VDD sky130_fd_sc_hd__tapvpwrvgnd_1
XTAP_TAPCELL_ROW_63_1360 VSS VDD sky130_fd_sc_hd__tapvpwrvgnd_1
XTAP_TAPCELL_ROW_63_1361 VSS VDD sky130_fd_sc_hd__tapvpwrvgnd_1
XTAP_TAPCELL_ROW_63_1362 VSS VDD sky130_fd_sc_hd__tapvpwrvgnd_1
XTAP_TAPCELL_ROW_63_1363 VSS VDD sky130_fd_sc_hd__tapvpwrvgnd_1
XTAP_TAPCELL_ROW_63_1364 VSS VDD sky130_fd_sc_hd__tapvpwrvgnd_1
XTAP_TAPCELL_ROW_64_1365 VSS VDD sky130_fd_sc_hd__tapvpwrvgnd_1
XTAP_TAPCELL_ROW_64_1366 VSS VDD sky130_fd_sc_hd__tapvpwrvgnd_1
XTAP_TAPCELL_ROW_64_1367 VSS VDD sky130_fd_sc_hd__tapvpwrvgnd_1
XTAP_TAPCELL_ROW_64_1368 VSS VDD sky130_fd_sc_hd__tapvpwrvgnd_1
XTAP_TAPCELL_ROW_64_1369 VSS VDD sky130_fd_sc_hd__tapvpwrvgnd_1
XTAP_TAPCELL_ROW_64_1370 VSS VDD sky130_fd_sc_hd__tapvpwrvgnd_1
XTAP_TAPCELL_ROW_64_1371 VSS VDD sky130_fd_sc_hd__tapvpwrvgnd_1
XTAP_TAPCELL_ROW_64_1372 VSS VDD sky130_fd_sc_hd__tapvpwrvgnd_1
XTAP_TAPCELL_ROW_64_1373 VSS VDD sky130_fd_sc_hd__tapvpwrvgnd_1
XTAP_TAPCELL_ROW_64_1374 VSS VDD sky130_fd_sc_hd__tapvpwrvgnd_1
XTAP_TAPCELL_ROW_64_1375 VSS VDD sky130_fd_sc_hd__tapvpwrvgnd_1
XTAP_TAPCELL_ROW_64_1376 VSS VDD sky130_fd_sc_hd__tapvpwrvgnd_1
XTAP_TAPCELL_ROW_64_1377 VSS VDD sky130_fd_sc_hd__tapvpwrvgnd_1
XTAP_TAPCELL_ROW_64_1378 VSS VDD sky130_fd_sc_hd__tapvpwrvgnd_1
XTAP_TAPCELL_ROW_64_1379 VSS VDD sky130_fd_sc_hd__tapvpwrvgnd_1
XTAP_TAPCELL_ROW_64_1380 VSS VDD sky130_fd_sc_hd__tapvpwrvgnd_1
XTAP_TAPCELL_ROW_64_1381 VSS VDD sky130_fd_sc_hd__tapvpwrvgnd_1
XTAP_TAPCELL_ROW_64_1382 VSS VDD sky130_fd_sc_hd__tapvpwrvgnd_1
XTAP_TAPCELL_ROW_64_1383 VSS VDD sky130_fd_sc_hd__tapvpwrvgnd_1
XTAP_TAPCELL_ROW_64_1384 VSS VDD sky130_fd_sc_hd__tapvpwrvgnd_1
XTAP_TAPCELL_ROW_64_1385 VSS VDD sky130_fd_sc_hd__tapvpwrvgnd_1
XTAP_TAPCELL_ROW_65_1386 VSS VDD sky130_fd_sc_hd__tapvpwrvgnd_1
XTAP_TAPCELL_ROW_65_1387 VSS VDD sky130_fd_sc_hd__tapvpwrvgnd_1
XTAP_TAPCELL_ROW_65_1388 VSS VDD sky130_fd_sc_hd__tapvpwrvgnd_1
XTAP_TAPCELL_ROW_65_1389 VSS VDD sky130_fd_sc_hd__tapvpwrvgnd_1
XTAP_TAPCELL_ROW_65_1390 VSS VDD sky130_fd_sc_hd__tapvpwrvgnd_1
XTAP_TAPCELL_ROW_65_1391 VSS VDD sky130_fd_sc_hd__tapvpwrvgnd_1
XTAP_TAPCELL_ROW_65_1392 VSS VDD sky130_fd_sc_hd__tapvpwrvgnd_1
XTAP_TAPCELL_ROW_65_1393 VSS VDD sky130_fd_sc_hd__tapvpwrvgnd_1
XTAP_TAPCELL_ROW_65_1394 VSS VDD sky130_fd_sc_hd__tapvpwrvgnd_1
XTAP_TAPCELL_ROW_65_1395 VSS VDD sky130_fd_sc_hd__tapvpwrvgnd_1
XTAP_TAPCELL_ROW_65_1396 VSS VDD sky130_fd_sc_hd__tapvpwrvgnd_1
XTAP_TAPCELL_ROW_65_1397 VSS VDD sky130_fd_sc_hd__tapvpwrvgnd_1
XTAP_TAPCELL_ROW_65_1398 VSS VDD sky130_fd_sc_hd__tapvpwrvgnd_1
XTAP_TAPCELL_ROW_65_1399 VSS VDD sky130_fd_sc_hd__tapvpwrvgnd_1
XTAP_TAPCELL_ROW_65_1400 VSS VDD sky130_fd_sc_hd__tapvpwrvgnd_1
XTAP_TAPCELL_ROW_65_1401 VSS VDD sky130_fd_sc_hd__tapvpwrvgnd_1
XTAP_TAPCELL_ROW_65_1402 VSS VDD sky130_fd_sc_hd__tapvpwrvgnd_1
XTAP_TAPCELL_ROW_65_1403 VSS VDD sky130_fd_sc_hd__tapvpwrvgnd_1
XTAP_TAPCELL_ROW_65_1404 VSS VDD sky130_fd_sc_hd__tapvpwrvgnd_1
XTAP_TAPCELL_ROW_65_1405 VSS VDD sky130_fd_sc_hd__tapvpwrvgnd_1
XTAP_TAPCELL_ROW_65_1406 VSS VDD sky130_fd_sc_hd__tapvpwrvgnd_1
XTAP_TAPCELL_ROW_66_1407 VSS VDD sky130_fd_sc_hd__tapvpwrvgnd_1
XTAP_TAPCELL_ROW_66_1408 VSS VDD sky130_fd_sc_hd__tapvpwrvgnd_1
XTAP_TAPCELL_ROW_66_1409 VSS VDD sky130_fd_sc_hd__tapvpwrvgnd_1
XTAP_TAPCELL_ROW_66_1410 VSS VDD sky130_fd_sc_hd__tapvpwrvgnd_1
XTAP_TAPCELL_ROW_66_1411 VSS VDD sky130_fd_sc_hd__tapvpwrvgnd_1
XTAP_TAPCELL_ROW_66_1412 VSS VDD sky130_fd_sc_hd__tapvpwrvgnd_1
XTAP_TAPCELL_ROW_66_1413 VSS VDD sky130_fd_sc_hd__tapvpwrvgnd_1
XTAP_TAPCELL_ROW_66_1414 VSS VDD sky130_fd_sc_hd__tapvpwrvgnd_1
XTAP_TAPCELL_ROW_66_1415 VSS VDD sky130_fd_sc_hd__tapvpwrvgnd_1
XTAP_TAPCELL_ROW_66_1416 VSS VDD sky130_fd_sc_hd__tapvpwrvgnd_1
XTAP_TAPCELL_ROW_66_1417 VSS VDD sky130_fd_sc_hd__tapvpwrvgnd_1
XTAP_TAPCELL_ROW_66_1418 VSS VDD sky130_fd_sc_hd__tapvpwrvgnd_1
XTAP_TAPCELL_ROW_66_1419 VSS VDD sky130_fd_sc_hd__tapvpwrvgnd_1
XTAP_TAPCELL_ROW_66_1420 VSS VDD sky130_fd_sc_hd__tapvpwrvgnd_1
XTAP_TAPCELL_ROW_66_1421 VSS VDD sky130_fd_sc_hd__tapvpwrvgnd_1
XTAP_TAPCELL_ROW_66_1422 VSS VDD sky130_fd_sc_hd__tapvpwrvgnd_1
XTAP_TAPCELL_ROW_66_1423 VSS VDD sky130_fd_sc_hd__tapvpwrvgnd_1
XTAP_TAPCELL_ROW_66_1424 VSS VDD sky130_fd_sc_hd__tapvpwrvgnd_1
XTAP_TAPCELL_ROW_66_1425 VSS VDD sky130_fd_sc_hd__tapvpwrvgnd_1
XTAP_TAPCELL_ROW_66_1426 VSS VDD sky130_fd_sc_hd__tapvpwrvgnd_1
XTAP_TAPCELL_ROW_66_1427 VSS VDD sky130_fd_sc_hd__tapvpwrvgnd_1
XTAP_TAPCELL_ROW_67_1428 VSS VDD sky130_fd_sc_hd__tapvpwrvgnd_1
XTAP_TAPCELL_ROW_67_1429 VSS VDD sky130_fd_sc_hd__tapvpwrvgnd_1
XTAP_TAPCELL_ROW_67_1430 VSS VDD sky130_fd_sc_hd__tapvpwrvgnd_1
XTAP_TAPCELL_ROW_67_1431 VSS VDD sky130_fd_sc_hd__tapvpwrvgnd_1
XTAP_TAPCELL_ROW_67_1432 VSS VDD sky130_fd_sc_hd__tapvpwrvgnd_1
XTAP_TAPCELL_ROW_67_1433 VSS VDD sky130_fd_sc_hd__tapvpwrvgnd_1
XTAP_TAPCELL_ROW_67_1434 VSS VDD sky130_fd_sc_hd__tapvpwrvgnd_1
XTAP_TAPCELL_ROW_67_1435 VSS VDD sky130_fd_sc_hd__tapvpwrvgnd_1
XTAP_TAPCELL_ROW_67_1436 VSS VDD sky130_fd_sc_hd__tapvpwrvgnd_1
XTAP_TAPCELL_ROW_67_1437 VSS VDD sky130_fd_sc_hd__tapvpwrvgnd_1
XTAP_TAPCELL_ROW_67_1438 VSS VDD sky130_fd_sc_hd__tapvpwrvgnd_1
XTAP_TAPCELL_ROW_67_1439 VSS VDD sky130_fd_sc_hd__tapvpwrvgnd_1
XTAP_TAPCELL_ROW_67_1440 VSS VDD sky130_fd_sc_hd__tapvpwrvgnd_1
XTAP_TAPCELL_ROW_67_1441 VSS VDD sky130_fd_sc_hd__tapvpwrvgnd_1
XTAP_TAPCELL_ROW_67_1442 VSS VDD sky130_fd_sc_hd__tapvpwrvgnd_1
XTAP_TAPCELL_ROW_67_1443 VSS VDD sky130_fd_sc_hd__tapvpwrvgnd_1
XTAP_TAPCELL_ROW_67_1444 VSS VDD sky130_fd_sc_hd__tapvpwrvgnd_1
XTAP_TAPCELL_ROW_67_1445 VSS VDD sky130_fd_sc_hd__tapvpwrvgnd_1
XTAP_TAPCELL_ROW_67_1446 VSS VDD sky130_fd_sc_hd__tapvpwrvgnd_1
XTAP_TAPCELL_ROW_67_1447 VSS VDD sky130_fd_sc_hd__tapvpwrvgnd_1
XTAP_TAPCELL_ROW_67_1448 VSS VDD sky130_fd_sc_hd__tapvpwrvgnd_1
XTAP_TAPCELL_ROW_68_1449 VSS VDD sky130_fd_sc_hd__tapvpwrvgnd_1
XTAP_TAPCELL_ROW_68_1450 VSS VDD sky130_fd_sc_hd__tapvpwrvgnd_1
XTAP_TAPCELL_ROW_68_1451 VSS VDD sky130_fd_sc_hd__tapvpwrvgnd_1
XTAP_TAPCELL_ROW_68_1452 VSS VDD sky130_fd_sc_hd__tapvpwrvgnd_1
XTAP_TAPCELL_ROW_68_1453 VSS VDD sky130_fd_sc_hd__tapvpwrvgnd_1
XTAP_TAPCELL_ROW_68_1454 VSS VDD sky130_fd_sc_hd__tapvpwrvgnd_1
XTAP_TAPCELL_ROW_68_1455 VSS VDD sky130_fd_sc_hd__tapvpwrvgnd_1
XTAP_TAPCELL_ROW_68_1456 VSS VDD sky130_fd_sc_hd__tapvpwrvgnd_1
XTAP_TAPCELL_ROW_68_1457 VSS VDD sky130_fd_sc_hd__tapvpwrvgnd_1
XTAP_TAPCELL_ROW_68_1458 VSS VDD sky130_fd_sc_hd__tapvpwrvgnd_1
XTAP_TAPCELL_ROW_68_1459 VSS VDD sky130_fd_sc_hd__tapvpwrvgnd_1
XTAP_TAPCELL_ROW_68_1460 VSS VDD sky130_fd_sc_hd__tapvpwrvgnd_1
XTAP_TAPCELL_ROW_68_1461 VSS VDD sky130_fd_sc_hd__tapvpwrvgnd_1
XTAP_TAPCELL_ROW_68_1462 VSS VDD sky130_fd_sc_hd__tapvpwrvgnd_1
XTAP_TAPCELL_ROW_68_1463 VSS VDD sky130_fd_sc_hd__tapvpwrvgnd_1
XTAP_TAPCELL_ROW_68_1464 VSS VDD sky130_fd_sc_hd__tapvpwrvgnd_1
XTAP_TAPCELL_ROW_68_1465 VSS VDD sky130_fd_sc_hd__tapvpwrvgnd_1
XTAP_TAPCELL_ROW_68_1466 VSS VDD sky130_fd_sc_hd__tapvpwrvgnd_1
XTAP_TAPCELL_ROW_68_1467 VSS VDD sky130_fd_sc_hd__tapvpwrvgnd_1
XTAP_TAPCELL_ROW_68_1468 VSS VDD sky130_fd_sc_hd__tapvpwrvgnd_1
XTAP_TAPCELL_ROW_68_1469 VSS VDD sky130_fd_sc_hd__tapvpwrvgnd_1
XTAP_TAPCELL_ROW_69_1470 VSS VDD sky130_fd_sc_hd__tapvpwrvgnd_1
XTAP_TAPCELL_ROW_69_1471 VSS VDD sky130_fd_sc_hd__tapvpwrvgnd_1
XTAP_TAPCELL_ROW_69_1472 VSS VDD sky130_fd_sc_hd__tapvpwrvgnd_1
XTAP_TAPCELL_ROW_69_1473 VSS VDD sky130_fd_sc_hd__tapvpwrvgnd_1
XTAP_TAPCELL_ROW_69_1474 VSS VDD sky130_fd_sc_hd__tapvpwrvgnd_1
XTAP_TAPCELL_ROW_69_1475 VSS VDD sky130_fd_sc_hd__tapvpwrvgnd_1
XTAP_TAPCELL_ROW_69_1476 VSS VDD sky130_fd_sc_hd__tapvpwrvgnd_1
XTAP_TAPCELL_ROW_69_1477 VSS VDD sky130_fd_sc_hd__tapvpwrvgnd_1
XTAP_TAPCELL_ROW_69_1478 VSS VDD sky130_fd_sc_hd__tapvpwrvgnd_1
XTAP_TAPCELL_ROW_69_1479 VSS VDD sky130_fd_sc_hd__tapvpwrvgnd_1
XTAP_TAPCELL_ROW_69_1480 VSS VDD sky130_fd_sc_hd__tapvpwrvgnd_1
XTAP_TAPCELL_ROW_69_1481 VSS VDD sky130_fd_sc_hd__tapvpwrvgnd_1
XTAP_TAPCELL_ROW_69_1482 VSS VDD sky130_fd_sc_hd__tapvpwrvgnd_1
XTAP_TAPCELL_ROW_69_1483 VSS VDD sky130_fd_sc_hd__tapvpwrvgnd_1
XTAP_TAPCELL_ROW_69_1484 VSS VDD sky130_fd_sc_hd__tapvpwrvgnd_1
XTAP_TAPCELL_ROW_69_1485 VSS VDD sky130_fd_sc_hd__tapvpwrvgnd_1
XTAP_TAPCELL_ROW_69_1486 VSS VDD sky130_fd_sc_hd__tapvpwrvgnd_1
XTAP_TAPCELL_ROW_69_1487 VSS VDD sky130_fd_sc_hd__tapvpwrvgnd_1
XTAP_TAPCELL_ROW_69_1488 VSS VDD sky130_fd_sc_hd__tapvpwrvgnd_1
XTAP_TAPCELL_ROW_69_1489 VSS VDD sky130_fd_sc_hd__tapvpwrvgnd_1
XTAP_TAPCELL_ROW_69_1490 VSS VDD sky130_fd_sc_hd__tapvpwrvgnd_1
XTAP_TAPCELL_ROW_70_1491 VSS VDD sky130_fd_sc_hd__tapvpwrvgnd_1
XTAP_TAPCELL_ROW_70_1492 VSS VDD sky130_fd_sc_hd__tapvpwrvgnd_1
XTAP_TAPCELL_ROW_70_1493 VSS VDD sky130_fd_sc_hd__tapvpwrvgnd_1
XTAP_TAPCELL_ROW_70_1494 VSS VDD sky130_fd_sc_hd__tapvpwrvgnd_1
XTAP_TAPCELL_ROW_70_1495 VSS VDD sky130_fd_sc_hd__tapvpwrvgnd_1
XTAP_TAPCELL_ROW_70_1496 VSS VDD sky130_fd_sc_hd__tapvpwrvgnd_1
XTAP_TAPCELL_ROW_70_1497 VSS VDD sky130_fd_sc_hd__tapvpwrvgnd_1
XTAP_TAPCELL_ROW_70_1498 VSS VDD sky130_fd_sc_hd__tapvpwrvgnd_1
XTAP_TAPCELL_ROW_70_1499 VSS VDD sky130_fd_sc_hd__tapvpwrvgnd_1
XTAP_TAPCELL_ROW_70_1500 VSS VDD sky130_fd_sc_hd__tapvpwrvgnd_1
XTAP_TAPCELL_ROW_70_1501 VSS VDD sky130_fd_sc_hd__tapvpwrvgnd_1
XTAP_TAPCELL_ROW_70_1502 VSS VDD sky130_fd_sc_hd__tapvpwrvgnd_1
XTAP_TAPCELL_ROW_70_1503 VSS VDD sky130_fd_sc_hd__tapvpwrvgnd_1
XTAP_TAPCELL_ROW_70_1504 VSS VDD sky130_fd_sc_hd__tapvpwrvgnd_1
XTAP_TAPCELL_ROW_70_1505 VSS VDD sky130_fd_sc_hd__tapvpwrvgnd_1
XTAP_TAPCELL_ROW_70_1506 VSS VDD sky130_fd_sc_hd__tapvpwrvgnd_1
XTAP_TAPCELL_ROW_70_1507 VSS VDD sky130_fd_sc_hd__tapvpwrvgnd_1
XTAP_TAPCELL_ROW_70_1508 VSS VDD sky130_fd_sc_hd__tapvpwrvgnd_1
XTAP_TAPCELL_ROW_70_1509 VSS VDD sky130_fd_sc_hd__tapvpwrvgnd_1
XTAP_TAPCELL_ROW_70_1510 VSS VDD sky130_fd_sc_hd__tapvpwrvgnd_1
XTAP_TAPCELL_ROW_70_1511 VSS VDD sky130_fd_sc_hd__tapvpwrvgnd_1
XTAP_TAPCELL_ROW_71_1512 VSS VDD sky130_fd_sc_hd__tapvpwrvgnd_1
XTAP_TAPCELL_ROW_71_1513 VSS VDD sky130_fd_sc_hd__tapvpwrvgnd_1
XTAP_TAPCELL_ROW_71_1514 VSS VDD sky130_fd_sc_hd__tapvpwrvgnd_1
XTAP_TAPCELL_ROW_71_1515 VSS VDD sky130_fd_sc_hd__tapvpwrvgnd_1
XTAP_TAPCELL_ROW_71_1516 VSS VDD sky130_fd_sc_hd__tapvpwrvgnd_1
XTAP_TAPCELL_ROW_71_1517 VSS VDD sky130_fd_sc_hd__tapvpwrvgnd_1
XTAP_TAPCELL_ROW_71_1518 VSS VDD sky130_fd_sc_hd__tapvpwrvgnd_1
XTAP_TAPCELL_ROW_71_1519 VSS VDD sky130_fd_sc_hd__tapvpwrvgnd_1
XTAP_TAPCELL_ROW_71_1520 VSS VDD sky130_fd_sc_hd__tapvpwrvgnd_1
XTAP_TAPCELL_ROW_71_1521 VSS VDD sky130_fd_sc_hd__tapvpwrvgnd_1
XTAP_TAPCELL_ROW_71_1522 VSS VDD sky130_fd_sc_hd__tapvpwrvgnd_1
XTAP_TAPCELL_ROW_71_1523 VSS VDD sky130_fd_sc_hd__tapvpwrvgnd_1
XTAP_TAPCELL_ROW_71_1524 VSS VDD sky130_fd_sc_hd__tapvpwrvgnd_1
XTAP_TAPCELL_ROW_71_1525 VSS VDD sky130_fd_sc_hd__tapvpwrvgnd_1
XTAP_TAPCELL_ROW_71_1526 VSS VDD sky130_fd_sc_hd__tapvpwrvgnd_1
XTAP_TAPCELL_ROW_71_1527 VSS VDD sky130_fd_sc_hd__tapvpwrvgnd_1
XTAP_TAPCELL_ROW_71_1528 VSS VDD sky130_fd_sc_hd__tapvpwrvgnd_1
XTAP_TAPCELL_ROW_71_1529 VSS VDD sky130_fd_sc_hd__tapvpwrvgnd_1
XTAP_TAPCELL_ROW_71_1530 VSS VDD sky130_fd_sc_hd__tapvpwrvgnd_1
XTAP_TAPCELL_ROW_71_1531 VSS VDD sky130_fd_sc_hd__tapvpwrvgnd_1
XTAP_TAPCELL_ROW_71_1532 VSS VDD sky130_fd_sc_hd__tapvpwrvgnd_1
XTAP_TAPCELL_ROW_72_1533 VSS VDD sky130_fd_sc_hd__tapvpwrvgnd_1
XTAP_TAPCELL_ROW_72_1534 VSS VDD sky130_fd_sc_hd__tapvpwrvgnd_1
XTAP_TAPCELL_ROW_72_1535 VSS VDD sky130_fd_sc_hd__tapvpwrvgnd_1
XTAP_TAPCELL_ROW_72_1536 VSS VDD sky130_fd_sc_hd__tapvpwrvgnd_1
XTAP_TAPCELL_ROW_72_1537 VSS VDD sky130_fd_sc_hd__tapvpwrvgnd_1
XTAP_TAPCELL_ROW_72_1538 VSS VDD sky130_fd_sc_hd__tapvpwrvgnd_1
XTAP_TAPCELL_ROW_72_1539 VSS VDD sky130_fd_sc_hd__tapvpwrvgnd_1
XTAP_TAPCELL_ROW_72_1540 VSS VDD sky130_fd_sc_hd__tapvpwrvgnd_1
XTAP_TAPCELL_ROW_72_1541 VSS VDD sky130_fd_sc_hd__tapvpwrvgnd_1
XTAP_TAPCELL_ROW_72_1542 VSS VDD sky130_fd_sc_hd__tapvpwrvgnd_1
XTAP_TAPCELL_ROW_72_1543 VSS VDD sky130_fd_sc_hd__tapvpwrvgnd_1
XTAP_TAPCELL_ROW_72_1544 VSS VDD sky130_fd_sc_hd__tapvpwrvgnd_1
XTAP_TAPCELL_ROW_72_1545 VSS VDD sky130_fd_sc_hd__tapvpwrvgnd_1
XTAP_TAPCELL_ROW_72_1546 VSS VDD sky130_fd_sc_hd__tapvpwrvgnd_1
XTAP_TAPCELL_ROW_72_1547 VSS VDD sky130_fd_sc_hd__tapvpwrvgnd_1
XTAP_TAPCELL_ROW_72_1548 VSS VDD sky130_fd_sc_hd__tapvpwrvgnd_1
XTAP_TAPCELL_ROW_72_1549 VSS VDD sky130_fd_sc_hd__tapvpwrvgnd_1
XTAP_TAPCELL_ROW_72_1550 VSS VDD sky130_fd_sc_hd__tapvpwrvgnd_1
XTAP_TAPCELL_ROW_72_1551 VSS VDD sky130_fd_sc_hd__tapvpwrvgnd_1
XTAP_TAPCELL_ROW_72_1552 VSS VDD sky130_fd_sc_hd__tapvpwrvgnd_1
XTAP_TAPCELL_ROW_72_1553 VSS VDD sky130_fd_sc_hd__tapvpwrvgnd_1
XTAP_TAPCELL_ROW_73_1554 VSS VDD sky130_fd_sc_hd__tapvpwrvgnd_1
XTAP_TAPCELL_ROW_73_1555 VSS VDD sky130_fd_sc_hd__tapvpwrvgnd_1
XTAP_TAPCELL_ROW_73_1556 VSS VDD sky130_fd_sc_hd__tapvpwrvgnd_1
XTAP_TAPCELL_ROW_73_1557 VSS VDD sky130_fd_sc_hd__tapvpwrvgnd_1
XTAP_TAPCELL_ROW_73_1558 VSS VDD sky130_fd_sc_hd__tapvpwrvgnd_1
XTAP_TAPCELL_ROW_73_1559 VSS VDD sky130_fd_sc_hd__tapvpwrvgnd_1
XTAP_TAPCELL_ROW_73_1560 VSS VDD sky130_fd_sc_hd__tapvpwrvgnd_1
XTAP_TAPCELL_ROW_73_1561 VSS VDD sky130_fd_sc_hd__tapvpwrvgnd_1
XTAP_TAPCELL_ROW_73_1562 VSS VDD sky130_fd_sc_hd__tapvpwrvgnd_1
XTAP_TAPCELL_ROW_73_1563 VSS VDD sky130_fd_sc_hd__tapvpwrvgnd_1
XTAP_TAPCELL_ROW_73_1564 VSS VDD sky130_fd_sc_hd__tapvpwrvgnd_1
XTAP_TAPCELL_ROW_73_1565 VSS VDD sky130_fd_sc_hd__tapvpwrvgnd_1
XTAP_TAPCELL_ROW_73_1566 VSS VDD sky130_fd_sc_hd__tapvpwrvgnd_1
XTAP_TAPCELL_ROW_73_1567 VSS VDD sky130_fd_sc_hd__tapvpwrvgnd_1
XTAP_TAPCELL_ROW_73_1568 VSS VDD sky130_fd_sc_hd__tapvpwrvgnd_1
XTAP_TAPCELL_ROW_73_1569 VSS VDD sky130_fd_sc_hd__tapvpwrvgnd_1
XTAP_TAPCELL_ROW_73_1570 VSS VDD sky130_fd_sc_hd__tapvpwrvgnd_1
XTAP_TAPCELL_ROW_73_1571 VSS VDD sky130_fd_sc_hd__tapvpwrvgnd_1
XTAP_TAPCELL_ROW_73_1572 VSS VDD sky130_fd_sc_hd__tapvpwrvgnd_1
XTAP_TAPCELL_ROW_73_1573 VSS VDD sky130_fd_sc_hd__tapvpwrvgnd_1
XTAP_TAPCELL_ROW_73_1574 VSS VDD sky130_fd_sc_hd__tapvpwrvgnd_1
XTAP_TAPCELL_ROW_74_1575 VSS VDD sky130_fd_sc_hd__tapvpwrvgnd_1
XTAP_TAPCELL_ROW_74_1576 VSS VDD sky130_fd_sc_hd__tapvpwrvgnd_1
XTAP_TAPCELL_ROW_74_1577 VSS VDD sky130_fd_sc_hd__tapvpwrvgnd_1
XTAP_TAPCELL_ROW_74_1578 VSS VDD sky130_fd_sc_hd__tapvpwrvgnd_1
XTAP_TAPCELL_ROW_74_1579 VSS VDD sky130_fd_sc_hd__tapvpwrvgnd_1
XTAP_TAPCELL_ROW_74_1580 VSS VDD sky130_fd_sc_hd__tapvpwrvgnd_1
XTAP_TAPCELL_ROW_74_1581 VSS VDD sky130_fd_sc_hd__tapvpwrvgnd_1
XTAP_TAPCELL_ROW_74_1582 VSS VDD sky130_fd_sc_hd__tapvpwrvgnd_1
XTAP_TAPCELL_ROW_74_1583 VSS VDD sky130_fd_sc_hd__tapvpwrvgnd_1
XTAP_TAPCELL_ROW_74_1584 VSS VDD sky130_fd_sc_hd__tapvpwrvgnd_1
XTAP_TAPCELL_ROW_74_1585 VSS VDD sky130_fd_sc_hd__tapvpwrvgnd_1
XTAP_TAPCELL_ROW_74_1586 VSS VDD sky130_fd_sc_hd__tapvpwrvgnd_1
XTAP_TAPCELL_ROW_74_1587 VSS VDD sky130_fd_sc_hd__tapvpwrvgnd_1
XTAP_TAPCELL_ROW_74_1588 VSS VDD sky130_fd_sc_hd__tapvpwrvgnd_1
XTAP_TAPCELL_ROW_74_1589 VSS VDD sky130_fd_sc_hd__tapvpwrvgnd_1
XTAP_TAPCELL_ROW_74_1590 VSS VDD sky130_fd_sc_hd__tapvpwrvgnd_1
XTAP_TAPCELL_ROW_74_1591 VSS VDD sky130_fd_sc_hd__tapvpwrvgnd_1
XTAP_TAPCELL_ROW_74_1592 VSS VDD sky130_fd_sc_hd__tapvpwrvgnd_1
XTAP_TAPCELL_ROW_74_1593 VSS VDD sky130_fd_sc_hd__tapvpwrvgnd_1
XTAP_TAPCELL_ROW_74_1594 VSS VDD sky130_fd_sc_hd__tapvpwrvgnd_1
XTAP_TAPCELL_ROW_74_1595 VSS VDD sky130_fd_sc_hd__tapvpwrvgnd_1
XTAP_TAPCELL_ROW_75_1596 VSS VDD sky130_fd_sc_hd__tapvpwrvgnd_1
XTAP_TAPCELL_ROW_75_1597 VSS VDD sky130_fd_sc_hd__tapvpwrvgnd_1
XTAP_TAPCELL_ROW_75_1598 VSS VDD sky130_fd_sc_hd__tapvpwrvgnd_1
XTAP_TAPCELL_ROW_75_1599 VSS VDD sky130_fd_sc_hd__tapvpwrvgnd_1
XTAP_TAPCELL_ROW_75_1600 VSS VDD sky130_fd_sc_hd__tapvpwrvgnd_1
XTAP_TAPCELL_ROW_75_1601 VSS VDD sky130_fd_sc_hd__tapvpwrvgnd_1
XTAP_TAPCELL_ROW_75_1602 VSS VDD sky130_fd_sc_hd__tapvpwrvgnd_1
XTAP_TAPCELL_ROW_75_1603 VSS VDD sky130_fd_sc_hd__tapvpwrvgnd_1
XTAP_TAPCELL_ROW_75_1604 VSS VDD sky130_fd_sc_hd__tapvpwrvgnd_1
XTAP_TAPCELL_ROW_75_1605 VSS VDD sky130_fd_sc_hd__tapvpwrvgnd_1
XTAP_TAPCELL_ROW_75_1606 VSS VDD sky130_fd_sc_hd__tapvpwrvgnd_1
XTAP_TAPCELL_ROW_75_1607 VSS VDD sky130_fd_sc_hd__tapvpwrvgnd_1
XTAP_TAPCELL_ROW_75_1608 VSS VDD sky130_fd_sc_hd__tapvpwrvgnd_1
XTAP_TAPCELL_ROW_75_1609 VSS VDD sky130_fd_sc_hd__tapvpwrvgnd_1
XTAP_TAPCELL_ROW_75_1610 VSS VDD sky130_fd_sc_hd__tapvpwrvgnd_1
XTAP_TAPCELL_ROW_75_1611 VSS VDD sky130_fd_sc_hd__tapvpwrvgnd_1
XTAP_TAPCELL_ROW_75_1612 VSS VDD sky130_fd_sc_hd__tapvpwrvgnd_1
XTAP_TAPCELL_ROW_75_1613 VSS VDD sky130_fd_sc_hd__tapvpwrvgnd_1
XTAP_TAPCELL_ROW_75_1614 VSS VDD sky130_fd_sc_hd__tapvpwrvgnd_1
XTAP_TAPCELL_ROW_75_1615 VSS VDD sky130_fd_sc_hd__tapvpwrvgnd_1
XTAP_TAPCELL_ROW_75_1616 VSS VDD sky130_fd_sc_hd__tapvpwrvgnd_1
XTAP_TAPCELL_ROW_76_1617 VSS VDD sky130_fd_sc_hd__tapvpwrvgnd_1
XTAP_TAPCELL_ROW_76_1618 VSS VDD sky130_fd_sc_hd__tapvpwrvgnd_1
XTAP_TAPCELL_ROW_76_1619 VSS VDD sky130_fd_sc_hd__tapvpwrvgnd_1
XTAP_TAPCELL_ROW_76_1620 VSS VDD sky130_fd_sc_hd__tapvpwrvgnd_1
XTAP_TAPCELL_ROW_76_1621 VSS VDD sky130_fd_sc_hd__tapvpwrvgnd_1
XTAP_TAPCELL_ROW_76_1622 VSS VDD sky130_fd_sc_hd__tapvpwrvgnd_1
XTAP_TAPCELL_ROW_76_1623 VSS VDD sky130_fd_sc_hd__tapvpwrvgnd_1
XTAP_TAPCELL_ROW_76_1624 VSS VDD sky130_fd_sc_hd__tapvpwrvgnd_1
XTAP_TAPCELL_ROW_76_1625 VSS VDD sky130_fd_sc_hd__tapvpwrvgnd_1
XTAP_TAPCELL_ROW_76_1626 VSS VDD sky130_fd_sc_hd__tapvpwrvgnd_1
XTAP_TAPCELL_ROW_76_1627 VSS VDD sky130_fd_sc_hd__tapvpwrvgnd_1
XTAP_TAPCELL_ROW_76_1628 VSS VDD sky130_fd_sc_hd__tapvpwrvgnd_1
XTAP_TAPCELL_ROW_76_1629 VSS VDD sky130_fd_sc_hd__tapvpwrvgnd_1
XTAP_TAPCELL_ROW_76_1630 VSS VDD sky130_fd_sc_hd__tapvpwrvgnd_1
XTAP_TAPCELL_ROW_76_1631 VSS VDD sky130_fd_sc_hd__tapvpwrvgnd_1
XTAP_TAPCELL_ROW_76_1632 VSS VDD sky130_fd_sc_hd__tapvpwrvgnd_1
XTAP_TAPCELL_ROW_76_1633 VSS VDD sky130_fd_sc_hd__tapvpwrvgnd_1
XTAP_TAPCELL_ROW_76_1634 VSS VDD sky130_fd_sc_hd__tapvpwrvgnd_1
XTAP_TAPCELL_ROW_76_1635 VSS VDD sky130_fd_sc_hd__tapvpwrvgnd_1
XTAP_TAPCELL_ROW_76_1636 VSS VDD sky130_fd_sc_hd__tapvpwrvgnd_1
XTAP_TAPCELL_ROW_76_1637 VSS VDD sky130_fd_sc_hd__tapvpwrvgnd_1
XTAP_TAPCELL_ROW_77_1638 VSS VDD sky130_fd_sc_hd__tapvpwrvgnd_1
XTAP_TAPCELL_ROW_77_1639 VSS VDD sky130_fd_sc_hd__tapvpwrvgnd_1
XTAP_TAPCELL_ROW_77_1640 VSS VDD sky130_fd_sc_hd__tapvpwrvgnd_1
XTAP_TAPCELL_ROW_77_1641 VSS VDD sky130_fd_sc_hd__tapvpwrvgnd_1
XTAP_TAPCELL_ROW_77_1642 VSS VDD sky130_fd_sc_hd__tapvpwrvgnd_1
XTAP_TAPCELL_ROW_77_1643 VSS VDD sky130_fd_sc_hd__tapvpwrvgnd_1
XTAP_TAPCELL_ROW_77_1644 VSS VDD sky130_fd_sc_hd__tapvpwrvgnd_1
XTAP_TAPCELL_ROW_77_1645 VSS VDD sky130_fd_sc_hd__tapvpwrvgnd_1
XTAP_TAPCELL_ROW_77_1646 VSS VDD sky130_fd_sc_hd__tapvpwrvgnd_1
XTAP_TAPCELL_ROW_77_1647 VSS VDD sky130_fd_sc_hd__tapvpwrvgnd_1
XTAP_TAPCELL_ROW_77_1648 VSS VDD sky130_fd_sc_hd__tapvpwrvgnd_1
XTAP_TAPCELL_ROW_77_1649 VSS VDD sky130_fd_sc_hd__tapvpwrvgnd_1
XTAP_TAPCELL_ROW_77_1650 VSS VDD sky130_fd_sc_hd__tapvpwrvgnd_1
XTAP_TAPCELL_ROW_77_1651 VSS VDD sky130_fd_sc_hd__tapvpwrvgnd_1
XTAP_TAPCELL_ROW_77_1652 VSS VDD sky130_fd_sc_hd__tapvpwrvgnd_1
XTAP_TAPCELL_ROW_77_1653 VSS VDD sky130_fd_sc_hd__tapvpwrvgnd_1
XTAP_TAPCELL_ROW_77_1654 VSS VDD sky130_fd_sc_hd__tapvpwrvgnd_1
XTAP_TAPCELL_ROW_77_1655 VSS VDD sky130_fd_sc_hd__tapvpwrvgnd_1
XTAP_TAPCELL_ROW_77_1656 VSS VDD sky130_fd_sc_hd__tapvpwrvgnd_1
XTAP_TAPCELL_ROW_77_1657 VSS VDD sky130_fd_sc_hd__tapvpwrvgnd_1
XTAP_TAPCELL_ROW_77_1658 VSS VDD sky130_fd_sc_hd__tapvpwrvgnd_1
XTAP_TAPCELL_ROW_78_1659 VSS VDD sky130_fd_sc_hd__tapvpwrvgnd_1
XTAP_TAPCELL_ROW_78_1660 VSS VDD sky130_fd_sc_hd__tapvpwrvgnd_1
XTAP_TAPCELL_ROW_78_1661 VSS VDD sky130_fd_sc_hd__tapvpwrvgnd_1
XTAP_TAPCELL_ROW_78_1662 VSS VDD sky130_fd_sc_hd__tapvpwrvgnd_1
XTAP_TAPCELL_ROW_78_1663 VSS VDD sky130_fd_sc_hd__tapvpwrvgnd_1
XTAP_TAPCELL_ROW_78_1664 VSS VDD sky130_fd_sc_hd__tapvpwrvgnd_1
XTAP_TAPCELL_ROW_78_1665 VSS VDD sky130_fd_sc_hd__tapvpwrvgnd_1
XTAP_TAPCELL_ROW_78_1666 VSS VDD sky130_fd_sc_hd__tapvpwrvgnd_1
XTAP_TAPCELL_ROW_78_1667 VSS VDD sky130_fd_sc_hd__tapvpwrvgnd_1
XTAP_TAPCELL_ROW_78_1668 VSS VDD sky130_fd_sc_hd__tapvpwrvgnd_1
XTAP_TAPCELL_ROW_78_1669 VSS VDD sky130_fd_sc_hd__tapvpwrvgnd_1
XTAP_TAPCELL_ROW_78_1670 VSS VDD sky130_fd_sc_hd__tapvpwrvgnd_1
XTAP_TAPCELL_ROW_78_1671 VSS VDD sky130_fd_sc_hd__tapvpwrvgnd_1
XTAP_TAPCELL_ROW_78_1672 VSS VDD sky130_fd_sc_hd__tapvpwrvgnd_1
XTAP_TAPCELL_ROW_78_1673 VSS VDD sky130_fd_sc_hd__tapvpwrvgnd_1
XTAP_TAPCELL_ROW_78_1674 VSS VDD sky130_fd_sc_hd__tapvpwrvgnd_1
XTAP_TAPCELL_ROW_78_1675 VSS VDD sky130_fd_sc_hd__tapvpwrvgnd_1
XTAP_TAPCELL_ROW_78_1676 VSS VDD sky130_fd_sc_hd__tapvpwrvgnd_1
XTAP_TAPCELL_ROW_78_1677 VSS VDD sky130_fd_sc_hd__tapvpwrvgnd_1
XTAP_TAPCELL_ROW_78_1678 VSS VDD sky130_fd_sc_hd__tapvpwrvgnd_1
XTAP_TAPCELL_ROW_78_1679 VSS VDD sky130_fd_sc_hd__tapvpwrvgnd_1
XTAP_TAPCELL_ROW_79_1680 VSS VDD sky130_fd_sc_hd__tapvpwrvgnd_1
XTAP_TAPCELL_ROW_79_1681 VSS VDD sky130_fd_sc_hd__tapvpwrvgnd_1
XTAP_TAPCELL_ROW_79_1682 VSS VDD sky130_fd_sc_hd__tapvpwrvgnd_1
XTAP_TAPCELL_ROW_79_1683 VSS VDD sky130_fd_sc_hd__tapvpwrvgnd_1
XTAP_TAPCELL_ROW_79_1684 VSS VDD sky130_fd_sc_hd__tapvpwrvgnd_1
XTAP_TAPCELL_ROW_79_1685 VSS VDD sky130_fd_sc_hd__tapvpwrvgnd_1
XTAP_TAPCELL_ROW_79_1686 VSS VDD sky130_fd_sc_hd__tapvpwrvgnd_1
XTAP_TAPCELL_ROW_79_1687 VSS VDD sky130_fd_sc_hd__tapvpwrvgnd_1
XTAP_TAPCELL_ROW_79_1688 VSS VDD sky130_fd_sc_hd__tapvpwrvgnd_1
XTAP_TAPCELL_ROW_79_1689 VSS VDD sky130_fd_sc_hd__tapvpwrvgnd_1
XTAP_TAPCELL_ROW_79_1690 VSS VDD sky130_fd_sc_hd__tapvpwrvgnd_1
XTAP_TAPCELL_ROW_79_1691 VSS VDD sky130_fd_sc_hd__tapvpwrvgnd_1
XTAP_TAPCELL_ROW_79_1692 VSS VDD sky130_fd_sc_hd__tapvpwrvgnd_1
XTAP_TAPCELL_ROW_79_1693 VSS VDD sky130_fd_sc_hd__tapvpwrvgnd_1
XTAP_TAPCELL_ROW_79_1694 VSS VDD sky130_fd_sc_hd__tapvpwrvgnd_1
XTAP_TAPCELL_ROW_79_1695 VSS VDD sky130_fd_sc_hd__tapvpwrvgnd_1
XTAP_TAPCELL_ROW_79_1696 VSS VDD sky130_fd_sc_hd__tapvpwrvgnd_1
XTAP_TAPCELL_ROW_79_1697 VSS VDD sky130_fd_sc_hd__tapvpwrvgnd_1
XTAP_TAPCELL_ROW_79_1698 VSS VDD sky130_fd_sc_hd__tapvpwrvgnd_1
XTAP_TAPCELL_ROW_79_1699 VSS VDD sky130_fd_sc_hd__tapvpwrvgnd_1
XTAP_TAPCELL_ROW_79_1700 VSS VDD sky130_fd_sc_hd__tapvpwrvgnd_1
XTAP_TAPCELL_ROW_80_1701 VSS VDD sky130_fd_sc_hd__tapvpwrvgnd_1
XTAP_TAPCELL_ROW_80_1702 VSS VDD sky130_fd_sc_hd__tapvpwrvgnd_1
XTAP_TAPCELL_ROW_80_1703 VSS VDD sky130_fd_sc_hd__tapvpwrvgnd_1
XTAP_TAPCELL_ROW_80_1704 VSS VDD sky130_fd_sc_hd__tapvpwrvgnd_1
XTAP_TAPCELL_ROW_80_1705 VSS VDD sky130_fd_sc_hd__tapvpwrvgnd_1
XTAP_TAPCELL_ROW_80_1706 VSS VDD sky130_fd_sc_hd__tapvpwrvgnd_1
XTAP_TAPCELL_ROW_80_1707 VSS VDD sky130_fd_sc_hd__tapvpwrvgnd_1
XTAP_TAPCELL_ROW_80_1708 VSS VDD sky130_fd_sc_hd__tapvpwrvgnd_1
XTAP_TAPCELL_ROW_80_1709 VSS VDD sky130_fd_sc_hd__tapvpwrvgnd_1
XTAP_TAPCELL_ROW_80_1710 VSS VDD sky130_fd_sc_hd__tapvpwrvgnd_1
XTAP_TAPCELL_ROW_80_1711 VSS VDD sky130_fd_sc_hd__tapvpwrvgnd_1
XTAP_TAPCELL_ROW_80_1712 VSS VDD sky130_fd_sc_hd__tapvpwrvgnd_1
XTAP_TAPCELL_ROW_80_1713 VSS VDD sky130_fd_sc_hd__tapvpwrvgnd_1
XTAP_TAPCELL_ROW_80_1714 VSS VDD sky130_fd_sc_hd__tapvpwrvgnd_1
XTAP_TAPCELL_ROW_80_1715 VSS VDD sky130_fd_sc_hd__tapvpwrvgnd_1
XTAP_TAPCELL_ROW_80_1716 VSS VDD sky130_fd_sc_hd__tapvpwrvgnd_1
XTAP_TAPCELL_ROW_80_1717 VSS VDD sky130_fd_sc_hd__tapvpwrvgnd_1
XTAP_TAPCELL_ROW_80_1718 VSS VDD sky130_fd_sc_hd__tapvpwrvgnd_1
XTAP_TAPCELL_ROW_80_1719 VSS VDD sky130_fd_sc_hd__tapvpwrvgnd_1
XTAP_TAPCELL_ROW_80_1720 VSS VDD sky130_fd_sc_hd__tapvpwrvgnd_1
XTAP_TAPCELL_ROW_80_1721 VSS VDD sky130_fd_sc_hd__tapvpwrvgnd_1
XTAP_TAPCELL_ROW_81_1722 VSS VDD sky130_fd_sc_hd__tapvpwrvgnd_1
XTAP_TAPCELL_ROW_81_1723 VSS VDD sky130_fd_sc_hd__tapvpwrvgnd_1
XTAP_TAPCELL_ROW_81_1724 VSS VDD sky130_fd_sc_hd__tapvpwrvgnd_1
XTAP_TAPCELL_ROW_81_1725 VSS VDD sky130_fd_sc_hd__tapvpwrvgnd_1
XTAP_TAPCELL_ROW_81_1726 VSS VDD sky130_fd_sc_hd__tapvpwrvgnd_1
XTAP_TAPCELL_ROW_81_1727 VSS VDD sky130_fd_sc_hd__tapvpwrvgnd_1
XTAP_TAPCELL_ROW_81_1728 VSS VDD sky130_fd_sc_hd__tapvpwrvgnd_1
XTAP_TAPCELL_ROW_81_1729 VSS VDD sky130_fd_sc_hd__tapvpwrvgnd_1
XTAP_TAPCELL_ROW_81_1730 VSS VDD sky130_fd_sc_hd__tapvpwrvgnd_1
XTAP_TAPCELL_ROW_81_1731 VSS VDD sky130_fd_sc_hd__tapvpwrvgnd_1
XTAP_TAPCELL_ROW_81_1732 VSS VDD sky130_fd_sc_hd__tapvpwrvgnd_1
XTAP_TAPCELL_ROW_81_1733 VSS VDD sky130_fd_sc_hd__tapvpwrvgnd_1
XTAP_TAPCELL_ROW_81_1734 VSS VDD sky130_fd_sc_hd__tapvpwrvgnd_1
XTAP_TAPCELL_ROW_81_1735 VSS VDD sky130_fd_sc_hd__tapvpwrvgnd_1
XTAP_TAPCELL_ROW_81_1736 VSS VDD sky130_fd_sc_hd__tapvpwrvgnd_1
XTAP_TAPCELL_ROW_81_1737 VSS VDD sky130_fd_sc_hd__tapvpwrvgnd_1
XTAP_TAPCELL_ROW_81_1738 VSS VDD sky130_fd_sc_hd__tapvpwrvgnd_1
XTAP_TAPCELL_ROW_81_1739 VSS VDD sky130_fd_sc_hd__tapvpwrvgnd_1
XTAP_TAPCELL_ROW_81_1740 VSS VDD sky130_fd_sc_hd__tapvpwrvgnd_1
XTAP_TAPCELL_ROW_81_1741 VSS VDD sky130_fd_sc_hd__tapvpwrvgnd_1
XTAP_TAPCELL_ROW_81_1742 VSS VDD sky130_fd_sc_hd__tapvpwrvgnd_1
XTAP_TAPCELL_ROW_82_1743 VSS VDD sky130_fd_sc_hd__tapvpwrvgnd_1
XTAP_TAPCELL_ROW_82_1744 VSS VDD sky130_fd_sc_hd__tapvpwrvgnd_1
XTAP_TAPCELL_ROW_82_1745 VSS VDD sky130_fd_sc_hd__tapvpwrvgnd_1
XTAP_TAPCELL_ROW_82_1746 VSS VDD sky130_fd_sc_hd__tapvpwrvgnd_1
XTAP_TAPCELL_ROW_82_1747 VSS VDD sky130_fd_sc_hd__tapvpwrvgnd_1
XTAP_TAPCELL_ROW_82_1748 VSS VDD sky130_fd_sc_hd__tapvpwrvgnd_1
XTAP_TAPCELL_ROW_82_1749 VSS VDD sky130_fd_sc_hd__tapvpwrvgnd_1
XTAP_TAPCELL_ROW_82_1750 VSS VDD sky130_fd_sc_hd__tapvpwrvgnd_1
XTAP_TAPCELL_ROW_82_1751 VSS VDD sky130_fd_sc_hd__tapvpwrvgnd_1
XTAP_TAPCELL_ROW_82_1752 VSS VDD sky130_fd_sc_hd__tapvpwrvgnd_1
XTAP_TAPCELL_ROW_82_1753 VSS VDD sky130_fd_sc_hd__tapvpwrvgnd_1
XTAP_TAPCELL_ROW_82_1754 VSS VDD sky130_fd_sc_hd__tapvpwrvgnd_1
XTAP_TAPCELL_ROW_82_1755 VSS VDD sky130_fd_sc_hd__tapvpwrvgnd_1
XTAP_TAPCELL_ROW_82_1756 VSS VDD sky130_fd_sc_hd__tapvpwrvgnd_1
XTAP_TAPCELL_ROW_82_1757 VSS VDD sky130_fd_sc_hd__tapvpwrvgnd_1
XTAP_TAPCELL_ROW_82_1758 VSS VDD sky130_fd_sc_hd__tapvpwrvgnd_1
XTAP_TAPCELL_ROW_82_1759 VSS VDD sky130_fd_sc_hd__tapvpwrvgnd_1
XTAP_TAPCELL_ROW_82_1760 VSS VDD sky130_fd_sc_hd__tapvpwrvgnd_1
XTAP_TAPCELL_ROW_82_1761 VSS VDD sky130_fd_sc_hd__tapvpwrvgnd_1
XTAP_TAPCELL_ROW_82_1762 VSS VDD sky130_fd_sc_hd__tapvpwrvgnd_1
XTAP_TAPCELL_ROW_82_1763 VSS VDD sky130_fd_sc_hd__tapvpwrvgnd_1
XTAP_TAPCELL_ROW_83_1764 VSS VDD sky130_fd_sc_hd__tapvpwrvgnd_1
XTAP_TAPCELL_ROW_83_1765 VSS VDD sky130_fd_sc_hd__tapvpwrvgnd_1
XTAP_TAPCELL_ROW_83_1766 VSS VDD sky130_fd_sc_hd__tapvpwrvgnd_1
XTAP_TAPCELL_ROW_83_1767 VSS VDD sky130_fd_sc_hd__tapvpwrvgnd_1
XTAP_TAPCELL_ROW_83_1768 VSS VDD sky130_fd_sc_hd__tapvpwrvgnd_1
XTAP_TAPCELL_ROW_83_1769 VSS VDD sky130_fd_sc_hd__tapvpwrvgnd_1
XTAP_TAPCELL_ROW_83_1770 VSS VDD sky130_fd_sc_hd__tapvpwrvgnd_1
XTAP_TAPCELL_ROW_83_1771 VSS VDD sky130_fd_sc_hd__tapvpwrvgnd_1
XTAP_TAPCELL_ROW_83_1772 VSS VDD sky130_fd_sc_hd__tapvpwrvgnd_1
XTAP_TAPCELL_ROW_83_1773 VSS VDD sky130_fd_sc_hd__tapvpwrvgnd_1
XTAP_TAPCELL_ROW_83_1774 VSS VDD sky130_fd_sc_hd__tapvpwrvgnd_1
XTAP_TAPCELL_ROW_83_1775 VSS VDD sky130_fd_sc_hd__tapvpwrvgnd_1
XTAP_TAPCELL_ROW_83_1776 VSS VDD sky130_fd_sc_hd__tapvpwrvgnd_1
XTAP_TAPCELL_ROW_83_1777 VSS VDD sky130_fd_sc_hd__tapvpwrvgnd_1
XTAP_TAPCELL_ROW_83_1778 VSS VDD sky130_fd_sc_hd__tapvpwrvgnd_1
XTAP_TAPCELL_ROW_83_1779 VSS VDD sky130_fd_sc_hd__tapvpwrvgnd_1
XTAP_TAPCELL_ROW_83_1780 VSS VDD sky130_fd_sc_hd__tapvpwrvgnd_1
XTAP_TAPCELL_ROW_83_1781 VSS VDD sky130_fd_sc_hd__tapvpwrvgnd_1
XTAP_TAPCELL_ROW_83_1782 VSS VDD sky130_fd_sc_hd__tapvpwrvgnd_1
XTAP_TAPCELL_ROW_83_1783 VSS VDD sky130_fd_sc_hd__tapvpwrvgnd_1
XTAP_TAPCELL_ROW_83_1784 VSS VDD sky130_fd_sc_hd__tapvpwrvgnd_1
XTAP_TAPCELL_ROW_84_1785 VSS VDD sky130_fd_sc_hd__tapvpwrvgnd_1
XTAP_TAPCELL_ROW_84_1786 VSS VDD sky130_fd_sc_hd__tapvpwrvgnd_1
XTAP_TAPCELL_ROW_84_1787 VSS VDD sky130_fd_sc_hd__tapvpwrvgnd_1
XTAP_TAPCELL_ROW_84_1788 VSS VDD sky130_fd_sc_hd__tapvpwrvgnd_1
XTAP_TAPCELL_ROW_84_1789 VSS VDD sky130_fd_sc_hd__tapvpwrvgnd_1
XTAP_TAPCELL_ROW_84_1790 VSS VDD sky130_fd_sc_hd__tapvpwrvgnd_1
XTAP_TAPCELL_ROW_84_1791 VSS VDD sky130_fd_sc_hd__tapvpwrvgnd_1
XTAP_TAPCELL_ROW_84_1792 VSS VDD sky130_fd_sc_hd__tapvpwrvgnd_1
XTAP_TAPCELL_ROW_84_1793 VSS VDD sky130_fd_sc_hd__tapvpwrvgnd_1
XTAP_TAPCELL_ROW_84_1794 VSS VDD sky130_fd_sc_hd__tapvpwrvgnd_1
XTAP_TAPCELL_ROW_84_1795 VSS VDD sky130_fd_sc_hd__tapvpwrvgnd_1
XTAP_TAPCELL_ROW_84_1796 VSS VDD sky130_fd_sc_hd__tapvpwrvgnd_1
XTAP_TAPCELL_ROW_84_1797 VSS VDD sky130_fd_sc_hd__tapvpwrvgnd_1
XTAP_TAPCELL_ROW_84_1798 VSS VDD sky130_fd_sc_hd__tapvpwrvgnd_1
XTAP_TAPCELL_ROW_84_1799 VSS VDD sky130_fd_sc_hd__tapvpwrvgnd_1
XTAP_TAPCELL_ROW_84_1800 VSS VDD sky130_fd_sc_hd__tapvpwrvgnd_1
XTAP_TAPCELL_ROW_84_1801 VSS VDD sky130_fd_sc_hd__tapvpwrvgnd_1
XTAP_TAPCELL_ROW_84_1802 VSS VDD sky130_fd_sc_hd__tapvpwrvgnd_1
XTAP_TAPCELL_ROW_84_1803 VSS VDD sky130_fd_sc_hd__tapvpwrvgnd_1
XTAP_TAPCELL_ROW_84_1804 VSS VDD sky130_fd_sc_hd__tapvpwrvgnd_1
XTAP_TAPCELL_ROW_84_1805 VSS VDD sky130_fd_sc_hd__tapvpwrvgnd_1
XTAP_TAPCELL_ROW_85_1806 VSS VDD sky130_fd_sc_hd__tapvpwrvgnd_1
XTAP_TAPCELL_ROW_85_1807 VSS VDD sky130_fd_sc_hd__tapvpwrvgnd_1
XTAP_TAPCELL_ROW_85_1808 VSS VDD sky130_fd_sc_hd__tapvpwrvgnd_1
XTAP_TAPCELL_ROW_85_1809 VSS VDD sky130_fd_sc_hd__tapvpwrvgnd_1
XTAP_TAPCELL_ROW_85_1810 VSS VDD sky130_fd_sc_hd__tapvpwrvgnd_1
XTAP_TAPCELL_ROW_85_1811 VSS VDD sky130_fd_sc_hd__tapvpwrvgnd_1
XTAP_TAPCELL_ROW_85_1812 VSS VDD sky130_fd_sc_hd__tapvpwrvgnd_1
XTAP_TAPCELL_ROW_85_1813 VSS VDD sky130_fd_sc_hd__tapvpwrvgnd_1
XTAP_TAPCELL_ROW_85_1814 VSS VDD sky130_fd_sc_hd__tapvpwrvgnd_1
XTAP_TAPCELL_ROW_85_1815 VSS VDD sky130_fd_sc_hd__tapvpwrvgnd_1
XTAP_TAPCELL_ROW_85_1816 VSS VDD sky130_fd_sc_hd__tapvpwrvgnd_1
XTAP_TAPCELL_ROW_85_1817 VSS VDD sky130_fd_sc_hd__tapvpwrvgnd_1
XTAP_TAPCELL_ROW_85_1818 VSS VDD sky130_fd_sc_hd__tapvpwrvgnd_1
XTAP_TAPCELL_ROW_85_1819 VSS VDD sky130_fd_sc_hd__tapvpwrvgnd_1
XTAP_TAPCELL_ROW_85_1820 VSS VDD sky130_fd_sc_hd__tapvpwrvgnd_1
XTAP_TAPCELL_ROW_85_1821 VSS VDD sky130_fd_sc_hd__tapvpwrvgnd_1
XTAP_TAPCELL_ROW_85_1822 VSS VDD sky130_fd_sc_hd__tapvpwrvgnd_1
XTAP_TAPCELL_ROW_85_1823 VSS VDD sky130_fd_sc_hd__tapvpwrvgnd_1
XTAP_TAPCELL_ROW_85_1824 VSS VDD sky130_fd_sc_hd__tapvpwrvgnd_1
XTAP_TAPCELL_ROW_85_1825 VSS VDD sky130_fd_sc_hd__tapvpwrvgnd_1
XTAP_TAPCELL_ROW_85_1826 VSS VDD sky130_fd_sc_hd__tapvpwrvgnd_1
XTAP_TAPCELL_ROW_86_1827 VSS VDD sky130_fd_sc_hd__tapvpwrvgnd_1
XTAP_TAPCELL_ROW_86_1828 VSS VDD sky130_fd_sc_hd__tapvpwrvgnd_1
XTAP_TAPCELL_ROW_86_1829 VSS VDD sky130_fd_sc_hd__tapvpwrvgnd_1
XTAP_TAPCELL_ROW_86_1830 VSS VDD sky130_fd_sc_hd__tapvpwrvgnd_1
XTAP_TAPCELL_ROW_86_1831 VSS VDD sky130_fd_sc_hd__tapvpwrvgnd_1
XTAP_TAPCELL_ROW_86_1832 VSS VDD sky130_fd_sc_hd__tapvpwrvgnd_1
XTAP_TAPCELL_ROW_86_1833 VSS VDD sky130_fd_sc_hd__tapvpwrvgnd_1
XTAP_TAPCELL_ROW_86_1834 VSS VDD sky130_fd_sc_hd__tapvpwrvgnd_1
XTAP_TAPCELL_ROW_86_1835 VSS VDD sky130_fd_sc_hd__tapvpwrvgnd_1
XTAP_TAPCELL_ROW_86_1836 VSS VDD sky130_fd_sc_hd__tapvpwrvgnd_1
XTAP_TAPCELL_ROW_86_1837 VSS VDD sky130_fd_sc_hd__tapvpwrvgnd_1
XTAP_TAPCELL_ROW_86_1838 VSS VDD sky130_fd_sc_hd__tapvpwrvgnd_1
XTAP_TAPCELL_ROW_86_1839 VSS VDD sky130_fd_sc_hd__tapvpwrvgnd_1
XTAP_TAPCELL_ROW_86_1840 VSS VDD sky130_fd_sc_hd__tapvpwrvgnd_1
XTAP_TAPCELL_ROW_86_1841 VSS VDD sky130_fd_sc_hd__tapvpwrvgnd_1
XTAP_TAPCELL_ROW_86_1842 VSS VDD sky130_fd_sc_hd__tapvpwrvgnd_1
XTAP_TAPCELL_ROW_86_1843 VSS VDD sky130_fd_sc_hd__tapvpwrvgnd_1
XTAP_TAPCELL_ROW_86_1844 VSS VDD sky130_fd_sc_hd__tapvpwrvgnd_1
XTAP_TAPCELL_ROW_86_1845 VSS VDD sky130_fd_sc_hd__tapvpwrvgnd_1
XTAP_TAPCELL_ROW_86_1846 VSS VDD sky130_fd_sc_hd__tapvpwrvgnd_1
XTAP_TAPCELL_ROW_86_1847 VSS VDD sky130_fd_sc_hd__tapvpwrvgnd_1
XTAP_TAPCELL_ROW_87_1848 VSS VDD sky130_fd_sc_hd__tapvpwrvgnd_1
XTAP_TAPCELL_ROW_87_1849 VSS VDD sky130_fd_sc_hd__tapvpwrvgnd_1
XTAP_TAPCELL_ROW_87_1850 VSS VDD sky130_fd_sc_hd__tapvpwrvgnd_1
XTAP_TAPCELL_ROW_87_1851 VSS VDD sky130_fd_sc_hd__tapvpwrvgnd_1
XTAP_TAPCELL_ROW_87_1852 VSS VDD sky130_fd_sc_hd__tapvpwrvgnd_1
XTAP_TAPCELL_ROW_87_1853 VSS VDD sky130_fd_sc_hd__tapvpwrvgnd_1
XTAP_TAPCELL_ROW_87_1854 VSS VDD sky130_fd_sc_hd__tapvpwrvgnd_1
XTAP_TAPCELL_ROW_87_1855 VSS VDD sky130_fd_sc_hd__tapvpwrvgnd_1
XTAP_TAPCELL_ROW_87_1856 VSS VDD sky130_fd_sc_hd__tapvpwrvgnd_1
XTAP_TAPCELL_ROW_87_1857 VSS VDD sky130_fd_sc_hd__tapvpwrvgnd_1
XTAP_TAPCELL_ROW_87_1858 VSS VDD sky130_fd_sc_hd__tapvpwrvgnd_1
XTAP_TAPCELL_ROW_87_1859 VSS VDD sky130_fd_sc_hd__tapvpwrvgnd_1
XTAP_TAPCELL_ROW_87_1860 VSS VDD sky130_fd_sc_hd__tapvpwrvgnd_1
XTAP_TAPCELL_ROW_87_1861 VSS VDD sky130_fd_sc_hd__tapvpwrvgnd_1
XTAP_TAPCELL_ROW_87_1862 VSS VDD sky130_fd_sc_hd__tapvpwrvgnd_1
XTAP_TAPCELL_ROW_87_1863 VSS VDD sky130_fd_sc_hd__tapvpwrvgnd_1
XTAP_TAPCELL_ROW_87_1864 VSS VDD sky130_fd_sc_hd__tapvpwrvgnd_1
XTAP_TAPCELL_ROW_87_1865 VSS VDD sky130_fd_sc_hd__tapvpwrvgnd_1
XTAP_TAPCELL_ROW_87_1866 VSS VDD sky130_fd_sc_hd__tapvpwrvgnd_1
XTAP_TAPCELL_ROW_87_1867 VSS VDD sky130_fd_sc_hd__tapvpwrvgnd_1
XTAP_TAPCELL_ROW_87_1868 VSS VDD sky130_fd_sc_hd__tapvpwrvgnd_1
XTAP_TAPCELL_ROW_88_1869 VSS VDD sky130_fd_sc_hd__tapvpwrvgnd_1
XTAP_TAPCELL_ROW_88_1870 VSS VDD sky130_fd_sc_hd__tapvpwrvgnd_1
XTAP_TAPCELL_ROW_88_1871 VSS VDD sky130_fd_sc_hd__tapvpwrvgnd_1
XTAP_TAPCELL_ROW_88_1872 VSS VDD sky130_fd_sc_hd__tapvpwrvgnd_1
XTAP_TAPCELL_ROW_88_1873 VSS VDD sky130_fd_sc_hd__tapvpwrvgnd_1
XTAP_TAPCELL_ROW_88_1874 VSS VDD sky130_fd_sc_hd__tapvpwrvgnd_1
XTAP_TAPCELL_ROW_88_1875 VSS VDD sky130_fd_sc_hd__tapvpwrvgnd_1
XTAP_TAPCELL_ROW_88_1876 VSS VDD sky130_fd_sc_hd__tapvpwrvgnd_1
XTAP_TAPCELL_ROW_88_1877 VSS VDD sky130_fd_sc_hd__tapvpwrvgnd_1
XTAP_TAPCELL_ROW_88_1878 VSS VDD sky130_fd_sc_hd__tapvpwrvgnd_1
XTAP_TAPCELL_ROW_88_1879 VSS VDD sky130_fd_sc_hd__tapvpwrvgnd_1
XTAP_TAPCELL_ROW_88_1880 VSS VDD sky130_fd_sc_hd__tapvpwrvgnd_1
XTAP_TAPCELL_ROW_88_1881 VSS VDD sky130_fd_sc_hd__tapvpwrvgnd_1
XTAP_TAPCELL_ROW_88_1882 VSS VDD sky130_fd_sc_hd__tapvpwrvgnd_1
XTAP_TAPCELL_ROW_88_1883 VSS VDD sky130_fd_sc_hd__tapvpwrvgnd_1
XTAP_TAPCELL_ROW_88_1884 VSS VDD sky130_fd_sc_hd__tapvpwrvgnd_1
XTAP_TAPCELL_ROW_88_1885 VSS VDD sky130_fd_sc_hd__tapvpwrvgnd_1
XTAP_TAPCELL_ROW_88_1886 VSS VDD sky130_fd_sc_hd__tapvpwrvgnd_1
XTAP_TAPCELL_ROW_88_1887 VSS VDD sky130_fd_sc_hd__tapvpwrvgnd_1
XTAP_TAPCELL_ROW_88_1888 VSS VDD sky130_fd_sc_hd__tapvpwrvgnd_1
XTAP_TAPCELL_ROW_88_1889 VSS VDD sky130_fd_sc_hd__tapvpwrvgnd_1
XTAP_TAPCELL_ROW_89_1890 VSS VDD sky130_fd_sc_hd__tapvpwrvgnd_1
XTAP_TAPCELL_ROW_89_1891 VSS VDD sky130_fd_sc_hd__tapvpwrvgnd_1
XTAP_TAPCELL_ROW_89_1892 VSS VDD sky130_fd_sc_hd__tapvpwrvgnd_1
XTAP_TAPCELL_ROW_89_1893 VSS VDD sky130_fd_sc_hd__tapvpwrvgnd_1
XTAP_TAPCELL_ROW_89_1894 VSS VDD sky130_fd_sc_hd__tapvpwrvgnd_1
XTAP_TAPCELL_ROW_89_1895 VSS VDD sky130_fd_sc_hd__tapvpwrvgnd_1
XTAP_TAPCELL_ROW_89_1896 VSS VDD sky130_fd_sc_hd__tapvpwrvgnd_1
XTAP_TAPCELL_ROW_89_1897 VSS VDD sky130_fd_sc_hd__tapvpwrvgnd_1
XTAP_TAPCELL_ROW_89_1898 VSS VDD sky130_fd_sc_hd__tapvpwrvgnd_1
XTAP_TAPCELL_ROW_89_1899 VSS VDD sky130_fd_sc_hd__tapvpwrvgnd_1
XTAP_TAPCELL_ROW_89_1900 VSS VDD sky130_fd_sc_hd__tapvpwrvgnd_1
XTAP_TAPCELL_ROW_89_1901 VSS VDD sky130_fd_sc_hd__tapvpwrvgnd_1
XTAP_TAPCELL_ROW_89_1902 VSS VDD sky130_fd_sc_hd__tapvpwrvgnd_1
XTAP_TAPCELL_ROW_89_1903 VSS VDD sky130_fd_sc_hd__tapvpwrvgnd_1
XTAP_TAPCELL_ROW_89_1904 VSS VDD sky130_fd_sc_hd__tapvpwrvgnd_1
XTAP_TAPCELL_ROW_89_1905 VSS VDD sky130_fd_sc_hd__tapvpwrvgnd_1
XTAP_TAPCELL_ROW_89_1906 VSS VDD sky130_fd_sc_hd__tapvpwrvgnd_1
XTAP_TAPCELL_ROW_89_1907 VSS VDD sky130_fd_sc_hd__tapvpwrvgnd_1
XTAP_TAPCELL_ROW_89_1908 VSS VDD sky130_fd_sc_hd__tapvpwrvgnd_1
XTAP_TAPCELL_ROW_89_1909 VSS VDD sky130_fd_sc_hd__tapvpwrvgnd_1
XTAP_TAPCELL_ROW_89_1910 VSS VDD sky130_fd_sc_hd__tapvpwrvgnd_1
XTAP_TAPCELL_ROW_90_1911 VSS VDD sky130_fd_sc_hd__tapvpwrvgnd_1
XTAP_TAPCELL_ROW_90_1912 VSS VDD sky130_fd_sc_hd__tapvpwrvgnd_1
XTAP_TAPCELL_ROW_90_1913 VSS VDD sky130_fd_sc_hd__tapvpwrvgnd_1
XTAP_TAPCELL_ROW_90_1914 VSS VDD sky130_fd_sc_hd__tapvpwrvgnd_1
XTAP_TAPCELL_ROW_90_1915 VSS VDD sky130_fd_sc_hd__tapvpwrvgnd_1
XTAP_TAPCELL_ROW_90_1916 VSS VDD sky130_fd_sc_hd__tapvpwrvgnd_1
XTAP_TAPCELL_ROW_90_1917 VSS VDD sky130_fd_sc_hd__tapvpwrvgnd_1
XTAP_TAPCELL_ROW_90_1918 VSS VDD sky130_fd_sc_hd__tapvpwrvgnd_1
XTAP_TAPCELL_ROW_90_1919 VSS VDD sky130_fd_sc_hd__tapvpwrvgnd_1
XTAP_TAPCELL_ROW_90_1920 VSS VDD sky130_fd_sc_hd__tapvpwrvgnd_1
XTAP_TAPCELL_ROW_90_1921 VSS VDD sky130_fd_sc_hd__tapvpwrvgnd_1
XTAP_TAPCELL_ROW_90_1922 VSS VDD sky130_fd_sc_hd__tapvpwrvgnd_1
XTAP_TAPCELL_ROW_90_1923 VSS VDD sky130_fd_sc_hd__tapvpwrvgnd_1
XTAP_TAPCELL_ROW_90_1924 VSS VDD sky130_fd_sc_hd__tapvpwrvgnd_1
XTAP_TAPCELL_ROW_90_1925 VSS VDD sky130_fd_sc_hd__tapvpwrvgnd_1
XTAP_TAPCELL_ROW_90_1926 VSS VDD sky130_fd_sc_hd__tapvpwrvgnd_1
XTAP_TAPCELL_ROW_90_1927 VSS VDD sky130_fd_sc_hd__tapvpwrvgnd_1
XTAP_TAPCELL_ROW_90_1928 VSS VDD sky130_fd_sc_hd__tapvpwrvgnd_1
XTAP_TAPCELL_ROW_90_1929 VSS VDD sky130_fd_sc_hd__tapvpwrvgnd_1
XTAP_TAPCELL_ROW_90_1930 VSS VDD sky130_fd_sc_hd__tapvpwrvgnd_1
XTAP_TAPCELL_ROW_90_1931 VSS VDD sky130_fd_sc_hd__tapvpwrvgnd_1
XTAP_TAPCELL_ROW_91_1932 VSS VDD sky130_fd_sc_hd__tapvpwrvgnd_1
XTAP_TAPCELL_ROW_91_1933 VSS VDD sky130_fd_sc_hd__tapvpwrvgnd_1
XTAP_TAPCELL_ROW_91_1934 VSS VDD sky130_fd_sc_hd__tapvpwrvgnd_1
XTAP_TAPCELL_ROW_91_1935 VSS VDD sky130_fd_sc_hd__tapvpwrvgnd_1
XTAP_TAPCELL_ROW_91_1936 VSS VDD sky130_fd_sc_hd__tapvpwrvgnd_1
XTAP_TAPCELL_ROW_91_1937 VSS VDD sky130_fd_sc_hd__tapvpwrvgnd_1
XTAP_TAPCELL_ROW_91_1938 VSS VDD sky130_fd_sc_hd__tapvpwrvgnd_1
XTAP_TAPCELL_ROW_91_1939 VSS VDD sky130_fd_sc_hd__tapvpwrvgnd_1
XTAP_TAPCELL_ROW_91_1940 VSS VDD sky130_fd_sc_hd__tapvpwrvgnd_1
XTAP_TAPCELL_ROW_91_1941 VSS VDD sky130_fd_sc_hd__tapvpwrvgnd_1
XTAP_TAPCELL_ROW_91_1942 VSS VDD sky130_fd_sc_hd__tapvpwrvgnd_1
XTAP_TAPCELL_ROW_91_1943 VSS VDD sky130_fd_sc_hd__tapvpwrvgnd_1
XTAP_TAPCELL_ROW_91_1944 VSS VDD sky130_fd_sc_hd__tapvpwrvgnd_1
XTAP_TAPCELL_ROW_91_1945 VSS VDD sky130_fd_sc_hd__tapvpwrvgnd_1
XTAP_TAPCELL_ROW_91_1946 VSS VDD sky130_fd_sc_hd__tapvpwrvgnd_1
XTAP_TAPCELL_ROW_91_1947 VSS VDD sky130_fd_sc_hd__tapvpwrvgnd_1
XTAP_TAPCELL_ROW_91_1948 VSS VDD sky130_fd_sc_hd__tapvpwrvgnd_1
XTAP_TAPCELL_ROW_91_1949 VSS VDD sky130_fd_sc_hd__tapvpwrvgnd_1
XTAP_TAPCELL_ROW_91_1950 VSS VDD sky130_fd_sc_hd__tapvpwrvgnd_1
XTAP_TAPCELL_ROW_91_1951 VSS VDD sky130_fd_sc_hd__tapvpwrvgnd_1
XTAP_TAPCELL_ROW_91_1952 VSS VDD sky130_fd_sc_hd__tapvpwrvgnd_1
XTAP_TAPCELL_ROW_92_1953 VSS VDD sky130_fd_sc_hd__tapvpwrvgnd_1
XTAP_TAPCELL_ROW_92_1954 VSS VDD sky130_fd_sc_hd__tapvpwrvgnd_1
XTAP_TAPCELL_ROW_92_1955 VSS VDD sky130_fd_sc_hd__tapvpwrvgnd_1
XTAP_TAPCELL_ROW_92_1956 VSS VDD sky130_fd_sc_hd__tapvpwrvgnd_1
XTAP_TAPCELL_ROW_92_1957 VSS VDD sky130_fd_sc_hd__tapvpwrvgnd_1
XTAP_TAPCELL_ROW_92_1958 VSS VDD sky130_fd_sc_hd__tapvpwrvgnd_1
XTAP_TAPCELL_ROW_92_1959 VSS VDD sky130_fd_sc_hd__tapvpwrvgnd_1
XTAP_TAPCELL_ROW_92_1960 VSS VDD sky130_fd_sc_hd__tapvpwrvgnd_1
XTAP_TAPCELL_ROW_92_1961 VSS VDD sky130_fd_sc_hd__tapvpwrvgnd_1
XTAP_TAPCELL_ROW_92_1962 VSS VDD sky130_fd_sc_hd__tapvpwrvgnd_1
XTAP_TAPCELL_ROW_92_1963 VSS VDD sky130_fd_sc_hd__tapvpwrvgnd_1
XTAP_TAPCELL_ROW_92_1964 VSS VDD sky130_fd_sc_hd__tapvpwrvgnd_1
XTAP_TAPCELL_ROW_92_1965 VSS VDD sky130_fd_sc_hd__tapvpwrvgnd_1
XTAP_TAPCELL_ROW_92_1966 VSS VDD sky130_fd_sc_hd__tapvpwrvgnd_1
XTAP_TAPCELL_ROW_92_1967 VSS VDD sky130_fd_sc_hd__tapvpwrvgnd_1
XTAP_TAPCELL_ROW_92_1968 VSS VDD sky130_fd_sc_hd__tapvpwrvgnd_1
XTAP_TAPCELL_ROW_92_1969 VSS VDD sky130_fd_sc_hd__tapvpwrvgnd_1
XTAP_TAPCELL_ROW_92_1970 VSS VDD sky130_fd_sc_hd__tapvpwrvgnd_1
XTAP_TAPCELL_ROW_92_1971 VSS VDD sky130_fd_sc_hd__tapvpwrvgnd_1
XTAP_TAPCELL_ROW_92_1972 VSS VDD sky130_fd_sc_hd__tapvpwrvgnd_1
XTAP_TAPCELL_ROW_92_1973 VSS VDD sky130_fd_sc_hd__tapvpwrvgnd_1
XTAP_TAPCELL_ROW_93_1974 VSS VDD sky130_fd_sc_hd__tapvpwrvgnd_1
XTAP_TAPCELL_ROW_93_1975 VSS VDD sky130_fd_sc_hd__tapvpwrvgnd_1
XTAP_TAPCELL_ROW_93_1976 VSS VDD sky130_fd_sc_hd__tapvpwrvgnd_1
XTAP_TAPCELL_ROW_93_1977 VSS VDD sky130_fd_sc_hd__tapvpwrvgnd_1
XTAP_TAPCELL_ROW_93_1978 VSS VDD sky130_fd_sc_hd__tapvpwrvgnd_1
XTAP_TAPCELL_ROW_93_1979 VSS VDD sky130_fd_sc_hd__tapvpwrvgnd_1
XTAP_TAPCELL_ROW_93_1980 VSS VDD sky130_fd_sc_hd__tapvpwrvgnd_1
XTAP_TAPCELL_ROW_93_1981 VSS VDD sky130_fd_sc_hd__tapvpwrvgnd_1
XTAP_TAPCELL_ROW_93_1982 VSS VDD sky130_fd_sc_hd__tapvpwrvgnd_1
XTAP_TAPCELL_ROW_93_1983 VSS VDD sky130_fd_sc_hd__tapvpwrvgnd_1
XTAP_TAPCELL_ROW_93_1984 VSS VDD sky130_fd_sc_hd__tapvpwrvgnd_1
XTAP_TAPCELL_ROW_93_1985 VSS VDD sky130_fd_sc_hd__tapvpwrvgnd_1
XTAP_TAPCELL_ROW_93_1986 VSS VDD sky130_fd_sc_hd__tapvpwrvgnd_1
XTAP_TAPCELL_ROW_93_1987 VSS VDD sky130_fd_sc_hd__tapvpwrvgnd_1
XTAP_TAPCELL_ROW_93_1988 VSS VDD sky130_fd_sc_hd__tapvpwrvgnd_1
XTAP_TAPCELL_ROW_93_1989 VSS VDD sky130_fd_sc_hd__tapvpwrvgnd_1
XTAP_TAPCELL_ROW_93_1990 VSS VDD sky130_fd_sc_hd__tapvpwrvgnd_1
XTAP_TAPCELL_ROW_93_1991 VSS VDD sky130_fd_sc_hd__tapvpwrvgnd_1
XTAP_TAPCELL_ROW_93_1992 VSS VDD sky130_fd_sc_hd__tapvpwrvgnd_1
XTAP_TAPCELL_ROW_93_1993 VSS VDD sky130_fd_sc_hd__tapvpwrvgnd_1
XTAP_TAPCELL_ROW_93_1994 VSS VDD sky130_fd_sc_hd__tapvpwrvgnd_1
XTAP_TAPCELL_ROW_94_1995 VSS VDD sky130_fd_sc_hd__tapvpwrvgnd_1
XTAP_TAPCELL_ROW_94_1996 VSS VDD sky130_fd_sc_hd__tapvpwrvgnd_1
XTAP_TAPCELL_ROW_94_1997 VSS VDD sky130_fd_sc_hd__tapvpwrvgnd_1
XTAP_TAPCELL_ROW_94_1998 VSS VDD sky130_fd_sc_hd__tapvpwrvgnd_1
XTAP_TAPCELL_ROW_94_1999 VSS VDD sky130_fd_sc_hd__tapvpwrvgnd_1
XTAP_TAPCELL_ROW_94_2000 VSS VDD sky130_fd_sc_hd__tapvpwrvgnd_1
XTAP_TAPCELL_ROW_94_2001 VSS VDD sky130_fd_sc_hd__tapvpwrvgnd_1
XTAP_TAPCELL_ROW_94_2002 VSS VDD sky130_fd_sc_hd__tapvpwrvgnd_1
XTAP_TAPCELL_ROW_94_2003 VSS VDD sky130_fd_sc_hd__tapvpwrvgnd_1
XTAP_TAPCELL_ROW_94_2004 VSS VDD sky130_fd_sc_hd__tapvpwrvgnd_1
XTAP_TAPCELL_ROW_94_2005 VSS VDD sky130_fd_sc_hd__tapvpwrvgnd_1
XTAP_TAPCELL_ROW_94_2006 VSS VDD sky130_fd_sc_hd__tapvpwrvgnd_1
XTAP_TAPCELL_ROW_94_2007 VSS VDD sky130_fd_sc_hd__tapvpwrvgnd_1
XTAP_TAPCELL_ROW_94_2008 VSS VDD sky130_fd_sc_hd__tapvpwrvgnd_1
XTAP_TAPCELL_ROW_94_2009 VSS VDD sky130_fd_sc_hd__tapvpwrvgnd_1
XTAP_TAPCELL_ROW_94_2010 VSS VDD sky130_fd_sc_hd__tapvpwrvgnd_1
XTAP_TAPCELL_ROW_94_2011 VSS VDD sky130_fd_sc_hd__tapvpwrvgnd_1
XTAP_TAPCELL_ROW_94_2012 VSS VDD sky130_fd_sc_hd__tapvpwrvgnd_1
XTAP_TAPCELL_ROW_94_2013 VSS VDD sky130_fd_sc_hd__tapvpwrvgnd_1
XTAP_TAPCELL_ROW_94_2014 VSS VDD sky130_fd_sc_hd__tapvpwrvgnd_1
XTAP_TAPCELL_ROW_94_2015 VSS VDD sky130_fd_sc_hd__tapvpwrvgnd_1
XTAP_TAPCELL_ROW_95_2016 VSS VDD sky130_fd_sc_hd__tapvpwrvgnd_1
XTAP_TAPCELL_ROW_95_2017 VSS VDD sky130_fd_sc_hd__tapvpwrvgnd_1
XTAP_TAPCELL_ROW_95_2018 VSS VDD sky130_fd_sc_hd__tapvpwrvgnd_1
XTAP_TAPCELL_ROW_95_2019 VSS VDD sky130_fd_sc_hd__tapvpwrvgnd_1
XTAP_TAPCELL_ROW_95_2020 VSS VDD sky130_fd_sc_hd__tapvpwrvgnd_1
XTAP_TAPCELL_ROW_95_2021 VSS VDD sky130_fd_sc_hd__tapvpwrvgnd_1
XTAP_TAPCELL_ROW_95_2022 VSS VDD sky130_fd_sc_hd__tapvpwrvgnd_1
XTAP_TAPCELL_ROW_95_2023 VSS VDD sky130_fd_sc_hd__tapvpwrvgnd_1
XTAP_TAPCELL_ROW_95_2024 VSS VDD sky130_fd_sc_hd__tapvpwrvgnd_1
XTAP_TAPCELL_ROW_95_2025 VSS VDD sky130_fd_sc_hd__tapvpwrvgnd_1
XTAP_TAPCELL_ROW_95_2026 VSS VDD sky130_fd_sc_hd__tapvpwrvgnd_1
XTAP_TAPCELL_ROW_95_2027 VSS VDD sky130_fd_sc_hd__tapvpwrvgnd_1
XTAP_TAPCELL_ROW_95_2028 VSS VDD sky130_fd_sc_hd__tapvpwrvgnd_1
XTAP_TAPCELL_ROW_95_2029 VSS VDD sky130_fd_sc_hd__tapvpwrvgnd_1
XTAP_TAPCELL_ROW_95_2030 VSS VDD sky130_fd_sc_hd__tapvpwrvgnd_1
XTAP_TAPCELL_ROW_95_2031 VSS VDD sky130_fd_sc_hd__tapvpwrvgnd_1
XTAP_TAPCELL_ROW_95_2032 VSS VDD sky130_fd_sc_hd__tapvpwrvgnd_1
XTAP_TAPCELL_ROW_95_2033 VSS VDD sky130_fd_sc_hd__tapvpwrvgnd_1
XTAP_TAPCELL_ROW_95_2034 VSS VDD sky130_fd_sc_hd__tapvpwrvgnd_1
XTAP_TAPCELL_ROW_95_2035 VSS VDD sky130_fd_sc_hd__tapvpwrvgnd_1
XTAP_TAPCELL_ROW_95_2036 VSS VDD sky130_fd_sc_hd__tapvpwrvgnd_1
XTAP_TAPCELL_ROW_96_2037 VSS VDD sky130_fd_sc_hd__tapvpwrvgnd_1
XTAP_TAPCELL_ROW_96_2038 VSS VDD sky130_fd_sc_hd__tapvpwrvgnd_1
XTAP_TAPCELL_ROW_96_2039 VSS VDD sky130_fd_sc_hd__tapvpwrvgnd_1
XTAP_TAPCELL_ROW_96_2040 VSS VDD sky130_fd_sc_hd__tapvpwrvgnd_1
XTAP_TAPCELL_ROW_96_2041 VSS VDD sky130_fd_sc_hd__tapvpwrvgnd_1
XTAP_TAPCELL_ROW_96_2042 VSS VDD sky130_fd_sc_hd__tapvpwrvgnd_1
XTAP_TAPCELL_ROW_96_2043 VSS VDD sky130_fd_sc_hd__tapvpwrvgnd_1
XTAP_TAPCELL_ROW_96_2044 VSS VDD sky130_fd_sc_hd__tapvpwrvgnd_1
XTAP_TAPCELL_ROW_96_2045 VSS VDD sky130_fd_sc_hd__tapvpwrvgnd_1
XTAP_TAPCELL_ROW_96_2046 VSS VDD sky130_fd_sc_hd__tapvpwrvgnd_1
XTAP_TAPCELL_ROW_96_2047 VSS VDD sky130_fd_sc_hd__tapvpwrvgnd_1
XTAP_TAPCELL_ROW_96_2048 VSS VDD sky130_fd_sc_hd__tapvpwrvgnd_1
XTAP_TAPCELL_ROW_96_2049 VSS VDD sky130_fd_sc_hd__tapvpwrvgnd_1
XTAP_TAPCELL_ROW_96_2050 VSS VDD sky130_fd_sc_hd__tapvpwrvgnd_1
XTAP_TAPCELL_ROW_96_2051 VSS VDD sky130_fd_sc_hd__tapvpwrvgnd_1
XTAP_TAPCELL_ROW_96_2052 VSS VDD sky130_fd_sc_hd__tapvpwrvgnd_1
XTAP_TAPCELL_ROW_96_2053 VSS VDD sky130_fd_sc_hd__tapvpwrvgnd_1
XTAP_TAPCELL_ROW_96_2054 VSS VDD sky130_fd_sc_hd__tapvpwrvgnd_1
XTAP_TAPCELL_ROW_96_2055 VSS VDD sky130_fd_sc_hd__tapvpwrvgnd_1
XTAP_TAPCELL_ROW_96_2056 VSS VDD sky130_fd_sc_hd__tapvpwrvgnd_1
XTAP_TAPCELL_ROW_96_2057 VSS VDD sky130_fd_sc_hd__tapvpwrvgnd_1
XTAP_TAPCELL_ROW_97_2058 VSS VDD sky130_fd_sc_hd__tapvpwrvgnd_1
XTAP_TAPCELL_ROW_97_2059 VSS VDD sky130_fd_sc_hd__tapvpwrvgnd_1
XTAP_TAPCELL_ROW_97_2060 VSS VDD sky130_fd_sc_hd__tapvpwrvgnd_1
XTAP_TAPCELL_ROW_97_2061 VSS VDD sky130_fd_sc_hd__tapvpwrvgnd_1
XTAP_TAPCELL_ROW_97_2062 VSS VDD sky130_fd_sc_hd__tapvpwrvgnd_1
XTAP_TAPCELL_ROW_97_2063 VSS VDD sky130_fd_sc_hd__tapvpwrvgnd_1
XTAP_TAPCELL_ROW_97_2064 VSS VDD sky130_fd_sc_hd__tapvpwrvgnd_1
XTAP_TAPCELL_ROW_97_2065 VSS VDD sky130_fd_sc_hd__tapvpwrvgnd_1
XTAP_TAPCELL_ROW_97_2066 VSS VDD sky130_fd_sc_hd__tapvpwrvgnd_1
XTAP_TAPCELL_ROW_97_2067 VSS VDD sky130_fd_sc_hd__tapvpwrvgnd_1
XTAP_TAPCELL_ROW_97_2068 VSS VDD sky130_fd_sc_hd__tapvpwrvgnd_1
XTAP_TAPCELL_ROW_97_2069 VSS VDD sky130_fd_sc_hd__tapvpwrvgnd_1
XTAP_TAPCELL_ROW_97_2070 VSS VDD sky130_fd_sc_hd__tapvpwrvgnd_1
XTAP_TAPCELL_ROW_97_2071 VSS VDD sky130_fd_sc_hd__tapvpwrvgnd_1
XTAP_TAPCELL_ROW_97_2072 VSS VDD sky130_fd_sc_hd__tapvpwrvgnd_1
XTAP_TAPCELL_ROW_97_2073 VSS VDD sky130_fd_sc_hd__tapvpwrvgnd_1
XTAP_TAPCELL_ROW_97_2074 VSS VDD sky130_fd_sc_hd__tapvpwrvgnd_1
XTAP_TAPCELL_ROW_97_2075 VSS VDD sky130_fd_sc_hd__tapvpwrvgnd_1
XTAP_TAPCELL_ROW_97_2076 VSS VDD sky130_fd_sc_hd__tapvpwrvgnd_1
XTAP_TAPCELL_ROW_97_2077 VSS VDD sky130_fd_sc_hd__tapvpwrvgnd_1
XTAP_TAPCELL_ROW_97_2078 VSS VDD sky130_fd_sc_hd__tapvpwrvgnd_1
XTAP_TAPCELL_ROW_98_2079 VSS VDD sky130_fd_sc_hd__tapvpwrvgnd_1
XTAP_TAPCELL_ROW_98_2080 VSS VDD sky130_fd_sc_hd__tapvpwrvgnd_1
XTAP_TAPCELL_ROW_98_2081 VSS VDD sky130_fd_sc_hd__tapvpwrvgnd_1
XTAP_TAPCELL_ROW_98_2082 VSS VDD sky130_fd_sc_hd__tapvpwrvgnd_1
XTAP_TAPCELL_ROW_98_2083 VSS VDD sky130_fd_sc_hd__tapvpwrvgnd_1
XTAP_TAPCELL_ROW_98_2084 VSS VDD sky130_fd_sc_hd__tapvpwrvgnd_1
XTAP_TAPCELL_ROW_98_2085 VSS VDD sky130_fd_sc_hd__tapvpwrvgnd_1
XTAP_TAPCELL_ROW_98_2086 VSS VDD sky130_fd_sc_hd__tapvpwrvgnd_1
XTAP_TAPCELL_ROW_98_2087 VSS VDD sky130_fd_sc_hd__tapvpwrvgnd_1
XTAP_TAPCELL_ROW_98_2088 VSS VDD sky130_fd_sc_hd__tapvpwrvgnd_1
XTAP_TAPCELL_ROW_98_2089 VSS VDD sky130_fd_sc_hd__tapvpwrvgnd_1
XTAP_TAPCELL_ROW_98_2090 VSS VDD sky130_fd_sc_hd__tapvpwrvgnd_1
XTAP_TAPCELL_ROW_98_2091 VSS VDD sky130_fd_sc_hd__tapvpwrvgnd_1
XTAP_TAPCELL_ROW_98_2092 VSS VDD sky130_fd_sc_hd__tapvpwrvgnd_1
XTAP_TAPCELL_ROW_98_2093 VSS VDD sky130_fd_sc_hd__tapvpwrvgnd_1
XTAP_TAPCELL_ROW_98_2094 VSS VDD sky130_fd_sc_hd__tapvpwrvgnd_1
XTAP_TAPCELL_ROW_98_2095 VSS VDD sky130_fd_sc_hd__tapvpwrvgnd_1
XTAP_TAPCELL_ROW_98_2096 VSS VDD sky130_fd_sc_hd__tapvpwrvgnd_1
XTAP_TAPCELL_ROW_98_2097 VSS VDD sky130_fd_sc_hd__tapvpwrvgnd_1
XTAP_TAPCELL_ROW_98_2098 VSS VDD sky130_fd_sc_hd__tapvpwrvgnd_1
XTAP_TAPCELL_ROW_98_2099 VSS VDD sky130_fd_sc_hd__tapvpwrvgnd_1
XTAP_TAPCELL_ROW_99_2100 VSS VDD sky130_fd_sc_hd__tapvpwrvgnd_1
XTAP_TAPCELL_ROW_99_2101 VSS VDD sky130_fd_sc_hd__tapvpwrvgnd_1
XTAP_TAPCELL_ROW_99_2102 VSS VDD sky130_fd_sc_hd__tapvpwrvgnd_1
XTAP_TAPCELL_ROW_99_2103 VSS VDD sky130_fd_sc_hd__tapvpwrvgnd_1
XTAP_TAPCELL_ROW_99_2104 VSS VDD sky130_fd_sc_hd__tapvpwrvgnd_1
XTAP_TAPCELL_ROW_99_2105 VSS VDD sky130_fd_sc_hd__tapvpwrvgnd_1
XTAP_TAPCELL_ROW_99_2106 VSS VDD sky130_fd_sc_hd__tapvpwrvgnd_1
XTAP_TAPCELL_ROW_99_2107 VSS VDD sky130_fd_sc_hd__tapvpwrvgnd_1
XTAP_TAPCELL_ROW_99_2108 VSS VDD sky130_fd_sc_hd__tapvpwrvgnd_1
XTAP_TAPCELL_ROW_99_2109 VSS VDD sky130_fd_sc_hd__tapvpwrvgnd_1
XTAP_TAPCELL_ROW_99_2110 VSS VDD sky130_fd_sc_hd__tapvpwrvgnd_1
XTAP_TAPCELL_ROW_99_2111 VSS VDD sky130_fd_sc_hd__tapvpwrvgnd_1
XTAP_TAPCELL_ROW_99_2112 VSS VDD sky130_fd_sc_hd__tapvpwrvgnd_1
XTAP_TAPCELL_ROW_99_2113 VSS VDD sky130_fd_sc_hd__tapvpwrvgnd_1
XTAP_TAPCELL_ROW_99_2114 VSS VDD sky130_fd_sc_hd__tapvpwrvgnd_1
XTAP_TAPCELL_ROW_99_2115 VSS VDD sky130_fd_sc_hd__tapvpwrvgnd_1
XTAP_TAPCELL_ROW_99_2116 VSS VDD sky130_fd_sc_hd__tapvpwrvgnd_1
XTAP_TAPCELL_ROW_99_2117 VSS VDD sky130_fd_sc_hd__tapvpwrvgnd_1
XTAP_TAPCELL_ROW_99_2118 VSS VDD sky130_fd_sc_hd__tapvpwrvgnd_1
XTAP_TAPCELL_ROW_99_2119 VSS VDD sky130_fd_sc_hd__tapvpwrvgnd_1
XTAP_TAPCELL_ROW_99_2120 VSS VDD sky130_fd_sc_hd__tapvpwrvgnd_1
XTAP_TAPCELL_ROW_100_2121 VSS VDD sky130_fd_sc_hd__tapvpwrvgnd_1
XTAP_TAPCELL_ROW_100_2122 VSS VDD sky130_fd_sc_hd__tapvpwrvgnd_1
XTAP_TAPCELL_ROW_100_2123 VSS VDD sky130_fd_sc_hd__tapvpwrvgnd_1
XTAP_TAPCELL_ROW_100_2124 VSS VDD sky130_fd_sc_hd__tapvpwrvgnd_1
XTAP_TAPCELL_ROW_100_2125 VSS VDD sky130_fd_sc_hd__tapvpwrvgnd_1
XTAP_TAPCELL_ROW_100_2126 VSS VDD sky130_fd_sc_hd__tapvpwrvgnd_1
XTAP_TAPCELL_ROW_100_2127 VSS VDD sky130_fd_sc_hd__tapvpwrvgnd_1
XTAP_TAPCELL_ROW_100_2128 VSS VDD sky130_fd_sc_hd__tapvpwrvgnd_1
XTAP_TAPCELL_ROW_100_2129 VSS VDD sky130_fd_sc_hd__tapvpwrvgnd_1
XTAP_TAPCELL_ROW_100_2130 VSS VDD sky130_fd_sc_hd__tapvpwrvgnd_1
XTAP_TAPCELL_ROW_100_2131 VSS VDD sky130_fd_sc_hd__tapvpwrvgnd_1
XTAP_TAPCELL_ROW_100_2132 VSS VDD sky130_fd_sc_hd__tapvpwrvgnd_1
XTAP_TAPCELL_ROW_100_2133 VSS VDD sky130_fd_sc_hd__tapvpwrvgnd_1
XTAP_TAPCELL_ROW_100_2134 VSS VDD sky130_fd_sc_hd__tapvpwrvgnd_1
XTAP_TAPCELL_ROW_100_2135 VSS VDD sky130_fd_sc_hd__tapvpwrvgnd_1
XTAP_TAPCELL_ROW_100_2136 VSS VDD sky130_fd_sc_hd__tapvpwrvgnd_1
XTAP_TAPCELL_ROW_100_2137 VSS VDD sky130_fd_sc_hd__tapvpwrvgnd_1
XTAP_TAPCELL_ROW_100_2138 VSS VDD sky130_fd_sc_hd__tapvpwrvgnd_1
XTAP_TAPCELL_ROW_100_2139 VSS VDD sky130_fd_sc_hd__tapvpwrvgnd_1
XTAP_TAPCELL_ROW_100_2140 VSS VDD sky130_fd_sc_hd__tapvpwrvgnd_1
XTAP_TAPCELL_ROW_100_2141 VSS VDD sky130_fd_sc_hd__tapvpwrvgnd_1
XTAP_TAPCELL_ROW_101_2142 VSS VDD sky130_fd_sc_hd__tapvpwrvgnd_1
XTAP_TAPCELL_ROW_101_2143 VSS VDD sky130_fd_sc_hd__tapvpwrvgnd_1
XTAP_TAPCELL_ROW_101_2144 VSS VDD sky130_fd_sc_hd__tapvpwrvgnd_1
XTAP_TAPCELL_ROW_101_2145 VSS VDD sky130_fd_sc_hd__tapvpwrvgnd_1
XTAP_TAPCELL_ROW_101_2146 VSS VDD sky130_fd_sc_hd__tapvpwrvgnd_1
XTAP_TAPCELL_ROW_101_2147 VSS VDD sky130_fd_sc_hd__tapvpwrvgnd_1
XTAP_TAPCELL_ROW_101_2148 VSS VDD sky130_fd_sc_hd__tapvpwrvgnd_1
XTAP_TAPCELL_ROW_101_2149 VSS VDD sky130_fd_sc_hd__tapvpwrvgnd_1
XTAP_TAPCELL_ROW_101_2150 VSS VDD sky130_fd_sc_hd__tapvpwrvgnd_1
XTAP_TAPCELL_ROW_101_2151 VSS VDD sky130_fd_sc_hd__tapvpwrvgnd_1
XTAP_TAPCELL_ROW_101_2152 VSS VDD sky130_fd_sc_hd__tapvpwrvgnd_1
XTAP_TAPCELL_ROW_101_2153 VSS VDD sky130_fd_sc_hd__tapvpwrvgnd_1
XTAP_TAPCELL_ROW_101_2154 VSS VDD sky130_fd_sc_hd__tapvpwrvgnd_1
XTAP_TAPCELL_ROW_101_2155 VSS VDD sky130_fd_sc_hd__tapvpwrvgnd_1
XTAP_TAPCELL_ROW_101_2156 VSS VDD sky130_fd_sc_hd__tapvpwrvgnd_1
XTAP_TAPCELL_ROW_101_2157 VSS VDD sky130_fd_sc_hd__tapvpwrvgnd_1
XTAP_TAPCELL_ROW_101_2158 VSS VDD sky130_fd_sc_hd__tapvpwrvgnd_1
XTAP_TAPCELL_ROW_101_2159 VSS VDD sky130_fd_sc_hd__tapvpwrvgnd_1
XTAP_TAPCELL_ROW_101_2160 VSS VDD sky130_fd_sc_hd__tapvpwrvgnd_1
XTAP_TAPCELL_ROW_101_2161 VSS VDD sky130_fd_sc_hd__tapvpwrvgnd_1
XTAP_TAPCELL_ROW_101_2162 VSS VDD sky130_fd_sc_hd__tapvpwrvgnd_1
XTAP_TAPCELL_ROW_102_2163 VSS VDD sky130_fd_sc_hd__tapvpwrvgnd_1
XTAP_TAPCELL_ROW_102_2164 VSS VDD sky130_fd_sc_hd__tapvpwrvgnd_1
XTAP_TAPCELL_ROW_102_2165 VSS VDD sky130_fd_sc_hd__tapvpwrvgnd_1
XTAP_TAPCELL_ROW_102_2166 VSS VDD sky130_fd_sc_hd__tapvpwrvgnd_1
XTAP_TAPCELL_ROW_102_2167 VSS VDD sky130_fd_sc_hd__tapvpwrvgnd_1
XTAP_TAPCELL_ROW_102_2168 VSS VDD sky130_fd_sc_hd__tapvpwrvgnd_1
XTAP_TAPCELL_ROW_102_2169 VSS VDD sky130_fd_sc_hd__tapvpwrvgnd_1
XTAP_TAPCELL_ROW_102_2170 VSS VDD sky130_fd_sc_hd__tapvpwrvgnd_1
XTAP_TAPCELL_ROW_102_2171 VSS VDD sky130_fd_sc_hd__tapvpwrvgnd_1
XTAP_TAPCELL_ROW_102_2172 VSS VDD sky130_fd_sc_hd__tapvpwrvgnd_1
XTAP_TAPCELL_ROW_102_2173 VSS VDD sky130_fd_sc_hd__tapvpwrvgnd_1
XTAP_TAPCELL_ROW_102_2174 VSS VDD sky130_fd_sc_hd__tapvpwrvgnd_1
XTAP_TAPCELL_ROW_102_2175 VSS VDD sky130_fd_sc_hd__tapvpwrvgnd_1
XTAP_TAPCELL_ROW_102_2176 VSS VDD sky130_fd_sc_hd__tapvpwrvgnd_1
XTAP_TAPCELL_ROW_102_2177 VSS VDD sky130_fd_sc_hd__tapvpwrvgnd_1
XTAP_TAPCELL_ROW_102_2178 VSS VDD sky130_fd_sc_hd__tapvpwrvgnd_1
XTAP_TAPCELL_ROW_102_2179 VSS VDD sky130_fd_sc_hd__tapvpwrvgnd_1
XTAP_TAPCELL_ROW_102_2180 VSS VDD sky130_fd_sc_hd__tapvpwrvgnd_1
XTAP_TAPCELL_ROW_102_2181 VSS VDD sky130_fd_sc_hd__tapvpwrvgnd_1
XTAP_TAPCELL_ROW_102_2182 VSS VDD sky130_fd_sc_hd__tapvpwrvgnd_1
XTAP_TAPCELL_ROW_102_2183 VSS VDD sky130_fd_sc_hd__tapvpwrvgnd_1
XTAP_TAPCELL_ROW_103_2184 VSS VDD sky130_fd_sc_hd__tapvpwrvgnd_1
XTAP_TAPCELL_ROW_103_2185 VSS VDD sky130_fd_sc_hd__tapvpwrvgnd_1
XTAP_TAPCELL_ROW_103_2186 VSS VDD sky130_fd_sc_hd__tapvpwrvgnd_1
XTAP_TAPCELL_ROW_103_2187 VSS VDD sky130_fd_sc_hd__tapvpwrvgnd_1
XTAP_TAPCELL_ROW_103_2188 VSS VDD sky130_fd_sc_hd__tapvpwrvgnd_1
XTAP_TAPCELL_ROW_103_2189 VSS VDD sky130_fd_sc_hd__tapvpwrvgnd_1
XTAP_TAPCELL_ROW_103_2190 VSS VDD sky130_fd_sc_hd__tapvpwrvgnd_1
XTAP_TAPCELL_ROW_103_2191 VSS VDD sky130_fd_sc_hd__tapvpwrvgnd_1
XTAP_TAPCELL_ROW_103_2192 VSS VDD sky130_fd_sc_hd__tapvpwrvgnd_1
XTAP_TAPCELL_ROW_103_2193 VSS VDD sky130_fd_sc_hd__tapvpwrvgnd_1
XTAP_TAPCELL_ROW_103_2194 VSS VDD sky130_fd_sc_hd__tapvpwrvgnd_1
XTAP_TAPCELL_ROW_103_2195 VSS VDD sky130_fd_sc_hd__tapvpwrvgnd_1
XTAP_TAPCELL_ROW_103_2196 VSS VDD sky130_fd_sc_hd__tapvpwrvgnd_1
XTAP_TAPCELL_ROW_103_2197 VSS VDD sky130_fd_sc_hd__tapvpwrvgnd_1
XTAP_TAPCELL_ROW_103_2198 VSS VDD sky130_fd_sc_hd__tapvpwrvgnd_1
XTAP_TAPCELL_ROW_103_2199 VSS VDD sky130_fd_sc_hd__tapvpwrvgnd_1
XTAP_TAPCELL_ROW_103_2200 VSS VDD sky130_fd_sc_hd__tapvpwrvgnd_1
XTAP_TAPCELL_ROW_103_2201 VSS VDD sky130_fd_sc_hd__tapvpwrvgnd_1
XTAP_TAPCELL_ROW_103_2202 VSS VDD sky130_fd_sc_hd__tapvpwrvgnd_1
XTAP_TAPCELL_ROW_103_2203 VSS VDD sky130_fd_sc_hd__tapvpwrvgnd_1
XTAP_TAPCELL_ROW_103_2204 VSS VDD sky130_fd_sc_hd__tapvpwrvgnd_1
XTAP_TAPCELL_ROW_104_2205 VSS VDD sky130_fd_sc_hd__tapvpwrvgnd_1
XTAP_TAPCELL_ROW_104_2206 VSS VDD sky130_fd_sc_hd__tapvpwrvgnd_1
XTAP_TAPCELL_ROW_104_2207 VSS VDD sky130_fd_sc_hd__tapvpwrvgnd_1
XTAP_TAPCELL_ROW_104_2208 VSS VDD sky130_fd_sc_hd__tapvpwrvgnd_1
XTAP_TAPCELL_ROW_104_2209 VSS VDD sky130_fd_sc_hd__tapvpwrvgnd_1
XTAP_TAPCELL_ROW_104_2210 VSS VDD sky130_fd_sc_hd__tapvpwrvgnd_1
XTAP_TAPCELL_ROW_104_2211 VSS VDD sky130_fd_sc_hd__tapvpwrvgnd_1
XTAP_TAPCELL_ROW_104_2212 VSS VDD sky130_fd_sc_hd__tapvpwrvgnd_1
XTAP_TAPCELL_ROW_104_2213 VSS VDD sky130_fd_sc_hd__tapvpwrvgnd_1
XTAP_TAPCELL_ROW_104_2214 VSS VDD sky130_fd_sc_hd__tapvpwrvgnd_1
XTAP_TAPCELL_ROW_104_2215 VSS VDD sky130_fd_sc_hd__tapvpwrvgnd_1
XTAP_TAPCELL_ROW_104_2216 VSS VDD sky130_fd_sc_hd__tapvpwrvgnd_1
XTAP_TAPCELL_ROW_104_2217 VSS VDD sky130_fd_sc_hd__tapvpwrvgnd_1
XTAP_TAPCELL_ROW_104_2218 VSS VDD sky130_fd_sc_hd__tapvpwrvgnd_1
XTAP_TAPCELL_ROW_104_2219 VSS VDD sky130_fd_sc_hd__tapvpwrvgnd_1
XTAP_TAPCELL_ROW_104_2220 VSS VDD sky130_fd_sc_hd__tapvpwrvgnd_1
XTAP_TAPCELL_ROW_104_2221 VSS VDD sky130_fd_sc_hd__tapvpwrvgnd_1
XTAP_TAPCELL_ROW_104_2222 VSS VDD sky130_fd_sc_hd__tapvpwrvgnd_1
XTAP_TAPCELL_ROW_104_2223 VSS VDD sky130_fd_sc_hd__tapvpwrvgnd_1
XTAP_TAPCELL_ROW_104_2224 VSS VDD sky130_fd_sc_hd__tapvpwrvgnd_1
XTAP_TAPCELL_ROW_104_2225 VSS VDD sky130_fd_sc_hd__tapvpwrvgnd_1
XTAP_TAPCELL_ROW_105_2226 VSS VDD sky130_fd_sc_hd__tapvpwrvgnd_1
XTAP_TAPCELL_ROW_105_2227 VSS VDD sky130_fd_sc_hd__tapvpwrvgnd_1
XTAP_TAPCELL_ROW_105_2228 VSS VDD sky130_fd_sc_hd__tapvpwrvgnd_1
XTAP_TAPCELL_ROW_105_2229 VSS VDD sky130_fd_sc_hd__tapvpwrvgnd_1
XTAP_TAPCELL_ROW_105_2230 VSS VDD sky130_fd_sc_hd__tapvpwrvgnd_1
XTAP_TAPCELL_ROW_105_2231 VSS VDD sky130_fd_sc_hd__tapvpwrvgnd_1
XTAP_TAPCELL_ROW_105_2232 VSS VDD sky130_fd_sc_hd__tapvpwrvgnd_1
XTAP_TAPCELL_ROW_105_2233 VSS VDD sky130_fd_sc_hd__tapvpwrvgnd_1
XTAP_TAPCELL_ROW_105_2234 VSS VDD sky130_fd_sc_hd__tapvpwrvgnd_1
XTAP_TAPCELL_ROW_105_2235 VSS VDD sky130_fd_sc_hd__tapvpwrvgnd_1
XTAP_TAPCELL_ROW_105_2236 VSS VDD sky130_fd_sc_hd__tapvpwrvgnd_1
XTAP_TAPCELL_ROW_105_2237 VSS VDD sky130_fd_sc_hd__tapvpwrvgnd_1
XTAP_TAPCELL_ROW_105_2238 VSS VDD sky130_fd_sc_hd__tapvpwrvgnd_1
XTAP_TAPCELL_ROW_105_2239 VSS VDD sky130_fd_sc_hd__tapvpwrvgnd_1
XTAP_TAPCELL_ROW_105_2240 VSS VDD sky130_fd_sc_hd__tapvpwrvgnd_1
XTAP_TAPCELL_ROW_105_2241 VSS VDD sky130_fd_sc_hd__tapvpwrvgnd_1
XTAP_TAPCELL_ROW_105_2242 VSS VDD sky130_fd_sc_hd__tapvpwrvgnd_1
XTAP_TAPCELL_ROW_105_2243 VSS VDD sky130_fd_sc_hd__tapvpwrvgnd_1
XTAP_TAPCELL_ROW_105_2244 VSS VDD sky130_fd_sc_hd__tapvpwrvgnd_1
XTAP_TAPCELL_ROW_105_2245 VSS VDD sky130_fd_sc_hd__tapvpwrvgnd_1
XTAP_TAPCELL_ROW_105_2246 VSS VDD sky130_fd_sc_hd__tapvpwrvgnd_1
XTAP_TAPCELL_ROW_106_2247 VSS VDD sky130_fd_sc_hd__tapvpwrvgnd_1
XTAP_TAPCELL_ROW_106_2248 VSS VDD sky130_fd_sc_hd__tapvpwrvgnd_1
XTAP_TAPCELL_ROW_106_2249 VSS VDD sky130_fd_sc_hd__tapvpwrvgnd_1
XTAP_TAPCELL_ROW_106_2250 VSS VDD sky130_fd_sc_hd__tapvpwrvgnd_1
XTAP_TAPCELL_ROW_106_2251 VSS VDD sky130_fd_sc_hd__tapvpwrvgnd_1
XTAP_TAPCELL_ROW_106_2252 VSS VDD sky130_fd_sc_hd__tapvpwrvgnd_1
XTAP_TAPCELL_ROW_106_2253 VSS VDD sky130_fd_sc_hd__tapvpwrvgnd_1
XTAP_TAPCELL_ROW_106_2254 VSS VDD sky130_fd_sc_hd__tapvpwrvgnd_1
XTAP_TAPCELL_ROW_106_2255 VSS VDD sky130_fd_sc_hd__tapvpwrvgnd_1
XTAP_TAPCELL_ROW_106_2256 VSS VDD sky130_fd_sc_hd__tapvpwrvgnd_1
XTAP_TAPCELL_ROW_106_2257 VSS VDD sky130_fd_sc_hd__tapvpwrvgnd_1
XTAP_TAPCELL_ROW_106_2258 VSS VDD sky130_fd_sc_hd__tapvpwrvgnd_1
XTAP_TAPCELL_ROW_106_2259 VSS VDD sky130_fd_sc_hd__tapvpwrvgnd_1
XTAP_TAPCELL_ROW_106_2260 VSS VDD sky130_fd_sc_hd__tapvpwrvgnd_1
XTAP_TAPCELL_ROW_106_2261 VSS VDD sky130_fd_sc_hd__tapvpwrvgnd_1
XTAP_TAPCELL_ROW_106_2262 VSS VDD sky130_fd_sc_hd__tapvpwrvgnd_1
XTAP_TAPCELL_ROW_106_2263 VSS VDD sky130_fd_sc_hd__tapvpwrvgnd_1
XTAP_TAPCELL_ROW_106_2264 VSS VDD sky130_fd_sc_hd__tapvpwrvgnd_1
XTAP_TAPCELL_ROW_106_2265 VSS VDD sky130_fd_sc_hd__tapvpwrvgnd_1
XTAP_TAPCELL_ROW_106_2266 VSS VDD sky130_fd_sc_hd__tapvpwrvgnd_1
XTAP_TAPCELL_ROW_106_2267 VSS VDD sky130_fd_sc_hd__tapvpwrvgnd_1
XTAP_TAPCELL_ROW_107_2268 VSS VDD sky130_fd_sc_hd__tapvpwrvgnd_1
XTAP_TAPCELL_ROW_107_2269 VSS VDD sky130_fd_sc_hd__tapvpwrvgnd_1
XTAP_TAPCELL_ROW_107_2270 VSS VDD sky130_fd_sc_hd__tapvpwrvgnd_1
XTAP_TAPCELL_ROW_107_2271 VSS VDD sky130_fd_sc_hd__tapvpwrvgnd_1
XTAP_TAPCELL_ROW_107_2272 VSS VDD sky130_fd_sc_hd__tapvpwrvgnd_1
XTAP_TAPCELL_ROW_107_2273 VSS VDD sky130_fd_sc_hd__tapvpwrvgnd_1
XTAP_TAPCELL_ROW_107_2274 VSS VDD sky130_fd_sc_hd__tapvpwrvgnd_1
XTAP_TAPCELL_ROW_107_2275 VSS VDD sky130_fd_sc_hd__tapvpwrvgnd_1
XTAP_TAPCELL_ROW_107_2276 VSS VDD sky130_fd_sc_hd__tapvpwrvgnd_1
XTAP_TAPCELL_ROW_107_2277 VSS VDD sky130_fd_sc_hd__tapvpwrvgnd_1
XTAP_TAPCELL_ROW_107_2278 VSS VDD sky130_fd_sc_hd__tapvpwrvgnd_1
XTAP_TAPCELL_ROW_107_2279 VSS VDD sky130_fd_sc_hd__tapvpwrvgnd_1
XTAP_TAPCELL_ROW_107_2280 VSS VDD sky130_fd_sc_hd__tapvpwrvgnd_1
XTAP_TAPCELL_ROW_107_2281 VSS VDD sky130_fd_sc_hd__tapvpwrvgnd_1
XTAP_TAPCELL_ROW_107_2282 VSS VDD sky130_fd_sc_hd__tapvpwrvgnd_1
XTAP_TAPCELL_ROW_107_2283 VSS VDD sky130_fd_sc_hd__tapvpwrvgnd_1
XTAP_TAPCELL_ROW_107_2284 VSS VDD sky130_fd_sc_hd__tapvpwrvgnd_1
XTAP_TAPCELL_ROW_107_2285 VSS VDD sky130_fd_sc_hd__tapvpwrvgnd_1
XTAP_TAPCELL_ROW_107_2286 VSS VDD sky130_fd_sc_hd__tapvpwrvgnd_1
XTAP_TAPCELL_ROW_107_2287 VSS VDD sky130_fd_sc_hd__tapvpwrvgnd_1
XTAP_TAPCELL_ROW_107_2288 VSS VDD sky130_fd_sc_hd__tapvpwrvgnd_1
XTAP_TAPCELL_ROW_108_2289 VSS VDD sky130_fd_sc_hd__tapvpwrvgnd_1
XTAP_TAPCELL_ROW_108_2290 VSS VDD sky130_fd_sc_hd__tapvpwrvgnd_1
XTAP_TAPCELL_ROW_108_2291 VSS VDD sky130_fd_sc_hd__tapvpwrvgnd_1
XTAP_TAPCELL_ROW_108_2292 VSS VDD sky130_fd_sc_hd__tapvpwrvgnd_1
XTAP_TAPCELL_ROW_108_2293 VSS VDD sky130_fd_sc_hd__tapvpwrvgnd_1
XTAP_TAPCELL_ROW_108_2294 VSS VDD sky130_fd_sc_hd__tapvpwrvgnd_1
XTAP_TAPCELL_ROW_108_2295 VSS VDD sky130_fd_sc_hd__tapvpwrvgnd_1
XTAP_TAPCELL_ROW_108_2296 VSS VDD sky130_fd_sc_hd__tapvpwrvgnd_1
XTAP_TAPCELL_ROW_108_2297 VSS VDD sky130_fd_sc_hd__tapvpwrvgnd_1
XTAP_TAPCELL_ROW_108_2298 VSS VDD sky130_fd_sc_hd__tapvpwrvgnd_1
XTAP_TAPCELL_ROW_108_2299 VSS VDD sky130_fd_sc_hd__tapvpwrvgnd_1
XTAP_TAPCELL_ROW_108_2300 VSS VDD sky130_fd_sc_hd__tapvpwrvgnd_1
XTAP_TAPCELL_ROW_108_2301 VSS VDD sky130_fd_sc_hd__tapvpwrvgnd_1
XTAP_TAPCELL_ROW_108_2302 VSS VDD sky130_fd_sc_hd__tapvpwrvgnd_1
XTAP_TAPCELL_ROW_108_2303 VSS VDD sky130_fd_sc_hd__tapvpwrvgnd_1
XTAP_TAPCELL_ROW_108_2304 VSS VDD sky130_fd_sc_hd__tapvpwrvgnd_1
XTAP_TAPCELL_ROW_108_2305 VSS VDD sky130_fd_sc_hd__tapvpwrvgnd_1
XTAP_TAPCELL_ROW_108_2306 VSS VDD sky130_fd_sc_hd__tapvpwrvgnd_1
XTAP_TAPCELL_ROW_108_2307 VSS VDD sky130_fd_sc_hd__tapvpwrvgnd_1
XTAP_TAPCELL_ROW_108_2308 VSS VDD sky130_fd_sc_hd__tapvpwrvgnd_1
XTAP_TAPCELL_ROW_108_2309 VSS VDD sky130_fd_sc_hd__tapvpwrvgnd_1
XTAP_TAPCELL_ROW_109_2310 VSS VDD sky130_fd_sc_hd__tapvpwrvgnd_1
XTAP_TAPCELL_ROW_109_2311 VSS VDD sky130_fd_sc_hd__tapvpwrvgnd_1
XTAP_TAPCELL_ROW_109_2312 VSS VDD sky130_fd_sc_hd__tapvpwrvgnd_1
XTAP_TAPCELL_ROW_109_2313 VSS VDD sky130_fd_sc_hd__tapvpwrvgnd_1
XTAP_TAPCELL_ROW_109_2314 VSS VDD sky130_fd_sc_hd__tapvpwrvgnd_1
XTAP_TAPCELL_ROW_109_2315 VSS VDD sky130_fd_sc_hd__tapvpwrvgnd_1
XTAP_TAPCELL_ROW_109_2316 VSS VDD sky130_fd_sc_hd__tapvpwrvgnd_1
XTAP_TAPCELL_ROW_109_2317 VSS VDD sky130_fd_sc_hd__tapvpwrvgnd_1
XTAP_TAPCELL_ROW_109_2318 VSS VDD sky130_fd_sc_hd__tapvpwrvgnd_1
XTAP_TAPCELL_ROW_109_2319 VSS VDD sky130_fd_sc_hd__tapvpwrvgnd_1
XTAP_TAPCELL_ROW_109_2320 VSS VDD sky130_fd_sc_hd__tapvpwrvgnd_1
XTAP_TAPCELL_ROW_109_2321 VSS VDD sky130_fd_sc_hd__tapvpwrvgnd_1
XTAP_TAPCELL_ROW_109_2322 VSS VDD sky130_fd_sc_hd__tapvpwrvgnd_1
XTAP_TAPCELL_ROW_109_2323 VSS VDD sky130_fd_sc_hd__tapvpwrvgnd_1
XTAP_TAPCELL_ROW_109_2324 VSS VDD sky130_fd_sc_hd__tapvpwrvgnd_1
XTAP_TAPCELL_ROW_109_2325 VSS VDD sky130_fd_sc_hd__tapvpwrvgnd_1
XTAP_TAPCELL_ROW_109_2326 VSS VDD sky130_fd_sc_hd__tapvpwrvgnd_1
XTAP_TAPCELL_ROW_109_2327 VSS VDD sky130_fd_sc_hd__tapvpwrvgnd_1
XTAP_TAPCELL_ROW_109_2328 VSS VDD sky130_fd_sc_hd__tapvpwrvgnd_1
XTAP_TAPCELL_ROW_109_2329 VSS VDD sky130_fd_sc_hd__tapvpwrvgnd_1
XTAP_TAPCELL_ROW_109_2330 VSS VDD sky130_fd_sc_hd__tapvpwrvgnd_1
XTAP_TAPCELL_ROW_110_2331 VSS VDD sky130_fd_sc_hd__tapvpwrvgnd_1
XTAP_TAPCELL_ROW_110_2332 VSS VDD sky130_fd_sc_hd__tapvpwrvgnd_1
XTAP_TAPCELL_ROW_110_2333 VSS VDD sky130_fd_sc_hd__tapvpwrvgnd_1
XTAP_TAPCELL_ROW_110_2334 VSS VDD sky130_fd_sc_hd__tapvpwrvgnd_1
XTAP_TAPCELL_ROW_110_2335 VSS VDD sky130_fd_sc_hd__tapvpwrvgnd_1
XTAP_TAPCELL_ROW_110_2336 VSS VDD sky130_fd_sc_hd__tapvpwrvgnd_1
XTAP_TAPCELL_ROW_110_2337 VSS VDD sky130_fd_sc_hd__tapvpwrvgnd_1
XTAP_TAPCELL_ROW_110_2338 VSS VDD sky130_fd_sc_hd__tapvpwrvgnd_1
XTAP_TAPCELL_ROW_110_2339 VSS VDD sky130_fd_sc_hd__tapvpwrvgnd_1
XTAP_TAPCELL_ROW_110_2340 VSS VDD sky130_fd_sc_hd__tapvpwrvgnd_1
XTAP_TAPCELL_ROW_110_2341 VSS VDD sky130_fd_sc_hd__tapvpwrvgnd_1
XTAP_TAPCELL_ROW_110_2342 VSS VDD sky130_fd_sc_hd__tapvpwrvgnd_1
XTAP_TAPCELL_ROW_110_2343 VSS VDD sky130_fd_sc_hd__tapvpwrvgnd_1
XTAP_TAPCELL_ROW_110_2344 VSS VDD sky130_fd_sc_hd__tapvpwrvgnd_1
XTAP_TAPCELL_ROW_110_2345 VSS VDD sky130_fd_sc_hd__tapvpwrvgnd_1
XTAP_TAPCELL_ROW_110_2346 VSS VDD sky130_fd_sc_hd__tapvpwrvgnd_1
XTAP_TAPCELL_ROW_110_2347 VSS VDD sky130_fd_sc_hd__tapvpwrvgnd_1
XTAP_TAPCELL_ROW_110_2348 VSS VDD sky130_fd_sc_hd__tapvpwrvgnd_1
XTAP_TAPCELL_ROW_110_2349 VSS VDD sky130_fd_sc_hd__tapvpwrvgnd_1
XTAP_TAPCELL_ROW_110_2350 VSS VDD sky130_fd_sc_hd__tapvpwrvgnd_1
XTAP_TAPCELL_ROW_110_2351 VSS VDD sky130_fd_sc_hd__tapvpwrvgnd_1
XTAP_TAPCELL_ROW_111_2352 VSS VDD sky130_fd_sc_hd__tapvpwrvgnd_1
XTAP_TAPCELL_ROW_111_2353 VSS VDD sky130_fd_sc_hd__tapvpwrvgnd_1
XTAP_TAPCELL_ROW_111_2354 VSS VDD sky130_fd_sc_hd__tapvpwrvgnd_1
XTAP_TAPCELL_ROW_111_2355 VSS VDD sky130_fd_sc_hd__tapvpwrvgnd_1
XTAP_TAPCELL_ROW_111_2356 VSS VDD sky130_fd_sc_hd__tapvpwrvgnd_1
XTAP_TAPCELL_ROW_111_2357 VSS VDD sky130_fd_sc_hd__tapvpwrvgnd_1
XTAP_TAPCELL_ROW_111_2358 VSS VDD sky130_fd_sc_hd__tapvpwrvgnd_1
XTAP_TAPCELL_ROW_111_2359 VSS VDD sky130_fd_sc_hd__tapvpwrvgnd_1
XTAP_TAPCELL_ROW_111_2360 VSS VDD sky130_fd_sc_hd__tapvpwrvgnd_1
XTAP_TAPCELL_ROW_111_2361 VSS VDD sky130_fd_sc_hd__tapvpwrvgnd_1
XTAP_TAPCELL_ROW_111_2362 VSS VDD sky130_fd_sc_hd__tapvpwrvgnd_1
XTAP_TAPCELL_ROW_111_2363 VSS VDD sky130_fd_sc_hd__tapvpwrvgnd_1
XTAP_TAPCELL_ROW_111_2364 VSS VDD sky130_fd_sc_hd__tapvpwrvgnd_1
XTAP_TAPCELL_ROW_111_2365 VSS VDD sky130_fd_sc_hd__tapvpwrvgnd_1
XTAP_TAPCELL_ROW_111_2366 VSS VDD sky130_fd_sc_hd__tapvpwrvgnd_1
XTAP_TAPCELL_ROW_111_2367 VSS VDD sky130_fd_sc_hd__tapvpwrvgnd_1
XTAP_TAPCELL_ROW_111_2368 VSS VDD sky130_fd_sc_hd__tapvpwrvgnd_1
XTAP_TAPCELL_ROW_111_2369 VSS VDD sky130_fd_sc_hd__tapvpwrvgnd_1
XTAP_TAPCELL_ROW_111_2370 VSS VDD sky130_fd_sc_hd__tapvpwrvgnd_1
XTAP_TAPCELL_ROW_111_2371 VSS VDD sky130_fd_sc_hd__tapvpwrvgnd_1
XTAP_TAPCELL_ROW_111_2372 VSS VDD sky130_fd_sc_hd__tapvpwrvgnd_1
XTAP_TAPCELL_ROW_112_2373 VSS VDD sky130_fd_sc_hd__tapvpwrvgnd_1
XTAP_TAPCELL_ROW_112_2374 VSS VDD sky130_fd_sc_hd__tapvpwrvgnd_1
XTAP_TAPCELL_ROW_112_2375 VSS VDD sky130_fd_sc_hd__tapvpwrvgnd_1
XTAP_TAPCELL_ROW_112_2376 VSS VDD sky130_fd_sc_hd__tapvpwrvgnd_1
XTAP_TAPCELL_ROW_112_2377 VSS VDD sky130_fd_sc_hd__tapvpwrvgnd_1
XTAP_TAPCELL_ROW_112_2378 VSS VDD sky130_fd_sc_hd__tapvpwrvgnd_1
XTAP_TAPCELL_ROW_112_2379 VSS VDD sky130_fd_sc_hd__tapvpwrvgnd_1
XTAP_TAPCELL_ROW_112_2380 VSS VDD sky130_fd_sc_hd__tapvpwrvgnd_1
XTAP_TAPCELL_ROW_112_2381 VSS VDD sky130_fd_sc_hd__tapvpwrvgnd_1
XTAP_TAPCELL_ROW_112_2382 VSS VDD sky130_fd_sc_hd__tapvpwrvgnd_1
XTAP_TAPCELL_ROW_112_2383 VSS VDD sky130_fd_sc_hd__tapvpwrvgnd_1
XTAP_TAPCELL_ROW_112_2384 VSS VDD sky130_fd_sc_hd__tapvpwrvgnd_1
XTAP_TAPCELL_ROW_112_2385 VSS VDD sky130_fd_sc_hd__tapvpwrvgnd_1
XTAP_TAPCELL_ROW_112_2386 VSS VDD sky130_fd_sc_hd__tapvpwrvgnd_1
XTAP_TAPCELL_ROW_112_2387 VSS VDD sky130_fd_sc_hd__tapvpwrvgnd_1
XTAP_TAPCELL_ROW_112_2388 VSS VDD sky130_fd_sc_hd__tapvpwrvgnd_1
XTAP_TAPCELL_ROW_112_2389 VSS VDD sky130_fd_sc_hd__tapvpwrvgnd_1
XTAP_TAPCELL_ROW_112_2390 VSS VDD sky130_fd_sc_hd__tapvpwrvgnd_1
XTAP_TAPCELL_ROW_112_2391 VSS VDD sky130_fd_sc_hd__tapvpwrvgnd_1
XTAP_TAPCELL_ROW_112_2392 VSS VDD sky130_fd_sc_hd__tapvpwrvgnd_1
XTAP_TAPCELL_ROW_112_2393 VSS VDD sky130_fd_sc_hd__tapvpwrvgnd_1
XTAP_TAPCELL_ROW_113_2394 VSS VDD sky130_fd_sc_hd__tapvpwrvgnd_1
XTAP_TAPCELL_ROW_113_2395 VSS VDD sky130_fd_sc_hd__tapvpwrvgnd_1
XTAP_TAPCELL_ROW_113_2396 VSS VDD sky130_fd_sc_hd__tapvpwrvgnd_1
XTAP_TAPCELL_ROW_113_2397 VSS VDD sky130_fd_sc_hd__tapvpwrvgnd_1
XTAP_TAPCELL_ROW_113_2398 VSS VDD sky130_fd_sc_hd__tapvpwrvgnd_1
XTAP_TAPCELL_ROW_113_2399 VSS VDD sky130_fd_sc_hd__tapvpwrvgnd_1
XTAP_TAPCELL_ROW_113_2400 VSS VDD sky130_fd_sc_hd__tapvpwrvgnd_1
XTAP_TAPCELL_ROW_113_2401 VSS VDD sky130_fd_sc_hd__tapvpwrvgnd_1
XTAP_TAPCELL_ROW_113_2402 VSS VDD sky130_fd_sc_hd__tapvpwrvgnd_1
XTAP_TAPCELL_ROW_113_2403 VSS VDD sky130_fd_sc_hd__tapvpwrvgnd_1
XTAP_TAPCELL_ROW_113_2404 VSS VDD sky130_fd_sc_hd__tapvpwrvgnd_1
XTAP_TAPCELL_ROW_113_2405 VSS VDD sky130_fd_sc_hd__tapvpwrvgnd_1
XTAP_TAPCELL_ROW_113_2406 VSS VDD sky130_fd_sc_hd__tapvpwrvgnd_1
XTAP_TAPCELL_ROW_113_2407 VSS VDD sky130_fd_sc_hd__tapvpwrvgnd_1
XTAP_TAPCELL_ROW_113_2408 VSS VDD sky130_fd_sc_hd__tapvpwrvgnd_1
XTAP_TAPCELL_ROW_113_2409 VSS VDD sky130_fd_sc_hd__tapvpwrvgnd_1
XTAP_TAPCELL_ROW_113_2410 VSS VDD sky130_fd_sc_hd__tapvpwrvgnd_1
XTAP_TAPCELL_ROW_113_2411 VSS VDD sky130_fd_sc_hd__tapvpwrvgnd_1
XTAP_TAPCELL_ROW_113_2412 VSS VDD sky130_fd_sc_hd__tapvpwrvgnd_1
XTAP_TAPCELL_ROW_113_2413 VSS VDD sky130_fd_sc_hd__tapvpwrvgnd_1
XTAP_TAPCELL_ROW_113_2414 VSS VDD sky130_fd_sc_hd__tapvpwrvgnd_1
XTAP_TAPCELL_ROW_114_2415 VSS VDD sky130_fd_sc_hd__tapvpwrvgnd_1
XTAP_TAPCELL_ROW_114_2416 VSS VDD sky130_fd_sc_hd__tapvpwrvgnd_1
XTAP_TAPCELL_ROW_114_2417 VSS VDD sky130_fd_sc_hd__tapvpwrvgnd_1
XTAP_TAPCELL_ROW_114_2418 VSS VDD sky130_fd_sc_hd__tapvpwrvgnd_1
XTAP_TAPCELL_ROW_114_2419 VSS VDD sky130_fd_sc_hd__tapvpwrvgnd_1
XTAP_TAPCELL_ROW_114_2420 VSS VDD sky130_fd_sc_hd__tapvpwrvgnd_1
XTAP_TAPCELL_ROW_114_2421 VSS VDD sky130_fd_sc_hd__tapvpwrvgnd_1
XTAP_TAPCELL_ROW_114_2422 VSS VDD sky130_fd_sc_hd__tapvpwrvgnd_1
XTAP_TAPCELL_ROW_114_2423 VSS VDD sky130_fd_sc_hd__tapvpwrvgnd_1
XTAP_TAPCELL_ROW_114_2424 VSS VDD sky130_fd_sc_hd__tapvpwrvgnd_1
XTAP_TAPCELL_ROW_114_2425 VSS VDD sky130_fd_sc_hd__tapvpwrvgnd_1
XTAP_TAPCELL_ROW_114_2426 VSS VDD sky130_fd_sc_hd__tapvpwrvgnd_1
XTAP_TAPCELL_ROW_114_2427 VSS VDD sky130_fd_sc_hd__tapvpwrvgnd_1
XTAP_TAPCELL_ROW_114_2428 VSS VDD sky130_fd_sc_hd__tapvpwrvgnd_1
XTAP_TAPCELL_ROW_114_2429 VSS VDD sky130_fd_sc_hd__tapvpwrvgnd_1
XTAP_TAPCELL_ROW_114_2430 VSS VDD sky130_fd_sc_hd__tapvpwrvgnd_1
XTAP_TAPCELL_ROW_114_2431 VSS VDD sky130_fd_sc_hd__tapvpwrvgnd_1
XTAP_TAPCELL_ROW_114_2432 VSS VDD sky130_fd_sc_hd__tapvpwrvgnd_1
XTAP_TAPCELL_ROW_114_2433 VSS VDD sky130_fd_sc_hd__tapvpwrvgnd_1
XTAP_TAPCELL_ROW_114_2434 VSS VDD sky130_fd_sc_hd__tapvpwrvgnd_1
XTAP_TAPCELL_ROW_114_2435 VSS VDD sky130_fd_sc_hd__tapvpwrvgnd_1
XTAP_TAPCELL_ROW_115_2436 VSS VDD sky130_fd_sc_hd__tapvpwrvgnd_1
XTAP_TAPCELL_ROW_115_2437 VSS VDD sky130_fd_sc_hd__tapvpwrvgnd_1
XTAP_TAPCELL_ROW_115_2438 VSS VDD sky130_fd_sc_hd__tapvpwrvgnd_1
XTAP_TAPCELL_ROW_115_2439 VSS VDD sky130_fd_sc_hd__tapvpwrvgnd_1
XTAP_TAPCELL_ROW_115_2440 VSS VDD sky130_fd_sc_hd__tapvpwrvgnd_1
XTAP_TAPCELL_ROW_115_2441 VSS VDD sky130_fd_sc_hd__tapvpwrvgnd_1
XTAP_TAPCELL_ROW_115_2442 VSS VDD sky130_fd_sc_hd__tapvpwrvgnd_1
XTAP_TAPCELL_ROW_115_2443 VSS VDD sky130_fd_sc_hd__tapvpwrvgnd_1
XTAP_TAPCELL_ROW_115_2444 VSS VDD sky130_fd_sc_hd__tapvpwrvgnd_1
XTAP_TAPCELL_ROW_115_2445 VSS VDD sky130_fd_sc_hd__tapvpwrvgnd_1
XTAP_TAPCELL_ROW_115_2446 VSS VDD sky130_fd_sc_hd__tapvpwrvgnd_1
XTAP_TAPCELL_ROW_115_2447 VSS VDD sky130_fd_sc_hd__tapvpwrvgnd_1
XTAP_TAPCELL_ROW_115_2448 VSS VDD sky130_fd_sc_hd__tapvpwrvgnd_1
XTAP_TAPCELL_ROW_115_2449 VSS VDD sky130_fd_sc_hd__tapvpwrvgnd_1
XTAP_TAPCELL_ROW_115_2450 VSS VDD sky130_fd_sc_hd__tapvpwrvgnd_1
XTAP_TAPCELL_ROW_115_2451 VSS VDD sky130_fd_sc_hd__tapvpwrvgnd_1
XTAP_TAPCELL_ROW_115_2452 VSS VDD sky130_fd_sc_hd__tapvpwrvgnd_1
XTAP_TAPCELL_ROW_115_2453 VSS VDD sky130_fd_sc_hd__tapvpwrvgnd_1
XTAP_TAPCELL_ROW_115_2454 VSS VDD sky130_fd_sc_hd__tapvpwrvgnd_1
XTAP_TAPCELL_ROW_115_2455 VSS VDD sky130_fd_sc_hd__tapvpwrvgnd_1
XTAP_TAPCELL_ROW_115_2456 VSS VDD sky130_fd_sc_hd__tapvpwrvgnd_1
XTAP_TAPCELL_ROW_116_2457 VSS VDD sky130_fd_sc_hd__tapvpwrvgnd_1
XTAP_TAPCELL_ROW_116_2458 VSS VDD sky130_fd_sc_hd__tapvpwrvgnd_1
XTAP_TAPCELL_ROW_116_2459 VSS VDD sky130_fd_sc_hd__tapvpwrvgnd_1
XTAP_TAPCELL_ROW_116_2460 VSS VDD sky130_fd_sc_hd__tapvpwrvgnd_1
XTAP_TAPCELL_ROW_116_2461 VSS VDD sky130_fd_sc_hd__tapvpwrvgnd_1
XTAP_TAPCELL_ROW_116_2462 VSS VDD sky130_fd_sc_hd__tapvpwrvgnd_1
XTAP_TAPCELL_ROW_116_2463 VSS VDD sky130_fd_sc_hd__tapvpwrvgnd_1
XTAP_TAPCELL_ROW_116_2464 VSS VDD sky130_fd_sc_hd__tapvpwrvgnd_1
XTAP_TAPCELL_ROW_116_2465 VSS VDD sky130_fd_sc_hd__tapvpwrvgnd_1
XTAP_TAPCELL_ROW_116_2466 VSS VDD sky130_fd_sc_hd__tapvpwrvgnd_1
XTAP_TAPCELL_ROW_116_2467 VSS VDD sky130_fd_sc_hd__tapvpwrvgnd_1
XTAP_TAPCELL_ROW_116_2468 VSS VDD sky130_fd_sc_hd__tapvpwrvgnd_1
XTAP_TAPCELL_ROW_116_2469 VSS VDD sky130_fd_sc_hd__tapvpwrvgnd_1
XTAP_TAPCELL_ROW_116_2470 VSS VDD sky130_fd_sc_hd__tapvpwrvgnd_1
XTAP_TAPCELL_ROW_116_2471 VSS VDD sky130_fd_sc_hd__tapvpwrvgnd_1
XTAP_TAPCELL_ROW_116_2472 VSS VDD sky130_fd_sc_hd__tapvpwrvgnd_1
XTAP_TAPCELL_ROW_116_2473 VSS VDD sky130_fd_sc_hd__tapvpwrvgnd_1
XTAP_TAPCELL_ROW_116_2474 VSS VDD sky130_fd_sc_hd__tapvpwrvgnd_1
XTAP_TAPCELL_ROW_116_2475 VSS VDD sky130_fd_sc_hd__tapvpwrvgnd_1
XTAP_TAPCELL_ROW_116_2476 VSS VDD sky130_fd_sc_hd__tapvpwrvgnd_1
XTAP_TAPCELL_ROW_116_2477 VSS VDD sky130_fd_sc_hd__tapvpwrvgnd_1
XTAP_TAPCELL_ROW_117_2478 VSS VDD sky130_fd_sc_hd__tapvpwrvgnd_1
XTAP_TAPCELL_ROW_117_2479 VSS VDD sky130_fd_sc_hd__tapvpwrvgnd_1
XTAP_TAPCELL_ROW_117_2480 VSS VDD sky130_fd_sc_hd__tapvpwrvgnd_1
XTAP_TAPCELL_ROW_117_2481 VSS VDD sky130_fd_sc_hd__tapvpwrvgnd_1
XTAP_TAPCELL_ROW_117_2482 VSS VDD sky130_fd_sc_hd__tapvpwrvgnd_1
XTAP_TAPCELL_ROW_117_2483 VSS VDD sky130_fd_sc_hd__tapvpwrvgnd_1
XTAP_TAPCELL_ROW_117_2484 VSS VDD sky130_fd_sc_hd__tapvpwrvgnd_1
XTAP_TAPCELL_ROW_117_2485 VSS VDD sky130_fd_sc_hd__tapvpwrvgnd_1
XTAP_TAPCELL_ROW_117_2486 VSS VDD sky130_fd_sc_hd__tapvpwrvgnd_1
XTAP_TAPCELL_ROW_117_2487 VSS VDD sky130_fd_sc_hd__tapvpwrvgnd_1
XTAP_TAPCELL_ROW_117_2488 VSS VDD sky130_fd_sc_hd__tapvpwrvgnd_1
XTAP_TAPCELL_ROW_117_2489 VSS VDD sky130_fd_sc_hd__tapvpwrvgnd_1
XTAP_TAPCELL_ROW_117_2490 VSS VDD sky130_fd_sc_hd__tapvpwrvgnd_1
XTAP_TAPCELL_ROW_117_2491 VSS VDD sky130_fd_sc_hd__tapvpwrvgnd_1
XTAP_TAPCELL_ROW_117_2492 VSS VDD sky130_fd_sc_hd__tapvpwrvgnd_1
XTAP_TAPCELL_ROW_117_2493 VSS VDD sky130_fd_sc_hd__tapvpwrvgnd_1
XTAP_TAPCELL_ROW_117_2494 VSS VDD sky130_fd_sc_hd__tapvpwrvgnd_1
XTAP_TAPCELL_ROW_117_2495 VSS VDD sky130_fd_sc_hd__tapvpwrvgnd_1
XTAP_TAPCELL_ROW_117_2496 VSS VDD sky130_fd_sc_hd__tapvpwrvgnd_1
XTAP_TAPCELL_ROW_117_2497 VSS VDD sky130_fd_sc_hd__tapvpwrvgnd_1
XTAP_TAPCELL_ROW_117_2498 VSS VDD sky130_fd_sc_hd__tapvpwrvgnd_1
XTAP_TAPCELL_ROW_118_2499 VSS VDD sky130_fd_sc_hd__tapvpwrvgnd_1
XTAP_TAPCELL_ROW_118_2500 VSS VDD sky130_fd_sc_hd__tapvpwrvgnd_1
XTAP_TAPCELL_ROW_118_2501 VSS VDD sky130_fd_sc_hd__tapvpwrvgnd_1
XTAP_TAPCELL_ROW_118_2502 VSS VDD sky130_fd_sc_hd__tapvpwrvgnd_1
XTAP_TAPCELL_ROW_118_2503 VSS VDD sky130_fd_sc_hd__tapvpwrvgnd_1
XTAP_TAPCELL_ROW_118_2504 VSS VDD sky130_fd_sc_hd__tapvpwrvgnd_1
XTAP_TAPCELL_ROW_118_2505 VSS VDD sky130_fd_sc_hd__tapvpwrvgnd_1
XTAP_TAPCELL_ROW_118_2506 VSS VDD sky130_fd_sc_hd__tapvpwrvgnd_1
XTAP_TAPCELL_ROW_118_2507 VSS VDD sky130_fd_sc_hd__tapvpwrvgnd_1
XTAP_TAPCELL_ROW_118_2508 VSS VDD sky130_fd_sc_hd__tapvpwrvgnd_1
XTAP_TAPCELL_ROW_118_2509 VSS VDD sky130_fd_sc_hd__tapvpwrvgnd_1
XTAP_TAPCELL_ROW_118_2510 VSS VDD sky130_fd_sc_hd__tapvpwrvgnd_1
XTAP_TAPCELL_ROW_118_2511 VSS VDD sky130_fd_sc_hd__tapvpwrvgnd_1
XTAP_TAPCELL_ROW_118_2512 VSS VDD sky130_fd_sc_hd__tapvpwrvgnd_1
XTAP_TAPCELL_ROW_118_2513 VSS VDD sky130_fd_sc_hd__tapvpwrvgnd_1
XTAP_TAPCELL_ROW_118_2514 VSS VDD sky130_fd_sc_hd__tapvpwrvgnd_1
XTAP_TAPCELL_ROW_118_2515 VSS VDD sky130_fd_sc_hd__tapvpwrvgnd_1
XTAP_TAPCELL_ROW_118_2516 VSS VDD sky130_fd_sc_hd__tapvpwrvgnd_1
XTAP_TAPCELL_ROW_118_2517 VSS VDD sky130_fd_sc_hd__tapvpwrvgnd_1
XTAP_TAPCELL_ROW_118_2518 VSS VDD sky130_fd_sc_hd__tapvpwrvgnd_1
XTAP_TAPCELL_ROW_118_2519 VSS VDD sky130_fd_sc_hd__tapvpwrvgnd_1
XTAP_TAPCELL_ROW_119_2520 VSS VDD sky130_fd_sc_hd__tapvpwrvgnd_1
XTAP_TAPCELL_ROW_119_2521 VSS VDD sky130_fd_sc_hd__tapvpwrvgnd_1
XTAP_TAPCELL_ROW_119_2522 VSS VDD sky130_fd_sc_hd__tapvpwrvgnd_1
XTAP_TAPCELL_ROW_119_2523 VSS VDD sky130_fd_sc_hd__tapvpwrvgnd_1
XTAP_TAPCELL_ROW_119_2524 VSS VDD sky130_fd_sc_hd__tapvpwrvgnd_1
XTAP_TAPCELL_ROW_119_2525 VSS VDD sky130_fd_sc_hd__tapvpwrvgnd_1
XTAP_TAPCELL_ROW_119_2526 VSS VDD sky130_fd_sc_hd__tapvpwrvgnd_1
XTAP_TAPCELL_ROW_119_2527 VSS VDD sky130_fd_sc_hd__tapvpwrvgnd_1
XTAP_TAPCELL_ROW_119_2528 VSS VDD sky130_fd_sc_hd__tapvpwrvgnd_1
XTAP_TAPCELL_ROW_119_2529 VSS VDD sky130_fd_sc_hd__tapvpwrvgnd_1
XTAP_TAPCELL_ROW_119_2530 VSS VDD sky130_fd_sc_hd__tapvpwrvgnd_1
XTAP_TAPCELL_ROW_119_2531 VSS VDD sky130_fd_sc_hd__tapvpwrvgnd_1
XTAP_TAPCELL_ROW_119_2532 VSS VDD sky130_fd_sc_hd__tapvpwrvgnd_1
XTAP_TAPCELL_ROW_119_2533 VSS VDD sky130_fd_sc_hd__tapvpwrvgnd_1
XTAP_TAPCELL_ROW_119_2534 VSS VDD sky130_fd_sc_hd__tapvpwrvgnd_1
XTAP_TAPCELL_ROW_119_2535 VSS VDD sky130_fd_sc_hd__tapvpwrvgnd_1
XTAP_TAPCELL_ROW_119_2536 VSS VDD sky130_fd_sc_hd__tapvpwrvgnd_1
XTAP_TAPCELL_ROW_119_2537 VSS VDD sky130_fd_sc_hd__tapvpwrvgnd_1
XTAP_TAPCELL_ROW_119_2538 VSS VDD sky130_fd_sc_hd__tapvpwrvgnd_1
XTAP_TAPCELL_ROW_119_2539 VSS VDD sky130_fd_sc_hd__tapvpwrvgnd_1
XTAP_TAPCELL_ROW_119_2540 VSS VDD sky130_fd_sc_hd__tapvpwrvgnd_1
XTAP_TAPCELL_ROW_120_2541 VSS VDD sky130_fd_sc_hd__tapvpwrvgnd_1
XTAP_TAPCELL_ROW_120_2542 VSS VDD sky130_fd_sc_hd__tapvpwrvgnd_1
XTAP_TAPCELL_ROW_120_2543 VSS VDD sky130_fd_sc_hd__tapvpwrvgnd_1
XTAP_TAPCELL_ROW_120_2544 VSS VDD sky130_fd_sc_hd__tapvpwrvgnd_1
XTAP_TAPCELL_ROW_120_2545 VSS VDD sky130_fd_sc_hd__tapvpwrvgnd_1
XTAP_TAPCELL_ROW_120_2546 VSS VDD sky130_fd_sc_hd__tapvpwrvgnd_1
XTAP_TAPCELL_ROW_120_2547 VSS VDD sky130_fd_sc_hd__tapvpwrvgnd_1
XTAP_TAPCELL_ROW_120_2548 VSS VDD sky130_fd_sc_hd__tapvpwrvgnd_1
XTAP_TAPCELL_ROW_120_2549 VSS VDD sky130_fd_sc_hd__tapvpwrvgnd_1
XTAP_TAPCELL_ROW_120_2550 VSS VDD sky130_fd_sc_hd__tapvpwrvgnd_1
XTAP_TAPCELL_ROW_120_2551 VSS VDD sky130_fd_sc_hd__tapvpwrvgnd_1
XTAP_TAPCELL_ROW_120_2552 VSS VDD sky130_fd_sc_hd__tapvpwrvgnd_1
XTAP_TAPCELL_ROW_120_2553 VSS VDD sky130_fd_sc_hd__tapvpwrvgnd_1
XTAP_TAPCELL_ROW_120_2554 VSS VDD sky130_fd_sc_hd__tapvpwrvgnd_1
XTAP_TAPCELL_ROW_120_2555 VSS VDD sky130_fd_sc_hd__tapvpwrvgnd_1
XTAP_TAPCELL_ROW_120_2556 VSS VDD sky130_fd_sc_hd__tapvpwrvgnd_1
XTAP_TAPCELL_ROW_120_2557 VSS VDD sky130_fd_sc_hd__tapvpwrvgnd_1
XTAP_TAPCELL_ROW_120_2558 VSS VDD sky130_fd_sc_hd__tapvpwrvgnd_1
XTAP_TAPCELL_ROW_120_2559 VSS VDD sky130_fd_sc_hd__tapvpwrvgnd_1
XTAP_TAPCELL_ROW_120_2560 VSS VDD sky130_fd_sc_hd__tapvpwrvgnd_1
XTAP_TAPCELL_ROW_120_2561 VSS VDD sky130_fd_sc_hd__tapvpwrvgnd_1
XTAP_TAPCELL_ROW_121_2562 VSS VDD sky130_fd_sc_hd__tapvpwrvgnd_1
XTAP_TAPCELL_ROW_121_2563 VSS VDD sky130_fd_sc_hd__tapvpwrvgnd_1
XTAP_TAPCELL_ROW_121_2564 VSS VDD sky130_fd_sc_hd__tapvpwrvgnd_1
XTAP_TAPCELL_ROW_121_2565 VSS VDD sky130_fd_sc_hd__tapvpwrvgnd_1
XTAP_TAPCELL_ROW_121_2566 VSS VDD sky130_fd_sc_hd__tapvpwrvgnd_1
XTAP_TAPCELL_ROW_121_2567 VSS VDD sky130_fd_sc_hd__tapvpwrvgnd_1
XTAP_TAPCELL_ROW_121_2568 VSS VDD sky130_fd_sc_hd__tapvpwrvgnd_1
XTAP_TAPCELL_ROW_121_2569 VSS VDD sky130_fd_sc_hd__tapvpwrvgnd_1
XTAP_TAPCELL_ROW_121_2570 VSS VDD sky130_fd_sc_hd__tapvpwrvgnd_1
XTAP_TAPCELL_ROW_121_2571 VSS VDD sky130_fd_sc_hd__tapvpwrvgnd_1
XTAP_TAPCELL_ROW_121_2572 VSS VDD sky130_fd_sc_hd__tapvpwrvgnd_1
XTAP_TAPCELL_ROW_121_2573 VSS VDD sky130_fd_sc_hd__tapvpwrvgnd_1
XTAP_TAPCELL_ROW_121_2574 VSS VDD sky130_fd_sc_hd__tapvpwrvgnd_1
XTAP_TAPCELL_ROW_121_2575 VSS VDD sky130_fd_sc_hd__tapvpwrvgnd_1
XTAP_TAPCELL_ROW_121_2576 VSS VDD sky130_fd_sc_hd__tapvpwrvgnd_1
XTAP_TAPCELL_ROW_121_2577 VSS VDD sky130_fd_sc_hd__tapvpwrvgnd_1
XTAP_TAPCELL_ROW_121_2578 VSS VDD sky130_fd_sc_hd__tapvpwrvgnd_1
XTAP_TAPCELL_ROW_121_2579 VSS VDD sky130_fd_sc_hd__tapvpwrvgnd_1
XTAP_TAPCELL_ROW_121_2580 VSS VDD sky130_fd_sc_hd__tapvpwrvgnd_1
XTAP_TAPCELL_ROW_121_2581 VSS VDD sky130_fd_sc_hd__tapvpwrvgnd_1
XTAP_TAPCELL_ROW_121_2582 VSS VDD sky130_fd_sc_hd__tapvpwrvgnd_1
XTAP_TAPCELL_ROW_122_2583 VSS VDD sky130_fd_sc_hd__tapvpwrvgnd_1
XTAP_TAPCELL_ROW_122_2584 VSS VDD sky130_fd_sc_hd__tapvpwrvgnd_1
XTAP_TAPCELL_ROW_122_2585 VSS VDD sky130_fd_sc_hd__tapvpwrvgnd_1
XTAP_TAPCELL_ROW_122_2586 VSS VDD sky130_fd_sc_hd__tapvpwrvgnd_1
XTAP_TAPCELL_ROW_122_2587 VSS VDD sky130_fd_sc_hd__tapvpwrvgnd_1
XTAP_TAPCELL_ROW_122_2588 VSS VDD sky130_fd_sc_hd__tapvpwrvgnd_1
XTAP_TAPCELL_ROW_122_2589 VSS VDD sky130_fd_sc_hd__tapvpwrvgnd_1
XTAP_TAPCELL_ROW_122_2590 VSS VDD sky130_fd_sc_hd__tapvpwrvgnd_1
XTAP_TAPCELL_ROW_122_2591 VSS VDD sky130_fd_sc_hd__tapvpwrvgnd_1
XTAP_TAPCELL_ROW_122_2592 VSS VDD sky130_fd_sc_hd__tapvpwrvgnd_1
XTAP_TAPCELL_ROW_122_2593 VSS VDD sky130_fd_sc_hd__tapvpwrvgnd_1
XTAP_TAPCELL_ROW_122_2594 VSS VDD sky130_fd_sc_hd__tapvpwrvgnd_1
XTAP_TAPCELL_ROW_122_2595 VSS VDD sky130_fd_sc_hd__tapvpwrvgnd_1
XTAP_TAPCELL_ROW_122_2596 VSS VDD sky130_fd_sc_hd__tapvpwrvgnd_1
XTAP_TAPCELL_ROW_122_2597 VSS VDD sky130_fd_sc_hd__tapvpwrvgnd_1
XTAP_TAPCELL_ROW_122_2598 VSS VDD sky130_fd_sc_hd__tapvpwrvgnd_1
XTAP_TAPCELL_ROW_122_2599 VSS VDD sky130_fd_sc_hd__tapvpwrvgnd_1
XTAP_TAPCELL_ROW_122_2600 VSS VDD sky130_fd_sc_hd__tapvpwrvgnd_1
XTAP_TAPCELL_ROW_122_2601 VSS VDD sky130_fd_sc_hd__tapvpwrvgnd_1
XTAP_TAPCELL_ROW_122_2602 VSS VDD sky130_fd_sc_hd__tapvpwrvgnd_1
XTAP_TAPCELL_ROW_122_2603 VSS VDD sky130_fd_sc_hd__tapvpwrvgnd_1
XTAP_TAPCELL_ROW_123_2604 VSS VDD sky130_fd_sc_hd__tapvpwrvgnd_1
XTAP_TAPCELL_ROW_123_2605 VSS VDD sky130_fd_sc_hd__tapvpwrvgnd_1
XTAP_TAPCELL_ROW_123_2606 VSS VDD sky130_fd_sc_hd__tapvpwrvgnd_1
XTAP_TAPCELL_ROW_123_2607 VSS VDD sky130_fd_sc_hd__tapvpwrvgnd_1
XTAP_TAPCELL_ROW_123_2608 VSS VDD sky130_fd_sc_hd__tapvpwrvgnd_1
XTAP_TAPCELL_ROW_123_2609 VSS VDD sky130_fd_sc_hd__tapvpwrvgnd_1
XTAP_TAPCELL_ROW_123_2610 VSS VDD sky130_fd_sc_hd__tapvpwrvgnd_1
XTAP_TAPCELL_ROW_123_2611 VSS VDD sky130_fd_sc_hd__tapvpwrvgnd_1
XTAP_TAPCELL_ROW_123_2612 VSS VDD sky130_fd_sc_hd__tapvpwrvgnd_1
XTAP_TAPCELL_ROW_123_2613 VSS VDD sky130_fd_sc_hd__tapvpwrvgnd_1
XTAP_TAPCELL_ROW_123_2614 VSS VDD sky130_fd_sc_hd__tapvpwrvgnd_1
XTAP_TAPCELL_ROW_123_2615 VSS VDD sky130_fd_sc_hd__tapvpwrvgnd_1
XTAP_TAPCELL_ROW_123_2616 VSS VDD sky130_fd_sc_hd__tapvpwrvgnd_1
XTAP_TAPCELL_ROW_123_2617 VSS VDD sky130_fd_sc_hd__tapvpwrvgnd_1
XTAP_TAPCELL_ROW_123_2618 VSS VDD sky130_fd_sc_hd__tapvpwrvgnd_1
XTAP_TAPCELL_ROW_123_2619 VSS VDD sky130_fd_sc_hd__tapvpwrvgnd_1
XTAP_TAPCELL_ROW_123_2620 VSS VDD sky130_fd_sc_hd__tapvpwrvgnd_1
XTAP_TAPCELL_ROW_123_2621 VSS VDD sky130_fd_sc_hd__tapvpwrvgnd_1
XTAP_TAPCELL_ROW_123_2622 VSS VDD sky130_fd_sc_hd__tapvpwrvgnd_1
XTAP_TAPCELL_ROW_123_2623 VSS VDD sky130_fd_sc_hd__tapvpwrvgnd_1
XTAP_TAPCELL_ROW_123_2624 VSS VDD sky130_fd_sc_hd__tapvpwrvgnd_1
XTAP_TAPCELL_ROW_124_2625 VSS VDD sky130_fd_sc_hd__tapvpwrvgnd_1
XTAP_TAPCELL_ROW_124_2626 VSS VDD sky130_fd_sc_hd__tapvpwrvgnd_1
XTAP_TAPCELL_ROW_124_2627 VSS VDD sky130_fd_sc_hd__tapvpwrvgnd_1
XTAP_TAPCELL_ROW_124_2628 VSS VDD sky130_fd_sc_hd__tapvpwrvgnd_1
XTAP_TAPCELL_ROW_124_2629 VSS VDD sky130_fd_sc_hd__tapvpwrvgnd_1
XTAP_TAPCELL_ROW_124_2630 VSS VDD sky130_fd_sc_hd__tapvpwrvgnd_1
XTAP_TAPCELL_ROW_124_2631 VSS VDD sky130_fd_sc_hd__tapvpwrvgnd_1
XTAP_TAPCELL_ROW_124_2632 VSS VDD sky130_fd_sc_hd__tapvpwrvgnd_1
XTAP_TAPCELL_ROW_124_2633 VSS VDD sky130_fd_sc_hd__tapvpwrvgnd_1
XTAP_TAPCELL_ROW_124_2634 VSS VDD sky130_fd_sc_hd__tapvpwrvgnd_1
XTAP_TAPCELL_ROW_124_2635 VSS VDD sky130_fd_sc_hd__tapvpwrvgnd_1
XTAP_TAPCELL_ROW_124_2636 VSS VDD sky130_fd_sc_hd__tapvpwrvgnd_1
XTAP_TAPCELL_ROW_124_2637 VSS VDD sky130_fd_sc_hd__tapvpwrvgnd_1
XTAP_TAPCELL_ROW_124_2638 VSS VDD sky130_fd_sc_hd__tapvpwrvgnd_1
XTAP_TAPCELL_ROW_124_2639 VSS VDD sky130_fd_sc_hd__tapvpwrvgnd_1
XTAP_TAPCELL_ROW_124_2640 VSS VDD sky130_fd_sc_hd__tapvpwrvgnd_1
XTAP_TAPCELL_ROW_124_2641 VSS VDD sky130_fd_sc_hd__tapvpwrvgnd_1
XTAP_TAPCELL_ROW_124_2642 VSS VDD sky130_fd_sc_hd__tapvpwrvgnd_1
XTAP_TAPCELL_ROW_124_2643 VSS VDD sky130_fd_sc_hd__tapvpwrvgnd_1
XTAP_TAPCELL_ROW_124_2644 VSS VDD sky130_fd_sc_hd__tapvpwrvgnd_1
XTAP_TAPCELL_ROW_124_2645 VSS VDD sky130_fd_sc_hd__tapvpwrvgnd_1
XTAP_TAPCELL_ROW_125_2646 VSS VDD sky130_fd_sc_hd__tapvpwrvgnd_1
XTAP_TAPCELL_ROW_125_2647 VSS VDD sky130_fd_sc_hd__tapvpwrvgnd_1
XTAP_TAPCELL_ROW_125_2648 VSS VDD sky130_fd_sc_hd__tapvpwrvgnd_1
XTAP_TAPCELL_ROW_125_2649 VSS VDD sky130_fd_sc_hd__tapvpwrvgnd_1
XTAP_TAPCELL_ROW_125_2650 VSS VDD sky130_fd_sc_hd__tapvpwrvgnd_1
XTAP_TAPCELL_ROW_125_2651 VSS VDD sky130_fd_sc_hd__tapvpwrvgnd_1
XTAP_TAPCELL_ROW_125_2652 VSS VDD sky130_fd_sc_hd__tapvpwrvgnd_1
XTAP_TAPCELL_ROW_125_2653 VSS VDD sky130_fd_sc_hd__tapvpwrvgnd_1
XTAP_TAPCELL_ROW_125_2654 VSS VDD sky130_fd_sc_hd__tapvpwrvgnd_1
XTAP_TAPCELL_ROW_125_2655 VSS VDD sky130_fd_sc_hd__tapvpwrvgnd_1
XTAP_TAPCELL_ROW_125_2656 VSS VDD sky130_fd_sc_hd__tapvpwrvgnd_1
XTAP_TAPCELL_ROW_125_2657 VSS VDD sky130_fd_sc_hd__tapvpwrvgnd_1
XTAP_TAPCELL_ROW_125_2658 VSS VDD sky130_fd_sc_hd__tapvpwrvgnd_1
XTAP_TAPCELL_ROW_125_2659 VSS VDD sky130_fd_sc_hd__tapvpwrvgnd_1
XTAP_TAPCELL_ROW_125_2660 VSS VDD sky130_fd_sc_hd__tapvpwrvgnd_1
XTAP_TAPCELL_ROW_125_2661 VSS VDD sky130_fd_sc_hd__tapvpwrvgnd_1
XTAP_TAPCELL_ROW_125_2662 VSS VDD sky130_fd_sc_hd__tapvpwrvgnd_1
XTAP_TAPCELL_ROW_125_2663 VSS VDD sky130_fd_sc_hd__tapvpwrvgnd_1
XTAP_TAPCELL_ROW_125_2664 VSS VDD sky130_fd_sc_hd__tapvpwrvgnd_1
XTAP_TAPCELL_ROW_125_2665 VSS VDD sky130_fd_sc_hd__tapvpwrvgnd_1
XTAP_TAPCELL_ROW_125_2666 VSS VDD sky130_fd_sc_hd__tapvpwrvgnd_1
XTAP_TAPCELL_ROW_126_2667 VSS VDD sky130_fd_sc_hd__tapvpwrvgnd_1
XTAP_TAPCELL_ROW_126_2668 VSS VDD sky130_fd_sc_hd__tapvpwrvgnd_1
XTAP_TAPCELL_ROW_126_2669 VSS VDD sky130_fd_sc_hd__tapvpwrvgnd_1
XTAP_TAPCELL_ROW_126_2670 VSS VDD sky130_fd_sc_hd__tapvpwrvgnd_1
XTAP_TAPCELL_ROW_126_2671 VSS VDD sky130_fd_sc_hd__tapvpwrvgnd_1
XTAP_TAPCELL_ROW_126_2672 VSS VDD sky130_fd_sc_hd__tapvpwrvgnd_1
XTAP_TAPCELL_ROW_126_2673 VSS VDD sky130_fd_sc_hd__tapvpwrvgnd_1
XTAP_TAPCELL_ROW_126_2674 VSS VDD sky130_fd_sc_hd__tapvpwrvgnd_1
XTAP_TAPCELL_ROW_126_2675 VSS VDD sky130_fd_sc_hd__tapvpwrvgnd_1
XTAP_TAPCELL_ROW_126_2676 VSS VDD sky130_fd_sc_hd__tapvpwrvgnd_1
XTAP_TAPCELL_ROW_126_2677 VSS VDD sky130_fd_sc_hd__tapvpwrvgnd_1
XTAP_TAPCELL_ROW_126_2678 VSS VDD sky130_fd_sc_hd__tapvpwrvgnd_1
XTAP_TAPCELL_ROW_126_2679 VSS VDD sky130_fd_sc_hd__tapvpwrvgnd_1
XTAP_TAPCELL_ROW_126_2680 VSS VDD sky130_fd_sc_hd__tapvpwrvgnd_1
XTAP_TAPCELL_ROW_126_2681 VSS VDD sky130_fd_sc_hd__tapvpwrvgnd_1
XTAP_TAPCELL_ROW_126_2682 VSS VDD sky130_fd_sc_hd__tapvpwrvgnd_1
XTAP_TAPCELL_ROW_126_2683 VSS VDD sky130_fd_sc_hd__tapvpwrvgnd_1
XTAP_TAPCELL_ROW_126_2684 VSS VDD sky130_fd_sc_hd__tapvpwrvgnd_1
XTAP_TAPCELL_ROW_126_2685 VSS VDD sky130_fd_sc_hd__tapvpwrvgnd_1
XTAP_TAPCELL_ROW_126_2686 VSS VDD sky130_fd_sc_hd__tapvpwrvgnd_1
XTAP_TAPCELL_ROW_126_2687 VSS VDD sky130_fd_sc_hd__tapvpwrvgnd_1
XTAP_TAPCELL_ROW_127_2688 VSS VDD sky130_fd_sc_hd__tapvpwrvgnd_1
XTAP_TAPCELL_ROW_127_2689 VSS VDD sky130_fd_sc_hd__tapvpwrvgnd_1
XTAP_TAPCELL_ROW_127_2690 VSS VDD sky130_fd_sc_hd__tapvpwrvgnd_1
XTAP_TAPCELL_ROW_127_2691 VSS VDD sky130_fd_sc_hd__tapvpwrvgnd_1
XTAP_TAPCELL_ROW_127_2692 VSS VDD sky130_fd_sc_hd__tapvpwrvgnd_1
XTAP_TAPCELL_ROW_127_2693 VSS VDD sky130_fd_sc_hd__tapvpwrvgnd_1
XTAP_TAPCELL_ROW_127_2694 VSS VDD sky130_fd_sc_hd__tapvpwrvgnd_1
XTAP_TAPCELL_ROW_127_2695 VSS VDD sky130_fd_sc_hd__tapvpwrvgnd_1
XTAP_TAPCELL_ROW_127_2696 VSS VDD sky130_fd_sc_hd__tapvpwrvgnd_1
XTAP_TAPCELL_ROW_127_2697 VSS VDD sky130_fd_sc_hd__tapvpwrvgnd_1
XTAP_TAPCELL_ROW_127_2698 VSS VDD sky130_fd_sc_hd__tapvpwrvgnd_1
XTAP_TAPCELL_ROW_127_2699 VSS VDD sky130_fd_sc_hd__tapvpwrvgnd_1
XTAP_TAPCELL_ROW_127_2700 VSS VDD sky130_fd_sc_hd__tapvpwrvgnd_1
XTAP_TAPCELL_ROW_127_2701 VSS VDD sky130_fd_sc_hd__tapvpwrvgnd_1
XTAP_TAPCELL_ROW_127_2702 VSS VDD sky130_fd_sc_hd__tapvpwrvgnd_1
XTAP_TAPCELL_ROW_127_2703 VSS VDD sky130_fd_sc_hd__tapvpwrvgnd_1
XTAP_TAPCELL_ROW_127_2704 VSS VDD sky130_fd_sc_hd__tapvpwrvgnd_1
XTAP_TAPCELL_ROW_127_2705 VSS VDD sky130_fd_sc_hd__tapvpwrvgnd_1
XTAP_TAPCELL_ROW_127_2706 VSS VDD sky130_fd_sc_hd__tapvpwrvgnd_1
XTAP_TAPCELL_ROW_127_2707 VSS VDD sky130_fd_sc_hd__tapvpwrvgnd_1
XTAP_TAPCELL_ROW_127_2708 VSS VDD sky130_fd_sc_hd__tapvpwrvgnd_1
XTAP_TAPCELL_ROW_128_2709 VSS VDD sky130_fd_sc_hd__tapvpwrvgnd_1
XTAP_TAPCELL_ROW_128_2710 VSS VDD sky130_fd_sc_hd__tapvpwrvgnd_1
XTAP_TAPCELL_ROW_128_2711 VSS VDD sky130_fd_sc_hd__tapvpwrvgnd_1
XTAP_TAPCELL_ROW_128_2712 VSS VDD sky130_fd_sc_hd__tapvpwrvgnd_1
XTAP_TAPCELL_ROW_128_2713 VSS VDD sky130_fd_sc_hd__tapvpwrvgnd_1
XTAP_TAPCELL_ROW_128_2714 VSS VDD sky130_fd_sc_hd__tapvpwrvgnd_1
XTAP_TAPCELL_ROW_128_2715 VSS VDD sky130_fd_sc_hd__tapvpwrvgnd_1
XTAP_TAPCELL_ROW_128_2716 VSS VDD sky130_fd_sc_hd__tapvpwrvgnd_1
XTAP_TAPCELL_ROW_128_2717 VSS VDD sky130_fd_sc_hd__tapvpwrvgnd_1
XTAP_TAPCELL_ROW_128_2718 VSS VDD sky130_fd_sc_hd__tapvpwrvgnd_1
XTAP_TAPCELL_ROW_128_2719 VSS VDD sky130_fd_sc_hd__tapvpwrvgnd_1
XTAP_TAPCELL_ROW_128_2720 VSS VDD sky130_fd_sc_hd__tapvpwrvgnd_1
XTAP_TAPCELL_ROW_128_2721 VSS VDD sky130_fd_sc_hd__tapvpwrvgnd_1
XTAP_TAPCELL_ROW_128_2722 VSS VDD sky130_fd_sc_hd__tapvpwrvgnd_1
XTAP_TAPCELL_ROW_128_2723 VSS VDD sky130_fd_sc_hd__tapvpwrvgnd_1
XTAP_TAPCELL_ROW_128_2724 VSS VDD sky130_fd_sc_hd__tapvpwrvgnd_1
XTAP_TAPCELL_ROW_128_2725 VSS VDD sky130_fd_sc_hd__tapvpwrvgnd_1
XTAP_TAPCELL_ROW_128_2726 VSS VDD sky130_fd_sc_hd__tapvpwrvgnd_1
XTAP_TAPCELL_ROW_128_2727 VSS VDD sky130_fd_sc_hd__tapvpwrvgnd_1
XTAP_TAPCELL_ROW_128_2728 VSS VDD sky130_fd_sc_hd__tapvpwrvgnd_1
XTAP_TAPCELL_ROW_128_2729 VSS VDD sky130_fd_sc_hd__tapvpwrvgnd_1
XTAP_TAPCELL_ROW_129_2730 VSS VDD sky130_fd_sc_hd__tapvpwrvgnd_1
XTAP_TAPCELL_ROW_129_2731 VSS VDD sky130_fd_sc_hd__tapvpwrvgnd_1
XTAP_TAPCELL_ROW_129_2732 VSS VDD sky130_fd_sc_hd__tapvpwrvgnd_1
XTAP_TAPCELL_ROW_129_2733 VSS VDD sky130_fd_sc_hd__tapvpwrvgnd_1
XTAP_TAPCELL_ROW_129_2734 VSS VDD sky130_fd_sc_hd__tapvpwrvgnd_1
XTAP_TAPCELL_ROW_129_2735 VSS VDD sky130_fd_sc_hd__tapvpwrvgnd_1
XTAP_TAPCELL_ROW_129_2736 VSS VDD sky130_fd_sc_hd__tapvpwrvgnd_1
XTAP_TAPCELL_ROW_129_2737 VSS VDD sky130_fd_sc_hd__tapvpwrvgnd_1
XTAP_TAPCELL_ROW_129_2738 VSS VDD sky130_fd_sc_hd__tapvpwrvgnd_1
XTAP_TAPCELL_ROW_129_2739 VSS VDD sky130_fd_sc_hd__tapvpwrvgnd_1
XTAP_TAPCELL_ROW_129_2740 VSS VDD sky130_fd_sc_hd__tapvpwrvgnd_1
XTAP_TAPCELL_ROW_129_2741 VSS VDD sky130_fd_sc_hd__tapvpwrvgnd_1
XTAP_TAPCELL_ROW_129_2742 VSS VDD sky130_fd_sc_hd__tapvpwrvgnd_1
XTAP_TAPCELL_ROW_129_2743 VSS VDD sky130_fd_sc_hd__tapvpwrvgnd_1
XTAP_TAPCELL_ROW_129_2744 VSS VDD sky130_fd_sc_hd__tapvpwrvgnd_1
XTAP_TAPCELL_ROW_129_2745 VSS VDD sky130_fd_sc_hd__tapvpwrvgnd_1
XTAP_TAPCELL_ROW_129_2746 VSS VDD sky130_fd_sc_hd__tapvpwrvgnd_1
XTAP_TAPCELL_ROW_129_2747 VSS VDD sky130_fd_sc_hd__tapvpwrvgnd_1
XTAP_TAPCELL_ROW_129_2748 VSS VDD sky130_fd_sc_hd__tapvpwrvgnd_1
XTAP_TAPCELL_ROW_129_2749 VSS VDD sky130_fd_sc_hd__tapvpwrvgnd_1
XTAP_TAPCELL_ROW_129_2750 VSS VDD sky130_fd_sc_hd__tapvpwrvgnd_1
XTAP_TAPCELL_ROW_130_2751 VSS VDD sky130_fd_sc_hd__tapvpwrvgnd_1
XTAP_TAPCELL_ROW_130_2752 VSS VDD sky130_fd_sc_hd__tapvpwrvgnd_1
XTAP_TAPCELL_ROW_130_2753 VSS VDD sky130_fd_sc_hd__tapvpwrvgnd_1
XTAP_TAPCELL_ROW_130_2754 VSS VDD sky130_fd_sc_hd__tapvpwrvgnd_1
XTAP_TAPCELL_ROW_130_2755 VSS VDD sky130_fd_sc_hd__tapvpwrvgnd_1
XTAP_TAPCELL_ROW_130_2756 VSS VDD sky130_fd_sc_hd__tapvpwrvgnd_1
XTAP_TAPCELL_ROW_130_2757 VSS VDD sky130_fd_sc_hd__tapvpwrvgnd_1
XTAP_TAPCELL_ROW_130_2758 VSS VDD sky130_fd_sc_hd__tapvpwrvgnd_1
XTAP_TAPCELL_ROW_130_2759 VSS VDD sky130_fd_sc_hd__tapvpwrvgnd_1
XTAP_TAPCELL_ROW_130_2760 VSS VDD sky130_fd_sc_hd__tapvpwrvgnd_1
XTAP_TAPCELL_ROW_130_2761 VSS VDD sky130_fd_sc_hd__tapvpwrvgnd_1
XTAP_TAPCELL_ROW_130_2762 VSS VDD sky130_fd_sc_hd__tapvpwrvgnd_1
XTAP_TAPCELL_ROW_130_2763 VSS VDD sky130_fd_sc_hd__tapvpwrvgnd_1
XTAP_TAPCELL_ROW_130_2764 VSS VDD sky130_fd_sc_hd__tapvpwrvgnd_1
XTAP_TAPCELL_ROW_130_2765 VSS VDD sky130_fd_sc_hd__tapvpwrvgnd_1
XTAP_TAPCELL_ROW_130_2766 VSS VDD sky130_fd_sc_hd__tapvpwrvgnd_1
XTAP_TAPCELL_ROW_130_2767 VSS VDD sky130_fd_sc_hd__tapvpwrvgnd_1
XTAP_TAPCELL_ROW_130_2768 VSS VDD sky130_fd_sc_hd__tapvpwrvgnd_1
XTAP_TAPCELL_ROW_130_2769 VSS VDD sky130_fd_sc_hd__tapvpwrvgnd_1
XTAP_TAPCELL_ROW_130_2770 VSS VDD sky130_fd_sc_hd__tapvpwrvgnd_1
XTAP_TAPCELL_ROW_130_2771 VSS VDD sky130_fd_sc_hd__tapvpwrvgnd_1
XTAP_TAPCELL_ROW_131_2772 VSS VDD sky130_fd_sc_hd__tapvpwrvgnd_1
XTAP_TAPCELL_ROW_131_2773 VSS VDD sky130_fd_sc_hd__tapvpwrvgnd_1
XTAP_TAPCELL_ROW_131_2774 VSS VDD sky130_fd_sc_hd__tapvpwrvgnd_1
XTAP_TAPCELL_ROW_131_2775 VSS VDD sky130_fd_sc_hd__tapvpwrvgnd_1
XTAP_TAPCELL_ROW_131_2776 VSS VDD sky130_fd_sc_hd__tapvpwrvgnd_1
XTAP_TAPCELL_ROW_131_2777 VSS VDD sky130_fd_sc_hd__tapvpwrvgnd_1
XTAP_TAPCELL_ROW_131_2778 VSS VDD sky130_fd_sc_hd__tapvpwrvgnd_1
XTAP_TAPCELL_ROW_131_2779 VSS VDD sky130_fd_sc_hd__tapvpwrvgnd_1
XTAP_TAPCELL_ROW_131_2780 VSS VDD sky130_fd_sc_hd__tapvpwrvgnd_1
XTAP_TAPCELL_ROW_131_2781 VSS VDD sky130_fd_sc_hd__tapvpwrvgnd_1
XTAP_TAPCELL_ROW_131_2782 VSS VDD sky130_fd_sc_hd__tapvpwrvgnd_1
XTAP_TAPCELL_ROW_131_2783 VSS VDD sky130_fd_sc_hd__tapvpwrvgnd_1
XTAP_TAPCELL_ROW_131_2784 VSS VDD sky130_fd_sc_hd__tapvpwrvgnd_1
XTAP_TAPCELL_ROW_131_2785 VSS VDD sky130_fd_sc_hd__tapvpwrvgnd_1
XTAP_TAPCELL_ROW_131_2786 VSS VDD sky130_fd_sc_hd__tapvpwrvgnd_1
XTAP_TAPCELL_ROW_131_2787 VSS VDD sky130_fd_sc_hd__tapvpwrvgnd_1
XTAP_TAPCELL_ROW_131_2788 VSS VDD sky130_fd_sc_hd__tapvpwrvgnd_1
XTAP_TAPCELL_ROW_131_2789 VSS VDD sky130_fd_sc_hd__tapvpwrvgnd_1
XTAP_TAPCELL_ROW_131_2790 VSS VDD sky130_fd_sc_hd__tapvpwrvgnd_1
XTAP_TAPCELL_ROW_131_2791 VSS VDD sky130_fd_sc_hd__tapvpwrvgnd_1
XTAP_TAPCELL_ROW_131_2792 VSS VDD sky130_fd_sc_hd__tapvpwrvgnd_1
XTAP_TAPCELL_ROW_132_2793 VSS VDD sky130_fd_sc_hd__tapvpwrvgnd_1
XTAP_TAPCELL_ROW_132_2794 VSS VDD sky130_fd_sc_hd__tapvpwrvgnd_1
XTAP_TAPCELL_ROW_132_2795 VSS VDD sky130_fd_sc_hd__tapvpwrvgnd_1
XTAP_TAPCELL_ROW_132_2796 VSS VDD sky130_fd_sc_hd__tapvpwrvgnd_1
XTAP_TAPCELL_ROW_132_2797 VSS VDD sky130_fd_sc_hd__tapvpwrvgnd_1
XTAP_TAPCELL_ROW_132_2798 VSS VDD sky130_fd_sc_hd__tapvpwrvgnd_1
XTAP_TAPCELL_ROW_132_2799 VSS VDD sky130_fd_sc_hd__tapvpwrvgnd_1
XTAP_TAPCELL_ROW_132_2800 VSS VDD sky130_fd_sc_hd__tapvpwrvgnd_1
XTAP_TAPCELL_ROW_132_2801 VSS VDD sky130_fd_sc_hd__tapvpwrvgnd_1
XTAP_TAPCELL_ROW_132_2802 VSS VDD sky130_fd_sc_hd__tapvpwrvgnd_1
XTAP_TAPCELL_ROW_132_2803 VSS VDD sky130_fd_sc_hd__tapvpwrvgnd_1
XTAP_TAPCELL_ROW_132_2804 VSS VDD sky130_fd_sc_hd__tapvpwrvgnd_1
XTAP_TAPCELL_ROW_132_2805 VSS VDD sky130_fd_sc_hd__tapvpwrvgnd_1
XTAP_TAPCELL_ROW_132_2806 VSS VDD sky130_fd_sc_hd__tapvpwrvgnd_1
XTAP_TAPCELL_ROW_132_2807 VSS VDD sky130_fd_sc_hd__tapvpwrvgnd_1
XTAP_TAPCELL_ROW_132_2808 VSS VDD sky130_fd_sc_hd__tapvpwrvgnd_1
XTAP_TAPCELL_ROW_132_2809 VSS VDD sky130_fd_sc_hd__tapvpwrvgnd_1
XTAP_TAPCELL_ROW_132_2810 VSS VDD sky130_fd_sc_hd__tapvpwrvgnd_1
XTAP_TAPCELL_ROW_132_2811 VSS VDD sky130_fd_sc_hd__tapvpwrvgnd_1
XTAP_TAPCELL_ROW_132_2812 VSS VDD sky130_fd_sc_hd__tapvpwrvgnd_1
XTAP_TAPCELL_ROW_132_2813 VSS VDD sky130_fd_sc_hd__tapvpwrvgnd_1
XTAP_TAPCELL_ROW_133_2814 VSS VDD sky130_fd_sc_hd__tapvpwrvgnd_1
XTAP_TAPCELL_ROW_133_2815 VSS VDD sky130_fd_sc_hd__tapvpwrvgnd_1
XTAP_TAPCELL_ROW_133_2816 VSS VDD sky130_fd_sc_hd__tapvpwrvgnd_1
XTAP_TAPCELL_ROW_133_2817 VSS VDD sky130_fd_sc_hd__tapvpwrvgnd_1
XTAP_TAPCELL_ROW_133_2818 VSS VDD sky130_fd_sc_hd__tapvpwrvgnd_1
XTAP_TAPCELL_ROW_133_2819 VSS VDD sky130_fd_sc_hd__tapvpwrvgnd_1
XTAP_TAPCELL_ROW_133_2820 VSS VDD sky130_fd_sc_hd__tapvpwrvgnd_1
XTAP_TAPCELL_ROW_133_2821 VSS VDD sky130_fd_sc_hd__tapvpwrvgnd_1
XTAP_TAPCELL_ROW_133_2822 VSS VDD sky130_fd_sc_hd__tapvpwrvgnd_1
XTAP_TAPCELL_ROW_133_2823 VSS VDD sky130_fd_sc_hd__tapvpwrvgnd_1
XTAP_TAPCELL_ROW_133_2824 VSS VDD sky130_fd_sc_hd__tapvpwrvgnd_1
XTAP_TAPCELL_ROW_133_2825 VSS VDD sky130_fd_sc_hd__tapvpwrvgnd_1
XTAP_TAPCELL_ROW_133_2826 VSS VDD sky130_fd_sc_hd__tapvpwrvgnd_1
XTAP_TAPCELL_ROW_133_2827 VSS VDD sky130_fd_sc_hd__tapvpwrvgnd_1
XTAP_TAPCELL_ROW_133_2828 VSS VDD sky130_fd_sc_hd__tapvpwrvgnd_1
XTAP_TAPCELL_ROW_133_2829 VSS VDD sky130_fd_sc_hd__tapvpwrvgnd_1
XTAP_TAPCELL_ROW_133_2830 VSS VDD sky130_fd_sc_hd__tapvpwrvgnd_1
XTAP_TAPCELL_ROW_133_2831 VSS VDD sky130_fd_sc_hd__tapvpwrvgnd_1
XTAP_TAPCELL_ROW_133_2832 VSS VDD sky130_fd_sc_hd__tapvpwrvgnd_1
XTAP_TAPCELL_ROW_133_2833 VSS VDD sky130_fd_sc_hd__tapvpwrvgnd_1
XTAP_TAPCELL_ROW_133_2834 VSS VDD sky130_fd_sc_hd__tapvpwrvgnd_1
XTAP_TAPCELL_ROW_134_2835 VSS VDD sky130_fd_sc_hd__tapvpwrvgnd_1
XTAP_TAPCELL_ROW_134_2836 VSS VDD sky130_fd_sc_hd__tapvpwrvgnd_1
XTAP_TAPCELL_ROW_134_2837 VSS VDD sky130_fd_sc_hd__tapvpwrvgnd_1
XTAP_TAPCELL_ROW_134_2838 VSS VDD sky130_fd_sc_hd__tapvpwrvgnd_1
XTAP_TAPCELL_ROW_134_2839 VSS VDD sky130_fd_sc_hd__tapvpwrvgnd_1
XTAP_TAPCELL_ROW_134_2840 VSS VDD sky130_fd_sc_hd__tapvpwrvgnd_1
XTAP_TAPCELL_ROW_134_2841 VSS VDD sky130_fd_sc_hd__tapvpwrvgnd_1
XTAP_TAPCELL_ROW_134_2842 VSS VDD sky130_fd_sc_hd__tapvpwrvgnd_1
XTAP_TAPCELL_ROW_134_2843 VSS VDD sky130_fd_sc_hd__tapvpwrvgnd_1
XTAP_TAPCELL_ROW_134_2844 VSS VDD sky130_fd_sc_hd__tapvpwrvgnd_1
XTAP_TAPCELL_ROW_134_2845 VSS VDD sky130_fd_sc_hd__tapvpwrvgnd_1
XTAP_TAPCELL_ROW_134_2846 VSS VDD sky130_fd_sc_hd__tapvpwrvgnd_1
XTAP_TAPCELL_ROW_134_2847 VSS VDD sky130_fd_sc_hd__tapvpwrvgnd_1
XTAP_TAPCELL_ROW_134_2848 VSS VDD sky130_fd_sc_hd__tapvpwrvgnd_1
XTAP_TAPCELL_ROW_134_2849 VSS VDD sky130_fd_sc_hd__tapvpwrvgnd_1
XTAP_TAPCELL_ROW_134_2850 VSS VDD sky130_fd_sc_hd__tapvpwrvgnd_1
XTAP_TAPCELL_ROW_134_2851 VSS VDD sky130_fd_sc_hd__tapvpwrvgnd_1
XTAP_TAPCELL_ROW_134_2852 VSS VDD sky130_fd_sc_hd__tapvpwrvgnd_1
XTAP_TAPCELL_ROW_134_2853 VSS VDD sky130_fd_sc_hd__tapvpwrvgnd_1
XTAP_TAPCELL_ROW_134_2854 VSS VDD sky130_fd_sc_hd__tapvpwrvgnd_1
XTAP_TAPCELL_ROW_134_2855 VSS VDD sky130_fd_sc_hd__tapvpwrvgnd_1
XTAP_TAPCELL_ROW_135_2856 VSS VDD sky130_fd_sc_hd__tapvpwrvgnd_1
XTAP_TAPCELL_ROW_135_2857 VSS VDD sky130_fd_sc_hd__tapvpwrvgnd_1
XTAP_TAPCELL_ROW_135_2858 VSS VDD sky130_fd_sc_hd__tapvpwrvgnd_1
XTAP_TAPCELL_ROW_135_2859 VSS VDD sky130_fd_sc_hd__tapvpwrvgnd_1
XTAP_TAPCELL_ROW_135_2860 VSS VDD sky130_fd_sc_hd__tapvpwrvgnd_1
XTAP_TAPCELL_ROW_135_2861 VSS VDD sky130_fd_sc_hd__tapvpwrvgnd_1
XTAP_TAPCELL_ROW_135_2862 VSS VDD sky130_fd_sc_hd__tapvpwrvgnd_1
XTAP_TAPCELL_ROW_135_2863 VSS VDD sky130_fd_sc_hd__tapvpwrvgnd_1
XTAP_TAPCELL_ROW_135_2864 VSS VDD sky130_fd_sc_hd__tapvpwrvgnd_1
XTAP_TAPCELL_ROW_135_2865 VSS VDD sky130_fd_sc_hd__tapvpwrvgnd_1
XTAP_TAPCELL_ROW_135_2866 VSS VDD sky130_fd_sc_hd__tapvpwrvgnd_1
XTAP_TAPCELL_ROW_135_2867 VSS VDD sky130_fd_sc_hd__tapvpwrvgnd_1
XTAP_TAPCELL_ROW_135_2868 VSS VDD sky130_fd_sc_hd__tapvpwrvgnd_1
XTAP_TAPCELL_ROW_135_2869 VSS VDD sky130_fd_sc_hd__tapvpwrvgnd_1
XTAP_TAPCELL_ROW_135_2870 VSS VDD sky130_fd_sc_hd__tapvpwrvgnd_1
XTAP_TAPCELL_ROW_135_2871 VSS VDD sky130_fd_sc_hd__tapvpwrvgnd_1
XTAP_TAPCELL_ROW_135_2872 VSS VDD sky130_fd_sc_hd__tapvpwrvgnd_1
XTAP_TAPCELL_ROW_135_2873 VSS VDD sky130_fd_sc_hd__tapvpwrvgnd_1
XTAP_TAPCELL_ROW_135_2874 VSS VDD sky130_fd_sc_hd__tapvpwrvgnd_1
XTAP_TAPCELL_ROW_135_2875 VSS VDD sky130_fd_sc_hd__tapvpwrvgnd_1
XTAP_TAPCELL_ROW_135_2876 VSS VDD sky130_fd_sc_hd__tapvpwrvgnd_1
XTAP_TAPCELL_ROW_136_2877 VSS VDD sky130_fd_sc_hd__tapvpwrvgnd_1
XTAP_TAPCELL_ROW_136_2878 VSS VDD sky130_fd_sc_hd__tapvpwrvgnd_1
XTAP_TAPCELL_ROW_136_2879 VSS VDD sky130_fd_sc_hd__tapvpwrvgnd_1
XTAP_TAPCELL_ROW_136_2880 VSS VDD sky130_fd_sc_hd__tapvpwrvgnd_1
XTAP_TAPCELL_ROW_136_2881 VSS VDD sky130_fd_sc_hd__tapvpwrvgnd_1
XTAP_TAPCELL_ROW_136_2882 VSS VDD sky130_fd_sc_hd__tapvpwrvgnd_1
XTAP_TAPCELL_ROW_136_2883 VSS VDD sky130_fd_sc_hd__tapvpwrvgnd_1
XTAP_TAPCELL_ROW_136_2884 VSS VDD sky130_fd_sc_hd__tapvpwrvgnd_1
XTAP_TAPCELL_ROW_136_2885 VSS VDD sky130_fd_sc_hd__tapvpwrvgnd_1
XTAP_TAPCELL_ROW_136_2886 VSS VDD sky130_fd_sc_hd__tapvpwrvgnd_1
XTAP_TAPCELL_ROW_136_2887 VSS VDD sky130_fd_sc_hd__tapvpwrvgnd_1
XTAP_TAPCELL_ROW_136_2888 VSS VDD sky130_fd_sc_hd__tapvpwrvgnd_1
XTAP_TAPCELL_ROW_136_2889 VSS VDD sky130_fd_sc_hd__tapvpwrvgnd_1
XTAP_TAPCELL_ROW_136_2890 VSS VDD sky130_fd_sc_hd__tapvpwrvgnd_1
XTAP_TAPCELL_ROW_136_2891 VSS VDD sky130_fd_sc_hd__tapvpwrvgnd_1
XTAP_TAPCELL_ROW_136_2892 VSS VDD sky130_fd_sc_hd__tapvpwrvgnd_1
XTAP_TAPCELL_ROW_136_2893 VSS VDD sky130_fd_sc_hd__tapvpwrvgnd_1
XTAP_TAPCELL_ROW_136_2894 VSS VDD sky130_fd_sc_hd__tapvpwrvgnd_1
XTAP_TAPCELL_ROW_136_2895 VSS VDD sky130_fd_sc_hd__tapvpwrvgnd_1
XTAP_TAPCELL_ROW_136_2896 VSS VDD sky130_fd_sc_hd__tapvpwrvgnd_1
XTAP_TAPCELL_ROW_136_2897 VSS VDD sky130_fd_sc_hd__tapvpwrvgnd_1
XTAP_TAPCELL_ROW_137_2898 VSS VDD sky130_fd_sc_hd__tapvpwrvgnd_1
XTAP_TAPCELL_ROW_137_2899 VSS VDD sky130_fd_sc_hd__tapvpwrvgnd_1
XTAP_TAPCELL_ROW_137_2900 VSS VDD sky130_fd_sc_hd__tapvpwrvgnd_1
XTAP_TAPCELL_ROW_137_2901 VSS VDD sky130_fd_sc_hd__tapvpwrvgnd_1
XTAP_TAPCELL_ROW_137_2902 VSS VDD sky130_fd_sc_hd__tapvpwrvgnd_1
XTAP_TAPCELL_ROW_137_2903 VSS VDD sky130_fd_sc_hd__tapvpwrvgnd_1
XTAP_TAPCELL_ROW_137_2904 VSS VDD sky130_fd_sc_hd__tapvpwrvgnd_1
XTAP_TAPCELL_ROW_137_2905 VSS VDD sky130_fd_sc_hd__tapvpwrvgnd_1
XTAP_TAPCELL_ROW_137_2906 VSS VDD sky130_fd_sc_hd__tapvpwrvgnd_1
XTAP_TAPCELL_ROW_137_2907 VSS VDD sky130_fd_sc_hd__tapvpwrvgnd_1
XTAP_TAPCELL_ROW_137_2908 VSS VDD sky130_fd_sc_hd__tapvpwrvgnd_1
XTAP_TAPCELL_ROW_137_2909 VSS VDD sky130_fd_sc_hd__tapvpwrvgnd_1
XTAP_TAPCELL_ROW_137_2910 VSS VDD sky130_fd_sc_hd__tapvpwrvgnd_1
XTAP_TAPCELL_ROW_137_2911 VSS VDD sky130_fd_sc_hd__tapvpwrvgnd_1
XTAP_TAPCELL_ROW_137_2912 VSS VDD sky130_fd_sc_hd__tapvpwrvgnd_1
XTAP_TAPCELL_ROW_137_2913 VSS VDD sky130_fd_sc_hd__tapvpwrvgnd_1
XTAP_TAPCELL_ROW_137_2914 VSS VDD sky130_fd_sc_hd__tapvpwrvgnd_1
XTAP_TAPCELL_ROW_137_2915 VSS VDD sky130_fd_sc_hd__tapvpwrvgnd_1
XTAP_TAPCELL_ROW_137_2916 VSS VDD sky130_fd_sc_hd__tapvpwrvgnd_1
XTAP_TAPCELL_ROW_137_2917 VSS VDD sky130_fd_sc_hd__tapvpwrvgnd_1
XTAP_TAPCELL_ROW_137_2918 VSS VDD sky130_fd_sc_hd__tapvpwrvgnd_1
XTAP_TAPCELL_ROW_138_2919 VSS VDD sky130_fd_sc_hd__tapvpwrvgnd_1
XTAP_TAPCELL_ROW_138_2920 VSS VDD sky130_fd_sc_hd__tapvpwrvgnd_1
XTAP_TAPCELL_ROW_138_2921 VSS VDD sky130_fd_sc_hd__tapvpwrvgnd_1
XTAP_TAPCELL_ROW_138_2922 VSS VDD sky130_fd_sc_hd__tapvpwrvgnd_1
XTAP_TAPCELL_ROW_138_2923 VSS VDD sky130_fd_sc_hd__tapvpwrvgnd_1
XTAP_TAPCELL_ROW_138_2924 VSS VDD sky130_fd_sc_hd__tapvpwrvgnd_1
XTAP_TAPCELL_ROW_138_2925 VSS VDD sky130_fd_sc_hd__tapvpwrvgnd_1
XTAP_TAPCELL_ROW_138_2926 VSS VDD sky130_fd_sc_hd__tapvpwrvgnd_1
XTAP_TAPCELL_ROW_138_2927 VSS VDD sky130_fd_sc_hd__tapvpwrvgnd_1
XTAP_TAPCELL_ROW_138_2928 VSS VDD sky130_fd_sc_hd__tapvpwrvgnd_1
XTAP_TAPCELL_ROW_138_2929 VSS VDD sky130_fd_sc_hd__tapvpwrvgnd_1
XTAP_TAPCELL_ROW_138_2930 VSS VDD sky130_fd_sc_hd__tapvpwrvgnd_1
XTAP_TAPCELL_ROW_138_2931 VSS VDD sky130_fd_sc_hd__tapvpwrvgnd_1
XTAP_TAPCELL_ROW_138_2932 VSS VDD sky130_fd_sc_hd__tapvpwrvgnd_1
XTAP_TAPCELL_ROW_138_2933 VSS VDD sky130_fd_sc_hd__tapvpwrvgnd_1
XTAP_TAPCELL_ROW_138_2934 VSS VDD sky130_fd_sc_hd__tapvpwrvgnd_1
XTAP_TAPCELL_ROW_138_2935 VSS VDD sky130_fd_sc_hd__tapvpwrvgnd_1
XTAP_TAPCELL_ROW_138_2936 VSS VDD sky130_fd_sc_hd__tapvpwrvgnd_1
XTAP_TAPCELL_ROW_138_2937 VSS VDD sky130_fd_sc_hd__tapvpwrvgnd_1
XTAP_TAPCELL_ROW_138_2938 VSS VDD sky130_fd_sc_hd__tapvpwrvgnd_1
XTAP_TAPCELL_ROW_138_2939 VSS VDD sky130_fd_sc_hd__tapvpwrvgnd_1
XTAP_TAPCELL_ROW_139_2940 VSS VDD sky130_fd_sc_hd__tapvpwrvgnd_1
XTAP_TAPCELL_ROW_139_2941 VSS VDD sky130_fd_sc_hd__tapvpwrvgnd_1
XTAP_TAPCELL_ROW_139_2942 VSS VDD sky130_fd_sc_hd__tapvpwrvgnd_1
XTAP_TAPCELL_ROW_139_2943 VSS VDD sky130_fd_sc_hd__tapvpwrvgnd_1
XTAP_TAPCELL_ROW_139_2944 VSS VDD sky130_fd_sc_hd__tapvpwrvgnd_1
XTAP_TAPCELL_ROW_139_2945 VSS VDD sky130_fd_sc_hd__tapvpwrvgnd_1
XTAP_TAPCELL_ROW_139_2946 VSS VDD sky130_fd_sc_hd__tapvpwrvgnd_1
XTAP_TAPCELL_ROW_139_2947 VSS VDD sky130_fd_sc_hd__tapvpwrvgnd_1
XTAP_TAPCELL_ROW_139_2948 VSS VDD sky130_fd_sc_hd__tapvpwrvgnd_1
XTAP_TAPCELL_ROW_139_2949 VSS VDD sky130_fd_sc_hd__tapvpwrvgnd_1
XTAP_TAPCELL_ROW_139_2950 VSS VDD sky130_fd_sc_hd__tapvpwrvgnd_1
XTAP_TAPCELL_ROW_139_2951 VSS VDD sky130_fd_sc_hd__tapvpwrvgnd_1
XTAP_TAPCELL_ROW_139_2952 VSS VDD sky130_fd_sc_hd__tapvpwrvgnd_1
XTAP_TAPCELL_ROW_139_2953 VSS VDD sky130_fd_sc_hd__tapvpwrvgnd_1
XTAP_TAPCELL_ROW_139_2954 VSS VDD sky130_fd_sc_hd__tapvpwrvgnd_1
XTAP_TAPCELL_ROW_139_2955 VSS VDD sky130_fd_sc_hd__tapvpwrvgnd_1
XTAP_TAPCELL_ROW_139_2956 VSS VDD sky130_fd_sc_hd__tapvpwrvgnd_1
XTAP_TAPCELL_ROW_139_2957 VSS VDD sky130_fd_sc_hd__tapvpwrvgnd_1
XTAP_TAPCELL_ROW_139_2958 VSS VDD sky130_fd_sc_hd__tapvpwrvgnd_1
XTAP_TAPCELL_ROW_139_2959 VSS VDD sky130_fd_sc_hd__tapvpwrvgnd_1
XTAP_TAPCELL_ROW_139_2960 VSS VDD sky130_fd_sc_hd__tapvpwrvgnd_1
XTAP_TAPCELL_ROW_140_2961 VSS VDD sky130_fd_sc_hd__tapvpwrvgnd_1
XTAP_TAPCELL_ROW_140_2962 VSS VDD sky130_fd_sc_hd__tapvpwrvgnd_1
XTAP_TAPCELL_ROW_140_2963 VSS VDD sky130_fd_sc_hd__tapvpwrvgnd_1
XTAP_TAPCELL_ROW_140_2964 VSS VDD sky130_fd_sc_hd__tapvpwrvgnd_1
XTAP_TAPCELL_ROW_140_2965 VSS VDD sky130_fd_sc_hd__tapvpwrvgnd_1
XTAP_TAPCELL_ROW_140_2966 VSS VDD sky130_fd_sc_hd__tapvpwrvgnd_1
XTAP_TAPCELL_ROW_140_2967 VSS VDD sky130_fd_sc_hd__tapvpwrvgnd_1
XTAP_TAPCELL_ROW_140_2968 VSS VDD sky130_fd_sc_hd__tapvpwrvgnd_1
XTAP_TAPCELL_ROW_140_2969 VSS VDD sky130_fd_sc_hd__tapvpwrvgnd_1
XTAP_TAPCELL_ROW_140_2970 VSS VDD sky130_fd_sc_hd__tapvpwrvgnd_1
XTAP_TAPCELL_ROW_140_2971 VSS VDD sky130_fd_sc_hd__tapvpwrvgnd_1
XTAP_TAPCELL_ROW_140_2972 VSS VDD sky130_fd_sc_hd__tapvpwrvgnd_1
XTAP_TAPCELL_ROW_140_2973 VSS VDD sky130_fd_sc_hd__tapvpwrvgnd_1
XTAP_TAPCELL_ROW_140_2974 VSS VDD sky130_fd_sc_hd__tapvpwrvgnd_1
XTAP_TAPCELL_ROW_140_2975 VSS VDD sky130_fd_sc_hd__tapvpwrvgnd_1
XTAP_TAPCELL_ROW_140_2976 VSS VDD sky130_fd_sc_hd__tapvpwrvgnd_1
XTAP_TAPCELL_ROW_140_2977 VSS VDD sky130_fd_sc_hd__tapvpwrvgnd_1
XTAP_TAPCELL_ROW_140_2978 VSS VDD sky130_fd_sc_hd__tapvpwrvgnd_1
XTAP_TAPCELL_ROW_140_2979 VSS VDD sky130_fd_sc_hd__tapvpwrvgnd_1
XTAP_TAPCELL_ROW_140_2980 VSS VDD sky130_fd_sc_hd__tapvpwrvgnd_1
XTAP_TAPCELL_ROW_140_2981 VSS VDD sky130_fd_sc_hd__tapvpwrvgnd_1
XTAP_TAPCELL_ROW_141_2982 VSS VDD sky130_fd_sc_hd__tapvpwrvgnd_1
XTAP_TAPCELL_ROW_141_2983 VSS VDD sky130_fd_sc_hd__tapvpwrvgnd_1
XTAP_TAPCELL_ROW_141_2984 VSS VDD sky130_fd_sc_hd__tapvpwrvgnd_1
XTAP_TAPCELL_ROW_141_2985 VSS VDD sky130_fd_sc_hd__tapvpwrvgnd_1
XTAP_TAPCELL_ROW_141_2986 VSS VDD sky130_fd_sc_hd__tapvpwrvgnd_1
XTAP_TAPCELL_ROW_141_2987 VSS VDD sky130_fd_sc_hd__tapvpwrvgnd_1
XTAP_TAPCELL_ROW_141_2988 VSS VDD sky130_fd_sc_hd__tapvpwrvgnd_1
XTAP_TAPCELL_ROW_141_2989 VSS VDD sky130_fd_sc_hd__tapvpwrvgnd_1
XTAP_TAPCELL_ROW_141_2990 VSS VDD sky130_fd_sc_hd__tapvpwrvgnd_1
XTAP_TAPCELL_ROW_141_2991 VSS VDD sky130_fd_sc_hd__tapvpwrvgnd_1
XTAP_TAPCELL_ROW_141_2992 VSS VDD sky130_fd_sc_hd__tapvpwrvgnd_1
XTAP_TAPCELL_ROW_141_2993 VSS VDD sky130_fd_sc_hd__tapvpwrvgnd_1
XTAP_TAPCELL_ROW_141_2994 VSS VDD sky130_fd_sc_hd__tapvpwrvgnd_1
XTAP_TAPCELL_ROW_141_2995 VSS VDD sky130_fd_sc_hd__tapvpwrvgnd_1
XTAP_TAPCELL_ROW_141_2996 VSS VDD sky130_fd_sc_hd__tapvpwrvgnd_1
XTAP_TAPCELL_ROW_141_2997 VSS VDD sky130_fd_sc_hd__tapvpwrvgnd_1
XTAP_TAPCELL_ROW_141_2998 VSS VDD sky130_fd_sc_hd__tapvpwrvgnd_1
XTAP_TAPCELL_ROW_141_2999 VSS VDD sky130_fd_sc_hd__tapvpwrvgnd_1
XTAP_TAPCELL_ROW_141_3000 VSS VDD sky130_fd_sc_hd__tapvpwrvgnd_1
XTAP_TAPCELL_ROW_141_3001 VSS VDD sky130_fd_sc_hd__tapvpwrvgnd_1
XTAP_TAPCELL_ROW_141_3002 VSS VDD sky130_fd_sc_hd__tapvpwrvgnd_1
XTAP_TAPCELL_ROW_142_3003 VSS VDD sky130_fd_sc_hd__tapvpwrvgnd_1
XTAP_TAPCELL_ROW_142_3004 VSS VDD sky130_fd_sc_hd__tapvpwrvgnd_1
XTAP_TAPCELL_ROW_142_3005 VSS VDD sky130_fd_sc_hd__tapvpwrvgnd_1
XTAP_TAPCELL_ROW_142_3006 VSS VDD sky130_fd_sc_hd__tapvpwrvgnd_1
XTAP_TAPCELL_ROW_142_3007 VSS VDD sky130_fd_sc_hd__tapvpwrvgnd_1
XTAP_TAPCELL_ROW_142_3008 VSS VDD sky130_fd_sc_hd__tapvpwrvgnd_1
XTAP_TAPCELL_ROW_142_3009 VSS VDD sky130_fd_sc_hd__tapvpwrvgnd_1
XTAP_TAPCELL_ROW_142_3010 VSS VDD sky130_fd_sc_hd__tapvpwrvgnd_1
XTAP_TAPCELL_ROW_142_3011 VSS VDD sky130_fd_sc_hd__tapvpwrvgnd_1
XTAP_TAPCELL_ROW_142_3012 VSS VDD sky130_fd_sc_hd__tapvpwrvgnd_1
XTAP_TAPCELL_ROW_142_3013 VSS VDD sky130_fd_sc_hd__tapvpwrvgnd_1
XTAP_TAPCELL_ROW_142_3014 VSS VDD sky130_fd_sc_hd__tapvpwrvgnd_1
XTAP_TAPCELL_ROW_142_3015 VSS VDD sky130_fd_sc_hd__tapvpwrvgnd_1
XTAP_TAPCELL_ROW_142_3016 VSS VDD sky130_fd_sc_hd__tapvpwrvgnd_1
XTAP_TAPCELL_ROW_142_3017 VSS VDD sky130_fd_sc_hd__tapvpwrvgnd_1
XTAP_TAPCELL_ROW_142_3018 VSS VDD sky130_fd_sc_hd__tapvpwrvgnd_1
XTAP_TAPCELL_ROW_142_3019 VSS VDD sky130_fd_sc_hd__tapvpwrvgnd_1
XTAP_TAPCELL_ROW_142_3020 VSS VDD sky130_fd_sc_hd__tapvpwrvgnd_1
XTAP_TAPCELL_ROW_142_3021 VSS VDD sky130_fd_sc_hd__tapvpwrvgnd_1
XTAP_TAPCELL_ROW_142_3022 VSS VDD sky130_fd_sc_hd__tapvpwrvgnd_1
XTAP_TAPCELL_ROW_142_3023 VSS VDD sky130_fd_sc_hd__tapvpwrvgnd_1
XTAP_TAPCELL_ROW_143_3024 VSS VDD sky130_fd_sc_hd__tapvpwrvgnd_1
XTAP_TAPCELL_ROW_143_3025 VSS VDD sky130_fd_sc_hd__tapvpwrvgnd_1
XTAP_TAPCELL_ROW_143_3026 VSS VDD sky130_fd_sc_hd__tapvpwrvgnd_1
XTAP_TAPCELL_ROW_143_3027 VSS VDD sky130_fd_sc_hd__tapvpwrvgnd_1
XTAP_TAPCELL_ROW_143_3028 VSS VDD sky130_fd_sc_hd__tapvpwrvgnd_1
XTAP_TAPCELL_ROW_143_3029 VSS VDD sky130_fd_sc_hd__tapvpwrvgnd_1
XTAP_TAPCELL_ROW_143_3030 VSS VDD sky130_fd_sc_hd__tapvpwrvgnd_1
XTAP_TAPCELL_ROW_143_3031 VSS VDD sky130_fd_sc_hd__tapvpwrvgnd_1
XTAP_TAPCELL_ROW_143_3032 VSS VDD sky130_fd_sc_hd__tapvpwrvgnd_1
XTAP_TAPCELL_ROW_143_3033 VSS VDD sky130_fd_sc_hd__tapvpwrvgnd_1
XTAP_TAPCELL_ROW_143_3034 VSS VDD sky130_fd_sc_hd__tapvpwrvgnd_1
XTAP_TAPCELL_ROW_143_3035 VSS VDD sky130_fd_sc_hd__tapvpwrvgnd_1
XTAP_TAPCELL_ROW_143_3036 VSS VDD sky130_fd_sc_hd__tapvpwrvgnd_1
XTAP_TAPCELL_ROW_143_3037 VSS VDD sky130_fd_sc_hd__tapvpwrvgnd_1
XTAP_TAPCELL_ROW_143_3038 VSS VDD sky130_fd_sc_hd__tapvpwrvgnd_1
XTAP_TAPCELL_ROW_143_3039 VSS VDD sky130_fd_sc_hd__tapvpwrvgnd_1
XTAP_TAPCELL_ROW_143_3040 VSS VDD sky130_fd_sc_hd__tapvpwrvgnd_1
XTAP_TAPCELL_ROW_143_3041 VSS VDD sky130_fd_sc_hd__tapvpwrvgnd_1
XTAP_TAPCELL_ROW_143_3042 VSS VDD sky130_fd_sc_hd__tapvpwrvgnd_1
XTAP_TAPCELL_ROW_143_3043 VSS VDD sky130_fd_sc_hd__tapvpwrvgnd_1
XTAP_TAPCELL_ROW_143_3044 VSS VDD sky130_fd_sc_hd__tapvpwrvgnd_1
XTAP_TAPCELL_ROW_144_3045 VSS VDD sky130_fd_sc_hd__tapvpwrvgnd_1
XTAP_TAPCELL_ROW_144_3046 VSS VDD sky130_fd_sc_hd__tapvpwrvgnd_1
XTAP_TAPCELL_ROW_144_3047 VSS VDD sky130_fd_sc_hd__tapvpwrvgnd_1
XTAP_TAPCELL_ROW_144_3048 VSS VDD sky130_fd_sc_hd__tapvpwrvgnd_1
XTAP_TAPCELL_ROW_144_3049 VSS VDD sky130_fd_sc_hd__tapvpwrvgnd_1
XTAP_TAPCELL_ROW_144_3050 VSS VDD sky130_fd_sc_hd__tapvpwrvgnd_1
XTAP_TAPCELL_ROW_144_3051 VSS VDD sky130_fd_sc_hd__tapvpwrvgnd_1
XTAP_TAPCELL_ROW_144_3052 VSS VDD sky130_fd_sc_hd__tapvpwrvgnd_1
XTAP_TAPCELL_ROW_144_3053 VSS VDD sky130_fd_sc_hd__tapvpwrvgnd_1
XTAP_TAPCELL_ROW_144_3054 VSS VDD sky130_fd_sc_hd__tapvpwrvgnd_1
XTAP_TAPCELL_ROW_144_3055 VSS VDD sky130_fd_sc_hd__tapvpwrvgnd_1
XTAP_TAPCELL_ROW_144_3056 VSS VDD sky130_fd_sc_hd__tapvpwrvgnd_1
XTAP_TAPCELL_ROW_144_3057 VSS VDD sky130_fd_sc_hd__tapvpwrvgnd_1
XTAP_TAPCELL_ROW_144_3058 VSS VDD sky130_fd_sc_hd__tapvpwrvgnd_1
XTAP_TAPCELL_ROW_144_3059 VSS VDD sky130_fd_sc_hd__tapvpwrvgnd_1
XTAP_TAPCELL_ROW_144_3060 VSS VDD sky130_fd_sc_hd__tapvpwrvgnd_1
XTAP_TAPCELL_ROW_144_3061 VSS VDD sky130_fd_sc_hd__tapvpwrvgnd_1
XTAP_TAPCELL_ROW_144_3062 VSS VDD sky130_fd_sc_hd__tapvpwrvgnd_1
XTAP_TAPCELL_ROW_144_3063 VSS VDD sky130_fd_sc_hd__tapvpwrvgnd_1
XTAP_TAPCELL_ROW_144_3064 VSS VDD sky130_fd_sc_hd__tapvpwrvgnd_1
XTAP_TAPCELL_ROW_144_3065 VSS VDD sky130_fd_sc_hd__tapvpwrvgnd_1
XTAP_TAPCELL_ROW_145_3066 VSS VDD sky130_fd_sc_hd__tapvpwrvgnd_1
XTAP_TAPCELL_ROW_145_3067 VSS VDD sky130_fd_sc_hd__tapvpwrvgnd_1
XTAP_TAPCELL_ROW_145_3068 VSS VDD sky130_fd_sc_hd__tapvpwrvgnd_1
XTAP_TAPCELL_ROW_145_3069 VSS VDD sky130_fd_sc_hd__tapvpwrvgnd_1
XTAP_TAPCELL_ROW_145_3070 VSS VDD sky130_fd_sc_hd__tapvpwrvgnd_1
XTAP_TAPCELL_ROW_145_3071 VSS VDD sky130_fd_sc_hd__tapvpwrvgnd_1
XTAP_TAPCELL_ROW_145_3072 VSS VDD sky130_fd_sc_hd__tapvpwrvgnd_1
XTAP_TAPCELL_ROW_145_3073 VSS VDD sky130_fd_sc_hd__tapvpwrvgnd_1
XTAP_TAPCELL_ROW_145_3074 VSS VDD sky130_fd_sc_hd__tapvpwrvgnd_1
XTAP_TAPCELL_ROW_145_3075 VSS VDD sky130_fd_sc_hd__tapvpwrvgnd_1
XTAP_TAPCELL_ROW_145_3076 VSS VDD sky130_fd_sc_hd__tapvpwrvgnd_1
XTAP_TAPCELL_ROW_145_3077 VSS VDD sky130_fd_sc_hd__tapvpwrvgnd_1
XTAP_TAPCELL_ROW_145_3078 VSS VDD sky130_fd_sc_hd__tapvpwrvgnd_1
XTAP_TAPCELL_ROW_145_3079 VSS VDD sky130_fd_sc_hd__tapvpwrvgnd_1
XTAP_TAPCELL_ROW_145_3080 VSS VDD sky130_fd_sc_hd__tapvpwrvgnd_1
XTAP_TAPCELL_ROW_145_3081 VSS VDD sky130_fd_sc_hd__tapvpwrvgnd_1
XTAP_TAPCELL_ROW_145_3082 VSS VDD sky130_fd_sc_hd__tapvpwrvgnd_1
XTAP_TAPCELL_ROW_145_3083 VSS VDD sky130_fd_sc_hd__tapvpwrvgnd_1
XTAP_TAPCELL_ROW_145_3084 VSS VDD sky130_fd_sc_hd__tapvpwrvgnd_1
XTAP_TAPCELL_ROW_145_3085 VSS VDD sky130_fd_sc_hd__tapvpwrvgnd_1
XTAP_TAPCELL_ROW_145_3086 VSS VDD sky130_fd_sc_hd__tapvpwrvgnd_1
XTAP_TAPCELL_ROW_146_3087 VSS VDD sky130_fd_sc_hd__tapvpwrvgnd_1
XTAP_TAPCELL_ROW_146_3088 VSS VDD sky130_fd_sc_hd__tapvpwrvgnd_1
XTAP_TAPCELL_ROW_146_3089 VSS VDD sky130_fd_sc_hd__tapvpwrvgnd_1
XTAP_TAPCELL_ROW_146_3090 VSS VDD sky130_fd_sc_hd__tapvpwrvgnd_1
XTAP_TAPCELL_ROW_146_3091 VSS VDD sky130_fd_sc_hd__tapvpwrvgnd_1
XTAP_TAPCELL_ROW_146_3092 VSS VDD sky130_fd_sc_hd__tapvpwrvgnd_1
XTAP_TAPCELL_ROW_146_3093 VSS VDD sky130_fd_sc_hd__tapvpwrvgnd_1
XTAP_TAPCELL_ROW_146_3094 VSS VDD sky130_fd_sc_hd__tapvpwrvgnd_1
XTAP_TAPCELL_ROW_146_3095 VSS VDD sky130_fd_sc_hd__tapvpwrvgnd_1
XTAP_TAPCELL_ROW_146_3096 VSS VDD sky130_fd_sc_hd__tapvpwrvgnd_1
XTAP_TAPCELL_ROW_146_3097 VSS VDD sky130_fd_sc_hd__tapvpwrvgnd_1
XTAP_TAPCELL_ROW_146_3098 VSS VDD sky130_fd_sc_hd__tapvpwrvgnd_1
XTAP_TAPCELL_ROW_146_3099 VSS VDD sky130_fd_sc_hd__tapvpwrvgnd_1
XTAP_TAPCELL_ROW_146_3100 VSS VDD sky130_fd_sc_hd__tapvpwrvgnd_1
XTAP_TAPCELL_ROW_146_3101 VSS VDD sky130_fd_sc_hd__tapvpwrvgnd_1
XTAP_TAPCELL_ROW_146_3102 VSS VDD sky130_fd_sc_hd__tapvpwrvgnd_1
XTAP_TAPCELL_ROW_146_3103 VSS VDD sky130_fd_sc_hd__tapvpwrvgnd_1
XTAP_TAPCELL_ROW_146_3104 VSS VDD sky130_fd_sc_hd__tapvpwrvgnd_1
XTAP_TAPCELL_ROW_146_3105 VSS VDD sky130_fd_sc_hd__tapvpwrvgnd_1
XTAP_TAPCELL_ROW_146_3106 VSS VDD sky130_fd_sc_hd__tapvpwrvgnd_1
XTAP_TAPCELL_ROW_146_3107 VSS VDD sky130_fd_sc_hd__tapvpwrvgnd_1
XTAP_TAPCELL_ROW_147_3108 VSS VDD sky130_fd_sc_hd__tapvpwrvgnd_1
XTAP_TAPCELL_ROW_147_3109 VSS VDD sky130_fd_sc_hd__tapvpwrvgnd_1
XTAP_TAPCELL_ROW_147_3110 VSS VDD sky130_fd_sc_hd__tapvpwrvgnd_1
XTAP_TAPCELL_ROW_147_3111 VSS VDD sky130_fd_sc_hd__tapvpwrvgnd_1
XTAP_TAPCELL_ROW_147_3112 VSS VDD sky130_fd_sc_hd__tapvpwrvgnd_1
XTAP_TAPCELL_ROW_147_3113 VSS VDD sky130_fd_sc_hd__tapvpwrvgnd_1
XTAP_TAPCELL_ROW_147_3114 VSS VDD sky130_fd_sc_hd__tapvpwrvgnd_1
XTAP_TAPCELL_ROW_147_3115 VSS VDD sky130_fd_sc_hd__tapvpwrvgnd_1
XTAP_TAPCELL_ROW_147_3116 VSS VDD sky130_fd_sc_hd__tapvpwrvgnd_1
XTAP_TAPCELL_ROW_147_3117 VSS VDD sky130_fd_sc_hd__tapvpwrvgnd_1
XTAP_TAPCELL_ROW_147_3118 VSS VDD sky130_fd_sc_hd__tapvpwrvgnd_1
XTAP_TAPCELL_ROW_147_3119 VSS VDD sky130_fd_sc_hd__tapvpwrvgnd_1
XTAP_TAPCELL_ROW_147_3120 VSS VDD sky130_fd_sc_hd__tapvpwrvgnd_1
XTAP_TAPCELL_ROW_147_3121 VSS VDD sky130_fd_sc_hd__tapvpwrvgnd_1
XTAP_TAPCELL_ROW_147_3122 VSS VDD sky130_fd_sc_hd__tapvpwrvgnd_1
XTAP_TAPCELL_ROW_147_3123 VSS VDD sky130_fd_sc_hd__tapvpwrvgnd_1
XTAP_TAPCELL_ROW_147_3124 VSS VDD sky130_fd_sc_hd__tapvpwrvgnd_1
XTAP_TAPCELL_ROW_147_3125 VSS VDD sky130_fd_sc_hd__tapvpwrvgnd_1
XTAP_TAPCELL_ROW_147_3126 VSS VDD sky130_fd_sc_hd__tapvpwrvgnd_1
XTAP_TAPCELL_ROW_147_3127 VSS VDD sky130_fd_sc_hd__tapvpwrvgnd_1
XTAP_TAPCELL_ROW_147_3128 VSS VDD sky130_fd_sc_hd__tapvpwrvgnd_1
XTAP_TAPCELL_ROW_148_3129 VSS VDD sky130_fd_sc_hd__tapvpwrvgnd_1
XTAP_TAPCELL_ROW_148_3130 VSS VDD sky130_fd_sc_hd__tapvpwrvgnd_1
XTAP_TAPCELL_ROW_148_3131 VSS VDD sky130_fd_sc_hd__tapvpwrvgnd_1
XTAP_TAPCELL_ROW_148_3132 VSS VDD sky130_fd_sc_hd__tapvpwrvgnd_1
XTAP_TAPCELL_ROW_148_3133 VSS VDD sky130_fd_sc_hd__tapvpwrvgnd_1
XTAP_TAPCELL_ROW_148_3134 VSS VDD sky130_fd_sc_hd__tapvpwrvgnd_1
XTAP_TAPCELL_ROW_148_3135 VSS VDD sky130_fd_sc_hd__tapvpwrvgnd_1
XTAP_TAPCELL_ROW_148_3136 VSS VDD sky130_fd_sc_hd__tapvpwrvgnd_1
XTAP_TAPCELL_ROW_148_3137 VSS VDD sky130_fd_sc_hd__tapvpwrvgnd_1
XTAP_TAPCELL_ROW_148_3138 VSS VDD sky130_fd_sc_hd__tapvpwrvgnd_1
XTAP_TAPCELL_ROW_148_3139 VSS VDD sky130_fd_sc_hd__tapvpwrvgnd_1
XTAP_TAPCELL_ROW_148_3140 VSS VDD sky130_fd_sc_hd__tapvpwrvgnd_1
XTAP_TAPCELL_ROW_148_3141 VSS VDD sky130_fd_sc_hd__tapvpwrvgnd_1
XTAP_TAPCELL_ROW_148_3142 VSS VDD sky130_fd_sc_hd__tapvpwrvgnd_1
XTAP_TAPCELL_ROW_148_3143 VSS VDD sky130_fd_sc_hd__tapvpwrvgnd_1
XTAP_TAPCELL_ROW_148_3144 VSS VDD sky130_fd_sc_hd__tapvpwrvgnd_1
XTAP_TAPCELL_ROW_148_3145 VSS VDD sky130_fd_sc_hd__tapvpwrvgnd_1
XTAP_TAPCELL_ROW_148_3146 VSS VDD sky130_fd_sc_hd__tapvpwrvgnd_1
XTAP_TAPCELL_ROW_148_3147 VSS VDD sky130_fd_sc_hd__tapvpwrvgnd_1
XTAP_TAPCELL_ROW_148_3148 VSS VDD sky130_fd_sc_hd__tapvpwrvgnd_1
XTAP_TAPCELL_ROW_148_3149 VSS VDD sky130_fd_sc_hd__tapvpwrvgnd_1
XTAP_TAPCELL_ROW_149_3150 VSS VDD sky130_fd_sc_hd__tapvpwrvgnd_1
XTAP_TAPCELL_ROW_149_3151 VSS VDD sky130_fd_sc_hd__tapvpwrvgnd_1
XTAP_TAPCELL_ROW_149_3152 VSS VDD sky130_fd_sc_hd__tapvpwrvgnd_1
XTAP_TAPCELL_ROW_149_3153 VSS VDD sky130_fd_sc_hd__tapvpwrvgnd_1
XTAP_TAPCELL_ROW_149_3154 VSS VDD sky130_fd_sc_hd__tapvpwrvgnd_1
XTAP_TAPCELL_ROW_149_3155 VSS VDD sky130_fd_sc_hd__tapvpwrvgnd_1
XTAP_TAPCELL_ROW_149_3156 VSS VDD sky130_fd_sc_hd__tapvpwrvgnd_1
XTAP_TAPCELL_ROW_149_3157 VSS VDD sky130_fd_sc_hd__tapvpwrvgnd_1
XTAP_TAPCELL_ROW_149_3158 VSS VDD sky130_fd_sc_hd__tapvpwrvgnd_1
XTAP_TAPCELL_ROW_149_3159 VSS VDD sky130_fd_sc_hd__tapvpwrvgnd_1
XTAP_TAPCELL_ROW_149_3160 VSS VDD sky130_fd_sc_hd__tapvpwrvgnd_1
XTAP_TAPCELL_ROW_149_3161 VSS VDD sky130_fd_sc_hd__tapvpwrvgnd_1
XTAP_TAPCELL_ROW_149_3162 VSS VDD sky130_fd_sc_hd__tapvpwrvgnd_1
XTAP_TAPCELL_ROW_149_3163 VSS VDD sky130_fd_sc_hd__tapvpwrvgnd_1
XTAP_TAPCELL_ROW_149_3164 VSS VDD sky130_fd_sc_hd__tapvpwrvgnd_1
XTAP_TAPCELL_ROW_149_3165 VSS VDD sky130_fd_sc_hd__tapvpwrvgnd_1
XTAP_TAPCELL_ROW_149_3166 VSS VDD sky130_fd_sc_hd__tapvpwrvgnd_1
XTAP_TAPCELL_ROW_149_3167 VSS VDD sky130_fd_sc_hd__tapvpwrvgnd_1
XTAP_TAPCELL_ROW_149_3168 VSS VDD sky130_fd_sc_hd__tapvpwrvgnd_1
XTAP_TAPCELL_ROW_149_3169 VSS VDD sky130_fd_sc_hd__tapvpwrvgnd_1
XTAP_TAPCELL_ROW_149_3170 VSS VDD sky130_fd_sc_hd__tapvpwrvgnd_1
XTAP_TAPCELL_ROW_150_3171 VSS VDD sky130_fd_sc_hd__tapvpwrvgnd_1
XTAP_TAPCELL_ROW_150_3172 VSS VDD sky130_fd_sc_hd__tapvpwrvgnd_1
XTAP_TAPCELL_ROW_150_3173 VSS VDD sky130_fd_sc_hd__tapvpwrvgnd_1
XTAP_TAPCELL_ROW_150_3174 VSS VDD sky130_fd_sc_hd__tapvpwrvgnd_1
XTAP_TAPCELL_ROW_150_3175 VSS VDD sky130_fd_sc_hd__tapvpwrvgnd_1
XTAP_TAPCELL_ROW_150_3176 VSS VDD sky130_fd_sc_hd__tapvpwrvgnd_1
XTAP_TAPCELL_ROW_150_3177 VSS VDD sky130_fd_sc_hd__tapvpwrvgnd_1
XTAP_TAPCELL_ROW_150_3178 VSS VDD sky130_fd_sc_hd__tapvpwrvgnd_1
XTAP_TAPCELL_ROW_150_3179 VSS VDD sky130_fd_sc_hd__tapvpwrvgnd_1
XTAP_TAPCELL_ROW_150_3180 VSS VDD sky130_fd_sc_hd__tapvpwrvgnd_1
XTAP_TAPCELL_ROW_150_3181 VSS VDD sky130_fd_sc_hd__tapvpwrvgnd_1
XTAP_TAPCELL_ROW_150_3182 VSS VDD sky130_fd_sc_hd__tapvpwrvgnd_1
XTAP_TAPCELL_ROW_150_3183 VSS VDD sky130_fd_sc_hd__tapvpwrvgnd_1
XTAP_TAPCELL_ROW_150_3184 VSS VDD sky130_fd_sc_hd__tapvpwrvgnd_1
XTAP_TAPCELL_ROW_150_3185 VSS VDD sky130_fd_sc_hd__tapvpwrvgnd_1
XTAP_TAPCELL_ROW_150_3186 VSS VDD sky130_fd_sc_hd__tapvpwrvgnd_1
XTAP_TAPCELL_ROW_150_3187 VSS VDD sky130_fd_sc_hd__tapvpwrvgnd_1
XTAP_TAPCELL_ROW_150_3188 VSS VDD sky130_fd_sc_hd__tapvpwrvgnd_1
XTAP_TAPCELL_ROW_150_3189 VSS VDD sky130_fd_sc_hd__tapvpwrvgnd_1
XTAP_TAPCELL_ROW_150_3190 VSS VDD sky130_fd_sc_hd__tapvpwrvgnd_1
XTAP_TAPCELL_ROW_150_3191 VSS VDD sky130_fd_sc_hd__tapvpwrvgnd_1
XTAP_TAPCELL_ROW_151_3192 VSS VDD sky130_fd_sc_hd__tapvpwrvgnd_1
XTAP_TAPCELL_ROW_151_3193 VSS VDD sky130_fd_sc_hd__tapvpwrvgnd_1
XTAP_TAPCELL_ROW_151_3194 VSS VDD sky130_fd_sc_hd__tapvpwrvgnd_1
XTAP_TAPCELL_ROW_151_3195 VSS VDD sky130_fd_sc_hd__tapvpwrvgnd_1
XTAP_TAPCELL_ROW_151_3196 VSS VDD sky130_fd_sc_hd__tapvpwrvgnd_1
XTAP_TAPCELL_ROW_151_3197 VSS VDD sky130_fd_sc_hd__tapvpwrvgnd_1
XTAP_TAPCELL_ROW_151_3198 VSS VDD sky130_fd_sc_hd__tapvpwrvgnd_1
XTAP_TAPCELL_ROW_151_3199 VSS VDD sky130_fd_sc_hd__tapvpwrvgnd_1
XTAP_TAPCELL_ROW_151_3200 VSS VDD sky130_fd_sc_hd__tapvpwrvgnd_1
XTAP_TAPCELL_ROW_151_3201 VSS VDD sky130_fd_sc_hd__tapvpwrvgnd_1
XTAP_TAPCELL_ROW_151_3202 VSS VDD sky130_fd_sc_hd__tapvpwrvgnd_1
XTAP_TAPCELL_ROW_151_3203 VSS VDD sky130_fd_sc_hd__tapvpwrvgnd_1
XTAP_TAPCELL_ROW_151_3204 VSS VDD sky130_fd_sc_hd__tapvpwrvgnd_1
XTAP_TAPCELL_ROW_151_3205 VSS VDD sky130_fd_sc_hd__tapvpwrvgnd_1
XTAP_TAPCELL_ROW_151_3206 VSS VDD sky130_fd_sc_hd__tapvpwrvgnd_1
XTAP_TAPCELL_ROW_151_3207 VSS VDD sky130_fd_sc_hd__tapvpwrvgnd_1
XTAP_TAPCELL_ROW_151_3208 VSS VDD sky130_fd_sc_hd__tapvpwrvgnd_1
XTAP_TAPCELL_ROW_151_3209 VSS VDD sky130_fd_sc_hd__tapvpwrvgnd_1
XTAP_TAPCELL_ROW_151_3210 VSS VDD sky130_fd_sc_hd__tapvpwrvgnd_1
XTAP_TAPCELL_ROW_151_3211 VSS VDD sky130_fd_sc_hd__tapvpwrvgnd_1
XTAP_TAPCELL_ROW_151_3212 VSS VDD sky130_fd_sc_hd__tapvpwrvgnd_1
XTAP_TAPCELL_ROW_152_3213 VSS VDD sky130_fd_sc_hd__tapvpwrvgnd_1
XTAP_TAPCELL_ROW_152_3214 VSS VDD sky130_fd_sc_hd__tapvpwrvgnd_1
XTAP_TAPCELL_ROW_152_3215 VSS VDD sky130_fd_sc_hd__tapvpwrvgnd_1
XTAP_TAPCELL_ROW_152_3216 VSS VDD sky130_fd_sc_hd__tapvpwrvgnd_1
XTAP_TAPCELL_ROW_152_3217 VSS VDD sky130_fd_sc_hd__tapvpwrvgnd_1
XTAP_TAPCELL_ROW_152_3218 VSS VDD sky130_fd_sc_hd__tapvpwrvgnd_1
XTAP_TAPCELL_ROW_152_3219 VSS VDD sky130_fd_sc_hd__tapvpwrvgnd_1
XTAP_TAPCELL_ROW_152_3220 VSS VDD sky130_fd_sc_hd__tapvpwrvgnd_1
XTAP_TAPCELL_ROW_152_3221 VSS VDD sky130_fd_sc_hd__tapvpwrvgnd_1
XTAP_TAPCELL_ROW_152_3222 VSS VDD sky130_fd_sc_hd__tapvpwrvgnd_1
XTAP_TAPCELL_ROW_152_3223 VSS VDD sky130_fd_sc_hd__tapvpwrvgnd_1
XTAP_TAPCELL_ROW_152_3224 VSS VDD sky130_fd_sc_hd__tapvpwrvgnd_1
XTAP_TAPCELL_ROW_152_3225 VSS VDD sky130_fd_sc_hd__tapvpwrvgnd_1
XTAP_TAPCELL_ROW_152_3226 VSS VDD sky130_fd_sc_hd__tapvpwrvgnd_1
XTAP_TAPCELL_ROW_152_3227 VSS VDD sky130_fd_sc_hd__tapvpwrvgnd_1
XTAP_TAPCELL_ROW_152_3228 VSS VDD sky130_fd_sc_hd__tapvpwrvgnd_1
XTAP_TAPCELL_ROW_152_3229 VSS VDD sky130_fd_sc_hd__tapvpwrvgnd_1
XTAP_TAPCELL_ROW_152_3230 VSS VDD sky130_fd_sc_hd__tapvpwrvgnd_1
XTAP_TAPCELL_ROW_152_3231 VSS VDD sky130_fd_sc_hd__tapvpwrvgnd_1
XTAP_TAPCELL_ROW_152_3232 VSS VDD sky130_fd_sc_hd__tapvpwrvgnd_1
XTAP_TAPCELL_ROW_152_3233 VSS VDD sky130_fd_sc_hd__tapvpwrvgnd_1
XTAP_TAPCELL_ROW_153_3234 VSS VDD sky130_fd_sc_hd__tapvpwrvgnd_1
XTAP_TAPCELL_ROW_153_3235 VSS VDD sky130_fd_sc_hd__tapvpwrvgnd_1
XTAP_TAPCELL_ROW_153_3236 VSS VDD sky130_fd_sc_hd__tapvpwrvgnd_1
XTAP_TAPCELL_ROW_153_3237 VSS VDD sky130_fd_sc_hd__tapvpwrvgnd_1
XTAP_TAPCELL_ROW_153_3238 VSS VDD sky130_fd_sc_hd__tapvpwrvgnd_1
XTAP_TAPCELL_ROW_153_3239 VSS VDD sky130_fd_sc_hd__tapvpwrvgnd_1
XTAP_TAPCELL_ROW_153_3240 VSS VDD sky130_fd_sc_hd__tapvpwrvgnd_1
XTAP_TAPCELL_ROW_153_3241 VSS VDD sky130_fd_sc_hd__tapvpwrvgnd_1
XTAP_TAPCELL_ROW_153_3242 VSS VDD sky130_fd_sc_hd__tapvpwrvgnd_1
XTAP_TAPCELL_ROW_153_3243 VSS VDD sky130_fd_sc_hd__tapvpwrvgnd_1
XTAP_TAPCELL_ROW_153_3244 VSS VDD sky130_fd_sc_hd__tapvpwrvgnd_1
XTAP_TAPCELL_ROW_153_3245 VSS VDD sky130_fd_sc_hd__tapvpwrvgnd_1
XTAP_TAPCELL_ROW_153_3246 VSS VDD sky130_fd_sc_hd__tapvpwrvgnd_1
XTAP_TAPCELL_ROW_153_3247 VSS VDD sky130_fd_sc_hd__tapvpwrvgnd_1
XTAP_TAPCELL_ROW_153_3248 VSS VDD sky130_fd_sc_hd__tapvpwrvgnd_1
XTAP_TAPCELL_ROW_153_3249 VSS VDD sky130_fd_sc_hd__tapvpwrvgnd_1
XTAP_TAPCELL_ROW_153_3250 VSS VDD sky130_fd_sc_hd__tapvpwrvgnd_1
XTAP_TAPCELL_ROW_153_3251 VSS VDD sky130_fd_sc_hd__tapvpwrvgnd_1
XTAP_TAPCELL_ROW_153_3252 VSS VDD sky130_fd_sc_hd__tapvpwrvgnd_1
XTAP_TAPCELL_ROW_153_3253 VSS VDD sky130_fd_sc_hd__tapvpwrvgnd_1
XTAP_TAPCELL_ROW_153_3254 VSS VDD sky130_fd_sc_hd__tapvpwrvgnd_1
XTAP_TAPCELL_ROW_154_3255 VSS VDD sky130_fd_sc_hd__tapvpwrvgnd_1
XTAP_TAPCELL_ROW_154_3256 VSS VDD sky130_fd_sc_hd__tapvpwrvgnd_1
XTAP_TAPCELL_ROW_154_3257 VSS VDD sky130_fd_sc_hd__tapvpwrvgnd_1
XTAP_TAPCELL_ROW_154_3258 VSS VDD sky130_fd_sc_hd__tapvpwrvgnd_1
XTAP_TAPCELL_ROW_154_3259 VSS VDD sky130_fd_sc_hd__tapvpwrvgnd_1
XTAP_TAPCELL_ROW_154_3260 VSS VDD sky130_fd_sc_hd__tapvpwrvgnd_1
XTAP_TAPCELL_ROW_154_3261 VSS VDD sky130_fd_sc_hd__tapvpwrvgnd_1
XTAP_TAPCELL_ROW_154_3262 VSS VDD sky130_fd_sc_hd__tapvpwrvgnd_1
XTAP_TAPCELL_ROW_154_3263 VSS VDD sky130_fd_sc_hd__tapvpwrvgnd_1
XTAP_TAPCELL_ROW_154_3264 VSS VDD sky130_fd_sc_hd__tapvpwrvgnd_1
XTAP_TAPCELL_ROW_154_3265 VSS VDD sky130_fd_sc_hd__tapvpwrvgnd_1
XTAP_TAPCELL_ROW_154_3266 VSS VDD sky130_fd_sc_hd__tapvpwrvgnd_1
XTAP_TAPCELL_ROW_154_3267 VSS VDD sky130_fd_sc_hd__tapvpwrvgnd_1
XTAP_TAPCELL_ROW_154_3268 VSS VDD sky130_fd_sc_hd__tapvpwrvgnd_1
XTAP_TAPCELL_ROW_154_3269 VSS VDD sky130_fd_sc_hd__tapvpwrvgnd_1
XTAP_TAPCELL_ROW_154_3270 VSS VDD sky130_fd_sc_hd__tapvpwrvgnd_1
XTAP_TAPCELL_ROW_154_3271 VSS VDD sky130_fd_sc_hd__tapvpwrvgnd_1
XTAP_TAPCELL_ROW_154_3272 VSS VDD sky130_fd_sc_hd__tapvpwrvgnd_1
XTAP_TAPCELL_ROW_154_3273 VSS VDD sky130_fd_sc_hd__tapvpwrvgnd_1
XTAP_TAPCELL_ROW_154_3274 VSS VDD sky130_fd_sc_hd__tapvpwrvgnd_1
XTAP_TAPCELL_ROW_154_3275 VSS VDD sky130_fd_sc_hd__tapvpwrvgnd_1
XTAP_TAPCELL_ROW_155_3276 VSS VDD sky130_fd_sc_hd__tapvpwrvgnd_1
XTAP_TAPCELL_ROW_155_3277 VSS VDD sky130_fd_sc_hd__tapvpwrvgnd_1
XTAP_TAPCELL_ROW_155_3278 VSS VDD sky130_fd_sc_hd__tapvpwrvgnd_1
XTAP_TAPCELL_ROW_155_3279 VSS VDD sky130_fd_sc_hd__tapvpwrvgnd_1
XTAP_TAPCELL_ROW_155_3280 VSS VDD sky130_fd_sc_hd__tapvpwrvgnd_1
XTAP_TAPCELL_ROW_155_3281 VSS VDD sky130_fd_sc_hd__tapvpwrvgnd_1
XTAP_TAPCELL_ROW_155_3282 VSS VDD sky130_fd_sc_hd__tapvpwrvgnd_1
XTAP_TAPCELL_ROW_155_3283 VSS VDD sky130_fd_sc_hd__tapvpwrvgnd_1
XTAP_TAPCELL_ROW_155_3284 VSS VDD sky130_fd_sc_hd__tapvpwrvgnd_1
XTAP_TAPCELL_ROW_155_3285 VSS VDD sky130_fd_sc_hd__tapvpwrvgnd_1
XTAP_TAPCELL_ROW_155_3286 VSS VDD sky130_fd_sc_hd__tapvpwrvgnd_1
XTAP_TAPCELL_ROW_155_3287 VSS VDD sky130_fd_sc_hd__tapvpwrvgnd_1
XTAP_TAPCELL_ROW_155_3288 VSS VDD sky130_fd_sc_hd__tapvpwrvgnd_1
XTAP_TAPCELL_ROW_155_3289 VSS VDD sky130_fd_sc_hd__tapvpwrvgnd_1
XTAP_TAPCELL_ROW_155_3290 VSS VDD sky130_fd_sc_hd__tapvpwrvgnd_1
XTAP_TAPCELL_ROW_155_3291 VSS VDD sky130_fd_sc_hd__tapvpwrvgnd_1
XTAP_TAPCELL_ROW_155_3292 VSS VDD sky130_fd_sc_hd__tapvpwrvgnd_1
XTAP_TAPCELL_ROW_155_3293 VSS VDD sky130_fd_sc_hd__tapvpwrvgnd_1
XTAP_TAPCELL_ROW_155_3294 VSS VDD sky130_fd_sc_hd__tapvpwrvgnd_1
XTAP_TAPCELL_ROW_155_3295 VSS VDD sky130_fd_sc_hd__tapvpwrvgnd_1
XTAP_TAPCELL_ROW_155_3296 VSS VDD sky130_fd_sc_hd__tapvpwrvgnd_1
XTAP_TAPCELL_ROW_156_3297 VSS VDD sky130_fd_sc_hd__tapvpwrvgnd_1
XTAP_TAPCELL_ROW_156_3298 VSS VDD sky130_fd_sc_hd__tapvpwrvgnd_1
XTAP_TAPCELL_ROW_156_3299 VSS VDD sky130_fd_sc_hd__tapvpwrvgnd_1
XTAP_TAPCELL_ROW_156_3300 VSS VDD sky130_fd_sc_hd__tapvpwrvgnd_1
XTAP_TAPCELL_ROW_156_3301 VSS VDD sky130_fd_sc_hd__tapvpwrvgnd_1
XTAP_TAPCELL_ROW_156_3302 VSS VDD sky130_fd_sc_hd__tapvpwrvgnd_1
XTAP_TAPCELL_ROW_156_3303 VSS VDD sky130_fd_sc_hd__tapvpwrvgnd_1
XTAP_TAPCELL_ROW_156_3304 VSS VDD sky130_fd_sc_hd__tapvpwrvgnd_1
XTAP_TAPCELL_ROW_156_3305 VSS VDD sky130_fd_sc_hd__tapvpwrvgnd_1
XTAP_TAPCELL_ROW_156_3306 VSS VDD sky130_fd_sc_hd__tapvpwrvgnd_1
XTAP_TAPCELL_ROW_156_3307 VSS VDD sky130_fd_sc_hd__tapvpwrvgnd_1
XTAP_TAPCELL_ROW_156_3308 VSS VDD sky130_fd_sc_hd__tapvpwrvgnd_1
XTAP_TAPCELL_ROW_156_3309 VSS VDD sky130_fd_sc_hd__tapvpwrvgnd_1
XTAP_TAPCELL_ROW_156_3310 VSS VDD sky130_fd_sc_hd__tapvpwrvgnd_1
XTAP_TAPCELL_ROW_156_3311 VSS VDD sky130_fd_sc_hd__tapvpwrvgnd_1
XTAP_TAPCELL_ROW_156_3312 VSS VDD sky130_fd_sc_hd__tapvpwrvgnd_1
XTAP_TAPCELL_ROW_156_3313 VSS VDD sky130_fd_sc_hd__tapvpwrvgnd_1
XTAP_TAPCELL_ROW_156_3314 VSS VDD sky130_fd_sc_hd__tapvpwrvgnd_1
XTAP_TAPCELL_ROW_156_3315 VSS VDD sky130_fd_sc_hd__tapvpwrvgnd_1
XTAP_TAPCELL_ROW_156_3316 VSS VDD sky130_fd_sc_hd__tapvpwrvgnd_1
XTAP_TAPCELL_ROW_156_3317 VSS VDD sky130_fd_sc_hd__tapvpwrvgnd_1
XTAP_TAPCELL_ROW_157_3318 VSS VDD sky130_fd_sc_hd__tapvpwrvgnd_1
XTAP_TAPCELL_ROW_157_3319 VSS VDD sky130_fd_sc_hd__tapvpwrvgnd_1
XTAP_TAPCELL_ROW_157_3320 VSS VDD sky130_fd_sc_hd__tapvpwrvgnd_1
XTAP_TAPCELL_ROW_157_3321 VSS VDD sky130_fd_sc_hd__tapvpwrvgnd_1
XTAP_TAPCELL_ROW_157_3322 VSS VDD sky130_fd_sc_hd__tapvpwrvgnd_1
XTAP_TAPCELL_ROW_157_3323 VSS VDD sky130_fd_sc_hd__tapvpwrvgnd_1
XTAP_TAPCELL_ROW_157_3324 VSS VDD sky130_fd_sc_hd__tapvpwrvgnd_1
XTAP_TAPCELL_ROW_157_3325 VSS VDD sky130_fd_sc_hd__tapvpwrvgnd_1
XTAP_TAPCELL_ROW_157_3326 VSS VDD sky130_fd_sc_hd__tapvpwrvgnd_1
XTAP_TAPCELL_ROW_157_3327 VSS VDD sky130_fd_sc_hd__tapvpwrvgnd_1
XTAP_TAPCELL_ROW_157_3328 VSS VDD sky130_fd_sc_hd__tapvpwrvgnd_1
XTAP_TAPCELL_ROW_157_3329 VSS VDD sky130_fd_sc_hd__tapvpwrvgnd_1
XTAP_TAPCELL_ROW_157_3330 VSS VDD sky130_fd_sc_hd__tapvpwrvgnd_1
XTAP_TAPCELL_ROW_157_3331 VSS VDD sky130_fd_sc_hd__tapvpwrvgnd_1
XTAP_TAPCELL_ROW_157_3332 VSS VDD sky130_fd_sc_hd__tapvpwrvgnd_1
XTAP_TAPCELL_ROW_157_3333 VSS VDD sky130_fd_sc_hd__tapvpwrvgnd_1
XTAP_TAPCELL_ROW_157_3334 VSS VDD sky130_fd_sc_hd__tapvpwrvgnd_1
XTAP_TAPCELL_ROW_157_3335 VSS VDD sky130_fd_sc_hd__tapvpwrvgnd_1
XTAP_TAPCELL_ROW_157_3336 VSS VDD sky130_fd_sc_hd__tapvpwrvgnd_1
XTAP_TAPCELL_ROW_157_3337 VSS VDD sky130_fd_sc_hd__tapvpwrvgnd_1
XTAP_TAPCELL_ROW_157_3338 VSS VDD sky130_fd_sc_hd__tapvpwrvgnd_1
XTAP_TAPCELL_ROW_158_3339 VSS VDD sky130_fd_sc_hd__tapvpwrvgnd_1
XTAP_TAPCELL_ROW_158_3340 VSS VDD sky130_fd_sc_hd__tapvpwrvgnd_1
XTAP_TAPCELL_ROW_158_3341 VSS VDD sky130_fd_sc_hd__tapvpwrvgnd_1
XTAP_TAPCELL_ROW_158_3342 VSS VDD sky130_fd_sc_hd__tapvpwrvgnd_1
XTAP_TAPCELL_ROW_158_3343 VSS VDD sky130_fd_sc_hd__tapvpwrvgnd_1
XTAP_TAPCELL_ROW_158_3344 VSS VDD sky130_fd_sc_hd__tapvpwrvgnd_1
XTAP_TAPCELL_ROW_158_3345 VSS VDD sky130_fd_sc_hd__tapvpwrvgnd_1
XTAP_TAPCELL_ROW_158_3346 VSS VDD sky130_fd_sc_hd__tapvpwrvgnd_1
XTAP_TAPCELL_ROW_158_3347 VSS VDD sky130_fd_sc_hd__tapvpwrvgnd_1
XTAP_TAPCELL_ROW_158_3348 VSS VDD sky130_fd_sc_hd__tapvpwrvgnd_1
XTAP_TAPCELL_ROW_158_3349 VSS VDD sky130_fd_sc_hd__tapvpwrvgnd_1
XTAP_TAPCELL_ROW_158_3350 VSS VDD sky130_fd_sc_hd__tapvpwrvgnd_1
XTAP_TAPCELL_ROW_158_3351 VSS VDD sky130_fd_sc_hd__tapvpwrvgnd_1
XTAP_TAPCELL_ROW_158_3352 VSS VDD sky130_fd_sc_hd__tapvpwrvgnd_1
XTAP_TAPCELL_ROW_158_3353 VSS VDD sky130_fd_sc_hd__tapvpwrvgnd_1
XTAP_TAPCELL_ROW_158_3354 VSS VDD sky130_fd_sc_hd__tapvpwrvgnd_1
XTAP_TAPCELL_ROW_158_3355 VSS VDD sky130_fd_sc_hd__tapvpwrvgnd_1
XTAP_TAPCELL_ROW_158_3356 VSS VDD sky130_fd_sc_hd__tapvpwrvgnd_1
XTAP_TAPCELL_ROW_158_3357 VSS VDD sky130_fd_sc_hd__tapvpwrvgnd_1
XTAP_TAPCELL_ROW_158_3358 VSS VDD sky130_fd_sc_hd__tapvpwrvgnd_1
XTAP_TAPCELL_ROW_158_3359 VSS VDD sky130_fd_sc_hd__tapvpwrvgnd_1
XTAP_TAPCELL_ROW_159_3360 VSS VDD sky130_fd_sc_hd__tapvpwrvgnd_1
XTAP_TAPCELL_ROW_159_3361 VSS VDD sky130_fd_sc_hd__tapvpwrvgnd_1
XTAP_TAPCELL_ROW_159_3362 VSS VDD sky130_fd_sc_hd__tapvpwrvgnd_1
XTAP_TAPCELL_ROW_159_3363 VSS VDD sky130_fd_sc_hd__tapvpwrvgnd_1
XTAP_TAPCELL_ROW_159_3364 VSS VDD sky130_fd_sc_hd__tapvpwrvgnd_1
XTAP_TAPCELL_ROW_159_3365 VSS VDD sky130_fd_sc_hd__tapvpwrvgnd_1
XTAP_TAPCELL_ROW_159_3366 VSS VDD sky130_fd_sc_hd__tapvpwrvgnd_1
XTAP_TAPCELL_ROW_159_3367 VSS VDD sky130_fd_sc_hd__tapvpwrvgnd_1
XTAP_TAPCELL_ROW_159_3368 VSS VDD sky130_fd_sc_hd__tapvpwrvgnd_1
XTAP_TAPCELL_ROW_159_3369 VSS VDD sky130_fd_sc_hd__tapvpwrvgnd_1
XTAP_TAPCELL_ROW_159_3370 VSS VDD sky130_fd_sc_hd__tapvpwrvgnd_1
XTAP_TAPCELL_ROW_159_3371 VSS VDD sky130_fd_sc_hd__tapvpwrvgnd_1
XTAP_TAPCELL_ROW_159_3372 VSS VDD sky130_fd_sc_hd__tapvpwrvgnd_1
XTAP_TAPCELL_ROW_159_3373 VSS VDD sky130_fd_sc_hd__tapvpwrvgnd_1
XTAP_TAPCELL_ROW_159_3374 VSS VDD sky130_fd_sc_hd__tapvpwrvgnd_1
XTAP_TAPCELL_ROW_159_3375 VSS VDD sky130_fd_sc_hd__tapvpwrvgnd_1
XTAP_TAPCELL_ROW_159_3376 VSS VDD sky130_fd_sc_hd__tapvpwrvgnd_1
XTAP_TAPCELL_ROW_159_3377 VSS VDD sky130_fd_sc_hd__tapvpwrvgnd_1
XTAP_TAPCELL_ROW_159_3378 VSS VDD sky130_fd_sc_hd__tapvpwrvgnd_1
XTAP_TAPCELL_ROW_159_3379 VSS VDD sky130_fd_sc_hd__tapvpwrvgnd_1
XTAP_TAPCELL_ROW_159_3380 VSS VDD sky130_fd_sc_hd__tapvpwrvgnd_1
XTAP_TAPCELL_ROW_160_3381 VSS VDD sky130_fd_sc_hd__tapvpwrvgnd_1
XTAP_TAPCELL_ROW_160_3382 VSS VDD sky130_fd_sc_hd__tapvpwrvgnd_1
XTAP_TAPCELL_ROW_160_3383 VSS VDD sky130_fd_sc_hd__tapvpwrvgnd_1
XTAP_TAPCELL_ROW_160_3384 VSS VDD sky130_fd_sc_hd__tapvpwrvgnd_1
XTAP_TAPCELL_ROW_160_3385 VSS VDD sky130_fd_sc_hd__tapvpwrvgnd_1
XTAP_TAPCELL_ROW_160_3386 VSS VDD sky130_fd_sc_hd__tapvpwrvgnd_1
XTAP_TAPCELL_ROW_160_3387 VSS VDD sky130_fd_sc_hd__tapvpwrvgnd_1
XTAP_TAPCELL_ROW_160_3388 VSS VDD sky130_fd_sc_hd__tapvpwrvgnd_1
XTAP_TAPCELL_ROW_160_3389 VSS VDD sky130_fd_sc_hd__tapvpwrvgnd_1
XTAP_TAPCELL_ROW_160_3390 VSS VDD sky130_fd_sc_hd__tapvpwrvgnd_1
XTAP_TAPCELL_ROW_160_3391 VSS VDD sky130_fd_sc_hd__tapvpwrvgnd_1
XTAP_TAPCELL_ROW_160_3392 VSS VDD sky130_fd_sc_hd__tapvpwrvgnd_1
XTAP_TAPCELL_ROW_160_3393 VSS VDD sky130_fd_sc_hd__tapvpwrvgnd_1
XTAP_TAPCELL_ROW_160_3394 VSS VDD sky130_fd_sc_hd__tapvpwrvgnd_1
XTAP_TAPCELL_ROW_160_3395 VSS VDD sky130_fd_sc_hd__tapvpwrvgnd_1
XTAP_TAPCELL_ROW_160_3396 VSS VDD sky130_fd_sc_hd__tapvpwrvgnd_1
XTAP_TAPCELL_ROW_160_3397 VSS VDD sky130_fd_sc_hd__tapvpwrvgnd_1
XTAP_TAPCELL_ROW_160_3398 VSS VDD sky130_fd_sc_hd__tapvpwrvgnd_1
XTAP_TAPCELL_ROW_160_3399 VSS VDD sky130_fd_sc_hd__tapvpwrvgnd_1
XTAP_TAPCELL_ROW_160_3400 VSS VDD sky130_fd_sc_hd__tapvpwrvgnd_1
XTAP_TAPCELL_ROW_160_3401 VSS VDD sky130_fd_sc_hd__tapvpwrvgnd_1
XTAP_TAPCELL_ROW_161_3402 VSS VDD sky130_fd_sc_hd__tapvpwrvgnd_1
XTAP_TAPCELL_ROW_161_3403 VSS VDD sky130_fd_sc_hd__tapvpwrvgnd_1
XTAP_TAPCELL_ROW_161_3404 VSS VDD sky130_fd_sc_hd__tapvpwrvgnd_1
XTAP_TAPCELL_ROW_161_3405 VSS VDD sky130_fd_sc_hd__tapvpwrvgnd_1
XTAP_TAPCELL_ROW_161_3406 VSS VDD sky130_fd_sc_hd__tapvpwrvgnd_1
XTAP_TAPCELL_ROW_161_3407 VSS VDD sky130_fd_sc_hd__tapvpwrvgnd_1
XTAP_TAPCELL_ROW_161_3408 VSS VDD sky130_fd_sc_hd__tapvpwrvgnd_1
XTAP_TAPCELL_ROW_161_3409 VSS VDD sky130_fd_sc_hd__tapvpwrvgnd_1
XTAP_TAPCELL_ROW_161_3410 VSS VDD sky130_fd_sc_hd__tapvpwrvgnd_1
XTAP_TAPCELL_ROW_161_3411 VSS VDD sky130_fd_sc_hd__tapvpwrvgnd_1
XTAP_TAPCELL_ROW_161_3412 VSS VDD sky130_fd_sc_hd__tapvpwrvgnd_1
XTAP_TAPCELL_ROW_161_3413 VSS VDD sky130_fd_sc_hd__tapvpwrvgnd_1
XTAP_TAPCELL_ROW_161_3414 VSS VDD sky130_fd_sc_hd__tapvpwrvgnd_1
XTAP_TAPCELL_ROW_161_3415 VSS VDD sky130_fd_sc_hd__tapvpwrvgnd_1
XTAP_TAPCELL_ROW_161_3416 VSS VDD sky130_fd_sc_hd__tapvpwrvgnd_1
XTAP_TAPCELL_ROW_161_3417 VSS VDD sky130_fd_sc_hd__tapvpwrvgnd_1
XTAP_TAPCELL_ROW_161_3418 VSS VDD sky130_fd_sc_hd__tapvpwrvgnd_1
XTAP_TAPCELL_ROW_161_3419 VSS VDD sky130_fd_sc_hd__tapvpwrvgnd_1
XTAP_TAPCELL_ROW_161_3420 VSS VDD sky130_fd_sc_hd__tapvpwrvgnd_1
XTAP_TAPCELL_ROW_161_3421 VSS VDD sky130_fd_sc_hd__tapvpwrvgnd_1
XTAP_TAPCELL_ROW_161_3422 VSS VDD sky130_fd_sc_hd__tapvpwrvgnd_1
XTAP_TAPCELL_ROW_162_3423 VSS VDD sky130_fd_sc_hd__tapvpwrvgnd_1
XTAP_TAPCELL_ROW_162_3424 VSS VDD sky130_fd_sc_hd__tapvpwrvgnd_1
XTAP_TAPCELL_ROW_162_3425 VSS VDD sky130_fd_sc_hd__tapvpwrvgnd_1
XTAP_TAPCELL_ROW_162_3426 VSS VDD sky130_fd_sc_hd__tapvpwrvgnd_1
XTAP_TAPCELL_ROW_162_3427 VSS VDD sky130_fd_sc_hd__tapvpwrvgnd_1
XTAP_TAPCELL_ROW_162_3428 VSS VDD sky130_fd_sc_hd__tapvpwrvgnd_1
XTAP_TAPCELL_ROW_162_3429 VSS VDD sky130_fd_sc_hd__tapvpwrvgnd_1
XTAP_TAPCELL_ROW_162_3430 VSS VDD sky130_fd_sc_hd__tapvpwrvgnd_1
XTAP_TAPCELL_ROW_162_3431 VSS VDD sky130_fd_sc_hd__tapvpwrvgnd_1
XTAP_TAPCELL_ROW_162_3432 VSS VDD sky130_fd_sc_hd__tapvpwrvgnd_1
XTAP_TAPCELL_ROW_162_3433 VSS VDD sky130_fd_sc_hd__tapvpwrvgnd_1
XTAP_TAPCELL_ROW_162_3434 VSS VDD sky130_fd_sc_hd__tapvpwrvgnd_1
XTAP_TAPCELL_ROW_162_3435 VSS VDD sky130_fd_sc_hd__tapvpwrvgnd_1
XTAP_TAPCELL_ROW_162_3436 VSS VDD sky130_fd_sc_hd__tapvpwrvgnd_1
XTAP_TAPCELL_ROW_162_3437 VSS VDD sky130_fd_sc_hd__tapvpwrvgnd_1
XTAP_TAPCELL_ROW_162_3438 VSS VDD sky130_fd_sc_hd__tapvpwrvgnd_1
XTAP_TAPCELL_ROW_162_3439 VSS VDD sky130_fd_sc_hd__tapvpwrvgnd_1
XTAP_TAPCELL_ROW_162_3440 VSS VDD sky130_fd_sc_hd__tapvpwrvgnd_1
XTAP_TAPCELL_ROW_162_3441 VSS VDD sky130_fd_sc_hd__tapvpwrvgnd_1
XTAP_TAPCELL_ROW_162_3442 VSS VDD sky130_fd_sc_hd__tapvpwrvgnd_1
XTAP_TAPCELL_ROW_162_3443 VSS VDD sky130_fd_sc_hd__tapvpwrvgnd_1
XTAP_TAPCELL_ROW_163_3444 VSS VDD sky130_fd_sc_hd__tapvpwrvgnd_1
XTAP_TAPCELL_ROW_163_3445 VSS VDD sky130_fd_sc_hd__tapvpwrvgnd_1
XTAP_TAPCELL_ROW_163_3446 VSS VDD sky130_fd_sc_hd__tapvpwrvgnd_1
XTAP_TAPCELL_ROW_163_3447 VSS VDD sky130_fd_sc_hd__tapvpwrvgnd_1
XTAP_TAPCELL_ROW_163_3448 VSS VDD sky130_fd_sc_hd__tapvpwrvgnd_1
XTAP_TAPCELL_ROW_163_3449 VSS VDD sky130_fd_sc_hd__tapvpwrvgnd_1
XTAP_TAPCELL_ROW_163_3450 VSS VDD sky130_fd_sc_hd__tapvpwrvgnd_1
XTAP_TAPCELL_ROW_163_3451 VSS VDD sky130_fd_sc_hd__tapvpwrvgnd_1
XTAP_TAPCELL_ROW_163_3452 VSS VDD sky130_fd_sc_hd__tapvpwrvgnd_1
XTAP_TAPCELL_ROW_163_3453 VSS VDD sky130_fd_sc_hd__tapvpwrvgnd_1
XTAP_TAPCELL_ROW_163_3454 VSS VDD sky130_fd_sc_hd__tapvpwrvgnd_1
XTAP_TAPCELL_ROW_163_3455 VSS VDD sky130_fd_sc_hd__tapvpwrvgnd_1
XTAP_TAPCELL_ROW_163_3456 VSS VDD sky130_fd_sc_hd__tapvpwrvgnd_1
XTAP_TAPCELL_ROW_163_3457 VSS VDD sky130_fd_sc_hd__tapvpwrvgnd_1
XTAP_TAPCELL_ROW_163_3458 VSS VDD sky130_fd_sc_hd__tapvpwrvgnd_1
XTAP_TAPCELL_ROW_163_3459 VSS VDD sky130_fd_sc_hd__tapvpwrvgnd_1
XTAP_TAPCELL_ROW_163_3460 VSS VDD sky130_fd_sc_hd__tapvpwrvgnd_1
XTAP_TAPCELL_ROW_163_3461 VSS VDD sky130_fd_sc_hd__tapvpwrvgnd_1
XTAP_TAPCELL_ROW_163_3462 VSS VDD sky130_fd_sc_hd__tapvpwrvgnd_1
XTAP_TAPCELL_ROW_163_3463 VSS VDD sky130_fd_sc_hd__tapvpwrvgnd_1
XTAP_TAPCELL_ROW_163_3464 VSS VDD sky130_fd_sc_hd__tapvpwrvgnd_1
XTAP_TAPCELL_ROW_164_3465 VSS VDD sky130_fd_sc_hd__tapvpwrvgnd_1
XTAP_TAPCELL_ROW_164_3466 VSS VDD sky130_fd_sc_hd__tapvpwrvgnd_1
XTAP_TAPCELL_ROW_164_3467 VSS VDD sky130_fd_sc_hd__tapvpwrvgnd_1
XTAP_TAPCELL_ROW_164_3468 VSS VDD sky130_fd_sc_hd__tapvpwrvgnd_1
XTAP_TAPCELL_ROW_164_3469 VSS VDD sky130_fd_sc_hd__tapvpwrvgnd_1
XTAP_TAPCELL_ROW_164_3470 VSS VDD sky130_fd_sc_hd__tapvpwrvgnd_1
XTAP_TAPCELL_ROW_164_3471 VSS VDD sky130_fd_sc_hd__tapvpwrvgnd_1
XTAP_TAPCELL_ROW_164_3472 VSS VDD sky130_fd_sc_hd__tapvpwrvgnd_1
XTAP_TAPCELL_ROW_164_3473 VSS VDD sky130_fd_sc_hd__tapvpwrvgnd_1
XTAP_TAPCELL_ROW_164_3474 VSS VDD sky130_fd_sc_hd__tapvpwrvgnd_1
XTAP_TAPCELL_ROW_164_3475 VSS VDD sky130_fd_sc_hd__tapvpwrvgnd_1
XTAP_TAPCELL_ROW_164_3476 VSS VDD sky130_fd_sc_hd__tapvpwrvgnd_1
XTAP_TAPCELL_ROW_164_3477 VSS VDD sky130_fd_sc_hd__tapvpwrvgnd_1
XTAP_TAPCELL_ROW_164_3478 VSS VDD sky130_fd_sc_hd__tapvpwrvgnd_1
XTAP_TAPCELL_ROW_164_3479 VSS VDD sky130_fd_sc_hd__tapvpwrvgnd_1
XTAP_TAPCELL_ROW_164_3480 VSS VDD sky130_fd_sc_hd__tapvpwrvgnd_1
XTAP_TAPCELL_ROW_164_3481 VSS VDD sky130_fd_sc_hd__tapvpwrvgnd_1
XTAP_TAPCELL_ROW_164_3482 VSS VDD sky130_fd_sc_hd__tapvpwrvgnd_1
XTAP_TAPCELL_ROW_164_3483 VSS VDD sky130_fd_sc_hd__tapvpwrvgnd_1
XTAP_TAPCELL_ROW_164_3484 VSS VDD sky130_fd_sc_hd__tapvpwrvgnd_1
XTAP_TAPCELL_ROW_164_3485 VSS VDD sky130_fd_sc_hd__tapvpwrvgnd_1
XTAP_TAPCELL_ROW_165_3486 VSS VDD sky130_fd_sc_hd__tapvpwrvgnd_1
XTAP_TAPCELL_ROW_165_3487 VSS VDD sky130_fd_sc_hd__tapvpwrvgnd_1
XTAP_TAPCELL_ROW_165_3488 VSS VDD sky130_fd_sc_hd__tapvpwrvgnd_1
XTAP_TAPCELL_ROW_165_3489 VSS VDD sky130_fd_sc_hd__tapvpwrvgnd_1
XTAP_TAPCELL_ROW_165_3490 VSS VDD sky130_fd_sc_hd__tapvpwrvgnd_1
XTAP_TAPCELL_ROW_165_3491 VSS VDD sky130_fd_sc_hd__tapvpwrvgnd_1
XTAP_TAPCELL_ROW_165_3492 VSS VDD sky130_fd_sc_hd__tapvpwrvgnd_1
XTAP_TAPCELL_ROW_165_3493 VSS VDD sky130_fd_sc_hd__tapvpwrvgnd_1
XTAP_TAPCELL_ROW_165_3494 VSS VDD sky130_fd_sc_hd__tapvpwrvgnd_1
XTAP_TAPCELL_ROW_165_3495 VSS VDD sky130_fd_sc_hd__tapvpwrvgnd_1
XTAP_TAPCELL_ROW_165_3496 VSS VDD sky130_fd_sc_hd__tapvpwrvgnd_1
XTAP_TAPCELL_ROW_165_3497 VSS VDD sky130_fd_sc_hd__tapvpwrvgnd_1
XTAP_TAPCELL_ROW_165_3498 VSS VDD sky130_fd_sc_hd__tapvpwrvgnd_1
XTAP_TAPCELL_ROW_165_3499 VSS VDD sky130_fd_sc_hd__tapvpwrvgnd_1
XTAP_TAPCELL_ROW_165_3500 VSS VDD sky130_fd_sc_hd__tapvpwrvgnd_1
XTAP_TAPCELL_ROW_165_3501 VSS VDD sky130_fd_sc_hd__tapvpwrvgnd_1
XTAP_TAPCELL_ROW_165_3502 VSS VDD sky130_fd_sc_hd__tapvpwrvgnd_1
XTAP_TAPCELL_ROW_165_3503 VSS VDD sky130_fd_sc_hd__tapvpwrvgnd_1
XTAP_TAPCELL_ROW_165_3504 VSS VDD sky130_fd_sc_hd__tapvpwrvgnd_1
XTAP_TAPCELL_ROW_165_3505 VSS VDD sky130_fd_sc_hd__tapvpwrvgnd_1
XTAP_TAPCELL_ROW_165_3506 VSS VDD sky130_fd_sc_hd__tapvpwrvgnd_1
XTAP_TAPCELL_ROW_166_3507 VSS VDD sky130_fd_sc_hd__tapvpwrvgnd_1
XTAP_TAPCELL_ROW_166_3508 VSS VDD sky130_fd_sc_hd__tapvpwrvgnd_1
XTAP_TAPCELL_ROW_166_3509 VSS VDD sky130_fd_sc_hd__tapvpwrvgnd_1
XTAP_TAPCELL_ROW_166_3510 VSS VDD sky130_fd_sc_hd__tapvpwrvgnd_1
XTAP_TAPCELL_ROW_166_3511 VSS VDD sky130_fd_sc_hd__tapvpwrvgnd_1
XTAP_TAPCELL_ROW_166_3512 VSS VDD sky130_fd_sc_hd__tapvpwrvgnd_1
XTAP_TAPCELL_ROW_166_3513 VSS VDD sky130_fd_sc_hd__tapvpwrvgnd_1
XTAP_TAPCELL_ROW_166_3514 VSS VDD sky130_fd_sc_hd__tapvpwrvgnd_1
XTAP_TAPCELL_ROW_166_3515 VSS VDD sky130_fd_sc_hd__tapvpwrvgnd_1
XTAP_TAPCELL_ROW_166_3516 VSS VDD sky130_fd_sc_hd__tapvpwrvgnd_1
XTAP_TAPCELL_ROW_166_3517 VSS VDD sky130_fd_sc_hd__tapvpwrvgnd_1
XTAP_TAPCELL_ROW_166_3518 VSS VDD sky130_fd_sc_hd__tapvpwrvgnd_1
XTAP_TAPCELL_ROW_166_3519 VSS VDD sky130_fd_sc_hd__tapvpwrvgnd_1
XTAP_TAPCELL_ROW_166_3520 VSS VDD sky130_fd_sc_hd__tapvpwrvgnd_1
XTAP_TAPCELL_ROW_166_3521 VSS VDD sky130_fd_sc_hd__tapvpwrvgnd_1
XTAP_TAPCELL_ROW_166_3522 VSS VDD sky130_fd_sc_hd__tapvpwrvgnd_1
XTAP_TAPCELL_ROW_166_3523 VSS VDD sky130_fd_sc_hd__tapvpwrvgnd_1
XTAP_TAPCELL_ROW_166_3524 VSS VDD sky130_fd_sc_hd__tapvpwrvgnd_1
XTAP_TAPCELL_ROW_166_3525 VSS VDD sky130_fd_sc_hd__tapvpwrvgnd_1
XTAP_TAPCELL_ROW_166_3526 VSS VDD sky130_fd_sc_hd__tapvpwrvgnd_1
XTAP_TAPCELL_ROW_166_3527 VSS VDD sky130_fd_sc_hd__tapvpwrvgnd_1
XTAP_TAPCELL_ROW_167_3528 VSS VDD sky130_fd_sc_hd__tapvpwrvgnd_1
XTAP_TAPCELL_ROW_167_3529 VSS VDD sky130_fd_sc_hd__tapvpwrvgnd_1
XTAP_TAPCELL_ROW_167_3530 VSS VDD sky130_fd_sc_hd__tapvpwrvgnd_1
XTAP_TAPCELL_ROW_167_3531 VSS VDD sky130_fd_sc_hd__tapvpwrvgnd_1
XTAP_TAPCELL_ROW_167_3532 VSS VDD sky130_fd_sc_hd__tapvpwrvgnd_1
XTAP_TAPCELL_ROW_167_3533 VSS VDD sky130_fd_sc_hd__tapvpwrvgnd_1
XTAP_TAPCELL_ROW_167_3534 VSS VDD sky130_fd_sc_hd__tapvpwrvgnd_1
XTAP_TAPCELL_ROW_167_3535 VSS VDD sky130_fd_sc_hd__tapvpwrvgnd_1
XTAP_TAPCELL_ROW_167_3536 VSS VDD sky130_fd_sc_hd__tapvpwrvgnd_1
XTAP_TAPCELL_ROW_167_3537 VSS VDD sky130_fd_sc_hd__tapvpwrvgnd_1
XTAP_TAPCELL_ROW_167_3538 VSS VDD sky130_fd_sc_hd__tapvpwrvgnd_1
XTAP_TAPCELL_ROW_167_3539 VSS VDD sky130_fd_sc_hd__tapvpwrvgnd_1
XTAP_TAPCELL_ROW_167_3540 VSS VDD sky130_fd_sc_hd__tapvpwrvgnd_1
XTAP_TAPCELL_ROW_167_3541 VSS VDD sky130_fd_sc_hd__tapvpwrvgnd_1
XTAP_TAPCELL_ROW_167_3542 VSS VDD sky130_fd_sc_hd__tapvpwrvgnd_1
XTAP_TAPCELL_ROW_167_3543 VSS VDD sky130_fd_sc_hd__tapvpwrvgnd_1
XTAP_TAPCELL_ROW_167_3544 VSS VDD sky130_fd_sc_hd__tapvpwrvgnd_1
XTAP_TAPCELL_ROW_167_3545 VSS VDD sky130_fd_sc_hd__tapvpwrvgnd_1
XTAP_TAPCELL_ROW_167_3546 VSS VDD sky130_fd_sc_hd__tapvpwrvgnd_1
XTAP_TAPCELL_ROW_167_3547 VSS VDD sky130_fd_sc_hd__tapvpwrvgnd_1
XTAP_TAPCELL_ROW_167_3548 VSS VDD sky130_fd_sc_hd__tapvpwrvgnd_1
XTAP_TAPCELL_ROW_168_3549 VSS VDD sky130_fd_sc_hd__tapvpwrvgnd_1
XTAP_TAPCELL_ROW_168_3550 VSS VDD sky130_fd_sc_hd__tapvpwrvgnd_1
XTAP_TAPCELL_ROW_168_3551 VSS VDD sky130_fd_sc_hd__tapvpwrvgnd_1
XTAP_TAPCELL_ROW_168_3552 VSS VDD sky130_fd_sc_hd__tapvpwrvgnd_1
XTAP_TAPCELL_ROW_168_3553 VSS VDD sky130_fd_sc_hd__tapvpwrvgnd_1
XTAP_TAPCELL_ROW_168_3554 VSS VDD sky130_fd_sc_hd__tapvpwrvgnd_1
XTAP_TAPCELL_ROW_168_3555 VSS VDD sky130_fd_sc_hd__tapvpwrvgnd_1
XTAP_TAPCELL_ROW_168_3556 VSS VDD sky130_fd_sc_hd__tapvpwrvgnd_1
XTAP_TAPCELL_ROW_168_3557 VSS VDD sky130_fd_sc_hd__tapvpwrvgnd_1
XTAP_TAPCELL_ROW_168_3558 VSS VDD sky130_fd_sc_hd__tapvpwrvgnd_1
XTAP_TAPCELL_ROW_168_3559 VSS VDD sky130_fd_sc_hd__tapvpwrvgnd_1
XTAP_TAPCELL_ROW_168_3560 VSS VDD sky130_fd_sc_hd__tapvpwrvgnd_1
XTAP_TAPCELL_ROW_168_3561 VSS VDD sky130_fd_sc_hd__tapvpwrvgnd_1
XTAP_TAPCELL_ROW_168_3562 VSS VDD sky130_fd_sc_hd__tapvpwrvgnd_1
XTAP_TAPCELL_ROW_168_3563 VSS VDD sky130_fd_sc_hd__tapvpwrvgnd_1
XTAP_TAPCELL_ROW_168_3564 VSS VDD sky130_fd_sc_hd__tapvpwrvgnd_1
XTAP_TAPCELL_ROW_168_3565 VSS VDD sky130_fd_sc_hd__tapvpwrvgnd_1
XTAP_TAPCELL_ROW_168_3566 VSS VDD sky130_fd_sc_hd__tapvpwrvgnd_1
XTAP_TAPCELL_ROW_168_3567 VSS VDD sky130_fd_sc_hd__tapvpwrvgnd_1
XTAP_TAPCELL_ROW_168_3568 VSS VDD sky130_fd_sc_hd__tapvpwrvgnd_1
XTAP_TAPCELL_ROW_168_3569 VSS VDD sky130_fd_sc_hd__tapvpwrvgnd_1
XTAP_TAPCELL_ROW_169_3570 VSS VDD sky130_fd_sc_hd__tapvpwrvgnd_1
XTAP_TAPCELL_ROW_169_3571 VSS VDD sky130_fd_sc_hd__tapvpwrvgnd_1
XTAP_TAPCELL_ROW_169_3572 VSS VDD sky130_fd_sc_hd__tapvpwrvgnd_1
XTAP_TAPCELL_ROW_169_3573 VSS VDD sky130_fd_sc_hd__tapvpwrvgnd_1
XTAP_TAPCELL_ROW_169_3574 VSS VDD sky130_fd_sc_hd__tapvpwrvgnd_1
XTAP_TAPCELL_ROW_169_3575 VSS VDD sky130_fd_sc_hd__tapvpwrvgnd_1
XTAP_TAPCELL_ROW_169_3576 VSS VDD sky130_fd_sc_hd__tapvpwrvgnd_1
XTAP_TAPCELL_ROW_169_3577 VSS VDD sky130_fd_sc_hd__tapvpwrvgnd_1
XTAP_TAPCELL_ROW_169_3578 VSS VDD sky130_fd_sc_hd__tapvpwrvgnd_1
XTAP_TAPCELL_ROW_169_3579 VSS VDD sky130_fd_sc_hd__tapvpwrvgnd_1
XTAP_TAPCELL_ROW_169_3580 VSS VDD sky130_fd_sc_hd__tapvpwrvgnd_1
XTAP_TAPCELL_ROW_169_3581 VSS VDD sky130_fd_sc_hd__tapvpwrvgnd_1
XTAP_TAPCELL_ROW_169_3582 VSS VDD sky130_fd_sc_hd__tapvpwrvgnd_1
XTAP_TAPCELL_ROW_169_3583 VSS VDD sky130_fd_sc_hd__tapvpwrvgnd_1
XTAP_TAPCELL_ROW_169_3584 VSS VDD sky130_fd_sc_hd__tapvpwrvgnd_1
XTAP_TAPCELL_ROW_169_3585 VSS VDD sky130_fd_sc_hd__tapvpwrvgnd_1
XTAP_TAPCELL_ROW_169_3586 VSS VDD sky130_fd_sc_hd__tapvpwrvgnd_1
XTAP_TAPCELL_ROW_169_3587 VSS VDD sky130_fd_sc_hd__tapvpwrvgnd_1
XTAP_TAPCELL_ROW_169_3588 VSS VDD sky130_fd_sc_hd__tapvpwrvgnd_1
XTAP_TAPCELL_ROW_169_3589 VSS VDD sky130_fd_sc_hd__tapvpwrvgnd_1
XTAP_TAPCELL_ROW_169_3590 VSS VDD sky130_fd_sc_hd__tapvpwrvgnd_1
XTAP_TAPCELL_ROW_170_3591 VSS VDD sky130_fd_sc_hd__tapvpwrvgnd_1
XTAP_TAPCELL_ROW_170_3592 VSS VDD sky130_fd_sc_hd__tapvpwrvgnd_1
XTAP_TAPCELL_ROW_170_3593 VSS VDD sky130_fd_sc_hd__tapvpwrvgnd_1
XTAP_TAPCELL_ROW_170_3594 VSS VDD sky130_fd_sc_hd__tapvpwrvgnd_1
XTAP_TAPCELL_ROW_170_3595 VSS VDD sky130_fd_sc_hd__tapvpwrvgnd_1
XTAP_TAPCELL_ROW_170_3596 VSS VDD sky130_fd_sc_hd__tapvpwrvgnd_1
XTAP_TAPCELL_ROW_170_3597 VSS VDD sky130_fd_sc_hd__tapvpwrvgnd_1
XTAP_TAPCELL_ROW_170_3598 VSS VDD sky130_fd_sc_hd__tapvpwrvgnd_1
XTAP_TAPCELL_ROW_170_3599 VSS VDD sky130_fd_sc_hd__tapvpwrvgnd_1
XTAP_TAPCELL_ROW_170_3600 VSS VDD sky130_fd_sc_hd__tapvpwrvgnd_1
XTAP_TAPCELL_ROW_170_3601 VSS VDD sky130_fd_sc_hd__tapvpwrvgnd_1
XTAP_TAPCELL_ROW_170_3602 VSS VDD sky130_fd_sc_hd__tapvpwrvgnd_1
XTAP_TAPCELL_ROW_170_3603 VSS VDD sky130_fd_sc_hd__tapvpwrvgnd_1
XTAP_TAPCELL_ROW_170_3604 VSS VDD sky130_fd_sc_hd__tapvpwrvgnd_1
XTAP_TAPCELL_ROW_170_3605 VSS VDD sky130_fd_sc_hd__tapvpwrvgnd_1
XTAP_TAPCELL_ROW_170_3606 VSS VDD sky130_fd_sc_hd__tapvpwrvgnd_1
XTAP_TAPCELL_ROW_170_3607 VSS VDD sky130_fd_sc_hd__tapvpwrvgnd_1
XTAP_TAPCELL_ROW_170_3608 VSS VDD sky130_fd_sc_hd__tapvpwrvgnd_1
XTAP_TAPCELL_ROW_170_3609 VSS VDD sky130_fd_sc_hd__tapvpwrvgnd_1
XTAP_TAPCELL_ROW_170_3610 VSS VDD sky130_fd_sc_hd__tapvpwrvgnd_1
XTAP_TAPCELL_ROW_170_3611 VSS VDD sky130_fd_sc_hd__tapvpwrvgnd_1
XTAP_TAPCELL_ROW_171_3612 VSS VDD sky130_fd_sc_hd__tapvpwrvgnd_1
XTAP_TAPCELL_ROW_171_3613 VSS VDD sky130_fd_sc_hd__tapvpwrvgnd_1
XTAP_TAPCELL_ROW_171_3614 VSS VDD sky130_fd_sc_hd__tapvpwrvgnd_1
XTAP_TAPCELL_ROW_171_3615 VSS VDD sky130_fd_sc_hd__tapvpwrvgnd_1
XTAP_TAPCELL_ROW_171_3616 VSS VDD sky130_fd_sc_hd__tapvpwrvgnd_1
XTAP_TAPCELL_ROW_171_3617 VSS VDD sky130_fd_sc_hd__tapvpwrvgnd_1
XTAP_TAPCELL_ROW_171_3618 VSS VDD sky130_fd_sc_hd__tapvpwrvgnd_1
XTAP_TAPCELL_ROW_171_3619 VSS VDD sky130_fd_sc_hd__tapvpwrvgnd_1
XTAP_TAPCELL_ROW_171_3620 VSS VDD sky130_fd_sc_hd__tapvpwrvgnd_1
XTAP_TAPCELL_ROW_171_3621 VSS VDD sky130_fd_sc_hd__tapvpwrvgnd_1
XTAP_TAPCELL_ROW_171_3622 VSS VDD sky130_fd_sc_hd__tapvpwrvgnd_1
XTAP_TAPCELL_ROW_171_3623 VSS VDD sky130_fd_sc_hd__tapvpwrvgnd_1
XTAP_TAPCELL_ROW_171_3624 VSS VDD sky130_fd_sc_hd__tapvpwrvgnd_1
XTAP_TAPCELL_ROW_171_3625 VSS VDD sky130_fd_sc_hd__tapvpwrvgnd_1
XTAP_TAPCELL_ROW_171_3626 VSS VDD sky130_fd_sc_hd__tapvpwrvgnd_1
XTAP_TAPCELL_ROW_171_3627 VSS VDD sky130_fd_sc_hd__tapvpwrvgnd_1
XTAP_TAPCELL_ROW_171_3628 VSS VDD sky130_fd_sc_hd__tapvpwrvgnd_1
XTAP_TAPCELL_ROW_171_3629 VSS VDD sky130_fd_sc_hd__tapvpwrvgnd_1
XTAP_TAPCELL_ROW_171_3630 VSS VDD sky130_fd_sc_hd__tapvpwrvgnd_1
XTAP_TAPCELL_ROW_171_3631 VSS VDD sky130_fd_sc_hd__tapvpwrvgnd_1
XTAP_TAPCELL_ROW_171_3632 VSS VDD sky130_fd_sc_hd__tapvpwrvgnd_1
XTAP_TAPCELL_ROW_172_3633 VSS VDD sky130_fd_sc_hd__tapvpwrvgnd_1
XTAP_TAPCELL_ROW_172_3634 VSS VDD sky130_fd_sc_hd__tapvpwrvgnd_1
XTAP_TAPCELL_ROW_172_3635 VSS VDD sky130_fd_sc_hd__tapvpwrvgnd_1
XTAP_TAPCELL_ROW_172_3636 VSS VDD sky130_fd_sc_hd__tapvpwrvgnd_1
XTAP_TAPCELL_ROW_172_3637 VSS VDD sky130_fd_sc_hd__tapvpwrvgnd_1
XTAP_TAPCELL_ROW_172_3638 VSS VDD sky130_fd_sc_hd__tapvpwrvgnd_1
XTAP_TAPCELL_ROW_172_3639 VSS VDD sky130_fd_sc_hd__tapvpwrvgnd_1
XTAP_TAPCELL_ROW_172_3640 VSS VDD sky130_fd_sc_hd__tapvpwrvgnd_1
XTAP_TAPCELL_ROW_172_3641 VSS VDD sky130_fd_sc_hd__tapvpwrvgnd_1
XTAP_TAPCELL_ROW_172_3642 VSS VDD sky130_fd_sc_hd__tapvpwrvgnd_1
XTAP_TAPCELL_ROW_172_3643 VSS VDD sky130_fd_sc_hd__tapvpwrvgnd_1
XTAP_TAPCELL_ROW_172_3644 VSS VDD sky130_fd_sc_hd__tapvpwrvgnd_1
XTAP_TAPCELL_ROW_172_3645 VSS VDD sky130_fd_sc_hd__tapvpwrvgnd_1
XTAP_TAPCELL_ROW_172_3646 VSS VDD sky130_fd_sc_hd__tapvpwrvgnd_1
XTAP_TAPCELL_ROW_172_3647 VSS VDD sky130_fd_sc_hd__tapvpwrvgnd_1
XTAP_TAPCELL_ROW_172_3648 VSS VDD sky130_fd_sc_hd__tapvpwrvgnd_1
XTAP_TAPCELL_ROW_172_3649 VSS VDD sky130_fd_sc_hd__tapvpwrvgnd_1
XTAP_TAPCELL_ROW_172_3650 VSS VDD sky130_fd_sc_hd__tapvpwrvgnd_1
XTAP_TAPCELL_ROW_172_3651 VSS VDD sky130_fd_sc_hd__tapvpwrvgnd_1
XTAP_TAPCELL_ROW_172_3652 VSS VDD sky130_fd_sc_hd__tapvpwrvgnd_1
XTAP_TAPCELL_ROW_172_3653 VSS VDD sky130_fd_sc_hd__tapvpwrvgnd_1
XTAP_TAPCELL_ROW_173_3654 VSS VDD sky130_fd_sc_hd__tapvpwrvgnd_1
XTAP_TAPCELL_ROW_173_3655 VSS VDD sky130_fd_sc_hd__tapvpwrvgnd_1
XTAP_TAPCELL_ROW_173_3656 VSS VDD sky130_fd_sc_hd__tapvpwrvgnd_1
XTAP_TAPCELL_ROW_173_3657 VSS VDD sky130_fd_sc_hd__tapvpwrvgnd_1
XTAP_TAPCELL_ROW_173_3658 VSS VDD sky130_fd_sc_hd__tapvpwrvgnd_1
XTAP_TAPCELL_ROW_173_3659 VSS VDD sky130_fd_sc_hd__tapvpwrvgnd_1
XTAP_TAPCELL_ROW_173_3660 VSS VDD sky130_fd_sc_hd__tapvpwrvgnd_1
XTAP_TAPCELL_ROW_173_3661 VSS VDD sky130_fd_sc_hd__tapvpwrvgnd_1
XTAP_TAPCELL_ROW_173_3662 VSS VDD sky130_fd_sc_hd__tapvpwrvgnd_1
XTAP_TAPCELL_ROW_173_3663 VSS VDD sky130_fd_sc_hd__tapvpwrvgnd_1
XTAP_TAPCELL_ROW_173_3664 VSS VDD sky130_fd_sc_hd__tapvpwrvgnd_1
XTAP_TAPCELL_ROW_173_3665 VSS VDD sky130_fd_sc_hd__tapvpwrvgnd_1
XTAP_TAPCELL_ROW_173_3666 VSS VDD sky130_fd_sc_hd__tapvpwrvgnd_1
XTAP_TAPCELL_ROW_173_3667 VSS VDD sky130_fd_sc_hd__tapvpwrvgnd_1
XTAP_TAPCELL_ROW_173_3668 VSS VDD sky130_fd_sc_hd__tapvpwrvgnd_1
XTAP_TAPCELL_ROW_173_3669 VSS VDD sky130_fd_sc_hd__tapvpwrvgnd_1
XTAP_TAPCELL_ROW_173_3670 VSS VDD sky130_fd_sc_hd__tapvpwrvgnd_1
XTAP_TAPCELL_ROW_173_3671 VSS VDD sky130_fd_sc_hd__tapvpwrvgnd_1
XTAP_TAPCELL_ROW_173_3672 VSS VDD sky130_fd_sc_hd__tapvpwrvgnd_1
XTAP_TAPCELL_ROW_173_3673 VSS VDD sky130_fd_sc_hd__tapvpwrvgnd_1
XTAP_TAPCELL_ROW_173_3674 VSS VDD sky130_fd_sc_hd__tapvpwrvgnd_1
XTAP_TAPCELL_ROW_174_3675 VSS VDD sky130_fd_sc_hd__tapvpwrvgnd_1
XTAP_TAPCELL_ROW_174_3676 VSS VDD sky130_fd_sc_hd__tapvpwrvgnd_1
XTAP_TAPCELL_ROW_174_3677 VSS VDD sky130_fd_sc_hd__tapvpwrvgnd_1
XTAP_TAPCELL_ROW_174_3678 VSS VDD sky130_fd_sc_hd__tapvpwrvgnd_1
XTAP_TAPCELL_ROW_174_3679 VSS VDD sky130_fd_sc_hd__tapvpwrvgnd_1
XTAP_TAPCELL_ROW_174_3680 VSS VDD sky130_fd_sc_hd__tapvpwrvgnd_1
XTAP_TAPCELL_ROW_174_3681 VSS VDD sky130_fd_sc_hd__tapvpwrvgnd_1
XTAP_TAPCELL_ROW_174_3682 VSS VDD sky130_fd_sc_hd__tapvpwrvgnd_1
XTAP_TAPCELL_ROW_174_3683 VSS VDD sky130_fd_sc_hd__tapvpwrvgnd_1
XTAP_TAPCELL_ROW_174_3684 VSS VDD sky130_fd_sc_hd__tapvpwrvgnd_1
XTAP_TAPCELL_ROW_174_3685 VSS VDD sky130_fd_sc_hd__tapvpwrvgnd_1
XTAP_TAPCELL_ROW_174_3686 VSS VDD sky130_fd_sc_hd__tapvpwrvgnd_1
XTAP_TAPCELL_ROW_174_3687 VSS VDD sky130_fd_sc_hd__tapvpwrvgnd_1
XTAP_TAPCELL_ROW_174_3688 VSS VDD sky130_fd_sc_hd__tapvpwrvgnd_1
XTAP_TAPCELL_ROW_174_3689 VSS VDD sky130_fd_sc_hd__tapvpwrvgnd_1
XTAP_TAPCELL_ROW_174_3690 VSS VDD sky130_fd_sc_hd__tapvpwrvgnd_1
XTAP_TAPCELL_ROW_174_3691 VSS VDD sky130_fd_sc_hd__tapvpwrvgnd_1
XTAP_TAPCELL_ROW_174_3692 VSS VDD sky130_fd_sc_hd__tapvpwrvgnd_1
XTAP_TAPCELL_ROW_174_3693 VSS VDD sky130_fd_sc_hd__tapvpwrvgnd_1
XTAP_TAPCELL_ROW_174_3694 VSS VDD sky130_fd_sc_hd__tapvpwrvgnd_1
XTAP_TAPCELL_ROW_174_3695 VSS VDD sky130_fd_sc_hd__tapvpwrvgnd_1
XTAP_TAPCELL_ROW_175_3696 VSS VDD sky130_fd_sc_hd__tapvpwrvgnd_1
XTAP_TAPCELL_ROW_175_3697 VSS VDD sky130_fd_sc_hd__tapvpwrvgnd_1
XTAP_TAPCELL_ROW_175_3698 VSS VDD sky130_fd_sc_hd__tapvpwrvgnd_1
XTAP_TAPCELL_ROW_175_3699 VSS VDD sky130_fd_sc_hd__tapvpwrvgnd_1
XTAP_TAPCELL_ROW_175_3700 VSS VDD sky130_fd_sc_hd__tapvpwrvgnd_1
XTAP_TAPCELL_ROW_175_3701 VSS VDD sky130_fd_sc_hd__tapvpwrvgnd_1
XTAP_TAPCELL_ROW_175_3702 VSS VDD sky130_fd_sc_hd__tapvpwrvgnd_1
XTAP_TAPCELL_ROW_175_3703 VSS VDD sky130_fd_sc_hd__tapvpwrvgnd_1
XTAP_TAPCELL_ROW_175_3704 VSS VDD sky130_fd_sc_hd__tapvpwrvgnd_1
XTAP_TAPCELL_ROW_175_3705 VSS VDD sky130_fd_sc_hd__tapvpwrvgnd_1
XTAP_TAPCELL_ROW_175_3706 VSS VDD sky130_fd_sc_hd__tapvpwrvgnd_1
XTAP_TAPCELL_ROW_175_3707 VSS VDD sky130_fd_sc_hd__tapvpwrvgnd_1
XTAP_TAPCELL_ROW_175_3708 VSS VDD sky130_fd_sc_hd__tapvpwrvgnd_1
XTAP_TAPCELL_ROW_175_3709 VSS VDD sky130_fd_sc_hd__tapvpwrvgnd_1
XTAP_TAPCELL_ROW_175_3710 VSS VDD sky130_fd_sc_hd__tapvpwrvgnd_1
XTAP_TAPCELL_ROW_175_3711 VSS VDD sky130_fd_sc_hd__tapvpwrvgnd_1
XTAP_TAPCELL_ROW_175_3712 VSS VDD sky130_fd_sc_hd__tapvpwrvgnd_1
XTAP_TAPCELL_ROW_175_3713 VSS VDD sky130_fd_sc_hd__tapvpwrvgnd_1
XTAP_TAPCELL_ROW_175_3714 VSS VDD sky130_fd_sc_hd__tapvpwrvgnd_1
XTAP_TAPCELL_ROW_175_3715 VSS VDD sky130_fd_sc_hd__tapvpwrvgnd_1
XTAP_TAPCELL_ROW_175_3716 VSS VDD sky130_fd_sc_hd__tapvpwrvgnd_1
XTAP_TAPCELL_ROW_176_3717 VSS VDD sky130_fd_sc_hd__tapvpwrvgnd_1
XTAP_TAPCELL_ROW_176_3718 VSS VDD sky130_fd_sc_hd__tapvpwrvgnd_1
XTAP_TAPCELL_ROW_176_3719 VSS VDD sky130_fd_sc_hd__tapvpwrvgnd_1
XTAP_TAPCELL_ROW_176_3720 VSS VDD sky130_fd_sc_hd__tapvpwrvgnd_1
XTAP_TAPCELL_ROW_176_3721 VSS VDD sky130_fd_sc_hd__tapvpwrvgnd_1
XTAP_TAPCELL_ROW_176_3722 VSS VDD sky130_fd_sc_hd__tapvpwrvgnd_1
XTAP_TAPCELL_ROW_176_3723 VSS VDD sky130_fd_sc_hd__tapvpwrvgnd_1
XTAP_TAPCELL_ROW_176_3724 VSS VDD sky130_fd_sc_hd__tapvpwrvgnd_1
XTAP_TAPCELL_ROW_176_3725 VSS VDD sky130_fd_sc_hd__tapvpwrvgnd_1
XTAP_TAPCELL_ROW_176_3726 VSS VDD sky130_fd_sc_hd__tapvpwrvgnd_1
XTAP_TAPCELL_ROW_176_3727 VSS VDD sky130_fd_sc_hd__tapvpwrvgnd_1
XTAP_TAPCELL_ROW_176_3728 VSS VDD sky130_fd_sc_hd__tapvpwrvgnd_1
XTAP_TAPCELL_ROW_176_3729 VSS VDD sky130_fd_sc_hd__tapvpwrvgnd_1
XTAP_TAPCELL_ROW_176_3730 VSS VDD sky130_fd_sc_hd__tapvpwrvgnd_1
XTAP_TAPCELL_ROW_176_3731 VSS VDD sky130_fd_sc_hd__tapvpwrvgnd_1
XTAP_TAPCELL_ROW_176_3732 VSS VDD sky130_fd_sc_hd__tapvpwrvgnd_1
XTAP_TAPCELL_ROW_176_3733 VSS VDD sky130_fd_sc_hd__tapvpwrvgnd_1
XTAP_TAPCELL_ROW_176_3734 VSS VDD sky130_fd_sc_hd__tapvpwrvgnd_1
XTAP_TAPCELL_ROW_176_3735 VSS VDD sky130_fd_sc_hd__tapvpwrvgnd_1
XTAP_TAPCELL_ROW_176_3736 VSS VDD sky130_fd_sc_hd__tapvpwrvgnd_1
XTAP_TAPCELL_ROW_176_3737 VSS VDD sky130_fd_sc_hd__tapvpwrvgnd_1
XTAP_TAPCELL_ROW_177_3738 VSS VDD sky130_fd_sc_hd__tapvpwrvgnd_1
XTAP_TAPCELL_ROW_177_3739 VSS VDD sky130_fd_sc_hd__tapvpwrvgnd_1
XTAP_TAPCELL_ROW_177_3740 VSS VDD sky130_fd_sc_hd__tapvpwrvgnd_1
XTAP_TAPCELL_ROW_177_3741 VSS VDD sky130_fd_sc_hd__tapvpwrvgnd_1
XTAP_TAPCELL_ROW_177_3742 VSS VDD sky130_fd_sc_hd__tapvpwrvgnd_1
XTAP_TAPCELL_ROW_177_3743 VSS VDD sky130_fd_sc_hd__tapvpwrvgnd_1
XTAP_TAPCELL_ROW_177_3744 VSS VDD sky130_fd_sc_hd__tapvpwrvgnd_1
XTAP_TAPCELL_ROW_177_3745 VSS VDD sky130_fd_sc_hd__tapvpwrvgnd_1
XTAP_TAPCELL_ROW_177_3746 VSS VDD sky130_fd_sc_hd__tapvpwrvgnd_1
XTAP_TAPCELL_ROW_177_3747 VSS VDD sky130_fd_sc_hd__tapvpwrvgnd_1
XTAP_TAPCELL_ROW_177_3748 VSS VDD sky130_fd_sc_hd__tapvpwrvgnd_1
XTAP_TAPCELL_ROW_177_3749 VSS VDD sky130_fd_sc_hd__tapvpwrvgnd_1
XTAP_TAPCELL_ROW_177_3750 VSS VDD sky130_fd_sc_hd__tapvpwrvgnd_1
XTAP_TAPCELL_ROW_177_3751 VSS VDD sky130_fd_sc_hd__tapvpwrvgnd_1
XTAP_TAPCELL_ROW_177_3752 VSS VDD sky130_fd_sc_hd__tapvpwrvgnd_1
XTAP_TAPCELL_ROW_177_3753 VSS VDD sky130_fd_sc_hd__tapvpwrvgnd_1
XTAP_TAPCELL_ROW_177_3754 VSS VDD sky130_fd_sc_hd__tapvpwrvgnd_1
XTAP_TAPCELL_ROW_177_3755 VSS VDD sky130_fd_sc_hd__tapvpwrvgnd_1
XTAP_TAPCELL_ROW_177_3756 VSS VDD sky130_fd_sc_hd__tapvpwrvgnd_1
XTAP_TAPCELL_ROW_177_3757 VSS VDD sky130_fd_sc_hd__tapvpwrvgnd_1
XTAP_TAPCELL_ROW_177_3758 VSS VDD sky130_fd_sc_hd__tapvpwrvgnd_1
XTAP_TAPCELL_ROW_178_3759 VSS VDD sky130_fd_sc_hd__tapvpwrvgnd_1
XTAP_TAPCELL_ROW_178_3760 VSS VDD sky130_fd_sc_hd__tapvpwrvgnd_1
XTAP_TAPCELL_ROW_178_3761 VSS VDD sky130_fd_sc_hd__tapvpwrvgnd_1
XTAP_TAPCELL_ROW_178_3762 VSS VDD sky130_fd_sc_hd__tapvpwrvgnd_1
XTAP_TAPCELL_ROW_178_3763 VSS VDD sky130_fd_sc_hd__tapvpwrvgnd_1
XTAP_TAPCELL_ROW_178_3764 VSS VDD sky130_fd_sc_hd__tapvpwrvgnd_1
XTAP_TAPCELL_ROW_178_3765 VSS VDD sky130_fd_sc_hd__tapvpwrvgnd_1
XTAP_TAPCELL_ROW_178_3766 VSS VDD sky130_fd_sc_hd__tapvpwrvgnd_1
XTAP_TAPCELL_ROW_178_3767 VSS VDD sky130_fd_sc_hd__tapvpwrvgnd_1
XTAP_TAPCELL_ROW_178_3768 VSS VDD sky130_fd_sc_hd__tapvpwrvgnd_1
XTAP_TAPCELL_ROW_178_3769 VSS VDD sky130_fd_sc_hd__tapvpwrvgnd_1
XTAP_TAPCELL_ROW_178_3770 VSS VDD sky130_fd_sc_hd__tapvpwrvgnd_1
XTAP_TAPCELL_ROW_178_3771 VSS VDD sky130_fd_sc_hd__tapvpwrvgnd_1
XTAP_TAPCELL_ROW_178_3772 VSS VDD sky130_fd_sc_hd__tapvpwrvgnd_1
XTAP_TAPCELL_ROW_178_3773 VSS VDD sky130_fd_sc_hd__tapvpwrvgnd_1
XTAP_TAPCELL_ROW_178_3774 VSS VDD sky130_fd_sc_hd__tapvpwrvgnd_1
XTAP_TAPCELL_ROW_178_3775 VSS VDD sky130_fd_sc_hd__tapvpwrvgnd_1
XTAP_TAPCELL_ROW_178_3776 VSS VDD sky130_fd_sc_hd__tapvpwrvgnd_1
XTAP_TAPCELL_ROW_178_3777 VSS VDD sky130_fd_sc_hd__tapvpwrvgnd_1
XTAP_TAPCELL_ROW_178_3778 VSS VDD sky130_fd_sc_hd__tapvpwrvgnd_1
XTAP_TAPCELL_ROW_178_3779 VSS VDD sky130_fd_sc_hd__tapvpwrvgnd_1
XTAP_TAPCELL_ROW_179_3780 VSS VDD sky130_fd_sc_hd__tapvpwrvgnd_1
XTAP_TAPCELL_ROW_179_3781 VSS VDD sky130_fd_sc_hd__tapvpwrvgnd_1
XTAP_TAPCELL_ROW_179_3782 VSS VDD sky130_fd_sc_hd__tapvpwrvgnd_1
XTAP_TAPCELL_ROW_179_3783 VSS VDD sky130_fd_sc_hd__tapvpwrvgnd_1
XTAP_TAPCELL_ROW_179_3784 VSS VDD sky130_fd_sc_hd__tapvpwrvgnd_1
XTAP_TAPCELL_ROW_179_3785 VSS VDD sky130_fd_sc_hd__tapvpwrvgnd_1
XTAP_TAPCELL_ROW_179_3786 VSS VDD sky130_fd_sc_hd__tapvpwrvgnd_1
XTAP_TAPCELL_ROW_179_3787 VSS VDD sky130_fd_sc_hd__tapvpwrvgnd_1
XTAP_TAPCELL_ROW_179_3788 VSS VDD sky130_fd_sc_hd__tapvpwrvgnd_1
XTAP_TAPCELL_ROW_179_3789 VSS VDD sky130_fd_sc_hd__tapvpwrvgnd_1
XTAP_TAPCELL_ROW_179_3790 VSS VDD sky130_fd_sc_hd__tapvpwrvgnd_1
XTAP_TAPCELL_ROW_179_3791 VSS VDD sky130_fd_sc_hd__tapvpwrvgnd_1
XTAP_TAPCELL_ROW_179_3792 VSS VDD sky130_fd_sc_hd__tapvpwrvgnd_1
XTAP_TAPCELL_ROW_179_3793 VSS VDD sky130_fd_sc_hd__tapvpwrvgnd_1
XTAP_TAPCELL_ROW_179_3794 VSS VDD sky130_fd_sc_hd__tapvpwrvgnd_1
XTAP_TAPCELL_ROW_179_3795 VSS VDD sky130_fd_sc_hd__tapvpwrvgnd_1
XTAP_TAPCELL_ROW_179_3796 VSS VDD sky130_fd_sc_hd__tapvpwrvgnd_1
XTAP_TAPCELL_ROW_179_3797 VSS VDD sky130_fd_sc_hd__tapvpwrvgnd_1
XTAP_TAPCELL_ROW_179_3798 VSS VDD sky130_fd_sc_hd__tapvpwrvgnd_1
XTAP_TAPCELL_ROW_179_3799 VSS VDD sky130_fd_sc_hd__tapvpwrvgnd_1
XTAP_TAPCELL_ROW_179_3800 VSS VDD sky130_fd_sc_hd__tapvpwrvgnd_1
XTAP_TAPCELL_ROW_180_3801 VSS VDD sky130_fd_sc_hd__tapvpwrvgnd_1
XTAP_TAPCELL_ROW_180_3802 VSS VDD sky130_fd_sc_hd__tapvpwrvgnd_1
XTAP_TAPCELL_ROW_180_3803 VSS VDD sky130_fd_sc_hd__tapvpwrvgnd_1
XTAP_TAPCELL_ROW_180_3804 VSS VDD sky130_fd_sc_hd__tapvpwrvgnd_1
XTAP_TAPCELL_ROW_180_3805 VSS VDD sky130_fd_sc_hd__tapvpwrvgnd_1
XTAP_TAPCELL_ROW_180_3806 VSS VDD sky130_fd_sc_hd__tapvpwrvgnd_1
XTAP_TAPCELL_ROW_180_3807 VSS VDD sky130_fd_sc_hd__tapvpwrvgnd_1
XTAP_TAPCELL_ROW_180_3808 VSS VDD sky130_fd_sc_hd__tapvpwrvgnd_1
XTAP_TAPCELL_ROW_180_3809 VSS VDD sky130_fd_sc_hd__tapvpwrvgnd_1
XTAP_TAPCELL_ROW_180_3810 VSS VDD sky130_fd_sc_hd__tapvpwrvgnd_1
XTAP_TAPCELL_ROW_180_3811 VSS VDD sky130_fd_sc_hd__tapvpwrvgnd_1
XTAP_TAPCELL_ROW_180_3812 VSS VDD sky130_fd_sc_hd__tapvpwrvgnd_1
XTAP_TAPCELL_ROW_180_3813 VSS VDD sky130_fd_sc_hd__tapvpwrvgnd_1
XTAP_TAPCELL_ROW_180_3814 VSS VDD sky130_fd_sc_hd__tapvpwrvgnd_1
XTAP_TAPCELL_ROW_180_3815 VSS VDD sky130_fd_sc_hd__tapvpwrvgnd_1
XTAP_TAPCELL_ROW_180_3816 VSS VDD sky130_fd_sc_hd__tapvpwrvgnd_1
XTAP_TAPCELL_ROW_180_3817 VSS VDD sky130_fd_sc_hd__tapvpwrvgnd_1
XTAP_TAPCELL_ROW_180_3818 VSS VDD sky130_fd_sc_hd__tapvpwrvgnd_1
XTAP_TAPCELL_ROW_180_3819 VSS VDD sky130_fd_sc_hd__tapvpwrvgnd_1
XTAP_TAPCELL_ROW_180_3820 VSS VDD sky130_fd_sc_hd__tapvpwrvgnd_1
XTAP_TAPCELL_ROW_180_3821 VSS VDD sky130_fd_sc_hd__tapvpwrvgnd_1
XTAP_TAPCELL_ROW_181_3822 VSS VDD sky130_fd_sc_hd__tapvpwrvgnd_1
XTAP_TAPCELL_ROW_181_3823 VSS VDD sky130_fd_sc_hd__tapvpwrvgnd_1
XTAP_TAPCELL_ROW_181_3824 VSS VDD sky130_fd_sc_hd__tapvpwrvgnd_1
XTAP_TAPCELL_ROW_181_3825 VSS VDD sky130_fd_sc_hd__tapvpwrvgnd_1
XTAP_TAPCELL_ROW_181_3826 VSS VDD sky130_fd_sc_hd__tapvpwrvgnd_1
XTAP_TAPCELL_ROW_181_3827 VSS VDD sky130_fd_sc_hd__tapvpwrvgnd_1
XTAP_TAPCELL_ROW_181_3828 VSS VDD sky130_fd_sc_hd__tapvpwrvgnd_1
XTAP_TAPCELL_ROW_181_3829 VSS VDD sky130_fd_sc_hd__tapvpwrvgnd_1
XTAP_TAPCELL_ROW_181_3830 VSS VDD sky130_fd_sc_hd__tapvpwrvgnd_1
XTAP_TAPCELL_ROW_181_3831 VSS VDD sky130_fd_sc_hd__tapvpwrvgnd_1
XTAP_TAPCELL_ROW_181_3832 VSS VDD sky130_fd_sc_hd__tapvpwrvgnd_1
XTAP_TAPCELL_ROW_181_3833 VSS VDD sky130_fd_sc_hd__tapvpwrvgnd_1
XTAP_TAPCELL_ROW_181_3834 VSS VDD sky130_fd_sc_hd__tapvpwrvgnd_1
XTAP_TAPCELL_ROW_181_3835 VSS VDD sky130_fd_sc_hd__tapvpwrvgnd_1
XTAP_TAPCELL_ROW_181_3836 VSS VDD sky130_fd_sc_hd__tapvpwrvgnd_1
XTAP_TAPCELL_ROW_181_3837 VSS VDD sky130_fd_sc_hd__tapvpwrvgnd_1
XTAP_TAPCELL_ROW_181_3838 VSS VDD sky130_fd_sc_hd__tapvpwrvgnd_1
XTAP_TAPCELL_ROW_181_3839 VSS VDD sky130_fd_sc_hd__tapvpwrvgnd_1
XTAP_TAPCELL_ROW_181_3840 VSS VDD sky130_fd_sc_hd__tapvpwrvgnd_1
XTAP_TAPCELL_ROW_181_3841 VSS VDD sky130_fd_sc_hd__tapvpwrvgnd_1
XTAP_TAPCELL_ROW_181_3842 VSS VDD sky130_fd_sc_hd__tapvpwrvgnd_1
XTAP_TAPCELL_ROW_182_3843 VSS VDD sky130_fd_sc_hd__tapvpwrvgnd_1
XTAP_TAPCELL_ROW_182_3844 VSS VDD sky130_fd_sc_hd__tapvpwrvgnd_1
XTAP_TAPCELL_ROW_182_3845 VSS VDD sky130_fd_sc_hd__tapvpwrvgnd_1
XTAP_TAPCELL_ROW_182_3846 VSS VDD sky130_fd_sc_hd__tapvpwrvgnd_1
XTAP_TAPCELL_ROW_182_3847 VSS VDD sky130_fd_sc_hd__tapvpwrvgnd_1
XTAP_TAPCELL_ROW_182_3848 VSS VDD sky130_fd_sc_hd__tapvpwrvgnd_1
XTAP_TAPCELL_ROW_182_3849 VSS VDD sky130_fd_sc_hd__tapvpwrvgnd_1
XTAP_TAPCELL_ROW_182_3850 VSS VDD sky130_fd_sc_hd__tapvpwrvgnd_1
XTAP_TAPCELL_ROW_182_3851 VSS VDD sky130_fd_sc_hd__tapvpwrvgnd_1
XTAP_TAPCELL_ROW_182_3852 VSS VDD sky130_fd_sc_hd__tapvpwrvgnd_1
XTAP_TAPCELL_ROW_182_3853 VSS VDD sky130_fd_sc_hd__tapvpwrvgnd_1
XTAP_TAPCELL_ROW_182_3854 VSS VDD sky130_fd_sc_hd__tapvpwrvgnd_1
XTAP_TAPCELL_ROW_182_3855 VSS VDD sky130_fd_sc_hd__tapvpwrvgnd_1
XTAP_TAPCELL_ROW_182_3856 VSS VDD sky130_fd_sc_hd__tapvpwrvgnd_1
XTAP_TAPCELL_ROW_182_3857 VSS VDD sky130_fd_sc_hd__tapvpwrvgnd_1
XTAP_TAPCELL_ROW_182_3858 VSS VDD sky130_fd_sc_hd__tapvpwrvgnd_1
XTAP_TAPCELL_ROW_182_3859 VSS VDD sky130_fd_sc_hd__tapvpwrvgnd_1
XTAP_TAPCELL_ROW_182_3860 VSS VDD sky130_fd_sc_hd__tapvpwrvgnd_1
XTAP_TAPCELL_ROW_182_3861 VSS VDD sky130_fd_sc_hd__tapvpwrvgnd_1
XTAP_TAPCELL_ROW_182_3862 VSS VDD sky130_fd_sc_hd__tapvpwrvgnd_1
XTAP_TAPCELL_ROW_182_3863 VSS VDD sky130_fd_sc_hd__tapvpwrvgnd_1
XTAP_TAPCELL_ROW_183_3864 VSS VDD sky130_fd_sc_hd__tapvpwrvgnd_1
XTAP_TAPCELL_ROW_183_3865 VSS VDD sky130_fd_sc_hd__tapvpwrvgnd_1
XTAP_TAPCELL_ROW_183_3866 VSS VDD sky130_fd_sc_hd__tapvpwrvgnd_1
XTAP_TAPCELL_ROW_183_3867 VSS VDD sky130_fd_sc_hd__tapvpwrvgnd_1
XTAP_TAPCELL_ROW_183_3868 VSS VDD sky130_fd_sc_hd__tapvpwrvgnd_1
XTAP_TAPCELL_ROW_183_3869 VSS VDD sky130_fd_sc_hd__tapvpwrvgnd_1
XTAP_TAPCELL_ROW_183_3870 VSS VDD sky130_fd_sc_hd__tapvpwrvgnd_1
XTAP_TAPCELL_ROW_183_3871 VSS VDD sky130_fd_sc_hd__tapvpwrvgnd_1
XTAP_TAPCELL_ROW_183_3872 VSS VDD sky130_fd_sc_hd__tapvpwrvgnd_1
XTAP_TAPCELL_ROW_183_3873 VSS VDD sky130_fd_sc_hd__tapvpwrvgnd_1
XTAP_TAPCELL_ROW_183_3874 VSS VDD sky130_fd_sc_hd__tapvpwrvgnd_1
XTAP_TAPCELL_ROW_183_3875 VSS VDD sky130_fd_sc_hd__tapvpwrvgnd_1
XTAP_TAPCELL_ROW_183_3876 VSS VDD sky130_fd_sc_hd__tapvpwrvgnd_1
XTAP_TAPCELL_ROW_183_3877 VSS VDD sky130_fd_sc_hd__tapvpwrvgnd_1
XTAP_TAPCELL_ROW_183_3878 VSS VDD sky130_fd_sc_hd__tapvpwrvgnd_1
XTAP_TAPCELL_ROW_183_3879 VSS VDD sky130_fd_sc_hd__tapvpwrvgnd_1
XTAP_TAPCELL_ROW_183_3880 VSS VDD sky130_fd_sc_hd__tapvpwrvgnd_1
XTAP_TAPCELL_ROW_183_3881 VSS VDD sky130_fd_sc_hd__tapvpwrvgnd_1
XTAP_TAPCELL_ROW_183_3882 VSS VDD sky130_fd_sc_hd__tapvpwrvgnd_1
XTAP_TAPCELL_ROW_183_3883 VSS VDD sky130_fd_sc_hd__tapvpwrvgnd_1
XTAP_TAPCELL_ROW_183_3884 VSS VDD sky130_fd_sc_hd__tapvpwrvgnd_1
XTAP_TAPCELL_ROW_184_3885 VSS VDD sky130_fd_sc_hd__tapvpwrvgnd_1
XTAP_TAPCELL_ROW_184_3886 VSS VDD sky130_fd_sc_hd__tapvpwrvgnd_1
XTAP_TAPCELL_ROW_184_3887 VSS VDD sky130_fd_sc_hd__tapvpwrvgnd_1
XTAP_TAPCELL_ROW_184_3888 VSS VDD sky130_fd_sc_hd__tapvpwrvgnd_1
XTAP_TAPCELL_ROW_184_3889 VSS VDD sky130_fd_sc_hd__tapvpwrvgnd_1
XTAP_TAPCELL_ROW_184_3890 VSS VDD sky130_fd_sc_hd__tapvpwrvgnd_1
XTAP_TAPCELL_ROW_184_3891 VSS VDD sky130_fd_sc_hd__tapvpwrvgnd_1
XTAP_TAPCELL_ROW_184_3892 VSS VDD sky130_fd_sc_hd__tapvpwrvgnd_1
XTAP_TAPCELL_ROW_184_3893 VSS VDD sky130_fd_sc_hd__tapvpwrvgnd_1
XTAP_TAPCELL_ROW_184_3894 VSS VDD sky130_fd_sc_hd__tapvpwrvgnd_1
XTAP_TAPCELL_ROW_184_3895 VSS VDD sky130_fd_sc_hd__tapvpwrvgnd_1
XTAP_TAPCELL_ROW_184_3896 VSS VDD sky130_fd_sc_hd__tapvpwrvgnd_1
XTAP_TAPCELL_ROW_184_3897 VSS VDD sky130_fd_sc_hd__tapvpwrvgnd_1
XTAP_TAPCELL_ROW_184_3898 VSS VDD sky130_fd_sc_hd__tapvpwrvgnd_1
XTAP_TAPCELL_ROW_184_3899 VSS VDD sky130_fd_sc_hd__tapvpwrvgnd_1
XTAP_TAPCELL_ROW_184_3900 VSS VDD sky130_fd_sc_hd__tapvpwrvgnd_1
XTAP_TAPCELL_ROW_184_3901 VSS VDD sky130_fd_sc_hd__tapvpwrvgnd_1
XTAP_TAPCELL_ROW_184_3902 VSS VDD sky130_fd_sc_hd__tapvpwrvgnd_1
XTAP_TAPCELL_ROW_184_3903 VSS VDD sky130_fd_sc_hd__tapvpwrvgnd_1
XTAP_TAPCELL_ROW_184_3904 VSS VDD sky130_fd_sc_hd__tapvpwrvgnd_1
XTAP_TAPCELL_ROW_184_3905 VSS VDD sky130_fd_sc_hd__tapvpwrvgnd_1
XTAP_TAPCELL_ROW_185_3906 VSS VDD sky130_fd_sc_hd__tapvpwrvgnd_1
XTAP_TAPCELL_ROW_185_3907 VSS VDD sky130_fd_sc_hd__tapvpwrvgnd_1
XTAP_TAPCELL_ROW_185_3908 VSS VDD sky130_fd_sc_hd__tapvpwrvgnd_1
XTAP_TAPCELL_ROW_185_3909 VSS VDD sky130_fd_sc_hd__tapvpwrvgnd_1
XTAP_TAPCELL_ROW_185_3910 VSS VDD sky130_fd_sc_hd__tapvpwrvgnd_1
XTAP_TAPCELL_ROW_185_3911 VSS VDD sky130_fd_sc_hd__tapvpwrvgnd_1
XTAP_TAPCELL_ROW_185_3912 VSS VDD sky130_fd_sc_hd__tapvpwrvgnd_1
XTAP_TAPCELL_ROW_185_3913 VSS VDD sky130_fd_sc_hd__tapvpwrvgnd_1
XTAP_TAPCELL_ROW_185_3914 VSS VDD sky130_fd_sc_hd__tapvpwrvgnd_1
XTAP_TAPCELL_ROW_185_3915 VSS VDD sky130_fd_sc_hd__tapvpwrvgnd_1
XTAP_TAPCELL_ROW_185_3916 VSS VDD sky130_fd_sc_hd__tapvpwrvgnd_1
XTAP_TAPCELL_ROW_185_3917 VSS VDD sky130_fd_sc_hd__tapvpwrvgnd_1
XTAP_TAPCELL_ROW_185_3918 VSS VDD sky130_fd_sc_hd__tapvpwrvgnd_1
XTAP_TAPCELL_ROW_185_3919 VSS VDD sky130_fd_sc_hd__tapvpwrvgnd_1
XTAP_TAPCELL_ROW_185_3920 VSS VDD sky130_fd_sc_hd__tapvpwrvgnd_1
XTAP_TAPCELL_ROW_185_3921 VSS VDD sky130_fd_sc_hd__tapvpwrvgnd_1
XTAP_TAPCELL_ROW_185_3922 VSS VDD sky130_fd_sc_hd__tapvpwrvgnd_1
XTAP_TAPCELL_ROW_185_3923 VSS VDD sky130_fd_sc_hd__tapvpwrvgnd_1
XTAP_TAPCELL_ROW_185_3924 VSS VDD sky130_fd_sc_hd__tapvpwrvgnd_1
XTAP_TAPCELL_ROW_185_3925 VSS VDD sky130_fd_sc_hd__tapvpwrvgnd_1
XTAP_TAPCELL_ROW_185_3926 VSS VDD sky130_fd_sc_hd__tapvpwrvgnd_1
XTAP_TAPCELL_ROW_186_3927 VSS VDD sky130_fd_sc_hd__tapvpwrvgnd_1
XTAP_TAPCELL_ROW_186_3928 VSS VDD sky130_fd_sc_hd__tapvpwrvgnd_1
XTAP_TAPCELL_ROW_186_3929 VSS VDD sky130_fd_sc_hd__tapvpwrvgnd_1
XTAP_TAPCELL_ROW_186_3930 VSS VDD sky130_fd_sc_hd__tapvpwrvgnd_1
XTAP_TAPCELL_ROW_186_3931 VSS VDD sky130_fd_sc_hd__tapvpwrvgnd_1
XTAP_TAPCELL_ROW_186_3932 VSS VDD sky130_fd_sc_hd__tapvpwrvgnd_1
XTAP_TAPCELL_ROW_186_3933 VSS VDD sky130_fd_sc_hd__tapvpwrvgnd_1
XTAP_TAPCELL_ROW_186_3934 VSS VDD sky130_fd_sc_hd__tapvpwrvgnd_1
XTAP_TAPCELL_ROW_186_3935 VSS VDD sky130_fd_sc_hd__tapvpwrvgnd_1
XTAP_TAPCELL_ROW_186_3936 VSS VDD sky130_fd_sc_hd__tapvpwrvgnd_1
XTAP_TAPCELL_ROW_186_3937 VSS VDD sky130_fd_sc_hd__tapvpwrvgnd_1
XTAP_TAPCELL_ROW_186_3938 VSS VDD sky130_fd_sc_hd__tapvpwrvgnd_1
XTAP_TAPCELL_ROW_186_3939 VSS VDD sky130_fd_sc_hd__tapvpwrvgnd_1
XTAP_TAPCELL_ROW_186_3940 VSS VDD sky130_fd_sc_hd__tapvpwrvgnd_1
XTAP_TAPCELL_ROW_186_3941 VSS VDD sky130_fd_sc_hd__tapvpwrvgnd_1
XTAP_TAPCELL_ROW_186_3942 VSS VDD sky130_fd_sc_hd__tapvpwrvgnd_1
XTAP_TAPCELL_ROW_186_3943 VSS VDD sky130_fd_sc_hd__tapvpwrvgnd_1
XTAP_TAPCELL_ROW_186_3944 VSS VDD sky130_fd_sc_hd__tapvpwrvgnd_1
XTAP_TAPCELL_ROW_186_3945 VSS VDD sky130_fd_sc_hd__tapvpwrvgnd_1
XTAP_TAPCELL_ROW_186_3946 VSS VDD sky130_fd_sc_hd__tapvpwrvgnd_1
XTAP_TAPCELL_ROW_186_3947 VSS VDD sky130_fd_sc_hd__tapvpwrvgnd_1
XTAP_TAPCELL_ROW_187_3948 VSS VDD sky130_fd_sc_hd__tapvpwrvgnd_1
XTAP_TAPCELL_ROW_187_3949 VSS VDD sky130_fd_sc_hd__tapvpwrvgnd_1
XTAP_TAPCELL_ROW_187_3950 VSS VDD sky130_fd_sc_hd__tapvpwrvgnd_1
XTAP_TAPCELL_ROW_187_3951 VSS VDD sky130_fd_sc_hd__tapvpwrvgnd_1
XTAP_TAPCELL_ROW_187_3952 VSS VDD sky130_fd_sc_hd__tapvpwrvgnd_1
XTAP_TAPCELL_ROW_187_3953 VSS VDD sky130_fd_sc_hd__tapvpwrvgnd_1
XTAP_TAPCELL_ROW_187_3954 VSS VDD sky130_fd_sc_hd__tapvpwrvgnd_1
XTAP_TAPCELL_ROW_187_3955 VSS VDD sky130_fd_sc_hd__tapvpwrvgnd_1
XTAP_TAPCELL_ROW_187_3956 VSS VDD sky130_fd_sc_hd__tapvpwrvgnd_1
XTAP_TAPCELL_ROW_187_3957 VSS VDD sky130_fd_sc_hd__tapvpwrvgnd_1
XTAP_TAPCELL_ROW_187_3958 VSS VDD sky130_fd_sc_hd__tapvpwrvgnd_1
XTAP_TAPCELL_ROW_187_3959 VSS VDD sky130_fd_sc_hd__tapvpwrvgnd_1
XTAP_TAPCELL_ROW_187_3960 VSS VDD sky130_fd_sc_hd__tapvpwrvgnd_1
XTAP_TAPCELL_ROW_187_3961 VSS VDD sky130_fd_sc_hd__tapvpwrvgnd_1
XTAP_TAPCELL_ROW_187_3962 VSS VDD sky130_fd_sc_hd__tapvpwrvgnd_1
XTAP_TAPCELL_ROW_187_3963 VSS VDD sky130_fd_sc_hd__tapvpwrvgnd_1
XTAP_TAPCELL_ROW_187_3964 VSS VDD sky130_fd_sc_hd__tapvpwrvgnd_1
XTAP_TAPCELL_ROW_187_3965 VSS VDD sky130_fd_sc_hd__tapvpwrvgnd_1
XTAP_TAPCELL_ROW_187_3966 VSS VDD sky130_fd_sc_hd__tapvpwrvgnd_1
XTAP_TAPCELL_ROW_187_3967 VSS VDD sky130_fd_sc_hd__tapvpwrvgnd_1
XTAP_TAPCELL_ROW_187_3968 VSS VDD sky130_fd_sc_hd__tapvpwrvgnd_1
XTAP_TAPCELL_ROW_188_3969 VSS VDD sky130_fd_sc_hd__tapvpwrvgnd_1
XTAP_TAPCELL_ROW_188_3970 VSS VDD sky130_fd_sc_hd__tapvpwrvgnd_1
XTAP_TAPCELL_ROW_188_3971 VSS VDD sky130_fd_sc_hd__tapvpwrvgnd_1
XTAP_TAPCELL_ROW_188_3972 VSS VDD sky130_fd_sc_hd__tapvpwrvgnd_1
XTAP_TAPCELL_ROW_188_3973 VSS VDD sky130_fd_sc_hd__tapvpwrvgnd_1
XTAP_TAPCELL_ROW_188_3974 VSS VDD sky130_fd_sc_hd__tapvpwrvgnd_1
XTAP_TAPCELL_ROW_188_3975 VSS VDD sky130_fd_sc_hd__tapvpwrvgnd_1
XTAP_TAPCELL_ROW_188_3976 VSS VDD sky130_fd_sc_hd__tapvpwrvgnd_1
XTAP_TAPCELL_ROW_188_3977 VSS VDD sky130_fd_sc_hd__tapvpwrvgnd_1
XTAP_TAPCELL_ROW_188_3978 VSS VDD sky130_fd_sc_hd__tapvpwrvgnd_1
XTAP_TAPCELL_ROW_188_3979 VSS VDD sky130_fd_sc_hd__tapvpwrvgnd_1
XTAP_TAPCELL_ROW_188_3980 VSS VDD sky130_fd_sc_hd__tapvpwrvgnd_1
XTAP_TAPCELL_ROW_188_3981 VSS VDD sky130_fd_sc_hd__tapvpwrvgnd_1
XTAP_TAPCELL_ROW_188_3982 VSS VDD sky130_fd_sc_hd__tapvpwrvgnd_1
XTAP_TAPCELL_ROW_188_3983 VSS VDD sky130_fd_sc_hd__tapvpwrvgnd_1
XTAP_TAPCELL_ROW_188_3984 VSS VDD sky130_fd_sc_hd__tapvpwrvgnd_1
XTAP_TAPCELL_ROW_188_3985 VSS VDD sky130_fd_sc_hd__tapvpwrvgnd_1
XTAP_TAPCELL_ROW_188_3986 VSS VDD sky130_fd_sc_hd__tapvpwrvgnd_1
XTAP_TAPCELL_ROW_188_3987 VSS VDD sky130_fd_sc_hd__tapvpwrvgnd_1
XTAP_TAPCELL_ROW_188_3988 VSS VDD sky130_fd_sc_hd__tapvpwrvgnd_1
XTAP_TAPCELL_ROW_188_3989 VSS VDD sky130_fd_sc_hd__tapvpwrvgnd_1
XTAP_TAPCELL_ROW_189_3990 VSS VDD sky130_fd_sc_hd__tapvpwrvgnd_1
XTAP_TAPCELL_ROW_189_3991 VSS VDD sky130_fd_sc_hd__tapvpwrvgnd_1
XTAP_TAPCELL_ROW_189_3992 VSS VDD sky130_fd_sc_hd__tapvpwrvgnd_1
XTAP_TAPCELL_ROW_189_3993 VSS VDD sky130_fd_sc_hd__tapvpwrvgnd_1
XTAP_TAPCELL_ROW_189_3994 VSS VDD sky130_fd_sc_hd__tapvpwrvgnd_1
XTAP_TAPCELL_ROW_189_3995 VSS VDD sky130_fd_sc_hd__tapvpwrvgnd_1
XTAP_TAPCELL_ROW_189_3996 VSS VDD sky130_fd_sc_hd__tapvpwrvgnd_1
XTAP_TAPCELL_ROW_189_3997 VSS VDD sky130_fd_sc_hd__tapvpwrvgnd_1
XTAP_TAPCELL_ROW_189_3998 VSS VDD sky130_fd_sc_hd__tapvpwrvgnd_1
XTAP_TAPCELL_ROW_189_3999 VSS VDD sky130_fd_sc_hd__tapvpwrvgnd_1
XTAP_TAPCELL_ROW_189_4000 VSS VDD sky130_fd_sc_hd__tapvpwrvgnd_1
XTAP_TAPCELL_ROW_189_4001 VSS VDD sky130_fd_sc_hd__tapvpwrvgnd_1
XTAP_TAPCELL_ROW_189_4002 VSS VDD sky130_fd_sc_hd__tapvpwrvgnd_1
XTAP_TAPCELL_ROW_189_4003 VSS VDD sky130_fd_sc_hd__tapvpwrvgnd_1
XTAP_TAPCELL_ROW_189_4004 VSS VDD sky130_fd_sc_hd__tapvpwrvgnd_1
XTAP_TAPCELL_ROW_189_4005 VSS VDD sky130_fd_sc_hd__tapvpwrvgnd_1
XTAP_TAPCELL_ROW_189_4006 VSS VDD sky130_fd_sc_hd__tapvpwrvgnd_1
XTAP_TAPCELL_ROW_189_4007 VSS VDD sky130_fd_sc_hd__tapvpwrvgnd_1
XTAP_TAPCELL_ROW_189_4008 VSS VDD sky130_fd_sc_hd__tapvpwrvgnd_1
XTAP_TAPCELL_ROW_189_4009 VSS VDD sky130_fd_sc_hd__tapvpwrvgnd_1
XTAP_TAPCELL_ROW_189_4010 VSS VDD sky130_fd_sc_hd__tapvpwrvgnd_1
XTAP_TAPCELL_ROW_190_4011 VSS VDD sky130_fd_sc_hd__tapvpwrvgnd_1
XTAP_TAPCELL_ROW_190_4012 VSS VDD sky130_fd_sc_hd__tapvpwrvgnd_1
XTAP_TAPCELL_ROW_190_4013 VSS VDD sky130_fd_sc_hd__tapvpwrvgnd_1
XTAP_TAPCELL_ROW_190_4014 VSS VDD sky130_fd_sc_hd__tapvpwrvgnd_1
XTAP_TAPCELL_ROW_190_4015 VSS VDD sky130_fd_sc_hd__tapvpwrvgnd_1
XTAP_TAPCELL_ROW_190_4016 VSS VDD sky130_fd_sc_hd__tapvpwrvgnd_1
XTAP_TAPCELL_ROW_190_4017 VSS VDD sky130_fd_sc_hd__tapvpwrvgnd_1
XTAP_TAPCELL_ROW_190_4018 VSS VDD sky130_fd_sc_hd__tapvpwrvgnd_1
XTAP_TAPCELL_ROW_190_4019 VSS VDD sky130_fd_sc_hd__tapvpwrvgnd_1
XTAP_TAPCELL_ROW_190_4020 VSS VDD sky130_fd_sc_hd__tapvpwrvgnd_1
XTAP_TAPCELL_ROW_190_4021 VSS VDD sky130_fd_sc_hd__tapvpwrvgnd_1
XTAP_TAPCELL_ROW_190_4022 VSS VDD sky130_fd_sc_hd__tapvpwrvgnd_1
XTAP_TAPCELL_ROW_190_4023 VSS VDD sky130_fd_sc_hd__tapvpwrvgnd_1
XTAP_TAPCELL_ROW_190_4024 VSS VDD sky130_fd_sc_hd__tapvpwrvgnd_1
XTAP_TAPCELL_ROW_190_4025 VSS VDD sky130_fd_sc_hd__tapvpwrvgnd_1
XTAP_TAPCELL_ROW_190_4026 VSS VDD sky130_fd_sc_hd__tapvpwrvgnd_1
XTAP_TAPCELL_ROW_190_4027 VSS VDD sky130_fd_sc_hd__tapvpwrvgnd_1
XTAP_TAPCELL_ROW_190_4028 VSS VDD sky130_fd_sc_hd__tapvpwrvgnd_1
XTAP_TAPCELL_ROW_190_4029 VSS VDD sky130_fd_sc_hd__tapvpwrvgnd_1
XTAP_TAPCELL_ROW_190_4030 VSS VDD sky130_fd_sc_hd__tapvpwrvgnd_1
XTAP_TAPCELL_ROW_190_4031 VSS VDD sky130_fd_sc_hd__tapvpwrvgnd_1
XTAP_TAPCELL_ROW_191_4032 VSS VDD sky130_fd_sc_hd__tapvpwrvgnd_1
XTAP_TAPCELL_ROW_191_4033 VSS VDD sky130_fd_sc_hd__tapvpwrvgnd_1
XTAP_TAPCELL_ROW_191_4034 VSS VDD sky130_fd_sc_hd__tapvpwrvgnd_1
XTAP_TAPCELL_ROW_191_4035 VSS VDD sky130_fd_sc_hd__tapvpwrvgnd_1
XTAP_TAPCELL_ROW_191_4036 VSS VDD sky130_fd_sc_hd__tapvpwrvgnd_1
XTAP_TAPCELL_ROW_191_4037 VSS VDD sky130_fd_sc_hd__tapvpwrvgnd_1
XTAP_TAPCELL_ROW_191_4038 VSS VDD sky130_fd_sc_hd__tapvpwrvgnd_1
XTAP_TAPCELL_ROW_191_4039 VSS VDD sky130_fd_sc_hd__tapvpwrvgnd_1
XTAP_TAPCELL_ROW_191_4040 VSS VDD sky130_fd_sc_hd__tapvpwrvgnd_1
XTAP_TAPCELL_ROW_191_4041 VSS VDD sky130_fd_sc_hd__tapvpwrvgnd_1
XTAP_TAPCELL_ROW_191_4042 VSS VDD sky130_fd_sc_hd__tapvpwrvgnd_1
XTAP_TAPCELL_ROW_191_4043 VSS VDD sky130_fd_sc_hd__tapvpwrvgnd_1
XTAP_TAPCELL_ROW_191_4044 VSS VDD sky130_fd_sc_hd__tapvpwrvgnd_1
XTAP_TAPCELL_ROW_191_4045 VSS VDD sky130_fd_sc_hd__tapvpwrvgnd_1
XTAP_TAPCELL_ROW_191_4046 VSS VDD sky130_fd_sc_hd__tapvpwrvgnd_1
XTAP_TAPCELL_ROW_191_4047 VSS VDD sky130_fd_sc_hd__tapvpwrvgnd_1
XTAP_TAPCELL_ROW_191_4048 VSS VDD sky130_fd_sc_hd__tapvpwrvgnd_1
XTAP_TAPCELL_ROW_191_4049 VSS VDD sky130_fd_sc_hd__tapvpwrvgnd_1
XTAP_TAPCELL_ROW_191_4050 VSS VDD sky130_fd_sc_hd__tapvpwrvgnd_1
XTAP_TAPCELL_ROW_191_4051 VSS VDD sky130_fd_sc_hd__tapvpwrvgnd_1
XTAP_TAPCELL_ROW_191_4052 VSS VDD sky130_fd_sc_hd__tapvpwrvgnd_1
XTAP_TAPCELL_ROW_192_4053 VSS VDD sky130_fd_sc_hd__tapvpwrvgnd_1
XTAP_TAPCELL_ROW_192_4054 VSS VDD sky130_fd_sc_hd__tapvpwrvgnd_1
XTAP_TAPCELL_ROW_192_4055 VSS VDD sky130_fd_sc_hd__tapvpwrvgnd_1
XTAP_TAPCELL_ROW_192_4056 VSS VDD sky130_fd_sc_hd__tapvpwrvgnd_1
XTAP_TAPCELL_ROW_192_4057 VSS VDD sky130_fd_sc_hd__tapvpwrvgnd_1
XTAP_TAPCELL_ROW_192_4058 VSS VDD sky130_fd_sc_hd__tapvpwrvgnd_1
XTAP_TAPCELL_ROW_192_4059 VSS VDD sky130_fd_sc_hd__tapvpwrvgnd_1
XTAP_TAPCELL_ROW_192_4060 VSS VDD sky130_fd_sc_hd__tapvpwrvgnd_1
XTAP_TAPCELL_ROW_192_4061 VSS VDD sky130_fd_sc_hd__tapvpwrvgnd_1
XTAP_TAPCELL_ROW_192_4062 VSS VDD sky130_fd_sc_hd__tapvpwrvgnd_1
XTAP_TAPCELL_ROW_192_4063 VSS VDD sky130_fd_sc_hd__tapvpwrvgnd_1
XTAP_TAPCELL_ROW_192_4064 VSS VDD sky130_fd_sc_hd__tapvpwrvgnd_1
XTAP_TAPCELL_ROW_192_4065 VSS VDD sky130_fd_sc_hd__tapvpwrvgnd_1
XTAP_TAPCELL_ROW_192_4066 VSS VDD sky130_fd_sc_hd__tapvpwrvgnd_1
XTAP_TAPCELL_ROW_192_4067 VSS VDD sky130_fd_sc_hd__tapvpwrvgnd_1
XTAP_TAPCELL_ROW_192_4068 VSS VDD sky130_fd_sc_hd__tapvpwrvgnd_1
XTAP_TAPCELL_ROW_192_4069 VSS VDD sky130_fd_sc_hd__tapvpwrvgnd_1
XTAP_TAPCELL_ROW_192_4070 VSS VDD sky130_fd_sc_hd__tapvpwrvgnd_1
XTAP_TAPCELL_ROW_192_4071 VSS VDD sky130_fd_sc_hd__tapvpwrvgnd_1
XTAP_TAPCELL_ROW_192_4072 VSS VDD sky130_fd_sc_hd__tapvpwrvgnd_1
XTAP_TAPCELL_ROW_192_4073 VSS VDD sky130_fd_sc_hd__tapvpwrvgnd_1
XTAP_TAPCELL_ROW_193_4074 VSS VDD sky130_fd_sc_hd__tapvpwrvgnd_1
XTAP_TAPCELL_ROW_193_4075 VSS VDD sky130_fd_sc_hd__tapvpwrvgnd_1
XTAP_TAPCELL_ROW_193_4076 VSS VDD sky130_fd_sc_hd__tapvpwrvgnd_1
XTAP_TAPCELL_ROW_193_4077 VSS VDD sky130_fd_sc_hd__tapvpwrvgnd_1
XTAP_TAPCELL_ROW_193_4078 VSS VDD sky130_fd_sc_hd__tapvpwrvgnd_1
XTAP_TAPCELL_ROW_193_4079 VSS VDD sky130_fd_sc_hd__tapvpwrvgnd_1
XTAP_TAPCELL_ROW_193_4080 VSS VDD sky130_fd_sc_hd__tapvpwrvgnd_1
XTAP_TAPCELL_ROW_193_4081 VSS VDD sky130_fd_sc_hd__tapvpwrvgnd_1
XTAP_TAPCELL_ROW_193_4082 VSS VDD sky130_fd_sc_hd__tapvpwrvgnd_1
XTAP_TAPCELL_ROW_193_4083 VSS VDD sky130_fd_sc_hd__tapvpwrvgnd_1
XTAP_TAPCELL_ROW_193_4084 VSS VDD sky130_fd_sc_hd__tapvpwrvgnd_1
XTAP_TAPCELL_ROW_193_4085 VSS VDD sky130_fd_sc_hd__tapvpwrvgnd_1
XTAP_TAPCELL_ROW_193_4086 VSS VDD sky130_fd_sc_hd__tapvpwrvgnd_1
XTAP_TAPCELL_ROW_193_4087 VSS VDD sky130_fd_sc_hd__tapvpwrvgnd_1
XTAP_TAPCELL_ROW_193_4088 VSS VDD sky130_fd_sc_hd__tapvpwrvgnd_1
XTAP_TAPCELL_ROW_193_4089 VSS VDD sky130_fd_sc_hd__tapvpwrvgnd_1
XTAP_TAPCELL_ROW_193_4090 VSS VDD sky130_fd_sc_hd__tapvpwrvgnd_1
XTAP_TAPCELL_ROW_193_4091 VSS VDD sky130_fd_sc_hd__tapvpwrvgnd_1
XTAP_TAPCELL_ROW_193_4092 VSS VDD sky130_fd_sc_hd__tapvpwrvgnd_1
XTAP_TAPCELL_ROW_193_4093 VSS VDD sky130_fd_sc_hd__tapvpwrvgnd_1
XTAP_TAPCELL_ROW_193_4094 VSS VDD sky130_fd_sc_hd__tapvpwrvgnd_1
XTAP_TAPCELL_ROW_194_4095 VSS VDD sky130_fd_sc_hd__tapvpwrvgnd_1
XTAP_TAPCELL_ROW_194_4096 VSS VDD sky130_fd_sc_hd__tapvpwrvgnd_1
XTAP_TAPCELL_ROW_194_4097 VSS VDD sky130_fd_sc_hd__tapvpwrvgnd_1
XTAP_TAPCELL_ROW_194_4098 VSS VDD sky130_fd_sc_hd__tapvpwrvgnd_1
XTAP_TAPCELL_ROW_194_4099 VSS VDD sky130_fd_sc_hd__tapvpwrvgnd_1
XTAP_TAPCELL_ROW_194_4100 VSS VDD sky130_fd_sc_hd__tapvpwrvgnd_1
XTAP_TAPCELL_ROW_194_4101 VSS VDD sky130_fd_sc_hd__tapvpwrvgnd_1
XTAP_TAPCELL_ROW_194_4102 VSS VDD sky130_fd_sc_hd__tapvpwrvgnd_1
XTAP_TAPCELL_ROW_194_4103 VSS VDD sky130_fd_sc_hd__tapvpwrvgnd_1
XTAP_TAPCELL_ROW_194_4104 VSS VDD sky130_fd_sc_hd__tapvpwrvgnd_1
XTAP_TAPCELL_ROW_194_4105 VSS VDD sky130_fd_sc_hd__tapvpwrvgnd_1
XTAP_TAPCELL_ROW_194_4106 VSS VDD sky130_fd_sc_hd__tapvpwrvgnd_1
XTAP_TAPCELL_ROW_194_4107 VSS VDD sky130_fd_sc_hd__tapvpwrvgnd_1
XTAP_TAPCELL_ROW_194_4108 VSS VDD sky130_fd_sc_hd__tapvpwrvgnd_1
XTAP_TAPCELL_ROW_194_4109 VSS VDD sky130_fd_sc_hd__tapvpwrvgnd_1
XTAP_TAPCELL_ROW_194_4110 VSS VDD sky130_fd_sc_hd__tapvpwrvgnd_1
XTAP_TAPCELL_ROW_194_4111 VSS VDD sky130_fd_sc_hd__tapvpwrvgnd_1
XTAP_TAPCELL_ROW_194_4112 VSS VDD sky130_fd_sc_hd__tapvpwrvgnd_1
XTAP_TAPCELL_ROW_194_4113 VSS VDD sky130_fd_sc_hd__tapvpwrvgnd_1
XTAP_TAPCELL_ROW_194_4114 VSS VDD sky130_fd_sc_hd__tapvpwrvgnd_1
XTAP_TAPCELL_ROW_194_4115 VSS VDD sky130_fd_sc_hd__tapvpwrvgnd_1
XTAP_TAPCELL_ROW_195_4116 VSS VDD sky130_fd_sc_hd__tapvpwrvgnd_1
XTAP_TAPCELL_ROW_195_4117 VSS VDD sky130_fd_sc_hd__tapvpwrvgnd_1
XTAP_TAPCELL_ROW_195_4118 VSS VDD sky130_fd_sc_hd__tapvpwrvgnd_1
XTAP_TAPCELL_ROW_195_4119 VSS VDD sky130_fd_sc_hd__tapvpwrvgnd_1
XTAP_TAPCELL_ROW_195_4120 VSS VDD sky130_fd_sc_hd__tapvpwrvgnd_1
XTAP_TAPCELL_ROW_195_4121 VSS VDD sky130_fd_sc_hd__tapvpwrvgnd_1
XTAP_TAPCELL_ROW_195_4122 VSS VDD sky130_fd_sc_hd__tapvpwrvgnd_1
XTAP_TAPCELL_ROW_195_4123 VSS VDD sky130_fd_sc_hd__tapvpwrvgnd_1
XTAP_TAPCELL_ROW_195_4124 VSS VDD sky130_fd_sc_hd__tapvpwrvgnd_1
XTAP_TAPCELL_ROW_195_4125 VSS VDD sky130_fd_sc_hd__tapvpwrvgnd_1
XTAP_TAPCELL_ROW_195_4126 VSS VDD sky130_fd_sc_hd__tapvpwrvgnd_1
XTAP_TAPCELL_ROW_195_4127 VSS VDD sky130_fd_sc_hd__tapvpwrvgnd_1
XTAP_TAPCELL_ROW_195_4128 VSS VDD sky130_fd_sc_hd__tapvpwrvgnd_1
XTAP_TAPCELL_ROW_195_4129 VSS VDD sky130_fd_sc_hd__tapvpwrvgnd_1
XTAP_TAPCELL_ROW_195_4130 VSS VDD sky130_fd_sc_hd__tapvpwrvgnd_1
XTAP_TAPCELL_ROW_195_4131 VSS VDD sky130_fd_sc_hd__tapvpwrvgnd_1
XTAP_TAPCELL_ROW_195_4132 VSS VDD sky130_fd_sc_hd__tapvpwrvgnd_1
XTAP_TAPCELL_ROW_195_4133 VSS VDD sky130_fd_sc_hd__tapvpwrvgnd_1
XTAP_TAPCELL_ROW_195_4134 VSS VDD sky130_fd_sc_hd__tapvpwrvgnd_1
XTAP_TAPCELL_ROW_195_4135 VSS VDD sky130_fd_sc_hd__tapvpwrvgnd_1
XTAP_TAPCELL_ROW_195_4136 VSS VDD sky130_fd_sc_hd__tapvpwrvgnd_1
XTAP_TAPCELL_ROW_196_4137 VSS VDD sky130_fd_sc_hd__tapvpwrvgnd_1
XTAP_TAPCELL_ROW_196_4138 VSS VDD sky130_fd_sc_hd__tapvpwrvgnd_1
XTAP_TAPCELL_ROW_196_4139 VSS VDD sky130_fd_sc_hd__tapvpwrvgnd_1
XTAP_TAPCELL_ROW_196_4140 VSS VDD sky130_fd_sc_hd__tapvpwrvgnd_1
XTAP_TAPCELL_ROW_196_4141 VSS VDD sky130_fd_sc_hd__tapvpwrvgnd_1
XTAP_TAPCELL_ROW_196_4142 VSS VDD sky130_fd_sc_hd__tapvpwrvgnd_1
XTAP_TAPCELL_ROW_196_4143 VSS VDD sky130_fd_sc_hd__tapvpwrvgnd_1
XTAP_TAPCELL_ROW_196_4144 VSS VDD sky130_fd_sc_hd__tapvpwrvgnd_1
XTAP_TAPCELL_ROW_196_4145 VSS VDD sky130_fd_sc_hd__tapvpwrvgnd_1
XTAP_TAPCELL_ROW_196_4146 VSS VDD sky130_fd_sc_hd__tapvpwrvgnd_1
XTAP_TAPCELL_ROW_196_4147 VSS VDD sky130_fd_sc_hd__tapvpwrvgnd_1
XTAP_TAPCELL_ROW_196_4148 VSS VDD sky130_fd_sc_hd__tapvpwrvgnd_1
XTAP_TAPCELL_ROW_196_4149 VSS VDD sky130_fd_sc_hd__tapvpwrvgnd_1
XTAP_TAPCELL_ROW_196_4150 VSS VDD sky130_fd_sc_hd__tapvpwrvgnd_1
XTAP_TAPCELL_ROW_196_4151 VSS VDD sky130_fd_sc_hd__tapvpwrvgnd_1
XTAP_TAPCELL_ROW_196_4152 VSS VDD sky130_fd_sc_hd__tapvpwrvgnd_1
XTAP_TAPCELL_ROW_196_4153 VSS VDD sky130_fd_sc_hd__tapvpwrvgnd_1
XTAP_TAPCELL_ROW_196_4154 VSS VDD sky130_fd_sc_hd__tapvpwrvgnd_1
XTAP_TAPCELL_ROW_196_4155 VSS VDD sky130_fd_sc_hd__tapvpwrvgnd_1
XTAP_TAPCELL_ROW_196_4156 VSS VDD sky130_fd_sc_hd__tapvpwrvgnd_1
XTAP_TAPCELL_ROW_196_4157 VSS VDD sky130_fd_sc_hd__tapvpwrvgnd_1
XTAP_TAPCELL_ROW_197_4158 VSS VDD sky130_fd_sc_hd__tapvpwrvgnd_1
XTAP_TAPCELL_ROW_197_4159 VSS VDD sky130_fd_sc_hd__tapvpwrvgnd_1
XTAP_TAPCELL_ROW_197_4160 VSS VDD sky130_fd_sc_hd__tapvpwrvgnd_1
XTAP_TAPCELL_ROW_197_4161 VSS VDD sky130_fd_sc_hd__tapvpwrvgnd_1
XTAP_TAPCELL_ROW_197_4162 VSS VDD sky130_fd_sc_hd__tapvpwrvgnd_1
XTAP_TAPCELL_ROW_197_4163 VSS VDD sky130_fd_sc_hd__tapvpwrvgnd_1
XTAP_TAPCELL_ROW_197_4164 VSS VDD sky130_fd_sc_hd__tapvpwrvgnd_1
XTAP_TAPCELL_ROW_197_4165 VSS VDD sky130_fd_sc_hd__tapvpwrvgnd_1
XTAP_TAPCELL_ROW_197_4166 VSS VDD sky130_fd_sc_hd__tapvpwrvgnd_1
XTAP_TAPCELL_ROW_197_4167 VSS VDD sky130_fd_sc_hd__tapvpwrvgnd_1
XTAP_TAPCELL_ROW_197_4168 VSS VDD sky130_fd_sc_hd__tapvpwrvgnd_1
XTAP_TAPCELL_ROW_197_4169 VSS VDD sky130_fd_sc_hd__tapvpwrvgnd_1
XTAP_TAPCELL_ROW_197_4170 VSS VDD sky130_fd_sc_hd__tapvpwrvgnd_1
XTAP_TAPCELL_ROW_197_4171 VSS VDD sky130_fd_sc_hd__tapvpwrvgnd_1
XTAP_TAPCELL_ROW_197_4172 VSS VDD sky130_fd_sc_hd__tapvpwrvgnd_1
XTAP_TAPCELL_ROW_197_4173 VSS VDD sky130_fd_sc_hd__tapvpwrvgnd_1
XTAP_TAPCELL_ROW_197_4174 VSS VDD sky130_fd_sc_hd__tapvpwrvgnd_1
XTAP_TAPCELL_ROW_197_4175 VSS VDD sky130_fd_sc_hd__tapvpwrvgnd_1
XTAP_TAPCELL_ROW_197_4176 VSS VDD sky130_fd_sc_hd__tapvpwrvgnd_1
XTAP_TAPCELL_ROW_197_4177 VSS VDD sky130_fd_sc_hd__tapvpwrvgnd_1
XTAP_TAPCELL_ROW_197_4178 VSS VDD sky130_fd_sc_hd__tapvpwrvgnd_1
XTAP_TAPCELL_ROW_198_4179 VSS VDD sky130_fd_sc_hd__tapvpwrvgnd_1
XTAP_TAPCELL_ROW_198_4180 VSS VDD sky130_fd_sc_hd__tapvpwrvgnd_1
XTAP_TAPCELL_ROW_198_4181 VSS VDD sky130_fd_sc_hd__tapvpwrvgnd_1
XTAP_TAPCELL_ROW_198_4182 VSS VDD sky130_fd_sc_hd__tapvpwrvgnd_1
XTAP_TAPCELL_ROW_198_4183 VSS VDD sky130_fd_sc_hd__tapvpwrvgnd_1
XTAP_TAPCELL_ROW_198_4184 VSS VDD sky130_fd_sc_hd__tapvpwrvgnd_1
XTAP_TAPCELL_ROW_198_4185 VSS VDD sky130_fd_sc_hd__tapvpwrvgnd_1
XTAP_TAPCELL_ROW_198_4186 VSS VDD sky130_fd_sc_hd__tapvpwrvgnd_1
XTAP_TAPCELL_ROW_198_4187 VSS VDD sky130_fd_sc_hd__tapvpwrvgnd_1
XTAP_TAPCELL_ROW_198_4188 VSS VDD sky130_fd_sc_hd__tapvpwrvgnd_1
XTAP_TAPCELL_ROW_198_4189 VSS VDD sky130_fd_sc_hd__tapvpwrvgnd_1
XTAP_TAPCELL_ROW_198_4190 VSS VDD sky130_fd_sc_hd__tapvpwrvgnd_1
XTAP_TAPCELL_ROW_198_4191 VSS VDD sky130_fd_sc_hd__tapvpwrvgnd_1
XTAP_TAPCELL_ROW_198_4192 VSS VDD sky130_fd_sc_hd__tapvpwrvgnd_1
XTAP_TAPCELL_ROW_198_4193 VSS VDD sky130_fd_sc_hd__tapvpwrvgnd_1
XTAP_TAPCELL_ROW_198_4194 VSS VDD sky130_fd_sc_hd__tapvpwrvgnd_1
XTAP_TAPCELL_ROW_198_4195 VSS VDD sky130_fd_sc_hd__tapvpwrvgnd_1
XTAP_TAPCELL_ROW_198_4196 VSS VDD sky130_fd_sc_hd__tapvpwrvgnd_1
XTAP_TAPCELL_ROW_198_4197 VSS VDD sky130_fd_sc_hd__tapvpwrvgnd_1
XTAP_TAPCELL_ROW_198_4198 VSS VDD sky130_fd_sc_hd__tapvpwrvgnd_1
XTAP_TAPCELL_ROW_198_4199 VSS VDD sky130_fd_sc_hd__tapvpwrvgnd_1
XTAP_TAPCELL_ROW_199_4200 VSS VDD sky130_fd_sc_hd__tapvpwrvgnd_1
XTAP_TAPCELL_ROW_199_4201 VSS VDD sky130_fd_sc_hd__tapvpwrvgnd_1
XTAP_TAPCELL_ROW_199_4202 VSS VDD sky130_fd_sc_hd__tapvpwrvgnd_1
XTAP_TAPCELL_ROW_199_4203 VSS VDD sky130_fd_sc_hd__tapvpwrvgnd_1
XTAP_TAPCELL_ROW_199_4204 VSS VDD sky130_fd_sc_hd__tapvpwrvgnd_1
XTAP_TAPCELL_ROW_199_4205 VSS VDD sky130_fd_sc_hd__tapvpwrvgnd_1
XTAP_TAPCELL_ROW_199_4206 VSS VDD sky130_fd_sc_hd__tapvpwrvgnd_1
XTAP_TAPCELL_ROW_199_4207 VSS VDD sky130_fd_sc_hd__tapvpwrvgnd_1
XTAP_TAPCELL_ROW_199_4208 VSS VDD sky130_fd_sc_hd__tapvpwrvgnd_1
XTAP_TAPCELL_ROW_199_4209 VSS VDD sky130_fd_sc_hd__tapvpwrvgnd_1
XTAP_TAPCELL_ROW_199_4210 VSS VDD sky130_fd_sc_hd__tapvpwrvgnd_1
XTAP_TAPCELL_ROW_199_4211 VSS VDD sky130_fd_sc_hd__tapvpwrvgnd_1
XTAP_TAPCELL_ROW_199_4212 VSS VDD sky130_fd_sc_hd__tapvpwrvgnd_1
XTAP_TAPCELL_ROW_199_4213 VSS VDD sky130_fd_sc_hd__tapvpwrvgnd_1
XTAP_TAPCELL_ROW_199_4214 VSS VDD sky130_fd_sc_hd__tapvpwrvgnd_1
XTAP_TAPCELL_ROW_199_4215 VSS VDD sky130_fd_sc_hd__tapvpwrvgnd_1
XTAP_TAPCELL_ROW_199_4216 VSS VDD sky130_fd_sc_hd__tapvpwrvgnd_1
XTAP_TAPCELL_ROW_199_4217 VSS VDD sky130_fd_sc_hd__tapvpwrvgnd_1
XTAP_TAPCELL_ROW_199_4218 VSS VDD sky130_fd_sc_hd__tapvpwrvgnd_1
XTAP_TAPCELL_ROW_199_4219 VSS VDD sky130_fd_sc_hd__tapvpwrvgnd_1
XTAP_TAPCELL_ROW_199_4220 VSS VDD sky130_fd_sc_hd__tapvpwrvgnd_1
XTAP_TAPCELL_ROW_200_4221 VSS VDD sky130_fd_sc_hd__tapvpwrvgnd_1
XTAP_TAPCELL_ROW_200_4222 VSS VDD sky130_fd_sc_hd__tapvpwrvgnd_1
XTAP_TAPCELL_ROW_200_4223 VSS VDD sky130_fd_sc_hd__tapvpwrvgnd_1
XTAP_TAPCELL_ROW_200_4224 VSS VDD sky130_fd_sc_hd__tapvpwrvgnd_1
XTAP_TAPCELL_ROW_200_4225 VSS VDD sky130_fd_sc_hd__tapvpwrvgnd_1
XTAP_TAPCELL_ROW_200_4226 VSS VDD sky130_fd_sc_hd__tapvpwrvgnd_1
XTAP_TAPCELL_ROW_200_4227 VSS VDD sky130_fd_sc_hd__tapvpwrvgnd_1
XTAP_TAPCELL_ROW_200_4228 VSS VDD sky130_fd_sc_hd__tapvpwrvgnd_1
XTAP_TAPCELL_ROW_200_4229 VSS VDD sky130_fd_sc_hd__tapvpwrvgnd_1
XTAP_TAPCELL_ROW_200_4230 VSS VDD sky130_fd_sc_hd__tapvpwrvgnd_1
XTAP_TAPCELL_ROW_200_4231 VSS VDD sky130_fd_sc_hd__tapvpwrvgnd_1
XTAP_TAPCELL_ROW_200_4232 VSS VDD sky130_fd_sc_hd__tapvpwrvgnd_1
XTAP_TAPCELL_ROW_200_4233 VSS VDD sky130_fd_sc_hd__tapvpwrvgnd_1
XTAP_TAPCELL_ROW_200_4234 VSS VDD sky130_fd_sc_hd__tapvpwrvgnd_1
XTAP_TAPCELL_ROW_200_4235 VSS VDD sky130_fd_sc_hd__tapvpwrvgnd_1
XTAP_TAPCELL_ROW_200_4236 VSS VDD sky130_fd_sc_hd__tapvpwrvgnd_1
XTAP_TAPCELL_ROW_200_4237 VSS VDD sky130_fd_sc_hd__tapvpwrvgnd_1
XTAP_TAPCELL_ROW_200_4238 VSS VDD sky130_fd_sc_hd__tapvpwrvgnd_1
XTAP_TAPCELL_ROW_200_4239 VSS VDD sky130_fd_sc_hd__tapvpwrvgnd_1
XTAP_TAPCELL_ROW_200_4240 VSS VDD sky130_fd_sc_hd__tapvpwrvgnd_1
XTAP_TAPCELL_ROW_200_4241 VSS VDD sky130_fd_sc_hd__tapvpwrvgnd_1
XTAP_TAPCELL_ROW_201_4242 VSS VDD sky130_fd_sc_hd__tapvpwrvgnd_1
XTAP_TAPCELL_ROW_201_4243 VSS VDD sky130_fd_sc_hd__tapvpwrvgnd_1
XTAP_TAPCELL_ROW_201_4244 VSS VDD sky130_fd_sc_hd__tapvpwrvgnd_1
XTAP_TAPCELL_ROW_201_4245 VSS VDD sky130_fd_sc_hd__tapvpwrvgnd_1
XTAP_TAPCELL_ROW_201_4246 VSS VDD sky130_fd_sc_hd__tapvpwrvgnd_1
XTAP_TAPCELL_ROW_201_4247 VSS VDD sky130_fd_sc_hd__tapvpwrvgnd_1
XTAP_TAPCELL_ROW_201_4248 VSS VDD sky130_fd_sc_hd__tapvpwrvgnd_1
XTAP_TAPCELL_ROW_201_4249 VSS VDD sky130_fd_sc_hd__tapvpwrvgnd_1
XTAP_TAPCELL_ROW_201_4250 VSS VDD sky130_fd_sc_hd__tapvpwrvgnd_1
XTAP_TAPCELL_ROW_201_4251 VSS VDD sky130_fd_sc_hd__tapvpwrvgnd_1
XTAP_TAPCELL_ROW_201_4252 VSS VDD sky130_fd_sc_hd__tapvpwrvgnd_1
XTAP_TAPCELL_ROW_201_4253 VSS VDD sky130_fd_sc_hd__tapvpwrvgnd_1
XTAP_TAPCELL_ROW_201_4254 VSS VDD sky130_fd_sc_hd__tapvpwrvgnd_1
XTAP_TAPCELL_ROW_201_4255 VSS VDD sky130_fd_sc_hd__tapvpwrvgnd_1
XTAP_TAPCELL_ROW_201_4256 VSS VDD sky130_fd_sc_hd__tapvpwrvgnd_1
XTAP_TAPCELL_ROW_201_4257 VSS VDD sky130_fd_sc_hd__tapvpwrvgnd_1
XTAP_TAPCELL_ROW_201_4258 VSS VDD sky130_fd_sc_hd__tapvpwrvgnd_1
XTAP_TAPCELL_ROW_201_4259 VSS VDD sky130_fd_sc_hd__tapvpwrvgnd_1
XTAP_TAPCELL_ROW_201_4260 VSS VDD sky130_fd_sc_hd__tapvpwrvgnd_1
XTAP_TAPCELL_ROW_201_4261 VSS VDD sky130_fd_sc_hd__tapvpwrvgnd_1
XTAP_TAPCELL_ROW_201_4262 VSS VDD sky130_fd_sc_hd__tapvpwrvgnd_1
XTAP_TAPCELL_ROW_202_4263 VSS VDD sky130_fd_sc_hd__tapvpwrvgnd_1
XTAP_TAPCELL_ROW_202_4264 VSS VDD sky130_fd_sc_hd__tapvpwrvgnd_1
XTAP_TAPCELL_ROW_202_4265 VSS VDD sky130_fd_sc_hd__tapvpwrvgnd_1
XTAP_TAPCELL_ROW_202_4266 VSS VDD sky130_fd_sc_hd__tapvpwrvgnd_1
XTAP_TAPCELL_ROW_202_4267 VSS VDD sky130_fd_sc_hd__tapvpwrvgnd_1
XTAP_TAPCELL_ROW_202_4268 VSS VDD sky130_fd_sc_hd__tapvpwrvgnd_1
XTAP_TAPCELL_ROW_202_4269 VSS VDD sky130_fd_sc_hd__tapvpwrvgnd_1
XTAP_TAPCELL_ROW_202_4270 VSS VDD sky130_fd_sc_hd__tapvpwrvgnd_1
XTAP_TAPCELL_ROW_202_4271 VSS VDD sky130_fd_sc_hd__tapvpwrvgnd_1
XTAP_TAPCELL_ROW_202_4272 VSS VDD sky130_fd_sc_hd__tapvpwrvgnd_1
XTAP_TAPCELL_ROW_202_4273 VSS VDD sky130_fd_sc_hd__tapvpwrvgnd_1
XTAP_TAPCELL_ROW_202_4274 VSS VDD sky130_fd_sc_hd__tapvpwrvgnd_1
XTAP_TAPCELL_ROW_202_4275 VSS VDD sky130_fd_sc_hd__tapvpwrvgnd_1
XTAP_TAPCELL_ROW_202_4276 VSS VDD sky130_fd_sc_hd__tapvpwrvgnd_1
XTAP_TAPCELL_ROW_202_4277 VSS VDD sky130_fd_sc_hd__tapvpwrvgnd_1
XTAP_TAPCELL_ROW_202_4278 VSS VDD sky130_fd_sc_hd__tapvpwrvgnd_1
XTAP_TAPCELL_ROW_202_4279 VSS VDD sky130_fd_sc_hd__tapvpwrvgnd_1
XTAP_TAPCELL_ROW_202_4280 VSS VDD sky130_fd_sc_hd__tapvpwrvgnd_1
XTAP_TAPCELL_ROW_202_4281 VSS VDD sky130_fd_sc_hd__tapvpwrvgnd_1
XTAP_TAPCELL_ROW_202_4282 VSS VDD sky130_fd_sc_hd__tapvpwrvgnd_1
XTAP_TAPCELL_ROW_202_4283 VSS VDD sky130_fd_sc_hd__tapvpwrvgnd_1
XTAP_TAPCELL_ROW_203_4284 VSS VDD sky130_fd_sc_hd__tapvpwrvgnd_1
XTAP_TAPCELL_ROW_203_4285 VSS VDD sky130_fd_sc_hd__tapvpwrvgnd_1
XTAP_TAPCELL_ROW_203_4286 VSS VDD sky130_fd_sc_hd__tapvpwrvgnd_1
XTAP_TAPCELL_ROW_203_4287 VSS VDD sky130_fd_sc_hd__tapvpwrvgnd_1
XTAP_TAPCELL_ROW_203_4288 VSS VDD sky130_fd_sc_hd__tapvpwrvgnd_1
XTAP_TAPCELL_ROW_203_4289 VSS VDD sky130_fd_sc_hd__tapvpwrvgnd_1
XTAP_TAPCELL_ROW_203_4290 VSS VDD sky130_fd_sc_hd__tapvpwrvgnd_1
XTAP_TAPCELL_ROW_203_4291 VSS VDD sky130_fd_sc_hd__tapvpwrvgnd_1
XTAP_TAPCELL_ROW_203_4292 VSS VDD sky130_fd_sc_hd__tapvpwrvgnd_1
XTAP_TAPCELL_ROW_203_4293 VSS VDD sky130_fd_sc_hd__tapvpwrvgnd_1
XTAP_TAPCELL_ROW_203_4294 VSS VDD sky130_fd_sc_hd__tapvpwrvgnd_1
XTAP_TAPCELL_ROW_203_4295 VSS VDD sky130_fd_sc_hd__tapvpwrvgnd_1
XTAP_TAPCELL_ROW_203_4296 VSS VDD sky130_fd_sc_hd__tapvpwrvgnd_1
XTAP_TAPCELL_ROW_203_4297 VSS VDD sky130_fd_sc_hd__tapvpwrvgnd_1
XTAP_TAPCELL_ROW_203_4298 VSS VDD sky130_fd_sc_hd__tapvpwrvgnd_1
XTAP_TAPCELL_ROW_203_4299 VSS VDD sky130_fd_sc_hd__tapvpwrvgnd_1
XTAP_TAPCELL_ROW_203_4300 VSS VDD sky130_fd_sc_hd__tapvpwrvgnd_1
XTAP_TAPCELL_ROW_203_4301 VSS VDD sky130_fd_sc_hd__tapvpwrvgnd_1
XTAP_TAPCELL_ROW_203_4302 VSS VDD sky130_fd_sc_hd__tapvpwrvgnd_1
XTAP_TAPCELL_ROW_203_4303 VSS VDD sky130_fd_sc_hd__tapvpwrvgnd_1
XTAP_TAPCELL_ROW_203_4304 VSS VDD sky130_fd_sc_hd__tapvpwrvgnd_1
XTAP_TAPCELL_ROW_204_4305 VSS VDD sky130_fd_sc_hd__tapvpwrvgnd_1
XTAP_TAPCELL_ROW_204_4306 VSS VDD sky130_fd_sc_hd__tapvpwrvgnd_1
XTAP_TAPCELL_ROW_204_4307 VSS VDD sky130_fd_sc_hd__tapvpwrvgnd_1
XTAP_TAPCELL_ROW_204_4308 VSS VDD sky130_fd_sc_hd__tapvpwrvgnd_1
XTAP_TAPCELL_ROW_204_4309 VSS VDD sky130_fd_sc_hd__tapvpwrvgnd_1
XTAP_TAPCELL_ROW_204_4310 VSS VDD sky130_fd_sc_hd__tapvpwrvgnd_1
XTAP_TAPCELL_ROW_204_4311 VSS VDD sky130_fd_sc_hd__tapvpwrvgnd_1
XTAP_TAPCELL_ROW_204_4312 VSS VDD sky130_fd_sc_hd__tapvpwrvgnd_1
XTAP_TAPCELL_ROW_204_4313 VSS VDD sky130_fd_sc_hd__tapvpwrvgnd_1
XTAP_TAPCELL_ROW_204_4314 VSS VDD sky130_fd_sc_hd__tapvpwrvgnd_1
XTAP_TAPCELL_ROW_204_4315 VSS VDD sky130_fd_sc_hd__tapvpwrvgnd_1
XTAP_TAPCELL_ROW_204_4316 VSS VDD sky130_fd_sc_hd__tapvpwrvgnd_1
XTAP_TAPCELL_ROW_204_4317 VSS VDD sky130_fd_sc_hd__tapvpwrvgnd_1
XTAP_TAPCELL_ROW_204_4318 VSS VDD sky130_fd_sc_hd__tapvpwrvgnd_1
XTAP_TAPCELL_ROW_204_4319 VSS VDD sky130_fd_sc_hd__tapvpwrvgnd_1
XTAP_TAPCELL_ROW_204_4320 VSS VDD sky130_fd_sc_hd__tapvpwrvgnd_1
XTAP_TAPCELL_ROW_204_4321 VSS VDD sky130_fd_sc_hd__tapvpwrvgnd_1
XTAP_TAPCELL_ROW_204_4322 VSS VDD sky130_fd_sc_hd__tapvpwrvgnd_1
XTAP_TAPCELL_ROW_204_4323 VSS VDD sky130_fd_sc_hd__tapvpwrvgnd_1
XTAP_TAPCELL_ROW_204_4324 VSS VDD sky130_fd_sc_hd__tapvpwrvgnd_1
XTAP_TAPCELL_ROW_204_4325 VSS VDD sky130_fd_sc_hd__tapvpwrvgnd_1
XTAP_TAPCELL_ROW_205_4326 VSS VDD sky130_fd_sc_hd__tapvpwrvgnd_1
XTAP_TAPCELL_ROW_205_4327 VSS VDD sky130_fd_sc_hd__tapvpwrvgnd_1
XTAP_TAPCELL_ROW_205_4328 VSS VDD sky130_fd_sc_hd__tapvpwrvgnd_1
XTAP_TAPCELL_ROW_205_4329 VSS VDD sky130_fd_sc_hd__tapvpwrvgnd_1
XTAP_TAPCELL_ROW_205_4330 VSS VDD sky130_fd_sc_hd__tapvpwrvgnd_1
XTAP_TAPCELL_ROW_205_4331 VSS VDD sky130_fd_sc_hd__tapvpwrvgnd_1
XTAP_TAPCELL_ROW_205_4332 VSS VDD sky130_fd_sc_hd__tapvpwrvgnd_1
XTAP_TAPCELL_ROW_205_4333 VSS VDD sky130_fd_sc_hd__tapvpwrvgnd_1
XTAP_TAPCELL_ROW_205_4334 VSS VDD sky130_fd_sc_hd__tapvpwrvgnd_1
XTAP_TAPCELL_ROW_205_4335 VSS VDD sky130_fd_sc_hd__tapvpwrvgnd_1
XTAP_TAPCELL_ROW_205_4336 VSS VDD sky130_fd_sc_hd__tapvpwrvgnd_1
XTAP_TAPCELL_ROW_205_4337 VSS VDD sky130_fd_sc_hd__tapvpwrvgnd_1
XTAP_TAPCELL_ROW_205_4338 VSS VDD sky130_fd_sc_hd__tapvpwrvgnd_1
XTAP_TAPCELL_ROW_205_4339 VSS VDD sky130_fd_sc_hd__tapvpwrvgnd_1
XTAP_TAPCELL_ROW_205_4340 VSS VDD sky130_fd_sc_hd__tapvpwrvgnd_1
XTAP_TAPCELL_ROW_205_4341 VSS VDD sky130_fd_sc_hd__tapvpwrvgnd_1
XTAP_TAPCELL_ROW_205_4342 VSS VDD sky130_fd_sc_hd__tapvpwrvgnd_1
XTAP_TAPCELL_ROW_205_4343 VSS VDD sky130_fd_sc_hd__tapvpwrvgnd_1
XTAP_TAPCELL_ROW_205_4344 VSS VDD sky130_fd_sc_hd__tapvpwrvgnd_1
XTAP_TAPCELL_ROW_205_4345 VSS VDD sky130_fd_sc_hd__tapvpwrvgnd_1
XTAP_TAPCELL_ROW_205_4346 VSS VDD sky130_fd_sc_hd__tapvpwrvgnd_1
XTAP_TAPCELL_ROW_206_4347 VSS VDD sky130_fd_sc_hd__tapvpwrvgnd_1
XTAP_TAPCELL_ROW_206_4348 VSS VDD sky130_fd_sc_hd__tapvpwrvgnd_1
XTAP_TAPCELL_ROW_206_4349 VSS VDD sky130_fd_sc_hd__tapvpwrvgnd_1
XTAP_TAPCELL_ROW_206_4350 VSS VDD sky130_fd_sc_hd__tapvpwrvgnd_1
XTAP_TAPCELL_ROW_206_4351 VSS VDD sky130_fd_sc_hd__tapvpwrvgnd_1
XTAP_TAPCELL_ROW_206_4352 VSS VDD sky130_fd_sc_hd__tapvpwrvgnd_1
XTAP_TAPCELL_ROW_206_4353 VSS VDD sky130_fd_sc_hd__tapvpwrvgnd_1
XTAP_TAPCELL_ROW_206_4354 VSS VDD sky130_fd_sc_hd__tapvpwrvgnd_1
XTAP_TAPCELL_ROW_206_4355 VSS VDD sky130_fd_sc_hd__tapvpwrvgnd_1
XTAP_TAPCELL_ROW_206_4356 VSS VDD sky130_fd_sc_hd__tapvpwrvgnd_1
XTAP_TAPCELL_ROW_206_4357 VSS VDD sky130_fd_sc_hd__tapvpwrvgnd_1
XTAP_TAPCELL_ROW_206_4358 VSS VDD sky130_fd_sc_hd__tapvpwrvgnd_1
XTAP_TAPCELL_ROW_206_4359 VSS VDD sky130_fd_sc_hd__tapvpwrvgnd_1
XTAP_TAPCELL_ROW_206_4360 VSS VDD sky130_fd_sc_hd__tapvpwrvgnd_1
XTAP_TAPCELL_ROW_206_4361 VSS VDD sky130_fd_sc_hd__tapvpwrvgnd_1
XTAP_TAPCELL_ROW_206_4362 VSS VDD sky130_fd_sc_hd__tapvpwrvgnd_1
XTAP_TAPCELL_ROW_206_4363 VSS VDD sky130_fd_sc_hd__tapvpwrvgnd_1
XTAP_TAPCELL_ROW_206_4364 VSS VDD sky130_fd_sc_hd__tapvpwrvgnd_1
XTAP_TAPCELL_ROW_206_4365 VSS VDD sky130_fd_sc_hd__tapvpwrvgnd_1
XTAP_TAPCELL_ROW_206_4366 VSS VDD sky130_fd_sc_hd__tapvpwrvgnd_1
XTAP_TAPCELL_ROW_206_4367 VSS VDD sky130_fd_sc_hd__tapvpwrvgnd_1
XTAP_TAPCELL_ROW_207_4368 VSS VDD sky130_fd_sc_hd__tapvpwrvgnd_1
XTAP_TAPCELL_ROW_207_4369 VSS VDD sky130_fd_sc_hd__tapvpwrvgnd_1
XTAP_TAPCELL_ROW_207_4370 VSS VDD sky130_fd_sc_hd__tapvpwrvgnd_1
XTAP_TAPCELL_ROW_207_4371 VSS VDD sky130_fd_sc_hd__tapvpwrvgnd_1
XTAP_TAPCELL_ROW_207_4372 VSS VDD sky130_fd_sc_hd__tapvpwrvgnd_1
XTAP_TAPCELL_ROW_207_4373 VSS VDD sky130_fd_sc_hd__tapvpwrvgnd_1
XTAP_TAPCELL_ROW_207_4374 VSS VDD sky130_fd_sc_hd__tapvpwrvgnd_1
XTAP_TAPCELL_ROW_207_4375 VSS VDD sky130_fd_sc_hd__tapvpwrvgnd_1
XTAP_TAPCELL_ROW_207_4376 VSS VDD sky130_fd_sc_hd__tapvpwrvgnd_1
XTAP_TAPCELL_ROW_207_4377 VSS VDD sky130_fd_sc_hd__tapvpwrvgnd_1
XTAP_TAPCELL_ROW_207_4378 VSS VDD sky130_fd_sc_hd__tapvpwrvgnd_1
XTAP_TAPCELL_ROW_207_4379 VSS VDD sky130_fd_sc_hd__tapvpwrvgnd_1
XTAP_TAPCELL_ROW_207_4380 VSS VDD sky130_fd_sc_hd__tapvpwrvgnd_1
XTAP_TAPCELL_ROW_207_4381 VSS VDD sky130_fd_sc_hd__tapvpwrvgnd_1
XTAP_TAPCELL_ROW_207_4382 VSS VDD sky130_fd_sc_hd__tapvpwrvgnd_1
XTAP_TAPCELL_ROW_207_4383 VSS VDD sky130_fd_sc_hd__tapvpwrvgnd_1
XTAP_TAPCELL_ROW_207_4384 VSS VDD sky130_fd_sc_hd__tapvpwrvgnd_1
XTAP_TAPCELL_ROW_207_4385 VSS VDD sky130_fd_sc_hd__tapvpwrvgnd_1
XTAP_TAPCELL_ROW_207_4386 VSS VDD sky130_fd_sc_hd__tapvpwrvgnd_1
XTAP_TAPCELL_ROW_207_4387 VSS VDD sky130_fd_sc_hd__tapvpwrvgnd_1
XTAP_TAPCELL_ROW_207_4388 VSS VDD sky130_fd_sc_hd__tapvpwrvgnd_1
XTAP_TAPCELL_ROW_208_4389 VSS VDD sky130_fd_sc_hd__tapvpwrvgnd_1
XTAP_TAPCELL_ROW_208_4390 VSS VDD sky130_fd_sc_hd__tapvpwrvgnd_1
XTAP_TAPCELL_ROW_208_4391 VSS VDD sky130_fd_sc_hd__tapvpwrvgnd_1
XTAP_TAPCELL_ROW_208_4392 VSS VDD sky130_fd_sc_hd__tapvpwrvgnd_1
XTAP_TAPCELL_ROW_208_4393 VSS VDD sky130_fd_sc_hd__tapvpwrvgnd_1
XTAP_TAPCELL_ROW_208_4394 VSS VDD sky130_fd_sc_hd__tapvpwrvgnd_1
XTAP_TAPCELL_ROW_208_4395 VSS VDD sky130_fd_sc_hd__tapvpwrvgnd_1
XTAP_TAPCELL_ROW_208_4396 VSS VDD sky130_fd_sc_hd__tapvpwrvgnd_1
XTAP_TAPCELL_ROW_208_4397 VSS VDD sky130_fd_sc_hd__tapvpwrvgnd_1
XTAP_TAPCELL_ROW_208_4398 VSS VDD sky130_fd_sc_hd__tapvpwrvgnd_1
XTAP_TAPCELL_ROW_208_4399 VSS VDD sky130_fd_sc_hd__tapvpwrvgnd_1
XTAP_TAPCELL_ROW_208_4400 VSS VDD sky130_fd_sc_hd__tapvpwrvgnd_1
XTAP_TAPCELL_ROW_208_4401 VSS VDD sky130_fd_sc_hd__tapvpwrvgnd_1
XTAP_TAPCELL_ROW_208_4402 VSS VDD sky130_fd_sc_hd__tapvpwrvgnd_1
XTAP_TAPCELL_ROW_208_4403 VSS VDD sky130_fd_sc_hd__tapvpwrvgnd_1
XTAP_TAPCELL_ROW_208_4404 VSS VDD sky130_fd_sc_hd__tapvpwrvgnd_1
XTAP_TAPCELL_ROW_208_4405 VSS VDD sky130_fd_sc_hd__tapvpwrvgnd_1
XTAP_TAPCELL_ROW_208_4406 VSS VDD sky130_fd_sc_hd__tapvpwrvgnd_1
XTAP_TAPCELL_ROW_208_4407 VSS VDD sky130_fd_sc_hd__tapvpwrvgnd_1
XTAP_TAPCELL_ROW_208_4408 VSS VDD sky130_fd_sc_hd__tapvpwrvgnd_1
XTAP_TAPCELL_ROW_208_4409 VSS VDD sky130_fd_sc_hd__tapvpwrvgnd_1
XTAP_TAPCELL_ROW_209_4410 VSS VDD sky130_fd_sc_hd__tapvpwrvgnd_1
XTAP_TAPCELL_ROW_209_4411 VSS VDD sky130_fd_sc_hd__tapvpwrvgnd_1
XTAP_TAPCELL_ROW_209_4412 VSS VDD sky130_fd_sc_hd__tapvpwrvgnd_1
XTAP_TAPCELL_ROW_209_4413 VSS VDD sky130_fd_sc_hd__tapvpwrvgnd_1
XTAP_TAPCELL_ROW_209_4414 VSS VDD sky130_fd_sc_hd__tapvpwrvgnd_1
XTAP_TAPCELL_ROW_209_4415 VSS VDD sky130_fd_sc_hd__tapvpwrvgnd_1
XTAP_TAPCELL_ROW_209_4416 VSS VDD sky130_fd_sc_hd__tapvpwrvgnd_1
XTAP_TAPCELL_ROW_209_4417 VSS VDD sky130_fd_sc_hd__tapvpwrvgnd_1
XTAP_TAPCELL_ROW_209_4418 VSS VDD sky130_fd_sc_hd__tapvpwrvgnd_1
XTAP_TAPCELL_ROW_209_4419 VSS VDD sky130_fd_sc_hd__tapvpwrvgnd_1
XTAP_TAPCELL_ROW_209_4420 VSS VDD sky130_fd_sc_hd__tapvpwrvgnd_1
XTAP_TAPCELL_ROW_209_4421 VSS VDD sky130_fd_sc_hd__tapvpwrvgnd_1
XTAP_TAPCELL_ROW_209_4422 VSS VDD sky130_fd_sc_hd__tapvpwrvgnd_1
XTAP_TAPCELL_ROW_209_4423 VSS VDD sky130_fd_sc_hd__tapvpwrvgnd_1
XTAP_TAPCELL_ROW_209_4424 VSS VDD sky130_fd_sc_hd__tapvpwrvgnd_1
XTAP_TAPCELL_ROW_209_4425 VSS VDD sky130_fd_sc_hd__tapvpwrvgnd_1
XTAP_TAPCELL_ROW_209_4426 VSS VDD sky130_fd_sc_hd__tapvpwrvgnd_1
XTAP_TAPCELL_ROW_209_4427 VSS VDD sky130_fd_sc_hd__tapvpwrvgnd_1
XTAP_TAPCELL_ROW_209_4428 VSS VDD sky130_fd_sc_hd__tapvpwrvgnd_1
XTAP_TAPCELL_ROW_209_4429 VSS VDD sky130_fd_sc_hd__tapvpwrvgnd_1
XTAP_TAPCELL_ROW_209_4430 VSS VDD sky130_fd_sc_hd__tapvpwrvgnd_1
XTAP_TAPCELL_ROW_210_4431 VSS VDD sky130_fd_sc_hd__tapvpwrvgnd_1
XTAP_TAPCELL_ROW_210_4432 VSS VDD sky130_fd_sc_hd__tapvpwrvgnd_1
XTAP_TAPCELL_ROW_210_4433 VSS VDD sky130_fd_sc_hd__tapvpwrvgnd_1
XTAP_TAPCELL_ROW_210_4434 VSS VDD sky130_fd_sc_hd__tapvpwrvgnd_1
XTAP_TAPCELL_ROW_210_4435 VSS VDD sky130_fd_sc_hd__tapvpwrvgnd_1
XTAP_TAPCELL_ROW_210_4436 VSS VDD sky130_fd_sc_hd__tapvpwrvgnd_1
XTAP_TAPCELL_ROW_210_4437 VSS VDD sky130_fd_sc_hd__tapvpwrvgnd_1
XTAP_TAPCELL_ROW_210_4438 VSS VDD sky130_fd_sc_hd__tapvpwrvgnd_1
XTAP_TAPCELL_ROW_210_4439 VSS VDD sky130_fd_sc_hd__tapvpwrvgnd_1
XTAP_TAPCELL_ROW_210_4440 VSS VDD sky130_fd_sc_hd__tapvpwrvgnd_1
XTAP_TAPCELL_ROW_210_4441 VSS VDD sky130_fd_sc_hd__tapvpwrvgnd_1
XTAP_TAPCELL_ROW_210_4442 VSS VDD sky130_fd_sc_hd__tapvpwrvgnd_1
XTAP_TAPCELL_ROW_210_4443 VSS VDD sky130_fd_sc_hd__tapvpwrvgnd_1
XTAP_TAPCELL_ROW_210_4444 VSS VDD sky130_fd_sc_hd__tapvpwrvgnd_1
XTAP_TAPCELL_ROW_210_4445 VSS VDD sky130_fd_sc_hd__tapvpwrvgnd_1
XTAP_TAPCELL_ROW_210_4446 VSS VDD sky130_fd_sc_hd__tapvpwrvgnd_1
XTAP_TAPCELL_ROW_210_4447 VSS VDD sky130_fd_sc_hd__tapvpwrvgnd_1
XTAP_TAPCELL_ROW_210_4448 VSS VDD sky130_fd_sc_hd__tapvpwrvgnd_1
XTAP_TAPCELL_ROW_210_4449 VSS VDD sky130_fd_sc_hd__tapvpwrvgnd_1
XTAP_TAPCELL_ROW_210_4450 VSS VDD sky130_fd_sc_hd__tapvpwrvgnd_1
XTAP_TAPCELL_ROW_210_4451 VSS VDD sky130_fd_sc_hd__tapvpwrvgnd_1
XTAP_TAPCELL_ROW_211_4452 VSS VDD sky130_fd_sc_hd__tapvpwrvgnd_1
XTAP_TAPCELL_ROW_211_4453 VSS VDD sky130_fd_sc_hd__tapvpwrvgnd_1
XTAP_TAPCELL_ROW_211_4454 VSS VDD sky130_fd_sc_hd__tapvpwrvgnd_1
XTAP_TAPCELL_ROW_211_4455 VSS VDD sky130_fd_sc_hd__tapvpwrvgnd_1
XTAP_TAPCELL_ROW_211_4456 VSS VDD sky130_fd_sc_hd__tapvpwrvgnd_1
XTAP_TAPCELL_ROW_211_4457 VSS VDD sky130_fd_sc_hd__tapvpwrvgnd_1
XTAP_TAPCELL_ROW_211_4458 VSS VDD sky130_fd_sc_hd__tapvpwrvgnd_1
XTAP_TAPCELL_ROW_211_4459 VSS VDD sky130_fd_sc_hd__tapvpwrvgnd_1
XTAP_TAPCELL_ROW_211_4460 VSS VDD sky130_fd_sc_hd__tapvpwrvgnd_1
XTAP_TAPCELL_ROW_211_4461 VSS VDD sky130_fd_sc_hd__tapvpwrvgnd_1
XTAP_TAPCELL_ROW_211_4462 VSS VDD sky130_fd_sc_hd__tapvpwrvgnd_1
XTAP_TAPCELL_ROW_211_4463 VSS VDD sky130_fd_sc_hd__tapvpwrvgnd_1
XTAP_TAPCELL_ROW_211_4464 VSS VDD sky130_fd_sc_hd__tapvpwrvgnd_1
XTAP_TAPCELL_ROW_211_4465 VSS VDD sky130_fd_sc_hd__tapvpwrvgnd_1
XTAP_TAPCELL_ROW_211_4466 VSS VDD sky130_fd_sc_hd__tapvpwrvgnd_1
XTAP_TAPCELL_ROW_211_4467 VSS VDD sky130_fd_sc_hd__tapvpwrvgnd_1
XTAP_TAPCELL_ROW_211_4468 VSS VDD sky130_fd_sc_hd__tapvpwrvgnd_1
XTAP_TAPCELL_ROW_211_4469 VSS VDD sky130_fd_sc_hd__tapvpwrvgnd_1
XTAP_TAPCELL_ROW_211_4470 VSS VDD sky130_fd_sc_hd__tapvpwrvgnd_1
XTAP_TAPCELL_ROW_211_4471 VSS VDD sky130_fd_sc_hd__tapvpwrvgnd_1
XTAP_TAPCELL_ROW_211_4472 VSS VDD sky130_fd_sc_hd__tapvpwrvgnd_1
XTAP_TAPCELL_ROW_212_4473 VSS VDD sky130_fd_sc_hd__tapvpwrvgnd_1
XTAP_TAPCELL_ROW_212_4474 VSS VDD sky130_fd_sc_hd__tapvpwrvgnd_1
XTAP_TAPCELL_ROW_212_4475 VSS VDD sky130_fd_sc_hd__tapvpwrvgnd_1
XTAP_TAPCELL_ROW_212_4476 VSS VDD sky130_fd_sc_hd__tapvpwrvgnd_1
XTAP_TAPCELL_ROW_212_4477 VSS VDD sky130_fd_sc_hd__tapvpwrvgnd_1
XTAP_TAPCELL_ROW_212_4478 VSS VDD sky130_fd_sc_hd__tapvpwrvgnd_1
XTAP_TAPCELL_ROW_212_4479 VSS VDD sky130_fd_sc_hd__tapvpwrvgnd_1
XTAP_TAPCELL_ROW_212_4480 VSS VDD sky130_fd_sc_hd__tapvpwrvgnd_1
XTAP_TAPCELL_ROW_212_4481 VSS VDD sky130_fd_sc_hd__tapvpwrvgnd_1
XTAP_TAPCELL_ROW_212_4482 VSS VDD sky130_fd_sc_hd__tapvpwrvgnd_1
XTAP_TAPCELL_ROW_212_4483 VSS VDD sky130_fd_sc_hd__tapvpwrvgnd_1
XTAP_TAPCELL_ROW_212_4484 VSS VDD sky130_fd_sc_hd__tapvpwrvgnd_1
XTAP_TAPCELL_ROW_212_4485 VSS VDD sky130_fd_sc_hd__tapvpwrvgnd_1
XTAP_TAPCELL_ROW_212_4486 VSS VDD sky130_fd_sc_hd__tapvpwrvgnd_1
XTAP_TAPCELL_ROW_212_4487 VSS VDD sky130_fd_sc_hd__tapvpwrvgnd_1
XTAP_TAPCELL_ROW_212_4488 VSS VDD sky130_fd_sc_hd__tapvpwrvgnd_1
XTAP_TAPCELL_ROW_212_4489 VSS VDD sky130_fd_sc_hd__tapvpwrvgnd_1
XTAP_TAPCELL_ROW_212_4490 VSS VDD sky130_fd_sc_hd__tapvpwrvgnd_1
XTAP_TAPCELL_ROW_212_4491 VSS VDD sky130_fd_sc_hd__tapvpwrvgnd_1
XTAP_TAPCELL_ROW_212_4492 VSS VDD sky130_fd_sc_hd__tapvpwrvgnd_1
XTAP_TAPCELL_ROW_212_4493 VSS VDD sky130_fd_sc_hd__tapvpwrvgnd_1
XTAP_TAPCELL_ROW_213_4494 VSS VDD sky130_fd_sc_hd__tapvpwrvgnd_1
XTAP_TAPCELL_ROW_213_4495 VSS VDD sky130_fd_sc_hd__tapvpwrvgnd_1
XTAP_TAPCELL_ROW_213_4496 VSS VDD sky130_fd_sc_hd__tapvpwrvgnd_1
XTAP_TAPCELL_ROW_213_4497 VSS VDD sky130_fd_sc_hd__tapvpwrvgnd_1
XTAP_TAPCELL_ROW_213_4498 VSS VDD sky130_fd_sc_hd__tapvpwrvgnd_1
XTAP_TAPCELL_ROW_213_4499 VSS VDD sky130_fd_sc_hd__tapvpwrvgnd_1
XTAP_TAPCELL_ROW_213_4500 VSS VDD sky130_fd_sc_hd__tapvpwrvgnd_1
XTAP_TAPCELL_ROW_213_4501 VSS VDD sky130_fd_sc_hd__tapvpwrvgnd_1
XTAP_TAPCELL_ROW_213_4502 VSS VDD sky130_fd_sc_hd__tapvpwrvgnd_1
XTAP_TAPCELL_ROW_213_4503 VSS VDD sky130_fd_sc_hd__tapvpwrvgnd_1
XTAP_TAPCELL_ROW_213_4504 VSS VDD sky130_fd_sc_hd__tapvpwrvgnd_1
XTAP_TAPCELL_ROW_213_4505 VSS VDD sky130_fd_sc_hd__tapvpwrvgnd_1
XTAP_TAPCELL_ROW_213_4506 VSS VDD sky130_fd_sc_hd__tapvpwrvgnd_1
XTAP_TAPCELL_ROW_213_4507 VSS VDD sky130_fd_sc_hd__tapvpwrvgnd_1
XTAP_TAPCELL_ROW_213_4508 VSS VDD sky130_fd_sc_hd__tapvpwrvgnd_1
XTAP_TAPCELL_ROW_213_4509 VSS VDD sky130_fd_sc_hd__tapvpwrvgnd_1
XTAP_TAPCELL_ROW_213_4510 VSS VDD sky130_fd_sc_hd__tapvpwrvgnd_1
XTAP_TAPCELL_ROW_213_4511 VSS VDD sky130_fd_sc_hd__tapvpwrvgnd_1
XTAP_TAPCELL_ROW_213_4512 VSS VDD sky130_fd_sc_hd__tapvpwrvgnd_1
XTAP_TAPCELL_ROW_213_4513 VSS VDD sky130_fd_sc_hd__tapvpwrvgnd_1
XTAP_TAPCELL_ROW_213_4514 VSS VDD sky130_fd_sc_hd__tapvpwrvgnd_1
XTAP_TAPCELL_ROW_214_4515 VSS VDD sky130_fd_sc_hd__tapvpwrvgnd_1
XTAP_TAPCELL_ROW_214_4516 VSS VDD sky130_fd_sc_hd__tapvpwrvgnd_1
XTAP_TAPCELL_ROW_214_4517 VSS VDD sky130_fd_sc_hd__tapvpwrvgnd_1
XTAP_TAPCELL_ROW_214_4518 VSS VDD sky130_fd_sc_hd__tapvpwrvgnd_1
XTAP_TAPCELL_ROW_214_4519 VSS VDD sky130_fd_sc_hd__tapvpwrvgnd_1
XTAP_TAPCELL_ROW_214_4520 VSS VDD sky130_fd_sc_hd__tapvpwrvgnd_1
XTAP_TAPCELL_ROW_214_4521 VSS VDD sky130_fd_sc_hd__tapvpwrvgnd_1
XTAP_TAPCELL_ROW_214_4522 VSS VDD sky130_fd_sc_hd__tapvpwrvgnd_1
XTAP_TAPCELL_ROW_214_4523 VSS VDD sky130_fd_sc_hd__tapvpwrvgnd_1
XTAP_TAPCELL_ROW_214_4524 VSS VDD sky130_fd_sc_hd__tapvpwrvgnd_1
XTAP_TAPCELL_ROW_214_4525 VSS VDD sky130_fd_sc_hd__tapvpwrvgnd_1
XTAP_TAPCELL_ROW_214_4526 VSS VDD sky130_fd_sc_hd__tapvpwrvgnd_1
XTAP_TAPCELL_ROW_214_4527 VSS VDD sky130_fd_sc_hd__tapvpwrvgnd_1
XTAP_TAPCELL_ROW_214_4528 VSS VDD sky130_fd_sc_hd__tapvpwrvgnd_1
XTAP_TAPCELL_ROW_214_4529 VSS VDD sky130_fd_sc_hd__tapvpwrvgnd_1
XTAP_TAPCELL_ROW_214_4530 VSS VDD sky130_fd_sc_hd__tapvpwrvgnd_1
XTAP_TAPCELL_ROW_214_4531 VSS VDD sky130_fd_sc_hd__tapvpwrvgnd_1
XTAP_TAPCELL_ROW_214_4532 VSS VDD sky130_fd_sc_hd__tapvpwrvgnd_1
XTAP_TAPCELL_ROW_214_4533 VSS VDD sky130_fd_sc_hd__tapvpwrvgnd_1
XTAP_TAPCELL_ROW_214_4534 VSS VDD sky130_fd_sc_hd__tapvpwrvgnd_1
XTAP_TAPCELL_ROW_214_4535 VSS VDD sky130_fd_sc_hd__tapvpwrvgnd_1
XTAP_TAPCELL_ROW_215_4536 VSS VDD sky130_fd_sc_hd__tapvpwrvgnd_1
XTAP_TAPCELL_ROW_215_4537 VSS VDD sky130_fd_sc_hd__tapvpwrvgnd_1
XTAP_TAPCELL_ROW_215_4538 VSS VDD sky130_fd_sc_hd__tapvpwrvgnd_1
XTAP_TAPCELL_ROW_215_4539 VSS VDD sky130_fd_sc_hd__tapvpwrvgnd_1
XTAP_TAPCELL_ROW_215_4540 VSS VDD sky130_fd_sc_hd__tapvpwrvgnd_1
XTAP_TAPCELL_ROW_215_4541 VSS VDD sky130_fd_sc_hd__tapvpwrvgnd_1
XTAP_TAPCELL_ROW_215_4542 VSS VDD sky130_fd_sc_hd__tapvpwrvgnd_1
XTAP_TAPCELL_ROW_215_4543 VSS VDD sky130_fd_sc_hd__tapvpwrvgnd_1
XTAP_TAPCELL_ROW_215_4544 VSS VDD sky130_fd_sc_hd__tapvpwrvgnd_1
XTAP_TAPCELL_ROW_215_4545 VSS VDD sky130_fd_sc_hd__tapvpwrvgnd_1
XTAP_TAPCELL_ROW_215_4546 VSS VDD sky130_fd_sc_hd__tapvpwrvgnd_1
XTAP_TAPCELL_ROW_215_4547 VSS VDD sky130_fd_sc_hd__tapvpwrvgnd_1
XTAP_TAPCELL_ROW_215_4548 VSS VDD sky130_fd_sc_hd__tapvpwrvgnd_1
XTAP_TAPCELL_ROW_215_4549 VSS VDD sky130_fd_sc_hd__tapvpwrvgnd_1
XTAP_TAPCELL_ROW_215_4550 VSS VDD sky130_fd_sc_hd__tapvpwrvgnd_1
XTAP_TAPCELL_ROW_215_4551 VSS VDD sky130_fd_sc_hd__tapvpwrvgnd_1
XTAP_TAPCELL_ROW_215_4552 VSS VDD sky130_fd_sc_hd__tapvpwrvgnd_1
XTAP_TAPCELL_ROW_215_4553 VSS VDD sky130_fd_sc_hd__tapvpwrvgnd_1
XTAP_TAPCELL_ROW_215_4554 VSS VDD sky130_fd_sc_hd__tapvpwrvgnd_1
XTAP_TAPCELL_ROW_215_4555 VSS VDD sky130_fd_sc_hd__tapvpwrvgnd_1
XTAP_TAPCELL_ROW_215_4556 VSS VDD sky130_fd_sc_hd__tapvpwrvgnd_1
XTAP_TAPCELL_ROW_215_4557 VSS VDD sky130_fd_sc_hd__tapvpwrvgnd_1
XTAP_TAPCELL_ROW_215_4558 VSS VDD sky130_fd_sc_hd__tapvpwrvgnd_1
XTAP_TAPCELL_ROW_215_4559 VSS VDD sky130_fd_sc_hd__tapvpwrvgnd_1
XTAP_TAPCELL_ROW_215_4560 VSS VDD sky130_fd_sc_hd__tapvpwrvgnd_1
XTAP_TAPCELL_ROW_215_4561 VSS VDD sky130_fd_sc_hd__tapvpwrvgnd_1
XTAP_TAPCELL_ROW_215_4562 VSS VDD sky130_fd_sc_hd__tapvpwrvgnd_1
XTAP_TAPCELL_ROW_215_4563 VSS VDD sky130_fd_sc_hd__tapvpwrvgnd_1
XTAP_TAPCELL_ROW_215_4564 VSS VDD sky130_fd_sc_hd__tapvpwrvgnd_1
XTAP_TAPCELL_ROW_215_4565 VSS VDD sky130_fd_sc_hd__tapvpwrvgnd_1
XTAP_TAPCELL_ROW_215_4566 VSS VDD sky130_fd_sc_hd__tapvpwrvgnd_1
XTAP_TAPCELL_ROW_215_4567 VSS VDD sky130_fd_sc_hd__tapvpwrvgnd_1
XTAP_TAPCELL_ROW_215_4568 VSS VDD sky130_fd_sc_hd__tapvpwrvgnd_1
XTAP_TAPCELL_ROW_215_4569 VSS VDD sky130_fd_sc_hd__tapvpwrvgnd_1
XTAP_TAPCELL_ROW_215_4570 VSS VDD sky130_fd_sc_hd__tapvpwrvgnd_1
XTAP_TAPCELL_ROW_215_4571 VSS VDD sky130_fd_sc_hd__tapvpwrvgnd_1
XTAP_TAPCELL_ROW_215_4572 VSS VDD sky130_fd_sc_hd__tapvpwrvgnd_1
XTAP_TAPCELL_ROW_215_4573 VSS VDD sky130_fd_sc_hd__tapvpwrvgnd_1
XTAP_TAPCELL_ROW_215_4574 VSS VDD sky130_fd_sc_hd__tapvpwrvgnd_1
XTAP_TAPCELL_ROW_215_4575 VSS VDD sky130_fd_sc_hd__tapvpwrvgnd_1
XTAP_TAPCELL_ROW_215_4576 VSS VDD sky130_fd_sc_hd__tapvpwrvgnd_1
XTAP_TAPCELL_ROW_215_4577 VSS VDD sky130_fd_sc_hd__tapvpwrvgnd_1
Xclkbuf_leaf_224_clk clknet_5_19__leaf_clk VSS VSS VDD VDD
+ clknet_leaf_224_clk sky130_fd_sc_hd__clkbuf_16
Xclkbuf_leaf_225_clk clknet_5_19__leaf_clk VSS VSS VDD VDD
+ clknet_leaf_225_clk sky130_fd_sc_hd__clkbuf_16
Xclkbuf_leaf_226_clk clknet_5_18__leaf_clk VSS VSS VDD VDD
+ clknet_leaf_226_clk sky130_fd_sc_hd__clkbuf_16
Xclkbuf_leaf_227_clk clknet_5_18__leaf_clk VSS VSS VDD VDD
+ clknet_leaf_227_clk sky130_fd_sc_hd__clkbuf_16
Xclkbuf_leaf_228_clk clknet_5_18__leaf_clk VSS VSS VDD VDD
+ clknet_leaf_228_clk sky130_fd_sc_hd__clkbuf_16
Xclkbuf_leaf_229_clk clknet_5_18__leaf_clk VSS VSS VDD VDD
+ clknet_leaf_229_clk sky130_fd_sc_hd__clkbuf_16
Xclkbuf_leaf_230_clk clknet_5_18__leaf_clk VSS VSS VDD VDD
+ clknet_leaf_230_clk sky130_fd_sc_hd__clkbuf_16
Xclkbuf_leaf_231_clk clknet_5_18__leaf_clk VSS VSS VDD VDD
+ clknet_leaf_231_clk sky130_fd_sc_hd__clkbuf_16
Xclkbuf_leaf_232_clk clknet_5_18__leaf_clk VSS VSS VDD VDD
+ clknet_leaf_232_clk sky130_fd_sc_hd__clkbuf_16
Xclkbuf_leaf_233_clk clknet_5_13__leaf_clk VSS VSS VDD VDD
+ clknet_leaf_233_clk sky130_fd_sc_hd__clkbuf_16
Xclkbuf_leaf_234_clk clknet_5_7__leaf_clk VSS VSS VDD VDD
+ clknet_leaf_234_clk sky130_fd_sc_hd__clkbuf_16
Xclkbuf_leaf_235_clk clknet_5_7__leaf_clk VSS VSS VDD VDD
+ clknet_leaf_235_clk sky130_fd_sc_hd__clkbuf_16
Xclkbuf_leaf_236_clk clknet_5_7__leaf_clk VSS VSS VDD VDD
+ clknet_leaf_236_clk sky130_fd_sc_hd__clkbuf_16
Xclkbuf_leaf_237_clk clknet_5_7__leaf_clk VSS VSS VDD VDD
+ clknet_leaf_237_clk sky130_fd_sc_hd__clkbuf_16
Xclkbuf_leaf_238_clk clknet_5_7__leaf_clk VSS VSS VDD VDD
+ clknet_leaf_238_clk sky130_fd_sc_hd__clkbuf_16
Xclkbuf_leaf_239_clk clknet_5_7__leaf_clk VSS VSS VDD VDD
+ clknet_leaf_239_clk sky130_fd_sc_hd__clkbuf_16
Xclkbuf_leaf_240_clk clknet_5_7__leaf_clk VSS VSS VDD VDD
+ clknet_leaf_240_clk sky130_fd_sc_hd__clkbuf_16
Xclkbuf_leaf_241_clk clknet_5_6__leaf_clk VSS VSS VDD VDD
+ clknet_leaf_241_clk sky130_fd_sc_hd__clkbuf_16
Xclkbuf_leaf_242_clk clknet_5_6__leaf_clk VSS VSS VDD VDD
+ clknet_leaf_242_clk sky130_fd_sc_hd__clkbuf_16
Xclkbuf_leaf_243_clk clknet_5_6__leaf_clk VSS VSS VDD VDD
+ clknet_leaf_243_clk sky130_fd_sc_hd__clkbuf_16
Xclkbuf_leaf_244_clk clknet_5_4__leaf_clk VSS VSS VDD VDD
+ clknet_leaf_244_clk sky130_fd_sc_hd__clkbuf_16
Xclkbuf_leaf_245_clk clknet_5_4__leaf_clk VSS VSS VDD VDD
+ clknet_leaf_245_clk sky130_fd_sc_hd__clkbuf_16
Xclkbuf_leaf_246_clk clknet_5_5__leaf_clk VSS VSS VDD VDD
+ clknet_leaf_246_clk sky130_fd_sc_hd__clkbuf_16
Xclkbuf_leaf_247_clk clknet_5_5__leaf_clk VSS VSS VDD VDD
+ clknet_leaf_247_clk sky130_fd_sc_hd__clkbuf_16
Xclkbuf_leaf_248_clk clknet_5_5__leaf_clk VSS VSS VDD VDD
+ clknet_leaf_248_clk sky130_fd_sc_hd__clkbuf_16
Xclkbuf_leaf_249_clk clknet_5_5__leaf_clk VSS VSS VDD VDD
+ clknet_leaf_249_clk sky130_fd_sc_hd__clkbuf_16
Xclkbuf_leaf_250_clk clknet_5_5__leaf_clk VSS VSS VDD VDD
+ clknet_leaf_250_clk sky130_fd_sc_hd__clkbuf_16
Xclkbuf_leaf_251_clk clknet_5_5__leaf_clk VSS VSS VDD VDD
+ clknet_leaf_251_clk sky130_fd_sc_hd__clkbuf_16
Xclkbuf_leaf_252_clk clknet_5_5__leaf_clk VSS VSS VDD VDD
+ clknet_leaf_252_clk sky130_fd_sc_hd__clkbuf_16
Xclkbuf_leaf_253_clk clknet_5_5__leaf_clk VSS VSS VDD VDD
+ clknet_leaf_253_clk sky130_fd_sc_hd__clkbuf_16
Xclkbuf_leaf_254_clk clknet_5_5__leaf_clk VSS VSS VDD VDD
+ clknet_leaf_254_clk sky130_fd_sc_hd__clkbuf_16
Xclkbuf_leaf_255_clk clknet_5_5__leaf_clk VSS VSS VDD VDD
+ clknet_leaf_255_clk sky130_fd_sc_hd__clkbuf_16
Xclkbuf_leaf_256_clk clknet_5_5__leaf_clk VSS VSS VDD VDD
+ clknet_leaf_256_clk sky130_fd_sc_hd__clkbuf_16
Xclkbuf_leaf_257_clk clknet_5_4__leaf_clk VSS VSS VDD VDD
+ clknet_leaf_257_clk sky130_fd_sc_hd__clkbuf_16
Xclkbuf_leaf_258_clk clknet_5_4__leaf_clk VSS VSS VDD VDD
+ clknet_leaf_258_clk sky130_fd_sc_hd__clkbuf_16
Xclkbuf_leaf_259_clk clknet_5_4__leaf_clk VSS VSS VDD VDD
+ clknet_leaf_259_clk sky130_fd_sc_hd__clkbuf_16
Xclkbuf_leaf_260_clk clknet_5_4__leaf_clk VSS VSS VDD VDD
+ clknet_leaf_260_clk sky130_fd_sc_hd__clkbuf_16
Xclkbuf_leaf_261_clk clknet_5_4__leaf_clk VSS VSS VDD VDD
+ clknet_leaf_261_clk sky130_fd_sc_hd__clkbuf_16
Xclkbuf_leaf_262_clk clknet_5_4__leaf_clk VSS VSS VDD VDD
+ clknet_leaf_262_clk sky130_fd_sc_hd__clkbuf_16
Xclkbuf_leaf_263_clk clknet_5_4__leaf_clk VSS VSS VDD VDD
+ clknet_leaf_263_clk sky130_fd_sc_hd__clkbuf_16
Xclkbuf_leaf_264_clk clknet_5_4__leaf_clk VSS VSS VDD VDD
+ clknet_leaf_264_clk sky130_fd_sc_hd__clkbuf_16
Xclkbuf_leaf_265_clk clknet_5_1__leaf_clk VSS VSS VDD VDD
+ clknet_leaf_265_clk sky130_fd_sc_hd__clkbuf_16
Xclkbuf_leaf_266_clk clknet_5_1__leaf_clk VSS VSS VDD VDD
+ clknet_leaf_266_clk sky130_fd_sc_hd__clkbuf_16
Xclkbuf_leaf_267_clk clknet_5_1__leaf_clk VSS VSS VDD VDD
+ clknet_leaf_267_clk sky130_fd_sc_hd__clkbuf_16
Xclkbuf_leaf_268_clk clknet_5_1__leaf_clk VSS VSS VDD VDD
+ clknet_leaf_268_clk sky130_fd_sc_hd__clkbuf_16
Xclkbuf_leaf_269_clk clknet_5_1__leaf_clk VSS VSS VDD VDD
+ clknet_leaf_269_clk sky130_fd_sc_hd__clkbuf_16
Xclkbuf_leaf_270_clk clknet_5_0__leaf_clk VSS VSS VDD VDD
+ clknet_leaf_270_clk sky130_fd_sc_hd__clkbuf_16
Xclkbuf_leaf_271_clk clknet_5_0__leaf_clk VSS VSS VDD VDD
+ clknet_leaf_271_clk sky130_fd_sc_hd__clkbuf_16
Xclkbuf_0_clk clk VSS VSS VDD VDD clknet_0_clk sky130_fd_sc_hd__clkbuf_16
Xclkbuf_2_0_0_clk clknet_0_clk VSS VSS VDD VDD clknet_2_0_0_clk
+ sky130_fd_sc_hd__clkbuf_16
Xclkbuf_2_1_0_clk clknet_0_clk VSS VSS VDD VDD clknet_2_1_0_clk
+ sky130_fd_sc_hd__clkbuf_16
Xclkbuf_2_2_0_clk clknet_0_clk VSS VSS VDD VDD clknet_2_2_0_clk
+ sky130_fd_sc_hd__clkbuf_16
Xclkbuf_2_3_0_clk clknet_0_clk VSS VSS VDD VDD clknet_2_3_0_clk
+ sky130_fd_sc_hd__clkbuf_16
Xclkbuf_5_0__f_clk clknet_2_0_0_clk VSS VSS VDD VDD clknet_5_0__leaf_clk
+ sky130_fd_sc_hd__clkbuf_16
Xclkbuf_5_1__f_clk clknet_2_0_0_clk VSS VSS VDD VDD clknet_5_1__leaf_clk
+ sky130_fd_sc_hd__clkbuf_16
Xclkbuf_5_2__f_clk clknet_2_0_0_clk VSS VSS VDD VDD clknet_5_2__leaf_clk
+ sky130_fd_sc_hd__clkbuf_16
Xclkbuf_5_3__f_clk clknet_2_0_0_clk VSS VSS VDD VDD clknet_5_3__leaf_clk
+ sky130_fd_sc_hd__clkbuf_16
Xclkbuf_5_4__f_clk clknet_2_0_0_clk VSS VSS VDD VDD clknet_5_4__leaf_clk
+ sky130_fd_sc_hd__clkbuf_16
Xclkbuf_5_5__f_clk clknet_2_0_0_clk VSS VSS VDD VDD clknet_5_5__leaf_clk
+ sky130_fd_sc_hd__clkbuf_16
Xclkbuf_5_6__f_clk clknet_2_0_0_clk VSS VSS VDD VDD clknet_5_6__leaf_clk
+ sky130_fd_sc_hd__clkbuf_16
Xclkbuf_5_7__f_clk clknet_2_0_0_clk VSS VSS VDD VDD clknet_5_7__leaf_clk
+ sky130_fd_sc_hd__clkbuf_16
Xclkbuf_5_8__f_clk clknet_2_1_0_clk VSS VSS VDD VDD clknet_5_8__leaf_clk
+ sky130_fd_sc_hd__clkbuf_16
Xclkbuf_5_9__f_clk clknet_2_1_0_clk VSS VSS VDD VDD clknet_5_9__leaf_clk
+ sky130_fd_sc_hd__clkbuf_16
Xclkbuf_5_10__f_clk clknet_2_1_0_clk VSS VSS VDD VDD clknet_5_10__leaf_clk
+ sky130_fd_sc_hd__clkbuf_16
Xclkbuf_5_11__f_clk clknet_2_1_0_clk VSS VSS VDD VDD clknet_5_11__leaf_clk
+ sky130_fd_sc_hd__clkbuf_16
Xclkbuf_5_12__f_clk clknet_2_1_0_clk VSS VSS VDD VDD clknet_5_12__leaf_clk
+ sky130_fd_sc_hd__clkbuf_16
Xclkbuf_5_13__f_clk clknet_2_1_0_clk VSS VSS VDD VDD clknet_5_13__leaf_clk
+ sky130_fd_sc_hd__clkbuf_16
Xclkbuf_5_14__f_clk clknet_2_1_0_clk VSS VSS VDD VDD clknet_5_14__leaf_clk
+ sky130_fd_sc_hd__clkbuf_16
Xclkbuf_5_15__f_clk clknet_2_1_0_clk VSS VSS VDD VDD clknet_5_15__leaf_clk
+ sky130_fd_sc_hd__clkbuf_16
Xclkbuf_5_16__f_clk clknet_2_2_0_clk VSS VSS VDD VDD clknet_5_16__leaf_clk
+ sky130_fd_sc_hd__clkbuf_16
Xclkbuf_5_17__f_clk clknet_2_2_0_clk VSS VSS VDD VDD clknet_5_17__leaf_clk
+ sky130_fd_sc_hd__clkbuf_16
Xclkbuf_5_18__f_clk clknet_2_2_0_clk VSS VSS VDD VDD clknet_5_18__leaf_clk
+ sky130_fd_sc_hd__clkbuf_16
Xclkbuf_5_19__f_clk clknet_2_2_0_clk VSS VSS VDD VDD clknet_5_19__leaf_clk
+ sky130_fd_sc_hd__clkbuf_16
Xclkbuf_5_20__f_clk clknet_2_2_0_clk VSS VSS VDD VDD clknet_5_20__leaf_clk
+ sky130_fd_sc_hd__clkbuf_16
Xclkbuf_5_21__f_clk clknet_2_2_0_clk VSS VSS VDD VDD clknet_5_21__leaf_clk
+ sky130_fd_sc_hd__clkbuf_16
Xclkbuf_5_22__f_clk clknet_2_2_0_clk VSS VSS VDD VDD clknet_5_22__leaf_clk
+ sky130_fd_sc_hd__clkbuf_16
Xclkbuf_5_23__f_clk clknet_2_2_0_clk VSS VSS VDD VDD clknet_5_23__leaf_clk
+ sky130_fd_sc_hd__clkbuf_16
Xclkbuf_5_24__f_clk clknet_2_3_0_clk VSS VSS VDD VDD clknet_5_24__leaf_clk
+ sky130_fd_sc_hd__clkbuf_16
Xclkbuf_5_25__f_clk clknet_2_3_0_clk VSS VSS VDD VDD clknet_5_25__leaf_clk
+ sky130_fd_sc_hd__clkbuf_16
Xclkbuf_5_26__f_clk clknet_2_3_0_clk VSS VSS VDD VDD clknet_5_26__leaf_clk
+ sky130_fd_sc_hd__clkbuf_16
Xclkbuf_5_27__f_clk clknet_2_3_0_clk VSS VSS VDD VDD clknet_5_27__leaf_clk
+ sky130_fd_sc_hd__clkbuf_16
Xclkbuf_5_28__f_clk clknet_2_3_0_clk VSS VSS VDD VDD clknet_5_28__leaf_clk
+ sky130_fd_sc_hd__clkbuf_16
Xclkbuf_5_29__f_clk clknet_2_3_0_clk VSS VSS VDD VDD clknet_5_29__leaf_clk
+ sky130_fd_sc_hd__clkbuf_16
Xclkbuf_5_30__f_clk clknet_2_3_0_clk VSS VSS VDD VDD clknet_5_30__leaf_clk
+ sky130_fd_sc_hd__clkbuf_16
Xclkbuf_5_31__f_clk clknet_2_3_0_clk VSS VSS VDD VDD clknet_5_31__leaf_clk
+ sky130_fd_sc_hd__clkbuf_16
Xclkload0 clknet_5_0__leaf_clk VSS VSS VDD VDD _unconnected_18
+ sky130_fd_sc_hd__clkinv_8
Xclkload1 clknet_5_1__leaf_clk VSS VSS VDD VDD _unconnected_19
+ sky130_fd_sc_hd__inv_16
Xclkload2 clknet_5_2__leaf_clk VSS VSS VDD VDD _unconnected_20
+ sky130_fd_sc_hd__clkinv_8
Xclkload3 clknet_5_3__leaf_clk VSS VSS VDD VDD _unconnected_21
+ sky130_fd_sc_hd__inv_6
Xclkload4 clknet_5_4__leaf_clk VSS VSS VDD VDD _unconnected_22
+ sky130_fd_sc_hd__clkbuf_16
Xclkload5 clknet_5_6__leaf_clk VSS VSS VDD VDD _unconnected_23
+ sky130_fd_sc_hd__clkinv_8
Xclkload6 clknet_5_7__leaf_clk VSS VSS VDD VDD _unconnected_24
+ sky130_fd_sc_hd__inv_6
Xclkload7 clknet_5_8__leaf_clk VSS VSS VDD VDD _unconnected_25
+ sky130_fd_sc_hd__inv_6
Xclkload8 clknet_5_9__leaf_clk VSS VSS VDD VDD _unconnected_26
+ sky130_fd_sc_hd__clkbuf_16
Xclkload9 clknet_5_10__leaf_clk VSS VSS VDD VDD _unconnected_27
+ sky130_fd_sc_hd__inv_6
Xclkload10 clknet_5_11__leaf_clk VSS VSS VDD VDD _unconnected_28
+ sky130_fd_sc_hd__inv_6
Xclkload11 clknet_5_13__leaf_clk VSS VSS VDD VDD _unconnected_29
+ sky130_fd_sc_hd__clkbuf_16
Xclkload12 clknet_5_14__leaf_clk VSS VSS VDD VDD _unconnected_30
+ sky130_fd_sc_hd__clkbuf_16
Xclkload13 clknet_5_15__leaf_clk VSS VSS VDD VDD _unconnected_31
+ sky130_fd_sc_hd__inv_6
Xclkload14 clknet_5_16__leaf_clk VSS VSS VDD VDD _unconnected_32
+ sky130_fd_sc_hd__clkbuf_16
Xclkload15 clknet_5_17__leaf_clk VSS VSS VDD VDD _unconnected_33
+ sky130_fd_sc_hd__clkbuf_16
Xclkload16 clknet_5_18__leaf_clk VSS VSS VDD VDD _unconnected_34
+ sky130_fd_sc_hd__inv_6
Xclkload17 clknet_5_19__leaf_clk VSS VSS VDD VDD _unconnected_35
+ sky130_fd_sc_hd__inv_6
Xclkload18 clknet_5_21__leaf_clk VSS VSS VDD VDD _unconnected_36
+ sky130_fd_sc_hd__clkbuf_16
Xclkload19 clknet_5_22__leaf_clk VSS VSS VDD VDD _unconnected_37
+ sky130_fd_sc_hd__clkbuf_16
Xclkload20 clknet_5_23__leaf_clk VSS VSS VDD VDD _unconnected_38
+ sky130_fd_sc_hd__clkinv_8
Xclkload21 clknet_5_25__leaf_clk VSS VSS VDD VDD _unconnected_39
+ sky130_fd_sc_hd__inv_6
Xclkload22 clknet_5_26__leaf_clk VSS VSS VDD VDD _unconnected_40
+ sky130_fd_sc_hd__clkbuf_16
Xclkload23 clknet_5_27__leaf_clk VSS VSS VDD VDD _unconnected_41
+ sky130_fd_sc_hd__clkbuf_16
Xclkload24 clknet_5_28__leaf_clk VSS VSS VDD VDD _unconnected_42
+ sky130_fd_sc_hd__inv_6
Xclkload25 clknet_5_29__leaf_clk VSS VSS VDD VDD _unconnected_43
+ sky130_fd_sc_hd__inv_6
Xclkload26 clknet_5_30__leaf_clk VSS VSS VDD VDD _unconnected_44
+ sky130_fd_sc_hd__clkinv_16
Xclkload27 clknet_5_31__leaf_clk VSS VSS VDD VDD _unconnected_45
+ sky130_fd_sc_hd__clkinv_8
Xclkload28 clknet_leaf_0_clk VSS VSS VDD VDD _unconnected_46
+ sky130_fd_sc_hd__clkbuf_1
Xclkload29 clknet_leaf_1_clk VSS VSS VDD VDD _unconnected_47
+ sky130_fd_sc_hd__clkbuf_1
Xclkload30 clknet_leaf_2_clk VSS VSS VDD VDD _unconnected_48
+ sky130_fd_sc_hd__clkbuf_1
Xclkload31 clknet_leaf_3_clk VSS VSS VDD VDD _unconnected_49
+ sky130_fd_sc_hd__clkbuf_1
Xclkload32 clknet_leaf_4_clk VSS VSS VDD VDD _unconnected_50
+ sky130_fd_sc_hd__clkbuf_1
Xclkload33 clknet_leaf_270_clk VSS VSS VDD VDD _unconnected_51
+ sky130_fd_sc_hd__clkbuf_1
Xclkload34 clknet_leaf_271_clk VSS VSS VDD VDD _unconnected_52
+ sky130_fd_sc_hd__clkinv_2
Xclkload35 clknet_leaf_6_clk VSS VSS VDD VDD _unconnected_53
+ sky130_fd_sc_hd__clkinv_2
Xclkload36 clknet_leaf_7_clk VSS VSS VDD VDD _unconnected_54
+ sky130_fd_sc_hd__clkbuf_1
Xclkload37 clknet_leaf_266_clk VSS VSS VDD VDD _unconnected_55
+ sky130_fd_sc_hd__clkbuf_1
Xclkload38 clknet_leaf_267_clk VSS VSS VDD VDD _unconnected_56
+ sky130_fd_sc_hd__clkbuf_8
Xclkload39 clknet_leaf_268_clk VSS VSS VDD VDD _unconnected_57
+ sky130_fd_sc_hd__clkbuf_1
Xclkload40 clknet_leaf_269_clk VSS VSS VDD VDD _unconnected_58
+ sky130_fd_sc_hd__bufinv_16
Xclkload41 clknet_leaf_12_clk VSS VSS VDD VDD _unconnected_59
+ sky130_fd_sc_hd__bufinv_16
Xclkload42 clknet_leaf_13_clk VSS VSS VDD VDD _unconnected_60
+ sky130_fd_sc_hd__clkinv_1
Xclkload43 clknet_leaf_14_clk VSS VSS VDD VDD _unconnected_61
+ sky130_fd_sc_hd__clkbuf_1
Xclkload44 clknet_leaf_16_clk VSS VSS VDD VDD _unconnected_62
+ sky130_fd_sc_hd__clkbuf_1
Xclkload45 clknet_leaf_20_clk VSS VSS VDD VDD _unconnected_63
+ sky130_fd_sc_hd__clkinv_2
Xclkload46 clknet_leaf_8_clk VSS VSS VDD VDD _unconnected_64
+ sky130_fd_sc_hd__clkinv_2
Xclkload47 clknet_leaf_10_clk VSS VSS VDD VDD _unconnected_65
+ sky130_fd_sc_hd__clkbuf_8
Xclkload48 clknet_leaf_21_clk VSS VSS VDD VDD _unconnected_66
+ sky130_fd_sc_hd__clkbuf_1
Xclkload49 clknet_leaf_24_clk VSS VSS VDD VDD _unconnected_67
+ sky130_fd_sc_hd__clkinvlp_4
Xclkload50 clknet_leaf_25_clk VSS VSS VDD VDD _unconnected_68
+ sky130_fd_sc_hd__clkinv_1
Xclkload51 clknet_leaf_26_clk VSS VSS VDD VDD _unconnected_69
+ sky130_fd_sc_hd__clkinv_2
Xclkload52 clknet_leaf_27_clk VSS VSS VDD VDD _unconnected_70
+ sky130_fd_sc_hd__clkbuf_1
Xclkload53 clknet_leaf_28_clk VSS VSS VDD VDD _unconnected_71
+ sky130_fd_sc_hd__clkbuf_1
Xclkload54 clknet_leaf_245_clk VSS VSS VDD VDD _unconnected_72
+ sky130_fd_sc_hd__clkinv_1
Xclkload55 clknet_leaf_257_clk VSS VSS VDD VDD _unconnected_73
+ sky130_fd_sc_hd__clkbuf_1
Xclkload56 clknet_leaf_258_clk VSS VSS VDD VDD _unconnected_74
+ sky130_fd_sc_hd__clkinv_1
Xclkload57 clknet_leaf_259_clk VSS VSS VDD VDD _unconnected_75
+ sky130_fd_sc_hd__clkinv_2
Xclkload58 clknet_leaf_260_clk VSS VSS VDD VDD _unconnected_76
+ sky130_fd_sc_hd__clkinv_2
Xclkload59 clknet_leaf_262_clk VSS VSS VDD VDD _unconnected_77
+ sky130_fd_sc_hd__clkinv_1
Xclkload60 clknet_leaf_263_clk VSS VSS VDD VDD _unconnected_78
+ sky130_fd_sc_hd__clkinv_1
Xclkload61 clknet_leaf_246_clk VSS VSS VDD VDD _unconnected_79
+ sky130_fd_sc_hd__clkbuf_1
Xclkload62 clknet_leaf_247_clk VSS VSS VDD VDD _unconnected_80
+ sky130_fd_sc_hd__clkinv_2
Xclkload63 clknet_leaf_248_clk VSS VSS VDD VDD _unconnected_81
+ sky130_fd_sc_hd__clkinv_1
Xclkload64 clknet_leaf_249_clk VSS VSS VDD VDD _unconnected_82
+ sky130_fd_sc_hd__clkinv_2
Xclkload65 clknet_leaf_250_clk VSS VSS VDD VDD _unconnected_83
+ sky130_fd_sc_hd__clkinv_2
Xclkload66 clknet_leaf_252_clk VSS VSS VDD VDD _unconnected_84
+ sky130_fd_sc_hd__clkinv_2
Xclkload67 clknet_leaf_253_clk VSS VSS VDD VDD _unconnected_85
+ sky130_fd_sc_hd__clkbuf_1
Xclkload68 clknet_leaf_254_clk VSS VSS VDD VDD _unconnected_86
+ sky130_fd_sc_hd__clkinv_1
Xclkload69 clknet_leaf_255_clk VSS VSS VDD VDD _unconnected_87
+ sky130_fd_sc_hd__bufinv_16
Xclkload70 clknet_leaf_256_clk VSS VSS VDD VDD _unconnected_88
+ sky130_fd_sc_hd__clkinv_2
Xclkload71 clknet_leaf_29_clk VSS VSS VDD VDD _unconnected_89
+ sky130_fd_sc_hd__clkinv_1
Xclkload72 clknet_leaf_30_clk VSS VSS VDD VDD _unconnected_90
+ sky130_fd_sc_hd__bufinv_16
Xclkload73 clknet_leaf_31_clk VSS VSS VDD VDD _unconnected_91
+ sky130_fd_sc_hd__clkinv_1
Xclkload74 clknet_leaf_32_clk VSS VSS VDD VDD _unconnected_92
+ sky130_fd_sc_hd__clkinv_1
Xclkload75 clknet_leaf_34_clk VSS VSS VDD VDD _unconnected_93
+ sky130_fd_sc_hd__bufinv_16
Xclkload76 clknet_leaf_241_clk VSS VSS VDD VDD _unconnected_94
+ sky130_fd_sc_hd__clkinv_1
Xclkload77 clknet_leaf_243_clk VSS VSS VDD VDD _unconnected_95
+ sky130_fd_sc_hd__clkinv_1
Xclkload78 clknet_leaf_35_clk VSS VSS VDD VDD _unconnected_96
+ sky130_fd_sc_hd__clkinv_2
Xclkload79 clknet_leaf_36_clk VSS VSS VDD VDD _unconnected_97
+ sky130_fd_sc_hd__bufinv_16
Xclkload80 clknet_leaf_234_clk VSS VSS VDD VDD _unconnected_98
+ sky130_fd_sc_hd__clkinv_2
Xclkload81 clknet_leaf_235_clk VSS VSS VDD VDD _unconnected_99
+ sky130_fd_sc_hd__clkinv_1
Xclkload82 clknet_leaf_237_clk VSS VSS VDD VDD _unconnected_100
+ sky130_fd_sc_hd__clkinv_1
Xclkload83 clknet_leaf_238_clk VSS VSS VDD VDD _unconnected_101
+ sky130_fd_sc_hd__clkinvlp_4
Xclkload84 clknet_leaf_240_clk VSS VSS VDD VDD _unconnected_102
+ sky130_fd_sc_hd__bufinv_16
Xclkload85 clknet_leaf_56_clk VSS VSS VDD VDD _unconnected_103
+ sky130_fd_sc_hd__clkbuf_1
Xclkload86 clknet_leaf_57_clk VSS VSS VDD VDD _unconnected_104
+ sky130_fd_sc_hd__clkbuf_1
Xclkload87 clknet_leaf_58_clk VSS VSS VDD VDD _unconnected_105
+ sky130_fd_sc_hd__clkinv_1
Xclkload88 clknet_leaf_59_clk VSS VSS VDD VDD _unconnected_106
+ sky130_fd_sc_hd__clkinv_1
Xclkload89 clknet_leaf_60_clk VSS VSS VDD VDD _unconnected_107
+ sky130_fd_sc_hd__clkinv_1
Xclkload90 clknet_leaf_61_clk VSS VSS VDD VDD _unconnected_108
+ sky130_fd_sc_hd__clkinv_1
Xclkload91 clknet_leaf_22_clk VSS VSS VDD VDD _unconnected_109
+ sky130_fd_sc_hd__bufinv_16
Xclkload92 clknet_leaf_23_clk VSS VSS VDD VDD _unconnected_110
+ sky130_fd_sc_hd__clkbuf_8
Xclkload93 clknet_leaf_43_clk VSS VSS VDD VDD _unconnected_111
+ sky130_fd_sc_hd__clkinv_2
Xclkload94 clknet_leaf_50_clk VSS VSS VDD VDD _unconnected_112
+ sky130_fd_sc_hd__clkbuf_8
Xclkload95 clknet_leaf_51_clk VSS VSS VDD VDD _unconnected_113
+ sky130_fd_sc_hd__clkinv_2
Xclkload96 clknet_leaf_52_clk VSS VSS VDD VDD _unconnected_114
+ sky130_fd_sc_hd__clkinv_2
Xclkload97 clknet_leaf_53_clk VSS VSS VDD VDD _unconnected_115
+ sky130_fd_sc_hd__clkbuf_1
Xclkload98 clknet_leaf_55_clk VSS VSS VDD VDD _unconnected_116
+ sky130_fd_sc_hd__clkinvlp_4
Xclkload99 clknet_leaf_62_clk VSS VSS VDD VDD _unconnected_117
+ sky130_fd_sc_hd__clkbuf_1
Xclkload100 clknet_leaf_64_clk VSS VSS VDD VDD _unconnected_118
+ sky130_fd_sc_hd__clkbuf_1
Xclkload101 clknet_leaf_65_clk VSS VSS VDD VDD _unconnected_119
+ sky130_fd_sc_hd__clkbuf_1
Xclkload102 clknet_leaf_66_clk VSS VSS VDD VDD _unconnected_120
+ sky130_fd_sc_hd__clkinv_1
Xclkload103 clknet_leaf_67_clk VSS VSS VDD VDD _unconnected_121
+ sky130_fd_sc_hd__clkinv_1
Xclkload104 clknet_leaf_73_clk VSS VSS VDD VDD _unconnected_122
+ sky130_fd_sc_hd__clkbuf_1
Xclkload105 clknet_leaf_74_clk VSS VSS VDD VDD _unconnected_123
+ sky130_fd_sc_hd__clkbuf_1
Xclkload106 clknet_leaf_49_clk VSS VSS VDD VDD _unconnected_124
+ sky130_fd_sc_hd__clkinv_2
Xclkload107 clknet_leaf_68_clk VSS VSS VDD VDD _unconnected_125
+ sky130_fd_sc_hd__bufinv_16
Xclkload108 clknet_leaf_69_clk VSS VSS VDD VDD _unconnected_126
+ sky130_fd_sc_hd__clkinv_2
Xclkload109 clknet_leaf_71_clk VSS VSS VDD VDD _unconnected_127
+ sky130_fd_sc_hd__clkbuf_8
Xclkload110 clknet_leaf_72_clk VSS VSS VDD VDD _unconnected_128
+ sky130_fd_sc_hd__clkbuf_8
Xclkload111 clknet_leaf_75_clk VSS VSS VDD VDD _unconnected_129
+ sky130_fd_sc_hd__clkinvlp_4
Xclkload112 clknet_leaf_76_clk VSS VSS VDD VDD _unconnected_130
+ sky130_fd_sc_hd__clkbuf_1
Xclkload113 clknet_leaf_33_clk VSS VSS VDD VDD _unconnected_131
+ sky130_fd_sc_hd__clkbuf_8
Xclkload114 clknet_leaf_40_clk VSS VSS VDD VDD _unconnected_132
+ sky130_fd_sc_hd__clkbuf_1
Xclkload115 clknet_leaf_42_clk VSS VSS VDD VDD _unconnected_133
+ sky130_fd_sc_hd__clkbuf_1
Xclkload116 clknet_leaf_44_clk VSS VSS VDD VDD _unconnected_134
+ sky130_fd_sc_hd__clkbuf_1
Xclkload117 clknet_leaf_45_clk VSS VSS VDD VDD _unconnected_135
+ sky130_fd_sc_hd__clkbuf_8
Xclkload118 clknet_leaf_46_clk VSS VSS VDD VDD _unconnected_136
+ sky130_fd_sc_hd__clkbuf_8
Xclkload119 clknet_leaf_47_clk VSS VSS VDD VDD _unconnected_137
+ sky130_fd_sc_hd__clkbuf_1
Xclkload120 clknet_leaf_91_clk VSS VSS VDD VDD _unconnected_138
+ sky130_fd_sc_hd__clkbuf_8
Xclkload121 clknet_leaf_92_clk VSS VSS VDD VDD _unconnected_139
+ sky130_fd_sc_hd__clkbuf_1
Xclkload122 clknet_leaf_37_clk VSS VSS VDD VDD _unconnected_140
+ sky130_fd_sc_hd__clkbuf_1
Xclkload123 clknet_leaf_38_clk VSS VSS VDD VDD _unconnected_141
+ sky130_fd_sc_hd__clkbuf_1
Xclkload124 clknet_leaf_95_clk VSS VSS VDD VDD _unconnected_142
+ sky130_fd_sc_hd__clkbuf_1
Xclkload125 clknet_leaf_96_clk VSS VSS VDD VDD _unconnected_143
+ sky130_fd_sc_hd__clkbuf_1
Xclkload126 clknet_leaf_97_clk VSS VSS VDD VDD _unconnected_144
+ sky130_fd_sc_hd__clkbuf_1
Xclkload127 clknet_leaf_98_clk VSS VSS VDD VDD _unconnected_145
+ sky130_fd_sc_hd__clkbuf_8
Xclkload128 clknet_leaf_99_clk VSS VSS VDD VDD _unconnected_146
+ sky130_fd_sc_hd__clkbuf_1
Xclkload129 clknet_leaf_233_clk VSS VSS VDD VDD _unconnected_147
+ sky130_fd_sc_hd__clkbuf_1
Xclkload130 clknet_leaf_48_clk VSS VSS VDD VDD _unconnected_148
+ sky130_fd_sc_hd__bufinv_16
Xclkload131 clknet_leaf_77_clk VSS VSS VDD VDD _unconnected_149
+ sky130_fd_sc_hd__bufinv_16
Xclkload132 clknet_leaf_79_clk VSS VSS VDD VDD _unconnected_150
+ sky130_fd_sc_hd__bufinv_16
Xclkload133 clknet_leaf_86_clk VSS VSS VDD VDD _unconnected_151
+ sky130_fd_sc_hd__clkinv_1
Xclkload134 clknet_leaf_87_clk VSS VSS VDD VDD _unconnected_152
+ sky130_fd_sc_hd__clkbuf_1
Xclkload135 clknet_leaf_88_clk VSS VSS VDD VDD _unconnected_153
+ sky130_fd_sc_hd__clkbuf_1
Xclkload136 clknet_leaf_89_clk VSS VSS VDD VDD _unconnected_154
+ sky130_fd_sc_hd__clkinv_1
Xclkload137 clknet_leaf_90_clk VSS VSS VDD VDD _unconnected_155
+ sky130_fd_sc_hd__clkinv_1
Xclkload138 clknet_leaf_80_clk VSS VSS VDD VDD _unconnected_156
+ sky130_fd_sc_hd__clkbuf_8
Xclkload139 clknet_leaf_82_clk VSS VSS VDD VDD _unconnected_157
+ sky130_fd_sc_hd__clkbuf_8
Xclkload140 clknet_leaf_83_clk VSS VSS VDD VDD _unconnected_158
+ sky130_fd_sc_hd__clkbuf_1
Xclkload141 clknet_leaf_84_clk VSS VSS VDD VDD _unconnected_159
+ sky130_fd_sc_hd__clkbuf_1
Xclkload142 clknet_leaf_85_clk VSS VSS VDD VDD _unconnected_160
+ sky130_fd_sc_hd__clkbuf_8
Xclkload143 clknet_leaf_93_clk VSS VSS VDD VDD _unconnected_161
+ sky130_fd_sc_hd__clkbuf_1
Xclkload144 clknet_leaf_94_clk VSS VSS VDD VDD _unconnected_162
+ sky130_fd_sc_hd__clkinv_1
Xclkload145 clknet_leaf_212_clk VSS VSS VDD VDD _unconnected_163
+ sky130_fd_sc_hd__clkbuf_1
Xclkload146 clknet_leaf_213_clk VSS VSS VDD VDD _unconnected_164
+ sky130_fd_sc_hd__clkbuf_1
Xclkload147 clknet_leaf_215_clk VSS VSS VDD VDD _unconnected_165
+ sky130_fd_sc_hd__clkbuf_1
Xclkload148 clknet_leaf_216_clk VSS VSS VDD VDD _unconnected_166
+ sky130_fd_sc_hd__clkbuf_1
Xclkload149 clknet_leaf_217_clk VSS VSS VDD VDD _unconnected_167
+ sky130_fd_sc_hd__clkbuf_8
Xclkload150 clknet_leaf_218_clk VSS VSS VDD VDD _unconnected_168
+ sky130_fd_sc_hd__clkbuf_1
Xclkload151 clknet_leaf_221_clk VSS VSS VDD VDD _unconnected_169
+ sky130_fd_sc_hd__clkbuf_8
Xclkload152 clknet_leaf_204_clk VSS VSS VDD VDD _unconnected_170
+ sky130_fd_sc_hd__clkinv_2
Xclkload153 clknet_leaf_205_clk VSS VSS VDD VDD _unconnected_171
+ sky130_fd_sc_hd__clkbuf_1
Xclkload154 clknet_leaf_206_clk VSS VSS VDD VDD _unconnected_172
+ sky130_fd_sc_hd__bufinv_16
Xclkload155 clknet_leaf_207_clk VSS VSS VDD VDD _unconnected_173
+ sky130_fd_sc_hd__clkbuf_1
Xclkload156 clknet_leaf_208_clk VSS VSS VDD VDD _unconnected_174
+ sky130_fd_sc_hd__clkbuf_8
Xclkload157 clknet_leaf_209_clk VSS VSS VDD VDD _unconnected_175
+ sky130_fd_sc_hd__clkbuf_8
Xclkload158 clknet_leaf_210_clk VSS VSS VDD VDD _unconnected_176
+ sky130_fd_sc_hd__clkinv_2
Xclkload159 clknet_leaf_222_clk VSS VSS VDD VDD _unconnected_177
+ sky130_fd_sc_hd__clkbuf_1
Xclkload160 clknet_leaf_219_clk VSS VSS VDD VDD _unconnected_178
+ sky130_fd_sc_hd__clkinv_2
Xclkload161 clknet_leaf_226_clk VSS VSS VDD VDD _unconnected_179
+ sky130_fd_sc_hd__clkbuf_1
Xclkload162 clknet_leaf_227_clk VSS VSS VDD VDD _unconnected_180
+ sky130_fd_sc_hd__clkinv_2
Xclkload163 clknet_leaf_229_clk VSS VSS VDD VDD _unconnected_181
+ sky130_fd_sc_hd__clkbuf_1
Xclkload164 clknet_leaf_230_clk VSS VSS VDD VDD _unconnected_182
+ sky130_fd_sc_hd__clkinv_1
Xclkload165 clknet_leaf_231_clk VSS VSS VDD VDD _unconnected_183
+ sky130_fd_sc_hd__clkbuf_1
Xclkload166 clknet_leaf_232_clk VSS VSS VDD VDD _unconnected_184
+ sky130_fd_sc_hd__clkinv_1
Xclkload167 clknet_leaf_161_clk VSS VSS VDD VDD _unconnected_185
+ sky130_fd_sc_hd__clkbuf_1
Xclkload168 clknet_leaf_162_clk VSS VSS VDD VDD _unconnected_186
+ sky130_fd_sc_hd__clkbuf_1
Xclkload169 clknet_leaf_163_clk VSS VSS VDD VDD _unconnected_187
+ sky130_fd_sc_hd__clkbuf_1
Xclkload170 clknet_leaf_164_clk VSS VSS VDD VDD _unconnected_188
+ sky130_fd_sc_hd__clkinv_2
Xclkload171 clknet_leaf_223_clk VSS VSS VDD VDD _unconnected_189
+ sky130_fd_sc_hd__clkbuf_1
Xclkload172 clknet_leaf_224_clk VSS VSS VDD VDD _unconnected_190
+ sky130_fd_sc_hd__clkbuf_1
Xclkload173 clknet_leaf_225_clk VSS VSS VDD VDD _unconnected_191
+ sky130_fd_sc_hd__clkbuf_1
Xclkload174 clknet_leaf_185_clk VSS VSS VDD VDD _unconnected_192
+ sky130_fd_sc_hd__clkbuf_1
Xclkload175 clknet_leaf_195_clk VSS VSS VDD VDD _unconnected_193
+ sky130_fd_sc_hd__clkbuf_1
Xclkload176 clknet_leaf_196_clk VSS VSS VDD VDD _unconnected_194
+ sky130_fd_sc_hd__clkbuf_1
Xclkload177 clknet_leaf_197_clk VSS VSS VDD VDD _unconnected_195
+ sky130_fd_sc_hd__clkbuf_1
Xclkload178 clknet_leaf_198_clk VSS VSS VDD VDD _unconnected_196
+ sky130_fd_sc_hd__clkbuf_1
Xclkload179 clknet_leaf_200_clk VSS VSS VDD VDD _unconnected_197
+ sky130_fd_sc_hd__clkbuf_8
Xclkload180 clknet_leaf_201_clk VSS VSS VDD VDD _unconnected_198
+ sky130_fd_sc_hd__clkbuf_1
Xclkload181 clknet_leaf_202_clk VSS VSS VDD VDD _unconnected_199
+ sky130_fd_sc_hd__clkbuf_1
Xclkload182 clknet_leaf_203_clk VSS VSS VDD VDD _unconnected_200
+ sky130_fd_sc_hd__clkbuf_1
Xclkload183 clknet_leaf_186_clk VSS VSS VDD VDD _unconnected_201
+ sky130_fd_sc_hd__clkbuf_8
Xclkload184 clknet_leaf_187_clk VSS VSS VDD VDD _unconnected_202
+ sky130_fd_sc_hd__clkbuf_8
Xclkload185 clknet_leaf_188_clk VSS VSS VDD VDD _unconnected_203
+ sky130_fd_sc_hd__clkinv_2
Xclkload186 clknet_leaf_190_clk VSS VSS VDD VDD _unconnected_204
+ sky130_fd_sc_hd__clkbuf_1
Xclkload187 clknet_leaf_191_clk VSS VSS VDD VDD _unconnected_205
+ sky130_fd_sc_hd__clkinv_2
Xclkload188 clknet_leaf_192_clk VSS VSS VDD VDD _unconnected_206
+ sky130_fd_sc_hd__clkinv_2
Xclkload189 clknet_leaf_193_clk VSS VSS VDD VDD _unconnected_207
+ sky130_fd_sc_hd__clkbuf_1
Xclkload190 clknet_leaf_194_clk VSS VSS VDD VDD _unconnected_208
+ sky130_fd_sc_hd__clkbuf_8
Xclkload191 clknet_leaf_165_clk VSS VSS VDD VDD _unconnected_209
+ sky130_fd_sc_hd__clkinv_2
Xclkload192 clknet_leaf_166_clk VSS VSS VDD VDD _unconnected_210
+ sky130_fd_sc_hd__clkinv_2
Xclkload193 clknet_leaf_168_clk VSS VSS VDD VDD _unconnected_211
+ sky130_fd_sc_hd__clkinv_2
Xclkload194 clknet_leaf_169_clk VSS VSS VDD VDD _unconnected_212
+ sky130_fd_sc_hd__clkinv_2
Xclkload195 clknet_leaf_172_clk VSS VSS VDD VDD _unconnected_213
+ sky130_fd_sc_hd__clkinv_2
Xclkload196 clknet_leaf_182_clk VSS VSS VDD VDD _unconnected_214
+ sky130_fd_sc_hd__clkbuf_1
Xclkload197 clknet_leaf_183_clk VSS VSS VDD VDD _unconnected_215
+ sky130_fd_sc_hd__clkbuf_1
Xclkload198 clknet_leaf_184_clk VSS VSS VDD VDD _unconnected_216
+ sky130_fd_sc_hd__clkbuf_8
Xclkload199 clknet_leaf_173_clk VSS VSS VDD VDD _unconnected_217
+ sky130_fd_sc_hd__clkbuf_16
Xclkload200 clknet_leaf_177_clk VSS VSS VDD VDD _unconnected_218
+ sky130_fd_sc_hd__clkbuf_16
Xclkload201 clknet_leaf_178_clk VSS VSS VDD VDD _unconnected_219
+ sky130_fd_sc_hd__clkinv_2
Xclkload202 clknet_leaf_179_clk VSS VSS VDD VDD _unconnected_220
+ sky130_fd_sc_hd__clkbuf_8
Xclkload203 clknet_leaf_180_clk VSS VSS VDD VDD _unconnected_221
+ sky130_fd_sc_hd__clkbuf_8
Xclkload204 clknet_leaf_181_clk VSS VSS VDD VDD _unconnected_222
+ sky130_fd_sc_hd__clkinv_2
Xclkload205 clknet_leaf_100_clk VSS VSS VDD VDD _unconnected_223
+ sky130_fd_sc_hd__bufinv_16
Xclkload206 clknet_leaf_101_clk VSS VSS VDD VDD _unconnected_224
+ sky130_fd_sc_hd__clkinv_2
Xclkload207 clknet_leaf_102_clk VSS VSS VDD VDD _unconnected_225
+ sky130_fd_sc_hd__clkbuf_1
Xclkload208 clknet_leaf_103_clk VSS VSS VDD VDD _unconnected_226
+ sky130_fd_sc_hd__clkbuf_1
Xclkload209 clknet_leaf_104_clk VSS VSS VDD VDD _unconnected_227
+ sky130_fd_sc_hd__clkbuf_1
Xclkload210 clknet_leaf_153_clk VSS VSS VDD VDD _unconnected_228
+ sky130_fd_sc_hd__clkinv_1
Xclkload211 clknet_leaf_154_clk VSS VSS VDD VDD _unconnected_229
+ sky130_fd_sc_hd__clkbuf_1
Xclkload212 clknet_leaf_155_clk VSS VSS VDD VDD _unconnected_230
+ sky130_fd_sc_hd__clkbuf_8
Xclkload213 clknet_leaf_157_clk VSS VSS VDD VDD _unconnected_231
+ sky130_fd_sc_hd__clkinv_2
Xclkload214 clknet_leaf_107_clk VSS VSS VDD VDD _unconnected_232
+ sky130_fd_sc_hd__clkinv_1
Xclkload215 clknet_leaf_146_clk VSS VSS VDD VDD _unconnected_233
+ sky130_fd_sc_hd__clkbuf_8
Xclkload216 clknet_leaf_147_clk VSS VSS VDD VDD _unconnected_234
+ sky130_fd_sc_hd__clkbuf_1
Xclkload217 clknet_leaf_148_clk VSS VSS VDD VDD _unconnected_235
+ sky130_fd_sc_hd__clkbuf_1
Xclkload218 clknet_leaf_151_clk VSS VSS VDD VDD _unconnected_236
+ sky130_fd_sc_hd__clkbuf_1
Xclkload219 clknet_leaf_152_clk VSS VSS VDD VDD _unconnected_237
+ sky130_fd_sc_hd__clkinv_2
Xclkload220 clknet_leaf_159_clk VSS VSS VDD VDD _unconnected_238
+ sky130_fd_sc_hd__clkbuf_1
Xclkload221 clknet_leaf_105_clk VSS VSS VDD VDD _unconnected_239
+ sky130_fd_sc_hd__clkinv_1
Xclkload222 clknet_leaf_113_clk VSS VSS VDD VDD _unconnected_240
+ sky130_fd_sc_hd__clkbuf_1
Xclkload223 clknet_leaf_114_clk VSS VSS VDD VDD _unconnected_241
+ sky130_fd_sc_hd__clkbuf_8
Xclkload224 clknet_leaf_115_clk VSS VSS VDD VDD _unconnected_242
+ sky130_fd_sc_hd__clkbuf_8
Xclkload225 clknet_leaf_116_clk VSS VSS VDD VDD _unconnected_243
+ sky130_fd_sc_hd__clkbuf_1
Xclkload226 clknet_leaf_117_clk VSS VSS VDD VDD _unconnected_244
+ sky130_fd_sc_hd__clkbuf_8
Xclkload227 clknet_leaf_118_clk VSS VSS VDD VDD _unconnected_245
+ sky130_fd_sc_hd__clkbuf_1
Xclkload228 clknet_leaf_119_clk VSS VSS VDD VDD _unconnected_246
+ sky130_fd_sc_hd__bufinv_16
Xclkload229 clknet_leaf_108_clk VSS VSS VDD VDD _unconnected_247
+ sky130_fd_sc_hd__clkbuf_1
Xclkload230 clknet_leaf_109_clk VSS VSS VDD VDD _unconnected_248
+ sky130_fd_sc_hd__clkinv_1
Xclkload231 clknet_leaf_110_clk VSS VSS VDD VDD _unconnected_249
+ sky130_fd_sc_hd__clkbuf_8
Xclkload232 clknet_leaf_111_clk VSS VSS VDD VDD _unconnected_250
+ sky130_fd_sc_hd__clkbuf_1
Xclkload233 clknet_leaf_112_clk VSS VSS VDD VDD _unconnected_251
+ sky130_fd_sc_hd__clkbuf_8
Xclkload234 clknet_leaf_120_clk VSS VSS VDD VDD _unconnected_252
+ sky130_fd_sc_hd__clkinv_2
Xclkload235 clknet_leaf_121_clk VSS VSS VDD VDD _unconnected_253
+ sky130_fd_sc_hd__clkinv_2
Xclkload236 clknet_leaf_123_clk VSS VSS VDD VDD _unconnected_254
+ sky130_fd_sc_hd__inv_6
Xclkload237 clknet_leaf_139_clk VSS VSS VDD VDD _unconnected_255
+ sky130_fd_sc_hd__clkinv_2
Xclkload238 clknet_leaf_140_clk VSS VSS VDD VDD _unconnected_256
+ sky130_fd_sc_hd__clkinvlp_4
Xclkload239 clknet_leaf_141_clk VSS VSS VDD VDD _unconnected_257
+ sky130_fd_sc_hd__clkinv_1
Xclkload240 clknet_leaf_142_clk VSS VSS VDD VDD _unconnected_258
+ sky130_fd_sc_hd__clkinv_4
Xclkload241 clknet_leaf_150_clk VSS VSS VDD VDD _unconnected_259
+ sky130_fd_sc_hd__clkbuf_1
Xclkload242 clknet_leaf_160_clk VSS VSS VDD VDD _unconnected_260
+ sky130_fd_sc_hd__clkinv_1
Xclkload243 clknet_leaf_170_clk VSS VSS VDD VDD _unconnected_261
+ sky130_fd_sc_hd__clkbuf_1
Xclkload244 clknet_leaf_133_clk VSS VSS VDD VDD _unconnected_262
+ sky130_fd_sc_hd__clkinvlp_4
Xclkload245 clknet_leaf_134_clk VSS VSS VDD VDD _unconnected_263
+ sky130_fd_sc_hd__clkinv_2
Xclkload246 clknet_leaf_135_clk VSS VSS VDD VDD _unconnected_264
+ sky130_fd_sc_hd__bufinv_16
Xclkload247 clknet_leaf_136_clk VSS VSS VDD VDD _unconnected_265
+ sky130_fd_sc_hd__clkinv_1
Xclkload248 clknet_leaf_138_clk VSS VSS VDD VDD _unconnected_266
+ sky130_fd_sc_hd__clkinv_1
Xclkload249 clknet_leaf_174_clk VSS VSS VDD VDD _unconnected_267
+ sky130_fd_sc_hd__clkinv_1
Xclkload250 clknet_leaf_175_clk VSS VSS VDD VDD _unconnected_268
+ sky130_fd_sc_hd__bufinv_16
Xclkload251 clknet_leaf_128_clk VSS VSS VDD VDD _unconnected_269
+ sky130_fd_sc_hd__clkbuf_1
Xclkload252 clknet_leaf_137_clk VSS VSS VDD VDD _unconnected_270
+ sky130_fd_sc_hd__clkinv_2
Xclkload253 clknet_leaf_143_clk VSS VSS VDD VDD _unconnected_271
+ sky130_fd_sc_hd__clkinv_2
Xclkload254 clknet_leaf_144_clk VSS VSS VDD VDD _unconnected_272
+ sky130_fd_sc_hd__clkinv_2
Xclkload255 clknet_leaf_125_clk VSS VSS VDD VDD _unconnected_273
+ sky130_fd_sc_hd__clkbuf_8
Xclkload256 clknet_leaf_126_clk VSS VSS VDD VDD _unconnected_274
+ sky130_fd_sc_hd__clkinv_4
Xclkload257 clknet_leaf_131_clk VSS VSS VDD VDD _unconnected_275
+ sky130_fd_sc_hd__clkbuf_1
Xclkload258 clknet_leaf_132_clk VSS VSS VDD VDD _unconnected_276
+ sky130_fd_sc_hd__clkbuf_1
Xhold460 reset VSS VSS VDD VDD net459 sky130_fd_sc_hd__dlygate4sd3_1
Xhold461 start VSS VSS VDD VDD net460 sky130_fd_sc_hd__dlygate4sd3_1
Xhold462 load_data[2] VSS VSS VDD VDD net461 sky130_fd_sc_hd__dlygate4sd3_1
Xhold463 load_data[3] VSS VSS VDD VDD net462 sky130_fd_sc_hd__dlygate4sd3_1
Xhold464 load_data[1] VSS VSS VDD VDD net463 sky130_fd_sc_hd__dlygate4sd3_1
Xhold465 load_data[0] VSS VSS VDD VDD net464 sky130_fd_sc_hd__dlygate4sd3_1
XANTENNA_1 clk VSS VSS VDD VDD sky130_fd_sc_hd__diode_2
XANTENNA_2 _04004_ VSS VSS VDD VDD sky130_fd_sc_hd__diode_2
XANTENNA_3 _04030_ VSS VSS VDD VDD sky130_fd_sc_hd__diode_2
XANTENNA_4 _04037_ VSS VSS VDD VDD sky130_fd_sc_hd__diode_2
XANTENNA_5 _04226_ VSS VSS VDD VDD sky130_fd_sc_hd__diode_2
XANTENNA_6 _07323_ VSS VSS VDD VDD sky130_fd_sc_hd__diode_2
XANTENNA_7 net293 VSS VSS VDD VDD sky130_fd_sc_hd__diode_2
XANTENNA_8 net293 VSS VSS VDD VDD sky130_fd_sc_hd__diode_2
XANTENNA_9 _09023_ VSS VSS VDD VDD sky130_fd_sc_hd__diode_2
XANTENNA_10 net43 VSS VSS VDD VDD sky130_fd_sc_hd__diode_2
.ENDS ecg_snn_core
