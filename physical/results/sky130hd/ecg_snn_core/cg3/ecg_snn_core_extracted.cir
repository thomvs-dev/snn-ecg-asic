* Extracted by KLayout on : 12/11/2026 12:18

.SUBCKT ecg_snn_core VDD VNB|VSS busy clk done inference_cycles[0]
+ inference_cycles[10] inference_cycles[11] inference_cycles[12]
+ inference_cycles[13] inference_cycles[14] inference_cycles[15]
+ inference_cycles[1] inference_cycles[2] inference_cycles[3]
+ inference_cycles[4] inference_cycles[5] inference_cycles[6]
+ inference_cycles[7] inference_cycles[8] inference_cycles[9] input_complete
+ load_data[0] load_data[1] load_data[2] load_data[3] load_ready load_valid
+ no_spike reset result_class[0] result_class[1] start synth_1 synth_10
+ synth_100 synth_1000 synth_10000 synth_10001 synth_10002 synth_10003
+ synth_10004 synth_10005 synth_10006 synth_10007 synth_10008 synth_10009
+ synth_1001 synth_10010 synth_10011 synth_10012 synth_10013 synth_10014
+ synth_10015 synth_10016 synth_10017 synth_10018 synth_10019 synth_1002
+ synth_10020 synth_10021 synth_10022 synth_10023 synth_10024 synth_10025
+ synth_10026 synth_10027 synth_10028 synth_10029 synth_1003 synth_10030
+ synth_10031 synth_10032 synth_10033 synth_10034 synth_10035 synth_10036
+ synth_10037 synth_10038 synth_10039 synth_1004 synth_10040 synth_10041
+ synth_10042 synth_10043 synth_10044 synth_10045 synth_10046 synth_10047
+ synth_10048 synth_10049 synth_1005 synth_10050 synth_10051 synth_10052
+ synth_10053 synth_10054 synth_10055 synth_10056 synth_10057 synth_10058
+ synth_10059 synth_1006 synth_10060 synth_10061 synth_10062 synth_10063
+ synth_10064 synth_10065 synth_10066 synth_10067 synth_10068 synth_10069
+ synth_1007 synth_10070 synth_10071 synth_10072 synth_10073 synth_10074
+ synth_10075 synth_10076 synth_10077 synth_10078 synth_10079 synth_1008
+ synth_10080 synth_10081 synth_10082 synth_10083 synth_10084 synth_10085
+ synth_10086 synth_10087 synth_10088 synth_10089 synth_1009 synth_10090
+ synth_10091 synth_10092 synth_10093 synth_10094 synth_10095 synth_10096
+ synth_10097 synth_10098 synth_10099 synth_101 synth_1010 synth_10100
+ synth_10101 synth_10102 synth_10103 synth_10104 synth_10105 synth_10106
+ synth_10107 synth_10108 synth_10109 synth_1011 synth_10110 synth_10111
+ synth_10112 synth_10113 synth_10114 synth_10115 synth_10116 synth_10117
+ synth_10118 synth_10119 synth_1012 synth_10120 synth_10121 synth_10122
+ synth_10123 synth_10124 synth_10125 synth_10126 synth_10127 synth_10128
+ synth_10129 synth_1013 synth_10130 synth_10131 synth_10132 synth_10133
+ synth_10134 synth_10135 synth_10136 synth_10137 synth_10138 synth_10139
+ synth_1014 synth_10140 synth_10141 synth_10142 synth_10143 synth_10144
+ synth_10145 synth_10146 synth_10147 synth_10148 synth_10149 synth_1015
+ synth_10150 synth_10151 synth_10152 synth_10153 synth_10154 synth_10155
+ synth_10156 synth_10157 synth_10158 synth_10159 synth_1016 synth_10160
+ synth_10161 synth_10162 synth_10163 synth_10164 synth_10165 synth_10166
+ synth_10167 synth_10168 synth_10169 synth_1017 synth_10170 synth_10171
+ synth_10172 synth_10173 synth_10174 synth_10175 synth_10176 synth_10177
+ synth_10178 synth_10179 synth_1018 synth_10180 synth_10181 synth_10182
+ synth_10183 synth_10184 synth_10185 synth_10186 synth_10187 synth_10188
+ synth_10189 synth_1019 synth_10190 synth_10191 synth_10192 synth_10193
+ synth_10194 synth_10195 synth_10196 synth_10197 synth_10198 synth_10199
+ synth_102 synth_1020 synth_10200 synth_10201 synth_10202 synth_10203
+ synth_10204 synth_10205 synth_10206 synth_10207 synth_10208 synth_10209
+ synth_1021 synth_10210 synth_10211 synth_10212 synth_10213 synth_10214
+ synth_10215 synth_10216 synth_10217 synth_10218 synth_10219 synth_1022
+ synth_10220 synth_10221 synth_10222 synth_10223 synth_10224 synth_10225
+ synth_10226 synth_10227 synth_10228 synth_10229 synth_1023 synth_10230
+ synth_10231 synth_10232 synth_10233 synth_10234 synth_10235 synth_10236
+ synth_10237 synth_10238 synth_10239 synth_1024 synth_10240 synth_10241
+ synth_10242 synth_10243 synth_10244 synth_10245 synth_10246 synth_10247
+ synth_10248 synth_10249 synth_1025 synth_10250 synth_10251 synth_10252
+ synth_10253 synth_10254 synth_10255 synth_10256 synth_10257 synth_10258
+ synth_10259 synth_1026 synth_10260 synth_10261 synth_10262 synth_10263
+ synth_10264 synth_10265 synth_10266 synth_10267 synth_10268 synth_10269
+ synth_1027 synth_10270 synth_10271 synth_10272 synth_10273 synth_10274
+ synth_10275 synth_10276 synth_10277 synth_10278 synth_10279 synth_1028
+ synth_10280 synth_10281 synth_10282 synth_10283 synth_10284 synth_10285
+ synth_10286 synth_10287 synth_10288 synth_10289 synth_1029 synth_10290
+ synth_10291 synth_10292 synth_10293 synth_10294 synth_10295 synth_10296
+ synth_10297 synth_10298 synth_10299 synth_103 synth_1030 synth_10300
+ synth_10301 synth_10302 synth_10303 synth_10304 synth_10305 synth_10306
+ synth_10307 synth_10308 synth_10309 synth_1031 synth_10310 synth_10311
+ synth_10312 synth_10313 synth_10314 synth_10315 synth_10316 synth_10317
+ synth_10318 synth_10319 synth_1032 synth_10320 synth_10321 synth_10322
+ synth_10323 synth_10324 synth_10325 synth_10326 synth_10327 synth_10328
+ synth_10329 synth_1033 synth_10330 synth_10331 synth_10332 synth_10333
+ synth_10334 synth_10335 synth_10336 synth_10337 synth_10338 synth_10339
+ synth_1034 synth_10340 synth_10341 synth_10342 synth_10343 synth_10344
+ synth_10345 synth_10346 synth_10347 synth_10348 synth_10349 synth_1035
+ synth_10350 synth_10351 synth_10352 synth_10353 synth_10354 synth_10355
+ synth_10356 synth_10357 synth_10358 synth_10359 synth_1036 synth_10360
+ synth_10361 synth_10362 synth_10363 synth_10364 synth_10365 synth_10366
+ synth_10367 synth_10368 synth_10369 synth_1037 synth_10370 synth_10371
+ synth_10372 synth_10373 synth_10374 synth_10375 synth_10376 synth_10377
+ synth_10378 synth_10379 synth_1038 synth_10380 synth_10381 synth_10382
+ synth_10383 synth_10384 synth_10385 synth_10386 synth_10387 synth_10388
+ synth_10389 synth_1039 synth_10390 synth_10391 synth_10392 synth_10393
+ synth_10394 synth_10395 synth_10396 synth_10397 synth_10398 synth_10399
+ synth_104 synth_1040 synth_10400 synth_10401 synth_10402 synth_10403
+ synth_10404 synth_10405 synth_10406 synth_10407 synth_10408 synth_10409
+ synth_1041 synth_10410 synth_10411 synth_10412 synth_10413 synth_10414
+ synth_10415 synth_10416 synth_10417 synth_10418 synth_10419 synth_1042
+ synth_10420 synth_10421 synth_10422 synth_10423 synth_10424 synth_10425
+ synth_10426 synth_10427 synth_10428 synth_10429 synth_1043 synth_10430
+ synth_10431 synth_10432 synth_10433 synth_10434 synth_10435 synth_10436
+ synth_10437 synth_10438 synth_10439 synth_1044 synth_10440 synth_10441
+ synth_10442 synth_10443 synth_10444 synth_10445 synth_10446 synth_10447
+ synth_10448 synth_10449 synth_1045 synth_10450 synth_10451 synth_10452
+ synth_10453 synth_10454 synth_10455 synth_10456 synth_10457 synth_10458
+ synth_10459 synth_1046 synth_10460 synth_10461 synth_10462 synth_10463
+ synth_10464 synth_10465 synth_10466 synth_10467 synth_10468 synth_10469
+ synth_1047 synth_10470 synth_10471 synth_10472 synth_10473 synth_10474
+ synth_10475 synth_10476 synth_10477 synth_10478 synth_10479 synth_1048
+ synth_10480 synth_10481 synth_10482 synth_10483 synth_10484 synth_10485
+ synth_10486 synth_10487 synth_10488 synth_10489 synth_1049 synth_10490
+ synth_10491 synth_10492 synth_10493 synth_10494 synth_10495 synth_10496
+ synth_10497 synth_10498 synth_10499 synth_105 synth_1050 synth_10500
+ synth_10501 synth_10502 synth_10503 synth_10504 synth_10505 synth_10506
+ synth_10507 synth_10508 synth_10509 synth_1051 synth_10510 synth_10511
+ synth_10512 synth_10513 synth_10514 synth_10515 synth_10516 synth_10517
+ synth_10518 synth_10519 synth_1052 synth_10520 synth_10521 synth_10522
+ synth_10523 synth_10524 synth_10525 synth_10526 synth_10527 synth_10528
+ synth_10529 synth_1053 synth_10530 synth_10531 synth_10532 synth_10533
+ synth_10534 synth_10535 synth_10536 synth_10537 synth_10538 synth_10539
+ synth_1054 synth_10540 synth_10541 synth_10542 synth_10543 synth_10544
+ synth_10545 synth_10546 synth_10547 synth_10548 synth_10549 synth_1055
+ synth_10550 synth_10551 synth_10552 synth_10553 synth_10554 synth_10555
+ synth_10556 synth_10557 synth_10558 synth_10559 synth_1056 synth_10560
+ synth_10561 synth_10562 synth_10563 synth_10564 synth_10565 synth_10566
+ synth_10567 synth_10568 synth_10569 synth_1057 synth_10570 synth_10571
+ synth_10572 synth_10573 synth_10574 synth_10575 synth_10576 synth_10577
+ synth_10578 synth_10579 synth_1058 synth_10580 synth_10581 synth_10582
+ synth_10583 synth_10584 synth_10585 synth_10586 synth_10587 synth_10588
+ synth_10589 synth_1059 synth_10590 synth_10591 synth_10592 synth_10593
+ synth_10594 synth_10595 synth_10596 synth_10597 synth_10598 synth_10599
+ synth_106 synth_1060 synth_10600 synth_10601 synth_10602 synth_10603
+ synth_10604 synth_10605 synth_10606 synth_10607 synth_10608 synth_10609
+ synth_1061 synth_10610 synth_10611 synth_10612 synth_10613 synth_10614
+ synth_10615 synth_10616 synth_10617 synth_10618 synth_10619 synth_1062
+ synth_10620 synth_10621 synth_10622 synth_10623 synth_10624 synth_10625
+ synth_10626 synth_10627 synth_10628 synth_10629 synth_1063 synth_10630
+ synth_10631 synth_10632 synth_10633 synth_10634 synth_10635 synth_10636
+ synth_10637 synth_10638 synth_10639 synth_1064 synth_10640 synth_10641
+ synth_10642 synth_10643 synth_10644 synth_10645 synth_10646 synth_10647
+ synth_10648 synth_10649 synth_1065 synth_10650 synth_10651 synth_10652
+ synth_10653 synth_10654 synth_10655 synth_10656 synth_10657 synth_10658
+ synth_10659 synth_1066 synth_10660 synth_10661 synth_10662 synth_10663
+ synth_10664 synth_10665 synth_10666 synth_10667 synth_10668 synth_10669
+ synth_1067 synth_10670 synth_10671 synth_10672 synth_10673 synth_10674
+ synth_10675 synth_10676 synth_10677 synth_10678 synth_10679 synth_1068
+ synth_10680 synth_10681 synth_10682 synth_10683 synth_10684 synth_10685
+ synth_10686 synth_10687 synth_10688 synth_10689 synth_1069 synth_10690
+ synth_10691 synth_10692 synth_10693 synth_10694 synth_10695 synth_10696
+ synth_10697 synth_10698 synth_10699 synth_107 synth_1070 synth_10700
+ synth_10701 synth_10702 synth_10703 synth_10704 synth_10705 synth_10706
+ synth_10707 synth_10708 synth_10709 synth_1071 synth_10710 synth_10711
+ synth_10712 synth_10713 synth_10714 synth_10715 synth_10716 synth_10717
+ synth_10718 synth_10719 synth_1072 synth_10720 synth_10721 synth_10722
+ synth_10723 synth_10724 synth_10725 synth_10726 synth_10727 synth_10728
+ synth_10729 synth_1073 synth_10730 synth_10731 synth_10732 synth_10733
+ synth_10734 synth_10735 synth_10736 synth_10737 synth_10738 synth_10739
+ synth_1074 synth_10740 synth_10741 synth_10742 synth_10743 synth_10744
+ synth_10745 synth_10746 synth_10747 synth_10748 synth_10749 synth_1075
+ synth_10750 synth_10751 synth_10752 synth_10753 synth_10754 synth_10755
+ synth_10756 synth_10757 synth_10758 synth_10759 synth_1076 synth_10760
+ synth_10761 synth_10762 synth_10763 synth_10764 synth_10765 synth_10766
+ synth_10767 synth_10768 synth_10769 synth_1077 synth_10770 synth_10771
+ synth_10772 synth_10773 synth_10774 synth_10775 synth_10776 synth_10777
+ synth_10778 synth_10779 synth_1078 synth_10780 synth_10781 synth_10782
+ synth_10783 synth_10784 synth_10785 synth_10786 synth_10787 synth_10788
+ synth_10789 synth_1079 synth_10790 synth_10791 synth_10792 synth_10793
+ synth_10794 synth_10795 synth_10796 synth_10797 synth_10798 synth_10799
+ synth_108 synth_1080 synth_10800 synth_10801 synth_10802 synth_10803
+ synth_10804 synth_10805 synth_10806 synth_10807 synth_10808 synth_10809
+ synth_1081 synth_10810 synth_10811 synth_10812 synth_10813 synth_10814
+ synth_10815 synth_10816 synth_10817 synth_10818 synth_10819 synth_1082
+ synth_10820 synth_10821 synth_10822 synth_10823 synth_10824 synth_10825
+ synth_10826 synth_10827 synth_10828 synth_10829 synth_1083 synth_10830
+ synth_10831 synth_10832 synth_10833 synth_10834 synth_10835 synth_10836
+ synth_10837 synth_10838 synth_10839 synth_1084 synth_10840 synth_10841
+ synth_10842 synth_10843 synth_10844 synth_10845 synth_10846 synth_10847
+ synth_10848 synth_10849 synth_1085 synth_10850 synth_10851 synth_10852
+ synth_10853 synth_10854 synth_10855 synth_10856 synth_10857 synth_10858
+ synth_10859 synth_1086 synth_10860 synth_10861 synth_10862 synth_10863
+ synth_10864 synth_10865 synth_10866 synth_10867 synth_10868 synth_10869
+ synth_1087 synth_10870 synth_10871 synth_10872 synth_10873 synth_10874
+ synth_10875 synth_10876 synth_10877 synth_10878 synth_10879 synth_1088
+ synth_10880 synth_10881 synth_10882 synth_10883 synth_10884 synth_10885
+ synth_10886 synth_10887 synth_10888 synth_10889 synth_1089 synth_10890
+ synth_10891 synth_10892 synth_10893 synth_10894 synth_10895 synth_10896
+ synth_10897 synth_10898 synth_10899 synth_109 synth_1090 synth_10900
+ synth_10901 synth_10902 synth_10903 synth_10904 synth_10905 synth_10906
+ synth_10907 synth_10908 synth_10909 synth_1091 synth_10910 synth_10911
+ synth_10912 synth_10913 synth_10914 synth_10915 synth_10916 synth_10917
+ synth_10918 synth_10919 synth_1092 synth_10920 synth_10921 synth_10922
+ synth_10923 synth_10924 synth_10925 synth_10926 synth_10927 synth_10928
+ synth_10929 synth_1093 synth_10930 synth_10931 synth_10932 synth_10933
+ synth_10934 synth_10935 synth_10936 synth_10937 synth_10938 synth_10939
+ synth_1094 synth_10940 synth_10941 synth_10942 synth_10943 synth_10944
+ synth_10945 synth_10946 synth_10947 synth_10948 synth_10949 synth_1095
+ synth_10950 synth_10951 synth_10952 synth_10953 synth_10954 synth_10955
+ synth_10956 synth_10957 synth_10958 synth_10959 synth_1096 synth_10960
+ synth_10961 synth_10962 synth_10963 synth_10964 synth_10965 synth_10966
+ synth_10967 synth_10968 synth_10969 synth_1097 synth_10970 synth_10971
+ synth_10972 synth_10973 synth_10974 synth_10975 synth_10976 synth_10977
+ synth_10978 synth_10979 synth_1098 synth_10980 synth_10981 synth_10982
+ synth_10983 synth_10984 synth_10985 synth_10986 synth_10987 synth_10988
+ synth_10989 synth_1099 synth_10990 synth_10991 synth_10992 synth_10993
+ synth_10994 synth_10995 synth_10996 synth_10997 synth_10998 synth_10999
+ synth_11 synth_110 synth_1100 synth_11000 synth_11001 synth_11002 synth_11003
+ synth_11004 synth_11005 synth_11006 synth_11007 synth_11008 synth_11009
+ synth_1101 synth_11010 synth_11011 synth_11012 synth_11013 synth_11014
+ synth_11015 synth_11016 synth_11017 synth_11018 synth_11019 synth_1102
+ synth_11020 synth_11021 synth_11022 synth_11023 synth_11024 synth_11025
+ synth_11026 synth_11027 synth_11028 synth_11029 synth_1103 synth_11030
+ synth_11031 synth_11032 synth_11033 synth_11034 synth_11035 synth_11036
+ synth_11037 synth_11038 synth_11039 synth_1104 synth_11040 synth_11041
+ synth_11042 synth_11043 synth_11044 synth_11045 synth_11046 synth_11047
+ synth_11048 synth_11049 synth_1105 synth_11050 synth_11051 synth_11052
+ synth_11053 synth_11054 synth_11055 synth_11056 synth_11057 synth_11058
+ synth_11059 synth_1106 synth_11060 synth_11061 synth_11062 synth_11063
+ synth_11064 synth_11065 synth_11066 synth_11067 synth_11068 synth_11069
+ synth_1107 synth_11070 synth_11071 synth_11072 synth_11073 synth_11074
+ synth_11075 synth_11076 synth_11077 synth_11078 synth_11079 synth_1108
+ synth_11080 synth_11081 synth_11082 synth_11083 synth_11084 synth_11085
+ synth_11086 synth_11087 synth_11088 synth_11089 synth_1109 synth_11090
+ synth_11091 synth_11092 synth_11093 synth_11094 synth_11095 synth_11096
+ synth_11097 synth_11098 synth_11099 synth_111 synth_1110 synth_11100
+ synth_11101 synth_11102 synth_11103 synth_11104 synth_11105 synth_11106
+ synth_11107 synth_11108 synth_11109 synth_1111 synth_11110 synth_11111
+ synth_11112 synth_11113 synth_11114 synth_11115 synth_11116 synth_11117
+ synth_11118 synth_11119 synth_1112 synth_11120 synth_11121 synth_11122
+ synth_11123 synth_11124 synth_11125 synth_11126 synth_11127 synth_11128
+ synth_11129 synth_1113 synth_11130 synth_11131 synth_11132 synth_11133
+ synth_11134 synth_11135 synth_11136 synth_11137 synth_11138 synth_11139
+ synth_1114 synth_11140 synth_11141 synth_11142 synth_11143 synth_11144
+ synth_11145 synth_11146 synth_11147 synth_11148 synth_11149 synth_1115
+ synth_11150 synth_11151 synth_11152 synth_11153 synth_11154 synth_11155
+ synth_11156 synth_11157 synth_11158 synth_11159 synth_1116 synth_11160
+ synth_11161 synth_11162 synth_11163 synth_11164 synth_11165 synth_11166
+ synth_11167 synth_11168 synth_11169 synth_1117 synth_11170 synth_11171
+ synth_11172 synth_11173 synth_11174 synth_11175 synth_11176 synth_11177
+ synth_11178 synth_11179 synth_1118 synth_11180 synth_11181 synth_11182
+ synth_11183 synth_11184 synth_11185 synth_11186 synth_11187 synth_11188
+ synth_11189 synth_1119 synth_11190 synth_11191 synth_11192 synth_11193
+ synth_11194 synth_11195 synth_11196 synth_11197 synth_11198 synth_11199
+ synth_112 synth_1120 synth_11200 synth_11201 synth_11202 synth_11203
+ synth_11204 synth_11205 synth_11206 synth_11207 synth_11208 synth_11209
+ synth_1121 synth_11210 synth_11211 synth_11212 synth_11213 synth_11214
+ synth_11215 synth_11216 synth_11217 synth_11218 synth_11219 synth_1122
+ synth_11220 synth_11221 synth_11222 synth_11223 synth_11224 synth_11225
+ synth_11226 synth_11227 synth_11228 synth_11229 synth_1123 synth_11230
+ synth_11231 synth_11232 synth_11233 synth_11234 synth_11235 synth_11236
+ synth_11237 synth_11238 synth_11239 synth_1124 synth_11240 synth_11241
+ synth_11242 synth_11243 synth_11244 synth_11245 synth_11246 synth_11247
+ synth_11248 synth_11249 synth_1125 synth_11250 synth_11251 synth_11252
+ synth_11253 synth_11254 synth_11255 synth_11256 synth_11257 synth_11258
+ synth_11259 synth_1126 synth_11260 synth_11261 synth_11262 synth_11263
+ synth_11264 synth_11265 synth_11266 synth_11267 synth_11268 synth_11269
+ synth_1127 synth_11270 synth_11271 synth_11272 synth_11273 synth_11274
+ synth_11275 synth_11276 synth_11277 synth_11278 synth_11279 synth_1128
+ synth_11280 synth_11281 synth_11282 synth_11283 synth_11284 synth_11285
+ synth_11286 synth_11287 synth_11288 synth_11289 synth_1129 synth_11290
+ synth_11291 synth_11292 synth_11293 synth_11294 synth_11295 synth_11296
+ synth_11297 synth_11298 synth_11299 synth_113 synth_1130 synth_11300
+ synth_11301 synth_11302 synth_11303 synth_11304 synth_11305 synth_11306
+ synth_11307 synth_11308 synth_11309 synth_1131 synth_11310 synth_11311
+ synth_11312 synth_11313 synth_11314 synth_11315 synth_11316 synth_11317
+ synth_11318 synth_11319 synth_1132 synth_11320 synth_11321 synth_11322
+ synth_11323 synth_11324 synth_11325 synth_11326 synth_11327 synth_11328
+ synth_11329 synth_1133 synth_11330 synth_11331 synth_11332 synth_11333
+ synth_11334 synth_11335 synth_11336 synth_11337 synth_11338 synth_11339
+ synth_1134 synth_11340 synth_11341 synth_11342 synth_11343 synth_11344
+ synth_11345 synth_11346 synth_11347 synth_11348 synth_11349 synth_1135
+ synth_11350 synth_11351 synth_11352 synth_11353 synth_11354 synth_11355
+ synth_11356 synth_11357 synth_11358 synth_11359 synth_1136 synth_11360
+ synth_11361 synth_11362 synth_11363 synth_11364 synth_11365 synth_11366
+ synth_11367 synth_11368 synth_11369 synth_1137 synth_11370 synth_11371
+ synth_11372 synth_11373 synth_11374 synth_11375 synth_11376 synth_11377
+ synth_11378 synth_11379 synth_1138 synth_11380 synth_11381 synth_11382
+ synth_11383 synth_11384 synth_11385 synth_11386 synth_11387 synth_11388
+ synth_11389 synth_1139 synth_11390 synth_11391 synth_11392 synth_11393
+ synth_11394 synth_11395 synth_11396 synth_11397 synth_11398 synth_11399
+ synth_114 synth_1140 synth_11400 synth_11401 synth_11402 synth_11403
+ synth_11404 synth_11405 synth_11406 synth_11407 synth_11408 synth_11409
+ synth_1141 synth_11410 synth_11411 synth_11412 synth_11413 synth_11414
+ synth_11415 synth_11416 synth_11417 synth_11418 synth_11419 synth_1142
+ synth_11420 synth_11421 synth_11422 synth_11423 synth_11424 synth_11425
+ synth_11426 synth_11427 synth_11428 synth_11429 synth_1143 synth_11430
+ synth_11431 synth_11432 synth_11433 synth_11434 synth_11435 synth_11436
+ synth_11437 synth_11438 synth_11439 synth_1144 synth_11440 synth_11441
+ synth_11442 synth_11443 synth_11444 synth_11445 synth_11446 synth_11447
+ synth_11448 synth_11449 synth_1145 synth_11450 synth_11451 synth_11452
+ synth_11453 synth_11454 synth_11455 synth_11456 synth_11457 synth_11458
+ synth_11459 synth_1146 synth_11460 synth_11461 synth_11462 synth_11463
+ synth_11464 synth_11465 synth_11466 synth_11467 synth_11468 synth_11469
+ synth_1147 synth_11470 synth_11471 synth_11472 synth_11473 synth_11474
+ synth_11475 synth_11476 synth_11477 synth_11478 synth_11479 synth_1148
+ synth_11480 synth_11481 synth_11482 synth_11483 synth_11484 synth_11485
+ synth_11486 synth_11487 synth_11488 synth_11489 synth_1149 synth_11490
+ synth_11491 synth_11492 synth_11493 synth_11494 synth_11495 synth_11496
+ synth_11497 synth_11498 synth_11499 synth_115 synth_1150 synth_11500
+ synth_11501 synth_11502 synth_11503 synth_11504 synth_11505 synth_11506
+ synth_11507 synth_11508 synth_11509 synth_1151 synth_11510 synth_11511
+ synth_11512 synth_11513 synth_11514 synth_11515 synth_11516 synth_11517
+ synth_11518 synth_11519 synth_1152 synth_11520 synth_11521 synth_11522
+ synth_11523 synth_11524 synth_11525 synth_11526 synth_11527 synth_11528
+ synth_11529 synth_1153 synth_11530 synth_11531 synth_11532 synth_11533
+ synth_11534 synth_11535 synth_11536 synth_11537 synth_11538 synth_11539
+ synth_1154 synth_11540 synth_11541 synth_11542 synth_11543 synth_11544
+ synth_11545 synth_11546 synth_11547 synth_11548 synth_11549 synth_1155
+ synth_11550 synth_11551 synth_11552 synth_11553 synth_11554 synth_11555
+ synth_11556 synth_11557 synth_11558 synth_11559 synth_1156 synth_11560
+ synth_11561 synth_11562 synth_11563 synth_11564 synth_11565 synth_11566
+ synth_11567 synth_11568 synth_11569 synth_1157 synth_11570 synth_11571
+ synth_11572 synth_11573 synth_11574 synth_11575 synth_11576 synth_11577
+ synth_11578 synth_11579 synth_1158 synth_11580 synth_11581 synth_11582
+ synth_11583 synth_11584 synth_11585 synth_11586 synth_11587 synth_11588
+ synth_11589 synth_1159 synth_11590 synth_11591 synth_11592 synth_11593
+ synth_11594 synth_11595 synth_11596 synth_11597 synth_11598 synth_11599
+ synth_116 synth_1160 synth_11600 synth_11601 synth_11602 synth_11603
+ synth_11604 synth_11605 synth_11606 synth_11607 synth_11608 synth_11609
+ synth_1161 synth_11610 synth_11611 synth_11612 synth_11613 synth_11614
+ synth_11615 synth_11616 synth_11617 synth_11618 synth_11619 synth_1162
+ synth_11620 synth_11621 synth_11622 synth_11623 synth_11624 synth_11625
+ synth_11626 synth_11627 synth_11628 synth_11629 synth_1163 synth_11630
+ synth_11631 synth_11632 synth_11633 synth_11634 synth_11635 synth_11636
+ synth_11637 synth_11638 synth_11639 synth_1164 synth_11640 synth_11641
+ synth_11642 synth_11643 synth_11644 synth_11645 synth_11646 synth_11647
+ synth_11648 synth_11649 synth_1165 synth_11650 synth_11651 synth_11652
+ synth_11653 synth_11654 synth_11655 synth_11656 synth_11657 synth_11658
+ synth_11659 synth_1166 synth_11660 synth_11661 synth_11662 synth_11663
+ synth_11664 synth_11665 synth_11666 synth_11667 synth_11668 synth_11669
+ synth_1167 synth_11670 synth_11671 synth_11672 synth_11673 synth_11674
+ synth_11675 synth_11676 synth_11677 synth_11678 synth_11679 synth_1168
+ synth_11680 synth_11681 synth_11682 synth_11683 synth_11684 synth_11685
+ synth_11686 synth_11687 synth_11688 synth_11689 synth_1169 synth_11690
+ synth_11691 synth_11692 synth_11693 synth_11694 synth_11695 synth_11696
+ synth_11697 synth_11698 synth_11699 synth_117 synth_1170 synth_11700
+ synth_11701 synth_11702 synth_11703 synth_11704 synth_11705 synth_11706
+ synth_11707 synth_11708 synth_11709 synth_1171 synth_11710 synth_11711
+ synth_11712 synth_11713 synth_11714 synth_11715 synth_11716 synth_11717
+ synth_11718 synth_11719 synth_1172 synth_11720 synth_11721 synth_11722
+ synth_11723 synth_11724 synth_11725 synth_11726 synth_11727 synth_11728
+ synth_11729 synth_1173 synth_11730 synth_11731 synth_11732 synth_11733
+ synth_11734 synth_11735 synth_11736 synth_11737 synth_11738 synth_11739
+ synth_1174 synth_11740 synth_11741 synth_11742 synth_11743 synth_11744
+ synth_11745 synth_11746 synth_11747 synth_11748 synth_11749 synth_1175
+ synth_11750 synth_11751 synth_11752 synth_11753 synth_11754 synth_11755
+ synth_11756 synth_11757 synth_11758 synth_11759 synth_1176 synth_11760
+ synth_11761 synth_11762 synth_11763 synth_11764 synth_11765 synth_11766
+ synth_11767 synth_11768 synth_11769 synth_1177 synth_11770 synth_11771
+ synth_11772 synth_11773 synth_11774 synth_11775 synth_11776 synth_11777
+ synth_11778 synth_11779 synth_1178 synth_11780 synth_11781 synth_11782
+ synth_11783 synth_11784 synth_11785 synth_11786 synth_11787 synth_11788
+ synth_11789 synth_1179 synth_11790 synth_11791 synth_11792 synth_11793
+ synth_11794 synth_11795 synth_11796 synth_11797 synth_11798 synth_11799
+ synth_118 synth_1180 synth_11800 synth_11801 synth_11802 synth_11803
+ synth_11804 synth_11805 synth_11806 synth_11807 synth_11808 synth_11809
+ synth_1181 synth_11810 synth_11811 synth_11812 synth_11813 synth_11814
+ synth_11815 synth_11816 synth_11817 synth_11818 synth_11819 synth_1182
+ synth_11820 synth_11821 synth_11822 synth_11823 synth_11824 synth_11825
+ synth_11826 synth_11827 synth_11828 synth_11829 synth_1183 synth_11830
+ synth_11831 synth_11832 synth_11833 synth_11834 synth_11835 synth_11836
+ synth_11837 synth_11838 synth_11839 synth_1184 synth_11840 synth_11841
+ synth_11842 synth_11843 synth_11844 synth_11845 synth_11846 synth_11847
+ synth_11848 synth_11849 synth_1185 synth_11850 synth_11851 synth_11852
+ synth_11853 synth_11854 synth_11855 synth_11856 synth_11857 synth_11858
+ synth_11859 synth_1186 synth_11860 synth_11861 synth_11862 synth_11863
+ synth_11864 synth_11865 synth_11866 synth_11867 synth_11868 synth_11869
+ synth_1187 synth_11870 synth_11871 synth_11872 synth_11873 synth_11874
+ synth_11875 synth_11876 synth_11877 synth_11878 synth_11879 synth_1188
+ synth_11880 synth_11881 synth_11882 synth_11883 synth_11884 synth_11885
+ synth_11886 synth_11887 synth_11888 synth_11889 synth_1189 synth_11890
+ synth_11891 synth_11892 synth_11893 synth_11894 synth_11895 synth_11896
+ synth_11897 synth_11898 synth_11899 synth_119 synth_1190 synth_11900
+ synth_11901 synth_11902 synth_11903 synth_11904 synth_11905 synth_11906
+ synth_11907 synth_11908 synth_11909 synth_1191 synth_11910 synth_11911
+ synth_11912 synth_11913 synth_11914 synth_11915 synth_11916 synth_11917
+ synth_11918 synth_11919 synth_1192 synth_11920 synth_11921 synth_11922
+ synth_11923 synth_11924 synth_11925 synth_11926 synth_11927 synth_11928
+ synth_11929 synth_1193 synth_11930 synth_11931 synth_11932 synth_11933
+ synth_11934 synth_11935 synth_11936 synth_11937 synth_11938 synth_11939
+ synth_1194 synth_11940 synth_11941 synth_11942 synth_11943 synth_11944
+ synth_11945 synth_11946 synth_11947 synth_11948 synth_11949 synth_1195
+ synth_11950 synth_11951 synth_11952 synth_11953 synth_11954 synth_11955
+ synth_11956 synth_11957 synth_11958 synth_11959 synth_1196 synth_11960
+ synth_11961 synth_11962 synth_11963 synth_11964 synth_11965 synth_11966
+ synth_11967 synth_11968 synth_11969 synth_1197 synth_11970 synth_11971
+ synth_11972 synth_11973 synth_11974 synth_11975 synth_11976 synth_11977
+ synth_11978 synth_11979 synth_1198 synth_11980 synth_11981 synth_11982
+ synth_11983 synth_11984 synth_11985 synth_11986 synth_11987 synth_11988
+ synth_11989 synth_1199 synth_11990 synth_11991 synth_11992 synth_11993
+ synth_11994 synth_11995 synth_11996 synth_11997 synth_11998 synth_11999
+ synth_12 synth_120 synth_1200 synth_12000 synth_12001 synth_12002 synth_12003
+ synth_12004 synth_12005 synth_12006 synth_12007 synth_12008 synth_12009
+ synth_1201 synth_12010 synth_12011 synth_12012 synth_12013 synth_12014
+ synth_12015 synth_12016 synth_12017 synth_12018 synth_12019 synth_1202
+ synth_12020 synth_12021 synth_12022 synth_12023 synth_12024 synth_12025
+ synth_12026 synth_12027 synth_12028 synth_12029 synth_1203 synth_12030
+ synth_12031 synth_12032 synth_12033 synth_12034 synth_12035 synth_12036
+ synth_12037 synth_12038 synth_12039 synth_1204 synth_12040 synth_12041
+ synth_12042 synth_12043 synth_12044 synth_12045 synth_12046 synth_12047
+ synth_12048 synth_12049 synth_1205 synth_12050 synth_12051 synth_12052
+ synth_12053 synth_12054 synth_12055 synth_12056 synth_12057 synth_12058
+ synth_12059 synth_1206 synth_12060 synth_12061 synth_12062 synth_12063
+ synth_12064 synth_12065 synth_12066 synth_12067 synth_12068 synth_12069
+ synth_1207 synth_12070 synth_12071 synth_12072 synth_12073 synth_12074
+ synth_12075 synth_12076 synth_12077 synth_12078 synth_12079 synth_1208
+ synth_12080 synth_12081 synth_12082 synth_12083 synth_12084 synth_12085
+ synth_12086 synth_12087 synth_12088 synth_12089 synth_1209 synth_12090
+ synth_12091 synth_12092 synth_12093 synth_12094 synth_12095 synth_12096
+ synth_12097 synth_12098 synth_12099 synth_121 synth_1210 synth_12100
+ synth_12101 synth_12102 synth_12103 synth_12104 synth_12105 synth_12106
+ synth_12107 synth_12108 synth_12109 synth_1211 synth_12110 synth_12111
+ synth_12112 synth_12113 synth_12114 synth_12115 synth_12116 synth_12117
+ synth_12118 synth_12119 synth_1212 synth_12120 synth_12121 synth_12122
+ synth_12123 synth_12124 synth_12125 synth_12126 synth_12127 synth_12128
+ synth_12129 synth_1213 synth_12130 synth_12131 synth_12132 synth_12133
+ synth_12134 synth_12135 synth_12136 synth_12137 synth_12138 synth_12139
+ synth_1214 synth_12140 synth_12141 synth_12142 synth_12143 synth_12144
+ synth_12145 synth_12146 synth_12147 synth_12148 synth_12149 synth_1215
+ synth_12150 synth_12151 synth_12152 synth_12153 synth_12154 synth_12155
+ synth_12156 synth_12157 synth_12158 synth_12159 synth_1216 synth_12160
+ synth_12161 synth_12162 synth_12163 synth_12164 synth_12165 synth_12166
+ synth_12167 synth_12168 synth_12169 synth_1217 synth_12170 synth_12171
+ synth_12172 synth_12173 synth_12174 synth_12175 synth_12176 synth_12177
+ synth_12178 synth_12179 synth_1218 synth_12180 synth_12181 synth_12182
+ synth_12183 synth_12184 synth_12185 synth_12186 synth_12187 synth_12188
+ synth_12189 synth_1219 synth_12190 synth_12191 synth_12192 synth_12193
+ synth_12194 synth_12195 synth_12196 synth_12197 synth_12198 synth_12199
+ synth_122 synth_1220 synth_12200 synth_12201 synth_12202 synth_12203
+ synth_12204 synth_12205 synth_12206 synth_12207 synth_12208 synth_12209
+ synth_1221 synth_12210 synth_12211 synth_12212 synth_12213 synth_12214
+ synth_12215 synth_12216 synth_12217 synth_12218 synth_12219 synth_1222
+ synth_12220 synth_12221 synth_12222 synth_12223 synth_12224 synth_12225
+ synth_12226 synth_12227 synth_12228 synth_12229 synth_1223 synth_12230
+ synth_12231 synth_12232 synth_12233 synth_12234 synth_12235 synth_12236
+ synth_12237 synth_12238 synth_12239 synth_1224 synth_12240 synth_12241
+ synth_12242 synth_12243 synth_12244 synth_12245 synth_12246 synth_12247
+ synth_12248 synth_12249 synth_1225 synth_12250 synth_12251 synth_12252
+ synth_12253 synth_12254 synth_12255 synth_12256 synth_12257 synth_12258
+ synth_12259 synth_1226 synth_12260 synth_12261 synth_12262 synth_12263
+ synth_12264 synth_12265 synth_12266 synth_12267 synth_12268 synth_12269
+ synth_1227 synth_12270 synth_12271 synth_12272 synth_12273 synth_12274
+ synth_12275 synth_12276 synth_12277 synth_12278 synth_12279 synth_1228
+ synth_12280 synth_12281 synth_12282 synth_12283 synth_12284 synth_12285
+ synth_12286 synth_12287 synth_12288 synth_12289 synth_1229 synth_12290
+ synth_12291 synth_12292 synth_12293 synth_12294 synth_12295 synth_12296
+ synth_12297 synth_12298 synth_12299 synth_123 synth_1230 synth_12300
+ synth_12301 synth_12302 synth_12303 synth_12304 synth_12305 synth_12306
+ synth_12307 synth_12308 synth_12309 synth_1231 synth_12310 synth_12311
+ synth_12312 synth_12313 synth_12314 synth_12315 synth_12316 synth_12317
+ synth_12318 synth_12319 synth_1232 synth_12320 synth_12321 synth_12322
+ synth_12323 synth_12324 synth_12325 synth_12326 synth_12327 synth_12328
+ synth_12329 synth_1233 synth_12330 synth_12331 synth_12332 synth_12333
+ synth_12334 synth_12335 synth_12336 synth_12337 synth_12338 synth_12339
+ synth_1234 synth_12340 synth_12341 synth_12342 synth_12343 synth_12344
+ synth_12345 synth_12346 synth_12347 synth_12348 synth_12349 synth_1235
+ synth_12350 synth_12351 synth_12352 synth_12353 synth_12354 synth_12355
+ synth_12356 synth_12357 synth_12358 synth_12359 synth_1236 synth_12360
+ synth_12361 synth_12362 synth_12363 synth_12364 synth_12365 synth_12366
+ synth_12367 synth_12368 synth_12369 synth_1237 synth_12370 synth_12371
+ synth_12372 synth_12373 synth_12374 synth_12375 synth_12376 synth_12377
+ synth_12378 synth_12379 synth_1238 synth_12380 synth_12381 synth_12382
+ synth_12383 synth_12384 synth_12385 synth_12386 synth_12387 synth_12388
+ synth_12389 synth_1239 synth_12390 synth_12391 synth_12392 synth_12393
+ synth_12394 synth_12395 synth_12396 synth_12397 synth_12398 synth_12399
+ synth_124 synth_1240 synth_12400 synth_12401 synth_12402 synth_12403
+ synth_12404 synth_12405 synth_12406 synth_12407 synth_12408 synth_12409
+ synth_1241 synth_12410 synth_12411 synth_12412 synth_12413 synth_12414
+ synth_12415 synth_12416 synth_12417 synth_12418 synth_12419 synth_1242
+ synth_12420 synth_12421 synth_12422 synth_12423 synth_12424 synth_12425
+ synth_12426 synth_12427 synth_12428 synth_12429 synth_1243 synth_12430
+ synth_12431 synth_12432 synth_12433 synth_12434 synth_12435 synth_12436
+ synth_12437 synth_12438 synth_12439 synth_1244 synth_12440 synth_12441
+ synth_12442 synth_12443 synth_12444 synth_12445 synth_12446 synth_12447
+ synth_12448 synth_12449 synth_1245 synth_12450 synth_12451 synth_12452
+ synth_12453 synth_12454 synth_12455 synth_12456 synth_12457 synth_12458
+ synth_12459 synth_1246 synth_12460 synth_12461 synth_12462 synth_12463
+ synth_12464 synth_12465 synth_12466 synth_12467 synth_12468 synth_12469
+ synth_1247 synth_12470 synth_12471 synth_12472 synth_12473 synth_12474
+ synth_12475 synth_12476 synth_12477 synth_12478 synth_12479 synth_1248
+ synth_12480 synth_12481 synth_12482 synth_12483 synth_12484 synth_12485
+ synth_12486 synth_12487 synth_12488 synth_12489 synth_1249 synth_12490
+ synth_12491 synth_12492 synth_12493 synth_12494 synth_12495 synth_12496
+ synth_12497 synth_12498 synth_12499 synth_125 synth_1250 synth_12500
+ synth_12501 synth_12502 synth_12503 synth_12504 synth_12505 synth_12506
+ synth_12507 synth_12508 synth_12509 synth_1251 synth_12510 synth_12511
+ synth_12512 synth_12513 synth_12514 synth_12515 synth_12516 synth_12517
+ synth_12518 synth_12519 synth_1252 synth_12520 synth_12521 synth_12522
+ synth_12523 synth_12524 synth_12525 synth_12526 synth_12527 synth_12528
+ synth_12529 synth_1253 synth_12530 synth_12531 synth_12532 synth_12533
+ synth_12534 synth_12535 synth_12536 synth_12537 synth_12538 synth_12539
+ synth_1254 synth_12540 synth_12541 synth_12542 synth_12543 synth_12544
+ synth_12545 synth_12546 synth_12547 synth_12548 synth_12549 synth_1255
+ synth_12550 synth_12551 synth_12552 synth_12553 synth_12554 synth_12555
+ synth_12556 synth_12557 synth_12558 synth_12559 synth_1256 synth_12560
+ synth_12561 synth_12562 synth_12563 synth_12564 synth_12565 synth_12566
+ synth_12567 synth_12568 synth_12569 synth_1257 synth_12570 synth_12571
+ synth_12572 synth_12573 synth_12574 synth_12575 synth_12576 synth_12577
+ synth_12578 synth_12579 synth_1258 synth_12580 synth_12581 synth_12582
+ synth_12583 synth_12584 synth_12585 synth_12586 synth_12587 synth_12588
+ synth_12589 synth_1259 synth_12590 synth_12591 synth_12592 synth_12593
+ synth_12594 synth_12595 synth_12596 synth_12597 synth_12598 synth_12599
+ synth_126 synth_1260 synth_12600 synth_12601 synth_12602 synth_12603
+ synth_12604 synth_12605 synth_12606 synth_12607 synth_12608 synth_12609
+ synth_1261 synth_12610 synth_12611 synth_12612 synth_12613 synth_12614
+ synth_12615 synth_12616 synth_12617 synth_12618 synth_12619 synth_1262
+ synth_12620 synth_12621 synth_12622 synth_12623 synth_12624 synth_12625
+ synth_12626 synth_12627 synth_12628 synth_12629 synth_1263 synth_12630
+ synth_12631 synth_12632 synth_12633 synth_12634 synth_12635 synth_12636
+ synth_12637 synth_12638 synth_12639 synth_1264 synth_12640 synth_12641
+ synth_12642 synth_12643 synth_12644 synth_12645 synth_12646 synth_12647
+ synth_12648 synth_12649 synth_1265 synth_12650 synth_12651 synth_12652
+ synth_12653 synth_12654 synth_12655 synth_12656 synth_12657 synth_12658
+ synth_12659 synth_1266 synth_12660 synth_12661 synth_12662 synth_12663
+ synth_12664 synth_12665 synth_12666 synth_12667 synth_12668 synth_12669
+ synth_1267 synth_12670 synth_12671 synth_12672 synth_12673 synth_12674
+ synth_12675 synth_12676 synth_12677 synth_12678 synth_12679 synth_1268
+ synth_12680 synth_12681 synth_12682 synth_12683 synth_12684 synth_12685
+ synth_12686 synth_12687 synth_12688 synth_12689 synth_1269 synth_12690
+ synth_12691 synth_12692 synth_12693 synth_12694 synth_12695 synth_12696
+ synth_12697 synth_12698 synth_12699 synth_127 synth_1270 synth_12700
+ synth_12701 synth_12702 synth_12703 synth_12704 synth_12705 synth_12706
+ synth_12707 synth_12708 synth_12709 synth_1271 synth_12710 synth_12711
+ synth_12712 synth_12713 synth_12714 synth_12715 synth_12716 synth_12717
+ synth_12718 synth_12719 synth_1272 synth_12720 synth_12721 synth_12722
+ synth_12723 synth_12724 synth_12725 synth_12726 synth_12727 synth_12728
+ synth_12729 synth_1273 synth_12730 synth_12731 synth_12732 synth_12733
+ synth_12734 synth_12735 synth_12736 synth_12737 synth_12738 synth_12739
+ synth_1274 synth_12740 synth_12741 synth_12742 synth_12743 synth_12744
+ synth_12745 synth_12746 synth_12747 synth_12748 synth_12749 synth_1275
+ synth_12750 synth_12751 synth_12752 synth_12753 synth_12754 synth_12755
+ synth_12756 synth_12757 synth_12758 synth_12759 synth_1276 synth_12760
+ synth_12761 synth_12762 synth_12763 synth_12764 synth_12765 synth_12766
+ synth_12767 synth_12768 synth_12769 synth_1277 synth_12770 synth_12771
+ synth_12772 synth_12773 synth_12774 synth_12775 synth_12776 synth_12777
+ synth_12778 synth_12779 synth_1278 synth_12780 synth_12781 synth_12782
+ synth_12783 synth_12784 synth_12785 synth_12786 synth_12787 synth_12788
+ synth_12789 synth_1279 synth_12790 synth_12791 synth_12792 synth_12793
+ synth_12794 synth_12795 synth_12796 synth_12797 synth_12798 synth_12799
+ synth_128 synth_1280 synth_12800 synth_12801 synth_12802 synth_12803
+ synth_12804 synth_12805 synth_12806 synth_12807 synth_12808 synth_12809
+ synth_1281 synth_12810 synth_12811 synth_12812 synth_12813 synth_12814
+ synth_12815 synth_12816 synth_12817 synth_12818 synth_12819 synth_1282
+ synth_12820 synth_12821 synth_12822 synth_12823 synth_12824 synth_12825
+ synth_12826 synth_12827 synth_12828 synth_12829 synth_1283 synth_12830
+ synth_12831 synth_12832 synth_12833 synth_12834 synth_12835 synth_12836
+ synth_12837 synth_12838 synth_12839 synth_1284 synth_12840 synth_12841
+ synth_12842 synth_12843 synth_12844 synth_12845 synth_12846 synth_12847
+ synth_12848 synth_12849 synth_1285 synth_12850 synth_12851 synth_12852
+ synth_12853 synth_12854 synth_1286 synth_1287 synth_1288 synth_1289 synth_129
+ synth_1290 synth_1291 synth_1292 synth_1293 synth_1294 synth_1295 synth_1296
+ synth_1297 synth_1298 synth_1299 synth_13 synth_130 synth_1300 synth_1301
+ synth_1302 synth_1303 synth_1304 synth_1305 synth_1306 synth_1307 synth_1308
+ synth_1309 synth_131 synth_1310 synth_1311 synth_1312 synth_1313 synth_1314
+ synth_1315 synth_1316 synth_1317 synth_1318 synth_1319 synth_132 synth_1320
+ synth_1321 synth_1322 synth_1323 synth_1324 synth_1325 synth_1326 synth_1327
+ synth_1328 synth_1329 synth_133 synth_1330 synth_1331 synth_1332 synth_1333
+ synth_1334 synth_1335 synth_1336 synth_1337 synth_1338 synth_1339 synth_134
+ synth_1340 synth_1341 synth_1342 synth_1343 synth_1344 synth_1345 synth_1346
+ synth_1347 synth_1348 synth_1349 synth_135 synth_1350 synth_1351 synth_1352
+ synth_1353 synth_1354 synth_1355 synth_1356 synth_1357 synth_1358 synth_1359
+ synth_136 synth_1360 synth_1361 synth_1362 synth_1363 synth_1364 synth_1365
+ synth_1366 synth_1367 synth_1368 synth_1369 synth_137 synth_1370 synth_1371
+ synth_1372 synth_1373 synth_1374 synth_1375 synth_1376 synth_1377 synth_1378
+ synth_1379 synth_138 synth_1380 synth_1381 synth_1382 synth_1383 synth_1384
+ synth_1385 synth_1386 synth_1387 synth_1388 synth_1389 synth_139 synth_1390
+ synth_1391 synth_1392 synth_1393 synth_1394 synth_1395 synth_1396 synth_1397
+ synth_1398 synth_1399 synth_14 synth_140 synth_1400 synth_1401 synth_1402
+ synth_1403 synth_1404 synth_1405 synth_1406 synth_1407 synth_1408 synth_1409
+ synth_141 synth_1410 synth_1411 synth_1412 synth_1413 synth_1414 synth_1415
+ synth_1416 synth_1417 synth_1418 synth_1419 synth_142 synth_1420 synth_1421
+ synth_1422 synth_1423 synth_1424 synth_1425 synth_1426 synth_1427 synth_1428
+ synth_1429 synth_143 synth_1430 synth_1431 synth_1432 synth_1433 synth_1434
+ synth_1435 synth_1436 synth_1437 synth_1438 synth_1439 synth_144 synth_1440
+ synth_1441 synth_1442 synth_1443 synth_1444 synth_1445 synth_1446 synth_1447
+ synth_1448 synth_1449 synth_145 synth_1450 synth_1451 synth_1452 synth_1453
+ synth_1454 synth_1455 synth_1456 synth_1457 synth_1458 synth_1459 synth_146
+ synth_1460 synth_1461 synth_1462 synth_1463 synth_1464 synth_1465 synth_1466
+ synth_1467 synth_1468 synth_1469 synth_147 synth_1470 synth_1471 synth_1472
+ synth_1473 synth_1474 synth_1475 synth_1476 synth_1477 synth_1478 synth_1479
+ synth_148 synth_1480 synth_1481 synth_1482 synth_1483 synth_1484 synth_1485
+ synth_1486 synth_1487 synth_1488 synth_1489 synth_149 synth_1490 synth_1491
+ synth_1492 synth_1493 synth_1494 synth_1495 synth_1496 synth_1497 synth_1498
+ synth_1499 synth_15 synth_150 synth_1500 synth_1501 synth_1502 synth_1503
+ synth_1504 synth_1505 synth_1506 synth_1507 synth_1508 synth_1509 synth_151
+ synth_1510 synth_1511 synth_1512 synth_1513 synth_1514 synth_1515 synth_1516
+ synth_1517 synth_1518 synth_1519 synth_152 synth_1520 synth_1521 synth_1522
+ synth_1523 synth_1524 synth_1525 synth_1526 synth_1527 synth_1528 synth_1529
+ synth_153 synth_1530 synth_1531 synth_1532 synth_1533 synth_1534 synth_1535
+ synth_1536 synth_1537 synth_1538 synth_1539 synth_154 synth_1540 synth_1541
+ synth_1542 synth_1543 synth_1544 synth_1545 synth_1546 synth_1547 synth_1548
+ synth_1549 synth_155 synth_1550 synth_1551 synth_1552 synth_1553 synth_1554
+ synth_1555 synth_1556 synth_1557 synth_1558 synth_1559 synth_156 synth_1560
+ synth_1561 synth_1562 synth_1563 synth_1564 synth_1565 synth_1566 synth_1567
+ synth_1568 synth_1569 synth_157 synth_1570 synth_1571 synth_1572 synth_1573
+ synth_1574 synth_1575 synth_1576 synth_1577 synth_1578 synth_1579 synth_158
+ synth_1580 synth_1581 synth_1582 synth_1583 synth_1584 synth_1585 synth_1586
+ synth_1587 synth_1588 synth_1589 synth_159 synth_1590 synth_1591 synth_1592
+ synth_1593 synth_1594 synth_1595 synth_1596 synth_1597 synth_1598 synth_1599
+ synth_16 synth_160 synth_1600 synth_1601 synth_1602 synth_1603 synth_1604
+ synth_1605 synth_1606 synth_1607 synth_1608 synth_1609 synth_161 synth_1610
+ synth_1611 synth_1612 synth_1613 synth_1614 synth_1615 synth_1616 synth_1617
+ synth_1618 synth_1619 synth_162 synth_1620 synth_1621 synth_1622 synth_1623
+ synth_1624 synth_1625 synth_1626 synth_1627 synth_1628 synth_1629 synth_163
+ synth_1630 synth_1631 synth_1632 synth_1633 synth_1634 synth_1635 synth_1636
+ synth_1637 synth_1638 synth_1639 synth_164 synth_1640 synth_1641 synth_1642
+ synth_1643 synth_1644 synth_1645 synth_1646 synth_1647 synth_1648 synth_1649
+ synth_165 synth_1650 synth_1651 synth_1652 synth_1653 synth_1654 synth_1655
+ synth_1656 synth_1657 synth_1658 synth_1659 synth_166 synth_1660 synth_1661
+ synth_1662 synth_1663 synth_1664 synth_1665 synth_1666 synth_1667 synth_1668
+ synth_1669 synth_167 synth_1670 synth_1671 synth_1672 synth_1673 synth_1674
+ synth_1675 synth_1676 synth_1677 synth_1678 synth_1679 synth_168 synth_1680
+ synth_1681 synth_1682 synth_1683 synth_1684 synth_1685 synth_1686 synth_1687
+ synth_1688 synth_1689 synth_169 synth_1690 synth_1691 synth_1692 synth_1693
+ synth_1694 synth_1695 synth_1696 synth_1697 synth_1698 synth_1699 synth_17
+ synth_170 synth_1700 synth_1701 synth_1702 synth_1703 synth_1704 synth_1705
+ synth_1706 synth_1707 synth_1708 synth_1709 synth_171 synth_1710 synth_1711
+ synth_1712 synth_1713 synth_1714 synth_1715 synth_1716 synth_1717 synth_1718
+ synth_1719 synth_172 synth_1720 synth_1721 synth_1722 synth_1723 synth_1724
+ synth_1725 synth_1726 synth_1727 synth_1728 synth_1729 synth_173 synth_1730
+ synth_1731 synth_1732 synth_1733 synth_1734 synth_1735 synth_1736 synth_1737
+ synth_1738 synth_1739 synth_174 synth_1740 synth_1741 synth_1742 synth_1743
+ synth_1744 synth_1745 synth_1746 synth_1747 synth_1748 synth_1749 synth_175
+ synth_1750 synth_1751 synth_1752 synth_1753 synth_1754 synth_1755 synth_1756
+ synth_1757 synth_1758 synth_1759 synth_176 synth_1760 synth_1761 synth_1762
+ synth_1763 synth_1764 synth_1765 synth_1766 synth_1767 synth_1768 synth_1769
+ synth_177 synth_1770 synth_1771 synth_1772 synth_1773 synth_1774 synth_1775
+ synth_1776 synth_1777 synth_1778 synth_1779 synth_178 synth_1780 synth_1781
+ synth_1782 synth_1783 synth_1784 synth_1785 synth_1786 synth_1787 synth_1788
+ synth_1789 synth_179 synth_1790 synth_1791 synth_1792 synth_1793 synth_1794
+ synth_1795 synth_1796 synth_1797 synth_1798 synth_1799 synth_18 synth_180
+ synth_1800 synth_1801 synth_1802 synth_1803 synth_1804 synth_1805 synth_1806
+ synth_1807 synth_1808 synth_1809 synth_181 synth_1810 synth_1811 synth_1812
+ synth_1813 synth_1814 synth_1815 synth_1816 synth_1817 synth_1818 synth_1819
+ synth_182 synth_1820 synth_1821 synth_1822 synth_1823 synth_1824 synth_1825
+ synth_1826 synth_1827 synth_1828 synth_1829 synth_183 synth_1830 synth_1831
+ synth_1832 synth_1833 synth_1834 synth_1835 synth_1836 synth_1837 synth_1838
+ synth_1839 synth_184 synth_1840 synth_1841 synth_1842 synth_1843 synth_1844
+ synth_1845 synth_1846 synth_1847 synth_1848 synth_1849 synth_185 synth_1850
+ synth_1851 synth_1852 synth_1853 synth_1854 synth_1855 synth_1856 synth_1857
+ synth_1858 synth_1859 synth_186 synth_1860 synth_1861 synth_1862 synth_1863
+ synth_1864 synth_1865 synth_1866 synth_1867 synth_1868 synth_1869 synth_187
+ synth_1870 synth_1871 synth_1872 synth_1873 synth_1874 synth_1875 synth_1876
+ synth_1877 synth_1878 synth_1879 synth_188 synth_1880 synth_1881 synth_1882
+ synth_1883 synth_1884 synth_1885 synth_1886 synth_1887 synth_1888 synth_1889
+ synth_189 synth_1890 synth_1891 synth_1892 synth_1893 synth_1894 synth_1895
+ synth_1896 synth_1897 synth_1898 synth_1899 synth_19 synth_190 synth_1900
+ synth_1901 synth_1902 synth_1903 synth_1904 synth_1905 synth_1906 synth_1907
+ synth_1908 synth_1909 synth_191 synth_1910 synth_1911 synth_1912 synth_1913
+ synth_1914 synth_1915 synth_1916 synth_1917 synth_1918 synth_1919 synth_192
+ synth_1920 synth_1921 synth_1922 synth_1923 synth_1924 synth_1925 synth_1926
+ synth_1927 synth_1928 synth_1929 synth_193 synth_1930 synth_1931 synth_1932
+ synth_1933 synth_1934 synth_1935 synth_1936 synth_1937 synth_1938 synth_1939
+ synth_194 synth_1940 synth_1941 synth_1942 synth_1943 synth_1944 synth_1945
+ synth_1946 synth_1947 synth_1948 synth_1949 synth_195 synth_1950 synth_1951
+ synth_1952 synth_1953 synth_1954 synth_1955 synth_1956 synth_1957 synth_1958
+ synth_1959 synth_196 synth_1960 synth_1961 synth_1962 synth_1963 synth_1964
+ synth_1965 synth_1966 synth_1967 synth_1968 synth_1969 synth_197 synth_1970
+ synth_1971 synth_1972 synth_1973 synth_1974 synth_1975 synth_1976 synth_1977
+ synth_1978 synth_1979 synth_198 synth_1980 synth_1981 synth_1982 synth_1983
+ synth_1984 synth_1985 synth_1986 synth_1987 synth_1988 synth_1989 synth_199
+ synth_1990 synth_1991 synth_1992 synth_1993 synth_1994 synth_1995 synth_1996
+ synth_1997 synth_1998 synth_1999 synth_2 synth_20 synth_200 synth_2000
+ synth_2001 synth_2002 synth_2003 synth_2004 synth_2005 synth_2006 synth_2007
+ synth_2008 synth_2009 synth_201 synth_2010 synth_2011 synth_2012 synth_2013
+ synth_2014 synth_2015 synth_2016 synth_2017 synth_2018 synth_2019 synth_202
+ synth_2020 synth_2021 synth_2022 synth_2023 synth_2024 synth_2025 synth_2026
+ synth_2027 synth_2028 synth_2029 synth_203 synth_2030 synth_2031 synth_2032
+ synth_2033 synth_2034 synth_2035 synth_2036 synth_2037 synth_2038 synth_2039
+ synth_204 synth_2040 synth_2041 synth_2042 synth_2043 synth_2044 synth_2045
+ synth_2046 synth_2047 synth_2048 synth_2049 synth_205 synth_2050 synth_2051
+ synth_2052 synth_2053 synth_2054 synth_2055 synth_2056 synth_2057 synth_2058
+ synth_2059 synth_206 synth_2060 synth_2061 synth_2062 synth_2063 synth_2064
+ synth_2065 synth_2066 synth_2067 synth_2068 synth_2069 synth_207 synth_2070
+ synth_2071 synth_2072 synth_2073 synth_2074 synth_2075 synth_2076 synth_2077
+ synth_2078 synth_2079 synth_208 synth_2080 synth_2081 synth_2082 synth_2083
+ synth_2084 synth_2085 synth_2086 synth_2087 synth_2088 synth_2089 synth_209
+ synth_2090 synth_2091 synth_2092 synth_2093 synth_2094 synth_2095 synth_2096
+ synth_2097 synth_2098 synth_2099 synth_21 synth_210 synth_2100 synth_2101
+ synth_2102 synth_2103 synth_2104 synth_2105 synth_2106 synth_2107 synth_2108
+ synth_2109 synth_211 synth_2110 synth_2111 synth_2112 synth_2113 synth_2114
+ synth_2115 synth_2116 synth_2117 synth_2118 synth_2119 synth_212 synth_2120
+ synth_2121 synth_2122 synth_2123 synth_2124 synth_2125 synth_2126 synth_2127
+ synth_2128 synth_2129 synth_213 synth_2130 synth_2131 synth_2132 synth_2133
+ synth_2134 synth_2135 synth_2136 synth_2137 synth_2138 synth_2139 synth_214
+ synth_2140 synth_2141 synth_2142 synth_2143 synth_2144 synth_2145 synth_2146
+ synth_2147 synth_2148 synth_2149 synth_215 synth_2150 synth_2151 synth_2152
+ synth_2153 synth_2154 synth_2155 synth_2156 synth_2157 synth_2158 synth_2159
+ synth_216 synth_2160 synth_2161 synth_2162 synth_2163 synth_2164 synth_2165
+ synth_2166 synth_2167 synth_2168 synth_2169 synth_217 synth_2170 synth_2171
+ synth_2172 synth_2173 synth_2174 synth_2175 synth_2176 synth_2177 synth_2178
+ synth_2179 synth_218 synth_2180 synth_2181 synth_2182 synth_2183 synth_2184
+ synth_2185 synth_2186 synth_2187 synth_2188 synth_2189 synth_219 synth_2190
+ synth_2191 synth_2192 synth_2193 synth_2194 synth_2195 synth_2196 synth_2197
+ synth_2198 synth_2199 synth_22 synth_220 synth_2200 synth_2201 synth_2202
+ synth_2203 synth_2204 synth_2205 synth_2206 synth_2207 synth_2208 synth_2209
+ synth_221 synth_2210 synth_2211 synth_2212 synth_2213 synth_2214 synth_2215
+ synth_2216 synth_2217 synth_2218 synth_2219 synth_222 synth_2220 synth_2221
+ synth_2222 synth_2223 synth_2224 synth_2225 synth_2226 synth_2227 synth_2228
+ synth_2229 synth_223 synth_2230 synth_2231 synth_2232 synth_2233 synth_2234
+ synth_2235 synth_2236 synth_2237 synth_2238 synth_2239 synth_224 synth_2240
+ synth_2241 synth_2242 synth_2243 synth_2244 synth_2245 synth_2246 synth_2247
+ synth_2248 synth_2249 synth_225 synth_2250 synth_2251 synth_2252 synth_2253
+ synth_2254 synth_2255 synth_2256 synth_2257 synth_2258 synth_2259 synth_226
+ synth_2260 synth_2261 synth_2262 synth_2263 synth_2264 synth_2265 synth_2266
+ synth_2267 synth_2268 synth_2269 synth_227 synth_2270 synth_2271 synth_2272
+ synth_2273 synth_2274 synth_2275 synth_2276 synth_2277 synth_2278 synth_2279
+ synth_228 synth_2280 synth_2281 synth_2282 synth_2283 synth_2284 synth_2285
+ synth_2286 synth_2287 synth_2288 synth_2289 synth_229 synth_2290 synth_2291
+ synth_2292 synth_2293 synth_2294 synth_2295 synth_2296 synth_2297 synth_2298
+ synth_2299 synth_23 synth_230 synth_2300 synth_2301 synth_2302 synth_2303
+ synth_2304 synth_2305 synth_2306 synth_2307 synth_2308 synth_2309 synth_231
+ synth_2310 synth_2311 synth_2312 synth_2313 synth_2314 synth_2315 synth_2316
+ synth_2317 synth_2318 synth_2319 synth_232 synth_2320 synth_2321 synth_2322
+ synth_2323 synth_2324 synth_2325 synth_2326 synth_2327 synth_2328 synth_2329
+ synth_233 synth_2330 synth_2331 synth_2332 synth_2333 synth_2334 synth_2335
+ synth_2336 synth_2337 synth_2338 synth_2339 synth_234 synth_2340 synth_2341
+ synth_2342 synth_2343 synth_2344 synth_2345 synth_2346 synth_2347 synth_2348
+ synth_2349 synth_235 synth_2350 synth_2351 synth_2352 synth_2353 synth_2354
+ synth_2355 synth_2356 synth_2357 synth_2358 synth_2359 synth_236 synth_2360
+ synth_2361 synth_2362 synth_2363 synth_2364 synth_2365 synth_2366 synth_2367
+ synth_2368 synth_2369 synth_237 synth_2370 synth_2371 synth_2372 synth_2373
+ synth_2374 synth_2375 synth_2376 synth_2377 synth_2378 synth_2379 synth_238
+ synth_2380 synth_2381 synth_2382 synth_2383 synth_2384 synth_2385 synth_2386
+ synth_2387 synth_2388 synth_2389 synth_239 synth_2390 synth_2391 synth_2392
+ synth_2393 synth_2394 synth_2395 synth_2396 synth_2397 synth_2398 synth_2399
+ synth_24 synth_240 synth_2400 synth_2401 synth_2402 synth_2403 synth_2404
+ synth_2405 synth_2406 synth_2407 synth_2408 synth_2409 synth_241 synth_2410
+ synth_2411 synth_2412 synth_2413 synth_2414 synth_2415 synth_2416 synth_2417
+ synth_2418 synth_2419 synth_242 synth_2420 synth_2421 synth_2422 synth_2423
+ synth_2424 synth_2425 synth_2426 synth_2427 synth_2428 synth_2429 synth_243
+ synth_2430 synth_2431 synth_2432 synth_2433 synth_2434 synth_2435 synth_2436
+ synth_2437 synth_2438 synth_2439 synth_244 synth_2440 synth_2441 synth_2442
+ synth_2443 synth_2444 synth_2445 synth_2446 synth_2447 synth_2448 synth_2449
+ synth_245 synth_2450 synth_2451 synth_2452 synth_2453 synth_2454 synth_2455
+ synth_2456 synth_2457 synth_2458 synth_2459 synth_246 synth_2460 synth_2461
+ synth_2462 synth_2463 synth_2464 synth_2465 synth_2466 synth_2467 synth_2468
+ synth_2469 synth_247 synth_2470 synth_2471 synth_2472 synth_2473 synth_2474
+ synth_2475 synth_2476 synth_2477 synth_2478 synth_2479 synth_248 synth_2480
+ synth_2481 synth_2482 synth_2483 synth_2484 synth_2485 synth_2486 synth_2487
+ synth_2488 synth_2489 synth_249 synth_2490 synth_2491 synth_2492 synth_2493
+ synth_2494 synth_2495 synth_2496 synth_2497 synth_2498 synth_2499 synth_25
+ synth_250 synth_2500 synth_2501 synth_2502 synth_2503 synth_2504 synth_2505
+ synth_2506 synth_2507 synth_2508 synth_2509 synth_251 synth_2510 synth_2511
+ synth_2512 synth_2513 synth_2514 synth_2515 synth_2516 synth_2517 synth_2518
+ synth_2519 synth_252 synth_2520 synth_2521 synth_2522 synth_2523 synth_2524
+ synth_2525 synth_2526 synth_2527 synth_2528 synth_2529 synth_253 synth_2530
+ synth_2531 synth_2532 synth_2533 synth_2534 synth_2535 synth_2536 synth_2537
+ synth_2538 synth_2539 synth_254 synth_2540 synth_2541 synth_2542 synth_2543
+ synth_2544 synth_2545 synth_2546 synth_2547 synth_2548 synth_2549 synth_255
+ synth_2550 synth_2551 synth_2552 synth_2553 synth_2554 synth_2555 synth_2556
+ synth_2557 synth_2558 synth_2559 synth_256 synth_2560 synth_2561 synth_2562
+ synth_2563 synth_2564 synth_2565 synth_2566 synth_2567 synth_2568 synth_2569
+ synth_257 synth_2570 synth_2571 synth_2572 synth_2573 synth_2574 synth_2575
+ synth_2576 synth_2577 synth_2578 synth_2579 synth_258 synth_2580 synth_2581
+ synth_2582 synth_2583 synth_2584 synth_2585 synth_2586 synth_2587 synth_2588
+ synth_2589 synth_259 synth_2590 synth_2591 synth_2592 synth_2593 synth_2594
+ synth_2595 synth_2596 synth_2597 synth_2598 synth_2599 synth_26 synth_260
+ synth_2600 synth_2601 synth_2602 synth_2603 synth_2604 synth_2605 synth_2606
+ synth_2607 synth_2608 synth_2609 synth_261 synth_2610 synth_2611 synth_2612
+ synth_2613 synth_2614 synth_2615 synth_2616 synth_2617 synth_2618 synth_2619
+ synth_262 synth_2620 synth_2621 synth_2622 synth_2623 synth_2624 synth_2625
+ synth_2626 synth_2627 synth_2628 synth_2629 synth_263 synth_2630 synth_2631
+ synth_2632 synth_2633 synth_2634 synth_2635 synth_2636 synth_2637 synth_2638
+ synth_2639 synth_264 synth_2640 synth_2641 synth_2642 synth_2643 synth_2644
+ synth_2645 synth_2646 synth_2647 synth_2648 synth_2649 synth_265 synth_2650
+ synth_2651 synth_2652 synth_2653 synth_2654 synth_2655 synth_2656 synth_2657
+ synth_2658 synth_2659 synth_266 synth_2660 synth_2661 synth_2662 synth_2663
+ synth_2664 synth_2665 synth_2666 synth_2667 synth_2668 synth_2669 synth_267
+ synth_2670 synth_2671 synth_2672 synth_2673 synth_2674 synth_2675 synth_2676
+ synth_2677 synth_2678 synth_2679 synth_268 synth_2680 synth_2681 synth_2682
+ synth_2683 synth_2684 synth_2685 synth_2686 synth_2687 synth_2688 synth_2689
+ synth_269 synth_2690 synth_2691 synth_2692 synth_2693 synth_2694 synth_2695
+ synth_2696 synth_2697 synth_2698 synth_2699 synth_27 synth_270 synth_2700
+ synth_2701 synth_2702 synth_2703 synth_2704 synth_2705 synth_2706 synth_2707
+ synth_2708 synth_2709 synth_271 synth_2710 synth_2711 synth_2712 synth_2713
+ synth_2714 synth_2715 synth_2716 synth_2717 synth_2718 synth_2719 synth_272
+ synth_2720 synth_2721 synth_2722 synth_2723 synth_2724 synth_2725 synth_2726
+ synth_2727 synth_2728 synth_2729 synth_273 synth_2730 synth_2731 synth_2732
+ synth_2733 synth_2734 synth_2735 synth_2736 synth_2737 synth_2738 synth_2739
+ synth_274 synth_2740 synth_2741 synth_2742 synth_2743 synth_2744 synth_2745
+ synth_2746 synth_2747 synth_2748 synth_2749 synth_275 synth_2750 synth_2751
+ synth_2752 synth_2753 synth_2754 synth_2755 synth_2756 synth_2757 synth_2758
+ synth_2759 synth_276 synth_2760 synth_2761 synth_2762 synth_2763 synth_2764
+ synth_2765 synth_2766 synth_2767 synth_2768 synth_2769 synth_277 synth_2770
+ synth_2771 synth_2772 synth_2773 synth_2774 synth_2775 synth_2776 synth_2777
+ synth_2778 synth_2779 synth_278 synth_2780 synth_2781 synth_2782 synth_2783
+ synth_2784 synth_2785 synth_2786 synth_2787 synth_2788 synth_2789 synth_279
+ synth_2790 synth_2791 synth_2792 synth_2793 synth_2794 synth_2795 synth_2796
+ synth_2797 synth_2798 synth_2799 synth_28 synth_280 synth_2800 synth_2801
+ synth_2802 synth_2803 synth_2804 synth_2805 synth_2806 synth_2807 synth_2808
+ synth_2809 synth_281 synth_2810 synth_2811 synth_2812 synth_2813 synth_2814
+ synth_2815 synth_2816 synth_2817 synth_2818 synth_2819 synth_282 synth_2820
+ synth_2821 synth_2822 synth_2823 synth_2824 synth_2825 synth_2826 synth_2827
+ synth_2828 synth_2829 synth_283 synth_2830 synth_2831 synth_2832 synth_2833
+ synth_2834 synth_2835 synth_2836 synth_2837 synth_2838 synth_2839 synth_284
+ synth_2840 synth_2841 synth_2842 synth_2843 synth_2844 synth_2845 synth_2846
+ synth_2847 synth_2848 synth_2849 synth_285 synth_2850 synth_2851 synth_2852
+ synth_2853 synth_2854 synth_2855 synth_2856 synth_2857 synth_2858 synth_2859
+ synth_286 synth_2860 synth_2861 synth_2862 synth_2863 synth_2864 synth_2865
+ synth_2866 synth_2867 synth_2868 synth_2869 synth_287 synth_2870 synth_2871
+ synth_2872 synth_2873 synth_2874 synth_2875 synth_2876 synth_2877 synth_2878
+ synth_2879 synth_288 synth_2880 synth_2881 synth_2882 synth_2883 synth_2884
+ synth_2885 synth_2886 synth_2887 synth_2888 synth_2889 synth_289 synth_2890
+ synth_2891 synth_2892 synth_2893 synth_2894 synth_2895 synth_2896 synth_2897
+ synth_2898 synth_2899 synth_29 synth_290 synth_2900 synth_2901 synth_2902
+ synth_2903 synth_2904 synth_2905 synth_2906 synth_2907 synth_2908 synth_2909
+ synth_291 synth_2910 synth_2911 synth_2912 synth_2913 synth_2914 synth_2915
+ synth_2916 synth_2917 synth_2918 synth_2919 synth_292 synth_2920 synth_2921
+ synth_2922 synth_2923 synth_2924 synth_2925 synth_2926 synth_2927 synth_2928
+ synth_2929 synth_293 synth_2930 synth_2931 synth_2932 synth_2933 synth_2934
+ synth_2935 synth_2936 synth_2937 synth_2938 synth_2939 synth_294 synth_2940
+ synth_2941 synth_2942 synth_2943 synth_2944 synth_2945 synth_2946 synth_2947
+ synth_2948 synth_2949 synth_295 synth_2950 synth_2951 synth_2952 synth_2953
+ synth_2954 synth_2955 synth_2956 synth_2957 synth_2958 synth_2959 synth_296
+ synth_2960 synth_2961 synth_2962 synth_2963 synth_2964 synth_2965 synth_2966
+ synth_2967 synth_2968 synth_2969 synth_297 synth_2970 synth_2971 synth_2972
+ synth_2973 synth_2974 synth_2975 synth_2976 synth_2977 synth_2978 synth_2979
+ synth_298 synth_2980 synth_2981 synth_2982 synth_2983 synth_2984 synth_2985
+ synth_2986 synth_2987 synth_2988 synth_2989 synth_299 synth_2990 synth_2991
+ synth_2992 synth_2993 synth_2994 synth_2995 synth_2996 synth_2997 synth_2998
+ synth_2999 synth_3 synth_30 synth_300 synth_3000 synth_3001 synth_3002
+ synth_3003 synth_3004 synth_3005 synth_3006 synth_3007 synth_3008 synth_3009
+ synth_301 synth_3010 synth_3011 synth_3012 synth_3013 synth_3014 synth_3015
+ synth_3016 synth_3017 synth_3018 synth_3019 synth_302 synth_3020 synth_3021
+ synth_3022 synth_3023 synth_3024 synth_3025 synth_3026 synth_3027 synth_3028
+ synth_3029 synth_303 synth_3030 synth_3031 synth_3032 synth_3033 synth_3034
+ synth_3035 synth_3036 synth_3037 synth_3038 synth_3039 synth_304 synth_3040
+ synth_3041 synth_3042 synth_3043 synth_3044 synth_3045 synth_3046 synth_3047
+ synth_3048 synth_3049 synth_305 synth_3050 synth_3051 synth_3052 synth_3053
+ synth_3054 synth_3055 synth_3056 synth_3057 synth_3058 synth_3059 synth_306
+ synth_3060 synth_3061 synth_3062 synth_3063 synth_3064 synth_3065 synth_3066
+ synth_3067 synth_3068 synth_3069 synth_307 synth_3070 synth_3071 synth_3072
+ synth_3073 synth_3074 synth_3075 synth_3076 synth_3077 synth_3078 synth_3079
+ synth_308 synth_3080 synth_3081 synth_3082 synth_3083 synth_3084 synth_3085
+ synth_3086 synth_3087 synth_3088 synth_3089 synth_309 synth_3090 synth_3091
+ synth_3092 synth_3093 synth_3094 synth_3095 synth_3096 synth_3097 synth_3098
+ synth_3099 synth_31 synth_310 synth_3100 synth_3101 synth_3102 synth_3103
+ synth_3104 synth_3105 synth_3106 synth_3107 synth_3108 synth_3109 synth_311
+ synth_3110 synth_3111 synth_3112 synth_3113 synth_3114 synth_3115 synth_3116
+ synth_3117 synth_3118 synth_3119 synth_312 synth_3120 synth_3121 synth_3122
+ synth_3123 synth_3124 synth_3125 synth_3126 synth_3127 synth_3128 synth_3129
+ synth_313 synth_3130 synth_3131 synth_3132 synth_3133 synth_3134 synth_3135
+ synth_3136 synth_3137 synth_3138 synth_3139 synth_314 synth_3140 synth_3141
+ synth_3142 synth_3143 synth_3144 synth_3145 synth_3146 synth_3147 synth_3148
+ synth_3149 synth_315 synth_3150 synth_3151 synth_3152 synth_3153 synth_3154
+ synth_3155 synth_3156 synth_3157 synth_3158 synth_3159 synth_316 synth_3160
+ synth_3161 synth_3162 synth_3163 synth_3164 synth_3165 synth_3166 synth_3167
+ synth_3168 synth_3169 synth_317 synth_3170 synth_3171 synth_3172 synth_3173
+ synth_3174 synth_3175 synth_3176 synth_3177 synth_3178 synth_3179 synth_318
+ synth_3180 synth_3181 synth_3182 synth_3183 synth_3184 synth_3185 synth_3186
+ synth_3187 synth_3188 synth_3189 synth_319 synth_3190 synth_3191 synth_3192
+ synth_3193 synth_3194 synth_3195 synth_3196 synth_3197 synth_3198 synth_3199
+ synth_32 synth_320 synth_3200 synth_3201 synth_3202 synth_3203 synth_3204
+ synth_3205 synth_3206 synth_3207 synth_3208 synth_3209 synth_321 synth_3210
+ synth_3211 synth_3212 synth_3213 synth_3214 synth_3215 synth_3216 synth_3217
+ synth_3218 synth_3219 synth_322 synth_3220 synth_3221 synth_3222 synth_3223
+ synth_3224 synth_3225 synth_3226 synth_3227 synth_3228 synth_3229 synth_323
+ synth_3230 synth_3231 synth_3232 synth_3233 synth_3234 synth_3235 synth_3236
+ synth_3237 synth_3238 synth_3239 synth_324 synth_3240 synth_3241 synth_3242
+ synth_3243 synth_3244 synth_3245 synth_3246 synth_3247 synth_3248 synth_3249
+ synth_325 synth_3250 synth_3251 synth_3252 synth_3253 synth_3254 synth_3255
+ synth_3256 synth_3257 synth_3258 synth_3259 synth_326 synth_3260 synth_3261
+ synth_3262 synth_3263 synth_3264 synth_3265 synth_3266 synth_3267 synth_3268
+ synth_3269 synth_327 synth_3270 synth_3271 synth_3272 synth_3273 synth_3274
+ synth_3275 synth_3276 synth_3277 synth_3278 synth_3279 synth_328 synth_3280
+ synth_3281 synth_3282 synth_3283 synth_3284 synth_3285 synth_3286 synth_3287
+ synth_3288 synth_3289 synth_329 synth_3290 synth_3291 synth_3292 synth_3293
+ synth_3294 synth_3295 synth_3296 synth_3297 synth_3298 synth_3299 synth_33
+ synth_330 synth_3300 synth_3301 synth_3302 synth_3303 synth_3304 synth_3305
+ synth_3306 synth_3307 synth_3308 synth_3309 synth_331 synth_3310 synth_3311
+ synth_3312 synth_3313 synth_3314 synth_3315 synth_3316 synth_3317 synth_3318
+ synth_3319 synth_332 synth_3320 synth_3321 synth_3322 synth_3323 synth_3324
+ synth_3325 synth_3326 synth_3327 synth_3328 synth_3329 synth_333 synth_3330
+ synth_3331 synth_3332 synth_3333 synth_3334 synth_3335 synth_3336 synth_3337
+ synth_3338 synth_3339 synth_334 synth_3340 synth_3341 synth_3342 synth_3343
+ synth_3344 synth_3345 synth_3346 synth_3347 synth_3348 synth_3349 synth_335
+ synth_3350 synth_3351 synth_3352 synth_3353 synth_3354 synth_3355 synth_3356
+ synth_3357 synth_3358 synth_3359 synth_336 synth_3360 synth_3361 synth_3362
+ synth_3363 synth_3364 synth_3365 synth_3366 synth_3367 synth_3368 synth_3369
+ synth_337 synth_3370 synth_3371 synth_3372 synth_3373 synth_3374 synth_3375
+ synth_3376 synth_3377 synth_3378 synth_3379 synth_338 synth_3380 synth_3381
+ synth_3382 synth_3383 synth_3384 synth_3385 synth_3386 synth_3387 synth_3388
+ synth_3389 synth_339 synth_3390 synth_3391 synth_3392 synth_3393 synth_3394
+ synth_3395 synth_3396 synth_3397 synth_3398 synth_3399 synth_34 synth_340
+ synth_3400 synth_3401 synth_3402 synth_3403 synth_3404 synth_3405 synth_3406
+ synth_3407 synth_3408 synth_3409 synth_341 synth_3410 synth_3411 synth_3412
+ synth_3413 synth_3414 synth_3415 synth_3416 synth_3417 synth_3418 synth_3419
+ synth_342 synth_3420 synth_3421 synth_3422 synth_3423 synth_3424 synth_3425
+ synth_3426 synth_3427 synth_3428 synth_3429 synth_343 synth_3430 synth_3431
+ synth_3432 synth_3433 synth_3434 synth_3435 synth_3436 synth_3437 synth_3438
+ synth_3439 synth_344 synth_3440 synth_3441 synth_3442 synth_3443 synth_3444
+ synth_3445 synth_3446 synth_3447 synth_3448 synth_3449 synth_345 synth_3450
+ synth_3451 synth_3452 synth_3453 synth_3454 synth_3455 synth_3456 synth_3457
+ synth_3458 synth_3459 synth_346 synth_3460 synth_3461 synth_3462 synth_3463
+ synth_3464 synth_3465 synth_3466 synth_3467 synth_3468 synth_3469 synth_347
+ synth_3470 synth_3471 synth_3472 synth_3473 synth_3474 synth_3475 synth_3476
+ synth_3477 synth_3478 synth_3479 synth_348 synth_3480 synth_3481 synth_3482
+ synth_3483 synth_3484 synth_3485 synth_3486 synth_3487 synth_3488 synth_3489
+ synth_349 synth_3490 synth_3491 synth_3492 synth_3493 synth_3494 synth_3495
+ synth_3496 synth_3497 synth_3498 synth_3499 synth_35 synth_350 synth_3500
+ synth_3501 synth_3502 synth_3503 synth_3504 synth_3505 synth_3506 synth_3507
+ synth_3508 synth_3509 synth_351 synth_3510 synth_3511 synth_3512 synth_3513
+ synth_3514 synth_3515 synth_3516 synth_3517 synth_3518 synth_3519 synth_352
+ synth_3520 synth_3521 synth_3522 synth_3523 synth_3524 synth_3525 synth_3526
+ synth_3527 synth_3528 synth_3529 synth_353 synth_3530 synth_3531 synth_3532
+ synth_3533 synth_3534 synth_3535 synth_3536 synth_3537 synth_3538 synth_3539
+ synth_354 synth_3540 synth_3541 synth_3542 synth_3543 synth_3544 synth_3545
+ synth_3546 synth_3547 synth_3548 synth_3549 synth_355 synth_3550 synth_3551
+ synth_3552 synth_3553 synth_3554 synth_3555 synth_3556 synth_3557 synth_3558
+ synth_3559 synth_356 synth_3560 synth_3561 synth_3562 synth_3563 synth_3564
+ synth_3565 synth_3566 synth_3567 synth_3568 synth_3569 synth_357 synth_3570
+ synth_3571 synth_3572 synth_3573 synth_3574 synth_3575 synth_3576 synth_3577
+ synth_3578 synth_3579 synth_358 synth_3580 synth_3581 synth_3582 synth_3583
+ synth_3584 synth_3585 synth_3586 synth_3587 synth_3588 synth_3589 synth_359
+ synth_3590 synth_3591 synth_3592 synth_3593 synth_3594 synth_3595 synth_3596
+ synth_3597 synth_3598 synth_3599 synth_36 synth_360 synth_3600 synth_3601
+ synth_3602 synth_3603 synth_3604 synth_3605 synth_3606 synth_3607 synth_3608
+ synth_3609 synth_361 synth_3610 synth_3611 synth_3612 synth_3613 synth_3614
+ synth_3615 synth_3616 synth_3617 synth_3618 synth_3619 synth_362 synth_3620
+ synth_3621 synth_3622 synth_3623 synth_3624 synth_3625 synth_3626 synth_3627
+ synth_3628 synth_3629 synth_363 synth_3630 synth_3631 synth_3632 synth_3633
+ synth_3634 synth_3635 synth_3636 synth_3637 synth_3638 synth_3639 synth_364
+ synth_3640 synth_3641 synth_3642 synth_3643 synth_3644 synth_3645 synth_3646
+ synth_3647 synth_3648 synth_3649 synth_365 synth_3650 synth_3651 synth_3652
+ synth_3653 synth_3654 synth_3655 synth_3656 synth_3657 synth_3658 synth_3659
+ synth_366 synth_3660 synth_3661 synth_3662 synth_3663 synth_3664 synth_3665
+ synth_3666 synth_3667 synth_3668 synth_3669 synth_367 synth_3670 synth_3671
+ synth_3672 synth_3673 synth_3674 synth_3675 synth_3676 synth_3677 synth_3678
+ synth_3679 synth_368 synth_3680 synth_3681 synth_3682 synth_3683 synth_3684
+ synth_3685 synth_3686 synth_3687 synth_3688 synth_3689 synth_369 synth_3690
+ synth_3691 synth_3692 synth_3693 synth_3694 synth_3695 synth_3696 synth_3697
+ synth_3698 synth_3699 synth_37 synth_370 synth_3700 synth_3701 synth_3702
+ synth_3703 synth_3704 synth_3705 synth_3706 synth_3707 synth_3708 synth_3709
+ synth_371 synth_3710 synth_3711 synth_3712 synth_3713 synth_3714 synth_3715
+ synth_3716 synth_3717 synth_3718 synth_3719 synth_372 synth_3720 synth_3721
+ synth_3722 synth_3723 synth_3724 synth_3725 synth_3726 synth_3727 synth_3728
+ synth_3729 synth_373 synth_3730 synth_3731 synth_3732 synth_3733 synth_3734
+ synth_3735 synth_3736 synth_3737 synth_3738 synth_3739 synth_374 synth_3740
+ synth_3741 synth_3742 synth_3743 synth_3745 synth_3746 synth_3747 synth_3748
+ synth_3749 synth_375 synth_3750 synth_3751 synth_3752 synth_3753 synth_3754
+ synth_3755 synth_3756 synth_3757 synth_3758 synth_3759 synth_376 synth_3760
+ synth_3761 synth_3762 synth_3763 synth_3764 synth_3765 synth_3766 synth_3767
+ synth_3768 synth_3769 synth_377 synth_3770 synth_3771 synth_3772 synth_3773
+ synth_3774 synth_3775 synth_3776 synth_3777 synth_3778 synth_3779 synth_378
+ synth_3780 synth_3781 synth_3782 synth_3783 synth_3784 synth_3785 synth_3786
+ synth_3787 synth_3788 synth_3789 synth_379 synth_3790 synth_3791 synth_3792
+ synth_3793 synth_3794 synth_3795 synth_3796 synth_3797 synth_3798 synth_3799
+ synth_38 synth_380 synth_3800 synth_3801 synth_3802 synth_3803 synth_3804
+ synth_3805 synth_3806 synth_3807 synth_3808 synth_3809 synth_381 synth_3810
+ synth_3811 synth_3812 synth_3813 synth_3814 synth_3815 synth_3816 synth_3817
+ synth_3818 synth_3819 synth_382 synth_3820 synth_3821 synth_3822 synth_3823
+ synth_3824 synth_3825 synth_3826 synth_3827 synth_3828 synth_3829 synth_383
+ synth_3830 synth_3831 synth_3832 synth_3833 synth_3834 synth_3835 synth_3836
+ synth_3837 synth_3838 synth_3839 synth_384 synth_3840 synth_3841 synth_3842
+ synth_3843 synth_3844 synth_3845 synth_3846 synth_3847 synth_3848 synth_3849
+ synth_385 synth_3850 synth_3851 synth_3852 synth_3853 synth_3854 synth_3855
+ synth_3856 synth_3857 synth_3858 synth_3859 synth_386 synth_3860 synth_3861
+ synth_3862 synth_3863 synth_3864 synth_3865 synth_3866 synth_3867 synth_3868
+ synth_3869 synth_387 synth_3870 synth_3871 synth_3872 synth_3873 synth_3874
+ synth_3875 synth_3876 synth_3877 synth_3878 synth_3879 synth_388 synth_3880
+ synth_3881 synth_3882 synth_3883 synth_3884 synth_3885 synth_3886 synth_3887
+ synth_3888 synth_3889 synth_389 synth_3890 synth_3891 synth_3892 synth_3893
+ synth_3894 synth_3895 synth_3896 synth_3897 synth_3898 synth_3899 synth_39
+ synth_390 synth_3900 synth_3901 synth_3902 synth_3903 synth_3904 synth_3905
+ synth_3906 synth_3907 synth_3908 synth_3909 synth_391 synth_3910 synth_3911
+ synth_3912 synth_3913 synth_3914 synth_3915 synth_3916 synth_3917 synth_3918
+ synth_3919 synth_392 synth_3920 synth_3921 synth_3922 synth_3923 synth_3924
+ synth_3925 synth_3926 synth_3927 synth_3928 synth_3929 synth_393 synth_3930
+ synth_3931 synth_3932 synth_3933 synth_3934 synth_3935 synth_3936 synth_3937
+ synth_3938 synth_3939 synth_394 synth_3940 synth_3941 synth_3942 synth_3943
+ synth_3944 synth_3945 synth_3946 synth_3947 synth_3948 synth_3949 synth_395
+ synth_3950 synth_3951 synth_3952 synth_3953 synth_3954 synth_3955 synth_3956
+ synth_3957 synth_3958 synth_3959 synth_396 synth_3960 synth_3961 synth_3962
+ synth_3963 synth_3964 synth_3965 synth_3966 synth_3967 synth_3968 synth_3969
+ synth_397 synth_3970 synth_3971 synth_3972 synth_3973 synth_3974 synth_3975
+ synth_3976 synth_3977 synth_3978 synth_3979 synth_398 synth_3980 synth_3981
+ synth_3982 synth_3983 synth_3984 synth_3985 synth_3986 synth_3987 synth_3988
+ synth_3989 synth_399 synth_3990 synth_3991 synth_3992 synth_3993 synth_3994
+ synth_3995 synth_3996 synth_3997 synth_3998 synth_3999 synth_4 synth_40
+ synth_400 synth_4000 synth_4001 synth_4002 synth_4003 synth_4004 synth_4005
+ synth_4006 synth_4007 synth_4008 synth_4009 synth_401 synth_4010 synth_4011
+ synth_4012 synth_4013 synth_4014 synth_4015 synth_4016 synth_4017 synth_4018
+ synth_4019 synth_402 synth_4020 synth_4021 synth_4022 synth_4023 synth_4024
+ synth_4025 synth_4026 synth_4027 synth_4028 synth_4029 synth_403 synth_4030
+ synth_4031 synth_4032 synth_4033 synth_4034 synth_4035 synth_4036 synth_4037
+ synth_4038 synth_4039 synth_404 synth_4040 synth_4041 synth_4042 synth_4043
+ synth_4044 synth_4045 synth_4046 synth_4047 synth_4048 synth_4049 synth_405
+ synth_4050 synth_4051 synth_4052 synth_4053 synth_4054 synth_4055 synth_4056
+ synth_4057 synth_4058 synth_4059 synth_406 synth_4060 synth_4061 synth_4062
+ synth_4063 synth_4064 synth_4065 synth_4066 synth_4067 synth_4068 synth_4069
+ synth_407 synth_4070 synth_4071 synth_4072 synth_4073 synth_4074 synth_4075
+ synth_4076 synth_4077 synth_4078 synth_4079 synth_408 synth_4080 synth_4081
+ synth_4082 synth_4083 synth_4084 synth_4085 synth_4086 synth_4087 synth_4088
+ synth_4089 synth_409 synth_4090 synth_4091 synth_4092 synth_4093 synth_4094
+ synth_4095 synth_4096 synth_4097 synth_4098 synth_4099 synth_41 synth_410
+ synth_4100 synth_4101 synth_4102 synth_4103 synth_4104 synth_4105 synth_4106
+ synth_4107 synth_4108 synth_4109 synth_411 synth_4110 synth_4111 synth_4112
+ synth_4113 synth_4114 synth_4115 synth_4116 synth_4117 synth_4118 synth_4119
+ synth_412 synth_4120 synth_4121 synth_4122 synth_4123 synth_4124 synth_4125
+ synth_4126 synth_4127 synth_4128 synth_4129 synth_413 synth_4130 synth_4131
+ synth_4132 synth_4133 synth_4134 synth_4135 synth_4136 synth_4137 synth_4138
+ synth_4139 synth_414 synth_4140 synth_4141 synth_4142 synth_4143 synth_4144
+ synth_4145 synth_4146 synth_4147 synth_4148 synth_4149 synth_415 synth_4150
+ synth_4151 synth_4152 synth_4153 synth_4154 synth_4155 synth_4156 synth_4157
+ synth_4158 synth_4159 synth_416 synth_4160 synth_4161 synth_4162 synth_4163
+ synth_4164 synth_4165 synth_4166 synth_4167 synth_4168 synth_417 synth_4170
+ synth_4171 synth_4172 synth_4173 synth_4174 synth_4175 synth_4176 synth_4177
+ synth_4178 synth_4179 synth_418 synth_4180 synth_4181 synth_4182 synth_4183
+ synth_4184 synth_4185 synth_4186 synth_4187 synth_4188 synth_4189 synth_419
+ synth_4190 synth_4191 synth_4192 synth_4193 synth_4194 synth_4195 synth_4196
+ synth_4197 synth_4198 synth_4199 synth_42 synth_420 synth_4200 synth_4201
+ synth_4202 synth_4203 synth_4204 synth_4205 synth_4206 synth_4207 synth_4208
+ synth_4209 synth_421 synth_4210 synth_4211 synth_4212 synth_4213 synth_4214
+ synth_4215 synth_4216 synth_4217 synth_4218 synth_4219 synth_422 synth_4220
+ synth_4221 synth_4222 synth_4223 synth_4224 synth_4225 synth_4226 synth_4227
+ synth_4228 synth_4229 synth_423 synth_4230 synth_4231 synth_4232 synth_4233
+ synth_4234 synth_4235 synth_4236 synth_4237 synth_4238 synth_4239 synth_424
+ synth_4240 synth_4241 synth_4242 synth_4243 synth_4244 synth_4245 synth_4246
+ synth_4247 synth_4248 synth_4249 synth_425 synth_4250 synth_4251 synth_4252
+ synth_4253 synth_4254 synth_4255 synth_4256 synth_4257 synth_4258 synth_4259
+ synth_426 synth_4260 synth_4261 synth_4262 synth_4263 synth_4264 synth_4265
+ synth_4266 synth_4267 synth_4268 synth_4269 synth_427 synth_4270 synth_4271
+ synth_4272 synth_4274 synth_4275 synth_4276 synth_4277 synth_4278 synth_428
+ synth_4280 synth_4281 synth_4282 synth_4283 synth_4284 synth_4285 synth_4286
+ synth_4287 synth_4288 synth_4289 synth_429 synth_4290 synth_4291 synth_4292
+ synth_4293 synth_4294 synth_4295 synth_4296 synth_4297 synth_4298 synth_4299
+ synth_43 synth_430 synth_4300 synth_4301 synth_4302 synth_4303 synth_4304
+ synth_4305 synth_4306 synth_4307 synth_4308 synth_4309 synth_431 synth_4310
+ synth_4311 synth_4312 synth_4313 synth_4314 synth_4315 synth_4316 synth_4317
+ synth_4318 synth_4319 synth_432 synth_4320 synth_4321 synth_4322 synth_4323
+ synth_4324 synth_4325 synth_4326 synth_4327 synth_4328 synth_4329 synth_433
+ synth_4330 synth_4331 synth_4332 synth_4333 synth_4334 synth_4335 synth_4336
+ synth_4337 synth_4338 synth_4339 synth_434 synth_4340 synth_4341 synth_4342
+ synth_4343 synth_4344 synth_4345 synth_4346 synth_4347 synth_4348 synth_4349
+ synth_435 synth_4350 synth_4351 synth_4352 synth_4353 synth_4354 synth_4355
+ synth_4356 synth_4357 synth_4358 synth_4359 synth_436 synth_4360 synth_4361
+ synth_4362 synth_4363 synth_4364 synth_4365 synth_4366 synth_4367 synth_4368
+ synth_4369 synth_437 synth_4370 synth_4371 synth_4372 synth_4373 synth_4374
+ synth_4375 synth_4376 synth_4377 synth_4378 synth_4379 synth_438 synth_4380
+ synth_4381 synth_4382 synth_4383 synth_4384 synth_4385 synth_4386 synth_4387
+ synth_4388 synth_4389 synth_439 synth_4390 synth_4391 synth_4392 synth_4393
+ synth_4394 synth_4395 synth_4396 synth_4397 synth_4398 synth_4399 synth_44
+ synth_440 synth_4400 synth_4401 synth_4402 synth_4403 synth_4404 synth_4405
+ synth_4406 synth_4407 synth_4408 synth_4409 synth_441 synth_4410 synth_4411
+ synth_4412 synth_4413 synth_4414 synth_4415 synth_4416 synth_4417 synth_4418
+ synth_4419 synth_442 synth_4420 synth_4421 synth_4422 synth_4423 synth_4424
+ synth_4425 synth_4426 synth_4427 synth_4428 synth_4429 synth_443 synth_4430
+ synth_4431 synth_4432 synth_4433 synth_4434 synth_4435 synth_4436 synth_4437
+ synth_4438 synth_4439 synth_444 synth_4440 synth_4441 synth_4442 synth_4443
+ synth_4444 synth_4445 synth_4446 synth_4447 synth_4448 synth_4449 synth_445
+ synth_4450 synth_4451 synth_4452 synth_4453 synth_4454 synth_4455 synth_4456
+ synth_4457 synth_4458 synth_4459 synth_446 synth_4460 synth_4461 synth_4462
+ synth_4463 synth_4464 synth_4465 synth_4466 synth_4467 synth_4468 synth_4469
+ synth_447 synth_4470 synth_4471 synth_4472 synth_4473 synth_4474 synth_4475
+ synth_4476 synth_4477 synth_4478 synth_4479 synth_448 synth_4480 synth_4481
+ synth_4482 synth_4483 synth_4484 synth_4485 synth_4486 synth_4487 synth_4488
+ synth_4489 synth_449 synth_4490 synth_4491 synth_4492 synth_4493 synth_4494
+ synth_4495 synth_4496 synth_4497 synth_4498 synth_4499 synth_45 synth_450
+ synth_4500 synth_4501 synth_4502 synth_4503 synth_4504 synth_4505 synth_4506
+ synth_4507 synth_4508 synth_4509 synth_451 synth_4510 synth_4511 synth_4512
+ synth_4513 synth_4514 synth_4515 synth_4516 synth_4517 synth_4518 synth_4519
+ synth_452 synth_4520 synth_4521 synth_4522 synth_4523 synth_4524 synth_4525
+ synth_4526 synth_4527 synth_4528 synth_4529 synth_453 synth_4530 synth_4531
+ synth_4532 synth_4533 synth_4534 synth_4535 synth_4536 synth_4537 synth_4538
+ synth_4539 synth_454 synth_4540 synth_4541 synth_4542 synth_4543 synth_4544
+ synth_4545 synth_4546 synth_4547 synth_4548 synth_4549 synth_455 synth_4550
+ synth_4551 synth_4552 synth_4553 synth_4554 synth_4555 synth_4556 synth_4557
+ synth_4558 synth_4559 synth_456 synth_4560 synth_4561 synth_4562 synth_4563
+ synth_4564 synth_4565 synth_4566 synth_4567 synth_4568 synth_4569 synth_457
+ synth_4570 synth_4571 synth_4572 synth_4573 synth_4574 synth_4575 synth_4576
+ synth_4577 synth_4578 synth_4579 synth_458 synth_4580 synth_4581 synth_4582
+ synth_4583 synth_4584 synth_4585 synth_4586 synth_4587 synth_4588 synth_4589
+ synth_459 synth_4590 synth_4591 synth_4592 synth_4593 synth_4594 synth_4595
+ synth_4596 synth_4597 synth_4598 synth_4599 synth_46 synth_460 synth_4600
+ synth_4601 synth_4602 synth_4603 synth_4604 synth_4605 synth_4606 synth_4607
+ synth_4608 synth_4609 synth_461 synth_4610 synth_4611 synth_4612 synth_4613
+ synth_4614 synth_4615 synth_4616 synth_4617 synth_4618 synth_4619 synth_462
+ synth_4620 synth_4621 synth_4622 synth_4623 synth_4624 synth_4625 synth_4626
+ synth_4627 synth_4628 synth_4629 synth_463 synth_4630 synth_4631 synth_4632
+ synth_4633 synth_4634 synth_4635 synth_4636 synth_4637 synth_4638 synth_4639
+ synth_464 synth_4640 synth_4641 synth_4642 synth_4643 synth_4644 synth_4645
+ synth_4646 synth_4647 synth_4648 synth_4649 synth_465 synth_4650 synth_4651
+ synth_4652 synth_4653 synth_4655 synth_4656 synth_4657 synth_4658 synth_4659
+ synth_466 synth_4660 synth_4661 synth_4662 synth_4663 synth_4664 synth_4665
+ synth_4666 synth_4667 synth_4668 synth_467 synth_4670 synth_4671 synth_4672
+ synth_4673 synth_4674 synth_4675 synth_4676 synth_4677 synth_4678 synth_4679
+ synth_468 synth_4680 synth_4681 synth_4682 synth_4683 synth_4684 synth_4685
+ synth_4686 synth_4687 synth_4688 synth_4689 synth_469 synth_4690 synth_4691
+ synth_4692 synth_4693 synth_4694 synth_4695 synth_4696 synth_4697 synth_4698
+ synth_4699 synth_47 synth_470 synth_4700 synth_4701 synth_4702 synth_4703
+ synth_4704 synth_4705 synth_4706 synth_4707 synth_4708 synth_4709 synth_471
+ synth_4710 synth_4711 synth_4712 synth_4713 synth_4714 synth_4715 synth_4716
+ synth_4717 synth_4718 synth_4719 synth_472 synth_4720 synth_4721 synth_4722
+ synth_4723 synth_4724 synth_4725 synth_4726 synth_4727 synth_4728 synth_4729
+ synth_473 synth_4730 synth_4731 synth_4732 synth_4733 synth_4734 synth_4735
+ synth_4736 synth_4737 synth_4738 synth_4739 synth_474 synth_4740 synth_4741
+ synth_4742 synth_4743 synth_4744 synth_4745 synth_4746 synth_4747 synth_4748
+ synth_4749 synth_475 synth_4750 synth_4751 synth_4752 synth_4753 synth_4754
+ synth_4755 synth_4756 synth_4757 synth_4758 synth_4759 synth_476 synth_4760
+ synth_4761 synth_4762 synth_4763 synth_4764 synth_4765 synth_4766 synth_4767
+ synth_4768 synth_4769 synth_477 synth_4770 synth_4771 synth_4772 synth_4773
+ synth_4774 synth_4775 synth_4776 synth_4777 synth_4778 synth_4779 synth_478
+ synth_4780 synth_4781 synth_4782 synth_4783 synth_4784 synth_4785 synth_4786
+ synth_4787 synth_4788 synth_4789 synth_479 synth_4790 synth_4791 synth_4792
+ synth_4793 synth_4794 synth_4795 synth_4796 synth_4797 synth_4798 synth_4799
+ synth_48 synth_480 synth_4800 synth_4801 synth_4802 synth_4803 synth_4804
+ synth_4805 synth_4806 synth_4807 synth_4808 synth_4809 synth_481 synth_4810
+ synth_4811 synth_4812 synth_4813 synth_4814 synth_4815 synth_4816 synth_4817
+ synth_4818 synth_4819 synth_482 synth_4820 synth_4821 synth_4822 synth_4823
+ synth_4824 synth_4825 synth_4826 synth_4827 synth_4828 synth_4829 synth_483
+ synth_4830 synth_4831 synth_4832 synth_4833 synth_4834 synth_4835 synth_4836
+ synth_4837 synth_4838 synth_4839 synth_484 synth_4840 synth_4841 synth_4842
+ synth_4843 synth_4844 synth_4845 synth_4846 synth_4847 synth_4848 synth_4849
+ synth_485 synth_4850 synth_4851 synth_4852 synth_4853 synth_4854 synth_4855
+ synth_4856 synth_4857 synth_4858 synth_4859 synth_486 synth_4860 synth_4861
+ synth_4862 synth_4863 synth_4864 synth_4865 synth_4866 synth_4867 synth_4868
+ synth_4869 synth_487 synth_4870 synth_4871 synth_4872 synth_4873 synth_4874
+ synth_4875 synth_4876 synth_4877 synth_4878 synth_4879 synth_488 synth_4880
+ synth_4881 synth_4882 synth_4883 synth_4884 synth_4885 synth_4886 synth_4887
+ synth_4888 synth_4889 synth_489 synth_4890 synth_4891 synth_4892 synth_4893
+ synth_4894 synth_4895 synth_4896 synth_4897 synth_4898 synth_4899 synth_49
+ synth_490 synth_4900 synth_4901 synth_4902 synth_4903 synth_4904 synth_4905
+ synth_4906 synth_4907 synth_4908 synth_4909 synth_491 synth_4910 synth_4911
+ synth_4912 synth_4913 synth_4914 synth_4915 synth_4916 synth_4917 synth_4918
+ synth_4919 synth_492 synth_4920 synth_4921 synth_4922 synth_4923 synth_4924
+ synth_4925 synth_4926 synth_4927 synth_4928 synth_4929 synth_493 synth_4930
+ synth_4931 synth_4932 synth_4933 synth_4934 synth_4935 synth_4936 synth_4937
+ synth_4938 synth_4939 synth_494 synth_4940 synth_4941 synth_4942 synth_4943
+ synth_4944 synth_4945 synth_4946 synth_4947 synth_4948 synth_4949 synth_495
+ synth_4950 synth_4951 synth_4952 synth_4953 synth_4954 synth_4955 synth_4956
+ synth_4957 synth_4958 synth_4959 synth_496 synth_4960 synth_4961 synth_4962
+ synth_4963 synth_4964 synth_4965 synth_4966 synth_4967 synth_4968 synth_4969
+ synth_497 synth_4970 synth_4971 synth_4972 synth_4973 synth_4974 synth_4975
+ synth_4976 synth_4977 synth_4978 synth_4979 synth_498 synth_4980 synth_4981
+ synth_4982 synth_4983 synth_4984 synth_4985 synth_4986 synth_4987 synth_4988
+ synth_4989 synth_499 synth_4990 synth_4992 synth_4993 synth_4994 synth_4995
+ synth_4996 synth_4997 synth_4998 synth_4999 synth_5 synth_50 synth_500
+ synth_5000 synth_5001 synth_5002 synth_5003 synth_5004 synth_5005 synth_5006
+ synth_5007 synth_5008 synth_5009 synth_501 synth_5010 synth_5011 synth_5012
+ synth_5013 synth_5014 synth_5015 synth_5016 synth_5017 synth_5018 synth_5019
+ synth_502 synth_5020 synth_5021 synth_5022 synth_5023 synth_5024 synth_5025
+ synth_5026 synth_5027 synth_5028 synth_5029 synth_503 synth_5030 synth_5031
+ synth_5032 synth_5033 synth_5034 synth_5035 synth_5036 synth_5037 synth_5038
+ synth_5039 synth_504 synth_5040 synth_5041 synth_5042 synth_5043 synth_5044
+ synth_5045 synth_5046 synth_5047 synth_5048 synth_5049 synth_505 synth_5050
+ synth_5051 synth_5052 synth_5053 synth_5054 synth_5055 synth_5056 synth_5057
+ synth_5058 synth_5059 synth_506 synth_5060 synth_5061 synth_5062 synth_5063
+ synth_5064 synth_5065 synth_5066 synth_5067 synth_5068 synth_5069 synth_507
+ synth_5070 synth_5071 synth_5072 synth_5073 synth_5074 synth_5075 synth_5076
+ synth_5077 synth_5078 synth_5079 synth_508 synth_5080 synth_5081 synth_5082
+ synth_5083 synth_5084 synth_5085 synth_5086 synth_5087 synth_5088 synth_5089
+ synth_509 synth_5090 synth_5091 synth_5092 synth_5093 synth_5094 synth_5095
+ synth_5096 synth_5097 synth_5098 synth_5099 synth_51 synth_510 synth_5100
+ synth_5101 synth_5102 synth_5103 synth_5104 synth_5105 synth_5106 synth_5107
+ synth_5108 synth_5109 synth_511 synth_5110 synth_5111 synth_5112 synth_5113
+ synth_5114 synth_5115 synth_5116 synth_5117 synth_5118 synth_5119 synth_512
+ synth_5120 synth_5121 synth_5122 synth_5123 synth_5124 synth_5125 synth_5126
+ synth_5127 synth_5128 synth_5129 synth_513 synth_5130 synth_5131 synth_5132
+ synth_5133 synth_5134 synth_5135 synth_5136 synth_5137 synth_5138 synth_5139
+ synth_514 synth_5140 synth_5141 synth_5142 synth_5143 synth_5144 synth_5145
+ synth_5146 synth_5147 synth_5148 synth_5149 synth_515 synth_5150 synth_5151
+ synth_5152 synth_5153 synth_5154 synth_5155 synth_5156 synth_5157 synth_5158
+ synth_5159 synth_516 synth_5160 synth_5161 synth_5162 synth_5163 synth_5164
+ synth_5165 synth_5166 synth_5167 synth_5168 synth_5169 synth_517 synth_5170
+ synth_5171 synth_5172 synth_5173 synth_5174 synth_5175 synth_5176 synth_5177
+ synth_5178 synth_5179 synth_518 synth_5180 synth_5181 synth_5182 synth_5183
+ synth_5184 synth_5185 synth_5186 synth_5187 synth_5188 synth_5189 synth_519
+ synth_5190 synth_5191 synth_5192 synth_5193 synth_5194 synth_5195 synth_5196
+ synth_5197 synth_5198 synth_5199 synth_52 synth_520 synth_5200 synth_5201
+ synth_5202 synth_5203 synth_5204 synth_5205 synth_5206 synth_5207 synth_5208
+ synth_5209 synth_521 synth_5210 synth_5211 synth_5212 synth_5213 synth_5214
+ synth_5215 synth_5216 synth_5217 synth_5218 synth_5219 synth_522 synth_5220
+ synth_5221 synth_5222 synth_5223 synth_5224 synth_5225 synth_5226 synth_5227
+ synth_5228 synth_5229 synth_523 synth_5230 synth_5231 synth_5232 synth_5233
+ synth_5234 synth_5235 synth_5236 synth_5237 synth_5238 synth_5239 synth_524
+ synth_5240 synth_5241 synth_5242 synth_5243 synth_5244 synth_5245 synth_5246
+ synth_5247 synth_5248 synth_5249 synth_525 synth_5250 synth_5251 synth_5252
+ synth_5253 synth_5254 synth_5255 synth_5256 synth_5257 synth_5258 synth_5259
+ synth_526 synth_5260 synth_5261 synth_5262 synth_5263 synth_5264 synth_5265
+ synth_5266 synth_5267 synth_5268 synth_5269 synth_527 synth_5270 synth_5271
+ synth_5272 synth_5273 synth_5274 synth_5275 synth_5276 synth_5277 synth_5278
+ synth_5279 synth_528 synth_5280 synth_5281 synth_5282 synth_5283 synth_5284
+ synth_5285 synth_5286 synth_5287 synth_5288 synth_5289 synth_529 synth_5290
+ synth_5291 synth_5292 synth_5293 synth_5294 synth_5295 synth_5296 synth_5297
+ synth_5298 synth_5299 synth_53 synth_530 synth_5300 synth_5301 synth_5302
+ synth_5303 synth_5304 synth_5305 synth_5306 synth_5307 synth_5308 synth_5309
+ synth_531 synth_5310 synth_5311 synth_5312 synth_5313 synth_5314 synth_5315
+ synth_5316 synth_5317 synth_5318 synth_5319 synth_532 synth_5320 synth_5321
+ synth_5322 synth_5323 synth_5324 synth_5325 synth_5326 synth_5327 synth_5328
+ synth_5329 synth_533 synth_5330 synth_5331 synth_5332 synth_5333 synth_5334
+ synth_5335 synth_5336 synth_5337 synth_5338 synth_5339 synth_534 synth_5340
+ synth_5341 synth_5342 synth_5343 synth_5344 synth_5345 synth_5346 synth_5347
+ synth_5348 synth_5349 synth_535 synth_5350 synth_5351 synth_5352 synth_5353
+ synth_5354 synth_5355 synth_5356 synth_5357 synth_5358 synth_5359 synth_536
+ synth_5360 synth_5361 synth_5362 synth_5363 synth_5364 synth_5365 synth_5366
+ synth_5367 synth_5368 synth_5369 synth_537 synth_5370 synth_5371 synth_5372
+ synth_5373 synth_5374 synth_5375 synth_5376 synth_5377 synth_5378 synth_5379
+ synth_538 synth_5380 synth_5381 synth_5382 synth_5383 synth_5385 synth_5387
+ synth_5388 synth_5389 synth_539 synth_5390 synth_5391 synth_5393 synth_5394
+ synth_5395 synth_5396 synth_5397 synth_5398 synth_5399 synth_54 synth_540
+ synth_5400 synth_5401 synth_5402 synth_5403 synth_5404 synth_5405 synth_5406
+ synth_5407 synth_5408 synth_5409 synth_541 synth_5410 synth_5411 synth_5412
+ synth_5413 synth_5414 synth_5415 synth_5416 synth_5417 synth_5418 synth_5419
+ synth_542 synth_5420 synth_5421 synth_5422 synth_5423 synth_5424 synth_5425
+ synth_5426 synth_5427 synth_5428 synth_5429 synth_543 synth_5430 synth_5431
+ synth_5432 synth_5433 synth_5434 synth_5435 synth_5436 synth_5437 synth_5438
+ synth_5439 synth_544 synth_5440 synth_5441 synth_5442 synth_5443 synth_5444
+ synth_5445 synth_5446 synth_5447 synth_5448 synth_5449 synth_545 synth_5450
+ synth_5451 synth_5452 synth_5453 synth_5454 synth_5455 synth_5456 synth_5457
+ synth_5458 synth_5459 synth_546 synth_5460 synth_5461 synth_5462 synth_5463
+ synth_5464 synth_5465 synth_5466 synth_5467 synth_5468 synth_5469 synth_547
+ synth_5470 synth_5471 synth_5472 synth_5473 synth_5474 synth_5475 synth_5476
+ synth_5477 synth_5478 synth_5479 synth_548 synth_5480 synth_5481 synth_5482
+ synth_5483 synth_5484 synth_5485 synth_5486 synth_5487 synth_5488 synth_5489
+ synth_549 synth_5490 synth_5491 synth_5492 synth_5493 synth_5494 synth_5495
+ synth_5496 synth_5497 synth_5498 synth_5499 synth_55 synth_550 synth_5500
+ synth_5501 synth_5502 synth_5503 synth_5504 synth_5505 synth_5506 synth_5507
+ synth_5508 synth_5509 synth_551 synth_5510 synth_5511 synth_5512 synth_5513
+ synth_5514 synth_5515 synth_5516 synth_5517 synth_5518 synth_5519 synth_552
+ synth_5520 synth_5521 synth_5522 synth_5523 synth_5524 synth_5525 synth_5526
+ synth_5527 synth_5528 synth_5529 synth_553 synth_5530 synth_5531 synth_5532
+ synth_5533 synth_5534 synth_5535 synth_5536 synth_5537 synth_5538 synth_5539
+ synth_554 synth_5540 synth_5541 synth_5542 synth_5543 synth_5544 synth_5545
+ synth_5546 synth_5547 synth_5548 synth_5549 synth_555 synth_5550 synth_5551
+ synth_5552 synth_5553 synth_5554 synth_5555 synth_5556 synth_5557 synth_5558
+ synth_5559 synth_556 synth_5560 synth_5561 synth_5562 synth_5563 synth_5564
+ synth_5565 synth_5566 synth_5567 synth_5568 synth_5569 synth_557 synth_5570
+ synth_5571 synth_5572 synth_5573 synth_5574 synth_5575 synth_5576 synth_5577
+ synth_5578 synth_5579 synth_558 synth_5580 synth_5581 synth_5582 synth_5583
+ synth_5584 synth_5585 synth_5586 synth_5587 synth_5588 synth_5589 synth_559
+ synth_5590 synth_5591 synth_5592 synth_5593 synth_5594 synth_5595 synth_5596
+ synth_5597 synth_5598 synth_5599 synth_56 synth_560 synth_5600 synth_5601
+ synth_5602 synth_5603 synth_5604 synth_5605 synth_5606 synth_5607 synth_5608
+ synth_5609 synth_561 synth_5610 synth_5611 synth_5612 synth_5613 synth_5614
+ synth_5615 synth_5616 synth_5617 synth_5618 synth_5619 synth_562 synth_5620
+ synth_5621 synth_5622 synth_5623 synth_5624 synth_5625 synth_5626 synth_5627
+ synth_5628 synth_5629 synth_563 synth_5630 synth_5631 synth_5632 synth_5633
+ synth_5634 synth_5635 synth_5636 synth_5637 synth_5638 synth_5639 synth_564
+ synth_5640 synth_5641 synth_5642 synth_5643 synth_5644 synth_5645 synth_5646
+ synth_5647 synth_5648 synth_5649 synth_565 synth_5650 synth_5651 synth_5652
+ synth_5653 synth_5654 synth_5655 synth_5656 synth_5657 synth_5658 synth_5659
+ synth_566 synth_5660 synth_5661 synth_5662 synth_5663 synth_5664 synth_5665
+ synth_5666 synth_5667 synth_5668 synth_5669 synth_567 synth_5670 synth_5671
+ synth_5672 synth_5673 synth_5674 synth_5675 synth_5676 synth_5677 synth_5678
+ synth_5679 synth_568 synth_5680 synth_5681 synth_5682 synth_5683 synth_5684
+ synth_5685 synth_5686 synth_5687 synth_5688 synth_5689 synth_569 synth_5690
+ synth_5691 synth_5692 synth_5693 synth_5694 synth_5695 synth_5696 synth_5697
+ synth_5698 synth_5699 synth_57 synth_570 synth_5700 synth_5701 synth_5702
+ synth_5703 synth_5704 synth_5705 synth_5706 synth_5707 synth_5709 synth_571
+ synth_5710 synth_5711 synth_5712 synth_5713 synth_5715 synth_5716 synth_5718
+ synth_5719 synth_572 synth_5721 synth_5722 synth_5723 synth_5724 synth_5725
+ synth_5726 synth_5727 synth_5728 synth_573 synth_5730 synth_5731 synth_5732
+ synth_5733 synth_5734 synth_5735 synth_5736 synth_5737 synth_5738 synth_5739
+ synth_574 synth_5740 synth_5741 synth_5742 synth_5743 synth_5744 synth_5745
+ synth_5746 synth_5747 synth_5748 synth_5749 synth_575 synth_5750 synth_5751
+ synth_5752 synth_5753 synth_5754 synth_5755 synth_5756 synth_5757 synth_5758
+ synth_5759 synth_576 synth_5760 synth_5761 synth_5762 synth_5763 synth_5764
+ synth_5765 synth_5766 synth_5767 synth_5768 synth_5769 synth_577 synth_5770
+ synth_5771 synth_5772 synth_5773 synth_5774 synth_5775 synth_5776 synth_5777
+ synth_5778 synth_5779 synth_578 synth_5780 synth_5781 synth_5782 synth_5783
+ synth_5784 synth_5785 synth_5786 synth_5787 synth_5788 synth_5789 synth_579
+ synth_5790 synth_5791 synth_5792 synth_5793 synth_5794 synth_5795 synth_5796
+ synth_5797 synth_5798 synth_5799 synth_58 synth_580 synth_5800 synth_5801
+ synth_5802 synth_5803 synth_5804 synth_5805 synth_5806 synth_5807 synth_5808
+ synth_5809 synth_581 synth_5810 synth_5811 synth_5812 synth_5813 synth_5814
+ synth_5815 synth_5816 synth_5817 synth_5818 synth_5819 synth_582 synth_5820
+ synth_5821 synth_5822 synth_5823 synth_5824 synth_5825 synth_5826 synth_5827
+ synth_5828 synth_5829 synth_583 synth_5830 synth_5831 synth_5832 synth_5833
+ synth_5834 synth_5835 synth_5836 synth_5837 synth_5838 synth_5839 synth_584
+ synth_5840 synth_5841 synth_5842 synth_5843 synth_5844 synth_5845 synth_5846
+ synth_5847 synth_5848 synth_5849 synth_585 synth_5850 synth_5851 synth_5852
+ synth_5853 synth_5854 synth_5855 synth_5856 synth_5857 synth_5858 synth_5859
+ synth_586 synth_5860 synth_5861 synth_5862 synth_5863 synth_5864 synth_5865
+ synth_5866 synth_5867 synth_5868 synth_5869 synth_587 synth_5870 synth_5871
+ synth_5872 synth_5873 synth_5874 synth_5875 synth_5876 synth_5877 synth_5878
+ synth_5879 synth_588 synth_5880 synth_5881 synth_5882 synth_5883 synth_5884
+ synth_5885 synth_5886 synth_5887 synth_5888 synth_5889 synth_589 synth_5890
+ synth_5891 synth_5892 synth_5893 synth_5894 synth_5895 synth_5896 synth_5897
+ synth_5898 synth_5899 synth_59 synth_590 synth_5900 synth_5901 synth_5902
+ synth_5903 synth_5904 synth_5905 synth_5906 synth_5907 synth_5908 synth_5909
+ synth_591 synth_5910 synth_5911 synth_5912 synth_5913 synth_5914 synth_5915
+ synth_5916 synth_5917 synth_5918 synth_5919 synth_592 synth_5920 synth_5921
+ synth_5922 synth_5923 synth_5924 synth_5925 synth_5926 synth_5927 synth_5928
+ synth_5929 synth_593 synth_5930 synth_5931 synth_5932 synth_5933 synth_5934
+ synth_5935 synth_5936 synth_5937 synth_5938 synth_5939 synth_594 synth_5940
+ synth_5941 synth_5942 synth_5943 synth_5944 synth_5945 synth_5946 synth_5947
+ synth_5948 synth_5949 synth_595 synth_5950 synth_5951 synth_5952 synth_5953
+ synth_5954 synth_5955 synth_5956 synth_5957 synth_5958 synth_5959 synth_596
+ synth_5960 synth_5961 synth_5962 synth_5963 synth_5964 synth_5965 synth_5966
+ synth_5967 synth_5968 synth_5969 synth_597 synth_5970 synth_5971 synth_5972
+ synth_5973 synth_5974 synth_5975 synth_5976 synth_5977 synth_5978 synth_5979
+ synth_598 synth_5980 synth_5981 synth_5982 synth_5983 synth_5984 synth_5985
+ synth_5986 synth_5987 synth_5988 synth_5989 synth_599 synth_5990 synth_5991
+ synth_5992 synth_5993 synth_5994 synth_5995 synth_5996 synth_5997 synth_5998
+ synth_5999 synth_6 synth_60 synth_600 synth_6000 synth_6001 synth_6002
+ synth_6003 synth_6004 synth_6005 synth_6006 synth_6007 synth_6008 synth_6009
+ synth_601 synth_6010 synth_6011 synth_6012 synth_6013 synth_6014 synth_6015
+ synth_6016 synth_6017 synth_6018 synth_6019 synth_602 synth_6020 synth_6021
+ synth_6022 synth_6023 synth_6024 synth_6025 synth_6026 synth_6027 synth_6028
+ synth_6029 synth_603 synth_6030 synth_6031 synth_6032 synth_6033 synth_6034
+ synth_6035 synth_6036 synth_6037 synth_6038 synth_6039 synth_604 synth_6040
+ synth_6041 synth_6042 synth_6043 synth_6044 synth_6045 synth_6046 synth_6047
+ synth_6048 synth_6049 synth_605 synth_6050 synth_6051 synth_6052 synth_6053
+ synth_6054 synth_6055 synth_6056 synth_6057 synth_6058 synth_6059 synth_606
+ synth_6060 synth_6061 synth_6062 synth_6063 synth_6064 synth_6065 synth_6066
+ synth_6067 synth_6068 synth_6069 synth_607 synth_6070 synth_6071 synth_6072
+ synth_6073 synth_6074 synth_6075 synth_6076 synth_6077 synth_6078 synth_6079
+ synth_608 synth_6080 synth_6081 synth_6082 synth_6083 synth_6084 synth_6085
+ synth_6086 synth_6087 synth_6088 synth_6089 synth_609 synth_6090 synth_6091
+ synth_6092 synth_6093 synth_6094 synth_6095 synth_6096 synth_6097 synth_6099
+ synth_61 synth_610 synth_6100 synth_6101 synth_6102 synth_6103 synth_6104
+ synth_6105 synth_6106 synth_6107 synth_6108 synth_6109 synth_611 synth_6110
+ synth_6111 synth_6113 synth_6114 synth_6115 synth_6118 synth_6119 synth_612
+ synth_6120 synth_6121 synth_6122 synth_6123 synth_6125 synth_6126 synth_6128
+ synth_613 synth_6130 synth_6131 synth_6132 synth_6133 synth_6134 synth_6135
+ synth_6136 synth_6137 synth_6138 synth_6139 synth_614 synth_6140 synth_6141
+ synth_6142 synth_6143 synth_6144 synth_6145 synth_6146 synth_6147 synth_6148
+ synth_6149 synth_615 synth_6150 synth_6151 synth_6152 synth_6153 synth_6154
+ synth_6155 synth_6156 synth_6157 synth_6158 synth_6159 synth_616 synth_6160
+ synth_6161 synth_6162 synth_6163 synth_6164 synth_6165 synth_6166 synth_6167
+ synth_6168 synth_6169 synth_617 synth_6170 synth_6171 synth_6172 synth_6173
+ synth_6174 synth_6175 synth_6176 synth_6177 synth_6178 synth_6179 synth_618
+ synth_6180 synth_6181 synth_6182 synth_6183 synth_6184 synth_6185 synth_6186
+ synth_6187 synth_6188 synth_6189 synth_619 synth_6190 synth_6191 synth_6192
+ synth_6193 synth_6194 synth_6195 synth_6196 synth_6197 synth_6198 synth_6199
+ synth_62 synth_620 synth_6200 synth_6201 synth_6202 synth_6203 synth_6204
+ synth_6205 synth_6206 synth_6207 synth_6208 synth_6209 synth_621 synth_6210
+ synth_6211 synth_6212 synth_6213 synth_6214 synth_6215 synth_6216 synth_6217
+ synth_6218 synth_6219 synth_622 synth_6220 synth_6221 synth_6222 synth_6223
+ synth_6224 synth_6225 synth_6226 synth_6227 synth_6229 synth_623 synth_6230
+ synth_6231 synth_6232 synth_6233 synth_6234 synth_6235 synth_6236 synth_6237
+ synth_6238 synth_6239 synth_624 synth_6240 synth_6241 synth_6243 synth_6244
+ synth_6245 synth_6246 synth_6247 synth_6248 synth_6249 synth_625 synth_6250
+ synth_6251 synth_6252 synth_6253 synth_6254 synth_6255 synth_6256 synth_6257
+ synth_6258 synth_6259 synth_626 synth_6260 synth_6261 synth_6262 synth_6263
+ synth_6264 synth_6265 synth_6266 synth_6267 synth_6268 synth_6269 synth_627
+ synth_6270 synth_6271 synth_6272 synth_6273 synth_6274 synth_6275 synth_6276
+ synth_6277 synth_6278 synth_6279 synth_628 synth_6280 synth_6281 synth_6282
+ synth_6283 synth_6284 synth_6285 synth_6286 synth_6287 synth_6288 synth_6289
+ synth_629 synth_6290 synth_6291 synth_6292 synth_6293 synth_6294 synth_6295
+ synth_6296 synth_6297 synth_6298 synth_6299 synth_63 synth_630 synth_6300
+ synth_6301 synth_6302 synth_6303 synth_6304 synth_6305 synth_6306 synth_6307
+ synth_6308 synth_6309 synth_631 synth_6310 synth_6311 synth_6312 synth_6313
+ synth_6314 synth_6315 synth_6316 synth_6317 synth_6318 synth_6319 synth_632
+ synth_6320 synth_6321 synth_6322 synth_6323 synth_6324 synth_6325 synth_6326
+ synth_6327 synth_6328 synth_6329 synth_633 synth_6330 synth_6331 synth_6332
+ synth_6333 synth_6334 synth_6335 synth_6336 synth_6337 synth_6338 synth_6339
+ synth_634 synth_6340 synth_6341 synth_6342 synth_6343 synth_6344 synth_6345
+ synth_6346 synth_6347 synth_6348 synth_6349 synth_635 synth_6350 synth_6351
+ synth_6352 synth_6353 synth_6354 synth_6355 synth_6356 synth_6357 synth_6358
+ synth_6359 synth_636 synth_6360 synth_6361 synth_6362 synth_6363 synth_6364
+ synth_6365 synth_6366 synth_6367 synth_6368 synth_6369 synth_637 synth_6370
+ synth_6371 synth_6372 synth_6373 synth_6374 synth_6375 synth_6376 synth_6377
+ synth_6378 synth_6379 synth_638 synth_6380 synth_6381 synth_6382 synth_6383
+ synth_6384 synth_6385 synth_6386 synth_6387 synth_6388 synth_6389 synth_639
+ synth_6390 synth_6391 synth_6392 synth_6393 synth_6394 synth_6395 synth_6396
+ synth_6397 synth_6398 synth_6399 synth_64 synth_640 synth_6400 synth_6401
+ synth_6402 synth_6403 synth_6404 synth_6405 synth_6406 synth_6407 synth_6408
+ synth_6409 synth_641 synth_6410 synth_6411 synth_6412 synth_6413 synth_6414
+ synth_6415 synth_6416 synth_6417 synth_6418 synth_6419 synth_642 synth_6420
+ synth_6421 synth_6422 synth_6423 synth_6424 synth_6425 synth_6426 synth_6427
+ synth_6428 synth_6429 synth_643 synth_6430 synth_6431 synth_6432 synth_6433
+ synth_6434 synth_6435 synth_6436 synth_6437 synth_6438 synth_6439 synth_644
+ synth_6440 synth_6441 synth_6442 synth_6443 synth_6444 synth_6445 synth_6446
+ synth_6447 synth_6448 synth_6449 synth_645 synth_6450 synth_6451 synth_6452
+ synth_6453 synth_6454 synth_6455 synth_6456 synth_6457 synth_6458 synth_6459
+ synth_646 synth_6460 synth_6461 synth_6462 synth_6463 synth_6464 synth_6465
+ synth_6466 synth_6467 synth_6468 synth_6469 synth_647 synth_6470 synth_6471
+ synth_6472 synth_6473 synth_6474 synth_6475 synth_6476 synth_6477 synth_6478
+ synth_6479 synth_648 synth_6480 synth_6481 synth_6482 synth_6483 synth_6484
+ synth_6485 synth_6486 synth_6487 synth_6488 synth_6489 synth_649 synth_6490
+ synth_6491 synth_6492 synth_6493 synth_6494 synth_6495 synth_6496 synth_6497
+ synth_6498 synth_6499 synth_65 synth_650 synth_6500 synth_6501 synth_6502
+ synth_6503 synth_6504 synth_6505 synth_6506 synth_6507 synth_6508 synth_6509
+ synth_651 synth_6510 synth_6511 synth_6512 synth_6513 synth_6514 synth_6515
+ synth_6516 synth_6517 synth_6518 synth_6519 synth_652 synth_6520 synth_6521
+ synth_6522 synth_6523 synth_6524 synth_6525 synth_6526 synth_6527 synth_6529
+ synth_653 synth_6531 synth_6532 synth_6533 synth_6534 synth_6535 synth_6536
+ synth_6537 synth_6538 synth_6539 synth_654 synth_6540 synth_6541 synth_6542
+ synth_6543 synth_6544 synth_6545 synth_6546 synth_6547 synth_6548 synth_6549
+ synth_655 synth_6550 synth_6551 synth_6552 synth_6553 synth_6554 synth_6555
+ synth_6556 synth_6557 synth_6558 synth_6559 synth_656 synth_6560 synth_6561
+ synth_6562 synth_6563 synth_6564 synth_6565 synth_6566 synth_6567 synth_6568
+ synth_6569 synth_657 synth_6570 synth_6571 synth_6572 synth_6573 synth_6574
+ synth_6575 synth_6576 synth_6577 synth_6578 synth_6579 synth_658 synth_6580
+ synth_6581 synth_6582 synth_6583 synth_6584 synth_6585 synth_6586 synth_6587
+ synth_6588 synth_6589 synth_659 synth_6590 synth_6591 synth_6592 synth_6593
+ synth_6594 synth_6595 synth_6596 synth_6597 synth_6598 synth_6599 synth_66
+ synth_660 synth_6600 synth_6601 synth_6602 synth_6603 synth_6604 synth_6605
+ synth_6606 synth_6607 synth_6608 synth_6609 synth_661 synth_6610 synth_6611
+ synth_6612 synth_6613 synth_6614 synth_6615 synth_6616 synth_6617 synth_6618
+ synth_6619 synth_662 synth_6620 synth_6621 synth_6622 synth_6623 synth_6624
+ synth_6625 synth_6626 synth_6627 synth_6628 synth_6629 synth_663 synth_6630
+ synth_6631 synth_6632 synth_6633 synth_6634 synth_6635 synth_6636 synth_6637
+ synth_6638 synth_6639 synth_664 synth_6640 synth_6641 synth_6642 synth_6643
+ synth_6644 synth_6645 synth_6646 synth_6647 synth_6648 synth_6649 synth_665
+ synth_6650 synth_6651 synth_6652 synth_6653 synth_6654 synth_6655 synth_6656
+ synth_6657 synth_6658 synth_6659 synth_666 synth_6660 synth_6661 synth_6662
+ synth_6663 synth_6664 synth_6665 synth_6666 synth_6667 synth_6668 synth_6669
+ synth_667 synth_6670 synth_6671 synth_6672 synth_6673 synth_6674 synth_6675
+ synth_6676 synth_6677 synth_6678 synth_6679 synth_668 synth_6680 synth_6681
+ synth_6682 synth_6683 synth_6684 synth_6685 synth_6686 synth_6687 synth_6688
+ synth_6689 synth_669 synth_6690 synth_6691 synth_6692 synth_6693 synth_6694
+ synth_6695 synth_6696 synth_6697 synth_6698 synth_6699 synth_67 synth_670
+ synth_6700 synth_6701 synth_6702 synth_6703 synth_6704 synth_6705 synth_6706
+ synth_6707 synth_6708 synth_6709 synth_671 synth_6710 synth_6711 synth_6712
+ synth_6713 synth_6714 synth_6715 synth_6716 synth_6717 synth_6718 synth_6719
+ synth_672 synth_6720 synth_6721 synth_6722 synth_6723 synth_6724 synth_6725
+ synth_6726 synth_6727 synth_6728 synth_6729 synth_673 synth_6730 synth_6731
+ synth_6732 synth_6733 synth_6734 synth_6735 synth_6736 synth_6737 synth_6738
+ synth_6739 synth_674 synth_6740 synth_6741 synth_6742 synth_6743 synth_6744
+ synth_6745 synth_6746 synth_6747 synth_6748 synth_6749 synth_675 synth_6750
+ synth_6751 synth_6752 synth_6753 synth_6754 synth_6755 synth_6756 synth_6757
+ synth_6758 synth_6759 synth_676 synth_6760 synth_6761 synth_6762 synth_6763
+ synth_6764 synth_6765 synth_6766 synth_6767 synth_6768 synth_6769 synth_677
+ synth_6770 synth_6771 synth_6772 synth_6773 synth_6774 synth_6775 synth_6776
+ synth_6777 synth_6778 synth_6779 synth_678 synth_6780 synth_6781 synth_6782
+ synth_6783 synth_6784 synth_6785 synth_6786 synth_6787 synth_6788 synth_6789
+ synth_679 synth_6790 synth_6791 synth_6792 synth_6793 synth_6794 synth_6795
+ synth_6796 synth_6797 synth_6798 synth_6799 synth_68 synth_680 synth_6800
+ synth_6801 synth_6802 synth_6803 synth_6804 synth_6805 synth_6806 synth_6807
+ synth_6808 synth_6809 synth_681 synth_6810 synth_6811 synth_6812 synth_6813
+ synth_6814 synth_6815 synth_6816 synth_6817 synth_6818 synth_6819 synth_682
+ synth_6820 synth_6821 synth_6822 synth_6823 synth_6824 synth_6825 synth_6826
+ synth_6827 synth_6828 synth_6829 synth_683 synth_6830 synth_6831 synth_6832
+ synth_6833 synth_6834 synth_6835 synth_6836 synth_6837 synth_6838 synth_6839
+ synth_684 synth_6840 synth_6841 synth_6842 synth_6843 synth_6844 synth_6845
+ synth_6846 synth_6847 synth_6848 synth_6849 synth_685 synth_6850 synth_6851
+ synth_6852 synth_6853 synth_6854 synth_6855 synth_6856 synth_6857 synth_6858
+ synth_6859 synth_686 synth_6860 synth_6861 synth_6862 synth_6863 synth_6864
+ synth_6865 synth_6866 synth_6867 synth_6868 synth_6869 synth_687 synth_6870
+ synth_6871 synth_6872 synth_6873 synth_6874 synth_6875 synth_6876 synth_6877
+ synth_6878 synth_6879 synth_688 synth_6880 synth_6881 synth_6882 synth_6883
+ synth_6884 synth_6885 synth_6886 synth_6887 synth_6888 synth_6889 synth_689
+ synth_6890 synth_6891 synth_6892 synth_6893 synth_6894 synth_6895 synth_6896
+ synth_6897 synth_6898 synth_6899 synth_69 synth_690 synth_6900 synth_6901
+ synth_6902 synth_6903 synth_6904 synth_6905 synth_6906 synth_6907 synth_6908
+ synth_6909 synth_691 synth_6910 synth_6911 synth_6912 synth_6913 synth_6914
+ synth_6915 synth_6916 synth_6917 synth_6918 synth_6919 synth_692 synth_6920
+ synth_6921 synth_6922 synth_6923 synth_6924 synth_6925 synth_6926 synth_6927
+ synth_6928 synth_6929 synth_693 synth_6930 synth_6931 synth_6933 synth_6934
+ synth_6936 synth_6937 synth_6938 synth_6939 synth_694 synth_6940 synth_6941
+ synth_6942 synth_6943 synth_6944 synth_6945 synth_6947 synth_6948 synth_6949
+ synth_695 synth_6950 synth_6952 synth_6953 synth_6954 synth_6955 synth_6956
+ synth_6957 synth_6958 synth_6959 synth_696 synth_6960 synth_6961 synth_6962
+ synth_6963 synth_6964 synth_6965 synth_6966 synth_6967 synth_6968 synth_6969
+ synth_697 synth_6970 synth_6971 synth_6972 synth_6973 synth_6974 synth_6975
+ synth_6976 synth_6977 synth_6978 synth_6979 synth_698 synth_6980 synth_6981
+ synth_6982 synth_6983 synth_6984 synth_6985 synth_6986 synth_6987 synth_6988
+ synth_6989 synth_699 synth_6990 synth_6991 synth_6992 synth_6993 synth_6994
+ synth_6995 synth_6996 synth_6997 synth_6998 synth_6999 synth_7 synth_70
+ synth_700 synth_7000 synth_7001 synth_7002 synth_7003 synth_7004 synth_7005
+ synth_7006 synth_7007 synth_7008 synth_7009 synth_701 synth_7010 synth_7011
+ synth_7012 synth_7013 synth_7014 synth_7015 synth_7016 synth_7017 synth_7018
+ synth_7019 synth_702 synth_7020 synth_7021 synth_7022 synth_7023 synth_7024
+ synth_7025 synth_7026 synth_7027 synth_7028 synth_7029 synth_703 synth_7030
+ synth_7031 synth_7032 synth_7033 synth_7034 synth_7035 synth_7036 synth_7037
+ synth_7038 synth_7039 synth_704 synth_7040 synth_7041 synth_7042 synth_7043
+ synth_7044 synth_7045 synth_7046 synth_7047 synth_7048 synth_7049 synth_705
+ synth_7050 synth_7051 synth_7052 synth_7053 synth_7054 synth_7055 synth_7056
+ synth_7057 synth_7058 synth_7059 synth_706 synth_7060 synth_7061 synth_7062
+ synth_7063 synth_7064 synth_7065 synth_7066 synth_7067 synth_7068 synth_7069
+ synth_707 synth_7070 synth_7071 synth_7072 synth_7073 synth_7074 synth_7075
+ synth_7076 synth_7077 synth_7078 synth_7079 synth_708 synth_7080 synth_7081
+ synth_7082 synth_7083 synth_7084 synth_7085 synth_7086 synth_7087 synth_7088
+ synth_7089 synth_709 synth_7090 synth_7091 synth_7092 synth_7093 synth_7094
+ synth_7095 synth_7096 synth_7097 synth_7098 synth_7099 synth_71 synth_710
+ synth_7100 synth_7101 synth_7102 synth_7103 synth_7104 synth_7105 synth_7106
+ synth_7107 synth_7108 synth_7109 synth_711 synth_7110 synth_7111 synth_7112
+ synth_7113 synth_7114 synth_7115 synth_7116 synth_7117 synth_7118 synth_7119
+ synth_712 synth_7120 synth_7121 synth_7122 synth_7123 synth_7124 synth_7125
+ synth_7126 synth_7127 synth_7128 synth_7129 synth_713 synth_7130 synth_7131
+ synth_7132 synth_7133 synth_7134 synth_7135 synth_7136 synth_7137 synth_7138
+ synth_7139 synth_714 synth_7140 synth_7141 synth_7142 synth_7143 synth_7144
+ synth_7145 synth_7146 synth_7147 synth_7148 synth_7149 synth_715 synth_7150
+ synth_7151 synth_7152 synth_7153 synth_7154 synth_7155 synth_7156 synth_7157
+ synth_7158 synth_7159 synth_716 synth_7160 synth_7161 synth_7162 synth_7163
+ synth_7164 synth_7165 synth_7166 synth_7167 synth_7168 synth_7169 synth_717
+ synth_7170 synth_7171 synth_7172 synth_7173 synth_7174 synth_7175 synth_7176
+ synth_7177 synth_7178 synth_7179 synth_718 synth_7180 synth_7181 synth_7182
+ synth_7183 synth_7184 synth_7185 synth_7186 synth_7187 synth_7188 synth_7189
+ synth_719 synth_7190 synth_7191 synth_7192 synth_7193 synth_7194 synth_7195
+ synth_7196 synth_7197 synth_7198 synth_7199 synth_72 synth_720 synth_7200
+ synth_7201 synth_7202 synth_7203 synth_7204 synth_7205 synth_7206 synth_7207
+ synth_7208 synth_7209 synth_721 synth_7210 synth_7211 synth_7212 synth_7213
+ synth_7214 synth_7215 synth_7216 synth_7217 synth_7218 synth_7219 synth_722
+ synth_7220 synth_7221 synth_7222 synth_7223 synth_7224 synth_7225 synth_7226
+ synth_7227 synth_7228 synth_7229 synth_723 synth_7230 synth_7231 synth_7232
+ synth_7233 synth_7234 synth_7235 synth_7236 synth_7237 synth_7238 synth_7239
+ synth_724 synth_7240 synth_7241 synth_7242 synth_7243 synth_7244 synth_7245
+ synth_7246 synth_7247 synth_7248 synth_7249 synth_725 synth_7250 synth_7251
+ synth_7252 synth_7253 synth_7254 synth_7255 synth_7256 synth_7257 synth_7258
+ synth_7259 synth_726 synth_7260 synth_7261 synth_7262 synth_7263 synth_7264
+ synth_7265 synth_7266 synth_7267 synth_7268 synth_7269 synth_727 synth_7270
+ synth_7271 synth_7272 synth_7273 synth_7274 synth_7275 synth_7276 synth_7277
+ synth_7278 synth_7279 synth_728 synth_7280 synth_7281 synth_7282 synth_7283
+ synth_7284 synth_7285 synth_7286 synth_7287 synth_7288 synth_7289 synth_729
+ synth_7290 synth_7292 synth_7293 synth_7294 synth_7295 synth_7296 synth_7297
+ synth_7298 synth_73 synth_730 synth_7300 synth_7301 synth_7302 synth_7303
+ synth_7304 synth_7305 synth_7307 synth_7308 synth_7309 synth_731 synth_7311
+ synth_7312 synth_7313 synth_7314 synth_7315 synth_7316 synth_7317 synth_7318
+ synth_7319 synth_732 synth_7320 synth_7321 synth_7322 synth_7323 synth_7324
+ synth_7325 synth_7326 synth_7327 synth_7328 synth_7329 synth_733 synth_7330
+ synth_7331 synth_7332 synth_7333 synth_7334 synth_7335 synth_7336 synth_7337
+ synth_7338 synth_7339 synth_734 synth_7340 synth_7341 synth_7342 synth_7343
+ synth_7344 synth_7345 synth_7346 synth_7347 synth_7348 synth_7349 synth_735
+ synth_7350 synth_7351 synth_7352 synth_7353 synth_7354 synth_7355 synth_7356
+ synth_7357 synth_7358 synth_7359 synth_736 synth_7360 synth_7361 synth_7362
+ synth_7363 synth_7364 synth_7365 synth_7366 synth_7367 synth_7368 synth_7369
+ synth_737 synth_7370 synth_7371 synth_7372 synth_7373 synth_7374 synth_7375
+ synth_7376 synth_7377 synth_7378 synth_7379 synth_738 synth_7380 synth_7381
+ synth_7382 synth_7383 synth_7384 synth_7385 synth_7386 synth_7387 synth_7388
+ synth_7389 synth_739 synth_7390 synth_7391 synth_7392 synth_7393 synth_7394
+ synth_7395 synth_7396 synth_7397 synth_7398 synth_7399 synth_74 synth_740
+ synth_7400 synth_7401 synth_7402 synth_7403 synth_7404 synth_7405 synth_7406
+ synth_7407 synth_7408 synth_7409 synth_741 synth_7410 synth_7411 synth_7412
+ synth_7413 synth_7414 synth_7415 synth_7416 synth_7417 synth_7418 synth_7419
+ synth_742 synth_7420 synth_7421 synth_7422 synth_7423 synth_7424 synth_7425
+ synth_7426 synth_7427 synth_7428 synth_7429 synth_743 synth_7430 synth_7431
+ synth_7432 synth_7433 synth_7434 synth_7435 synth_7436 synth_7437 synth_7438
+ synth_7439 synth_744 synth_7440 synth_7441 synth_7442 synth_7443 synth_7444
+ synth_7445 synth_7446 synth_7447 synth_7448 synth_7449 synth_745 synth_7450
+ synth_7451 synth_7452 synth_7453 synth_7454 synth_7455 synth_7456 synth_7457
+ synth_7458 synth_7459 synth_746 synth_7460 synth_7461 synth_7462 synth_7463
+ synth_7464 synth_7465 synth_7466 synth_7467 synth_7468 synth_7469 synth_747
+ synth_7470 synth_7471 synth_7472 synth_7473 synth_7474 synth_7475 synth_7476
+ synth_7477 synth_7478 synth_7479 synth_748 synth_7480 synth_7481 synth_7482
+ synth_7483 synth_7484 synth_7485 synth_7486 synth_7487 synth_7488 synth_7489
+ synth_749 synth_7490 synth_7491 synth_7492 synth_7493 synth_7494 synth_7495
+ synth_7496 synth_7497 synth_7498 synth_7499 synth_75 synth_750 synth_7500
+ synth_7501 synth_7502 synth_7503 synth_7504 synth_7505 synth_7506 synth_7507
+ synth_7508 synth_7509 synth_751 synth_7510 synth_7511 synth_7512 synth_7513
+ synth_7514 synth_7515 synth_7516 synth_7517 synth_7518 synth_7519 synth_752
+ synth_7520 synth_7521 synth_7522 synth_7523 synth_7524 synth_7525 synth_7526
+ synth_7527 synth_7528 synth_7529 synth_753 synth_7530 synth_7531 synth_7532
+ synth_7533 synth_7534 synth_7535 synth_7536 synth_7537 synth_7538 synth_7539
+ synth_754 synth_7540 synth_7541 synth_7542 synth_7543 synth_7544 synth_7545
+ synth_7546 synth_7547 synth_7548 synth_7549 synth_755 synth_7550 synth_7551
+ synth_7552 synth_7553 synth_7554 synth_7555 synth_7556 synth_7557 synth_7558
+ synth_7559 synth_756 synth_7560 synth_7561 synth_7562 synth_7563 synth_7564
+ synth_7565 synth_7566 synth_7567 synth_7568 synth_7569 synth_757 synth_7570
+ synth_7571 synth_7572 synth_7573 synth_7574 synth_7575 synth_7576 synth_7577
+ synth_7578 synth_7579 synth_758 synth_7580 synth_7581 synth_7582 synth_7583
+ synth_7584 synth_7585 synth_7586 synth_7587 synth_7588 synth_7589 synth_759
+ synth_7590 synth_7591 synth_7592 synth_7593 synth_7594 synth_7595 synth_7596
+ synth_7597 synth_7598 synth_7599 synth_76 synth_760 synth_7600 synth_7601
+ synth_7602 synth_7603 synth_7604 synth_7605 synth_7606 synth_7607 synth_7608
+ synth_7609 synth_761 synth_7610 synth_7611 synth_7612 synth_7613 synth_7614
+ synth_7615 synth_7616 synth_7617 synth_7618 synth_7619 synth_762 synth_7620
+ synth_7621 synth_7622 synth_7623 synth_7624 synth_7625 synth_7626 synth_7627
+ synth_7628 synth_7629 synth_763 synth_7630 synth_7631 synth_7632 synth_7633
+ synth_7634 synth_7635 synth_7636 synth_7637 synth_7638 synth_7639 synth_764
+ synth_7640 synth_7641 synth_7642 synth_7643 synth_7644 synth_7645 synth_7646
+ synth_7647 synth_7648 synth_7649 synth_765 synth_7650 synth_7651 synth_7652
+ synth_7653 synth_7654 synth_7655 synth_7656 synth_7657 synth_7658 synth_7659
+ synth_766 synth_7660 synth_7661 synth_7662 synth_7663 synth_7664 synth_7665
+ synth_7666 synth_7667 synth_7668 synth_7669 synth_767 synth_7670 synth_7671
+ synth_7672 synth_7673 synth_7674 synth_7675 synth_7676 synth_7677 synth_7678
+ synth_7679 synth_768 synth_7680 synth_7681 synth_7682 synth_7683 synth_7684
+ synth_7685 synth_7686 synth_7687 synth_7688 synth_7689 synth_769 synth_7691
+ synth_7692 synth_7693 synth_7695 synth_7696 synth_7697 synth_7698 synth_7699
+ synth_77 synth_770 synth_7700 synth_7701 synth_7702 synth_7703 synth_7704
+ synth_7705 synth_7706 synth_7707 synth_7708 synth_7709 synth_771 synth_7710
+ synth_7711 synth_7714 synth_7715 synth_7716 synth_7717 synth_7718 synth_7719
+ synth_772 synth_7720 synth_7721 synth_7722 synth_7723 synth_7724 synth_7725
+ synth_7726 synth_7727 synth_7728 synth_7729 synth_773 synth_7730 synth_7731
+ synth_7732 synth_7733 synth_7734 synth_7735 synth_7736 synth_7737 synth_7738
+ synth_7739 synth_774 synth_7740 synth_7741 synth_7742 synth_7743 synth_7744
+ synth_7745 synth_7746 synth_7747 synth_7748 synth_7749 synth_775 synth_7750
+ synth_7751 synth_7752 synth_7753 synth_7754 synth_7755 synth_7756 synth_7757
+ synth_7758 synth_7759 synth_776 synth_7760 synth_7761 synth_7762 synth_7763
+ synth_7764 synth_7765 synth_7766 synth_7767 synth_7768 synth_7769 synth_777
+ synth_7770 synth_7771 synth_7772 synth_7773 synth_7774 synth_7775 synth_7776
+ synth_7777 synth_7778 synth_7779 synth_778 synth_7780 synth_7781 synth_7782
+ synth_7783 synth_7784 synth_7785 synth_7786 synth_7787 synth_7788 synth_7789
+ synth_779 synth_7790 synth_7791 synth_7792 synth_7793 synth_7794 synth_7795
+ synth_7796 synth_7797 synth_7798 synth_7799 synth_78 synth_780 synth_7800
+ synth_7801 synth_7802 synth_7803 synth_7804 synth_7805 synth_7806 synth_7807
+ synth_7808 synth_7809 synth_781 synth_7810 synth_7811 synth_7812 synth_7813
+ synth_7814 synth_7815 synth_7816 synth_7817 synth_7818 synth_7819 synth_782
+ synth_7820 synth_7821 synth_7822 synth_7823 synth_7824 synth_7825 synth_7826
+ synth_7827 synth_7828 synth_7829 synth_783 synth_7830 synth_7831 synth_7832
+ synth_7833 synth_7834 synth_7835 synth_7836 synth_7837 synth_7838 synth_7839
+ synth_784 synth_7840 synth_7841 synth_7842 synth_7843 synth_7844 synth_7845
+ synth_7846 synth_7847 synth_7848 synth_7849 synth_785 synth_7850 synth_7851
+ synth_7852 synth_7853 synth_7854 synth_7855 synth_7856 synth_7857 synth_7858
+ synth_7859 synth_786 synth_7860 synth_7861 synth_7862 synth_7863 synth_7864
+ synth_7865 synth_7866 synth_7867 synth_7868 synth_7869 synth_787 synth_7870
+ synth_7871 synth_7872 synth_7873 synth_7874 synth_7875 synth_7876 synth_7877
+ synth_7878 synth_7879 synth_788 synth_7880 synth_7881 synth_7882 synth_7883
+ synth_7884 synth_7885 synth_7886 synth_7887 synth_7888 synth_7889 synth_789
+ synth_7890 synth_7891 synth_7892 synth_7893 synth_7894 synth_7895 synth_7896
+ synth_7897 synth_7898 synth_7899 synth_79 synth_790 synth_7900 synth_7901
+ synth_7902 synth_7903 synth_7904 synth_7905 synth_7906 synth_7907 synth_7908
+ synth_7909 synth_791 synth_7910 synth_7911 synth_7912 synth_7913 synth_7914
+ synth_7915 synth_7916 synth_7917 synth_7918 synth_7919 synth_792 synth_7920
+ synth_7921 synth_7922 synth_7923 synth_7924 synth_7925 synth_7926 synth_7927
+ synth_7928 synth_7929 synth_793 synth_7930 synth_7931 synth_7932 synth_7933
+ synth_7934 synth_7935 synth_7936 synth_7937 synth_7938 synth_7939 synth_794
+ synth_7940 synth_7941 synth_7942 synth_7943 synth_7944 synth_7945 synth_7946
+ synth_7947 synth_7948 synth_7949 synth_795 synth_7950 synth_7951 synth_7952
+ synth_7953 synth_7954 synth_7955 synth_7956 synth_7957 synth_7958 synth_7959
+ synth_796 synth_7960 synth_7961 synth_7962 synth_7963 synth_7964 synth_7965
+ synth_7966 synth_7967 synth_7968 synth_7969 synth_797 synth_7970 synth_7971
+ synth_7972 synth_7973 synth_7974 synth_7975 synth_7976 synth_7977 synth_7978
+ synth_7979 synth_798 synth_7980 synth_7981 synth_7982 synth_7983 synth_7984
+ synth_7985 synth_7986 synth_7987 synth_7988 synth_7989 synth_799 synth_7990
+ synth_7991 synth_7992 synth_7993 synth_7994 synth_7995 synth_7996 synth_7997
+ synth_7998 synth_7999 synth_8 synth_80 synth_800 synth_8000 synth_8001
+ synth_8002 synth_8003 synth_8004 synth_8005 synth_8006 synth_8007 synth_8008
+ synth_8009 synth_801 synth_8010 synth_8011 synth_8012 synth_8013 synth_8014
+ synth_8015 synth_8016 synth_8017 synth_8018 synth_8019 synth_802 synth_8020
+ synth_8021 synth_8022 synth_8023 synth_8024 synth_8025 synth_8026 synth_8027
+ synth_8028 synth_8029 synth_803 synth_8030 synth_8031 synth_8032 synth_8033
+ synth_8034 synth_8035 synth_8036 synth_8037 synth_8038 synth_8039 synth_804
+ synth_8040 synth_8041 synth_8043 synth_8044 synth_8045 synth_8046 synth_8047
+ synth_8049 synth_805 synth_8050 synth_8051 synth_8052 synth_8053 synth_8054
+ synth_8055 synth_8056 synth_8057 synth_8059 synth_806 synth_8060 synth_8062
+ synth_8063 synth_8064 synth_8065 synth_8066 synth_8067 synth_8068 synth_8069
+ synth_807 synth_8070 synth_8071 synth_8072 synth_8073 synth_8074 synth_8075
+ synth_8076 synth_8077 synth_8078 synth_8079 synth_808 synth_8080 synth_8081
+ synth_8082 synth_8083 synth_8084 synth_8085 synth_8086 synth_8087 synth_8088
+ synth_8089 synth_809 synth_8090 synth_8091 synth_8092 synth_8093 synth_8094
+ synth_8095 synth_8096 synth_8097 synth_8098 synth_8099 synth_81 synth_810
+ synth_8100 synth_8101 synth_8102 synth_8103 synth_8104 synth_8105 synth_8106
+ synth_8107 synth_8108 synth_8109 synth_811 synth_8110 synth_8111 synth_8112
+ synth_8113 synth_8114 synth_8115 synth_8116 synth_8117 synth_8118 synth_8119
+ synth_812 synth_8120 synth_8121 synth_8122 synth_8123 synth_8124 synth_8125
+ synth_8126 synth_8127 synth_8128 synth_8129 synth_813 synth_8130 synth_8131
+ synth_8132 synth_8133 synth_8134 synth_8135 synth_8136 synth_8137 synth_8138
+ synth_8139 synth_814 synth_8140 synth_8141 synth_8142 synth_8143 synth_8144
+ synth_8145 synth_8146 synth_8147 synth_8148 synth_8149 synth_815 synth_8150
+ synth_8151 synth_8152 synth_8153 synth_8154 synth_8155 synth_8156 synth_8157
+ synth_8158 synth_8159 synth_816 synth_8160 synth_8161 synth_8162 synth_8163
+ synth_8164 synth_8165 synth_8166 synth_8167 synth_8168 synth_8169 synth_817
+ synth_8170 synth_8171 synth_8172 synth_8173 synth_8174 synth_8175 synth_8176
+ synth_8177 synth_8178 synth_8179 synth_818 synth_8180 synth_8181 synth_8182
+ synth_8183 synth_8184 synth_8185 synth_8186 synth_8187 synth_8188 synth_8189
+ synth_819 synth_8190 synth_8191 synth_8192 synth_8193 synth_8194 synth_8195
+ synth_8196 synth_8197 synth_8198 synth_8199 synth_82 synth_820 synth_8200
+ synth_8201 synth_8202 synth_8203 synth_8204 synth_8205 synth_8206 synth_8207
+ synth_8208 synth_8209 synth_821 synth_8210 synth_8211 synth_8212 synth_8213
+ synth_8214 synth_8215 synth_8216 synth_8217 synth_8218 synth_8219 synth_822
+ synth_8220 synth_8221 synth_8222 synth_8223 synth_8224 synth_8225 synth_8226
+ synth_8227 synth_8228 synth_8229 synth_823 synth_8230 synth_8231 synth_8232
+ synth_8233 synth_8234 synth_8235 synth_8236 synth_8237 synth_8238 synth_8239
+ synth_824 synth_8240 synth_8241 synth_8242 synth_8243 synth_8244 synth_8245
+ synth_8246 synth_8247 synth_8248 synth_8249 synth_825 synth_8250 synth_8251
+ synth_8252 synth_8253 synth_8254 synth_8255 synth_8256 synth_8257 synth_8258
+ synth_8259 synth_826 synth_8260 synth_8261 synth_8262 synth_8263 synth_8264
+ synth_8265 synth_8266 synth_8267 synth_8268 synth_8269 synth_827 synth_8270
+ synth_8271 synth_8272 synth_8273 synth_8274 synth_8275 synth_8276 synth_8277
+ synth_8278 synth_8279 synth_828 synth_8280 synth_8281 synth_8282 synth_8283
+ synth_8284 synth_8285 synth_8286 synth_8287 synth_8288 synth_8289 synth_829
+ synth_8290 synth_8291 synth_8292 synth_8293 synth_8294 synth_8295 synth_8296
+ synth_8297 synth_8298 synth_8299 synth_83 synth_830 synth_8300 synth_8301
+ synth_8302 synth_8303 synth_8304 synth_8305 synth_8306 synth_8307 synth_8308
+ synth_8309 synth_831 synth_8310 synth_8311 synth_8312 synth_8313 synth_8314
+ synth_8315 synth_8316 synth_8317 synth_8318 synth_8319 synth_832 synth_8320
+ synth_8321 synth_8322 synth_8323 synth_8324 synth_8325 synth_8326 synth_8327
+ synth_8328 synth_8329 synth_833 synth_8330 synth_8331 synth_8332 synth_8333
+ synth_8334 synth_8335 synth_8336 synth_8337 synth_8338 synth_8339 synth_834
+ synth_8340 synth_8341 synth_8342 synth_8343 synth_8344 synth_8345 synth_8346
+ synth_8347 synth_8348 synth_8349 synth_835 synth_8350 synth_8351 synth_8352
+ synth_8353 synth_8354 synth_8355 synth_8356 synth_8357 synth_8358 synth_8359
+ synth_836 synth_8360 synth_8361 synth_8362 synth_8363 synth_8364 synth_8365
+ synth_8366 synth_8367 synth_8368 synth_8369 synth_837 synth_8370 synth_8371
+ synth_8372 synth_8373 synth_8374 synth_8375 synth_8376 synth_8377 synth_8378
+ synth_8379 synth_838 synth_8380 synth_8381 synth_8382 synth_8383 synth_8384
+ synth_8385 synth_8386 synth_8387 synth_8388 synth_8389 synth_839 synth_8390
+ synth_8391 synth_8392 synth_8393 synth_8394 synth_8395 synth_8396 synth_8397
+ synth_8398 synth_8399 synth_84 synth_840 synth_8400 synth_8401 synth_8402
+ synth_8403 synth_8404 synth_8405 synth_8406 synth_8407 synth_8408 synth_8409
+ synth_841 synth_8410 synth_8411 synth_8412 synth_8413 synth_8414 synth_8415
+ synth_8416 synth_8417 synth_8418 synth_8419 synth_842 synth_8421 synth_8422
+ synth_8423 synth_8424 synth_8425 synth_8426 synth_8427 synth_8429 synth_843
+ synth_8430 synth_8431 synth_8432 synth_8433 synth_8434 synth_8435 synth_8436
+ synth_8437 synth_8438 synth_8439 synth_844 synth_8440 synth_8441 synth_8442
+ synth_8443 synth_8445 synth_8446 synth_8448 synth_8449 synth_845 synth_8450
+ synth_8451 synth_8452 synth_8453 synth_8454 synth_8455 synth_8456 synth_8457
+ synth_8458 synth_8459 synth_846 synth_8460 synth_8461 synth_8462 synth_8463
+ synth_8464 synth_8465 synth_8466 synth_8467 synth_8468 synth_8469 synth_847
+ synth_8470 synth_8471 synth_8472 synth_8473 synth_8474 synth_8475 synth_8476
+ synth_8477 synth_8478 synth_8479 synth_848 synth_8480 synth_8481 synth_8482
+ synth_8483 synth_8484 synth_8485 synth_8486 synth_8487 synth_8488 synth_8489
+ synth_849 synth_8490 synth_8491 synth_8492 synth_8493 synth_8494 synth_8495
+ synth_8496 synth_8497 synth_8498 synth_8499 synth_85 synth_850 synth_8500
+ synth_8501 synth_8502 synth_8503 synth_8504 synth_8505 synth_8506 synth_8507
+ synth_8508 synth_8509 synth_851 synth_8510 synth_8511 synth_8512 synth_8513
+ synth_8514 synth_8515 synth_8516 synth_8517 synth_8518 synth_8519 synth_852
+ synth_8520 synth_8521 synth_8522 synth_8523 synth_8524 synth_8525 synth_8526
+ synth_8527 synth_8528 synth_8529 synth_853 synth_8530 synth_8531 synth_8532
+ synth_8533 synth_8534 synth_8535 synth_8536 synth_8537 synth_8538 synth_8539
+ synth_854 synth_8540 synth_8541 synth_8542 synth_8543 synth_8544 synth_8545
+ synth_8546 synth_8547 synth_8548 synth_8549 synth_855 synth_8550 synth_8551
+ synth_8552 synth_8553 synth_8554 synth_8555 synth_8556 synth_8557 synth_8558
+ synth_8559 synth_856 synth_8560 synth_8561 synth_8562 synth_8563 synth_8564
+ synth_8565 synth_8566 synth_8567 synth_8568 synth_8569 synth_857 synth_8570
+ synth_8571 synth_8572 synth_8573 synth_8574 synth_8575 synth_8576 synth_8577
+ synth_8578 synth_8579 synth_858 synth_8580 synth_8581 synth_8582 synth_8583
+ synth_8584 synth_8585 synth_8586 synth_8587 synth_8588 synth_8589 synth_859
+ synth_8590 synth_8591 synth_8592 synth_8593 synth_8594 synth_8595 synth_8596
+ synth_8597 synth_8598 synth_8599 synth_86 synth_860 synth_8600 synth_8601
+ synth_8602 synth_8603 synth_8604 synth_8605 synth_8606 synth_8607 synth_8608
+ synth_8609 synth_861 synth_8610 synth_8611 synth_8612 synth_8613 synth_8614
+ synth_8615 synth_8616 synth_8617 synth_8618 synth_8619 synth_862 synth_8620
+ synth_8621 synth_8622 synth_8623 synth_8624 synth_8625 synth_8626 synth_8627
+ synth_8628 synth_8629 synth_863 synth_8630 synth_8631 synth_8632 synth_8633
+ synth_8634 synth_8635 synth_8636 synth_8637 synth_8638 synth_8639 synth_864
+ synth_8640 synth_8641 synth_8642 synth_8643 synth_8644 synth_8645 synth_8646
+ synth_8647 synth_8648 synth_8649 synth_865 synth_8650 synth_8651 synth_8652
+ synth_8653 synth_8654 synth_8655 synth_8656 synth_8657 synth_8658 synth_8659
+ synth_866 synth_8660 synth_8661 synth_8662 synth_8663 synth_8664 synth_8665
+ synth_8666 synth_8667 synth_8668 synth_8669 synth_867 synth_8670 synth_8671
+ synth_8672 synth_8673 synth_8674 synth_8675 synth_8676 synth_8677 synth_8678
+ synth_8679 synth_868 synth_8680 synth_8681 synth_8682 synth_8683 synth_8684
+ synth_8685 synth_8686 synth_8687 synth_8688 synth_8689 synth_869 synth_8690
+ synth_8691 synth_8692 synth_8693 synth_8694 synth_8695 synth_8696 synth_8697
+ synth_8698 synth_8699 synth_87 synth_870 synth_8700 synth_8701 synth_8702
+ synth_8703 synth_8704 synth_8705 synth_8706 synth_8707 synth_8708 synth_8709
+ synth_871 synth_8710 synth_8711 synth_8712 synth_8713 synth_8714 synth_8715
+ synth_8716 synth_8717 synth_8718 synth_8719 synth_872 synth_8720 synth_8721
+ synth_8722 synth_8723 synth_8724 synth_8725 synth_8726 synth_8727 synth_8728
+ synth_8729 synth_873 synth_8730 synth_8731 synth_8732 synth_8733 synth_8734
+ synth_8735 synth_8736 synth_8737 synth_8738 synth_8739 synth_874 synth_8740
+ synth_8741 synth_8742 synth_8743 synth_8744 synth_8745 synth_8746 synth_8747
+ synth_8748 synth_8749 synth_875 synth_8750 synth_8751 synth_8752 synth_8753
+ synth_8754 synth_8755 synth_8756 synth_8757 synth_8758 synth_8759 synth_876
+ synth_8760 synth_8761 synth_8762 synth_8763 synth_8764 synth_8765 synth_8766
+ synth_8767 synth_8768 synth_8769 synth_877 synth_8770 synth_8771 synth_8772
+ synth_8773 synth_8774 synth_8775 synth_8776 synth_8777 synth_8778 synth_8779
+ synth_878 synth_8780 synth_8781 synth_8782 synth_8783 synth_8784 synth_8785
+ synth_8786 synth_8787 synth_8788 synth_8789 synth_879 synth_8790 synth_8791
+ synth_8792 synth_8793 synth_8794 synth_8795 synth_8796 synth_8797 synth_8798
+ synth_8799 synth_88 synth_880 synth_8800 synth_8801 synth_8802 synth_8803
+ synth_8804 synth_8805 synth_8806 synth_8807 synth_8808 synth_8809 synth_881
+ synth_8810 synth_8811 synth_8812 synth_8813 synth_8814 synth_8815 synth_8816
+ synth_8817 synth_8818 synth_8819 synth_882 synth_8820 synth_8821 synth_8822
+ synth_8823 synth_8824 synth_8825 synth_8826 synth_8827 synth_8828 synth_883
+ synth_8830 synth_8831 synth_8832 synth_8833 synth_8835 synth_8836 synth_8837
+ synth_8838 synth_884 synth_8840 synth_8841 synth_8842 synth_8843 synth_8844
+ synth_8845 synth_8846 synth_8847 synth_8848 synth_8849 synth_885 synth_8850
+ synth_8852 synth_8853 synth_8854 synth_8855 synth_8856 synth_8857 synth_8858
+ synth_8859 synth_886 synth_8860 synth_8861 synth_8862 synth_8863 synth_8864
+ synth_8865 synth_8866 synth_8867 synth_8868 synth_8869 synth_887 synth_8870
+ synth_8871 synth_8872 synth_8873 synth_8874 synth_8875 synth_8876 synth_8877
+ synth_8878 synth_8879 synth_888 synth_8880 synth_8881 synth_8882 synth_8883
+ synth_8884 synth_8885 synth_8886 synth_8887 synth_8888 synth_8889 synth_889
+ synth_8890 synth_8891 synth_8892 synth_8893 synth_8894 synth_8895 synth_8896
+ synth_8897 synth_8898 synth_8899 synth_89 synth_890 synth_8900 synth_8901
+ synth_8902 synth_8903 synth_8904 synth_8905 synth_8906 synth_8907 synth_8908
+ synth_8909 synth_891 synth_8910 synth_8911 synth_8912 synth_8913 synth_8914
+ synth_8915 synth_8916 synth_8917 synth_8918 synth_8919 synth_892 synth_8920
+ synth_8921 synth_8922 synth_8923 synth_8924 synth_8925 synth_8926 synth_8927
+ synth_8928 synth_8929 synth_893 synth_8930 synth_8931 synth_8932 synth_8933
+ synth_8934 synth_8935 synth_8936 synth_8937 synth_8938 synth_8939 synth_894
+ synth_8940 synth_8941 synth_8942 synth_8943 synth_8944 synth_8945 synth_8946
+ synth_8947 synth_8948 synth_8949 synth_895 synth_8950 synth_8951 synth_8952
+ synth_8953 synth_8954 synth_8955 synth_8956 synth_8957 synth_8958 synth_8959
+ synth_896 synth_8960 synth_8961 synth_8962 synth_8963 synth_8964 synth_8965
+ synth_8966 synth_8967 synth_8968 synth_8969 synth_897 synth_8970 synth_8971
+ synth_8972 synth_8973 synth_8974 synth_8975 synth_8976 synth_8977 synth_8978
+ synth_8979 synth_898 synth_8980 synth_8981 synth_8982 synth_8983 synth_8984
+ synth_8985 synth_8986 synth_8987 synth_8988 synth_8989 synth_899 synth_8990
+ synth_8991 synth_8992 synth_8993 synth_8994 synth_8995 synth_8996 synth_8997
+ synth_8998 synth_8999 synth_9 synth_90 synth_900 synth_9000 synth_9001
+ synth_9002 synth_9004 synth_9006 synth_9007 synth_9008 synth_9009 synth_901
+ synth_9011 synth_9012 synth_9013 synth_9014 synth_9015 synth_9016 synth_9017
+ synth_9018 synth_9019 synth_902 synth_9020 synth_9021 synth_9022 synth_9023
+ synth_9024 synth_9025 synth_9026 synth_9027 synth_9028 synth_9029 synth_903
+ synth_9030 synth_9031 synth_9032 synth_9033 synth_9034 synth_9035 synth_9036
+ synth_9037 synth_9038 synth_9039 synth_904 synth_9040 synth_9041 synth_9042
+ synth_9043 synth_9044 synth_9045 synth_9046 synth_9047 synth_9048 synth_9049
+ synth_905 synth_9050 synth_9051 synth_9052 synth_9053 synth_9054 synth_9055
+ synth_9056 synth_9057 synth_9058 synth_9059 synth_906 synth_9060 synth_9061
+ synth_9062 synth_9063 synth_9064 synth_9065 synth_9066 synth_9067 synth_9068
+ synth_9069 synth_907 synth_9070 synth_9071 synth_9072 synth_9073 synth_9074
+ synth_9075 synth_9076 synth_9077 synth_9078 synth_9079 synth_908 synth_9080
+ synth_9081 synth_9082 synth_9083 synth_9084 synth_9085 synth_9086 synth_9087
+ synth_9088 synth_9089 synth_909 synth_9090 synth_9091 synth_9092 synth_9093
+ synth_9094 synth_9095 synth_9096 synth_9097 synth_9098 synth_9099 synth_91
+ synth_910 synth_9100 synth_9101 synth_9102 synth_9103 synth_9104 synth_9105
+ synth_9106 synth_9107 synth_9108 synth_9109 synth_911 synth_9110 synth_9111
+ synth_9112 synth_9113 synth_9114 synth_9115 synth_9116 synth_9117 synth_9118
+ synth_9119 synth_912 synth_9120 synth_9121 synth_9122 synth_9123 synth_9124
+ synth_9125 synth_9126 synth_9127 synth_9128 synth_9129 synth_913 synth_9130
+ synth_9131 synth_9132 synth_9133 synth_9134 synth_9135 synth_9136 synth_9137
+ synth_9138 synth_9139 synth_914 synth_9140 synth_9141 synth_9142 synth_9143
+ synth_9144 synth_9145 synth_9146 synth_9147 synth_9148 synth_9149 synth_915
+ synth_9150 synth_9151 synth_9152 synth_9153 synth_9154 synth_9155 synth_9156
+ synth_9157 synth_9158 synth_9159 synth_916 synth_9160 synth_9161 synth_9162
+ synth_9163 synth_9164 synth_9165 synth_9166 synth_9167 synth_9168 synth_9169
+ synth_917 synth_9170 synth_9171 synth_9172 synth_9173 synth_9174 synth_9175
+ synth_9176 synth_9177 synth_9178 synth_9179 synth_918 synth_9180 synth_9181
+ synth_9182 synth_9183 synth_9184 synth_9185 synth_9186 synth_9187 synth_9188
+ synth_9189 synth_919 synth_9190 synth_9191 synth_9192 synth_9193 synth_9194
+ synth_9195 synth_9196 synth_9197 synth_9198 synth_9199 synth_92 synth_920
+ synth_9200 synth_9201 synth_9202 synth_9203 synth_9204 synth_9205 synth_9206
+ synth_9207 synth_9208 synth_9209 synth_921 synth_9210 synth_9211 synth_9212
+ synth_9213 synth_9214 synth_9215 synth_9216 synth_9217 synth_9218 synth_9219
+ synth_922 synth_9220 synth_9221 synth_9222 synth_9223 synth_9224 synth_9225
+ synth_9226 synth_9227 synth_9228 synth_9229 synth_923 synth_9230 synth_9231
+ synth_9232 synth_9233 synth_9234 synth_9235 synth_9236 synth_9237 synth_9238
+ synth_9239 synth_924 synth_9240 synth_9241 synth_9242 synth_9243 synth_9244
+ synth_9245 synth_9246 synth_9247 synth_9248 synth_9249 synth_925 synth_9250
+ synth_9251 synth_9252 synth_9253 synth_9254 synth_9255 synth_9256 synth_9257
+ synth_9258 synth_9259 synth_926 synth_9260 synth_9261 synth_9262 synth_9263
+ synth_9264 synth_9265 synth_9266 synth_9267 synth_9268 synth_9269 synth_927
+ synth_9270 synth_9271 synth_9272 synth_9273 synth_9274 synth_9275 synth_9276
+ synth_9277 synth_9278 synth_9279 synth_928 synth_9280 synth_9281 synth_9282
+ synth_9283 synth_9284 synth_9285 synth_9286 synth_9287 synth_9288 synth_9289
+ synth_929 synth_9290 synth_9291 synth_9292 synth_9293 synth_9294 synth_9295
+ synth_9296 synth_9297 synth_9298 synth_9299 synth_93 synth_930 synth_9300
+ synth_9301 synth_9302 synth_9303 synth_9304 synth_9305 synth_9306 synth_9307
+ synth_9308 synth_9309 synth_931 synth_9310 synth_9311 synth_9312 synth_9313
+ synth_9314 synth_9315 synth_9316 synth_9317 synth_9318 synth_9319 synth_932
+ synth_9320 synth_9321 synth_9322 synth_9323 synth_9324 synth_9325 synth_9326
+ synth_9327 synth_9328 synth_9329 synth_933 synth_9330 synth_9331 synth_9332
+ synth_9333 synth_9334 synth_9335 synth_9336 synth_9337 synth_9338 synth_9339
+ synth_934 synth_9340 synth_9341 synth_9342 synth_9343 synth_9344 synth_9345
+ synth_9346 synth_9347 synth_9348 synth_9349 synth_935 synth_9350 synth_9351
+ synth_9352 synth_9353 synth_9354 synth_9355 synth_9356 synth_9357 synth_9358
+ synth_9359 synth_936 synth_9360 synth_9361 synth_9362 synth_9363 synth_9364
+ synth_9365 synth_9366 synth_9367 synth_9368 synth_9369 synth_937 synth_9370
+ synth_9371 synth_9372 synth_9373 synth_9374 synth_9375 synth_9376 synth_9377
+ synth_9378 synth_9379 synth_938 synth_9380 synth_9381 synth_9382 synth_9383
+ synth_9384 synth_9385 synth_9386 synth_9387 synth_9388 synth_9389 synth_939
+ synth_9390 synth_9391 synth_9392 synth_9393 synth_9394 synth_9395 synth_9396
+ synth_9397 synth_9398 synth_9399 synth_94 synth_940 synth_9400 synth_9401
+ synth_9402 synth_9403 synth_9404 synth_9405 synth_9406 synth_9407 synth_9408
+ synth_9409 synth_941 synth_9410 synth_9411 synth_9412 synth_9413 synth_9414
+ synth_9415 synth_9416 synth_9417 synth_9418 synth_9419 synth_942 synth_9420
+ synth_9421 synth_9422 synth_9423 synth_9424 synth_9425 synth_9426 synth_9427
+ synth_9428 synth_9429 synth_943 synth_9430 synth_9431 synth_9432 synth_9433
+ synth_9434 synth_9435 synth_9436 synth_9437 synth_9438 synth_9439 synth_944
+ synth_9440 synth_9441 synth_9442 synth_9443 synth_9444 synth_9445 synth_9446
+ synth_9447 synth_9448 synth_9449 synth_945 synth_9450 synth_9451 synth_9452
+ synth_9453 synth_9454 synth_9455 synth_9456 synth_9457 synth_9458 synth_9459
+ synth_946 synth_9460 synth_9461 synth_9462 synth_9463 synth_9464 synth_9465
+ synth_9466 synth_9467 synth_9468 synth_9469 synth_947 synth_9470 synth_9471
+ synth_9472 synth_9473 synth_9474 synth_9475 synth_9476 synth_9477 synth_9478
+ synth_9479 synth_948 synth_9480 synth_9481 synth_9482 synth_9483 synth_9484
+ synth_9485 synth_9486 synth_9487 synth_9488 synth_9489 synth_949 synth_9490
+ synth_9491 synth_9492 synth_9493 synth_9494 synth_9495 synth_9496 synth_9497
+ synth_9498 synth_9499 synth_95 synth_950 synth_9500 synth_9501 synth_9502
+ synth_9503 synth_9504 synth_9505 synth_9506 synth_9507 synth_9508 synth_9509
+ synth_951 synth_9510 synth_9511 synth_9512 synth_9513 synth_9514 synth_9515
+ synth_9516 synth_9517 synth_9518 synth_9519 synth_952 synth_9520 synth_9521
+ synth_9522 synth_9523 synth_9524 synth_9525 synth_9526 synth_9527 synth_9528
+ synth_9529 synth_953 synth_9530 synth_9531 synth_9532 synth_9533 synth_9534
+ synth_9535 synth_9536 synth_9537 synth_9538 synth_9539 synth_954 synth_9540
+ synth_9541 synth_9542 synth_9543 synth_9544 synth_9545 synth_9546 synth_9547
+ synth_9548 synth_9549 synth_955 synth_9550 synth_9551 synth_9552 synth_9553
+ synth_9554 synth_9555 synth_9556 synth_9557 synth_9558 synth_9559 synth_956
+ synth_9560 synth_9561 synth_9562 synth_9563 synth_9564 synth_9565 synth_9566
+ synth_9567 synth_9569 synth_957 synth_9570 synth_9571 synth_9572 synth_9573
+ synth_9574 synth_9575 synth_9576 synth_9577 synth_9578 synth_9579 synth_958
+ synth_9580 synth_9581 synth_9582 synth_9583 synth_9584 synth_9585 synth_9586
+ synth_9587 synth_9588 synth_9589 synth_959 synth_9590 synth_9591 synth_9592
+ synth_9593 synth_9594 synth_9595 synth_9596 synth_9597 synth_9598 synth_9599
+ synth_96 synth_960 synth_9600 synth_9601 synth_9602 synth_9603 synth_9604
+ synth_9605 synth_9606 synth_9607 synth_9608 synth_9609 synth_961 synth_9610
+ synth_9612 synth_9613 synth_9614 synth_9615 synth_9616 synth_9618 synth_9619
+ synth_962 synth_9620 synth_9621 synth_9622 synth_9623 synth_9624 synth_9625
+ synth_9626 synth_9627 synth_9628 synth_9629 synth_963 synth_9630 synth_9631
+ synth_9632 synth_9633 synth_9634 synth_9635 synth_9636 synth_9637 synth_9638
+ synth_9639 synth_964 synth_9640 synth_9641 synth_9642 synth_9643 synth_9644
+ synth_9645 synth_9646 synth_9647 synth_9648 synth_9649 synth_965 synth_9650
+ synth_9651 synth_9652 synth_9653 synth_9654 synth_9655 synth_9656 synth_9657
+ synth_9658 synth_9659 synth_966 synth_9660 synth_9661 synth_9662 synth_9663
+ synth_9664 synth_9665 synth_9666 synth_9667 synth_9668 synth_9669 synth_967
+ synth_9670 synth_9671 synth_9672 synth_9673 synth_9674 synth_9675 synth_9676
+ synth_9677 synth_9678 synth_9679 synth_968 synth_9680 synth_9681 synth_9682
+ synth_9683 synth_9684 synth_9685 synth_9686 synth_9687 synth_9688 synth_9689
+ synth_969 synth_9690 synth_9691 synth_9692 synth_9693 synth_9694 synth_9695
+ synth_9696 synth_9697 synth_9698 synth_9699 synth_97 synth_970 synth_9700
+ synth_9701 synth_9702 synth_9703 synth_9704 synth_9705 synth_9706 synth_9707
+ synth_9708 synth_9709 synth_971 synth_9710 synth_9711 synth_9712 synth_9713
+ synth_9714 synth_9715 synth_9716 synth_9717 synth_9718 synth_9719 synth_972
+ synth_9720 synth_9721 synth_9722 synth_9723 synth_9724 synth_9725 synth_9726
+ synth_9727 synth_9728 synth_9729 synth_973 synth_9730 synth_9731 synth_9732
+ synth_9733 synth_9734 synth_9735 synth_9736 synth_9737 synth_9738 synth_9739
+ synth_974 synth_9740 synth_9741 synth_9742 synth_9743 synth_9744 synth_9745
+ synth_9746 synth_9747 synth_9748 synth_9749 synth_975 synth_9750 synth_9751
+ synth_9752 synth_9753 synth_9754 synth_9755 synth_9756 synth_9757 synth_9758
+ synth_9759 synth_976 synth_9760 synth_9761 synth_9762 synth_9763 synth_9764
+ synth_9765 synth_9766 synth_9767 synth_9768 synth_9769 synth_977 synth_9770
+ synth_9771 synth_9772 synth_9773 synth_9774 synth_9775 synth_9776 synth_9777
+ synth_9778 synth_9779 synth_978 synth_9780 synth_9781 synth_9782 synth_9783
+ synth_9784 synth_9785 synth_9786 synth_9787 synth_9788 synth_9789 synth_979
+ synth_9790 synth_9791 synth_9792 synth_9793 synth_9794 synth_9795 synth_9796
+ synth_9797 synth_9798 synth_9799 synth_98 synth_980 synth_9800 synth_9801
+ synth_9802 synth_9803 synth_9804 synth_9805 synth_9806 synth_9807 synth_9808
+ synth_9809 synth_981 synth_9810 synth_9811 synth_9812 synth_9813 synth_9814
+ synth_9815 synth_9816 synth_9817 synth_9818 synth_9819 synth_982 synth_9820
+ synth_9821 synth_9822 synth_9823 synth_9824 synth_9825 synth_9826 synth_9827
+ synth_9828 synth_9829 synth_983 synth_9830 synth_9831 synth_9832 synth_9833
+ synth_9834 synth_9835 synth_9836 synth_9837 synth_9838 synth_9839 synth_984
+ synth_9840 synth_9841 synth_9842 synth_9843 synth_9844 synth_9845 synth_9846
+ synth_9847 synth_9848 synth_9849 synth_985 synth_9850 synth_9851 synth_9852
+ synth_9853 synth_9854 synth_9855 synth_9856 synth_9857 synth_9858 synth_9859
+ synth_986 synth_9860 synth_9861 synth_9862 synth_9863 synth_9864 synth_9865
+ synth_9866 synth_9867 synth_9868 synth_9869 synth_987 synth_9870 synth_9871
+ synth_9872 synth_9873 synth_9874 synth_9875 synth_9876 synth_9877 synth_9878
+ synth_9879 synth_988 synth_9880 synth_9881 synth_9882 synth_9883 synth_9884
+ synth_9885 synth_9886 synth_9887 synth_9888 synth_9889 synth_989 synth_9890
+ synth_9891 synth_9892 synth_9893 synth_9894 synth_9895 synth_9896 synth_9897
+ synth_9898 synth_9899 synth_99 synth_990 synth_9900 synth_9901 synth_9902
+ synth_9903 synth_9904 synth_9905 synth_9906 synth_9907 synth_9908 synth_9909
+ synth_991 synth_9910 synth_9911 synth_9912 synth_9913 synth_9914 synth_9915
+ synth_9916 synth_9917 synth_9918 synth_9919 synth_992 synth_9920 synth_9921
+ synth_9922 synth_9923 synth_9924 synth_9925 synth_9926 synth_9927 synth_9928
+ synth_9929 synth_993 synth_9930 synth_9931 synth_9932 synth_9933 synth_9934
+ synth_9935 synth_9936 synth_9937 synth_9938 synth_9939 synth_994 synth_9940
+ synth_9941 synth_9942 synth_9943 synth_9944 synth_9945 synth_9946 synth_9947
+ synth_9948 synth_9949 synth_995 synth_9950 synth_9951 synth_9952 synth_9953
+ synth_9954 synth_9955 synth_9956 synth_9957 synth_9958 synth_9959 synth_996
+ synth_9960 synth_9961 synth_9962 synth_9963 synth_9964 synth_9965 synth_9966
+ synth_9967 synth_9968 synth_9969 synth_997 synth_9970 synth_9971 synth_9972
+ synth_9973 synth_9974 synth_9975 synth_9976 synth_9977 synth_9978 synth_9979
+ synth_998 synth_9980 synth_9981 synth_9982 synth_9983 synth_9984 synth_9985
+ synth_9986 synth_9987 synth_9988 synth_9989 synth_999 synth_9990 synth_9991
+ synth_9992 synth_9993 synth_9994 synth_9995 synth_9996 synth_9997 synth_9998
+ synth_9999
X$15 VNB|VSS synth_440 synth_1 synth_547 synth_95 VDD VDD VNB|VSS
+ sky130_fd_sc_hd__edfxtp_1
X$16 VNB|VSS synth_146 synth_1 synth_121 synth_95 VDD VDD VNB|VSS
+ sky130_fd_sc_hd__edfxtp_1
X$17 VNB|VSS synth_153 synth_1 synth_119 synth_4 VDD VDD VNB|VSS
+ sky130_fd_sc_hd__edfxtp_1
X$18 VNB|VSS synth_44 synth_1 synth_122 synth_95 VDD VDD VNB|VSS
+ sky130_fd_sc_hd__edfxtp_1
X$19 VNB|VSS synth_16 synth_1 synth_41 synth_4 VDD VDD VNB|VSS
+ sky130_fd_sc_hd__edfxtp_1
X$20 VNB|VSS synth_3 synth_1 synth_216 synth_95 VDD VDD VNB|VSS
+ sky130_fd_sc_hd__edfxtp_1
X$21 VNB|VSS synth_567 synth_1 synth_601 synth_515 VDD VDD VNB|VSS
+ sky130_fd_sc_hd__edfxtp_1
X$22 VNB|VSS synth_82 synth_1 synth_5 synth_4 VDD VDD VNB|VSS
+ sky130_fd_sc_hd__edfxtp_1
X$26 VDD synth_1 VDD VNB|VSS VNB|VSS sky130_fd_sc_hd__clkinv_2
X$28 VNB|VSS synth_38 synth_1 VDD VDD VNB|VSS sky130_fd_sc_hd__clkbuf_16
X$36 VDD synth_279 synth_214 synth_2 VDD VNB|VSS VNB|VSS
+ sky130_fd_sc_hd__nand2_1
X$46 VNB|VSS synth_394 synth_63 synth_343 synth_2 VDD VDD VNB|VSS
+ sky130_fd_sc_hd__edfxtp_1
X$47 VNB|VSS synth_141 synth_63 synth_126 synth_2 VDD VDD VNB|VSS
+ sky130_fd_sc_hd__edfxtp_1
X$48 VNB|VSS synth_94 synth_63 synth_255 synth_2 VDD VDD VNB|VSS
+ sky130_fd_sc_hd__edfxtp_1
X$49 VNB|VSS synth_46 synth_63 synth_47 synth_2 VDD VDD VNB|VSS
+ sky130_fd_sc_hd__edfxtp_1
X$56 VDD synth_3 synth_217 synth_328 VDD synth_216 VNB|VSS VNB|VSS
+ sky130_fd_sc_hd__o21ai_0
X$57 VDD synth_3 VDD VNB|VSS synth_144 VNB|VSS sky130_fd_sc_hd__inv_1
X$64 VDD synth_84 synth_3 synth_44 VDD VNB|VSS synth_42 VNB|VSS
+ sky130_fd_sc_hd__o21bai_1
X$66 VDD synth_364 synth_345 synth_4 VDD VNB|VSS VNB|VSS
+ sky130_fd_sc_hd__nand2_1
X$72 VNB|VSS synth_442 synth_568 synth_492 synth_4 VDD VDD VNB|VSS
+ sky130_fd_sc_hd__edfxtp_1
X$79 VDD synth_220 synth_149 synth_325 VDD synth_5 VNB|VSS VNB|VSS
+ sky130_fd_sc_hd__o21ai_0
X$84 VDD synth_289 synth_364 synth_6 VDD VNB|VSS VNB|VSS
+ sky130_fd_sc_hd__nand2_1
X$91 VNB|VSS synth_171 synth_33 synth_76 synth_6 VDD VDD VNB|VSS
+ sky130_fd_sc_hd__edfxtp_1
X$92 VNB|VSS synth_447 synth_33 synth_409 synth_6 VDD VDD VNB|VSS
+ sky130_fd_sc_hd__edfxtp_1
X$93 VNB|VSS synth_65 synth_33 synth_31 synth_6 VDD VDD VNB|VSS
+ sky130_fd_sc_hd__edfxtp_1
X$94 VNB|VSS synth_159 synth_33 synth_173 synth_6 VDD VDD VNB|VSS
+ sky130_fd_sc_hd__edfxtp_1
X$100 VDD synth_355 synth_364 synth_7 VDD VNB|VSS VNB|VSS
+ sky130_fd_sc_hd__nand2_1
X$107 VNB|VSS synth_293 synth_33 synth_170 synth_7 VDD VDD VNB|VSS
+ sky130_fd_sc_hd__edfxtp_1
X$108 VNB|VSS synth_106 synth_33 synth_107 synth_7 VDD VDD VNB|VSS
+ sky130_fd_sc_hd__edfxtp_1
X$109 VNB|VSS synth_519 synth_33 synth_637 synth_7 VDD VDD VNB|VSS
+ sky130_fd_sc_hd__edfxtp_1
X$110 VNB|VSS synth_72 synth_33 synth_11 synth_7 VDD VDD VNB|VSS
+ sky130_fd_sc_hd__edfxtp_1
X$405 VDD synth_12455 synth_9234 synth_9175 synth_12407 synth_8803 synth_12358
+ synth_12359 VNB|VSS VDD VNB|VSS sky130_fd_sc_hd__a222oi_1
X$406 VDD synth_8805 synth_11871 synth_11937 synth_9379 synth_9483 synth_9396
+ synth_11831 VNB|VSS VDD VNB|VSS sky130_fd_sc_hd__a222oi_1
X$407 VDD synth_10438 synth_10793 synth_11166 synth_9322 synth_10724
+ synth_11288 VDD VNB|VSS VNB|VSS sky130_fd_sc_hd__a221o_1
X$408 VDD synth_8873 synth_12630 synth_12669 synth_9062 synth_12628 synth_12109
+ VDD VNB|VSS VNB|VSS sky130_fd_sc_hd__a221o_1
X$409 VDD synth_11465 synth_12702 synth_11504 synth_10285 synth_10312
+ synth_12622 VDD VNB|VSS VNB|VSS sky130_fd_sc_hd__o221ai_1
X$410 VDD synth_9042 synth_12489 synth_10778 synth_9738 synth_10212 synth_12599
+ VDD VNB|VSS VNB|VSS sky130_fd_sc_hd__o221ai_1
X$411 VDD synth_11093 synth_11223 synth_9850 synth_10376 synth_10212
+ synth_10729 VDD VNB|VSS VNB|VSS sky130_fd_sc_hd__o221ai_1
X$412 VDD synth_8981 synth_12649 synth_9239 synth_10793 synth_8803 synth_12596
+ VDD VNB|VSS VNB|VSS sky130_fd_sc_hd__o221ai_1
X$413 VDD synth_10353 synth_10368 synth_10410 synth_8710 synth_9672 synth_10352
+ VDD VNB|VSS VNB|VSS sky130_fd_sc_hd__o221ai_1
X$414 VDD synth_9160 synth_10294 synth_10548 synth_9062 synth_10309 synth_10546
+ VDD VNB|VSS VNB|VSS sky130_fd_sc_hd__o221ai_1
X$415 VDD synth_12027 synth_12049 synth_12028 synth_9900 synth_9042 synth_12159
+ VDD VNB|VSS VNB|VSS sky130_fd_sc_hd__o221ai_1
X$416 VDD synth_9677 synth_10509 synth_10510 synth_9695 synth_9474 synth_10490
+ VDD VNB|VSS VNB|VSS sky130_fd_sc_hd__o221ai_1
X$417 VDD synth_8764 synth_10230 synth_10308 synth_9615 synth_10291 synth_10417
+ VDD VNB|VSS VNB|VSS sky130_fd_sc_hd__o221ai_1
X$418 VDD synth_9112 synth_12301 synth_9695 synth_10101 synth_10212 synth_12155
+ VDD VNB|VSS VNB|VSS sky130_fd_sc_hd__o221ai_1
X$419 VDD synth_10575 synth_10770 synth_10916 synth_9292 synth_9434 synth_9981
+ VDD VNB|VSS VNB|VSS sky130_fd_sc_hd__o221ai_1
X$420 VDD synth_9160 synth_12097 synth_9117 synth_11794 VDD synth_12008 VNB|VSS
+ VNB|VSS sky130_fd_sc_hd__o2bb2ai_1
X$421 VDD synth_11377 synth_11777 synth_11357 synth_11242 VDD synth_11304
+ VNB|VSS VNB|VSS sky130_fd_sc_hd__o2bb2ai_1
X$422 VDD synth_9160 synth_11796 synth_9117 synth_12154 VDD synth_11967 VNB|VSS
+ VNB|VSS sky130_fd_sc_hd__o2bb2ai_1
X$423 VDD synth_9427 synth_12159 synth_9848 synth_10233 VDD synth_11675 VNB|VSS
+ VNB|VSS sky130_fd_sc_hd__o2bb2ai_1
X$424 VNB|VSS synth_9695 synth_9555 synth_8738 VDD VDD VNB|VSS
+ sky130_fd_sc_hd__nor2_4
X$425 VDD synth_12599 synth_12671 synth_9701 synth_12549 VNB|VSS synth_12628
+ VDD VNB|VSS sky130_fd_sc_hd__a22o_1
X$426 VDD synth_9931 synth_12091 synth_9160 synth_11798 VNB|VSS synth_11995 VDD
+ VNB|VSS sky130_fd_sc_hd__a22o_1
X$427 VDD synth_9895 synth_10217 synth_8946 synth_10103 VNB|VSS synth_10149 VDD
+ VNB|VSS sky130_fd_sc_hd__a22o_1
X$428 VDD synth_9160 synth_10352 synth_9931 synth_10647 VNB|VSS synth_10798 VDD
+ VNB|VSS sky130_fd_sc_hd__a22o_1
X$429 VDD synth_9931 synth_11278 synth_9160 synth_11325 VNB|VSS synth_11425 VDD
+ VNB|VSS sky130_fd_sc_hd__a22o_1
X$430 VDD synth_9932 synth_9515 synth_9062 synth_9855 VNB|VSS synth_9856 VDD
+ VNB|VSS sky130_fd_sc_hd__a22o_1
X$431 VDD synth_9931 synth_12135 synth_9160 synth_12055 VNB|VSS synth_12056 VDD
+ VNB|VSS sky130_fd_sc_hd__a22o_1
X$432 VDD synth_9434 synth_8604 VDD VNB|VSS synth_10170 VNB|VSS
+ sky130_fd_sc_hd__nand2b_2
X$433 VNB|VSS synth_12602 synth_12605 synth_12530 synth_12531 VDD synth_10888
+ VDD VNB|VSS sky130_fd_sc_hd__o31ai_2
X$434 VNB|VSS synth_11235 synth_11234 synth_11494 synth_11198 VDD synth_9001
+ VDD VNB|VSS sky130_fd_sc_hd__o31ai_2
X$435 VNB|VSS synth_9599 synth_9708 synth_9707 synth_9706 synth_9643 VDD VDD
+ VNB|VSS sky130_fd_sc_hd__fa_1
X$436 VNB|VSS synth_11274 synth_11329 synth_11173 synth_11328 synth_11172 VDD
+ VDD VNB|VSS sky130_fd_sc_hd__fa_1
X$437 VNB|VSS synth_9182 synth_9356 synth_9447 synth_9448 synth_9524 VDD VDD
+ VNB|VSS sky130_fd_sc_hd__fa_1
X$438 VNB|VSS synth_10957 synth_10955 synth_11028 synth_10874 synth_10954 VDD
+ VDD VNB|VSS sky130_fd_sc_hd__fa_1
X$439 VNB|VSS synth_10610 synth_10827 synth_10972 synth_10893 synth_10896 VDD
+ VDD VNB|VSS sky130_fd_sc_hd__fa_1
X$440 VNB|VSS synth_9011 synth_9030 synth_8809 synth_8877 synth_9031 VDD VDD
+ VNB|VSS sky130_fd_sc_hd__fa_1
X$441 VNB|VSS synth_12245 synth_12127 synth_12126 synth_12114 synth_12113 VDD
+ VDD VNB|VSS sky130_fd_sc_hd__fa_1
X$442 VNB|VSS synth_11039 synth_11035 synth_11034 synth_11025 synth_10879 VDD
+ VDD VNB|VSS sky130_fd_sc_hd__fa_1
X$443 VNB|VSS synth_10459 synth_10112 synth_10191 synth_10241 synth_10188 VDD
+ VDD VNB|VSS sky130_fd_sc_hd__fa_1
X$444 VNB|VSS synth_9245 synth_9462 synth_9460 synth_9369 synth_9521 VDD VDD
+ VNB|VSS sky130_fd_sc_hd__fa_1
X$445 VNB|VSS synth_11821 synth_11756 synth_11701 synth_11758 synth_11757 VDD
+ VDD VNB|VSS sky130_fd_sc_hd__fa_1
X$446 VNB|VSS synth_12179 synth_12079 synth_11997 synth_12077 synth_11888 VDD
+ VDD VNB|VSS sky130_fd_sc_hd__fa_1
X$447 VNB|VSS synth_9935 synth_10015 synth_10207 synth_9865 synth_10138 VDD VDD
+ VNB|VSS sky130_fd_sc_hd__fa_1
X$448 VNB|VSS synth_8238 synth_9309 synth_9311 synth_8833 synth_8997 VDD VDD
+ VNB|VSS sky130_fd_sc_hd__nand4_2
X$449 VDD synth_8710 synth_8919 synth_8984 synth_8947 synth_8803 VDD synth_8986
+ VNB|VSS VNB|VSS sky130_fd_sc_hd__o2111ai_1
X$450 VDD synth_10793 synth_11092 synth_11009 synth_9565 synth_10795 VDD
+ synth_11224 VNB|VSS VNB|VSS sky130_fd_sc_hd__o2111ai_1
X$451 VDD synth_8311 synth_8314 synth_8787 synth_8432 synth_8707 VDD synth_8460
+ VNB|VSS VNB|VSS sky130_fd_sc_hd__o2111ai_1
X$452 VDD synth_9062 synth_10407 synth_9627 synth_10308 synth_10372 VDD
+ synth_10309 VNB|VSS VNB|VSS sky130_fd_sc_hd__o2111ai_1
X$453 VDD synth_9431 synth_9432 synth_9557 synth_8945 synth_9474 VDD synth_9285
+ VNB|VSS VNB|VSS sky130_fd_sc_hd__o2111ai_1
X$454 VDD synth_8805 synth_10730 synth_10444 synth_9775 synth_8948 VDD
+ synth_10779 VNB|VSS VNB|VSS sky130_fd_sc_hd__o2111ai_1
X$455 VDD synth_11929 synth_11975 synth_11906 synth_12029 synth_8870 VDD
+ synth_11457 VNB|VSS VNB|VSS sky130_fd_sc_hd__o2111ai_1
X$456 VDD synth_8560 synth_8583 synth_8588 VDD VNB|VSS synth_8015 VNB|VSS
+ sky130_fd_sc_hd__or3_2
X$457 sky130_fd_sc_hd__conb_1
X$458 sky130_fd_sc_hd__conb_1
X$459 sky130_fd_sc_hd__conb_1
X$460 sky130_fd_sc_hd__conb_1
X$461 sky130_fd_sc_hd__conb_1
X$462 sky130_fd_sc_hd__conb_1
X$463 sky130_fd_sc_hd__conb_1
X$464 sky130_fd_sc_hd__conb_1
X$465 sky130_fd_sc_hd__conb_1
X$466 sky130_fd_sc_hd__conb_1
X$467 sky130_fd_sc_hd__conb_1
X$468 sky130_fd_sc_hd__conb_1
X$469 sky130_fd_sc_hd__conb_1
X$470 sky130_fd_sc_hd__conb_1
X$471 sky130_fd_sc_hd__conb_1
X$472 sky130_fd_sc_hd__conb_1
X$473 sky130_fd_sc_hd__conb_1
X$474 VDD synth_9677 synth_9474 synth_8870 VDD synth_11164 VNB|VSS VNB|VSS
+ sky130_fd_sc_hd__a21oi_2
X$475 VDD synth_10444 synth_10231 synth_10446 synth_10374 VDD synth_10375
+ VNB|VSS VNB|VSS sky130_fd_sc_hd__a22oi_1
X$476 VDD synth_9387 synth_10942 synth_10578 synth_10778 VDD synth_10982
+ VNB|VSS VNB|VSS sky130_fd_sc_hd__a22oi_1
X$477 VDD synth_9629 synth_11214 synth_10652 synth_10489 VDD synth_12489
+ VNB|VSS VNB|VSS sky130_fd_sc_hd__a22oi_1
X$478 VDD synth_10212 synth_11122 synth_9699 synth_10441 VDD synth_11014
+ VNB|VSS VNB|VSS sky130_fd_sc_hd__a22oi_1
X$479 VDD synth_10793 synth_9895 synth_8870 synth_12452 VDD synth_10770 VNB|VSS
+ VNB|VSS sky130_fd_sc_hd__a22oi_1
X$480 VDD synth_9239 synth_8945 synth_9483 synth_10007 VDD synth_10866 VNB|VSS
+ VNB|VSS sky130_fd_sc_hd__a22oi_1
X$481 VDD synth_10578 synth_10440 synth_9895 synth_10840 VDD synth_10645
+ VNB|VSS VNB|VSS sky130_fd_sc_hd__a22oi_1
X$482 VDD synth_9474 synth_9851 synth_9119 synth_8946 VDD synth_9742 VNB|VSS
+ VNB|VSS sky130_fd_sc_hd__a22oi_1
X$483 VDD synth_10697 synth_10939 synth_8803 synth_10940 VDD synth_10987
+ VNB|VSS VNB|VSS sky130_fd_sc_hd__a22oi_1
X$484 VDD synth_9474 synth_9628 synth_9738 synth_9431 VDD synth_9662 VNB|VSS
+ VNB|VSS sky130_fd_sc_hd__a22oi_1
X$485 VDD synth_10312 synth_10494 synth_9063 synth_10371 VDD synth_10404
+ VNB|VSS VNB|VSS sky130_fd_sc_hd__a22oi_1
X$486 VDD synth_10060 synth_9234 synth_9387 synth_9927 VDD synth_9982 VNB|VSS
+ VNB|VSS sky130_fd_sc_hd__a22oi_1
X$487 VDD synth_10285 synth_9927 synth_8870 synth_10007 VDD synth_12396 VNB|VSS
+ VNB|VSS sky130_fd_sc_hd__a22oi_1
X$488 VDD synth_10097 synth_10011 synth_9926 synth_9907 VDD synth_10098 VNB|VSS
+ VNB|VSS sky130_fd_sc_hd__a22oi_1
X$489 VDD synth_9036 synth_9172 synth_10169 synth_9175 VDD synth_12639 VNB|VSS
+ VNB|VSS sky130_fd_sc_hd__a22oi_1
X$490 VDD synth_6695 synth_8813 synth_8814 synth_8654 VDD synth_8889 VNB|VSS
+ VNB|VSS sky130_fd_sc_hd__a22oi_1
X$491 VDD synth_7670 synth_7505 synth_7750 synth_6695 VDD synth_7813 VNB|VSS
+ VNB|VSS sky130_fd_sc_hd__a22oi_1
X$492 VDD synth_10440 synth_10441 synth_10511 synth_9930 VDD synth_10512
+ VNB|VSS VNB|VSS sky130_fd_sc_hd__a22oi_1
X$493 VDD synth_9234 synth_11728 synth_10793 synth_11729 VDD synth_9680 VNB|VSS
+ VNB|VSS sky130_fd_sc_hd__a22oi_1
X$494 VDD synth_8870 synth_9105 synth_9112 synth_9235 VDD synth_9390 VNB|VSS
+ VNB|VSS sky130_fd_sc_hd__a22oi_1
X$495 VDD synth_8770 synth_8654 synth_6695 synth_8482 VDD synth_8891 VNB|VSS
+ VNB|VSS sky130_fd_sc_hd__a22oi_1
X$496 VDD synth_10312 synth_11636 synth_9629 synth_11900 VDD synth_11994
+ VNB|VSS VNB|VSS sky130_fd_sc_hd__a22oi_1
X$497 VDD synth_10652 synth_10899 synth_9629 synth_10867 VDD synth_10977
+ VNB|VSS VNB|VSS sky130_fd_sc_hd__a22oi_1
X$498 VDD synth_9042 synth_11288 synth_9701 synth_10511 VDD synth_11627 VNB|VSS
+ VNB|VSS sky130_fd_sc_hd__a22oi_1
X$499 VDD synth_9063 synth_9473 synth_9036 synth_9824 VDD synth_9825 VNB|VSS
+ VNB|VSS sky130_fd_sc_hd__a22oi_1
X$500 VNB|VSS synth_7420 synth_7286 synth_7341 VDD VDD VNB|VSS
+ sky130_fd_sc_hd__nor2b_4
X$501 VDD synth_7341 synth_7286 VDD synth_7500 VNB|VSS VNB|VSS
+ sky130_fd_sc_hd__and2_2
X$502 VDD synth_9366 synth_9273 VDD synth_9197 VNB|VSS VNB|VSS
+ sky130_fd_sc_hd__xor2_1
X$503 VDD synth_8132 synth_8093 VDD synth_8181 VNB|VSS VNB|VSS
+ sky130_fd_sc_hd__xor2_1
X$504 VDD synth_11546 synth_11681 VDD synth_11775 VNB|VSS VNB|VSS
+ sky130_fd_sc_hd__xor2_1
X$505 VDD synth_8964 synth_8885 VDD synth_8955 VNB|VSS VNB|VSS
+ sky130_fd_sc_hd__xor2_1
X$506 VDD synth_9799 synth_9866 VDD synth_9588 VNB|VSS VNB|VSS
+ sky130_fd_sc_hd__xor2_1
X$507 VDD synth_11563 synth_11543 VDD synth_11602 VNB|VSS VNB|VSS
+ sky130_fd_sc_hd__xor2_1
X$508 VDD synth_7342 synth_4531 VDD synth_7343 VNB|VSS VNB|VSS
+ sky130_fd_sc_hd__xor2_1
X$509 VDD synth_7344 synth_4598 VDD synth_7284 VNB|VSS VNB|VSS
+ sky130_fd_sc_hd__xor2_1
X$510 VDD synth_8673 synth_8638 VDD synth_8596 VNB|VSS VNB|VSS
+ sky130_fd_sc_hd__xor2_1
X$511 VDD synth_11608 synth_11478 VDD synth_11607 VNB|VSS VNB|VSS
+ sky130_fd_sc_hd__xor2_1
X$512 VDD synth_12118 synth_12001 VDD synth_12002 VNB|VSS VNB|VSS
+ sky130_fd_sc_hd__xor2_1
X$513 VDD synth_12473 synth_12533 VDD synth_12731 VNB|VSS VNB|VSS
+ sky130_fd_sc_hd__xor2_1
X$514 VDD synth_9351 synth_9187 VDD synth_9185 VNB|VSS VNB|VSS
+ sky130_fd_sc_hd__xor2_1
X$515 VDD synth_9945 synth_9871 VDD synth_9946 VNB|VSS VNB|VSS
+ sky130_fd_sc_hd__xor2_1
X$516 VDD synth_9249 synth_9269 VDD synth_9452 VNB|VSS VNB|VSS
+ sky130_fd_sc_hd__xor2_1
X$517 VDD synth_9941 synth_9721 VDD synth_9781 VNB|VSS VNB|VSS
+ sky130_fd_sc_hd__xor2_1
X$518 VDD synth_11616 synth_11475 VDD synth_11548 VNB|VSS VNB|VSS
+ sky130_fd_sc_hd__xor2_1
X$519 VDD synth_10734 synth_10606 VDD synth_10735 VNB|VSS VNB|VSS
+ sky130_fd_sc_hd__xor2_1
X$520 VDD synth_9266 synth_9252 VDD synth_9251 VNB|VSS VNB|VSS
+ sky130_fd_sc_hd__xor2_1
X$521 VDD synth_7514 synth_7501 VDD synth_7503 VNB|VSS VNB|VSS
+ sky130_fd_sc_hd__xor2_1
X$522 VDD synth_12308 synth_12307 VDD synth_12378 VNB|VSS VNB|VSS
+ sky130_fd_sc_hd__xor2_1
X$523 VDD synth_8560 synth_8478 VDD synth_8587 VNB|VSS VNB|VSS
+ sky130_fd_sc_hd__xor2_1
X$524 VDD synth_10528 synth_10398 VDD synth_10456 VNB|VSS VNB|VSS
+ sky130_fd_sc_hd__xor2_1
X$525 VDD synth_9335 synth_9271 VDD synth_9438 VNB|VSS VNB|VSS
+ sky130_fd_sc_hd__xor2_1
X$526 VDD synth_12672 synth_12413 VDD synth_12728 VNB|VSS VNB|VSS
+ sky130_fd_sc_hd__xor2_1
X$527 VDD synth_11019 synth_11020 VDD synth_11174 VNB|VSS VNB|VSS
+ sky130_fd_sc_hd__xor2_1
X$528 VDD synth_8414 synth_8331 VDD synth_8416 VNB|VSS VNB|VSS
+ sky130_fd_sc_hd__xor2_1
X$529 VDD synth_12471 synth_12470 VDD synth_12618 VNB|VSS VNB|VSS
+ sky130_fd_sc_hd__xor2_1
X$530 VDD synth_8205 synth_8017 VDD synth_8272 VNB|VSS VNB|VSS
+ sky130_fd_sc_hd__xor2_1
X$531 VDD synth_7519 synth_7341 VDD synth_7517 VNB|VSS VNB|VSS
+ sky130_fd_sc_hd__xor2_1
X$532 VDD synth_9869 synth_9870 VDD synth_10034 VNB|VSS VNB|VSS
+ sky130_fd_sc_hd__xor2_1
X$533 VDD synth_12060 synth_12061 VDD synth_12125 VNB|VSS VNB|VSS
+ sky130_fd_sc_hd__xor2_1
X$534 VDD synth_7587 synth_7423 VDD synth_7676 VNB|VSS VNB|VSS
+ sky130_fd_sc_hd__xor2_1
X$535 VDD synth_10818 synth_10889 VDD synth_10871 VNB|VSS VNB|VSS
+ sky130_fd_sc_hd__xor2_1
X$536 VDD synth_10656 synth_10679 VDD synth_10732 VNB|VSS VNB|VSS
+ sky130_fd_sc_hd__xor2_1
X$537 VDD synth_8115 synth_8024 VDD synth_8111 VNB|VSS VNB|VSS
+ sky130_fd_sc_hd__xor2_1
X$538 VNB|VSS synth_10290 VDD synth_9677 synth_8870 VDD VNB|VSS
+ sky130_fd_sc_hd__nor2_2
X$539 VNB|VSS synth_5984 VDD synth_10997 synth_11054 VDD VNB|VSS
+ sky130_fd_sc_hd__nor2_2
X$540 VNB|VSS synth_12239 VDD synth_10578 synth_9677 VDD VNB|VSS
+ sky130_fd_sc_hd__nor2_2
X$541 VNB|VSS synth_11463 VDD synth_9387 synth_10312 VDD VNB|VSS
+ sky130_fd_sc_hd__nor2_2
X$542 VNB|VSS synth_9701 VDD synth_10652 synth_9629 VDD VNB|VSS
+ sky130_fd_sc_hd__nor2_2
X$543 VNB|VSS synth_11095 VDD synth_8806 synth_10212 VDD VNB|VSS
+ sky130_fd_sc_hd__nor2_2
X$544 VNB|VSS synth_9432 VDD synth_8765 synth_9774 VDD VNB|VSS
+ sky130_fd_sc_hd__nor2_2
X$545 VNB|VSS synth_10615 VDD synth_9112 synth_9700 VDD VNB|VSS
+ sky130_fd_sc_hd__nor2_2
X$546 VNB|VSS synth_9175 VDD synth_8803 synth_10285 VDD VNB|VSS
+ sky130_fd_sc_hd__nor2_2
X$547 VNB|VSS synth_9773 VDD synth_9427 synth_9233 VDD VNB|VSS
+ sky130_fd_sc_hd__nor2_2
X$548 VNB|VSS synth_10726 VDD synth_9677 synth_8981 VDD VNB|VSS
+ sky130_fd_sc_hd__nor2_2
X$549 VNB|VSS synth_10011 VDD synth_10285 synth_10212 VDD VNB|VSS
+ sky130_fd_sc_hd__nor2_2
X$550 VNB|VSS synth_7420 synth_7668 synth_1456 VDD VDD VNB|VSS
+ sky130_fd_sc_hd__nand2_8
X$551 VNB|VSS synth_7499 synth_7746 synth_1070 VDD VDD VNB|VSS
+ sky130_fd_sc_hd__nand2_8
X$552 VNB|VSS synth_7499 synth_7668 synth_647 VDD VDD VNB|VSS
+ sky130_fd_sc_hd__nand2_8
X$553 VDD synth_7501 synth_7423 synth_6374 VNB|VSS VDD synth_4530 VNB|VSS
+ sky130_fd_sc_hd__and3_2
X$554 VNB|VSS synth_7499 synth_7421 synth_877 VDD VDD VNB|VSS
+ sky130_fd_sc_hd__nand2_8
X$555 VNB|VSS synth_7337 synth_7421 synth_1125 VDD VDD VNB|VSS
+ sky130_fd_sc_hd__nand2_8
X$556 VNB|VSS synth_7337 synth_7668 synth_1711 VDD VDD VNB|VSS
+ sky130_fd_sc_hd__nand2_8
X$557 VDD synth_7802 VDD VNB|VSS synth_7747 VNB|VSS
+ sky130_fd_sc_hd__clkdlybuf4s15_2
X$558 VNB|VSS synth_7499 synth_7437 synth_560 VDD VDD VNB|VSS
+ sky130_fd_sc_hd__nand2_8
X$559 VNB|VSS synth_7500 synth_7668 synth_580 VDD VDD VNB|VSS
+ sky130_fd_sc_hd__nand2_8
X$560 VNB|VSS synth_7500 synth_7746 synth_939 VDD VDD VNB|VSS
+ sky130_fd_sc_hd__nand2_8
X$561 VNB|VSS synth_7420 synth_7421 synth_545 VDD VDD VNB|VSS
+ sky130_fd_sc_hd__nand2_8
X$562 VNB|VSS synth_7420 synth_7437 synth_995 VDD VDD VNB|VSS
+ sky130_fd_sc_hd__nand2_8
X$563 VNB|VSS synth_7420 synth_7746 synth_1094 VDD VDD VNB|VSS
+ sky130_fd_sc_hd__nand2_8
X$564 VNB|VSS synth_7500 synth_7437 synth_513 VDD VDD VNB|VSS
+ sky130_fd_sc_hd__nand2_8
X$565 VNB|VSS synth_6452 clk synth_7537 VDD VDD VNB|VSS
+ sky130_fd_sc_hd__dlclkp_1
X$566 VNB|VSS synth_6730 synth_6728 synth_6727 VDD VDD VNB|VSS
+ sky130_fd_sc_hd__dlclkp_1
X$567 VDD synth_9583 synth_9427 synth_11510 VNB|VSS VDD synth_11571 VNB|VSS
+ sky130_fd_sc_hd__a21boi_0
X$568 VDD synth_10486 synth_9063 synth_9775 VNB|VSS VDD synth_10775 VNB|VSS
+ sky130_fd_sc_hd__a21boi_0
X$569 VDD synth_10943 synth_9063 synth_10840 VNB|VSS VDD synth_11063 VNB|VSS
+ sky130_fd_sc_hd__a21boi_0
X$570 VDD synth_9376 synth_9112 synth_8946 VNB|VSS VDD synth_9377 VNB|VSS
+ sky130_fd_sc_hd__a21boi_0
X$571 VDD synth_12168 synth_9292 synth_12216 synth_8870 synth_11648 VDD VNB|VSS
+ synth_12105 VNB|VSS sky130_fd_sc_hd__a221oi_1
X$572 VDD synth_11463 synth_11598 synth_11678 synth_11596 synth_9062 VDD
+ VNB|VSS synth_11440 VNB|VSS sky130_fd_sc_hd__a221oi_1
X$573 VDD synth_11454 synth_11572 synth_11506 synth_11453 synth_11507 VDD
+ VNB|VSS synth_9313 VNB|VSS sky130_fd_sc_hd__a221oi_1
X$574 VDD synth_9497 synth_9498 synth_9464 synth_9607 synth_9413 VDD VNB|VSS
+ synth_9546 VNB|VSS sky130_fd_sc_hd__a221oi_1
X$575 VDD synth_9851 synth_9895 synth_11222 synth_8806 synth_11064 VDD VNB|VSS
+ synth_11282 VNB|VSS sky130_fd_sc_hd__a221oi_1
X$576 VDD synth_8627 synth_8755 synth_8442 synth_8740 synth_8797 VDD VNB|VSS
+ synth_8796 VNB|VSS sky130_fd_sc_hd__a221oi_1
X$577 VDD synth_12643 synth_8803 synth_11229 synth_10285 synth_11320 VDD
+ VNB|VSS synth_11441 VNB|VSS sky130_fd_sc_hd__a221oi_1
X$578 VDD synth_9835 synth_8604 synth_9745 synth_8764 synth_9768 VDD VNB|VSS
+ synth_9766 VNB|VSS sky130_fd_sc_hd__a221oi_1
X$579 VDD synth_9234 synth_10438 synth_10724 synth_11138 synth_8710 VDD VNB|VSS
+ synth_11165 VNB|VSS sky130_fd_sc_hd__a221oi_1
X$580 VDD synth_9605 synth_9427 synth_9587 synth_9434 synth_9467 VDD VNB|VSS
+ synth_9586 VNB|VSS sky130_fd_sc_hd__a221oi_1
X$581 VDD synth_11291 synth_9434 synth_10988 synth_9895 synth_9292 VDD VNB|VSS
+ synth_11436 VNB|VSS sky130_fd_sc_hd__a221oi_1
X$582 VDD synth_10441 synth_9775 synth_10689 synth_10652 synth_8806 VDD VNB|VSS
+ synth_10781 VNB|VSS sky130_fd_sc_hd__a221oi_1
X$583 VDD synth_9907 synth_9322 synth_10938 synth_9232 synth_10793 VDD VNB|VSS
+ synth_11008 VNB|VSS sky130_fd_sc_hd__a221oi_1
X$584 VDD synth_9895 synth_8806 synth_11731 synth_10652 synth_10833 VDD VNB|VSS
+ synth_11597 VNB|VSS sky130_fd_sc_hd__a221oi_1
X$585 VDD synth_10059 synth_9978 synth_9480 synth_8872 synth_10008 VDD VNB|VSS
+ synth_10058 VNB|VSS sky130_fd_sc_hd__a221oi_1
X$586 VDD synth_10582 synth_9119 synth_10581 synth_8805 synth_9666 VDD VNB|VSS
+ synth_10548 VNB|VSS sky130_fd_sc_hd__a221oi_1
X$587 VDD synth_10441 synth_8946 synth_12212 synth_8805 synth_12174 VDD VNB|VSS
+ synth_12208 VNB|VSS sky130_fd_sc_hd__a221oi_1
X$588 VDD synth_9900 synth_9677 synth_10797 synth_9387 synth_10003 VDD VNB|VSS
+ synth_10941 VNB|VSS sky130_fd_sc_hd__a221oi_1
X$589 VDD synth_9769 synth_8764 synth_9770 synth_9292 synth_9767 VDD VNB|VSS
+ synth_9698 VNB|VSS sky130_fd_sc_hd__a221oi_1
X$590 VDD synth_10627 VNB|VSS synth_6023 VDD VNB|VSS sky130_fd_sc_hd__buf_2
X$591 VDD synth_7805 VNB|VSS synth_6469 VDD VNB|VSS sky130_fd_sc_hd__buf_2
X$592 VNB|VSS synth_11084 synth_11455 synth_11669 synth_11671 synth_11670 VDD
+ VDD VNB|VSS sky130_fd_sc_hd__nor4_4
X$593 VNB|VSS synth_11081 synth_11664 synth_11666 synth_11665 synth_11505 VDD
+ VDD VNB|VSS sky130_fd_sc_hd__nor4_4
X$594 VNB|VSS synth_11076 synth_10819 synth_10852 synth_10930 synth_11120 VDD
+ VDD VNB|VSS sky130_fd_sc_hd__nor4_4
X$595 VNB|VSS synth_8467 synth_8862 synth_8849 synth_8921 synth_8797 VDD VDD
+ VNB|VSS sky130_fd_sc_hd__nor4_4
X$596 VNB|VSS synth_8997 synth_9220 synth_9375 synth_9221 synth_9169 VDD VDD
+ VNB|VSS sky130_fd_sc_hd__nor4_4
X$597 VNB|VSS synth_4185 synth_8311 synth_8279 synth_8237 synth_8238 VDD VDD
+ VNB|VSS sky130_fd_sc_hd__or4_4
X$598 VDD synth_10212 synth_8831 VNB|VSS VDD synth_10234 VNB|VSS
+ sky130_fd_sc_hd__nor2b_2
X$599 VDD synth_9474 synth_9677 VNB|VSS VDD synth_11221 VNB|VSS
+ sky130_fd_sc_hd__nor2b_2
X$600 VDD synth_8831 synth_8604 VNB|VSS VDD synth_9037 VNB|VSS
+ sky130_fd_sc_hd__nor2b_2
X$601 VDD synth_4598 synth_4531 VNB|VSS VDD synth_4627 VNB|VSS
+ sky130_fd_sc_hd__nor2b_2
X$602 VDD synth_10312 synth_9629 VNB|VSS VDD synth_10863 VNB|VSS
+ sky130_fd_sc_hd__nor2b_2
X$603 VDD synth_10312 synth_8806 VNB|VSS VDD synth_10489 VNB|VSS
+ sky130_fd_sc_hd__nor2b_2
X$604 VDD synth_8738 synth_8604 VNB|VSS VDD synth_8987 VNB|VSS
+ sky130_fd_sc_hd__nor2b_2
X$605 VNB|VSS synth_6497 synth_6360 synth_6441 synth_2233 synth_2386 synth_6406
+ VDD VDD VNB|VSS sky130_fd_sc_hd__o221a_2
X$606 VNB|VSS synth_4936 synth_4598 synth_4531 synth_4821 VDD VDD VNB|VSS
+ sky130_fd_sc_hd__nand3_2
X$607 VNB|VSS synth_6636 synth_4598 synth_4531 synth_4653 VDD VDD VNB|VSS
+ sky130_fd_sc_hd__nand3_2
X$608 VNB|VSS synth_2807 synth_4598 synth_4531 synth_4527 VDD VDD VNB|VSS
+ sky130_fd_sc_hd__nand3_2
X$609 VNB|VSS synth_5138 VDD synth_4627 synth_4653 VDD VNB|VSS
+ sky130_fd_sc_hd__nand2_2
X$610 VNB|VSS synth_7350 VDD synth_7337 synth_7437 VDD VNB|VSS
+ sky130_fd_sc_hd__nand2_2
X$611 VNB|VSS synth_7337 VDD synth_7341 synth_7286 VDD VNB|VSS
+ sky130_fd_sc_hd__nor2_2
X$612 VNB|VSS synth_3107 VDD synth_4527 synth_4628 VDD VNB|VSS
+ sky130_fd_sc_hd__nand2_2
X$613 VNB|VSS synth_5129 VDD synth_4627 synth_6044 VDD VNB|VSS
+ sky130_fd_sc_hd__nand2_2
X$614 VNB|VSS synth_7819 VDD synth_4527 synth_7495 VDD VNB|VSS
+ sky130_fd_sc_hd__nand2_2
X$615 VNB|VSS synth_7000 VDD synth_6044 synth_7495 VDD VNB|VSS
+ sky130_fd_sc_hd__nand2_2
X$616 VNB|VSS synth_8765 VDD synth_4747 synth_8675 VDD VNB|VSS
+ sky130_fd_sc_hd__nand2_2
X$617 VNB|VSS synth_514 VDD synth_4821 synth_4628 VDD VNB|VSS
+ sky130_fd_sc_hd__nand2_2
X$618 VNB|VSS synth_9240 VDD synth_9481 synth_9232 VDD VNB|VSS
+ sky130_fd_sc_hd__nand2_2
X$619 VNB|VSS synth_570 VDD synth_4628 synth_4530 VDD VNB|VSS
+ sky130_fd_sc_hd__nand2_2
X$620 VNB|VSS synth_10099 VDD synth_9474 synth_8738 VDD VNB|VSS
+ sky130_fd_sc_hd__nand2_2
X$621 VNB|VSS synth_550 VDD synth_4627 synth_4527 VDD VNB|VSS
+ sky130_fd_sc_hd__nand2_2
X$622 VNB|VSS synth_7777 VDD synth_4530 synth_7495 VDD VNB|VSS
+ sky130_fd_sc_hd__nand2_2
X$623 VNB|VSS synth_7780 VDD synth_4653 synth_7495 VDD VNB|VSS
+ sky130_fd_sc_hd__nand2_2
X$624 VNB|VSS synth_509 VDD synth_4653 synth_4628 VDD VNB|VSS
+ sky130_fd_sc_hd__nand2_2
X$625 VDD synth_8517 synth_8437 synth_8361 synth_8435 synth_8518 VNB|VSS VDD
+ synth_8432 VNB|VSS sky130_fd_sc_hd__a2111oi_0
X$626 VDD synth_5505 synth_5345 synth_5507 synth_5528 synth_5587 VNB|VSS VDD
+ synth_5105 VNB|VSS sky130_fd_sc_hd__a2111oi_0
X$627 VDD synth_9042 synth_12304 synth_12240 synth_10312 synth_12276 VNB|VSS
+ VDD synth_12219 VNB|VSS sky130_fd_sc_hd__a2111oi_0
X$628 VDD synth_9040 synth_9113 synth_9039 synth_8806 synth_9038 VNB|VSS VDD
+ synth_9009 VNB|VSS sky130_fd_sc_hd__a2111oi_0
X$629 VDD synth_9042 synth_9104 synth_9041 synth_8764 synth_8948 VNB|VSS VDD
+ synth_9040 VNB|VSS sky130_fd_sc_hd__a2111oi_0
X$630 VDD synth_11303 synth_11236 synth_10819 synth_11233 synth_11195 VNB|VSS
+ VDD synth_11234 VNB|VSS sky130_fd_sc_hd__a2111oi_0
X$631 VDD synth_8710 synth_9392 synth_9393 synth_9234 synth_9391 VNB|VSS VDD
+ synth_9288 VNB|VSS sky130_fd_sc_hd__a2111oi_0
X$632 VDD synth_8870 synth_9175 synth_9172 synth_9044 synth_9047 VNB|VSS VDD
+ synth_9236 VNB|VSS sky130_fd_sc_hd__a2111oi_0
X$633 VDD synth_5507 synth_5586 synth_5614 synth_5564 synth_5566 VNB|VSS VDD
+ synth_4893 VNB|VSS sky130_fd_sc_hd__a2111oi_0
X$634 VDD synth_8805 synth_9062 synth_10580 synth_8806 synth_10171 VNB|VSS VDD
+ synth_10682 VNB|VSS sky130_fd_sc_hd__a2111oi_0
X$635 VDD synth_10793 synth_9895 synth_8945 synth_10312 synth_12236 VNB|VSS VDD
+ synth_12654 VNB|VSS sky130_fd_sc_hd__a2111oi_0
X$636 VDD synth_9429 synth_9672 synth_9668 synth_9434 synth_9771 VNB|VSS VDD
+ synth_10008 VNB|VSS sky130_fd_sc_hd__a2111oi_0
X$637 VDD synth_5265 synth_5211 synth_5346 synth_5267 VNB|VSS synth_5345 VDD
+ VNB|VSS sky130_fd_sc_hd__nor4b_1
X$638 VDD synth_6752 synth_6637 synth_6874 synth_6753 VNB|VSS synth_6904 VDD
+ VNB|VSS sky130_fd_sc_hd__nor4b_1
X$639 VDD synth_8311 synth_8279 synth_8237 synth_8238 VNB|VSS synth_9054 VDD
+ VNB|VSS sky130_fd_sc_hd__nor4b_1
X$640 VDD synth_9313 synth_9001 synth_9002 synth_8794 VNB|VSS VDD synth_6497
+ VNB|VSS sky130_fd_sc_hd__o211a_1
X$641 VDD synth_11345 synth_11680 synth_11603 synth_11682 synth_11604 VNB|VSS
+ VDD VNB|VSS sky130_fd_sc_hd__o31a_1
X$642 VDD synth_11085 synth_11160 synth_11359 synth_11244 synth_11357 VNB|VSS
+ VDD VNB|VSS sky130_fd_sc_hd__o31a_1
X$643 VDD synth_11191 synth_11193 synth_11412 synth_11347 synth_11297 VNB|VSS
+ VDD VNB|VSS sky130_fd_sc_hd__o31a_1
X$644 VDD synth_10824 synth_10893 synth_10823 synth_10607 synth_10799 VNB|VSS
+ VDD VNB|VSS sky130_fd_sc_hd__o31a_1
X$645 VDD synth_8639 synth_8556 synth_8669 synth_8476 synth_8640 VNB|VSS VDD
+ VNB|VSS sky130_fd_sc_hd__o31a_1
X$646 VDD synth_9333 synth_9369 synth_9368 synth_9336 synth_9334 VNB|VSS VDD
+ VNB|VSS sky130_fd_sc_hd__o31a_1
X$647 VDD synth_9656 synth_9782 synth_9780 synth_9805 synth_9882 VNB|VSS VDD
+ VNB|VSS sky130_fd_sc_hd__o31a_1
X$648 VDD synth_12077 synth_12330 synth_12414 synth_12362 synth_12436 VNB|VSS
+ VDD VNB|VSS sky130_fd_sc_hd__o31a_1
X$649 VDD synth_12312 synth_12255 synth_12483 synth_12417 synth_12480 VNB|VSS
+ VDD VNB|VSS sky130_fd_sc_hd__o31a_1
X$650 VDD synth_11758 synth_11874 synth_12006 synth_11944 synth_11946 VNB|VSS
+ VDD VNB|VSS sky130_fd_sc_hd__o31a_1
X$651 VDD synth_6663 synth_6633 synth_6711 synth_6773 synth_6712 VNB|VSS VDD
+ VNB|VSS sky130_fd_sc_hd__o31a_1
X$652 VDD synth_4276 synth_4275 synth_4576 synth_4357 synth_4248 VNB|VSS VDD
+ VNB|VSS sky130_fd_sc_hd__o31a_1
X$653 VDD synth_8806 synth_10774 synth_10654 VNB|VSS VDD synth_10581 VNB|VSS
+ sky130_fd_sc_hd__a21o_1
X$654 VDD synth_11756 synth_11767 synth_11755 VNB|VSS VDD synth_11825 VNB|VSS
+ sky130_fd_sc_hd__a21o_1
X$655 VDD synth_12178 synth_12203 synth_12177 VNB|VSS VDD synth_12112 VNB|VSS
+ sky130_fd_sc_hd__a21o_1
X$656 VDD synth_12079 synth_12080 synth_11996 VNB|VSS VDD synth_12203 VNB|VSS
+ sky130_fd_sc_hd__a21o_1
X$657 VDD synth_12127 synth_12181 synth_12115 VNB|VSS VDD synth_12198 VNB|VSS
+ sky130_fd_sc_hd__a21o_1
X$658 VDD synth_8634 synth_8636 synth_8635 VNB|VSS VDD synth_8555 VNB|VSS
+ sky130_fd_sc_hd__a21o_1
X$659 VDD synth_9182 synth_9181 synth_9255 VNB|VSS VDD synth_9262 VNB|VSS
+ sky130_fd_sc_hd__a21o_1
X$660 VDD synth_8952 synth_8874 synth_8951 VNB|VSS VDD synth_8636 VNB|VSS
+ sky130_fd_sc_hd__a21o_1
X$661 VDD synth_9462 synth_9544 synth_9437 VNB|VSS VDD synth_9372 VNB|VSS
+ sky130_fd_sc_hd__a21o_1
X$662 VDD synth_12363 synth_12364 synth_12365 VNB|VSS VDD synth_12431 VNB|VSS
+ sky130_fd_sc_hd__a21o_1
X$663 VDD synth_9470 synth_10142 synth_9063 VNB|VSS VDD synth_10406 VNB|VSS
+ sky130_fd_sc_hd__a21o_1
X$664 VDD synth_8952 synth_9011 synth_8951 VNB|VSS VDD synth_8711 VNB|VSS
+ sky130_fd_sc_hd__a21o_1
X$665 VDD synth_11998 synth_11882 synth_12058 VNB|VSS VDD synth_12059 VNB|VSS
+ sky130_fd_sc_hd__a21o_1
X$666 VDD synth_11408 synth_11338 synth_11402 VNB|VSS VDD synth_11552 VNB|VSS
+ sky130_fd_sc_hd__a21o_1
X$667 VDD synth_9677 synth_11912 synth_10312 VNB|VSS VDD synth_12655 VNB|VSS
+ sky130_fd_sc_hd__a21o_1
X$668 VDD synth_10739 synth_10665 synth_10738 VNB|VSS VDD synth_10670 VNB|VSS
+ sky130_fd_sc_hd__a21o_1
X$669 VDD synth_8408 synth_8404 synth_8405 VNB|VSS VDD synth_8486 VNB|VSS
+ sky130_fd_sc_hd__a21o_1
X$670 VDD synth_10460 synth_10458 synth_10523 VNB|VSS VDD synth_10593 VNB|VSS
+ sky130_fd_sc_hd__a21o_1
X$671 VDD synth_4808 synth_4894 synth_3964 VNB|VSS VDD synth_4597 VNB|VSS
+ sky130_fd_sc_hd__a21o_1
X$672 VDD synth_10459 synth_10460 synth_10523 VNB|VSS VDD synth_10594 VNB|VSS
+ sky130_fd_sc_hd__a21o_1
X$673 VDD synth_9725 synth_9935 synth_9860 VNB|VSS VDD synth_9961 VNB|VSS
+ sky130_fd_sc_hd__a21o_1
X$674 VDD synth_10595 synth_10593 synth_10666 VNB|VSS VDD synth_10747 VNB|VSS
+ sky130_fd_sc_hd__a21o_1
X$675 VDD synth_10112 synth_10395 synth_10396 VNB|VSS VDD synth_10458 VNB|VSS
+ sky130_fd_sc_hd__a21o_1
X$676 VDD synth_8975 synth_9030 synth_8953 VNB|VSS VDD synth_8874 VNB|VSS
+ sky130_fd_sc_hd__a21o_1
X$677 VDD synth_12279 synth_12642 synth_10312 VNB|VSS VDD synth_12281 VNB|VSS
+ sky130_fd_sc_hd__a21o_1
X$678 VDD synth_9599 synth_9635 synth_9637 VNB|VSS VDD synth_9527 VNB|VSS
+ sky130_fd_sc_hd__a21o_1
X$679 VDD synth_9356 synth_9533 synth_9523 VNB|VSS VDD synth_9355 VNB|VSS
+ sky130_fd_sc_hd__a21o_1
X$680 VDD synth_9708 synth_9709 synth_9705 VNB|VSS VDD synth_9704 VNB|VSS
+ sky130_fd_sc_hd__a21o_1
X$681 VDD synth_11101 synth_11039 synth_11100 VNB|VSS VDD synth_11261 VNB|VSS
+ sky130_fd_sc_hd__a21o_1
X$682 VDD synth_10955 synth_11027 synth_11106 VNB|VSS VDD synth_11333 VNB|VSS
+ sky130_fd_sc_hd__a21o_1
X$683 VDD synth_12207 synth_12112 synth_12175 VNB|VSS VDD synth_12261 VNB|VSS
+ sky130_fd_sc_hd__a21o_1
X$684 VDD synth_12179 synth_12178 synth_12177 VNB|VSS VDD synth_12176 VNB|VSS
+ sky130_fd_sc_hd__a21o_1
X$685 VDD synth_11390 synth_11424 synth_11391 VNB|VSS VDD synth_11500 VNB|VSS
+ sky130_fd_sc_hd__a21o_1
X$686 VDD synth_10892 synth_10827 synth_10870 VNB|VSS VDD synth_10894 VNB|VSS
+ sky130_fd_sc_hd__a21o_1
X$687 VDD synth_8566 synth_8568 synth_8487 VNB|VSS VDD synth_8490 VNB|VSS
+ sky130_fd_sc_hd__a21o_1
X$688 VDD synth_11601 synth_11500 synth_11566 VNB|VSS VDD synth_11545 VNB|VSS
+ sky130_fd_sc_hd__a21o_1
X$689 VDD synth_9243 synth_9245 synth_9244 VNB|VSS VDD synth_9123 VNB|VSS
+ sky130_fd_sc_hd__a21o_1
X$690 VDD synth_12199 synth_12198 synth_12200 VNB|VSS VDD synth_12364 VNB|VSS
+ sky130_fd_sc_hd__a21o_1
X$691 VDD synth_11820 synth_11825 synth_11875 VNB|VSS VDD synth_11882 VNB|VSS
+ sky130_fd_sc_hd__a21o_1
X$692 VDD synth_10038 synth_10015 synth_10137 VNB|VSS VDD synth_9861 VNB|VSS
+ sky130_fd_sc_hd__a21o_1
X$693 VDD synth_7807 synth_7589 synth_7590 VNB|VSS VDD synth_7505 VNB|VSS
+ sky130_fd_sc_hd__a21o_1
X$694 VDD synth_11390 synth_11274 synth_11391 VNB|VSS VDD synth_11714 VNB|VSS
+ sky130_fd_sc_hd__a21o_1
X$695 VDD synth_11111 synth_11035 synth_11110 VNB|VSS VDD synth_11175 VNB|VSS
+ sky130_fd_sc_hd__a21o_1
X$696 VDD synth_10595 synth_10594 synth_10666 VNB|VSS VDD synth_10665 VNB|VSS
+ sky130_fd_sc_hd__a21o_1
X$697 VDD synth_10610 synth_10544 synth_10514 VNB|VSS VDD synth_10608 VNB|VSS
+ sky130_fd_sc_hd__a21o_1
X$698 VDD synth_12245 synth_12199 synth_12200 VNB|VSS VDD synth_12371 VNB|VSS
+ sky130_fd_sc_hd__a21o_1
X$699 VDD synth_11329 synth_11420 synth_11393 VNB|VSS VDD synth_11424 VNB|VSS
+ sky130_fd_sc_hd__a21o_1
X$700 VDD synth_11821 synth_11820 synth_11875 VNB|VSS VDD synth_11881 VNB|VSS
+ sky130_fd_sc_hd__a21o_1
X$701 VDD synth_4675 synth_4674 synth_4676 synth_3642 VNB|VSS VDD VNB|VSS
+ sky130_fd_sc_hd__nor3_2
X$702 VDD synth_9470 synth_10375 synth_10376 synth_8765 synth_9117 VDD VNB|VSS
+ synth_10239 VNB|VSS sky130_fd_sc_hd__o32ai_1
X$703 VDD synth_4034 synth_4066 synth_4108 synth_3798 synth_4109 VDD VNB|VSS
+ synth_4065 VNB|VSS sky130_fd_sc_hd__o32ai_1
X$704 VDD synth_3798 synth_4106 synth_3831 synth_4108 synth_4107 VDD VNB|VSS
+ synth_3729 VNB|VSS sky130_fd_sc_hd__o32ai_1
X$705 VDD synth_10727 synth_10645 synth_10646 synth_9387 synth_9474 VDD VNB|VSS
+ synth_10647 VNB|VSS sky130_fd_sc_hd__o32ai_1
X$706 VDD synth_9743 synth_8944 synth_9615 synth_9048 synth_9387 VDD VNB|VSS
+ synth_9515 VNB|VSS sky130_fd_sc_hd__o32ai_1
X$707 VDD synth_10840 synth_10615 synth_9396 synth_10988 synth_10793 VDD
+ VNB|VSS synth_9323 VNB|VSS sky130_fd_sc_hd__o32ai_1
X$708 VDD synth_9322 synth_10833 synth_9774 synth_11324 synth_10212 VDD VNB|VSS
+ synth_11326 VNB|VSS sky130_fd_sc_hd__o32ai_1
X$709 VDD synth_5194 synth_4403 synth_5195 synth_4257 synth_5196 VDD VNB|VSS
+ synth_4781 VNB|VSS sky130_fd_sc_hd__o32ai_1
X$710 VDD synth_4893 synth_3728 synth_4889 synth_4843 synth_4811 VDD VNB|VSS
+ synth_4892 VNB|VSS sky130_fd_sc_hd__o32ai_1
X$711 VDD synth_9283 synth_9116 synth_9204 synth_9114 synth_9117 VDD VNB|VSS
+ synth_8979 VNB|VSS sky130_fd_sc_hd__o32ai_1
X$712 VDD synth_10512 synth_10442 synth_9774 synth_8873 synth_10212 VDD VNB|VSS
+ synth_10552 VNB|VSS sky130_fd_sc_hd__o32ai_1
X$713 VDD synth_4355 synth_4419 synth_4420 synth_4245 synth_4274 VDD VNB|VSS
+ synth_4421 VNB|VSS sky130_fd_sc_hd__o32ai_1
X$714 VNB|VSS synth_10180 VDD VDD VNB|VSS sky130_fd_sc_hd__clkinv_16
X$715 VNB|VSS synth_5333 VDD VDD VNB|VSS sky130_fd_sc_hd__clkinv_16
X$716 VNB|VSS synth_4935 VDD VDD VNB|VSS sky130_fd_sc_hd__clkinv_16
X$717 VDD synth_5825 synth_5912 synth_5911 synth_5910 VNB|VSS VDD VNB|VSS
+ sky130_fd_sc_hd__or3b_2
X$718 VDD synth_8870 synth_8910 synth_8604 synth_9848 VNB|VSS VDD VNB|VSS
+ sky130_fd_sc_hd__or3b_2
X$719 VDD synth_10605 synth_10799 synth_10661 VDD synth_10816 VNB|VSS VNB|VSS
+ sky130_fd_sc_hd__o21a_1
X$720 VDD synth_9072 synth_9334 synth_9451 VDD synth_9362 VNB|VSS VNB|VSS
+ sky130_fd_sc_hd__o21a_1
X$721 VDD synth_11605 synth_11604 synth_11684 VDD synth_11496 VNB|VSS VNB|VSS
+ sky130_fd_sc_hd__o21a_1
X$722 VDD synth_10285 synth_10293 synth_11504 VDD synth_11579 VNB|VSS VNB|VSS
+ sky130_fd_sc_hd__o21a_1
X$723 VDD synth_10533 synth_10185 synth_9947 VDD synth_10602 VNB|VSS VNB|VSS
+ sky130_fd_sc_hd__o21a_1
X$724 VDD synth_8251 synth_8640 synth_8333 VDD synth_8641 VNB|VSS VNB|VSS
+ sky130_fd_sc_hd__o21a_1
X$725 VDD synth_9868 synth_9882 synth_9718 VDD synth_9796 VNB|VSS VNB|VSS
+ sky130_fd_sc_hd__o21a_1
X$726 VDD synth_12606 synth_12480 synth_12479 VDD synth_12478 VNB|VSS VNB|VSS
+ sky130_fd_sc_hd__o21a_1
X$727 VDD synth_10793 synth_10849 synth_10312 VDD synth_12300 VNB|VSS VNB|VSS
+ sky130_fd_sc_hd__o21a_1
X$728 VDD synth_6936 synth_7079 synth_6972 VDD synth_4712 VNB|VSS VNB|VSS
+ sky130_fd_sc_hd__o21a_1
X$729 VDD synth_12529 synth_12436 synth_12601 VDD synth_12530 VNB|VSS VNB|VSS
+ sky130_fd_sc_hd__o21a_1
X$730 VDD synth_12185 synth_11946 synth_12120 VDD synth_12252 VNB|VSS VNB|VSS
+ sky130_fd_sc_hd__o21a_1
X$731 VDD synth_7219 synth_6471 synth_7217 synth_7048 synth_6469 VDD synth_7278
+ VNB|VSS VNB|VSS sky130_fd_sc_hd__a311oi_1
X$732 VDD synth_6705 synth_6471 synth_6559 synth_6563 synth_6469 VDD synth_6472
+ VNB|VSS VNB|VSS sky130_fd_sc_hd__a311oi_1
X$733 VDD synth_6986 synth_6471 synth_6913 synth_6758 synth_6469 VDD synth_6839
+ VNB|VSS VNB|VSS sky130_fd_sc_hd__a311oi_1
X$734 VDD synth_6471 synth_6844 synth_6706 synth_6310 synth_6469 VDD synth_6474
+ VNB|VSS VNB|VSS sky130_fd_sc_hd__a311oi_1
X$735 VDD synth_11151 synth_11074 synth_8237 synth_11076 synth_11237 VDD
+ synth_11198 VNB|VSS VNB|VSS sky130_fd_sc_hd__a311oi_1
X$736 VDD synth_6701 synth_6471 synth_6560 synth_6309 synth_6469 VDD synth_6467
+ VNB|VSS VNB|VSS sky130_fd_sc_hd__a311oi_1
X$737 VDD synth_7592 synth_6471 synth_7594 synth_7127 synth_6469 VDD synth_7593
+ VNB|VSS VNB|VSS sky130_fd_sc_hd__a311oi_1
X$738 VDD synth_9559 synth_9983 synth_11866 synth_9387 synth_11815 VDD
+ synth_10839 VNB|VSS VNB|VSS sky130_fd_sc_hd__a311oi_1
X$739 VDD synth_7275 synth_6471 synth_7347 synth_6170 synth_6469 VDD synth_7274
+ VNB|VSS VNB|VSS sky130_fd_sc_hd__a311oi_1
X$740 VDD synth_6911 synth_6471 synth_6915 synth_6466 synth_6469 VDD synth_6988
+ VNB|VSS VNB|VSS sky130_fd_sc_hd__a311oi_1
X$741 VDD synth_10220 synth_10697 synth_11518 synth_9112 synth_11385 VDD
+ synth_11580 VNB|VSS VNB|VSS sky130_fd_sc_hd__a311oi_1
X$742 VDD synth_4409 synth_3567 synth_4696 synth_3642 synth_5103 VDD synth_4707
+ VNB|VSS VNB|VSS sky130_fd_sc_hd__a311oi_1
X$743 VDD synth_10729 synth_8803 synth_10839 synth_9062 synth_10723 VDD
+ synth_9207 VNB|VSS VNB|VSS sky130_fd_sc_hd__a311oi_1
X$744 VDD synth_6703 synth_6471 synth_6561 synth_6390 synth_6469 VDD synth_6470
+ VNB|VSS VNB|VSS sky130_fd_sc_hd__a311oi_1
X$745 VDD synth_9324 synth_9233 synth_9395 synth_9292 synth_8910 VDD synth_9394
+ VNB|VSS VNB|VSS sky130_fd_sc_hd__a311oi_1
X$746 VDD synth_4095 synth_4160 synth_4248 synth_4021 synth_3897 VDD synth_4161
+ VNB|VSS VNB|VSS sky130_fd_sc_hd__a311oi_1
X$747 VDD synth_4455 synth_4290 synth_4458 synth_4550 synth_4537 synth_4618 VDD
+ VNB|VSS VNB|VSS sky130_fd_sc_hd__o32a_1
X$748 VDD synth_6818 synth_6819 synth_6683 synth_6902 synth_6872 synth_6936 VDD
+ VNB|VSS VNB|VSS sky130_fd_sc_hd__o32a_1
X$749 VDD synth_10003 synth_9292 synth_8764 synth_10006 synth_10104 synth_10160
+ VDD VNB|VSS VNB|VSS sky130_fd_sc_hd__o32a_1
X$750 VDD synth_10451 synth_10478 synth_10470 synth_10586 synth_10317
+ synth_10389 VDD VNB|VSS VNB|VSS sky130_fd_sc_hd__o32a_1
X$751 VDD synth_9119 synth_9516 synth_9434 synth_9239 synth_9583 synth_9385
+ VNB|VSS VDD VNB|VSS sky130_fd_sc_hd__a311o_1
X$752 VDD synth_8873 synth_10782 synth_11464 synth_11976 synth_12151
+ synth_11931 VNB|VSS VDD VNB|VSS sky130_fd_sc_hd__a311o_1
X$757 VDD synth_11379 VNB|VSS VDD VNB|VSS sky130_fd_sc_hd__clkinv_4
X$758 VDD synth_10808 VNB|VSS VDD VNB|VSS sky130_fd_sc_hd__clkinv_4
X$759 VDD synth_7809 VNB|VSS VDD VNB|VSS sky130_fd_sc_hd__clkinv_4
X$760 VDD synth_11626 VNB|VSS VDD VNB|VSS sky130_fd_sc_hd__clkinv_4
X$761 VDD synth_7933 VNB|VSS VDD VNB|VSS sky130_fd_sc_hd__clkinv_4
X$762 VDD synth_9102 VNB|VSS VDD VNB|VSS sky130_fd_sc_hd__clkinv_4
X$763 VDD synth_7808 VNB|VSS VDD VNB|VSS sky130_fd_sc_hd__clkinv_4
X$764 VDD synth_7076 VDD VNB|VSS VNB|VSS sky130_fd_sc_hd__inv_6
X$765 VDD synth_7066 VDD VNB|VSS VNB|VSS sky130_fd_sc_hd__inv_6
X$766 VDD synth_3885 VDD VNB|VSS VNB|VSS sky130_fd_sc_hd__inv_6
X$767 VDD synth_564 VDD VNB|VSS VNB|VSS sky130_fd_sc_hd__inv_6
X$768 VDD synth_4090 VDD VNB|VSS VNB|VSS sky130_fd_sc_hd__inv_6
X$769 VDD synth_12202 VDD VNB|VSS VNB|VSS sky130_fd_sc_hd__inv_6
X$770 VDD synth_11117 VDD VNB|VSS VNB|VSS sky130_fd_sc_hd__inv_6
X$771 VDD synth_8873 synth_8807 synth_8950 VDD VNB|VSS VNB|VSS
+ sky130_fd_sc_hd__and2_1
X$772 VDD synth_8217 synth_7111 synth_8324 VDD VNB|VSS VNB|VSS
+ sky130_fd_sc_hd__and2_1
X$773 VDD synth_8291 synth_7111 synth_8779 VDD VNB|VSS VNB|VSS
+ sky130_fd_sc_hd__and2_1
X$774 VDD synth_8910 synth_8870 synth_8804 VDD VNB|VSS VNB|VSS
+ sky130_fd_sc_hd__and2_1
X$775 VDD synth_8632 synth_8000 synth_8739 VDD VNB|VSS VNB|VSS
+ sky130_fd_sc_hd__and2_1
X$776 VDD synth_9948 synth_10029 synth_9881 VDD VNB|VSS VNB|VSS
+ sky130_fd_sc_hd__and2_1
X$777 VDD synth_6940 synth_8000 synth_8474 VDD VNB|VSS VNB|VSS
+ sky130_fd_sc_hd__and2_1
X$778 VDD synth_7968 synth_7111 synth_8043 VDD VNB|VSS VNB|VSS
+ sky130_fd_sc_hd__and2_1
X$779 VDD synth_6466 synth_6836 synth_6838 VDD VNB|VSS VNB|VSS
+ sky130_fd_sc_hd__and2_1
X$780 VDD synth_9292 synth_10846 synth_10845 VDD VNB|VSS VNB|VSS
+ sky130_fd_sc_hd__and2_1
X$781 VDD synth_8036 synth_8015 synth_7955 VDD VNB|VSS VNB|VSS
+ sky130_fd_sc_hd__and2_1
X$782 VDD synth_8426 synth_7111 synth_8684 VDD VNB|VSS VNB|VSS
+ sky130_fd_sc_hd__and2_1
X$783 VDD synth_4305 synth_4377 synth_4375 VDD VNB|VSS VNB|VSS
+ sky130_fd_sc_hd__and2_1
X$784 VDD synth_8604 synth_8870 synth_9904 VDD VNB|VSS VNB|VSS
+ sky130_fd_sc_hd__and2_1
X$785 VDD synth_7837 synth_7111 synth_8676 VDD VNB|VSS VNB|VSS
+ sky130_fd_sc_hd__and2_1
X$786 VDD synth_8139 synth_7111 synth_8508 VDD VNB|VSS VNB|VSS
+ sky130_fd_sc_hd__and2_1
X$787 VDD synth_8509 synth_8000 synth_8685 VDD VNB|VSS VNB|VSS
+ sky130_fd_sc_hd__and2_1
X$788 VDD synth_9434 synth_9474 synth_10371 VDD VNB|VSS VNB|VSS
+ sky130_fd_sc_hd__and2_1
X$789 VDD synth_5342 synth_5261 synth_5322 VDD VNB|VSS VNB|VSS
+ sky130_fd_sc_hd__and2_1
X$790 VDD synth_10578 synth_9677 synth_12348 VDD VNB|VSS VNB|VSS
+ sky130_fd_sc_hd__and2_1
X$791 VDD synth_10605 synth_10606 synth_10679 synth_10733 synth_10820 VDD
+ synth_10818 VNB|VSS VNB|VSS sky130_fd_sc_hd__a41oi_1
X$792 VDD synth_9868 synth_9866 synth_9721 synth_9798 synth_9956 VDD synth_9869
+ VNB|VSS VNB|VSS sky130_fd_sc_hd__a41oi_1
X$793 VDD synth_5821 synth_3940 synth_4374 synth_5383 synth_4597 VDD synth_5951
+ VNB|VSS VNB|VSS sky130_fd_sc_hd__a41oi_1
X$794 VDD synth_1925 synth_2018 synth_1881 synth_2241 synth_2240 VDD synth_2243
+ VNB|VSS VNB|VSS sky130_fd_sc_hd__a41oi_1
X$795 VDD synth_11638 synth_11438 synth_11730 synth_11832 synth_8765 VDD
+ synth_11781 VNB|VSS VNB|VSS sky130_fd_sc_hd__a41oi_1
X$796 VDD synth_9072 synth_9273 synth_9271 synth_9089 synth_9248 VDD synth_9249
+ VNB|VSS VNB|VSS sky130_fd_sc_hd__a41oi_1
X$797 VDD synth_9234 synth_8944 synth_9905 synth_11066 synth_9062 VDD
+ synth_11464 VNB|VSS VNB|VSS sky130_fd_sc_hd__a41oi_1
X$798 VDD synth_4808 synth_4743 synth_4742 synth_4562 VDD synth_4843 VNB|VSS
+ VNB|VSS sky130_fd_sc_hd__nand4_1
X$799 VDD synth_10292 synth_8710 synth_10484 synth_10364 VDD synth_10491
+ VNB|VSS VNB|VSS sky130_fd_sc_hd__nand4_1
X$800 VDD synth_12417 synth_12533 synth_12479 synth_12606 VDD synth_12419
+ VNB|VSS VNB|VSS sky130_fd_sc_hd__nand4_1
X$801 VDD synth_2055 synth_2056 synth_2012 synth_1858 VDD synth_2124 VNB|VSS
+ VNB|VSS sky130_fd_sc_hd__nand4_1
X$802 VDD synth_2056 synth_2012 synth_1858 synth_2090 synth_1968 VDD synth_2058
+ VNB|VSS VNB|VSS sky130_fd_sc_hd__a41oi_1
X$803 VDD synth_4343 synth_2107 synth_4256 synth_4083 VDD synth_3858 VNB|VSS
+ VNB|VSS sky130_fd_sc_hd__nand4_1
X$804 VDD synth_4343 synth_2107 synth_4256 synth_4215 VDD synth_4062 VNB|VSS
+ VNB|VSS sky130_fd_sc_hd__nand4_1
X$805 VDD synth_6487 synth_2107 synth_4256 synth_5098 VDD synth_7016 VNB|VSS
+ VNB|VSS sky130_fd_sc_hd__nand4_1
X$806 VDD synth_9615 synth_8805 synth_9629 synth_9177 VDD synth_9661 VNB|VSS
+ VNB|VSS sky130_fd_sc_hd__nand4_1
X$807 VDD synth_12001 synth_11944 synth_12120 synth_12185 VDD synth_12116
+ VNB|VSS VNB|VSS sky130_fd_sc_hd__nand4_1
X$808 VDD synth_6309 synth_6466 synth_6758 synth_6836 VDD synth_6697 VNB|VSS
+ VNB|VSS sky130_fd_sc_hd__nand4_1
X$809 VDD synth_6223 synth_6137 synth_6138 synth_6222 VDD synth_4649 VNB|VSS
+ VNB|VSS sky130_fd_sc_hd__nand4_1
X$810 VDD synth_7215 synth_7214 synth_6759 synth_6760 VDD synth_6832 VNB|VSS
+ VNB|VSS sky130_fd_sc_hd__nand4_1
X$811 VDD synth_12601 synth_12413 synth_12529 synth_12362 VDD synth_12603
+ VNB|VSS VNB|VSS sky130_fd_sc_hd__nand4_1
X$812 VDD synth_4291 synth_4305 synth_4377 synth_4376 VDD synth_4397 VNB|VSS
+ VNB|VSS sky130_fd_sc_hd__nand4_1
X$813 VDD synth_10446 synth_10104 synth_10486 synth_10488 VDD synth_10314
+ VNB|VSS VNB|VSS sky130_fd_sc_hd__nand4_1
X$814 VDD synth_4453 synth_4375 synth_4394 synth_4042 VDD synth_4140 VNB|VSS
+ VNB|VSS sky130_fd_sc_hd__nand4_1
X$815 VDD synth_12349 synth_8803 synth_9700 synth_12237 VDD synth_12284 VNB|VSS
+ VNB|VSS sky130_fd_sc_hd__nand4_1
X$816 VDD synth_11682 synth_11681 synth_11684 synth_11605 VDD synth_11547
+ VNB|VSS VNB|VSS sky130_fd_sc_hd__nand4_1
X$817 VDD synth_2108 synth_2107 synth_2033 synth_2230 VDD synth_2231 VNB|VSS
+ VNB|VSS sky130_fd_sc_hd__nand4_1
X$818 VDD synth_6138 synth_2107 synth_6137 synth_6136 VDD synth_6066 VNB|VSS
+ VNB|VSS sky130_fd_sc_hd__nand4_1
X$819 VDD synth_1999 synth_2107 synth_2033 synth_2108 VDD synth_1794 VNB|VSS
+ VNB|VSS sky130_fd_sc_hd__nand4_1
X$820 VDD synth_8910 synth_8805 synth_9119 synth_9555 VDD synth_9477 VNB|VSS
+ VNB|VSS sky130_fd_sc_hd__nand4_1
X$821 VDD synth_3822 synth_2049 synth_1290 synth_3552 VDD synth_4097 VNB|VSS
+ VNB|VSS sky130_fd_sc_hd__nand4_1
X$822 VDD synth_8331 synth_8333 synth_8476 synth_8251 VDD synth_8557 VNB|VSS
+ VNB|VSS sky130_fd_sc_hd__nand4_1
X$823 VDD synth_4343 synth_2107 synth_4256 synth_4402 VDD synth_4257 VNB|VSS
+ VNB|VSS sky130_fd_sc_hd__nand4_1
X$824 VDD synth_4082 synth_4173 synth_4217 synth_3551 synth_4403 VNB|VSS VDD
+ VNB|VSS sky130_fd_sc_hd__o31a_1
X$825 VDD synth_7422 synth_7501 synth_7423 synth_7502 VDD synth_7344 VNB|VSS
+ VNB|VSS sky130_fd_sc_hd__nand4_1
X$826 VDD synth_11075 synth_11076 synth_11074 synth_11150 VDD synth_8279
+ VNB|VSS VNB|VSS sky130_fd_sc_hd__nand4_1
X$827 VDD synth_10209 synth_9932 synth_10487 synth_10176 VDD synth_10178
+ VNB|VSS VNB|VSS sky130_fd_sc_hd__nand4_1
X$828 VDD synth_4741 synth_2059 synth_4552 synth_4744 VDD synth_4889 VNB|VSS
+ VNB|VSS sky130_fd_sc_hd__nand4_1
X$829 VDD synth_8524 synth_8314 synth_8467 synth_8311 VDD synth_8468 VNB|VSS
+ VNB|VSS sky130_fd_sc_hd__nand4_1
X$830 VDD synth_4492 synth_4534 synth_4448 synth_1353 VDD synth_4490 VNB|VSS
+ VNB|VSS sky130_fd_sc_hd__nand4_1
X$831 VDD synth_8464 synth_8314 synth_8467 synth_8311 VDD synth_8440 VNB|VSS
+ VNB|VSS sky130_fd_sc_hd__nand4_1
X$832 VDD synth_8832 synth_8803 synth_8764 synth_8802 VDD synth_8919 VNB|VSS
+ VNB|VSS sky130_fd_sc_hd__nand4_1
X$833 VDD synth_8314 synth_9110 synth_8238 synth_8703 VDD synth_9208 VNB|VSS
+ VNB|VSS sky130_fd_sc_hd__nand4_1
X$834 VDD synth_5098 synth_2107 synth_4256 synth_5798 VDD synth_5732 VNB|VSS
+ VNB|VSS sky130_fd_sc_hd__nand4_1
X$835 VDD synth_4741 synth_2059 synth_4397 synth_4743 VDD synth_4699 VNB|VSS
+ VNB|VSS sky130_fd_sc_hd__nand4_1
X$836 VDD synth_2123 synth_2107 synth_2125 synth_2057 VDD synth_2202 VNB|VSS
+ VNB|VSS sky130_fd_sc_hd__nand4_1
X$837 VDD synth_8802 synth_9172 synth_9905 synth_11293 VDD synth_10861 VNB|VSS
+ VNB|VSS sky130_fd_sc_hd__nand4_1
X$838 VDD synth_12343 synth_10312 synth_9060 synth_12346 VDD synth_12303
+ VNB|VSS VNB|VSS sky130_fd_sc_hd__nand4_1
X$839 VDD synth_2052 synth_3881 synth_2257 synth_3882 VDD synth_2049 VNB|VSS
+ VNB|VSS sky130_fd_sc_hd__nand4_1
X$840 VDD synth_4343 synth_4650 synth_2035 synth_4061 VDD synth_4586 VNB|VSS
+ VNB|VSS sky130_fd_sc_hd__nand4_1
X$841 VDD synth_4699 synth_4671 synth_4843 synth_4889 VNB|VSS VDD synth_4894
+ VNB|VSS sky130_fd_sc_hd__and4_1
X$842 VDD synth_7048 synth_6170 synth_7128 synth_7127 VNB|VSS VDD synth_6836
+ VNB|VSS sky130_fd_sc_hd__and4_1
X$843 VDD synth_6909 synth_6760 synth_6834 synth_6759 VNB|VSS VDD synth_6693
+ VNB|VSS sky130_fd_sc_hd__and4_1
X$844 VDD synth_4093 synth_4190 synth_3876 synth_4094 VNB|VSS VDD synth_3881
+ VNB|VSS sky130_fd_sc_hd__and4_1
X$845 VDD synth_6222 synth_6223 synth_6138 synth_6137 VNB|VSS VDD synth_4650
+ VNB|VSS sky130_fd_sc_hd__and4_1
X$846 VDD synth_2124 synth_2123 synth_2125 synth_2107 VNB|VSS VDD synth_2010
+ VNB|VSS sky130_fd_sc_hd__and4_1
X$847 VDD synth_6327 synth_4405 synth_6290 synth_6406 VNB|VSS VDD synth_6227
+ VNB|VSS sky130_fd_sc_hd__and4_1
X$848 VNB|VSS synth_7460 VDD VDD VNB|VSS sky130_fd_sc_hd__clkinv_8
X$849 VNB|VSS synth_9595 VDD VDD VNB|VSS sky130_fd_sc_hd__clkinv_8
X$850 VNB|VSS synth_6981 VDD VDD VNB|VSS sky130_fd_sc_hd__clkinv_8
X$851 VNB|VSS synth_6970 VDD VDD VNB|VSS sky130_fd_sc_hd__clkinv_8
X$852 VNB|VSS synth_701 VDD VDD VNB|VSS sky130_fd_sc_hd__clkinv_8
X$853 VNB|VSS synth_3336 VDD VDD VNB|VSS sky130_fd_sc_hd__clkinv_8
X$854 VDD synth_8870 synth_9396 synth_9322 synth_11590 VDD synth_11643 VNB|VSS
+ VNB|VSS sky130_fd_sc_hd__a211o_1
X$855 VDD synth_8957 synth_6469 synth_9020 synth_8654 VDD synth_9129 VNB|VSS
+ VNB|VSS sky130_fd_sc_hd__a211o_1
X$856 VDD synth_12116 synth_12117 synth_12183 synth_12192 VNB|VSS VDD VNB|VSS
+ sky130_fd_sc_hd__nor3b_1
X$857 VDD synth_11547 synth_11499 synth_11394 synth_11497 VNB|VSS VDD VNB|VSS
+ sky130_fd_sc_hd__nor3b_1
X$858 VDD synth_12767 synth_12418 synth_12479 synth_12772 VNB|VSS VDD VNB|VSS
+ sky130_fd_sc_hd__nor3b_1
X$859 VDD synth_10252 synth_9019 synth_10533 synth_10599 VNB|VSS VDD VNB|VSS
+ sky130_fd_sc_hd__nor3b_1
X$860 VDD synth_11683 synth_11499 synth_11684 synth_11886 VNB|VSS VDD VNB|VSS
+ sky130_fd_sc_hd__nor3b_1
X$861 VDD synth_5265 synth_5211 synth_5346 synth_5586 VNB|VSS VDD VNB|VSS
+ sky130_fd_sc_hd__nor3b_1
X$862 VDD synth_12603 synth_12376 synth_12602 synth_12604 VNB|VSS VDD VNB|VSS
+ sky130_fd_sc_hd__nor3b_1
X$863 VDD synth_12600 synth_12376 synth_12601 synth_12700 VNB|VSS VDD VNB|VSS
+ sky130_fd_sc_hd__nor3b_1
X$864 VDD synth_12119 synth_12117 synth_12120 synth_12251 VNB|VSS VDD VNB|VSS
+ sky130_fd_sc_hd__nor3b_1
X$865 VDD synth_8557 synth_8397 synth_8558 synth_8668 VNB|VSS VDD VNB|VSS
+ sky130_fd_sc_hd__nor3b_1
X$866 VNB|VSS synth_8558 synth_8713 synth_8641 synth_8642 VDD synth_8728 VDD
+ VNB|VSS sky130_fd_sc_hd__o31ai_2
X$867 VDD synth_2100 synth_2050 synth_2052 synth_2122 VNB|VSS VDD VNB|VSS
+ sky130_fd_sc_hd__nor3b_1
X$868 VDD synth_12419 synth_12418 synth_12368 synth_12427 VNB|VSS VDD VNB|VSS
+ sky130_fd_sc_hd__nor3b_1
X$869 VDD synth_9474 synth_9677 synth_10578 synth_12757 VNB|VSS VDD VNB|VSS
+ sky130_fd_sc_hd__nor3b_1
X$870 VDD synth_8332 synth_8397 synth_8333 synth_8362 VNB|VSS VDD VNB|VSS
+ sky130_fd_sc_hd__nor3b_1
X$871 VDD synth_9583 synth_9514 synth_11382 synth_9738 synth_10060 VDD
+ synth_11795 VNB|VSS VNB|VSS sky130_fd_sc_hd__o311ai_0
X$872 VDD synth_9292 synth_12285 synth_11010 synth_9474 synth_9232 VDD
+ synth_11226 VNB|VSS VNB|VSS sky130_fd_sc_hd__o311ai_0
X$873 VDD synth_10483 synth_11439 synth_11383 synth_9677 synth_9042 VDD
+ synth_12106 VNB|VSS VNB|VSS sky130_fd_sc_hd__o311ai_0
X$874 VDD synth_5889 synth_5972 synth_1794 synth_1718 synth_5891 VDD VNB|VSS
+ VNB|VSS sky130_fd_sc_hd__o211ai_1
X$875 VDD synth_8806 synth_12145 synth_12144 synth_9470 synth_12218 VDD VNB|VSS
+ VNB|VSS sky130_fd_sc_hd__o211ai_1
X$876 VDD synth_8945 synth_9034 synth_9119 synth_9036 synth_9100 VDD VNB|VSS
+ VNB|VSS sky130_fd_sc_hd__o211ai_1
X$877 VDD synth_9434 synth_11248 synth_11517 synth_12344 synth_11459 VDD
+ VNB|VSS VNB|VSS sky130_fd_sc_hd__o211ai_1
X$878 VDD synth_10793 synth_11459 synth_10417 synth_8710 synth_11458 VDD
+ VNB|VSS VNB|VSS sky130_fd_sc_hd__o211ai_1
X$879 VDD synth_9850 synth_9322 synth_10912 synth_10651 synth_9283 VDD VNB|VSS
+ VNB|VSS sky130_fd_sc_hd__o211ai_1
X$880 VDD synth_10578 synth_10440 synth_12560 synth_11465 synth_12455 VDD
+ VNB|VSS VNB|VSS sky130_fd_sc_hd__o211ai_1
X$881 VDD synth_10376 synth_10372 synth_9047 synth_10406 synth_10493 VDD
+ VNB|VSS VNB|VSS sky130_fd_sc_hd__o211ai_1
X$882 VDD synth_8977 synth_9095 synth_9053 synth_9054 synth_6290 VDD VNB|VSS
+ VNB|VSS sky130_fd_sc_hd__o211ai_1
X$883 VDD synth_8806 synth_11431 synth_11279 synth_8805 synth_11428 VDD VNB|VSS
+ VNB|VSS sky130_fd_sc_hd__o211ai_1
X$884 VDD synth_8805 synth_10373 synth_10492 synth_9062 synth_10346 VDD VNB|VSS
+ VNB|VSS sky130_fd_sc_hd__o211ai_1
X$885 VDD synth_3202 synth_3292 synth_3591 synth_3662 synth_3551 VDD VNB|VSS
+ VNB|VSS sky130_fd_sc_hd__o211ai_1
X$886 VDD synth_8805 synth_9658 synth_9584 synth_9730 synth_9605 VDD VNB|VSS
+ VNB|VSS sky130_fd_sc_hd__o211ai_1
X$887 VDD synth_9292 synth_12156 synth_12283 synth_12158 synth_12160 VDD
+ VNB|VSS VNB|VSS sky130_fd_sc_hd__o211ai_1
X$888 VDD synth_9474 synth_9980 synth_9327 synth_9328 synth_9480 VDD VNB|VSS
+ VNB|VSS sky130_fd_sc_hd__o211ai_1
X$889 VDD synth_10578 synth_9233 synth_10099 synth_11642 synth_11594 VDD
+ VNB|VSS VNB|VSS sky130_fd_sc_hd__o211ai_1
X$890 VDD synth_9292 synth_10847 synth_10861 synth_8710 synth_10848 VDD VNB|VSS
+ VNB|VSS sky130_fd_sc_hd__o211ai_1
X$891 VDD synth_11225 synth_11226 synth_11224 synth_11165 synth_11011 VDD
+ VNB|VSS VNB|VSS sky130_fd_sc_hd__o211ai_1
X$892 VDD synth_9119 synth_9201 synth_9120 synth_9100 synth_9200 VDD VNB|VSS
+ VNB|VSS sky130_fd_sc_hd__o211ai_1
X$893 VDD synth_9292 synth_11912 synth_9580 synth_8870 synth_11139 VDD VNB|VSS
+ VNB|VSS sky130_fd_sc_hd__o211ai_1
X$894 VDD synth_10865 synth_12670 synth_12726 synth_8806 synth_12725 VDD
+ VNB|VSS VNB|VSS sky130_fd_sc_hd__o211ai_1
X$895 VDD synth_8918 synth_11382 synth_12280 synth_12281 synth_10373 VDD
+ VNB|VSS VNB|VSS sky130_fd_sc_hd__o211ai_1
X$896 VDD synth_8910 synth_9553 synth_9172 synth_10172 synth_10292 VDD VNB|VSS
+ VNB|VSS sky130_fd_sc_hd__o211ai_1
X$897 VDD synth_9695 synth_9582 synth_9700 synth_9744 synth_9771 VDD VNB|VSS
+ VNB|VSS sky130_fd_sc_hd__o211ai_1
X$898 VDD synth_1942 synth_2079 synth_2149 synth_1990 synth_1610 synth_2031
+ VNB|VSS VDD VNB|VSS sky130_fd_sc_hd__a32oi_1
X$899 VDD synth_8199 synth_7880 synth_8021 synth_7815 synth_8029 synth_8100
+ VNB|VSS VDD VNB|VSS sky130_fd_sc_hd__a32oi_1
X$900 VDD synth_10003 synth_11013 synth_11096 synth_11017 synth_9063
+ synth_11015 VNB|VSS VDD VNB|VSS sky130_fd_sc_hd__a32oi_1
X$901 VDD synth_9041 synth_9175 synth_9172 synth_8946 synth_8910 synth_9206
+ VNB|VSS VDD VNB|VSS sky130_fd_sc_hd__a32oi_1
X$902 VDD synth_11084 synth_11152 synth_10994 synth_11075 synth_10996
+ synth_10627 VNB|VSS VDD VNB|VSS sky130_fd_sc_hd__a32oi_1
X$903 VDD synth_10697 synth_11315 synth_10344 synth_8870 synth_10285
+ synth_11292 VNB|VSS VDD VNB|VSS sky130_fd_sc_hd__a32oi_1
X$904 VDD synth_8910 synth_9681 synth_9379 synth_9483 synth_8738 synth_10415
+ VNB|VSS VDD VNB|VSS sky130_fd_sc_hd__a32oi_1
X$905 VDD synth_9513 synth_9738 synth_9580 synth_9474 synth_9292 synth_11929
+ VNB|VSS VDD VNB|VSS sky130_fd_sc_hd__a32oi_1
X$906 VDD synth_4212 synth_4202 synth_4117 synth_4135 synth_3707 synth_4137
+ VNB|VSS VDD VNB|VSS sky130_fd_sc_hd__a32oi_1
X$907 VDD synth_4049 synth_4118 synth_4117 synth_4043 synth_4116 synth_4607
+ VNB|VSS VDD VNB|VSS sky130_fd_sc_hd__a32oi_1
X$908 VNB|VSS synth_657 synth_364 VDD VDD VNB|VSS sky130_fd_sc_hd__buf_6
X$909 VNB|VSS synth_7196 synth_5738 VDD VDD VNB|VSS sky130_fd_sc_hd__buf_6
X$910 VNB|VSS synth_7803 synth_1827 VDD VDD VNB|VSS sky130_fd_sc_hd__buf_6
X$911 VNB|VSS synth_4821 synth_6044 VDD VDD VNB|VSS sky130_fd_sc_hd__buf_6
X$912 VNB|VSS synth_5787 synth_88 VDD VDD VNB|VSS sky130_fd_sc_hd__buf_6
X$913 VNB|VSS synth_449 synth_626 VDD VDD VNB|VSS sky130_fd_sc_hd__buf_6
X$914 VNB|VSS synth_2850 synth_387 VDD VDD VNB|VSS sky130_fd_sc_hd__buf_6
X$915 VNB|VSS synth_7350 synth_1467 VDD VDD VNB|VSS sky130_fd_sc_hd__buf_6
X$916 VNB|VSS synth_5738 synth_3616 VDD VDD VNB|VSS sky130_fd_sc_hd__buf_6
X$917 VDD synth_11681 synth_11624 synth_11328 synth_11344 synth_11603 VDD
+ VNB|VSS VNB|VSS sky130_fd_sc_hd__or4_1
X$918 VDD synth_9499 synth_9497 synth_9571 synth_9548 synth_8934 VDD VNB|VSS
+ VNB|VSS sky130_fd_sc_hd__or4_1
X$919 VDD synth_6637 synth_6752 synth_6753 synth_6822 synth_6684 VDD VNB|VSS
+ VNB|VSS sky130_fd_sc_hd__or4_1
X$920 VDD synth_9865 synth_9779 synth_9887 synth_9778 synth_9780 VDD VNB|VSS
+ VNB|VSS sky130_fd_sc_hd__or4_1
X$921 VDD synth_2166 synth_2337 synth_2336 synth_2477 synth_2113 VDD VNB|VSS
+ VNB|VSS sky130_fd_sc_hd__or4_1
X$922 VDD synth_3367 synth_3366 synth_3202 synth_3292 synth_3500 VDD VNB|VSS
+ VNB|VSS sky130_fd_sc_hd__or4_1
X$923 VDD synth_1622 synth_1635 synth_1687 synth_1798 synth_2042 VDD VNB|VSS
+ VNB|VSS sky130_fd_sc_hd__or4_1
X$924 VDD synth_5846 synth_5882 synth_5848 synth_5734 synth_5098 VDD VNB|VSS
+ VNB|VSS sky130_fd_sc_hd__or4_1
X$925 VDD synth_12001 synth_11686 synth_11999 synth_12000 synth_12006 VDD
+ VNB|VSS VNB|VSS sky130_fd_sc_hd__or4_1
X$926 VDD synth_4397 synth_4675 synth_4742 synth_4674 synth_4818 VDD VNB|VSS
+ VNB|VSS sky130_fd_sc_hd__or4_1
X$927 VDD synth_6540 synth_6577 synth_6403 synth_6434 synth_5848 VDD VNB|VSS
+ VNB|VSS sky130_fd_sc_hd__or4_1
X$928 VDD synth_5793 synth_5795 synth_5796 synth_5731 synth_5882 VDD VNB|VSS
+ VNB|VSS sky130_fd_sc_hd__or4_1
X$929 VDD synth_12413 synth_12111 synth_11938 synth_12309 synth_12414 VDD
+ VNB|VSS VNB|VSS sky130_fd_sc_hd__or4_1
X$930 VDD synth_3955 synth_4011 synth_3787 synth_3888 synth_4141 VDD VNB|VSS
+ VNB|VSS sky130_fd_sc_hd__or4_1
X$931 VDD synth_3550 synth_3554 synth_3553 synth_3453 synth_3719 VDD VNB|VSS
+ VNB|VSS sky130_fd_sc_hd__or4_1
X$932 VDD synth_2042 synth_2041 synth_2114 synth_2113 synth_2424 VDD VNB|VSS
+ VNB|VSS sky130_fd_sc_hd__or4_1
X$933 VDD synth_7804 synth_8121 synth_8653 synth_6727 synth_7537 VDD VNB|VSS
+ VNB|VSS sky130_fd_sc_hd__or4_1
X$934 VDD synth_8331 synth_8876 synth_8877 synth_8808 synth_8669 VDD VNB|VSS
+ VNB|VSS sky130_fd_sc_hd__or4_1
X$935 VDD synth_3401 synth_3832 synth_3830 synth_3831 synth_3641 VDD VNB|VSS
+ VNB|VSS sky130_fd_sc_hd__or4_1
X$936 VDD synth_6432 synth_6538 synth_6431 synth_6433 synth_5734 VDD VNB|VSS
+ VNB|VSS sky130_fd_sc_hd__or4_1
X$937 VDD synth_5966 synth_6061 synth_5632 synth_5733 synth_5846 VDD VNB|VSS
+ VNB|VSS sky130_fd_sc_hd__or4_1
X$938 VDD synth_10285 synth_12153 synth_11908 synth_12168 synth_12594 VDD
+ VNB|VSS VNB|VSS sky130_fd_sc_hd__or4_1
X$939 VDD synth_9143 synth_9178 synth_9065 synth_8969 synth_9368 VDD VNB|VSS
+ VNB|VSS sky130_fd_sc_hd__or4_1
X$940 VDD synth_4082 synth_4173 synth_4084 synth_4081 synth_3888 VDD VNB|VSS
+ VNB|VSS sky130_fd_sc_hd__or4_1
X$941 VDD synth_11371 synth_11300 synth_11299 synth_11301 synth_11303 VDD
+ VNB|VSS VNB|VSS sky130_fd_sc_hd__or4_1
X$942 VDD synth_2240 synth_2335 synth_2167 synth_2309 synth_2114 VDD VNB|VSS
+ VNB|VSS sky130_fd_sc_hd__or4_1
X$943 VDD synth_3719 synth_3500 synth_3888 synth_3890 synth_4083 VDD VNB|VSS
+ VNB|VSS sky130_fd_sc_hd__or4_1
X$944 VDD synth_4036 synth_4035 synth_4109 synth_4108 synth_3640 VDD VNB|VSS
+ VNB|VSS sky130_fd_sc_hd__or4_1
X$945 VDD synth_4458 synth_4538 synth_4457 synth_4456 synth_4292 VDD VNB|VSS
+ VNB|VSS sky130_fd_sc_hd__or4_1
X$946 VDD synth_10264 synth_10543 synth_10450 synth_10380 synth_10823 VDD
+ VNB|VSS VNB|VSS sky130_fd_sc_hd__or4_1
X$947 VDD synth_4185 synth_4184 synth_4164 synth_2089 synth_4674 VDD VNB|VSS
+ VNB|VSS sky130_fd_sc_hd__or4_1
X$948 VDD synth_12415 synth_12533 synth_12472 synth_12114 synth_12483 VDD
+ VNB|VSS VNB|VSS sky130_fd_sc_hd__or4_1
X$949 VDD synth_3955 synth_4011 synth_3787 synth_3748 synth_3890 VDD VNB|VSS
+ VNB|VSS sky130_fd_sc_hd__or4_1
X$950 VDD synth_10819 synth_10852 synth_10930 synth_11120 synth_11072 VDD
+ VNB|VSS VNB|VSS sky130_fd_sc_hd__or4_1
X$951 VDD synth_8361 synth_8437 synth_8381 synth_8382 synth_8547 VDD VNB|VSS
+ VNB|VSS sky130_fd_sc_hd__or4_1
X$952 VDD synth_6541 VDD VNB|VSS VNB|VSS sky130_fd_sc_hd__clkinvlp_4
X$953 VDD synth_3242 VDD VNB|VSS VNB|VSS sky130_fd_sc_hd__clkinvlp_4
X$954 VDD synth_10269 VDD VNB|VSS VNB|VSS sky130_fd_sc_hd__clkinvlp_4
X$955 VDD synth_5249 VDD VNB|VSS VNB|VSS sky130_fd_sc_hd__clkinvlp_4
X$956 VDD synth_3576 VDD VNB|VSS VNB|VSS sky130_fd_sc_hd__clkinvlp_4
X$957 VDD synth_5447 VDD VNB|VSS VNB|VSS sky130_fd_sc_hd__clkinvlp_4
X$958 VDD synth_3937 VDD VNB|VSS VNB|VSS sky130_fd_sc_hd__clkinvlp_4
X$959 VDD synth_10549 VDD VNB|VSS VNB|VSS sky130_fd_sc_hd__clkinvlp_4
X$960 VDD synth_5087 VDD VNB|VSS VNB|VSS sky130_fd_sc_hd__clkinvlp_4
X$961 VDD synth_3781 VDD VNB|VSS VNB|VSS sky130_fd_sc_hd__clkinvlp_4
X$962 VDD synth_9896 VDD VNB|VSS VNB|VSS sky130_fd_sc_hd__clkinvlp_4
X$963 VDD synth_3794 VDD VNB|VSS VNB|VSS sky130_fd_sc_hd__clkinvlp_4
X$964 VDD synth_6801 VDD VNB|VSS VNB|VSS sky130_fd_sc_hd__clkinvlp_4
X$965 VDD synth_3335 VDD VNB|VSS VNB|VSS sky130_fd_sc_hd__clkinvlp_4
X$966 VDD synth_5016 VDD VNB|VSS VNB|VSS sky130_fd_sc_hd__clkinvlp_4
X$967 VNB|VSS synth_2043 synth_2042 synth_2041 synth_2114 synth_2113 VDD VDD
+ VNB|VSS sky130_fd_sc_hd__nor4_2
X$968 VNB|VSS synth_6138 synth_6663 synth_6633 synth_6595 synth_6291 VDD VDD
+ VNB|VSS sky130_fd_sc_hd__nor4_2
X$969 VNB|VSS synth_2311 synth_2091 synth_2114 synth_2190 synth_2191 VDD VDD
+ VNB|VSS sky130_fd_sc_hd__nor4_2
X$970 VNB|VSS synth_11083 synth_10911 synth_11056 synth_11158 synth_11245 VDD
+ VDD VNB|VSS sky130_fd_sc_hd__nor4_2
X$971 VNB|VSS synth_6137 synth_6962 synth_6443 synth_6740 synth_6793 VDD VDD
+ VNB|VSS sky130_fd_sc_hd__nor4_2
X$972 VNB|VSS synth_11074 synth_11191 synth_11193 synth_11149 synth_11148 VDD
+ VDD VNB|VSS sky130_fd_sc_hd__nor4_2
X$973 VNB|VSS synth_8241 synth_8361 synth_8437 synth_8381 synth_8382 VDD VDD
+ VNB|VSS sky130_fd_sc_hd__nor4_2
X$974 VNB|VSS synth_4377 synth_4203 synth_4201 synth_4212 synth_4049 VDD VDD
+ VNB|VSS sky130_fd_sc_hd__nor4_2
X$975 VNB|VSS synth_9309 synth_9142 synth_9166 synth_9310 synth_9413 VDD VDD
+ VNB|VSS sky130_fd_sc_hd__nor4_2
X$976 VNB|VSS synth_4673 synth_4816 synth_4697 synth_4672 synth_4892 VDD VDD
+ VNB|VSS sky130_fd_sc_hd__nor4_2
X$977 VNB|VSS synth_8464 synth_8626 synth_8627 synth_8548 synth_8442 VDD VDD
+ VNB|VSS sky130_fd_sc_hd__nor4_2
X$978 VNB|VSS synth_8833 synth_8752 synth_8702 synth_8751 synth_8701 VDD VDD
+ VNB|VSS sky130_fd_sc_hd__nor4_2
X$979 VNB|VSS synth_2033 synth_2109 synth_2037 synth_1946 synth_1947 VDD VDD
+ VNB|VSS sky130_fd_sc_hd__nor4_2
X$980 VNB|VSS synth_4623 synth_4649 synth_2152 synth_5098 synth_4083 VDD VDD
+ VNB|VSS sky130_fd_sc_hd__nor4_2
X$981 VNB|VSS synth_9311 synth_9499 synth_9497 synth_9571 synth_9548 VDD VDD
+ VNB|VSS sky130_fd_sc_hd__nor4_2
X$982 VNB|VSS synth_11082 synth_11085 synth_11160 synth_11310 synth_11309 VDD
+ VDD VNB|VSS sky130_fd_sc_hd__nor4_2
X$983 VNB|VSS synth_8312 synth_8238 synth_8237 synth_8279 synth_8311 VDD VDD
+ VNB|VSS sky130_fd_sc_hd__nor4_2
X$984 VDD synth_9499 synth_9497 synth_9608 synth_9144 VDD VNB|VSS synth_9277
+ VNB|VSS sky130_fd_sc_hd__o31ai_1
X$985 VDD synth_11371 synth_11300 synth_11588 synth_11299 VDD VNB|VSS
+ synth_11706 VNB|VSS sky130_fd_sc_hd__o31ai_1
X$986 VDD synth_3550 synth_3554 synth_3718 synth_3786 VDD VNB|VSS synth_4172
+ VNB|VSS sky130_fd_sc_hd__o31ai_1
X$987 VDD synth_12183 synth_12246 synth_12252 synth_12319 VDD VNB|VSS
+ synth_11606 VNB|VSS sky130_fd_sc_hd__o31ai_1
X$988 VDD synth_10399 synth_10478 synth_10451 synth_10516 VDD VNB|VSS
+ synth_10662 VNB|VSS sky130_fd_sc_hd__o31ai_1
X$989 VDD synth_9499 synth_9497 synth_6634 synth_9571 VDD VNB|VSS synth_9962
+ VNB|VSS sky130_fd_sc_hd__o31ai_1
X$990 VDD synth_4035 synth_4109 synth_4198 synth_4036 VDD VNB|VSS synth_4285
+ VNB|VSS sky130_fd_sc_hd__o31ai_1
X$991 VDD synth_10819 synth_10852 synth_10895 synth_10930 VDD VNB|VSS
+ synth_10927 VNB|VSS sky130_fd_sc_hd__o31ai_1
X$992 VDD synth_1622 synth_1635 synth_1718 synth_1687 VDD VNB|VSS synth_1719
+ VNB|VSS sky130_fd_sc_hd__o31ai_1
X$993 VDD synth_6443 synth_6740 synth_7186 synth_6793 VDD VNB|VSS synth_7185
+ VNB|VSS sky130_fd_sc_hd__o31ai_1
X$994 VDD synth_9292 synth_10862 synth_11519 synth_12284 VDD VNB|VSS
+ synth_11749 VNB|VSS sky130_fd_sc_hd__o31ai_1
X$995 VDD synth_9870 synth_9871 synth_9796 synth_9650 VDD VNB|VSS synth_9703
+ VNB|VSS sky130_fd_sc_hd__o31ai_1
X$996 VDD synth_8862 synth_8849 synth_8795 synth_8921 VDD VNB|VSS synth_8938
+ VNB|VSS sky130_fd_sc_hd__o31ai_1
X$997 VDD synth_11455 synth_11669 synth_11671 synth_11670 VDD VNB|VSS
+ synth_12044 VNB|VSS sky130_fd_sc_hd__o31ai_1
X$998 VDD synth_11664 synth_11666 synth_11778 synth_11668 VDD VNB|VSS
+ synth_11777 VNB|VSS sky130_fd_sc_hd__o31ai_1
X$999 VDD synth_3830 synth_3831 synth_3940 synth_3832 VDD VNB|VSS synth_3938
+ VNB|VSS sky130_fd_sc_hd__o31ai_1
X$1000 VDD synth_2166 synth_2114 synth_2310 synth_2337 VDD VNB|VSS synth_2425
+ VNB|VSS sky130_fd_sc_hd__o31ai_1
X$1001 VDD synth_4592 synth_4655 synth_4656 synth_4591 VDD VNB|VSS synth_4799
+ VNB|VSS sky130_fd_sc_hd__o31ai_1
X$1002 VDD synth_6432 synth_6538 synth_7016 synth_6431 VDD VNB|VSS synth_7143
+ VNB|VSS sky130_fd_sc_hd__o31ai_1
X$1003 VDD synth_12366 synth_12368 synth_12478 synth_12421 VDD VNB|VSS
+ synth_10949 VNB|VSS sky130_fd_sc_hd__o31ai_1
X$1004 VDD synth_4811 synth_5504 synth_4818 synth_5421 VDD VNB|VSS synth_5754
+ VNB|VSS sky130_fd_sc_hd__o31ai_1
X$1005 VDD synth_8752 synth_8702 synth_8750 synth_8751 VDD VNB|VSS synth_8753
+ VNB|VSS sky130_fd_sc_hd__o31ai_1
X$1006 VDD synth_8094 synth_8127 synth_8099 synth_8098 VDD VNB|VSS synth_8186
+ VNB|VSS sky130_fd_sc_hd__o31ai_1
X$1007 VDD synth_3550 synth_3554 synth_3552 synth_3553 VDD VNB|VSS synth_3621
+ VNB|VSS sky130_fd_sc_hd__o31ai_1
X$1008 VDD synth_2109 synth_2037 synth_2236 synth_1946 VDD VNB|VSS synth_2187
+ VNB|VSS sky130_fd_sc_hd__o31ai_1
X$1009 VDD synth_7240 synth_7265 synth_6771 synth_7266 VDD VNB|VSS synth_7538
+ VNB|VSS sky130_fd_sc_hd__o31ai_1
X$1010 VDD synth_5260 synth_5156 synth_4709 synth_5157 VDD VNB|VSS synth_5216
+ VNB|VSS sky130_fd_sc_hd__o31ai_1
X$1011 VDD synth_8805 synth_11387 synth_11277 synth_11428 VDD VNB|VSS
+ synth_11503 VNB|VSS sky130_fd_sc_hd__o31ai_1
X$1012 VDD synth_3639 synth_3636 synth_3685 synth_3614 VDD VNB|VSS synth_3635
+ VNB|VSS sky130_fd_sc_hd__o31ai_1
X$1013 VDD synth_5346 synth_5211 synth_5268 synth_5267 VDD VNB|VSS synth_5269
+ VNB|VSS sky130_fd_sc_hd__o31ai_1
X$1014 VDD synth_5793 synth_5795 synth_5794 synth_5796 VDD VNB|VSS synth_5842
+ VNB|VSS sky130_fd_sc_hd__o31ai_1
X$1015 VDD synth_6663 synth_6633 synth_6631 synth_6595 VDD VNB|VSS synth_6792
+ VNB|VSS sky130_fd_sc_hd__o31ai_1
X$1016 VDD synth_4109 synth_4108 synth_4199 synth_4035 VDD VNB|VSS synth_4367
+ VNB|VSS sky130_fd_sc_hd__o31ai_1
X$1017 VDD synth_2240 synth_2335 synth_2310 synth_2167 VDD VNB|VSS synth_2308
+ VNB|VSS sky130_fd_sc_hd__o31ai_1
X$1018 VDD synth_1761 synth_1870 synth_1794 synth_1942 VDD VNB|VSS synth_2106
+ VNB|VSS sky130_fd_sc_hd__o31ai_1
X$1019 VDD synth_4203 synth_4292 synth_4392 synth_4201 VDD VNB|VSS synth_4682
+ VNB|VSS sky130_fd_sc_hd__o31ai_1
X$1020 VDD synth_1704 synth_1705 synth_1630 synth_1610 VDD VNB|VSS synth_1672
+ VNB|VSS sky130_fd_sc_hd__o31ai_1
X$1021 VDD synth_3519 synth_3432 synth_3471 synth_3795 VDD VNB|VSS synth_3969
+ VNB|VSS sky130_fd_sc_hd__o31ai_1
X$1022 VDD synth_11416 synth_11394 synth_11496 synth_11330 VDD VNB|VSS
+ synth_10872 VNB|VSS sky130_fd_sc_hd__o31ai_1
X$1023 VDD synth_9269 synth_9252 synth_9362 synth_9073 VDD VNB|VSS synth_9250
+ VNB|VSS sky130_fd_sc_hd__o31ai_1
X$1024 VDD synth_11191 synth_11193 synth_11147 synth_11149 VDD VNB|VSS
+ synth_11369 VNB|VSS sky130_fd_sc_hd__o31ai_1
X$1025 VDD synth_9387 synth_10212 synth_12239 synth_12027 VDD VNB|VSS
+ synth_12169 VNB|VSS sky130_fd_sc_hd__o31ai_1
X$1026 VDD synth_10578 synth_10312 synth_9553 synth_10579 VDD VNB|VSS
+ synth_10612 VNB|VSS sky130_fd_sc_hd__o31ai_1
X$1027 VDD synth_1546 synth_1675 synth_1632 synth_1708 VDD VNB|VSS synth_1710
+ VNB|VSS sky130_fd_sc_hd__o31ai_1
X$1028 VDD synth_8752 synth_8702 synth_8837 synth_8998 VDD VNB|VSS synth_9035
+ VNB|VSS sky130_fd_sc_hd__o31ai_1
X$1029 VDD synth_3273 synth_3272 synth_3274 synth_3338 VDD VNB|VSS synth_3238
+ VNB|VSS sky130_fd_sc_hd__o31ai_1
X$1030 VDD synth_2167 synth_2309 synth_2475 synth_2564 VDD VNB|VSS synth_2535
+ VNB|VSS sky130_fd_sc_hd__o31ai_1
X$1031 VDD synth_10312 synth_12302 synth_12394 synth_12303 VDD VNB|VSS
+ synth_12221 VNB|VSS sky130_fd_sc_hd__o31ai_1
X$1032 VDD synth_6637 synth_6752 synth_6685 synth_6753 VDD VNB|VSS synth_6688
+ VNB|VSS sky130_fd_sc_hd__o31ai_1
X$1033 VDD synth_11664 synth_11666 synth_11667 synth_11665 VDD VNB|VSS
+ synth_11971 VNB|VSS sky130_fd_sc_hd__o31ai_1
X$1034 VDD synth_4082 synth_4173 synth_3858 synth_4084 VDD VNB|VSS synth_4175
+ VNB|VSS sky130_fd_sc_hd__o31ai_1
X$1035 VDD synth_2120 synth_2048 synth_2049 synth_1965 VDD VNB|VSS synth_2199
+ VNB|VSS sky130_fd_sc_hd__o31ai_1
X$1036 VDD synth_9062 synth_12219 synth_12220 synth_12170 VDD VNB|VSS
+ synth_12171 VNB|VSS sky130_fd_sc_hd__o31ai_1
X$1037 VDD synth_4022 synth_4023 synth_3822 synth_4021 VDD VNB|VSS synth_4158
+ VNB|VSS sky130_fd_sc_hd__o31ai_1
X$1038 VDD synth_3774 synth_3841 synth_3840 synth_3707 VDD VNB|VSS synth_3775
+ VNB|VSS sky130_fd_sc_hd__o31ai_1
X$1039 VDD synth_10652 synth_11504 synth_9901 synth_11389 VDD VNB|VSS
+ synth_11431 VNB|VSS sky130_fd_sc_hd__o31ai_1
X$1040 VDD synth_9042 synth_9474 synth_12396 synth_12347 VDD VNB|VSS
+ synth_12397 VNB|VSS sky130_fd_sc_hd__o31ai_1
X$1041 VDD synth_9112 synth_8946 synth_9900 synth_12269 VDD VNB|VSS synth_12135
+ VNB|VSS sky130_fd_sc_hd__o31ai_1
X$1042 VDD synth_5793 synth_5795 synth_5931 synth_5933 VDD VNB|VSS synth_5799
+ VNB|VSS sky130_fd_sc_hd__o31ai_1
X$1043 VDD synth_6140 synth_6225 synth_6226 synth_5973 VDD VNB|VSS synth_6191
+ VNB|VSS sky130_fd_sc_hd__o31ai_1
X$1044 VDD synth_3955 synth_4011 synth_4062 synth_3787 VDD VNB|VSS synth_3993
+ VNB|VSS sky130_fd_sc_hd__o31ai_1
X$1045 VDD synth_6403 synth_6434 synth_5196 synth_6540 VDD VNB|VSS synth_6916
+ VNB|VSS sky130_fd_sc_hd__o31ai_1
X$1046 VDD synth_6819 synth_6903 synth_5900 synth_6874 VDD VNB|VSS synth_7236
+ VNB|VSS sky130_fd_sc_hd__o31ai_1
X$1047 VDD synth_10889 synth_11020 synth_10816 synth_11046 VDD VNB|VSS
+ synth_10760 VNB|VSS sky130_fd_sc_hd__o31ai_1
X$1048 VDD synth_8397 synth_8331 synth_8415 VNB|VSS VDD VNB|VSS
+ sky130_fd_sc_hd__nor2b_1
X$1049 VDD synth_8765 synth_9517 synth_8777 VNB|VSS VDD VNB|VSS
+ sky130_fd_sc_hd__nor2b_1
X$1050 VDD synth_8873 synth_9062 synth_10444 VNB|VSS VDD VNB|VSS
+ sky130_fd_sc_hd__nor2b_1
X$1051 VDD synth_11194 synth_11398 synth_11332 VNB|VSS VDD VNB|VSS
+ sky130_fd_sc_hd__nor2b_1
X$1052 VDD synth_8189 synth_8105 synth_8104 VNB|VSS VDD VNB|VSS
+ sky130_fd_sc_hd__nor2b_1
X$1053 VDD synth_9677 synth_9292 synth_10577 VNB|VSS VDD VNB|VSS
+ sky130_fd_sc_hd__nor2b_1
X$1054 VDD synth_11398 synth_11194 synth_11331 VNB|VSS VDD VNB|VSS
+ sky130_fd_sc_hd__nor2b_1
X$1055 VDD synth_12117 synth_12001 synth_12005 VNB|VSS VDD VNB|VSS
+ sky130_fd_sc_hd__nor2b_1
X$1056 VDD synth_9528 synth_9526 synth_9444 VNB|VSS VDD VNB|VSS
+ sky130_fd_sc_hd__nor2b_1
X$1057 VDD synth_11481 synth_11550 synth_11480 VNB|VSS VDD VNB|VSS
+ sky130_fd_sc_hd__nor2b_1
X$1058 VDD synth_8765 synth_11784 synth_11782 VNB|VSS VDD VNB|VSS
+ sky130_fd_sc_hd__nor2b_1
X$1059 VDD synth_8402 synth_8483 synth_8403 VNB|VSS VDD VNB|VSS
+ sky130_fd_sc_hd__nor2b_1
X$1060 VDD synth_9075 synth_9074 synth_9081 VNB|VSS VDD VNB|VSS
+ sky130_fd_sc_hd__nor2b_1
X$1061 VDD synth_9074 synth_9075 synth_8883 VNB|VSS VDD VNB|VSS
+ sky130_fd_sc_hd__nor2b_1
X$1062 VDD synth_6432 synth_6538 synth_6787 VNB|VSS VDD VNB|VSS
+ sky130_fd_sc_hd__nor2b_1
X$1063 VDD synth_9180 synth_9253 synth_9139 VNB|VSS VDD VNB|VSS
+ sky130_fd_sc_hd__nor2b_1
X$1064 VDD synth_9253 synth_9180 synth_9140 VNB|VSS VDD VNB|VSS
+ sky130_fd_sc_hd__nor2b_1
X$1065 VDD synth_12418 synth_12533 synth_12740 VNB|VSS VDD VNB|VSS
+ sky130_fd_sc_hd__nor2b_1
X$1066 VDD synth_8105 synth_8189 synth_8106 VNB|VSS VDD VNB|VSS
+ sky130_fd_sc_hd__nor2b_1
X$1067 VDD synth_11550 synth_11481 synth_11689 VNB|VSS VDD VNB|VSS
+ sky130_fd_sc_hd__nor2b_1
X$1068 VDD synth_11149 synth_11148 synth_11346 VNB|VSS VDD VNB|VSS
+ sky130_fd_sc_hd__nor2b_1
X$1069 VDD synth_9441 synth_9440 synth_9442 VNB|VSS VDD VNB|VSS
+ sky130_fd_sc_hd__nor2b_1
X$1070 VDD synth_9019 synth_9130 synth_9877 VNB|VSS VDD VNB|VSS
+ sky130_fd_sc_hd__nor2b_1
X$1071 VDD synth_11400 synth_11471 synth_11491 VNB|VSS VDD VNB|VSS
+ sky130_fd_sc_hd__nor2b_1
X$1072 VDD synth_11471 synth_11400 synth_11472 VNB|VSS VDD VNB|VSS
+ sky130_fd_sc_hd__nor2b_1
X$1073 VDD synth_11499 synth_11681 synth_11774 VNB|VSS VDD VNB|VSS
+ sky130_fd_sc_hd__nor2b_1
X$1074 VDD synth_10578 synth_9474 synth_10795 VNB|VSS VDD VNB|VSS
+ sky130_fd_sc_hd__nor2b_1
X$1075 VDD synth_8870 synth_10578 synth_12756 VNB|VSS VDD VNB|VSS
+ sky130_fd_sc_hd__nor2b_1
X$1076 VDD synth_9019 synth_9018 synth_8959 VNB|VSS VDD VNB|VSS
+ sky130_fd_sc_hd__nor2b_1
X$1077 VDD synth_8237 synth_8279 synth_9109 VNB|VSS VDD VNB|VSS
+ sky130_fd_sc_hd__nor2b_1
X$1078 VDD synth_9526 synth_9528 synth_9594 VNB|VSS VDD VNB|VSS
+ sky130_fd_sc_hd__nor2b_1
X$1079 VDD synth_10312 synth_8806 synth_10940 VNB|VSS VDD VNB|VSS
+ sky130_fd_sc_hd__nor2b_1
X$1080 VDD synth_9119 synth_9629 synth_10286 VNB|VSS VDD VNB|VSS
+ sky130_fd_sc_hd__nor2b_1
X$1081 VDD synth_8764 synth_9474 synth_10724 VNB|VSS VDD VNB|VSS
+ sky130_fd_sc_hd__nor2b_1
X$1082 VDD synth_9440 synth_9441 synth_9342 VNB|VSS VDD VNB|VSS
+ sky130_fd_sc_hd__nor2b_1
X$1083 VDD synth_9119 synth_8831 synth_9431 VNB|VSS VDD VNB|VSS
+ sky130_fd_sc_hd__nor2b_1
X$1084 VDD synth_8803 synth_8870 synth_10939 VNB|VSS VDD VNB|VSS
+ sky130_fd_sc_hd__nor2b_1
X$1085 VDD synth_9474 synth_10578 synth_12724 VNB|VSS VDD VNB|VSS
+ sky130_fd_sc_hd__nor2b_1
X$1086 VDD synth_8053 synth_8164 synth_8284 VNB|VSS VDD VNB|VSS
+ sky130_fd_sc_hd__nor2b_1
X$1087 VDD synth_11299 synth_11301 synth_11528 VNB|VSS VDD VNB|VSS
+ sky130_fd_sc_hd__nor2b_1
X$1088 VDD synth_10588 synth_10589 synth_10591 VNB|VSS VDD VNB|VSS
+ sky130_fd_sc_hd__nor2b_1
X$1089 VDD synth_10589 synth_10588 synth_10669 VNB|VSS VDD VNB|VSS
+ sky130_fd_sc_hd__nor2b_1
X$1090 VDD synth_12376 synth_12413 synth_12546 VNB|VSS VDD VNB|VSS
+ sky130_fd_sc_hd__nor2b_1
X$1091 VDD synth_10249 synth_10022 synth_10752 VNB|VSS VDD VNB|VSS
+ sky130_fd_sc_hd__nor2b_1
X$1092 VDD synth_8751 synth_8701 synth_9033 VNB|VSS VDD VNB|VSS
+ sky130_fd_sc_hd__nor2b_1
X$1093 VDD synth_10023 synth_10022 synth_10107 VNB|VSS VDD VNB|VSS
+ sky130_fd_sc_hd__nor2b_1
X$1094 VDD synth_8483 synth_8402 synth_8401 VNB|VSS VDD VNB|VSS
+ sky130_fd_sc_hd__nor2b_1
X$1095 VDD synth_3639 synth_3636 synth_3878 VNB|VSS VDD VNB|VSS
+ sky130_fd_sc_hd__nor2b_1
X$1096 VDD synth_8803 synth_8710 synth_9978 VNB|VSS VDD VNB|VSS
+ sky130_fd_sc_hd__nor2b_1
X$1097 VDD synth_8701 synth_8750 synth_8751 synth_8752 synth_8702 VNB|VSS
+ synth_8667 VDD VNB|VSS sky130_fd_sc_hd__o41ai_1
X$1098 VDD synth_11120 synth_10895 synth_10930 synth_10819 synth_10852 VNB|VSS
+ synth_11272 VDD VNB|VSS sky130_fd_sc_hd__o41ai_1
X$1099 VDD synth_8797 synth_8795 synth_8921 synth_8862 synth_8849 VNB|VSS
+ synth_8991 VDD VNB|VSS sky130_fd_sc_hd__o41ai_1
X$1100 VDD synth_1798 synth_1718 synth_1687 synth_1622 synth_1635 VNB|VSS
+ synth_1797 VDD VNB|VSS sky130_fd_sc_hd__o41ai_1
X$1101 VDD synth_1871 synth_1794 synth_1942 synth_1761 synth_1870 VNB|VSS
+ synth_1869 VDD VNB|VSS sky130_fd_sc_hd__o41ai_1
X$1102 VDD synth_6577 synth_5196 synth_6434 synth_6540 synth_6403 VNB|VSS
+ synth_6736 VDD VNB|VSS sky130_fd_sc_hd__o41ai_1
X$1103 VDD synth_11148 synth_11147 synth_11149 synth_11191 synth_11193 VNB|VSS
+ synth_11269 VDD VNB|VSS sky130_fd_sc_hd__o41ai_1
X$1104 VDD synth_8353 synth_8209 synth_8093 synth_8256 synth_8180 VNB|VSS
+ synth_8276 VDD VNB|VSS sky130_fd_sc_hd__o41ai_1
X$1105 VDD synth_2309 synth_2310 synth_2167 synth_2240 synth_2335 VNB|VSS
+ synth_2396 VDD VNB|VSS sky130_fd_sc_hd__o41ai_1
X$1106 VDD synth_11301 synth_11588 synth_11299 synth_11371 synth_11300 VNB|VSS
+ synth_11657 VDD VNB|VSS sky130_fd_sc_hd__o41ai_1
X$1107 VDD synth_9548 synth_6634 synth_9571 synth_9499 synth_9497 VNB|VSS
+ synth_9689 VDD VNB|VSS sky130_fd_sc_hd__o41ai_1
X$1108 VDD synth_3758 synth_3685 synth_3614 synth_3639 synth_3636 VNB|VSS
+ synth_3637 VDD VNB|VSS sky130_fd_sc_hd__o41ai_1
X$1109 VDD synth_6291 synth_6631 synth_6595 synth_6663 synth_6633 VNB|VSS
+ synth_6739 VDD VNB|VSS sky130_fd_sc_hd__o41ai_1
X$1110 VDD synth_3453 synth_3552 synth_3553 synth_3550 synth_3554 VNB|VSS
+ synth_3623 VDD VNB|VSS sky130_fd_sc_hd__o41ai_1
X$1111 VDD synth_2148 synth_1630 synth_1610 synth_1704 synth_1705 VNB|VSS
+ synth_1873 VDD VNB|VSS sky130_fd_sc_hd__o41ai_1
X$1112 VDD synth_11370 synth_11298 synth_11297 synth_11371 synth_11300 VNB|VSS
+ synth_11302 VDD VNB|VSS sky130_fd_sc_hd__o41ai_1
X$1113 VDD synth_7415 synth_6771 synth_7266 synth_7240 synth_7265 VNB|VSS
+ synth_7493 VDD VNB|VSS sky130_fd_sc_hd__o41ai_1
X$1114 VDD synth_4081 synth_3858 synth_4084 synth_4082 synth_4173 VNB|VSS
+ synth_4260 VDD VNB|VSS sky130_fd_sc_hd__o41ai_1
X$1115 VDD synth_1642 synth_1279 synth_1517 synth_1220 synth_1278 VNB|VSS
+ synth_1688 VDD VNB|VSS sky130_fd_sc_hd__o41ai_1
X$1116 VDD synth_1947 synth_2236 synth_1946 synth_2109 synth_2037 VNB|VSS
+ synth_2155 VDD VNB|VSS sky130_fd_sc_hd__o41ai_1
X$1117 VDD synth_5420 synth_4818 synth_5504 synth_5421 synth_4811 VNB|VSS
+ synth_5613 VDD VNB|VSS sky130_fd_sc_hd__o41ai_1
X$1118 VDD synth_1707 synth_1632 synth_1708 synth_1546 synth_1675 VNB|VSS
+ synth_1631 VDD VNB|VSS sky130_fd_sc_hd__o41ai_1
X$1119 VDD synth_2401 synth_2310 synth_2114 synth_2166 synth_2337 VNB|VSS
+ synth_2314 VDD VNB|VSS sky130_fd_sc_hd__o41ai_1
X$1120 VDD synth_1788 synth_1886 synth_1815 synth_1813 synth_1866 VNB|VSS
+ synth_1811 VDD VNB|VSS sky130_fd_sc_hd__o41ai_1
X$1121 VDD synth_5930 synth_5794 synth_5796 synth_5793 synth_5795 VNB|VSS
+ synth_5845 VDD VNB|VSS sky130_fd_sc_hd__o41ai_1
X$1122 VDD synth_6822 synth_6685 synth_6753 synth_6637 synth_6752 VNB|VSS
+ synth_6870 VDD VNB|VSS sky130_fd_sc_hd__o41ai_1
X$1123 VDD synth_4212 synth_4392 synth_4292 synth_4203 synth_4201 VNB|VSS
+ synth_4205 VDD VNB|VSS sky130_fd_sc_hd__o41ai_1
X$1124 VDD synth_3748 synth_4062 synth_3787 synth_3955 synth_4011 VNB|VSS
+ synth_3954 VDD VNB|VSS sky130_fd_sc_hd__o41ai_1
X$1125 VDD synth_8547 synth_8464 synth_8463 VDD VNB|VSS synth_8544 VNB|VSS
+ sky130_fd_sc_hd__o21ai_1
X$1126 VNB|VSS synth_8311 synth_8463 synth_8241 synth_8464 synth_8467 VDD VDD
+ VNB|VSS sky130_fd_sc_hd__nand4_2
X$1127 VDD synth_9396 synth_9695 synth_10793 synth_10438 VNB|VSS synth_11317
+ VDD VNB|VSS sky130_fd_sc_hd__a211oi_1
X$1128 VDD synth_11010 synth_10578 synth_9738 synth_11091 VNB|VSS synth_11515
+ VDD VNB|VSS sky130_fd_sc_hd__a211oi_1
X$1129 VDD synth_10185 synth_9947 synth_9019 synth_10128 VNB|VSS synth_9794 VDD
+ VNB|VSS sky130_fd_sc_hd__a211oi_1
X$1130 VDD synth_6593 synth_6622 synth_6434 synth_6403 VNB|VSS synth_5797 VDD
+ VNB|VSS sky130_fd_sc_hd__a211oi_1
X$1131 VDD synth_6471 synth_7591 synth_6469 synth_7812 VNB|VSS synth_7749 VDD
+ VNB|VSS sky130_fd_sc_hd__a211oi_1
X$1132 sky130_fd_sc_hd__conb_1
X$1133 VDD synth_9293 synth_9063 synth_9173 synth_9209 VNB|VSS synth_9176 VDD
+ VNB|VSS sky130_fd_sc_hd__a211oi_1
X$1134 VDD synth_11640 synth_10212 synth_9062 synth_12758 VNB|VSS synth_12667
+ VDD VNB|VSS sky130_fd_sc_hd__a211oi_1
X$1135 VDD synth_9239 synth_8738 synth_9292 synth_9325 VNB|VSS synth_9395 VDD
+ VNB|VSS sky130_fd_sc_hd__a211oi_1
X$1136 VDD synth_4172 synth_4216 synth_4081 synth_4084 VNB|VSS synth_4217 VDD
+ VNB|VSS sky130_fd_sc_hd__a211oi_1
X$1137 VDD synth_9325 synth_9292 synth_8764 synth_10159 VNB|VSS synth_10221 VDD
+ VNB|VSS sky130_fd_sc_hd__a211oi_1
X$1138 VDD synth_10290 synth_9292 synth_8604 synth_9034 VNB|VSS synth_10291 VDD
+ VNB|VSS sky130_fd_sc_hd__a211oi_1
X$1139 VDD synth_2009 synth_1862 synth_1735 synth_1737 VNB|VSS synth_1967 VDD
+ VNB|VSS sky130_fd_sc_hd__a211oi_1
X$1140 VDD synth_10902 synth_8806 synth_10833 synth_10781 VNB|VSS synth_10831
+ VDD VNB|VSS sky130_fd_sc_hd__a211oi_1
X$1141 VDD synth_10688 synth_9677 synth_10578 synth_10695 VNB|VSS synth_10780
+ VDD VNB|VSS sky130_fd_sc_hd__a211oi_1
X$1142 VDD synth_12345 synth_10312 synth_9292 synth_12453 VNB|VSS synth_12220
+ VDD VNB|VSS sky130_fd_sc_hd__a211oi_1
X$1143 VDD synth_8880 synth_8968 synth_8954 synth_8881 VNB|VSS synth_8902 VDD
+ VNB|VSS sky130_fd_sc_hd__a211oi_1
X$1144 VDD synth_6224 synth_6139 synth_6109 synth_5944 VNB|VSS synth_6293 VDD
+ VNB|VSS sky130_fd_sc_hd__a211oi_1
X$1145 VDD synth_11395 synth_11414 synth_11392 synth_11415 VNB|VSS synth_11265
+ VDD VNB|VSS sky130_fd_sc_hd__a211oi_1
X$1146 VDD synth_9553 synth_9292 synth_8870 synth_9625 VNB|VSS synth_9697 VDD
+ VNB|VSS sky130_fd_sc_hd__a211oi_1
X$1147 VDD synth_9591 synth_9653 synth_9589 synth_9652 VNB|VSS synth_9590 VDD
+ VNB|VSS sky130_fd_sc_hd__a211oi_1
X$1148 VDD synth_9473 synth_9387 synth_11751 synth_11815 VNB|VSS synth_12148
+ VDD VNB|VSS sky130_fd_sc_hd__a211oi_1
X$1149 VDD synth_3878 synth_3896 synth_3897 synth_4421 VNB|VSS synth_3759 VDD
+ VNB|VSS sky130_fd_sc_hd__a211oi_1
X$1150 VDD synth_10455 synth_9947 synth_9019 synth_10249 VNB|VSS synth_9875 VDD
+ VNB|VSS sky130_fd_sc_hd__a211oi_1
X$1151 VDD synth_4153 synth_3795 synth_4036 synth_4035 VNB|VSS synth_4034 VDD
+ VNB|VSS sky130_fd_sc_hd__a211oi_1
X$1152 VDD synth_1996 synth_1995 synth_1871 synth_1707 VNB|VSS synth_1945 VDD
+ VNB|VSS sky130_fd_sc_hd__a211oi_1
X$1153 VDD synth_9048 synth_10849 synth_10796 synth_9677 VNB|VSS synth_10574
+ VDD VNB|VSS sky130_fd_sc_hd__a211oi_1
X$1154 VDD synth_9775 synth_9851 synth_9773 synth_9829 VNB|VSS synth_9772 VDD
+ VNB|VSS sky130_fd_sc_hd__a211oi_1
X$1155 VDD synth_9239 synth_9119 synth_9629 synth_11097 VNB|VSS synth_11277 VDD
+ VNB|VSS sky130_fd_sc_hd__a211oi_1
X$1156 VDD synth_10102 synth_9062 synth_8873 synth_10348 VNB|VSS synth_10147
+ VDD VNB|VSS sky130_fd_sc_hd__a211oi_1
X$1157 VDD synth_11676 synth_10312 synth_11644 synth_11648 VNB|VSS synth_11647
+ VDD VNB|VSS sky130_fd_sc_hd__a211oi_1
X$1158 VDD synth_8945 synth_9483 synth_10793 synth_10849 VNB|VSS synth_11813
+ VDD VNB|VSS sky130_fd_sc_hd__a211oi_1
X$1159 VDD synth_5423 synth_5264 synth_5422 synth_5469 VNB|VSS synth_5506 VDD
+ VNB|VSS sky130_fd_sc_hd__a211oi_1
X$1160 VDD synth_11045 synth_11201 synth_10449 synth_11197 VNB|VSS synth_11116
+ VDD VNB|VSS sky130_fd_sc_hd__a211oi_1
X$1161 VDD synth_10149 synth_8872 synth_10014 synth_9967 VNB|VSS synth_10010
+ VDD VNB|VSS sky130_fd_sc_hd__a211oi_1
X$1162 VDD synth_12474 synth_12534 synth_11940 synth_12611 VNB|VSS synth_12422
+ VDD VNB|VSS sky130_fd_sc_hd__a211oi_1
X$1163 VDD synth_10915 synth_10793 synth_10862 synth_10917 VNB|VSS synth_10916
+ VDD VNB|VSS sky130_fd_sc_hd__a211oi_1
X$1164 VDD synth_10186 synth_9947 synth_9019 synth_10663 VNB|VSS synth_10807
+ VDD VNB|VSS sky130_fd_sc_hd__a211oi_1
X$1165 VDD synth_12675 synth_12745 synth_12310 synth_12744 VNB|VSS synth_12544
+ VDD VNB|VSS sky130_fd_sc_hd__a211oi_1
X$1166 VDD synth_5341 synth_5157 synth_5421 synth_5420 VNB|VSS synth_5533 VDD
+ VNB|VSS sky130_fd_sc_hd__a211oi_1
X$1167 VDD synth_1964 synth_1815 synth_2122 synth_1966 VNB|VSS synth_2007 VDD
+ VNB|VSS sky130_fd_sc_hd__a211oi_1
X$1168 VDD synth_1517 synth_1642 synth_1965 synth_2258 VDD synth_2009 VNB|VSS
+ VNB|VSS sky130_fd_sc_hd__a211o_1
X$1169 VDD synth_9821 synth_8872 synth_9967 synth_9933 VNB|VSS synth_9894 VDD
+ VNB|VSS sky130_fd_sc_hd__a211oi_1
X$1170 VDD synth_2000 synth_1708 synth_1947 synth_1946 VNB|VSS synth_2083 VDD
+ VNB|VSS sky130_fd_sc_hd__a211oi_1
X$1171 VDD synth_10725 synth_9042 synth_9677 synth_10845 VNB|VSS synth_10695
+ VDD VNB|VSS sky130_fd_sc_hd__a211oi_1
X$1172 VDD synth_10828 synth_9119 synth_10869 synth_11783 VNB|VSS synth_10731
+ VDD VNB|VSS sky130_fd_sc_hd__a211oi_1
X$1173 VDD synth_9290 synth_8910 synth_9174 synth_9394 VNB|VSS synth_9393 VDD
+ VNB|VSS sky130_fd_sc_hd__a211oi_1
X$1174 VDD synth_12607 synth_12737 synth_12314 synth_12735 VNB|VSS synth_12763
+ VDD VNB|VSS sky130_fd_sc_hd__a211oi_1
X$1175 VDD synth_6442 synth_6292 synth_6443 synth_6502 VNB|VSS synth_6360 VDD
+ VNB|VSS sky130_fd_sc_hd__a211oi_1
X$1176 VDD synth_10002 synth_8738 synth_10003 synth_9625 VNB|VSS synth_10230
+ VDD VNB|VSS sky130_fd_sc_hd__a211oi_1
X$1177 VDD synth_4618 synth_4607 synth_4680 synth_4699 VNB|VSS synth_4697 VDD
+ VNB|VSS sky130_fd_sc_hd__a211oi_1
X$1178 VDD synth_8643 synth_8664 synth_8250 synth_8726 VNB|VSS synth_8477 VDD
+ VNB|VSS sky130_fd_sc_hd__a211oi_1
X$1179 VDD synth_9700 synth_10578 synth_9387 synth_10440 VNB|VSS synth_10727
+ VDD VNB|VSS sky130_fd_sc_hd__a211oi_1
X$1180 VDD synth_8607 synth_8433 synth_8517 synth_8361 VNB|VSS synth_8465 VDD
+ VNB|VSS sky130_fd_sc_hd__a211oi_1
X$1181 VDD synth_7500 synth_7501 synth_7423 VNB|VSS VDD synth_7518 VNB|VSS
+ sky130_fd_sc_hd__and3_1
X$1182 VDD synth_11606 synth_11704 synth_7743 VNB|VSS VDD synth_11685 VNB|VSS
+ sky130_fd_sc_hd__and3_1
X$1183 VDD synth_9703 synth_10207 synth_7743 VNB|VSS VDD synth_10135 VNB|VSS
+ sky130_fd_sc_hd__and3_1
X$1184 VDD synth_10760 synth_10972 synth_7743 VNB|VSS VDD synth_10946 VNB|VSS
+ sky130_fd_sc_hd__and3_1
X$1185 VDD synth_10888 synth_11997 synth_7743 VNB|VSS VDD synth_11953 VNB|VSS
+ sky130_fd_sc_hd__and3_1
X$1186 VDD synth_10949 synth_12126 synth_7743 VNB|VSS VDD synth_12182 VNB|VSS
+ sky130_fd_sc_hd__and3_1
X$1187 VDD synth_10760 synth_10826 synth_7743 VNB|VSS VDD synth_10890 VNB|VSS
+ sky130_fd_sc_hd__and3_1
X$1188 VDD synth_9250 synth_9460 synth_7743 VNB|VSS VDD synth_9458 VNB|VSS
+ sky130_fd_sc_hd__and3_1
X$1189 VDD synth_10888 synth_11962 synth_7743 VNB|VSS VDD synth_11960 VNB|VSS
+ sky130_fd_sc_hd__and3_1
X$1190 VDD synth_10872 synth_11173 synth_7743 VNB|VSS VDD synth_11270 VNB|VSS
+ sky130_fd_sc_hd__and3_1
X$1191 VDD synth_7214 synth_7591 synth_7670 VNB|VSS VDD synth_6909 VNB|VSS
+ sky130_fd_sc_hd__and3_1
X$1192 VDD synth_9514 synth_8764 synth_9583 VNB|VSS VDD synth_9613 VNB|VSS
+ sky130_fd_sc_hd__and3_1
X$1193 VDD synth_6223 synth_6137 synth_6138 VNB|VSS VDD synth_6292 VNB|VSS
+ sky130_fd_sc_hd__and3_1
X$1194 VDD synth_7437 synth_7341 synth_7286 VNB|VSS VDD synth_7502 VNB|VSS
+ sky130_fd_sc_hd__and3_1
X$1195 VDD synth_8400 synth_8484 synth_8575 VNB|VSS VDD synth_8197 VNB|VSS
+ sky130_fd_sc_hd__and3_1
X$1196 VDD synth_4291 synth_4305 synth_4377 VNB|VSS VDD synth_4117 VNB|VSS
+ sky130_fd_sc_hd__and3_1
X$1197 VDD synth_6170 synth_7127 synth_7128 VNB|VSS VDD synth_7126 VNB|VSS
+ sky130_fd_sc_hd__and3_1
X$1198 VDD synth_1451 synth_1522 synth_1521 VNB|VSS VDD synth_1452 VNB|VSS
+ sky130_fd_sc_hd__and3_1
X$1199 VNB|VSS synth_1523 synth_1589 synth_1524 synth_1553 synth_1599 VDD VDD
+ VNB|VSS sky130_fd_sc_hd__nor4_2
X$1200 VDD synth_10949 synth_12197 synth_7743 VNB|VSS VDD synth_12256 VNB|VSS
+ sky130_fd_sc_hd__and3_1
X$1201 VDD synth_9703 synth_9777 synth_7743 VNB|VSS VDD synth_9813 VNB|VSS
+ sky130_fd_sc_hd__and3_1
X$1202 VDD synth_1969 synth_4818 synth_4994 VNB|VSS VDD synth_4815 VNB|VSS
+ sky130_fd_sc_hd__and3_1
X$1203 VDD synth_8728 synth_9148 synth_7743 VNB|VSS VDD synth_9121 VNB|VSS
+ sky130_fd_sc_hd__and3_1
X$1204 VDD synth_8728 synth_8809 synth_7743 VNB|VSS VDD synth_8905 VNB|VSS
+ sky130_fd_sc_hd__and3_1
X$1205 VDD synth_9250 synth_9371 synth_7743 VNB|VSS VDD synth_9246 VNB|VSS
+ sky130_fd_sc_hd__and3_1
X$1206 VDD synth_11639 synth_10285 synth_11900 VNB|VSS VDD synth_11902 VNB|VSS
+ sky130_fd_sc_hd__and3_1
X$1207 VDD synth_11606 synth_11701 synth_7743 VNB|VSS VDD synth_11822 VNB|VSS
+ sky130_fd_sc_hd__and3_1
X$1208 VDD synth_7422 synth_7608 synth_7677 VNB|VSS VDD synth_7340 VNB|VSS
+ sky130_fd_sc_hd__and3_1
X$1209 VDD synth_10872 synth_11250 synth_7743 VNB|VSS VDD synth_11419 VNB|VSS
+ sky130_fd_sc_hd__and3_1
X$1210 VDD synth_7733 synth_7804 VNB|VSS VDD VNB|VSS sky130_fd_sc_hd__buf_1
X$1211 VDD synth_6309 inference_cycles[9] VNB|VSS VDD VNB|VSS
+ sky130_fd_sc_hd__buf_1
X$1212 VDD synth_6759 inference_cycles[11] VNB|VSS VDD VNB|VSS
+ sky130_fd_sc_hd__buf_1
X$1213 VDD synth_7591 inference_cycles[0] VNB|VSS VDD VNB|VSS
+ sky130_fd_sc_hd__buf_1
X$1214 VDD synth_6834 inference_cycles[12] VNB|VSS VDD VNB|VSS
+ sky130_fd_sc_hd__buf_1
X$1215 VDD synth_6390 inference_cycles[10] VNB|VSS VDD VNB|VSS
+ sky130_fd_sc_hd__buf_1
X$1216 VDD synth_6391 inference_cycles[15] VNB|VSS VDD VNB|VSS
+ sky130_fd_sc_hd__buf_1
X$1217 VDD synth_6466 inference_cycles[7] VNB|VSS VDD VNB|VSS
+ sky130_fd_sc_hd__buf_1
X$1218 VDD synth_6758 inference_cycles[8] VNB|VSS VDD VNB|VSS
+ sky130_fd_sc_hd__buf_1
X$1219 VDD synth_8770 no_spike VNB|VSS VDD VNB|VSS sky130_fd_sc_hd__buf_1
X$1220 VDD synth_7127 inference_cycles[3] VNB|VSS VDD VNB|VSS
+ sky130_fd_sc_hd__buf_1
X$1221 VDD synth_8201 synth_8121 VNB|VSS VDD VNB|VSS sky130_fd_sc_hd__buf_1
X$1222 VDD synth_7048 inference_cycles[6] VNB|VSS VDD VNB|VSS
+ sky130_fd_sc_hd__buf_1
X$1223 VDD synth_7128 inference_cycles[4] VNB|VSS VDD VNB|VSS
+ sky130_fd_sc_hd__buf_1
X$1224 VDD synth_6170 inference_cycles[5] VNB|VSS VDD VNB|VSS
+ sky130_fd_sc_hd__buf_1
X$1225 VDD synth_6310 inference_cycles[14] VNB|VSS VDD VNB|VSS
+ sky130_fd_sc_hd__buf_1
X$1226 VDD synth_7815 input_complete VNB|VSS VDD VNB|VSS sky130_fd_sc_hd__buf_1
X$1227 VDD synth_7214 inference_cycles[2] VNB|VSS VDD VNB|VSS
+ sky130_fd_sc_hd__buf_1
X$1228 VDD synth_7670 inference_cycles[1] VNB|VSS VDD VNB|VSS
+ sky130_fd_sc_hd__buf_1
X$1229 VDD synth_8653 done VNB|VSS VDD VNB|VSS sky130_fd_sc_hd__buf_1
X$1230 VDD synth_7946 load_ready VNB|VSS VDD VNB|VSS sky130_fd_sc_hd__buf_1
X$1231 VDD synth_8199 busy VNB|VSS VDD VNB|VSS sky130_fd_sc_hd__buf_1
X$1232 VDD synth_2816 synth_2738 VNB|VSS VDD VNB|VSS sky130_fd_sc_hd__buf_1
X$1233 VDD synth_6393 inference_cycles[13] VNB|VSS VDD VNB|VSS
+ sky130_fd_sc_hd__buf_1
X$1234 VDD synth_4381 synth_4333 VNB|VSS VDD VNB|VSS sky130_fd_sc_hd__buf_1
X$1235 VDD synth_8890 result_class[1] VNB|VSS VDD VNB|VSS sky130_fd_sc_hd__buf_1
X$1236 VDD synth_9021 result_class[0] VNB|VSS VDD VNB|VSS sky130_fd_sc_hd__buf_1
X$1237 VDD synth_11322 synth_9730 synth_9851 synth_11323 VNB|VSS VDD
+ synth_11321 VNB|VSS sky130_fd_sc_hd__a31oi_1
X$1238 VDD synth_6837 synth_7128 synth_7127 synth_6170 VNB|VSS VDD synth_7347
+ VNB|VSS sky130_fd_sc_hd__a31oi_1
X$1239 VDD synth_12668 synth_9239 synth_9629 synth_12627 VNB|VSS VDD
+ synth_12636 VNB|VSS sky130_fd_sc_hd__a31oi_1
X$1240 VDD synth_9047 synth_9834 synth_8870 synth_9697 VNB|VSS VDD synth_9745
+ VNB|VSS sky130_fd_sc_hd__a31oi_1
X$1241 VDD synth_11462 synth_11461 synth_8944 synth_9062 VNB|VSS VDD
+ synth_11520 VNB|VSS sky130_fd_sc_hd__a31oi_1
X$1242 VDD synth_3500 synth_3862 synth_3863 synth_3890 VNB|VSS VDD synth_3817
+ VNB|VSS sky130_fd_sc_hd__a31oi_1
X$1243 VDD synth_6837 synth_6838 synth_6758 synth_6309 VNB|VSS VDD synth_6560
+ VNB|VSS sky130_fd_sc_hd__a31oi_1
X$1244 VDD synth_1294 synth_4815 synth_4199 synth_4597 VNB|VSS VDD synth_4817
+ VNB|VSS sky130_fd_sc_hd__a31oi_1
X$1245 VDD synth_9826 synth_9895 synth_9701 synth_10014 VNB|VSS VDD synth_9817
+ VNB|VSS sky130_fd_sc_hd__a31oi_1
X$1246 VDD synth_11137 synth_11007 synth_10483 synth_10285 VNB|VSS VDD
+ synth_9679 VNB|VSS sky130_fd_sc_hd__a31oi_1
X$1247 VDD synth_8802 synth_10653 synth_9850 synth_10652 VNB|VSS VDD
+ synth_10692 VNB|VSS sky130_fd_sc_hd__a31oi_1
X$1248 VDD synth_12556 synth_12711 synth_9062 synth_12667 VNB|VSS VDD
+ synth_12638 VNB|VSS sky130_fd_sc_hd__a31oi_1
X$1249 VDD synth_11485 synth_11474 synth_11475 synth_11687 VNB|VSS VDD
+ synth_11612 VNB|VSS sky130_fd_sc_hd__a31oi_1
X$1250 VDD synth_9700 synth_9695 synth_9112 synth_12408 VNB|VSS VDD synth_12407
+ VNB|VSS sky130_fd_sc_hd__a31oi_1
X$1251 VDD synth_7422 synth_8021 synth_7945 synth_7951 VNB|VSS VDD synth_7950
+ VNB|VSS sky130_fd_sc_hd__a31oi_1
X$1252 VDD synth_11313 synth_11360 synth_9292 synth_11436 VNB|VSS VDD
+ synth_11437 VNB|VSS sky130_fd_sc_hd__a31oi_1
X$1253 VDD synth_4223 synth_4372 synth_4448 synth_4489 VNB|VSS VDD synth_4406
+ VNB|VSS sky130_fd_sc_hd__a31oi_1
X$1254 VDD synth_9477 synth_9476 synth_9062 synth_9101 VNB|VSS VDD synth_9330
+ VNB|VSS sky130_fd_sc_hd__a31oi_1
X$1255 VDD synth_10493 synth_9160 synth_8872 synth_10055 VNB|VSS VDD synth_9776
+ VNB|VSS sky130_fd_sc_hd__a31oi_1
X$1256 VDD synth_9189 synth_9187 synth_9188 synth_9190 VNB|VSS VDD synth_9191
+ VNB|VSS sky130_fd_sc_hd__a31oi_1
X$1257 VDD synth_5882 synth_5881 synth_5933 synth_5734 VNB|VSS VDD synth_5967
+ VNB|VSS sky130_fd_sc_hd__a31oi_1
X$1258 VDD synth_6292 synth_6504 synth_5973 synth_6362 VNB|VSS VDD synth_6503
+ VNB|VSS sky130_fd_sc_hd__a31oi_1
X$1259 VDD synth_11302 synth_9109 synth_11351 synth_11304 VNB|VSS VDD
+ synth_8541 VNB|VSS sky130_fd_sc_hd__a31oi_1
X$1260 VDD synth_9167 synth_9144 synth_9168 synth_8704 VNB|VSS VDD synth_9281
+ VNB|VSS sky130_fd_sc_hd__a31oi_1
X$1261 VDD synth_12558 synth_12454 synth_9062 synth_12357 VNB|VSS VDD
+ synth_12381 VNB|VSS sky130_fd_sc_hd__a31oi_1
X$1262 VDD synth_6873 synth_6686 synth_6770 synth_6637 VNB|VSS VDD synth_6872
+ VNB|VSS sky130_fd_sc_hd__a31oi_1
X$1263 VDD synth_10232 synth_9677 synth_9042 synth_10796 VNB|VSS VDD
+ synth_12559 VNB|VSS sky130_fd_sc_hd__a31oi_1
X$1264 VDD synth_10099 synth_8870 synth_10793 synth_11314 VNB|VSS VDD
+ synth_11313 VNB|VSS sky130_fd_sc_hd__a31oi_1
X$1265 VDD synth_8108 synth_8107 synth_8024 synth_7870 VNB|VSS VDD synth_8261
+ VNB|VSS sky130_fd_sc_hd__a31oi_1
X$1266 VDD synth_11797 synth_11837 synth_9062 synth_11649 VNB|VSS VDD
+ synth_11798 VNB|VSS sky130_fd_sc_hd__a31oi_1
X$1267 VDD synth_11065 synth_10989 synth_10793 synth_11008 VNB|VSS VDD
+ synth_11067 VNB|VSS sky130_fd_sc_hd__a31oi_1
X$1268 VDD synth_9514 synth_9322 synth_10312 synth_11932 VNB|VSS VDD
+ synth_11866 VNB|VSS sky130_fd_sc_hd__a31oi_1
X$1269 VDD synth_12218 synth_8803 synth_9062 synth_12171 VNB|VSS VDD
+ synth_12172 VNB|VSS sky130_fd_sc_hd__a31oi_1
X$1270 VDD synth_4438 synth_4353 synth_4521 synth_4494 VNB|VSS VDD synth_4519
+ VNB|VSS sky130_fd_sc_hd__a31oi_1
X$1271 VDD synth_9108 synth_9160 synth_8872 synth_10055 VNB|VSS VDD synth_9964
+ VNB|VSS sky130_fd_sc_hd__a31oi_1
X$1272 VDD synth_6539 synth_6487 synth_6433 synth_6484 VNB|VSS VDD synth_6483
+ VNB|VSS sky130_fd_sc_hd__a31oi_1
X$1273 VDD synth_9696 synth_11912 synth_8806 synth_10489 VNB|VSS VDD
+ synth_12016 VNB|VSS sky130_fd_sc_hd__a31oi_1
X$1274 VDD synth_9017 synth_8810 synth_8885 synth_8886 VNB|VSS VDD synth_8822
+ VNB|VSS sky130_fd_sc_hd__a31oi_1
X$1275 VDD synth_8944 synth_9284 synth_9063 synth_9613 VNB|VSS VDD synth_9545
+ VNB|VSS sky130_fd_sc_hd__a31oi_1
X$1276 VDD synth_10172 synth_10222 synth_8764 synth_10221 VNB|VSS VDD
+ synth_10294 VNB|VSS sky130_fd_sc_hd__a31oi_1
X$1277 VDD synth_9743 synth_10220 synth_9677 synth_10161 VNB|VSS VDD
+ synth_10173 VNB|VSS sky130_fd_sc_hd__a31oi_1
X$1278 VDD synth_8944 synth_9060 synth_10793 synth_11317 VNB|VSS VDD
+ synth_11519 VNB|VSS sky130_fd_sc_hd__a31oi_1
X$1279 VDD synth_4284 synth_3732 synth_3704 synth_4108 VNB|VSS VDD synth_4409
+ VNB|VSS sky130_fd_sc_hd__a31oi_1
X$1280 VDD synth_12173 synth_12214 synth_12110 synth_8805 VNB|VSS VDD
+ synth_12174 VNB|VSS sky130_fd_sc_hd__a31oi_1
X$1281 VDD synth_9553 synth_8831 synth_9434 synth_9241 VNB|VSS VDD synth_9518
+ VNB|VSS sky130_fd_sc_hd__a31oi_1
X$1282 VDD synth_11441 synth_11287 synth_9062 synth_11440 VNB|VSS VDD
+ synth_11325 VNB|VSS sky130_fd_sc_hd__a31oi_1
X$1283 VDD synth_2587 synth_2624 synth_1353 synth_2706 VNB|VSS VDD synth_2707
+ VNB|VSS sky130_fd_sc_hd__a31oi_1
X$1284 VDD synth_12655 synth_12560 synth_10793 synth_12654 VNB|VSS VDD
+ synth_12358 VNB|VSS sky130_fd_sc_hd__a31oi_1
X$1285 VDD synth_11290 synth_11465 synth_10793 synth_11813 VNB|VSS VDD
+ synth_11913 VNB|VSS sky130_fd_sc_hd__a31oi_1
X$1286 VDD synth_4331 synth_3876 synth_4094 synth_4245 VNB|VSS VDD synth_3898
+ VNB|VSS sky130_fd_sc_hd__a31oi_1
X$1287 VDD synth_7215 synth_7127 synth_7214 synth_6696 VNB|VSS VDD synth_7506
+ VNB|VSS sky130_fd_sc_hd__a31oi_1
X$1288 VDD synth_8804 synth_11537 synth_10101 synth_8917 VNB|VSS VDD
+ synth_11718 VNB|VSS sky130_fd_sc_hd__a31oi_1
X$1289 VDD synth_9240 synth_10312 synth_10285 synth_10007 VNB|VSS VDD
+ synth_11895 VNB|VSS sky130_fd_sc_hd__a31oi_1
X$1290 VDD synth_9240 synth_10312 synth_8803 synth_11648 VNB|VSS VDD
+ synth_12052 VNB|VSS sky130_fd_sc_hd__a31oi_1
X$1291 VDD synth_4634 synth_1294 synth_4199 synth_4597 VNB|VSS VDD synth_4717
+ VNB|VSS sky130_fd_sc_hd__a31oi_1
X$1292 VDD synth_10211 synth_10283 synth_10284 synth_10351 VDD VNB|VSS VNB|VSS
+ sky130_fd_sc_hd__mux2i_1
X$1293 VDD synth_2621 synth_2701 synth_2698 synth_2731 VDD VNB|VSS VNB|VSS
+ sky130_fd_sc_hd__mux2i_1
X$1294 VDD synth_6598 synth_6777 synth_6741 synth_6716 VDD VNB|VSS VNB|VSS
+ sky130_fd_sc_hd__mux2i_1
X$1295 VDD synth_2413 synth_2414 synth_2415 synth_2371 VDD VNB|VSS VNB|VSS
+ sky130_fd_sc_hd__mux2i_1
X$1296 VDD synth_10063 synth_10245 synth_10224 synth_10223 VDD VNB|VSS VNB|VSS
+ sky130_fd_sc_hd__mux2i_1
X$1297 VDD synth_11449 synth_11501 synth_11451 synth_11635 VDD VNB|VSS VNB|VSS
+ sky130_fd_sc_hd__mux2i_1
X$1298 VDD synth_2911 synth_2910 synth_2909 synth_2785 VDD VNB|VSS VNB|VSS
+ sky130_fd_sc_hd__mux2i_1
X$1299 VDD synth_9981 synth_9766 synth_8710 synth_9828 VDD VNB|VSS VNB|VSS
+ sky130_fd_sc_hd__mux2i_1
X$1300 VDD synth_4301 synth_4255 synth_4429 synth_4393 VDD VNB|VSS VNB|VSS
+ sky130_fd_sc_hd__mux2i_1
X$1301 VDD synth_2950 synth_3152 synth_3112 synth_3154 VDD VNB|VSS VNB|VSS
+ sky130_fd_sc_hd__mux2i_1
X$1302 VDD synth_11029 synth_11113 synth_11033 synth_11144 VDD VNB|VSS VNB|VSS
+ sky130_fd_sc_hd__mux2i_1
X$1303 VDD synth_2569 synth_2559 synth_2507 synth_2618 VDD VNB|VSS VNB|VSS
+ sky130_fd_sc_hd__mux2i_1
X$1304 VDD synth_2749 synth_2680 synth_2681 synth_2753 VDD VNB|VSS VNB|VSS
+ sky130_fd_sc_hd__mux2i_1
X$1305 VDD synth_8674 synth_8705 synth_8735 synth_8785 VDD VNB|VSS VNB|VSS
+ sky130_fd_sc_hd__mux2i_1
X$1306 VDD synth_1225 synth_1256 synth_1257 synth_1344 VDD VNB|VSS VNB|VSS
+ sky130_fd_sc_hd__mux2i_1
X$1307 VDD synth_2631 synth_2560 synth_2587 synth_2628 VDD VNB|VSS VNB|VSS
+ sky130_fd_sc_hd__mux2i_1
X$1308 VDD synth_1393 synth_1426 synth_1470 synth_1469 VDD VNB|VSS VNB|VSS
+ sky130_fd_sc_hd__mux2i_1
X$1309 VDD synth_11979 synth_11981 synth_12068 synth_11980 VDD VNB|VSS VNB|VSS
+ sky130_fd_sc_hd__mux2i_1
X$1310 VDD synth_2734 synth_2745 synth_2896 synth_2746 VDD VNB|VSS VNB|VSS
+ sky130_fd_sc_hd__mux2i_1
X$1311 VDD synth_9687 synth_9655 synth_9495 synth_9654 VDD VNB|VSS VNB|VSS
+ sky130_fd_sc_hd__mux2i_1
X$1312 VDD synth_3266 synth_3575 synth_3661 synth_3663 VDD VNB|VSS VNB|VSS
+ sky130_fd_sc_hd__mux2i_1
X$1313 VDD synth_5596 synth_5707 synth_5740 synth_5739 VDD VNB|VSS VNB|VSS
+ sky130_fd_sc_hd__mux2i_1
X$1314 VDD synth_12040 synth_12019 synth_11965 synth_12041 VDD VNB|VSS VNB|VSS
+ sky130_fd_sc_hd__mux2i_1
X$1315 VDD synth_10280 synth_10694 synth_10792 synth_10720 VDD VNB|VSS VNB|VSS
+ sky130_fd_sc_hd__mux2i_1
X$1316 VDD synth_5104 synth_5009 synth_5107 synth_5206 VDD VNB|VSS VNB|VSS
+ sky130_fd_sc_hd__mux2i_1
X$1317 VDD synth_7301 synth_7465 synth_7467 synth_7379 VDD VNB|VSS VNB|VSS
+ sky130_fd_sc_hd__mux2i_1
X$1318 VDD synth_12271 synth_12495 synth_12520 synth_12703 VDD VNB|VSS VNB|VSS
+ sky130_fd_sc_hd__mux2i_1
X$1319 VDD synth_7566 synth_7479 synth_7567 synth_7529 VDD VNB|VSS VNB|VSS
+ sky130_fd_sc_hd__mux2i_1
X$1320 VDD synth_7390 synth_7366 synth_7391 synth_7450 VDD VNB|VSS VNB|VSS
+ sky130_fd_sc_hd__mux2i_1
X$1321 VDD synth_7438 synth_7523 synth_7441 synth_7524 VDD VNB|VSS VNB|VSS
+ sky130_fd_sc_hd__mux2i_1
X$1322 VDD synth_6954 synth_6955 synth_7015 synth_7216 VDD VNB|VSS VNB|VSS
+ sky130_fd_sc_hd__mux2i_1
X$1323 VDD synth_11855 synth_11896 synth_11925 synth_11858 VDD VNB|VSS VNB|VSS
+ sky130_fd_sc_hd__mux2i_1
X$1324 VDD synth_3028 synth_3146 synth_3029 synth_3147 VDD VNB|VSS VNB|VSS
+ sky130_fd_sc_hd__mux2i_1
X$1325 VDD synth_8038 synth_8277 synth_8069 synth_8155 VDD VNB|VSS VNB|VSS
+ sky130_fd_sc_hd__mux2i_1
X$1326 VDD synth_3875 synth_3965 synth_3997 synth_3944 VDD VNB|VSS VNB|VSS
+ sky130_fd_sc_hd__mux2i_1
X$1327 VDD synth_5425 synth_5462 synth_5426 synth_5461 VDD VNB|VSS VNB|VSS
+ sky130_fd_sc_hd__mux2i_1
X$1328 VDD synth_8306 synth_8308 synth_8309 synth_8307 VDD VNB|VSS VNB|VSS
+ sky130_fd_sc_hd__mux2i_1
X$1329 VDD synth_7781 synth_7857 synth_7856 synth_7924 VDD VNB|VSS VNB|VSS
+ sky130_fd_sc_hd__mux2i_1
X$1330 VDD synth_7883 synth_8203 synth_8154 synth_8153 VDD VNB|VSS VNB|VSS
+ sky130_fd_sc_hd__mux2i_1
X$1331 VDD synth_12167 synth_12278 synth_12210 synth_12277 VDD VNB|VSS VNB|VSS
+ sky130_fd_sc_hd__mux2i_1
X$1332 VDD synth_4921 synth_4923 synth_4924 synth_4920 VDD VNB|VSS VNB|VSS
+ sky130_fd_sc_hd__mux2i_1
X$1333 VDD synth_8506 synth_9000 synth_8935 synth_9043 VDD VNB|VSS VNB|VSS
+ sky130_fd_sc_hd__mux2i_1
X$1334 VDD synth_7103 synth_7233 synth_7104 synth_7101 VDD VNB|VSS VNB|VSS
+ sky130_fd_sc_hd__mux2i_1
X$1335 VDD synth_10127 synth_10167 synth_10131 synth_10200 VDD VNB|VSS VNB|VSS
+ sky130_fd_sc_hd__mux2i_1
X$1336 VDD synth_2834 synth_3121 synth_3047 synth_3120 VDD VNB|VSS VNB|VSS
+ sky130_fd_sc_hd__mux2i_1
X$1337 VDD synth_4907 synth_5039 synth_5038 synth_4873 VDD VNB|VSS VNB|VSS
+ sky130_fd_sc_hd__mux2i_1
X$1338 VDD synth_2433 synth_2506 synth_2504 synth_2547 VDD VNB|VSS VNB|VSS
+ sky130_fd_sc_hd__mux2i_1
X$1339 VDD synth_5273 synth_5369 synth_5274 synth_5514 VDD VNB|VSS VNB|VSS
+ sky130_fd_sc_hd__mux2i_1
X$1340 VDD synth_2882 synth_2905 synth_2881 synth_2983 VDD VNB|VSS VNB|VSS
+ sky130_fd_sc_hd__mux2i_1
X$1341 VDD synth_9408 synth_9301 synth_9455 synth_9539 VDD VNB|VSS VNB|VSS
+ sky130_fd_sc_hd__mux2i_1
X$1342 VDD synth_775 synth_1022 synth_938 synth_937 VDD VNB|VSS VNB|VSS
+ sky130_fd_sc_hd__mux2i_1
X$1343 VDD synth_11920 synth_12015 synth_11957 synth_11954 VDD VNB|VSS VNB|VSS
+ sky130_fd_sc_hd__mux2i_1
X$1344 VDD synth_5484 synth_5582 synth_5605 synth_5634 VDD VNB|VSS VNB|VSS
+ sky130_fd_sc_hd__mux2i_1
X$1345 VDD synth_6206 synth_6277 synth_6300 synth_6299 VDD VNB|VSS VNB|VSS
+ sky130_fd_sc_hd__mux2i_1
X$1346 VDD synth_2721 synth_2836 synth_2694 synth_2790 VDD VNB|VSS VNB|VSS
+ sky130_fd_sc_hd__mux2i_1
X$1347 VDD synth_5664 synth_5778 synth_5780 synth_5704 VDD VNB|VSS VNB|VSS
+ sky130_fd_sc_hd__mux2i_1
X$1348 VDD synth_9684 synth_9750 synth_9752 synth_9683 VDD VNB|VSS VNB|VSS
+ sky130_fd_sc_hd__mux2i_1
X$1349 VDD synth_2333 synth_2393 synth_2307 synth_2266 VDD VNB|VSS VNB|VSS
+ sky130_fd_sc_hd__mux2i_1
X$1350 VDD synth_11525 synth_11621 synth_11367 synth_11622 VDD VNB|VSS VNB|VSS
+ sky130_fd_sc_hd__mux2i_1
X$1351 VDD synth_8300 synth_8741 synth_8552 synth_8630 VDD VNB|VSS VNB|VSS
+ sky130_fd_sc_hd__mux2i_1
X$1352 VDD synth_12208 synth_11628 synth_9062 synth_12055 VDD VNB|VSS VNB|VSS
+ sky130_fd_sc_hd__mux2i_1
X$1353 VDD synth_12463 synth_12651 synth_12524 synth_12523 VDD VNB|VSS VNB|VSS
+ sky130_fd_sc_hd__mux2i_1
X$1354 VDD synth_8532 synth_8725 synth_8727 synth_8658 VDD VNB|VSS VNB|VSS
+ sky130_fd_sc_hd__mux2i_1
X$1355 VDD synth_10342 synth_10343 synth_10228 synth_10208 VDD VNB|VSS VNB|VSS
+ sky130_fd_sc_hd__mux2i_1
X$1356 VDD synth_9970 synth_9971 synth_9920 synth_9972 VDD VNB|VSS VNB|VSS
+ sky130_fd_sc_hd__mux2i_1
X$1357 VDD synth_7476 synth_7515 synth_7561 synth_7641 VDD VNB|VSS VNB|VSS
+ sky130_fd_sc_hd__mux2i_1
X$1358 VDD synth_1324 synth_1617 synth_1488 synth_1562 VDD VNB|VSS VNB|VSS
+ sky130_fd_sc_hd__mux2i_1
X$1359 VDD synth_3447 synth_3607 synth_3466 synth_3686 VDD VNB|VSS VNB|VSS
+ sky130_fd_sc_hd__mux2i_1
X$1360 VDD synth_8827 synth_8994 synth_8933 synth_9029 VDD VNB|VSS VNB|VSS
+ sky130_fd_sc_hd__mux2i_1
X$1361 VDD synth_6149 synth_6286 synth_5983 synth_6209 VDD VNB|VSS VNB|VSS
+ sky130_fd_sc_hd__mux2i_1
X$1362 VNB|VSS synth_9407 synth_9165 synth_9304 synth_9265 synth_9302
+ synth_7089 VDD VDD VNB|VSS sky130_fd_sc_hd__o311a_1
X$1363 VNB|VSS synth_5459 synth_5205 synth_5427 synth_4977 synth_4747
+ synth_5428 VDD VDD VNB|VSS sky130_fd_sc_hd__o311a_1
X$1364 VNB|VSS synth_11112 synth_10992 synth_10882 synth_10990 synth_11031
+ synth_8746 VDD VDD VNB|VSS sky130_fd_sc_hd__o311a_1
X$1365 VNB|VSS synth_2571 synth_2570 synth_2532 synth_2448 synth_2509
+ synth_1338 VDD VDD VNB|VSS sky130_fd_sc_hd__o311a_1
X$1366 VNB|VSS synth_7166 synth_7194 synth_7193 synth_7002 synth_7081
+ synth_6597 VDD VDD VNB|VSS sky130_fd_sc_hd__o311a_1
X$1367 VNB|VSS synth_5705 synth_5865 synth_5779 synth_5593 synth_5406
+ synth_3544 VDD VDD VNB|VSS sky130_fd_sc_hd__o311a_1
X$1368 VNB|VSS synth_4635 synth_4075 synth_4242 synth_4439 synth_4589
+ synth_3632 VDD VDD VNB|VSS sky130_fd_sc_hd__o311a_1
X$1369 VNB|VSS synth_8912 synth_8793 synth_8936 synth_8858 synth_8860
+ synth_7183 VDD VDD VNB|VSS sky130_fd_sc_hd__o311a_1
X$1370 VNB|VSS synth_4309 synth_4533 synth_4222 synth_4370 synth_1353
+ synth_4288 VDD VDD VNB|VSS sky130_fd_sc_hd__o311a_1
X$1371 VNB|VSS synth_8620 synth_8699 synth_8775 synth_8579 synth_8746
+ synth_8621 VDD VDD VNB|VSS sky130_fd_sc_hd__o311a_1
X$1372 VNB|VSS synth_7599 synth_7276 synth_7383 synth_7140 synth_7089
+ synth_7562 VDD VDD VNB|VSS sky130_fd_sc_hd__o311a_1
X$1373 VNB|VSS synth_4960 synth_4909 synth_4878 synth_4872 synth_4829
+ synth_3544 VDD VDD VNB|VSS sky130_fd_sc_hd__o311a_1
X$1374 VNB|VSS synth_8040 synth_7990 synth_7913 synth_7912 synth_7915
+ synth_7089 VDD VDD VNB|VSS sky130_fd_sc_hd__o311a_1
X$1375 VNB|VSS synth_2744 synth_2441 synth_2671 synth_2551 synth_167 synth_2664
+ VDD VDD VNB|VSS sky130_fd_sc_hd__o311a_1
X$1376 VNB|VSS synth_1680 synth_1583 synth_1582 synth_1427 synth_1504
+ synth_1067 VDD VDD VNB|VSS sky130_fd_sc_hd__o311a_1
X$1377 VNB|VSS synth_11956 synth_11887 synth_12017 synth_11955 synth_11848
+ synth_9762 VDD VDD VNB|VSS sky130_fd_sc_hd__o311a_1
X$1378 VNB|VSS synth_2987 synth_2608 synth_2883 synth_2663 synth_167 synth_2806
+ VDD VDD VNB|VSS sky130_fd_sc_hd__o311a_1
X$1379 VNB|VSS synth_5106 synth_4788 synth_5011 synth_4789 synth_5010
+ synth_3632 VDD VDD VNB|VSS sky130_fd_sc_hd__o311a_1
X$1380 VNB|VSS synth_3531 synth_3382 synth_3352 synth_3383 synth_3464
+ synth_2116 VDD VDD VNB|VSS sky130_fd_sc_hd__o311a_1
X$1381 VNB|VSS synth_7300 synth_7484 synth_7485 synth_7548 synth_7400
+ synth_7183 VDD VDD VNB|VSS sky130_fd_sc_hd__o311a_1
X$1382 VNB|VSS synth_6956 synth_6989 synth_6914 synth_6885 synth_7089
+ synth_7011 VDD VDD VNB|VSS sky130_fd_sc_hd__o311a_1
X$1383 VNB|VSS synth_6202 synth_6154 synth_6120 synth_6200 synth_6153
+ synth_3632 VDD VDD VNB|VSS sky130_fd_sc_hd__o311a_1
X$1384 VNB|VSS synth_2556 synth_2519 synth_2544 synth_2343 synth_2429
+ synth_1353 VDD VDD VNB|VSS sky130_fd_sc_hd__o311a_1
X$1385 VNB|VSS synth_9792 synth_9753 synth_9793 synth_9751 synth_9712
+ synth_8746 VDD VDD VNB|VSS sky130_fd_sc_hd__o311a_1
X$1386 VNB|VSS synth_12149 synth_12093 synth_12104 synth_12031 synth_12213
+ synth_9423 VDD VDD VNB|VSS sky130_fd_sc_hd__o311a_1
X$1387 VNB|VSS synth_9493 synth_9496 synth_9410 synth_9494 synth_9272
+ synth_7089 VDD VDD VNB|VSS sky130_fd_sc_hd__o311a_1
X$1388 VNB|VSS synth_1252 synth_1250 synth_1177 synth_1251 synth_1067
+ synth_1254 VDD VDD VNB|VSS sky130_fd_sc_hd__o311a_1
X$1389 VNB|VSS synth_5272 synth_5024 synth_5169 synth_5188 synth_4961
+ synth_5170 VDD VDD VNB|VSS sky130_fd_sc_hd__o311a_1
X$1390 VNB|VSS synth_12650 synth_12449 synth_12591 synth_12592 synth_12466
+ synth_9423 VDD VDD VNB|VSS sky130_fd_sc_hd__o311a_1
X$1391 VNB|VSS synth_2859 synth_2908 synth_2858 synth_2830 synth_2718
+ synth_1067 VDD VDD VNB|VSS sky130_fd_sc_hd__o311a_1
X$1392 VNB|VSS synth_1433 synth_1507 synth_1351 synth_1268 synth_1434 synth_194
+ VDD VDD VNB|VSS sky130_fd_sc_hd__o311a_1
X$1393 VNB|VSS synth_5047 synth_4794 synth_4980 synth_4895 synth_4922
+ synth_3632 VDD VDD VNB|VSS sky130_fd_sc_hd__o311a_1
X$1394 VNB|VSS synth_2716 synth_2717 synth_2778 synth_2825 synth_1338
+ synth_2780 VDD VDD VNB|VSS sky130_fd_sc_hd__o311a_1
X$1395 VNB|VSS synth_8235 synth_7879 synth_8066 synth_8270 synth_8198
+ synth_7089 VDD VDD VNB|VSS sky130_fd_sc_hd__o311a_1
X$1396 VNB|VSS synth_10768 synth_10436 synth_10638 synth_10555 synth_10636
+ synth_9423 VDD VDD VNB|VSS sky130_fd_sc_hd__o311a_1
X$1397 VNB|VSS synth_852 synth_801 synth_662 synth_936 synth_659 synth_773 VDD
+ VDD VNB|VSS sky130_fd_sc_hd__o311a_1
X$1398 VNB|VSS synth_5581 synth_5289 synth_5526 synth_5373 synth_3541
+ synth_5552 VDD VDD VNB|VSS sky130_fd_sc_hd__o311a_1
X$1399 VNB|VSS synth_4000 synth_3765 synth_3826 synth_3738 synth_3828
+ synth_3468 VDD VDD VNB|VSS sky130_fd_sc_hd__o311a_1
X$1400 VNB|VSS synth_2917 synth_2791 synth_2647 synth_2835 synth_2722
+ synth_1067 VDD VDD VNB|VSS sky130_fd_sc_hd__o311a_1
X$1401 VNB|VSS synth_7389 synth_7723 synth_7612 synth_7692 synth_7392
+ synth_7183 VDD VDD VNB|VSS sky130_fd_sc_hd__o311a_1
X$1402 VNB|VSS synth_2654 synth_2341 synth_2315 synth_2540 synth_2586
+ synth_1353 VDD VDD VNB|VSS sky130_fd_sc_hd__o311a_1
X$1403 VNB|VSS synth_10050 synth_9997 synth_10087 synth_10086 synth_9918
+ synth_9762 VDD VDD VNB|VSS sky130_fd_sc_hd__o311a_1
X$1404 VNB|VSS synth_12164 synth_11661 synth_11987 synth_11773 synth_11921
+ synth_9762 VDD VDD VNB|VSS sky130_fd_sc_hd__o311a_1
X$1405 VNB|VSS synth_2463 synth_2464 synth_2260 synth_2496 synth_659 synth_2323
+ VDD VDD VNB|VSS sky130_fd_sc_hd__o311a_1
X$1406 VNB|VSS synth_10129 synth_10166 synth_10133 synth_10071 synth_9988
+ synth_10164 VDD VDD VNB|VSS sky130_fd_sc_hd__o311a_1
X$1407 VNB|VSS synth_6210 synth_6148 synth_6205 synth_5814 synth_5897
+ synth_3632 VDD VDD VNB|VSS sky130_fd_sc_hd__o311a_1
X$1408 VNB|VSS synth_10281 synth_9979 synth_10056 synth_10168 synth_10214
+ synth_9423 VDD VDD VNB|VSS sky130_fd_sc_hd__o311a_1
X$1409 VNB|VSS synth_4681 synth_4458 synth_4538 synth_4549 synth_4607
+ synth_4137 VDD VDD VNB|VSS sky130_fd_sc_hd__o311a_1
X$1410 VNB|VSS synth_11559 synth_11524 synth_11526 synth_11266 synth_11368
+ synth_10164 VDD VDD VNB|VSS sky130_fd_sc_hd__o311a_1
X$1411 VNB|VSS synth_11450 synth_11211 synth_11374 synth_11210 synth_11452
+ synth_9762 VDD VDD VNB|VSS sky130_fd_sc_hd__o311a_1
X$1412 VNB|VSS synth_12304 synth_10312 synth_9824 synth_10007 synth_12305
+ synth_10212 VDD VDD VNB|VSS sky130_fd_sc_hd__o311a_1
X$1413 VNB|VSS synth_7447 synth_7254 synth_7386 synth_7530 synth_7321
+ synth_7183 VDD VDD VNB|VSS sky130_fd_sc_hd__o311a_1
X$1414 VNB|VSS synth_4302 synth_4391 synth_4338 synth_4389 synth_4478
+ synth_3544 VDD VDD VNB|VSS sky130_fd_sc_hd__o311a_1
X$1415 VNB|VSS synth_3011 synth_2848 synth_2801 synth_2849 synth_2870
+ synth_2116 VDD VDD VNB|VSS sky130_fd_sc_hd__o311a_1
X$1416 VNB|VSS synth_3785 synth_3574 synth_3664 synth_3407 synth_3481 synth_167
+ VDD VDD VNB|VSS sky130_fd_sc_hd__o311a_1
X$1417 VNB|VSS synth_5972 synth_2152 synth_6134 synth_6133 synth_6222
+ synth_6223 VDD VDD VNB|VSS sky130_fd_sc_hd__o311a_1
X$1418 VNB|VSS synth_11897 synth_11805 synth_11854 synth_11899 synth_11856
+ synth_9762 VDD VDD VNB|VSS sky130_fd_sc_hd__o311a_1
X$1419 VNB|VSS synth_3209 synth_3079 synth_2961 synth_3045 synth_66 synth_2959
+ VDD VDD VNB|VSS sky130_fd_sc_hd__o311a_1
X$1420 VNB|VSS synth_7898 synth_7547 synth_7858 synth_7621 synth_7922
+ synth_7183 VDD VDD VNB|VSS sky130_fd_sc_hd__o311a_1
X$1421 VNB|VSS synth_2613 synth_2212 synth_2356 synth_2286 synth_2486 synth_66
+ VDD VDD VNB|VSS sky130_fd_sc_hd__o311a_1
X$1422 VNB|VSS synth_7604 synth_7281 synth_7563 synth_7385 synth_7320
+ synth_6597 VDD VDD VNB|VSS sky130_fd_sc_hd__o311a_1
X$1423 VNB|VSS synth_12521 synth_12226 synth_12391 synth_12584 synth_12583
+ synth_9423 VDD VDD VNB|VSS sky130_fd_sc_hd__o311a_1
X$1424 VNB|VSS synth_5807 synth_5559 synth_5545 synth_5646 synth_5665
+ synth_3544 VDD VDD VNB|VSS sky130_fd_sc_hd__o311a_1
X$1425 VNB|VSS synth_12065 synth_11916 synth_12033 synth_12066 synth_11947
+ synth_10164 VDD VDD VNB|VSS sky130_fd_sc_hd__o311a_1
X$1426 VNB|VSS synth_8125 synth_7987 synth_7988 synth_7847 synth_7989
+ synth_7089 VDD VDD VNB|VSS sky130_fd_sc_hd__o311a_1
X$1427 VNB|VSS synth_3075 synth_2944 synth_2862 synth_3148 synth_3030
+ synth_1067 VDD VDD VNB|VSS sky130_fd_sc_hd__o311a_1
X$1428 VNB|VSS synth_10193 synth_9911 synth_10120 synth_9747 synth_10064
+ synth_8746 VDD VDD VNB|VSS sky130_fd_sc_hd__o311a_1
X$1429 VNB|VSS synth_8613 synth_8445 synth_8520 synth_8441 synth_8471
+ synth_8000 VDD VDD VNB|VSS sky130_fd_sc_hd__o311a_1
X$1430 VNB|VSS synth_2511 synth_2474 synth_2472 synth_2334 synth_2265
+ synth_1067 VDD VDD VNB|VSS sky130_fd_sc_hd__o311a_1
X$1431 VNB|VSS synth_10272 synth_10083 synth_10304 synth_10303 synth_10143
+ synth_8000 VDD VDD VNB|VSS sky130_fd_sc_hd__o311a_1
X$1432 VNB|VSS synth_8850 synth_8430 synth_8706 synth_8514 synth_8682
+ synth_7183 VDD VDD VNB|VSS sky130_fd_sc_hd__o311a_1
X$1433 VNB|VSS synth_8932 synth_8853 synth_8996 synth_8995 synth_8830
+ synth_7089 VDD VDD VNB|VSS sky130_fd_sc_hd__o311a_1
X$1434 VNB|VSS synth_6664 synth_6365 synth_6337 synth_6367 synth_6640
+ synth_6597 VDD VDD VNB|VSS sky130_fd_sc_hd__o311a_1
X$1435 VDD synth_5504 synth_5420 synth_5421 synth_4811 VNB|VSS synth_5343 VDD
+ VNB|VSS sky130_fd_sc_hd__nor4_1
X$1436 VDD synth_7871 synth_7810 synth_7870 synth_7811 VNB|VSS synth_7872 VDD
+ VNB|VSS sky130_fd_sc_hd__nor4_1
X$1437 VDD synth_5286 synth_5779 synth_5865 synth_5593 VNB|VSS synth_5778 VDD
+ VNB|VSS sky130_fd_sc_hd__nor4_1
X$1438 VDD synth_1213 synth_2532 synth_2570 synth_2448 VNB|VSS synth_2559 VDD
+ VNB|VSS sky130_fd_sc_hd__nor4_1
X$1439 VDD synth_1478 synth_1450 synth_1310 synth_1449 VNB|VSS synth_1553 VDD
+ VNB|VSS sky130_fd_sc_hd__nor4_1
X$1440 VDD synth_6934 synth_6903 synth_6819 synth_6818 VNB|VSS synth_6817 VDD
+ VNB|VSS sky130_fd_sc_hd__nor4_1
X$1441 VDD synth_474 synth_1177 synth_1250 synth_1251 VNB|VSS synth_1256 VDD
+ VNB|VSS sky130_fd_sc_hd__nor4_1
X$1442 VDD synth_474 synth_662 synth_801 synth_936 VNB|VSS synth_1022 VDD
+ VNB|VSS sky130_fd_sc_hd__nor4_1
X$1443 VDD synth_10387 synth_10316 synth_10259 synth_10260 VNB|VSS synth_10388
+ VDD VNB|VSS sky130_fd_sc_hd__nor4_1
X$1444 VDD synth_5422 synth_5156 synth_5260 synth_5157 VNB|VSS synth_5342 VDD
+ VNB|VSS sky130_fd_sc_hd__nor4_1
X$1445 VDD synth_10731 synth_10682 synth_10044 synth_10611 VNB|VSS synth_10771
+ VDD VNB|VSS sky130_fd_sc_hd__nor4_1
X$1446 VDD synth_1789 synth_1866 synth_1813 synth_1815 VNB|VSS synth_2012 VDD
+ VNB|VSS sky130_fd_sc_hd__nor4_1
X$1447 VDD synth_9049 synth_12104 synth_12093 synth_12031 VNB|VSS synth_12278
+ VDD VNB|VSS sky130_fd_sc_hd__nor4_1
X$1448 VDD synth_6139 synth_6225 synth_6140 synth_5973 VNB|VSS synth_6222 VDD
+ VNB|VSS sky130_fd_sc_hd__nor4_1
X$1449 VDD synth_11010 synth_9117 synth_9474 synth_10376 VNB|VSS synth_10055
+ VDD VNB|VSS sky130_fd_sc_hd__nor4_1
X$1450 VDD synth_1213 synth_2472 synth_2474 synth_2334 VNB|VSS synth_2393 VDD
+ VNB|VSS sky130_fd_sc_hd__nor4_1
X$1451 VDD synth_9636 synth_9593 synth_9706 synth_9638 VNB|VSS synth_9646 VDD
+ VNB|VSS sky130_fd_sc_hd__nor4_1
X$1452 VDD synth_9049 synth_11854 synth_11805 synth_11899 VNB|VSS synth_11896
+ VDD VNB|VSS sky130_fd_sc_hd__nor4_1
X$1453 VDD synth_4275 synth_4356 synth_4245 synth_4276 VNB|VSS synth_4190 VDD
+ VNB|VSS sky130_fd_sc_hd__nor4_1
X$1454 VDD synth_3757 synth_4023 synth_4022 synth_4021 VNB|VSS synth_4094 VDD
+ VNB|VSS sky130_fd_sc_hd__nor4_1
X$1455 VDD synth_9297 synth_10882 synth_10992 synth_10990 VNB|VSS synth_11113
+ VDD VNB|VSS sky130_fd_sc_hd__nor4_1
X$1456 VDD synth_1081 synth_2315 synth_2341 synth_2540 VNB|VSS synth_2560 VDD
+ VNB|VSS sky130_fd_sc_hd__nor4_1
X$1457 VDD synth_7117 synth_7033 synth_6972 synth_7080 VNB|VSS synth_6820 VDD
+ VNB|VSS sky130_fd_sc_hd__nor4_1
X$1458 VDD synth_850 synth_5011 synth_4788 synth_4789 VNB|VSS synth_5009 VDD
+ VNB|VSS sky130_fd_sc_hd__nor4_1
X$1459 VDD synth_408 synth_2671 synth_2441 synth_2551 VNB|VSS synth_2745 VDD
+ VNB|VSS sky130_fd_sc_hd__nor4_1
X$1460 VDD synth_1995 synth_1705 synth_1704 synth_1610 VNB|VSS synth_2032 VDD
+ VNB|VSS sky130_fd_sc_hd__nor4_1
X$1461 VDD synth_9077 synth_9194 synth_9193 synth_9192 VNB|VSS synth_9344 VDD
+ VNB|VSS sky130_fd_sc_hd__nor4_1
X$1462 VDD synth_8093 synth_8274 synth_8256 synth_8180 VNB|VSS synth_8334 VDD
+ VNB|VSS sky130_fd_sc_hd__nor4_1
X$1463 VDD synth_5286 synth_5545 synth_5559 synth_5646 VNB|VSS synth_5707 VDD
+ VNB|VSS sky130_fd_sc_hd__nor4_1
X$1464 VDD synth_4116 synth_3841 synth_3774 synth_3707 VNB|VSS synth_4376 VDD
+ VNB|VSS sky130_fd_sc_hd__nor4_1
X$1465 VDD synth_7435 synth_7988 synth_7987 synth_7847 VNB|VSS synth_8203 VDD
+ VNB|VSS sky130_fd_sc_hd__nor4_1
X$1466 VDD synth_6476 synth_6914 synth_6989 synth_6885 VNB|VSS synth_6955 VDD
+ VNB|VSS sky130_fd_sc_hd__nor4_1
X$1467 VDD synth_10513 synth_10580 synth_8765 synth_10013 VNB|VSS synth_10583
+ VDD VNB|VSS sky130_fd_sc_hd__nor4_1
X$1468 VDD synth_8015 synth_8412 synth_8498 synth_8399 VNB|VSS synth_8497 VDD
+ VNB|VSS sky130_fd_sc_hd__nor4_1
X$1469 VDD synth_4292 synth_4201 synth_4203 synth_4212 VNB|VSS synth_4118 VDD
+ VNB|VSS sky130_fd_sc_hd__nor4_1
X$1470 VDD synth_581 synth_5427 synth_5205 synth_4977 VNB|VSS synth_5462 VDD
+ VNB|VSS sky130_fd_sc_hd__nor4_1
X$1471 VDD synth_1707 synth_1675 synth_1546 synth_1708 VNB|VSS synth_1999 VDD
+ VNB|VSS sky130_fd_sc_hd__nor4_1
X$1472 VDD synth_1642 synth_1278 synth_1220 synth_1517 VNB|VSS synth_1858 VDD
+ VNB|VSS sky130_fd_sc_hd__nor4_1
X$1473 VDD synth_408 synth_2883 synth_2608 synth_2663 VNB|VSS synth_2905 VDD
+ VNB|VSS sky130_fd_sc_hd__nor4_1
X$1474 VDD synth_11759 synth_11688 synth_11765 synth_11766 VNB|VSS synth_11340
+ VDD VNB|VSS sky130_fd_sc_hd__nor4_1
X$1475 VDD synth_4108 synth_4035 synth_4036 synth_4109 VNB|VSS synth_4234 VDD
+ VNB|VSS sky130_fd_sc_hd__nor4_1
X$1476 VDD synth_11301 synth_11300 synth_11371 synth_11299 VNB|VSS synth_11150
+ VDD VNB|VSS sky130_fd_sc_hd__nor4_1
X$1477 VDD synth_1213 synth_2647 synth_2791 synth_2835 VNB|VSS synth_2836 VDD
+ VNB|VSS sky130_fd_sc_hd__nor4_1
X$1478 VDD synth_9297 synth_11526 synth_11524 synth_11266 VNB|VSS synth_11621
+ VDD VNB|VSS sky130_fd_sc_hd__nor4_1
X$1479 VDD synth_10241 synth_10111 synth_10394 synth_10592 VNB|VSS synth_10113
+ VDD VNB|VSS sky130_fd_sc_hd__nor4_1
X$1480 VDD synth_8230 synth_8706 synth_8430 synth_8514 VNB|VSS synth_8705 VDD
+ VNB|VSS sky130_fd_sc_hd__nor4_1
X$1481 VDD synth_9691 synth_12017 synth_11887 synth_11955 VNB|VSS synth_12015
+ VDD VNB|VSS sky130_fd_sc_hd__nor4_1
X$1482 VDD synth_9545 synth_9963 synth_9062 synth_10140 VNB|VSS synth_10044 VDD
+ VNB|VSS sky130_fd_sc_hd__nor4_1
X$1483 VDD synth_9297 synth_9304 synth_9165 synth_9265 VNB|VSS synth_9301 VDD
+ VNB|VSS sky130_fd_sc_hd__nor4_1
X$1484 VDD synth_1213 synth_2862 synth_2944 synth_3148 VNB|VSS synth_3146 VDD
+ VNB|VSS sky130_fd_sc_hd__nor4_1
X$1485 VDD synth_11303 synth_11350 synth_11235 synth_11372 VNB|VSS synth_11151
+ VDD VNB|VSS sky130_fd_sc_hd__nor4_1
X$1486 VDD synth_8094 synth_8017 synth_8098 synth_8095 VNB|VSS synth_8184 VDD
+ VNB|VSS sky130_fd_sc_hd__nor4_1
X$1487 VDD synth_408 synth_3664 synth_3574 synth_3407 VNB|VSS synth_3575 VDD
+ VNB|VSS sky130_fd_sc_hd__nor4_1
X$1488 VDD synth_2089 synth_4184 synth_4185 synth_4164 VNB|VSS synth_4711 VDD
+ VNB|VSS sky130_fd_sc_hd__nor4_1
X$1489 VDD synth_1213 synth_1582 synth_1583 synth_1427 VNB|VSS synth_1426 VDD
+ VNB|VSS sky130_fd_sc_hd__nor4_1
X$1490 VDD synth_7435 synth_7612 synth_7723 synth_7692 VNB|VSS synth_7366 VDD
+ VNB|VSS sky130_fd_sc_hd__nor4_1
X$1491 VDD synth_9297 synth_9410 synth_9496 synth_9494 VNB|VSS synth_9655 VDD
+ VNB|VSS sky130_fd_sc_hd__nor4_1
X$1492 VDD synth_11372 synth_11235 synth_11237 synth_11350 VNB|VSS synth_11075
+ VDD VNB|VSS sky130_fd_sc_hd__nor4_1
X$1493 VDD synth_5286 synth_5526 synth_5289 synth_5373 VNB|VSS synth_5582 VDD
+ VNB|VSS sky130_fd_sc_hd__nor4_1
X$1494 VDD synth_5286 synth_7193 synth_7194 synth_7002 VNB|VSS synth_7233 VDD
+ VNB|VSS sky130_fd_sc_hd__nor4_1
X$1495 VDD synth_9691 synth_11987 synth_11661 synth_11773 VNB|VSS synth_12019
+ VDD VNB|VSS sky130_fd_sc_hd__nor4_1
X$1496 VDD synth_6211 synth_6205 synth_6148 synth_5814 VNB|VSS synth_6286 VDD
+ VNB|VSS sky130_fd_sc_hd__nor4_1
X$1497 VDD synth_5469 synth_5564 synth_5528 synth_5645 VNB|VSS synth_5263 VDD
+ VNB|VSS sky130_fd_sc_hd__nor4_1
X$1498 VDD synth_9297 synth_9793 synth_9753 synth_9751 VNB|VSS synth_9750 VDD
+ VNB|VSS sky130_fd_sc_hd__nor4_1
X$1499 VDD synth_8230 synth_8936 synth_8793 synth_8858 VNB|VSS synth_9000 VDD
+ VNB|VSS sky130_fd_sc_hd__nor4_1
X$1500 VDD synth_850 synth_4980 synth_4794 synth_4895 VNB|VSS synth_4923 VDD
+ VNB|VSS sky130_fd_sc_hd__nor4_1
X$1501 VDD synth_3890 synth_4084 synth_4173 synth_4081 VNB|VSS synth_4080 VDD
+ VNB|VSS sky130_fd_sc_hd__nor4_1
X$1502 VDD synth_8407 synth_8338 synth_8335 synth_8406 VNB|VSS synth_8260 VDD
+ VNB|VSS sky130_fd_sc_hd__nor4_1
X$1503 VDD synth_9691 synth_10304 synth_10083 synth_10303 VNB|VSS synth_10343
+ VDD VNB|VSS sky130_fd_sc_hd__nor4_1
X$1504 VDD synth_581 synth_5169 synth_5024 synth_5188 VNB|VSS synth_5369 VDD
+ VNB|VSS sky130_fd_sc_hd__nor4_1
X$1505 VDD synth_11104 synth_11030 synth_11105 synth_10874 VNB|VSS synth_11335
+ VDD VNB|VSS sky130_fd_sc_hd__nor4_1
X$1506 VDD synth_9297 synth_10120 synth_9911 synth_9747 VNB|VSS synth_10245 VDD
+ VNB|VSS sky130_fd_sc_hd__nor4_1
X$1507 VDD synth_850 synth_4878 synth_4909 synth_4872 VNB|VSS synth_5039 VDD
+ VNB|VSS sky130_fd_sc_hd__nor4_1
X$1508 VDD synth_2051 synth_2048 synth_2120 synth_1965 VNB|VSS synth_2277 VDD
+ VNB|VSS sky130_fd_sc_hd__nor4_1
X$1509 VDD synth_1081 synth_3352 synth_3382 synth_3383 VNB|VSS synth_3607 VDD
+ VNB|VSS sky130_fd_sc_hd__nor4_1
X$1510 VDD synth_6109 synth_6065 synth_5945 synth_5944 VNB|VSS synth_6223 VDD
+ VNB|VSS sky130_fd_sc_hd__nor4_1
X$1511 VDD synth_850 synth_2778 synth_2717 synth_2825 VNB|VSS synth_2680 VDD
+ VNB|VSS sky130_fd_sc_hd__nor4_1
X$1512 VDD synth_1081 synth_2801 synth_2848 synth_2849 VNB|VSS synth_3152 VDD
+ VNB|VSS sky130_fd_sc_hd__nor4_1
X$1513 VDD synth_1311 synth_1296 synth_1374 synth_1310 VNB|VSS synth_1451 VDD
+ VNB|VSS sky130_fd_sc_hd__nor4_1
X$1514 VDD synth_1081 synth_2961 synth_3079 synth_3045 VNB|VSS synth_3121 VDD
+ VNB|VSS sky130_fd_sc_hd__nor4_1
X$1515 VDD synth_9049 synth_12391 synth_12226 synth_12584 VNB|VSS synth_12495
+ VDD VNB|VSS sky130_fd_sc_hd__nor4_1
X$1516 VDD synth_7267 synth_7265 synth_7240 synth_7266 VNB|VSS synth_6751 VDD
+ VNB|VSS sky130_fd_sc_hd__nor4_1
X$1517 VDD synth_11024 synth_11023 synth_11251 synth_11025 VNB|VSS synth_11192
+ VDD VNB|VSS sky130_fd_sc_hd__nor4_1
X$1518 VDD synth_3964 synth_3826 synth_3765 synth_3738 VNB|VSS synth_3965 VDD
+ VNB|VSS sky130_fd_sc_hd__nor4_1
X$1519 VDD synth_1213 synth_2858 synth_2908 synth_2830 VNB|VSS synth_2910 VDD
+ VNB|VSS sky130_fd_sc_hd__nor4_1
X$1520 VDD synth_3745 synth_3636 synth_3639 synth_3614 VNB|VSS synth_3876 VDD
+ VNB|VSS sky130_fd_sc_hd__nor4_1
X$1521 VDD synth_11120 synth_11301 synth_11299 synth_10930 VNB|VSS synth_11347
+ VDD VNB|VSS sky130_fd_sc_hd__nor4_1
X$1522 VDD synth_850 synth_2260 synth_2464 synth_2496 VNB|VSS synth_2414 VDD
+ VNB|VSS sky130_fd_sc_hd__nor4_1
X$1523 VDD synth_7435 synth_7913 synth_7990 synth_7912 VNB|VSS synth_8277 VDD
+ VNB|VSS sky130_fd_sc_hd__nor4_1
X$1524 VDD synth_7435 synth_7858 synth_7547 synth_7621 VNB|VSS synth_7857 VDD
+ VNB|VSS sky130_fd_sc_hd__nor4_1
X$1525 VDD synth_2311 synth_4702 synth_4652 synth_4231 VNB|VSS synth_4968 VDD
+ VNB|VSS sky130_fd_sc_hd__nor4_1
X$1526 VDD synth_2114 synth_2337 synth_2166 synth_2336 VNB|VSS synth_2536 VDD
+ VNB|VSS sky130_fd_sc_hd__nor4_1
X$1527 VDD synth_7435 synth_7563 synth_7281 synth_7385 VNB|VSS synth_7523 VDD
+ VNB|VSS sky130_fd_sc_hd__nor4_1
X$1528 VDD synth_1798 synth_1635 synth_1622 synth_1687 VNB|VSS synth_1925 VDD
+ VNB|VSS sky130_fd_sc_hd__nor4_1
X$1529 VDD synth_1735 synth_2005 synth_1968 synth_1737 VNB|VSS synth_2055 VDD
+ VNB|VSS sky130_fd_sc_hd__nor4_1
X$1530 VDD synth_11823 synth_11878 synth_11877 synth_11942 VNB|VSS synth_11334
+ VDD VNB|VSS sky130_fd_sc_hd__nor4_1
X$1531 VDD synth_4354 synth_4655 synth_4592 synth_4591 VNB|VSS synth_4093 VDD
+ VNB|VSS sky130_fd_sc_hd__nor4_1
X$1532 VDD synth_7435 synth_7383 synth_7276 synth_7140 VNB|VSS synth_7515 VDD
+ VNB|VSS sky130_fd_sc_hd__nor4_1
X$1533 VDD synth_4330 synth_4276 synth_4356 synth_4275 VNB|VSS synth_4331 VDD
+ VNB|VSS sky130_fd_sc_hd__nor4_1
X$1534 VDD synth_3748 synth_4011 synth_3955 synth_3787 VNB|VSS synth_3889 VDD
+ VNB|VSS sky130_fd_sc_hd__nor4_1
X$1535 VDD synth_7435 synth_8520 synth_8445 synth_8441 VNB|VSS synth_8741 VDD
+ VNB|VSS sky130_fd_sc_hd__nor4_1
X$1536 VDD synth_9049 synth_10638 synth_10436 synth_10555 VNB|VSS synth_10694
+ VDD VNB|VSS sky130_fd_sc_hd__nor4_1
X$1537 VDD synth_8230 synth_8775 synth_8699 synth_8579 VNB|VSS synth_8725 VDD
+ VNB|VSS sky130_fd_sc_hd__nor4_1
X$1538 VDD synth_3854 synth_4398 synth_4290 synth_4041 VNB|VSS synth_4291 VDD
+ VNB|VSS sky130_fd_sc_hd__nor4_1
X$1539 VDD synth_4394 synth_4377 synth_3854 synth_4041 VNB|VSS VDD synth_4396
+ VNB|VSS sky130_fd_sc_hd__o211a_1
X$1540 VDD synth_7435 synth_7386 synth_7254 synth_7530 VNB|VSS synth_7479 VDD
+ VNB|VSS sky130_fd_sc_hd__nor4_1
X$1541 VDD synth_4456 synth_4538 synth_4458 synth_4457 VNB|VSS synth_4305 VDD
+ VNB|VSS sky130_fd_sc_hd__nor4_1
X$1542 VDD synth_11667 synth_11666 synth_11664 synth_11665 VNB|VSS synth_11453
+ VDD VNB|VSS sky130_fd_sc_hd__nor4_1
X$1543 VDD synth_346 synth_1351 synth_1507 synth_1268 VNB|VSS synth_1617 VDD
+ VNB|VSS sky130_fd_sc_hd__nor4_1
X$1544 VDD synth_11249 synth_9774 synth_10652 synth_11169 VNB|VSS synth_11434
+ VDD VNB|VSS sky130_fd_sc_hd__nor4_1
X$1545 VDD synth_9691 synth_10087 synth_9997 synth_10086 VNB|VSS synth_9971 VDD
+ VNB|VSS sky130_fd_sc_hd__nor4_1
X$1546 VDD synth_6434 synth_6577 synth_6540 synth_6403 VNB|VSS synth_6487 VDD
+ VNB|VSS sky130_fd_sc_hd__nor4_1
X$1547 VDD synth_6433 synth_6538 synth_6432 synth_6431 VNB|VSS synth_6356 VDD
+ VNB|VSS sky130_fd_sc_hd__nor4_1
X$1548 VDD synth_11580 synth_11647 synth_9062 synth_11645 VNB|VSS synth_12095
+ VDD VNB|VSS sky130_fd_sc_hd__nor4_1
X$1549 VDD synth_9297 synth_12033 synth_11916 synth_12066 VNB|VSS synth_11981
+ VDD VNB|VSS sky130_fd_sc_hd__nor4_1
X$1550 VDD synth_9184 synth_9439 synth_9448 synth_9254 VNB|VSS synth_9260 VDD
+ VNB|VSS sky130_fd_sc_hd__nor4_1
X$1551 VDD synth_9297 synth_10133 synth_10166 synth_10071 VNB|VSS synth_10167
+ VDD VNB|VSS sky130_fd_sc_hd__nor4_1
X$1552 VDD synth_474 synth_6120 synth_6154 synth_6200 VNB|VSS synth_6277 VDD
+ VNB|VSS sky130_fd_sc_hd__nor4_1
X$1553 VDD synth_8230 synth_8996 synth_8853 synth_8995 VNB|VSS synth_8994 VDD
+ VNB|VSS sky130_fd_sc_hd__nor4_1
X$1554 VDD synth_8495 synth_8714 synth_8494 synth_8563 VNB|VSS synth_8961 VDD
+ VNB|VSS sky130_fd_sc_hd__nor4_1
X$1555 VDD synth_3890 synth_3500 synth_3719 synth_3888 VNB|VSS synth_4061 VDD
+ VNB|VSS sky130_fd_sc_hd__nor4_1
X$1556 VDD synth_8164 synth_8239 synth_7974 synth_8053 VNB|VSS synth_8463 VDD
+ VNB|VSS sky130_fd_sc_hd__nor4_1
X$1557 VDD synth_10612 synth_8805 synth_9062 synth_9119 VNB|VSS synth_10611 VDD
+ VNB|VSS sky130_fd_sc_hd__nor4_1
X$1558 VDD synth_4781 synth_4830 synth_2385 synth_2534 VNB|VSS synth_4724 VDD
+ VNB|VSS sky130_fd_sc_hd__nor4_1
X$1559 VDD synth_2113 synth_2167 synth_2335 synth_2309 VNB|VSS synth_2241 VDD
+ VNB|VSS sky130_fd_sc_hd__nor4_1
X$1560 VDD synth_10026 synth_10118 synth_10244 synth_9950 VNB|VSS synth_10115
+ VDD VNB|VSS sky130_fd_sc_hd__nor4_1
X$1561 VDD synth_408 synth_2356 synth_2212 synth_2286 VNB|VSS synth_2506 VDD
+ VNB|VSS sky130_fd_sc_hd__nor4_1
X$1562 VDD synth_9049 synth_12591 synth_12449 synth_12592 VNB|VSS synth_12651
+ VDD VNB|VSS sky130_fd_sc_hd__nor4_1
X$1563 VDD synth_8230 synth_8066 synth_7879 synth_8270 VNB|VSS synth_8308 VDD
+ VNB|VSS sky130_fd_sc_hd__nor4_1
X$1564 VDD synth_1081 synth_2544 synth_2519 synth_2343 VNB|VSS synth_2701 VDD
+ VNB|VSS sky130_fd_sc_hd__nor4_1
X$1565 VDD synth_9691 synth_11374 synth_11211 synth_11210 VNB|VSS synth_11501
+ VDD VNB|VSS sky130_fd_sc_hd__nor4_1
X$1566 VDD synth_6476 synth_6337 synth_6365 synth_6367 VNB|VSS synth_6777 VDD
+ VNB|VSS sky130_fd_sc_hd__nor4_1
X$1567 VDD synth_1871 synth_1870 synth_1761 synth_1942 VNB|VSS synth_1990 VDD
+ VNB|VSS sky130_fd_sc_hd__nor4_1
X$1568 VDD synth_1195 synth_1194 synth_1212 synth_1292 VNB|VSS synth_1196 VDD
+ VNB|VSS sky130_fd_sc_hd__nor4_1
X$1569 VDD synth_9049 synth_10056 synth_9979 synth_10168 VNB|VSS synth_10283
+ VDD VNB|VSS sky130_fd_sc_hd__nor4_1
X$1570 VDD synth_850 synth_4338 synth_4391 synth_4389 VNB|VSS synth_4255 VDD
+ VNB|VSS sky130_fd_sc_hd__nor4_1
X$1571 VDD synth_5286 synth_7485 synth_7484 synth_7548 VNB|VSS synth_7465 VDD
+ VNB|VSS sky130_fd_sc_hd__nor4_1
X$1572 VDD synth_4674 synth_4675 synth_4397 synth_4742 VNB|VSS synth_4993 VDD
+ VNB|VSS sky130_fd_sc_hd__nor4_1
X$1573 VNB|VSS synth_11878 synth_11549 VNB|VSS VDD VDD VNB|VSS
+ sky130_fd_sc_hd__dfxtp_1
X$1574 VNB|VSS synth_8494 synth_8103 VNB|VSS VDD VDD VNB|VSS
+ sky130_fd_sc_hd__dfxtp_1
X$1575 VNB|VSS synth_10118 synth_10025 VNB|VSS VDD VDD VNB|VSS
+ sky130_fd_sc_hd__dfxtp_1
X$1576 VNB|VSS synth_11759 synth_11549 VNB|VSS VDD VDD VNB|VSS
+ sky130_fd_sc_hd__dfxtp_1
X$1577 VNB|VSS synth_11766 synth_11549 VNB|VSS VDD VDD VNB|VSS
+ sky130_fd_sc_hd__dfxtp_1
X$1578 VNB|VSS synth_9950 synth_10025 VNB|VSS VDD VDD VNB|VSS
+ sky130_fd_sc_hd__dfxtp_1
X$1579 VNB|VSS synth_8495 synth_8103 VNB|VSS VDD VDD VNB|VSS
+ sky130_fd_sc_hd__dfxtp_1
X$1580 VNB|VSS synth_9192 synth_9256 VNB|VSS VDD VDD VNB|VSS
+ sky130_fd_sc_hd__dfxtp_1
X$1581 VNB|VSS synth_9077 synth_8650 VNB|VSS VDD VDD VNB|VSS
+ sky130_fd_sc_hd__dfxtp_1
X$1582 VNB|VSS synth_7871 synth_7809 VNB|VSS VDD VDD VNB|VSS
+ sky130_fd_sc_hd__dfxtp_1
X$1583 VNB|VSS synth_11765 synth_11549 VNB|VSS VDD VDD VNB|VSS
+ sky130_fd_sc_hd__dfxtp_1
X$1584 VNB|VSS synth_10026 synth_10025 VNB|VSS VDD VDD VNB|VSS
+ sky130_fd_sc_hd__dfxtp_1
X$1585 VNB|VSS synth_11942 synth_11549 VNB|VSS VDD VDD VNB|VSS
+ sky130_fd_sc_hd__dfxtp_1
X$1586 VNB|VSS synth_7811 synth_7809 VNB|VSS VDD VDD VNB|VSS
+ sky130_fd_sc_hd__dfxtp_1
X$1587 VNB|VSS synth_7810 synth_7809 VNB|VSS VDD VDD VNB|VSS
+ sky130_fd_sc_hd__dfxtp_1
X$1588 VNB|VSS synth_8563 synth_8103 VNB|VSS VDD VDD VNB|VSS
+ sky130_fd_sc_hd__dfxtp_1
X$1589 VNB|VSS synth_9193 synth_8650 VNB|VSS VDD VDD VNB|VSS
+ sky130_fd_sc_hd__dfxtp_1
X$1590 VNB|VSS synth_11823 synth_11549 VNB|VSS VDD VDD VNB|VSS
+ sky130_fd_sc_hd__dfxtp_1
X$1591 VNB|VSS synth_3367 synth_3263 synth_3495 VDD VDD VNB|VSS
+ sky130_fd_sc_hd__dfxtp_1
X$1592 VNB|VSS synth_10461 synth_10806 synth_10805 VDD VDD VNB|VSS
+ sky130_fd_sc_hd__dfxtp_1
X$1593 VNB|VSS synth_8969 synth_8479 synth_8970 VDD VDD VNB|VSS
+ sky130_fd_sc_hd__dfxtp_1
X$1594 VNB|VSS synth_10387 synth_10802 synth_10810 VDD VDD VNB|VSS
+ sky130_fd_sc_hd__dfxtp_1
X$1595 VNB|VSS synth_3550 synth_3263 synth_3660 VDD VDD VNB|VSS
+ sky130_fd_sc_hd__dfxtp_1
X$1596 VNB|VSS synth_1311 synth_640 synth_1398 VDD VDD VNB|VSS
+ sky130_fd_sc_hd__dfxtp_1
X$1597 VDD synth_1311 synth_1294 synth_1449 synth_1310 synth_1450 VNB|VSS
+ synth_1314 VDD VNB|VSS sky130_fd_sc_hd__o41ai_1
X$1598 VNB|VSS synth_4592 synth_4575 synth_4730 VDD VDD VNB|VSS
+ sky130_fd_sc_hd__dfxtp_1
X$1599 VNB|VSS synth_2477 synth_2268 synth_2771 VDD VDD VNB|VSS
+ sky130_fd_sc_hd__dfxtp_1
X$1600 VNB|VSS synth_9252 synth_9127 synth_9267 VDD VDD VNB|VSS
+ sky130_fd_sc_hd__dfxtp_1
X$1601 VNB|VSS synth_6633 synth_6853 synth_7072 VDD VDD VNB|VSS
+ sky130_fd_sc_hd__dfxtp_1
X$1602 VNB|VSS synth_10259 synth_10021 synth_10240 VDD VDD VNB|VSS
+ sky130_fd_sc_hd__dfxtp_1
X$1603 VNB|VSS synth_11148 synth_10030 synth_11146 VDD VDD VNB|VSS
+ sky130_fd_sc_hd__dfxtp_1
X$1604 VNB|VSS synth_5944 synth_5450 synth_6026 VDD VDD VNB|VSS
+ sky130_fd_sc_hd__dfxtp_1
X$1605 VNB|VSS synth_11665 synth_10910 synth_11859 VDD VDD VNB|VSS
+ sky130_fd_sc_hd__dfxtp_1
X$1606 VNB|VSS synth_11085 synth_10616 synth_10790 VDD VDD VNB|VSS
+ sky130_fd_sc_hd__dfxtp_1
X$1607 VNB|VSS synth_10889 synth_10106 synth_10968 VDD VDD VNB|VSS
+ sky130_fd_sc_hd__dfxtp_1
X$1608 VNB|VSS synth_6663 synth_6853 synth_7064 VDD VDD VNB|VSS
+ sky130_fd_sc_hd__dfxtp_1
X$1609 VNB|VSS synth_12183 synth_12315 synth_12253 VDD VDD VNB|VSS
+ sky130_fd_sc_hd__dfxtp_1
X$1610 VNB|VSS synth_4082 synth_3263 synth_4304 VDD VDD VNB|VSS
+ sky130_fd_sc_hd__dfxtp_1
X$1611 VNB|VSS synth_2120 synth_1810 synth_2317 VDD VDD VNB|VSS
+ sky130_fd_sc_hd__dfxtp_1
X$1612 VNB|VSS synth_4457 synth_4293 synth_4772 VDD VDD VNB|VSS
+ sky130_fd_sc_hd__dfxtp_1
X$1613 VNB|VSS synth_6577 synth_6734 synth_6735 VDD VDD VNB|VSS
+ sky130_fd_sc_hd__dfxtp_1
X$1614 VNB|VSS synth_1619 synth_51 synth_1585 VDD VDD VNB|VSS
+ sky130_fd_sc_hd__dfxtp_1
X$1615 VNB|VSS synth_8406 synth_8650 synth_8493 VDD VDD VNB|VSS
+ sky130_fd_sc_hd__dfxtp_1
X$1616 VNB|VSS synth_12113 synth_11939 synth_11967 VDD VDD VNB|VSS
+ sky130_fd_sc_hd__dfxtp_1
X$1617 VNB|VSS synth_1220 synth_568 synth_1223 VDD VDD VNB|VSS
+ sky130_fd_sc_hd__dfxtp_1
X$1618 VNB|VSS synth_11490 synth_10808 synth_10029 VDD VDD VNB|VSS
+ sky130_fd_sc_hd__dfxtp_1
X$1619 VNB|VSS synth_4023 synth_3462 synth_4191 VDD VDD VNB|VSS
+ sky130_fd_sc_hd__dfxtp_1
X$1620 VNB|VSS synth_8098 synth_6828 synth_8034 VDD VDD VNB|VSS
+ sky130_fd_sc_hd__dfxtp_1
X$1621 VNB|VSS synth_5796 synth_5658 synth_6019 VDD VDD VNB|VSS
+ sky130_fd_sc_hd__dfxtp_1
X$1622 VNB|VSS synth_12114 synth_11470 synth_12182 VDD VDD VNB|VSS
+ sky130_fd_sc_hd__dfxtp_1
X$1623 VNB|VSS synth_9143 synth_8413 synth_8971 VDD VDD VNB|VSS
+ sky130_fd_sc_hd__dfxtp_1
X$1624 VNB|VSS synth_10316 synth_10802 synth_10950 VDD VDD VNB|VSS
+ sky130_fd_sc_hd__dfxtp_1
X$1625 VNB|VSS synth_1866 synth_1810 synth_1865 VDD VDD VNB|VSS
+ sky130_fd_sc_hd__dfxtp_1
X$1626 VNB|VSS synth_9336 synth_9370 synth_9541 VDD VDD VNB|VSS
+ sky130_fd_sc_hd__dfxtp_1
X$1627 VNB|VSS synth_2335 synth_2533 synth_2573 VDD VDD VNB|VSS
+ sky130_fd_sc_hd__dfxtp_1
X$1628 VNB|VSS synth_4531 synth_7213 synth_7285 VDD VDD VNB|VSS
+ sky130_fd_sc_hd__dfxtp_1
X$1629 VNB|VSS synth_7790 synth_7115 synth_4996 VDD VDD VNB|VSS
+ sky130_fd_sc_hd__dfxtp_1
X$1630 VNB|VSS synth_11684 synth_11470 synth_11884 VDD VDD VNB|VSS
+ sky130_fd_sc_hd__dfxtp_1
X$1631 VNB|VSS synth_9373 synth_8595 synth_9466 VDD VDD VNB|VSS
+ sky130_fd_sc_hd__dfxtp_1
X$1632 VNB|VSS synth_11681 synth_11939 synth_11952 VDD VDD VNB|VSS
+ sky130_fd_sc_hd__dfxtp_1
X$1633 VNB|VSS synth_7080 synth_7115 synth_7202 VDD VDD VNB|VSS
+ sky130_fd_sc_hd__dfxtp_1
X$1634 VNB|VSS synth_12076 synth_11939 synth_12056 VDD VDD VNB|VSS
+ sky130_fd_sc_hd__dfxtp_1
X$1635 VNB|VSS synth_8437 synth_8315 synth_8525 VDD VDD VNB|VSS
+ sky130_fd_sc_hd__dfxtp_1
X$1636 VNB|VSS synth_11200 synth_11117 synth_11267 VDD VDD VNB|VSS
+ sky130_fd_sc_hd__dfxtp_1
X$1637 VNB|VSS synth_11664 synth_12024 synth_11992 VDD VDD VNB|VSS
+ sky130_fd_sc_hd__dfxtp_1
X$1638 VNB|VSS synth_7601 synth_7588 synth_8028 VDD VDD VNB|VSS
+ sky130_fd_sc_hd__dfxtp_1
X$1639 VNB|VSS synth_9521 synth_8778 synth_9604 VDD VDD VNB|VSS
+ sky130_fd_sc_hd__dfxtp_1
X$1640 VNB|VSS synth_8921 synth_8863 synth_9057 VDD VDD VNB|VSS
+ sky130_fd_sc_hd__dfxtp_1
X$1641 VNB|VSS synth_5966 synth_5658 synth_6316 VDD VDD VNB|VSS
+ sky130_fd_sc_hd__dfxtp_1
X$1642 VNB|VSS synth_9947 synth_10021 synth_10391 VDD VDD VNB|VSS
+ sky130_fd_sc_hd__dfxtp_1
X$1643 VNB|VSS synth_6433 synth_5658 synth_6591 VDD VDD VNB|VSS
+ sky130_fd_sc_hd__dfxtp_1
X$1644 VNB|VSS synth_11624 synth_11117 synth_11776 VDD VDD VNB|VSS
+ sky130_fd_sc_hd__dfxtp_1
X$1645 VNB|VSS synth_7117 synth_7115 synth_7304 VDD VDD VNB|VSS
+ sky130_fd_sc_hd__dfxtp_1
X$1646 VNB|VSS synth_5795 synth_5658 synth_5840 VDD VDD VNB|VSS
+ sky130_fd_sc_hd__dfxtp_1
X$1647 VNB|VSS synth_8714 synth_8650 synth_8772 VDD VDD VNB|VSS
+ sky130_fd_sc_hd__dfxtp_1
X$1648 VNB|VSS synth_7457 synth_7115 synth_5773 VDD VDD VNB|VSS
+ sky130_fd_sc_hd__dfxtp_1
X$1649 VNB|VSS synth_3639 synth_3462 synth_3559 VDD VDD VNB|VSS
+ sky130_fd_sc_hd__dfxtp_1
X$1650 VNB|VSS synth_12678 synth_12315 synth_12764 VDD VDD VNB|VSS
+ sky130_fd_sc_hd__dfxtp_1
X$1651 VNB|VSS synth_4212 synth_4293 synth_4204 VDD VDD VNB|VSS
+ sky130_fd_sc_hd__dfxtp_1
X$1652 VNB|VSS synth_6740 synth_6961 synth_7290 VDD VDD VNB|VSS
+ sky130_fd_sc_hd__dfxtp_1
X$1653 VNB|VSS synth_4458 synth_4293 synth_4945 VDD VDD VNB|VSS
+ sky130_fd_sc_hd__dfxtp_1
X$1654 VNB|VSS synth_11350 synth_11495 synth_11629 VDD VDD VNB|VSS
+ sky130_fd_sc_hd__dfxtp_1
X$1655 VNB|VSS synth_8047 synth_7115 synth_5951 VDD VDD VNB|VSS
+ sky130_fd_sc_hd__dfxtp_1
X$1656 VNB|VSS synth_11666 synth_12024 synth_11860 VDD VDD VNB|VSS
+ sky130_fd_sc_hd__dfxtp_1
X$1657 VNB|VSS synth_8570 synth_8650 synth_9135 VDD VDD VNB|VSS
+ sky130_fd_sc_hd__dfxtp_1
X$1658 VNB|VSS synth_12000 synth_11470 synth_12195 VDD VDD VNB|VSS
+ sky130_fd_sc_hd__dfxtp_1
X$1659 VNB|VSS synth_8877 synth_8595 synth_8905 VDD VDD VNB|VSS
+ sky130_fd_sc_hd__dfxtp_1
X$1660 VDD synth_8875 VDD VNB|VSS synth_7805 VNB|VSS sky130_fd_sc_hd__clkbuf_2
X$1661 VNB|VSS synth_1724 synth_1432 synth_1725 VDD VDD VNB|VSS
+ sky130_fd_sc_hd__dfxtp_1
X$1662 VNB|VSS synth_6793 synth_6853 synth_7184 VDD VDD VNB|VSS
+ sky130_fd_sc_hd__dfxtp_1
X$1663 VNB|VSS synth_4201 synth_4293 synth_4614 VDD VDD VNB|VSS
+ sky130_fd_sc_hd__dfxtp_1
X$1664 VNB|VSS synth_9522 synth_10269 synth_10583 VDD VDD VNB|VSS
+ sky130_fd_sc_hd__dfxtp_1
X$1665 VNB|VSS synth_12601 synth_12311 synth_12780 VDD VDD VNB|VSS
+ sky130_fd_sc_hd__dfxtp_1
X$1666 VNB|VSS synth_9198 synth_10269 synth_10239 VDD VDD VNB|VSS
+ sky130_fd_sc_hd__dfxtp_1
X$1667 VNB|VSS synth_12368 synth_12315 synth_12426 VDD VDD VNB|VSS
+ sky130_fd_sc_hd__dfxtp_1
X$1668 VNB|VSS synth_8548 synth_8315 synth_8443 VDD VDD VNB|VSS
+ sky130_fd_sc_hd__dfxtp_1
X$1669 VNB|VSS synth_8717 synth_8650 synth_8959 VDD VDD VNB|VSS
+ sky130_fd_sc_hd__dfxtp_1
X$1670 VNB|VSS synth_9188 synth_9256 synth_9346 VDD VDD VNB|VSS
+ sky130_fd_sc_hd__dfxtp_1
X$1671 VNB|VSS synth_3554 synth_2643 synth_3749 VDD VDD VNB|VSS
+ sky130_fd_sc_hd__dfxtp_1
X$1672 VNB|VSS synth_4021 synth_3820 synth_4187 VDD VDD VNB|VSS
+ sky130_fd_sc_hd__dfxtp_1
X$1673 VNB|VSS synth_1588 synth_1453 synth_2147 VDD VDD VNB|VSS
+ sky130_fd_sc_hd__dfxtp_1
X$1674 VNB|VSS synth_5632 synth_5658 synth_5601 VDD VDD VNB|VSS
+ sky130_fd_sc_hd__dfxtp_1
X$1675 VNB|VSS synth_8824 synth_8413 synth_8767 VDD VDD VNB|VSS
+ sky130_fd_sc_hd__dfxtp_1
X$1676 VNB|VSS synth_9187 synth_9256 synth_9259 VDD VDD VNB|VSS
+ sky130_fd_sc_hd__dfxtp_1
X$1677 VNB|VSS synth_11372 synth_11495 synth_11447 VDD VDD VNB|VSS
+ sky130_fd_sc_hd__dfxtp_1
X$1678 VNB|VSS synth_11191 synth_10030 synth_11410 VDD VDD VNB|VSS
+ sky130_fd_sc_hd__dfxtp_1
X$1679 VNB|VSS synth_8733 synth_8778 synth_8777 VDD VDD VNB|VSS
+ sky130_fd_sc_hd__dfxtp_1
X$1680 VNB|VSS synth_7870 synth_7809 synth_8027 VDD VDD VNB|VSS
+ sky130_fd_sc_hd__dfxtp_1
X$1681 VNB|VSS synth_6225 synth_5327 synth_6363 VDD VDD VNB|VSS
+ sky130_fd_sc_hd__dfxtp_1
X$1682 VNB|VSS synth_11025 synth_10808 synth_11102 VDD VDD VNB|VSS
+ sky130_fd_sc_hd__dfxtp_1
X$1683 VNB|VSS synth_8752 synth_8380 synth_8903 VDD VDD VNB|VSS
+ sky130_fd_sc_hd__dfxtp_1
X$1684 VNB|VSS synth_9031 synth_8778 synth_9099 VDD VDD VNB|VSS
+ sky130_fd_sc_hd__dfxtp_1
X$1685 VNB|VSS synth_3202 synth_1872 synth_3201 VDD VDD VNB|VSS
+ sky130_fd_sc_hd__dfxtp_1
X$1686 VNB|VSS synth_10852 synth_10226 synth_10928 VDD VDD VNB|VSS
+ sky130_fd_sc_hd__dfxtp_1
X$1687 VNB|VSS synth_1815 synth_1276 synth_1864 VDD VDD VNB|VSS
+ sky130_fd_sc_hd__dfxtp_1
X$1688 VNB|VSS synth_11056 synth_10910 synth_11055 VDD VDD VNB|VSS
+ sky130_fd_sc_hd__dfxtp_1
X$1689 VNB|VSS synth_10138 synth_9702 synth_10270 VDD VDD VNB|VSS
+ sky130_fd_sc_hd__dfxtp_1
X$1690 VNB|VSS synth_1946 synth_1795 synth_2186 VDD VDD VNB|VSS
+ sky130_fd_sc_hd__dfxtp_1
X$1691 VNB|VSS synth_11158 synth_10910 synth_11285 VDD VDD VNB|VSS
+ sky130_fd_sc_hd__dfxtp_1
X$1692 VNB|VSS synth_11344 synth_11117 synth_11419 VDD VDD VNB|VSS
+ sky130_fd_sc_hd__dfxtp_1
X$1693 VNB|VSS synth_3795 synth_3569 synth_4037 VDD VDD VNB|VSS
+ sky130_fd_sc_hd__dfxtp_1
X$1694 VNB|VSS synth_5973 synth_5327 synth_5890 VDD VDD VNB|VSS
+ sky130_fd_sc_hd__dfxtp_1
X$1695 VNB|VSS synth_8565 synth_8650 synth_9080 VDD VDD VNB|VSS
+ sky130_fd_sc_hd__dfxtp_1
X$1696 VNB|VSS synth_12602 synth_12311 synth_12777 VDD VDD VNB|VSS
+ sky130_fd_sc_hd__dfxtp_1
X$1697 VNB|VSS synth_12012 synth_11626 synth_11995 VDD VDD VNB|VSS
+ sky130_fd_sc_hd__dfxtp_1
X$1698 VNB|VSS synth_5157 synth_4505 synth_5017 VDD VDD VNB|VSS
+ sky130_fd_sc_hd__dfxtp_1
X$1699 VNB|VSS synth_11779 synth_11626 synth_11963 VDD VDD VNB|VSS
+ sky130_fd_sc_hd__dfxtp_1
X$1700 VNB|VSS synth_11686 synth_10808 synth_11685 VDD VDD VNB|VSS
+ sky130_fd_sc_hd__dfxtp_1
X$1701 VNB|VSS synth_12185 synth_11549 synth_12250 VDD VDD VNB|VSS
+ sky130_fd_sc_hd__dfxtp_1
X$1702 VNB|VSS synth_6139 synth_5327 synth_6110 VDD VDD VNB|VSS
+ sky130_fd_sc_hd__dfxtp_1
X$1703 VNB|VSS synth_3292 synth_3263 synth_3225 VDD VDD VNB|VSS
+ sky130_fd_sc_hd__dfxtp_1
X$1704 VNB|VSS synth_11505 synth_10910 synth_11713 VDD VDD VNB|VSS
+ sky130_fd_sc_hd__dfxtp_1
X$1705 VNB|VSS synth_3774 synth_3576 synth_3920 VDD VDD VNB|VSS
+ sky130_fd_sc_hd__dfxtp_1
X$1706 VNB|VSS synth_4035 synth_4505 synth_4366 VDD VDD VNB|VSS
+ sky130_fd_sc_hd__dfxtp_1
X$1707 VNB|VSS synth_4109 synth_3397 synth_4196 VDD VDD VNB|VSS
+ sky130_fd_sc_hd__dfxtp_1
X$1708 VNB|VSS synth_9269 synth_9127 synth_9450 VDD VDD VNB|VSS
+ sky130_fd_sc_hd__dfxtp_1
X$1709 VNB|VSS synth_9656 synth_9370 synth_9722 VDD VDD VNB|VSS
+ sky130_fd_sc_hd__dfxtp_1
X$1710 VNB|VSS synth_6109 synth_5450 synth_6025 VDD VDD VNB|VSS
+ sky130_fd_sc_hd__dfxtp_1
X$1711 VNB|VSS synth_8675 synth_8391 synth_8676 VDD VDD VNB|VSS
+ sky130_fd_sc_hd__dfxtp_1
X$1712 VNB|VSS synth_11310 synth_10616 synth_11311 VDD VDD VNB|VSS
+ sky130_fd_sc_hd__dfxtp_1
X$1713 VNB|VSS synth_10893 synth_10269 synth_10946 VDD VDD VNB|VSS
+ sky130_fd_sc_hd__dfxtp_1
X$1714 VNB|VSS synth_8849 synth_8863 synth_8988 VDD VDD VNB|VSS
+ sky130_fd_sc_hd__dfxtp_1
X$1715 VNB|VSS synth_10244 synth_10025 synth_10246 VDD VDD VNB|VSS
+ sky130_fd_sc_hd__dfxtp_1
X$1716 VNB|VSS synth_10896 synth_10269 synth_10973 VDD VDD VNB|VSS
+ sky130_fd_sc_hd__dfxtp_1
X$1717 VNB|VSS synth_8639 synth_8595 synth_8732 VDD VDD VNB|VSS
+ sky130_fd_sc_hd__dfxtp_1
X$1718 VNB|VSS synth_9097 synth_8778 synth_9149 VDD VDD VNB|VSS
+ sky130_fd_sc_hd__dfxtp_1
X$1719 VNB|VSS synth_6434 synth_6734 synth_6990 VDD VDD VNB|VSS
+ sky130_fd_sc_hd__dfxtp_1
X$1720 VNB|VSS synth_11371 synth_11527 synth_11735 VDD VDD VNB|VSS
+ sky130_fd_sc_hd__dfxtp_1
X$1721 VNB|VSS synth_5267 synth_5159 synth_5347 VDD VDD VNB|VSS
+ sky130_fd_sc_hd__dfxtp_1
X$1722 VNB|VSS synth_6065 synth_5450 synth_6107 VDD VDD VNB|VSS
+ sky130_fd_sc_hd__dfxtp_1
X$1723 VNB|VSS synth_1622 synth_1345 synth_1620 VDD VDD VNB|VSS
+ sky130_fd_sc_hd__dfxtp_1
X$1724 VNB|VSS synth_10607 synth_10106 synth_10769 VDD VDD VNB|VSS
+ sky130_fd_sc_hd__dfxtp_1
X$1725 VNB|VSS synth_8831 synth_8553 synth_8779 VDD VDD VNB|VSS
+ sky130_fd_sc_hd__dfxtp_1
X$1726 VNB|VSS synth_2309 synth_1717 synth_2572 VDD VDD VNB|VSS
+ sky130_fd_sc_hd__dfxtp_1
X$1727 VNB|VSS synth_9643 synth_9256 synth_9877 VDD VDD VNB|VSS
+ sky130_fd_sc_hd__dfxtp_1
X$1728 VNB|VSS synth_8604 synth_8391 synth_8684 VDD VDD VNB|VSS
+ sky130_fd_sc_hd__dfxtp_1
X$1729 VNB|VSS synth_9199 synth_8595 synth_9118 VDD VDD VNB|VSS
+ sky130_fd_sc_hd__dfxtp_1
X$1730 VNB|VSS synth_4538 synth_4293 synth_4944 VDD VDD VNB|VSS
+ sky130_fd_sc_hd__dfxtp_1
X$1731 VNB|VSS synth_10519 synth_10021 synth_10518 VDD VDD VNB|VSS
+ sky130_fd_sc_hd__dfxtp_1
X$1732 VNB|VSS synth_11328 synth_11117 synth_11270 VDD VDD VNB|VSS
+ sky130_fd_sc_hd__dfxtp_1
X$1733 VNB|VSS synth_4354 synth_4575 synth_4984 VDD VDD VNB|VSS
+ sky130_fd_sc_hd__dfxtp_1
X$1734 VNB|VSS synth_11036 synth_10802 synth_10673 VDD VDD VNB|VSS
+ sky130_fd_sc_hd__dfxtp_1
X$1735 VNB|VSS synth_6391 synth_6388 synth_6472 VDD VDD VNB|VSS
+ sky130_fd_sc_hd__dfxtp_1
X$1736 VNB|VSS synth_8731 synth_8778 synth_8979 VDD VDD VNB|VSS
+ sky130_fd_sc_hd__dfxtp_1
X$1737 VNB|VSS synth_5469 synth_5159 synth_5677 VDD VDD VNB|VSS
+ sky130_fd_sc_hd__dfxtp_1
X$1738 VNB|VSS synth_8410 synth_8103 synth_8496 VDD VDD VNB|VSS
+ sky130_fd_sc_hd__dfxtp_1
X$1739 VNB|VSS synth_11299 synth_11846 synth_11736 VDD VDD VNB|VSS
+ sky130_fd_sc_hd__dfxtp_1
X$1740 VNB|VSS synth_1707 synth_1795 synth_1706 VDD VDD VNB|VSS
+ sky130_fd_sc_hd__dfxtp_1
X$1741 VNB|VSS synth_9169 synth_9045 synth_9282 VDD VDD VNB|VSS
+ sky130_fd_sc_hd__dfxtp_1
X$1742 VNB|VSS synth_12258 synth_11939 synth_12008 VDD VDD VNB|VSS
+ sky130_fd_sc_hd__dfxtp_1
X$1743 VNB|VSS synth_6403 synth_6734 synth_6887 VDD VDD VNB|VSS
+ sky130_fd_sc_hd__dfxtp_1
X$1744 VNB|VSS synth_5422 synth_5478 synth_5673 VDD VDD VNB|VSS
+ sky130_fd_sc_hd__dfxtp_1
X$1745 VNB|VSS synth_12425 synth_12315 synth_12422 VDD VDD VNB|VSS
+ sky130_fd_sc_hd__dfxtp_1
X$1746 VNB|VSS synth_1871 synth_1833 synth_1868 VDD VDD VNB|VSS
+ sky130_fd_sc_hd__dfxtp_1
X$1747 VNB|VSS synth_9178 synth_8595 synth_9276 VDD VDD VNB|VSS
+ sky130_fd_sc_hd__dfxtp_1
X$1748 VNB|VSS synth_9413 synth_9045 synth_9729 VDD VDD VNB|VSS
+ sky130_fd_sc_hd__dfxtp_1
X$1749 VNB|VSS synth_9571 synth_9045 synth_9843 VDD VDD VNB|VSS
+ sky130_fd_sc_hd__dfxtp_1
X$1750 VNB|VSS synth_10111 synth_10025 synth_10027 VDD VDD VNB|VSS
+ sky130_fd_sc_hd__dfxtp_1
X$1751 VNB|VSS synth_12733 synth_12315 synth_12763 VDD VDD VNB|VSS
+ sky130_fd_sc_hd__dfxtp_1
X$1752 VNB|VSS synth_8914 synth_8553 synth_8474 VDD VDD VNB|VSS
+ sky130_fd_sc_hd__dfxtp_1
X$1753 VNB|VSS synth_10022 synth_10021 synth_10258 VDD VDD VNB|VSS
+ sky130_fd_sc_hd__dfxtp_1
X$1754 VNB|VSS synth_8770 synth_7808 synth_8771 VDD VDD VNB|VSS
+ sky130_fd_sc_hd__dfxtp_1
X$1755 VNB|VSS synth_12111 synth_12311 synth_12331 VDD VDD VNB|VSS
+ sky130_fd_sc_hd__dfxtp_1
X$1756 VNB|VSS synth_6686 synth_5159 synth_6639 VDD VDD VNB|VSS
+ sky130_fd_sc_hd__dfxtp_1
X$1757 VNB|VSS synth_5528 synth_5159 synth_5822 VDD VDD VNB|VSS
+ sky130_fd_sc_hd__dfxtp_1
X$1758 VNB|VSS synth_10819 synth_10226 synth_10817 VDD VDD VNB|VSS
+ sky130_fd_sc_hd__dfxtp_1
X$1759 VNB|VSS synth_11413 synth_11470 synth_11493 VDD VDD VNB|VSS
+ sky130_fd_sc_hd__dfxtp_1
X$1760 VNB|VSS synth_9183 synth_9127 synth_9716 VDD VDD VNB|VSS
+ sky130_fd_sc_hd__dfxtp_1
X$1761 VNB|VSS synth_4049 synth_3576 synth_4044 VDD VDD VNB|VSS
+ sky130_fd_sc_hd__dfxtp_1
X$1762 VNB|VSS synth_11030 synth_10806 synth_11107 VDD VDD VNB|VSS
+ sky130_fd_sc_hd__dfxtp_1
X$1763 VNB|VSS synth_12374 synth_12311 synth_12361 VDD VDD VNB|VSS
+ sky130_fd_sc_hd__dfxtp_1
X$1764 VNB|VSS synth_9727 synth_9702 synth_9631 VDD VDD VNB|VSS
+ sky130_fd_sc_hd__dfxtp_1
X$1765 VNB|VSS synth_9871 synth_10021 synth_10031 VDD VDD VNB|VSS
+ sky130_fd_sc_hd__dfxtp_1
X$1766 VNB|VSS synth_8633 synth_8553 synth_8685 VDD VDD VNB|VSS
+ sky130_fd_sc_hd__dfxtp_1
X$1767 VNB|VSS synth_4173 synth_4826 synth_4517 VDD VDD VNB|VSS
+ sky130_fd_sc_hd__dfxtp_1
X$1768 VNB|VSS synth_2167 synth_1717 synth_2112 VDD VDD VNB|VSS
+ sky130_fd_sc_hd__dfxtp_1
X$1769 VNB|VSS synth_9815 synth_9702 synth_9859 VDD VDD VNB|VSS
+ sky130_fd_sc_hd__dfxtp_1
X$1770 VNB|VSS synth_11023 synth_10802 synth_11114 VDD VDD VNB|VSS
+ sky130_fd_sc_hd__dfxtp_1
X$1771 VNB|VSS synth_3400 synth_3397 synth_3530 VDD VDD VNB|VSS
+ sky130_fd_sc_hd__dfxtp_1
X$1772 VNB|VSS synth_9782 synth_10106 synth_10134 VDD VDD VNB|VSS
+ sky130_fd_sc_hd__dfxtp_1
X$1773 VNB|VSS synth_7365 synth_7115 synth_7459 VDD VDD VNB|VSS
+ sky130_fd_sc_hd__dfxtp_1
X$1774 VNB|VSS synth_3955 synth_3263 synth_4170 VDD VDD VNB|VSS
+ sky130_fd_sc_hd__dfxtp_1
X$1775 VNB|VSS synth_7286 synth_7213 synth_7212 VDD VDD VNB|VSS
+ sky130_fd_sc_hd__dfxtp_1
X$1776 VNB|VSS synth_12362 synth_11626 synth_12547 VDD VDD VNB|VSS
+ sky130_fd_sc_hd__dfxtp_1
X$1777 VNB|VSS synth_1296 synth_1453 synth_1295 VDD VDD VNB|VSS
+ sky130_fd_sc_hd__dfxtp_1
X$1778 VNB|VSS synth_6874 synth_6815 synth_7159 VDD VDD VNB|VSS
+ sky130_fd_sc_hd__dfxtp_1
X$1779 VNB|VSS synth_1675 synth_1423 synth_1612 VDD VDD VNB|VSS
+ sky130_fd_sc_hd__dfxtp_1
X$1780 VNB|VSS synth_9497 synth_9270 synth_9720 VDD VDD VNB|VSS
+ sky130_fd_sc_hd__dfxtp_1
X$1781 VNB|VSS synth_5564 synth_5753 synth_6048 VDD VDD VNB|VSS
+ sky130_fd_sc_hd__dfxtp_1
X$1782 VNB|VSS synth_6393 synth_6388 synth_6387 VDD VDD VNB|VSS
+ sky130_fd_sc_hd__dfxtp_1
X$1783 VNB|VSS synth_8713 synth_8595 synth_8776 VDD VDD VNB|VSS
+ sky130_fd_sc_hd__dfxtp_1
X$1784 VNB|VSS synth_9713 synth_9127 synth_9879 VDD VDD VNB|VSS
+ sky130_fd_sc_hd__dfxtp_1
X$1785 VNB|VSS synth_9096 synth_8778 synth_9242 VDD VDD VNB|VSS
+ sky130_fd_sc_hd__dfxtp_1
X$1786 VNB|VSS synth_1517 synth_1276 synth_1571 VDD VDD VNB|VSS
+ sky130_fd_sc_hd__dfxtp_1
X$1787 VNB|VSS synth_6822 synth_6815 synth_6871 VDD VDD VNB|VSS
+ sky130_fd_sc_hd__dfxtp_1
X$1788 VNB|VSS synth_8862 synth_8863 synth_8937 VDD VDD VNB|VSS
+ sky130_fd_sc_hd__dfxtp_1
X$1789 VNB|VSS synth_12688 synth_12311 synth_12691 VDD VDD VNB|VSS
+ sky130_fd_sc_hd__dfxtp_1
X$1790 VNB|VSS synth_1761 synth_1833 synth_1836 VDD VDD VNB|VSS
+ sky130_fd_sc_hd__dfxtp_1
X$1791 VNB|VSS synth_3614 synth_3462 synth_3634 VDD VDD VNB|VSS
+ sky130_fd_sc_hd__dfxtp_1
X$1792 VNB|VSS synth_1708 synth_1795 synth_1709 VDD VDD VNB|VSS
+ sky130_fd_sc_hd__dfxtp_1
X$1793 VNB|VSS synth_7266 synth_7334 synth_7451 VDD VDD VNB|VSS
+ sky130_fd_sc_hd__dfxtp_1
X$1794 VNB|VSS synth_7591 synth_6388 synth_7749 VDD VDD VNB|VSS
+ sky130_fd_sc_hd__dfxtp_1
X$1795 VNB|VSS synth_8265 synth_8103 synth_8342 VDD VDD VNB|VSS
+ sky130_fd_sc_hd__dfxtp_1
X$1796 VNB|VSS synth_1705 synth_1423 synth_1580 VDD VDD VNB|VSS
+ sky130_fd_sc_hd__dfxtp_1
X$1797 VNB|VSS synth_1642 synth_1276 synth_1689 VDD VDD VNB|VSS
+ sky130_fd_sc_hd__dfxtp_1
X$1798 VNB|VSS synth_1610 synth_1423 synth_1581 VDD VDD VNB|VSS
+ sky130_fd_sc_hd__dfxtp_1
X$1799 VNB|VSS synth_7608 synth_7588 synth_8202 VDD VDD VNB|VSS
+ sky130_fd_sc_hd__dfxtp_1
X$1800 VNB|VSS synth_6390 synth_6388 synth_6470 VDD VDD VNB|VSS
+ sky130_fd_sc_hd__dfxtp_1
X$1801 VNB|VSS synth_9499 synth_9270 synth_9807 VDD VDD VNB|VSS
+ sky130_fd_sc_hd__dfxtp_1
X$1802 VNB|VSS synth_11455 synth_10910 synth_11511 VDD VDD VNB|VSS
+ sky130_fd_sc_hd__dfxtp_1
X$1803 VNB|VSS synth_7670 synth_7808 synth_7875 VDD VDD VNB|VSS
+ sky130_fd_sc_hd__dfxtp_1
X$1804 VNB|VSS synth_11877 synth_11549 synth_11762 VDD VDD VNB|VSS
+ sky130_fd_sc_hd__dfxtp_1
X$1805 VNB|VSS synth_1813 synth_1810 synth_1734 VDD VDD VNB|VSS
+ sky130_fd_sc_hd__dfxtp_1
X$1806 VNB|VSS synth_3519 synth_3043 synth_3520 VDD VDD VNB|VSS
+ sky130_fd_sc_hd__dfxtp_1
X$1807 VNB|VSS synth_11160 synth_10910 synth_11159 VDD VDD VNB|VSS
+ sky130_fd_sc_hd__dfxtp_1
X$1808 VNB|VSS synth_11474 synth_11549 synth_11476 VDD VDD VNB|VSS
+ sky130_fd_sc_hd__dfxtp_1
X$1809 VNB|VSS synth_3636 synth_3462 synth_3805 VDD VDD VNB|VSS
+ sky130_fd_sc_hd__dfxtp_1
X$1810 VNB|VSS synth_10451 synth_10106 synth_10800 VDD VDD VNB|VSS
+ sky130_fd_sc_hd__dfxtp_1
X$1811 VNB|VSS synth_9065 synth_8413 synth_8973 VDD VDD VNB|VSS
+ sky130_fd_sc_hd__dfxtp_1
X$1812 VNB|VSS synth_6753 synth_6815 synth_6768 VDD VDD VNB|VSS
+ sky130_fd_sc_hd__dfxtp_1
X$1813 VNB|VSS synth_3310 synth_3043 synth_3275 VDD VDD VNB|VSS
+ sky130_fd_sc_hd__dfxtp_1
X$1814 VNB|VSS synth_10264 synth_9702 synth_10266 VDD VDD VNB|VSS
+ sky130_fd_sc_hd__dfxtp_1
X$1815 VNB|VSS synth_1635 synth_1717 synth_1779 VDD VDD VNB|VSS
+ sky130_fd_sc_hd__dfxtp_1
X$1816 VNB|VSS synth_1735 synth_1276 synth_1863 VDD VDD VNB|VSS
+ sky130_fd_sc_hd__dfxtp_1
X$1817 VNB|VSS synth_7267 synth_7334 synth_7452 VDD VDD VNB|VSS
+ sky130_fd_sc_hd__dfxtp_1
X$1818 VNB|VSS synth_8361 synth_8315 synth_8360 VDD VDD VNB|VSS
+ sky130_fd_sc_hd__dfxtp_1
X$1819 VNB|VSS synth_3472 synth_3397 synth_3437 VDD VDD VNB|VSS
+ sky130_fd_sc_hd__dfxtp_1
X$1820 VNB|VSS synth_5264 synth_5159 synth_5158 VDD VDD VNB|VSS
+ sky130_fd_sc_hd__dfxtp_1
X$1821 VNB|VSS synth_11757 synth_11470 synth_11754 VDD VDD VNB|VSS
+ sky130_fd_sc_hd__dfxtp_1
X$1822 VNB|VSS synth_12606 synth_12315 synth_12677 VDD VDD VNB|VSS
+ sky130_fd_sc_hd__dfxtp_1
X$1823 VNB|VSS synth_6752 synth_6815 synth_6975 VDD VDD VNB|VSS
+ sky130_fd_sc_hd__dfxtp_1
X$1824 VNB|VSS synth_6903 synth_6815 synth_6973 VDD VDD VNB|VSS
+ sky130_fd_sc_hd__dfxtp_1
X$1825 VNB|VSS synth_1374 synth_1453 synth_1549 VDD VDD VNB|VSS
+ sky130_fd_sc_hd__dfxtp_1
X$1826 VNB|VSS synth_12413 synth_12311 synth_12701 VDD VDD VNB|VSS
+ sky130_fd_sc_hd__dfxtp_1
X$1827 VNB|VSS synth_11416 synth_11117 synth_11417 VDD VDD VNB|VSS
+ sky130_fd_sc_hd__dfxtp_1
X$1828 VNB|VSS synth_3707 synth_3576 synth_3706 VDD VDD VNB|VSS
+ sky130_fd_sc_hd__dfxtp_1
X$1829 VNB|VSS synth_3273 synth_3043 synth_3517 VDD VDD VNB|VSS
+ sky130_fd_sc_hd__dfxtp_1
X$1830 VNB|VSS synth_2109 synth_1795 synth_2158 VDD VDD VNB|VSS
+ sky130_fd_sc_hd__dfxtp_1
X$1831 VNB|VSS synth_9448 synth_9127 synth_9715 VDD VDD VNB|VSS
+ sky130_fd_sc_hd__dfxtp_1
X$1832 VNB|VSS synth_9354 synth_9127 synth_9714 VDD VDD VNB|VSS
+ sky130_fd_sc_hd__dfxtp_1
X$1833 VNB|VSS synth_12542 synth_12311 synth_12544 VDD VDD VNB|VSS
+ sky130_fd_sc_hd__dfxtp_1
X$1834 VNB|VSS synth_4456 synth_4293 synth_5025 VDD VDD VNB|VSS
+ sky130_fd_sc_hd__dfxtp_1
X$1835 VNB|VSS synth_11020 synth_11117 synth_11118 VDD VDD VNB|VSS
+ sky130_fd_sc_hd__dfxtp_1
X$1836 VNB|VSS synth_8164 synth_7826 synth_8138 VDD VDD VNB|VSS
+ sky130_fd_sc_hd__dfxtp_1
X$1837 VNB|VSS synth_9439 synth_9127 synth_9537 VDD VDD VNB|VSS
+ sky130_fd_sc_hd__dfxtp_1
X$1838 VNB|VSS synth_7214 synth_7213 synth_7430 VDD VDD VNB|VSS
+ sky130_fd_sc_hd__dfxtp_1
X$1839 VNB|VSS synth_8333 synth_7868 synth_8252 VDD VDD VNB|VSS
+ sky130_fd_sc_hd__dfxtp_1
X$1840 VNB|VSS synth_8251 synth_6929 synth_8364 VDD VDD VNB|VSS
+ sky130_fd_sc_hd__dfxtp_1
X$1841 VNB|VSS synth_8898 synth_8479 synth_8966 VDD VDD VNB|VSS
+ sky130_fd_sc_hd__dfxtp_1
X$1842 VNB|VSS synth_1995 synth_1872 synth_1874 VDD VDD VNB|VSS
+ sky130_fd_sc_hd__dfxtp_1
X$1843 VDD synth_1943 synth_1870 synth_1990 synth_1705 synth_1993 synth_1909
+ VNB|VSS VDD VNB|VSS sky130_fd_sc_hd__a32oi_1
X$1844 VNB|VSS synth_8107 synth_8103 synth_8194 VDD VDD VNB|VSS
+ sky130_fd_sc_hd__dfxtp_1
X$1845 VNB|VSS synth_7974 synth_6801 synth_7920 VDD VDD VNB|VSS
+ sky130_fd_sc_hd__dfxtp_1
X$1846 VNB|VSS synth_1652 synth_1453 synth_1986 VDD VDD VNB|VSS
+ sky130_fd_sc_hd__dfxtp_1
X$1847 VNB|VSS synth_1942 synth_1833 synth_2030 VDD VDD VNB|VSS
+ sky130_fd_sc_hd__dfxtp_1
X$1848 VNB|VSS synth_10394 synth_10025 synth_10393 VDD VDD VNB|VSS
+ sky130_fd_sc_hd__dfxtp_1
X$1849 VNB|VSS synth_8810 synth_8479 synth_8773 VDD VDD VNB|VSS
+ sky130_fd_sc_hd__dfxtp_1
X$1850 VNB|VSS synth_10464 synth_10025 synth_10596 VDD VDD VNB|VSS
+ sky130_fd_sc_hd__dfxtp_1
X$1851 VNB|VSS synth_10323 synth_10025 synth_10457 VDD VDD VNB|VSS
+ sky130_fd_sc_hd__dfxtp_1
X$1852 VNB|VSS synth_12533 synth_11939 synth_12774 VDD VDD VNB|VSS
+ sky130_fd_sc_hd__dfxtp_1
X$1853 VNB|VSS synth_2166 synth_1717 synth_2165 VDD VDD VNB|VSS
+ sky130_fd_sc_hd__dfxtp_1
X$1854 VNB|VSS synth_3830 synth_3397 synth_4031 VDD VDD VNB|VSS
+ sky130_fd_sc_hd__dfxtp_1
X$1855 VNB|VSS synth_7501 synth_7588 synth_7605 VDD VDD VNB|VSS
+ sky130_fd_sc_hd__dfxtp_1
X$1856 VNB|VSS synth_6637 synth_5715 synth_6610 VDD VDD VNB|VSS
+ sky130_fd_sc_hd__dfxtp_1
X$1857 VNB|VSS synth_4084 synth_3818 synth_4174 VDD VDD VNB|VSS
+ sky130_fd_sc_hd__dfxtp_1
X$1858 VNB|VSS synth_10524 synth_10808 synth_10807 VDD VDD VNB|VSS
+ sky130_fd_sc_hd__dfxtp_1
X$1859 VNB|VSS synth_1870 synth_1833 synth_1985 VDD VDD VNB|VSS
+ sky130_fd_sc_hd__dfxtp_1
X$1860 VNB|VSS synth_11149 synth_10628 synth_11446 VDD VDD VNB|VSS
+ sky130_fd_sc_hd__dfxtp_1
X$1861 VNB|VSS synth_12255 synth_12315 synth_12256 VDD VDD VNB|VSS
+ sky130_fd_sc_hd__dfxtp_1
X$1862 VNB|VSS synth_8558 synth_8413 synth_8665 VDD VDD VNB|VSS
+ sky130_fd_sc_hd__dfxtp_1
X$1863 VNB|VSS synth_9718 synth_9370 synth_9719 VDD VDD VNB|VSS
+ sky130_fd_sc_hd__dfxtp_1
X$1864 VNB|VSS synth_12472 synth_11939 synth_12687 VDD VDD VNB|VSS
+ sky130_fd_sc_hd__dfxtp_1
X$1865 VNB|VSS synth_4011 synth_3263 synth_4136 VDD VDD VNB|VSS
+ sky130_fd_sc_hd__dfxtp_1
X$1866 VNB|VSS synth_10661 synth_10106 synth_10660 VDD VDD VNB|VSS
+ sky130_fd_sc_hd__dfxtp_1
X$1867 VNB|VSS synth_9076 synth_9127 synth_9881 VDD VDD VNB|VSS
+ sky130_fd_sc_hd__dfxtp_1
X$1868 VNB|VSS synth_10809 synth_10802 synth_10676 VDD VDD VNB|VSS
+ sky130_fd_sc_hd__dfxtp_1
X$1869 VNB|VSS synth_12529 synth_12311 synth_12781 VDD VDD VNB|VSS
+ sky130_fd_sc_hd__dfxtp_1
X$1870 VNB|VSS synth_1195 synth_640 synth_1291 VDD VDD VNB|VSS
+ sky130_fd_sc_hd__dfxtp_1
X$1871 VDD synth_1292 synth_1195 synth_1485 VDD VNB|VSS synth_1315 VNB|VSS
+ sky130_fd_sc_hd__o21ai_1
X$1872 VNB|VSS synth_2051 synth_1810 synth_1962 VDD VDD VNB|VSS
+ sky130_fd_sc_hd__dfxtp_1
X$1873 VNB|VSS synth_11345 synth_10269 synth_11275 VDD VDD VNB|VSS
+ sky130_fd_sc_hd__dfxtp_1
X$1874 VNB|VSS synth_8093 synth_7868 synth_8014 VDD VDD VNB|VSS
+ sky130_fd_sc_hd__dfxtp_1
X$1875 VNB|VSS synth_10737 synth_10025 synth_10736 VDD VDD VNB|VSS
+ sky130_fd_sc_hd__dfxtp_1
X$1876 VNB|VSS synth_9706 synth_9256 synth_9597 VDD VDD VNB|VSS
+ sky130_fd_sc_hd__dfxtp_1
X$1877 VNB|VSS synth_9194 synth_9256 synth_9445 VDD VDD VNB|VSS
+ sky130_fd_sc_hd__dfxtp_1
X$1878 VNB|VSS synth_2240 synth_1717 synth_2516 VDD VDD VNB|VSS
+ sky130_fd_sc_hd__dfxtp_1
X$1879 VNB|VSS synth_9166 synth_9270 synth_9461 VDD VDD VNB|VSS
+ sky130_fd_sc_hd__dfxtp_1
X$1880 VNB|VSS synth_8381 synth_8863 synth_8737 VDD VDD VNB|VSS
+ sky130_fd_sc_hd__dfxtp_1
X$1881 VNB|VSS synth_5421 synth_5753 synth_5728 VDD VDD VNB|VSS
+ sky130_fd_sc_hd__dfxtp_1
X$1882 VNB|VSS synth_3272 synth_3043 synth_3521 VDD VDD VNB|VSS
+ sky130_fd_sc_hd__dfxtp_1
X$1883 VNB|VSS synth_1968 synth_1276 synth_2121 VDD VDD VNB|VSS
+ sky130_fd_sc_hd__dfxtp_1
X$1884 VNB|VSS synth_9779 synth_9370 synth_9809 VDD VDD VNB|VSS
+ sky130_fd_sc_hd__dfxtp_1
X$1885 VNB|VSS synth_6819 synth_6454 synth_6969 VDD VDD VNB|VSS
+ sky130_fd_sc_hd__dfxtp_1
X$1886 VNB|VSS synth_9221 synth_9045 synth_9471 VDD VDD VNB|VSS
+ sky130_fd_sc_hd__dfxtp_1
X$1887 VNB|VSS synth_9310 synth_8380 synth_9812 VDD VDD VNB|VSS
+ sky130_fd_sc_hd__dfxtp_1
X$1888 VNB|VSS synth_9463 synth_8778 synth_9465 VDD VDD VNB|VSS
+ sky130_fd_sc_hd__dfxtp_1
X$1889 VNB|VSS synth_3453 synth_2643 synth_3501 VDD VDD VNB|VSS
+ sky130_fd_sc_hd__dfxtp_1
X$1890 VNB|VSS synth_11682 synth_11470 synth_11828 VDD VDD VNB|VSS
+ sky130_fd_sc_hd__dfxtp_1
X$1891 VNB|VSS synth_3553 synth_2643 synth_3499 VDD VDD VNB|VSS
+ sky130_fd_sc_hd__dfxtp_1
X$1892 VNB|VSS synth_8890 synth_7808 synth_8815 VDD VDD VNB|VSS
+ sky130_fd_sc_hd__dfxtp_1
X$1893 VNB|VSS synth_9142 synth_9270 synth_9219 VDD VDD VNB|VSS
+ sky130_fd_sc_hd__dfxtp_1
X$1894 VNB|VSS synth_10930 synth_10226 synth_10926 VDD VDD VNB|VSS
+ sky130_fd_sc_hd__dfxtp_1
X$1895 VNB|VSS synth_3854 synth_3478 synth_3839 VDD VDD VNB|VSS
+ sky130_fd_sc_hd__dfxtp_1
X$1896 VNB|VSS synth_9369 synth_9370 synth_9458 VDD VDD VNB|VSS
+ sky130_fd_sc_hd__dfxtp_1
X$1897 VNB|VSS synth_4591 synth_4575 synth_4899 VDD VDD VNB|VSS
+ sky130_fd_sc_hd__dfxtp_1
X$1898 VNB|VSS synth_2005 synth_1970 synth_2008 VDD VDD VNB|VSS
+ sky130_fd_sc_hd__dfxtp_1
X$1899 VNB|VSS synth_11394 synth_10808 synth_11498 VDD VDD VNB|VSS
+ sky130_fd_sc_hd__dfxtp_1
X$1900 VNB|VSS synth_6140 synth_5953 synth_6192 VDD VDD VNB|VSS
+ sky130_fd_sc_hd__dfxtp_1
X$1901 VNB|VSS synth_9638 synth_9256 synth_9786 VDD VDD VNB|VSS
+ sky130_fd_sc_hd__dfxtp_1
X$1902 VNB|VSS synth_3832 synth_3043 synth_3833 VDD VDD VNB|VSS
+ sky130_fd_sc_hd__dfxtp_1
X$1903 VNB|VSS synth_8876 synth_8595 synth_8828 VDD VDD VNB|VSS
+ sky130_fd_sc_hd__dfxtp_1
X$1904 VNB|VSS synth_6940 synth_6454 synth_4717 VDD VDD VNB|VSS
+ sky130_fd_sc_hd__dfxtp_1
X$1905 VNB|VSS synth_9358 synth_9127 synth_9872 VDD VDD VNB|VSS
+ sky130_fd_sc_hd__dfxtp_1
X$1906 VNB|VSS synth_11758 synth_10808 synth_11822 VDD VDD VNB|VSS
+ sky130_fd_sc_hd__dfxtp_1
X$1907 VNB|VSS synth_11874 synth_11470 synth_11948 VDD VDD VNB|VSS
+ sky130_fd_sc_hd__dfxtp_1
X$1908 VNB|VSS synth_8338 synth_8650 synth_8715 VDD VDD VNB|VSS
+ sky130_fd_sc_hd__dfxtp_1
X$1909 VNB|VSS synth_9375 synth_9045 synth_9414 VDD VDD VNB|VSS
+ sky130_fd_sc_hd__dfxtp_1
X$1910 VNB|VSS synth_7127 synth_6388 synth_7593 VDD VDD VNB|VSS
+ sky130_fd_sc_hd__dfxtp_1
X$1911 VNB|VSS synth_4811 synth_5478 synth_5589 VDD VDD VNB|VSS
+ sky130_fd_sc_hd__dfxtp_1
X$1912 VNB|VSS synth_11120 synth_10226 synth_11271 VDD VDD VNB|VSS
+ sky130_fd_sc_hd__dfxtp_1
X$1913 VNB|VSS synth_11245 synth_10910 synth_11375 VDD VDD VNB|VSS
+ sky130_fd_sc_hd__dfxtp_1
X$1914 VNB|VSS synth_11888 synth_11626 synth_11781 VDD VDD VNB|VSS
+ sky130_fd_sc_hd__dfxtp_1
X$1915 VNB|VSS synth_1737 synth_1276 synth_1609 VDD VDD VNB|VSS
+ sky130_fd_sc_hd__dfxtp_1
X$1916 VNB|VSS synth_1546 synth_1423 synth_1502 VDD VDD VNB|VSS
+ sky130_fd_sc_hd__dfxtp_1
X$1917 VNB|VSS synth_5793 synth_6059 synth_6016 VDD VDD VNB|VSS
+ sky130_fd_sc_hd__dfxtp_1
X$1918 VNB|VSS synth_11044 synth_10802 synth_11021 VDD VDD VNB|VSS
+ sky130_fd_sc_hd__dfxtp_1
X$1919 VNB|VSS synth_8382 synth_8315 synth_8286 VDD VDD VNB|VSS
+ sky130_fd_sc_hd__dfxtp_1
X$1920 VNB|VSS synth_10824 synth_10269 synth_10890 VDD VDD VNB|VSS
+ sky130_fd_sc_hd__dfxtp_1
X$1921 VNB|VSS synth_11679 synth_11626 synth_11425 VDD VDD VNB|VSS
+ sky130_fd_sc_hd__dfxtp_1
X$1922 VNB|VSS synth_12415 synth_11939 synth_12434 VDD VDD VNB|VSS
+ sky130_fd_sc_hd__dfxtp_1
X$1923 VNB|VSS synth_4276 synth_4575 synth_4731 VDD VDD VNB|VSS
+ sky130_fd_sc_hd__dfxtp_1
X$1924 VNB|VSS synth_10478 synth_10802 synth_10885 VDD VDD VNB|VSS
+ sky130_fd_sc_hd__dfxtp_1
X$1925 VNB|VSS synth_11477 synth_11549 synth_11554 VDD VDD VNB|VSS
+ sky130_fd_sc_hd__dfxtp_1
X$1926 VNB|VSS synth_8127 synth_7868 synth_8349 VDD VDD VNB|VSS
+ sky130_fd_sc_hd__dfxtp_1
X$1927 VNB|VSS synth_8239 synth_7826 synth_8163 VDD VDD VNB|VSS
+ sky130_fd_sc_hd__dfxtp_1
X$1928 VNB|VSS synth_11172 synth_10269 synth_9892 VDD VDD VNB|VSS
+ sky130_fd_sc_hd__dfxtp_1
X$1929 VNB|VSS synth_10592 synth_10806 synth_10742 VDD VDD VNB|VSS
+ sky130_fd_sc_hd__dfxtp_1
X$1930 VNB|VSS synth_10879 synth_10802 synth_10873 VDD VDD VNB|VSS
+ sky130_fd_sc_hd__dfxtp_1
X$1931 VNB|VSS synth_8274 synth_7868 synth_8351 VDD VDD VNB|VSS
+ sky130_fd_sc_hd__dfxtp_1
X$1932 VNB|VSS synth_2337 synth_2268 synth_2402 VDD VDD VNB|VSS
+ sky130_fd_sc_hd__dfxtp_1
X$1933 VNB|VSS synth_12475 synth_12315 synth_12423 VDD VDD VNB|VSS
+ sky130_fd_sc_hd__dfxtp_1
X$1934 VNB|VSS synth_8702 synth_8380 synth_8748 VDD VDD VNB|VSS
+ sky130_fd_sc_hd__dfxtp_1
X$1935 VNB|VSS synth_1589 synth_640 synth_1556 VDD VDD VNB|VSS
+ sky130_fd_sc_hd__dfxtp_1
X$1936 VNB|VSS synth_11205 synth_10269 synth_11018 VDD VDD VNB|VSS
+ sky130_fd_sc_hd__dfxtp_1
X$1937 VNB|VSS synth_9275 synth_8595 synth_9279 VDD VDD VNB|VSS
+ sky130_fd_sc_hd__dfxtp_1
X$1938 VNB|VSS synth_11605 synth_11470 synth_11826 VDD VDD VNB|VSS
+ sky130_fd_sc_hd__dfxtp_1
X$1939 VNB|VSS synth_8053 synth_6801 synth_8140 VDD VDD VNB|VSS
+ sky130_fd_sc_hd__dfxtp_1
X$1940 VNB|VSS synth_8751 synth_8380 synth_8730 VDD VDD VNB|VSS
+ sky130_fd_sc_hd__dfxtp_1
X$1941 VNB|VSS synth_7048 synth_7213 synth_7278 VDD VDD VNB|VSS
+ sky130_fd_sc_hd__dfxtp_1
X$1942 VNB|VSS synth_5945 synth_5450 synth_5946 VDD VDD VNB|VSS
+ sky130_fd_sc_hd__dfxtp_1
X$1943 VNB|VSS synth_9648 synth_9127 synth_9784 VDD VDD VNB|VSS
+ sky130_fd_sc_hd__dfxtp_1
X$1944 VNB|VSS synth_10322 synth_10021 synth_10321 VDD VDD VNB|VSS
+ sky130_fd_sc_hd__dfxtp_1
X$1945 VNB|VSS synth_8399 synth_8103 synth_8345 VDD VDD VNB|VSS
+ sky130_fd_sc_hd__dfxtp_1
X$1946 VNB|VSS synth_8094 synth_7868 synth_8131 VDD VDD VNB|VSS
+ sky130_fd_sc_hd__dfxtp_1
X$1947 VNB|VSS synth_9015 synth_8479 synth_9141 VDD VDD VNB|VSS
+ sky130_fd_sc_hd__dfxtp_1
X$1948 VNB|VSS synth_11541 synth_11626 synth_11502 VDD VDD VNB|VSS
+ sky130_fd_sc_hd__dfxtp_1
X$1949 VNB|VSS synth_2336 synth_2268 synth_2312 VDD VDD VNB|VSS
+ sky130_fd_sc_hd__dfxtp_1
X$1950 VNB|VSS synth_8644 synth_8413 synth_8477 VDD VDD VNB|VSS
+ sky130_fd_sc_hd__dfxtp_1
X$1951 VNB|VSS synth_3787 synth_3818 synth_3816 VDD VDD VNB|VSS
+ sky130_fd_sc_hd__dfxtp_1
X$1952 VNB|VSS synth_8017 synth_6828 synth_8019 VDD VDD VNB|VSS
+ sky130_fd_sc_hd__dfxtp_1
X$1953 VNB|VSS synth_4081 synth_3818 synth_4259 VDD VDD VNB|VSS
+ sky130_fd_sc_hd__dfxtp_1
X$1954 VNB|VSS synth_12007 synth_11939 synth_12010 VDD VDD VNB|VSS
+ sky130_fd_sc_hd__dfxtp_1
X$1955 VNB|VSS synth_11670 synth_12024 synth_11972 VDD VDD VNB|VSS
+ sky130_fd_sc_hd__dfxtp_1
X$1956 VNB|VSS synth_9254 synth_9127 synth_9264 VDD VDD VNB|VSS
+ sky130_fd_sc_hd__dfxtp_1
X$1957 VNB|VSS synth_12120 synth_11549 synth_12249 VDD VDD VNB|VSS
+ sky130_fd_sc_hd__dfxtp_1
X$1958 VNB|VSS synth_2037 synth_2330 synth_2688 VDD VDD VNB|VSS
+ sky130_fd_sc_hd__dfxtp_1
X$1959 VNB|VSS synth_11688 synth_11549 synth_11697 VDD VDD VNB|VSS
+ sky130_fd_sc_hd__dfxtp_1
X$1960 VNB|VSS synth_12417 synth_11939 synth_12616 VDD VDD VNB|VSS
+ sky130_fd_sc_hd__dfxtp_1
X$1961 VNB|VSS synth_4290 synth_3478 synth_4401 VDD VDD VNB|VSS
+ sky130_fd_sc_hd__dfxtp_1
X$1962 VNB|VSS synth_8797 synth_8863 synth_9046 VDD VDD VNB|VSS
+ sky130_fd_sc_hd__dfxtp_1
X$1963 VNB|VSS synth_7341 synth_7213 synth_7287 VDD VDD VNB|VSS
+ sky130_fd_sc_hd__dfxtp_1
X$1964 VNB|VSS synth_12262 synth_11626 synth_11890 VDD VDD VNB|VSS
+ sky130_fd_sc_hd__dfxtp_1
X$1965 VNB|VSS synth_12366 synth_12315 synth_12316 VDD VDD VNB|VSS
+ sky130_fd_sc_hd__dfxtp_1
X$1966 VNB|VSS synth_9548 synth_9811 synth_9810 VDD VDD VNB|VSS
+ sky130_fd_sc_hd__dfxtp_1
X$1967 VNB|VSS synth_8442 synth_8315 synth_8317 VDD VDD VNB|VSS
+ sky130_fd_sc_hd__dfxtp_1
X$1968 VNB|VSS synth_11473 synth_10808 synth_11558 VDD VDD VNB|VSS
+ sky130_fd_sc_hd__dfxtp_1
X$1969 VNB|VSS synth_12130 synth_11626 synth_11782 VDD VDD VNB|VSS
+ sky130_fd_sc_hd__dfxtp_1
X$1970 VNB|VSS synth_8024 synth_7809 synth_8025 VDD VDD VNB|VSS
+ sky130_fd_sc_hd__dfxtp_1
X$1971 VNB|VSS synth_9636 synth_9256 synth_9788 VDD VDD VNB|VSS
+ sky130_fd_sc_hd__dfxtp_1
X$1972 VNB|VSS synth_7677 synth_7588 synth_8126 VDD VDD VNB|VSS
+ sky130_fd_sc_hd__dfxtp_1
X$1973 VNB|VSS synth_11958 synth_11626 synth_11964 VDD VDD VNB|VSS
+ sky130_fd_sc_hd__dfxtp_1
X$1974 VNB|VSS synth_8099 synth_6828 synth_8204 VDD VDD VNB|VSS
+ sky130_fd_sc_hd__dfxtp_1
X$1975 VNB|VSS synth_8734 synth_8391 synth_8043 VDD VDD VNB|VSS
+ sky130_fd_sc_hd__dfxtp_1
X$1976 VNB|VSS synth_6431 synth_6734 synth_7093 VDD VDD VNB|VSS
+ sky130_fd_sc_hd__dfxtp_1
X$1977 VNB|VSS synth_10877 synth_10808 synth_10878 VDD VDD VNB|VSS
+ sky130_fd_sc_hd__dfxtp_1
X$1978 VNB|VSS synth_9887 synth_9370 synth_9864 VDD VDD VNB|VSS
+ sky130_fd_sc_hd__dfxtp_1
X$1979 VNB|VSS synth_8116 synth_8103 synth_8023 VDD VDD VNB|VSS
+ sky130_fd_sc_hd__dfxtp_1
X$1980 VNB|VSS synth_10543 synth_9702 synth_10609 VDD VDD VNB|VSS
+ sky130_fd_sc_hd__dfxtp_1
X$1981 VNB|VSS synth_5346 synth_5159 synth_5424 VDD VDD VNB|VSS
+ sky130_fd_sc_hd__dfxtp_1
X$1982 VNB|VSS synth_8095 synth_7868 synth_8016 VDD VDD VNB|VSS
+ sky130_fd_sc_hd__dfxtp_1
X$1983 VNB|VSS synth_8256 synth_8413 synth_8355 VDD VDD VNB|VSS
+ sky130_fd_sc_hd__dfxtp_1
X$1984 VNB|VSS synth_4116 synth_3576 synth_3924 VDD VDD VNB|VSS
+ sky130_fd_sc_hd__dfxtp_1
X$1985 VNB|VSS synth_5260 synth_5478 synth_5258 VDD VDD VNB|VSS
+ sky130_fd_sc_hd__dfxtp_1
X$1986 VNB|VSS synth_1687 synth_1345 synth_1636 VDD VDD VNB|VSS
+ sky130_fd_sc_hd__dfxtp_1
X$1987 VNB|VSS synth_10109 synth_10025 synth_10108 VDD VDD VNB|VSS
+ sky130_fd_sc_hd__dfxtp_1
X$1988 VNB|VSS synth_12001 synth_11470 synth_12067 VDD VDD VNB|VSS
+ sky130_fd_sc_hd__dfxtp_1
X$1989 VNB|VSS synth_11037 synth_10802 synth_10883 VDD VDD VNB|VSS
+ sky130_fd_sc_hd__dfxtp_1
X$1990 VNB|VSS synth_8407 synth_8650 synth_8572 VDD VDD VNB|VSS
+ sky130_fd_sc_hd__dfxtp_1
X$1991 VNB|VSS synth_9949 synth_9256 synth_9875 VDD VDD VNB|VSS
+ sky130_fd_sc_hd__dfxtp_1
X$1992 VNB|VSS synth_10911 synth_10910 synth_10859 VDD VDD VNB|VSS
+ sky130_fd_sc_hd__dfxtp_1
X$1993 VNB|VSS synth_6432 synth_6734 synth_6957 VDD VDD VNB|VSS
+ sky130_fd_sc_hd__dfxtp_1
X$1994 VNB|VSS synth_11406 synth_10806 synth_10961 VDD VDD VNB|VSS
+ sky130_fd_sc_hd__dfxtp_1
X$1995 VNB|VSS synth_4398 synth_3478 synth_4482 VDD VDD VNB|VSS
+ sky130_fd_sc_hd__dfxtp_1
X$1996 VNB|VSS synth_11300 synth_11527 synth_11703 VDD VDD VNB|VSS
+ sky130_fd_sc_hd__dfxtp_1
X$1997 VNB|VSS synth_11273 synth_10269 synth_10798 VDD VDD VNB|VSS
+ sky130_fd_sc_hd__dfxtp_1
X$1998 VNB|VSS synth_4036 synth_3569 synth_4314 VDD VDD VNB|VSS
+ sky130_fd_sc_hd__dfxtp_1
X$1999 VNB|VSS synth_8331 synth_8595 synth_8282 VDD VDD VNB|VSS
+ sky130_fd_sc_hd__dfxtp_1
X$2000 VNB|VSS synth_8199 synth_7588 synth_8200 VDD VDD VNB|VSS
+ sky130_fd_sc_hd__dfxtp_1
X$2001 VNB|VSS synth_12479 synth_12315 synth_12766 VDD VDD VNB|VSS
+ sky130_fd_sc_hd__dfxtp_1
X$2002 VNB|VSS synth_8180 synth_7868 synth_8280 VDD VDD VNB|VSS
+ sky130_fd_sc_hd__dfxtp_1
X$2003 VNB|VSS synth_9634 synth_9370 synth_9795 VDD VDD VNB|VSS
+ sky130_fd_sc_hd__dfxtp_1
X$2004 VNB|VSS synth_10516 synth_10106 synth_10759 VDD VDD VNB|VSS
+ sky130_fd_sc_hd__dfxtp_1
X$2005 VNB|VSS synth_1292 synth_571 synth_1486 VDD VDD VNB|VSS
+ sky130_fd_sc_hd__dfxtp_1
X$2006 VNB|VSS synth_11938 synth_11117 synth_11960 VDD VDD VNB|VSS
+ sky130_fd_sc_hd__dfxtp_1
X$2007 VNB|VSS synth_10260 synth_10106 synth_10181 VDD VDD VNB|VSS
+ sky130_fd_sc_hd__dfxtp_1
X$2008 VNB|VSS synth_10399 synth_10106 synth_10334 VDD VDD VNB|VSS
+ sky130_fd_sc_hd__dfxtp_1
X$2009 VNB|VSS synth_12246 synth_12315 synth_12322 VDD VDD VNB|VSS
+ sky130_fd_sc_hd__dfxtp_1
X$2010 VNB|VSS synth_10590 synth_10021 synth_10599 VDD VDD VNB|VSS
+ sky130_fd_sc_hd__dfxtp_1
X$2011 VNB|VSS synth_2048 synth_1810 synth_2173 VDD VDD VNB|VSS
+ sky130_fd_sc_hd__dfxtp_1
X$2012 VNB|VSS synth_8901 synth_8479 synth_8902 VDD VDD VNB|VSS
+ sky130_fd_sc_hd__dfxtp_1
X$2013 VNB|VSS synth_6443 synth_6853 synth_7096 VDD VDD VNB|VSS
+ sky130_fd_sc_hd__dfxtp_1
X$2014 VNB|VSS synth_1278 synth_1276 synth_1159 VDD VDD VNB|VSS
+ sky130_fd_sc_hd__dfxtp_1
X$2015 VNB|VSS synth_6466 synth_6388 synth_6988 VDD VDD VNB|VSS
+ sky130_fd_sc_hd__dfxtp_1
X$2016 VNB|VSS synth_4356 synth_4575 synth_4500 VDD VDD VNB|VSS
+ sky130_fd_sc_hd__dfxtp_1
X$2017 VNB|VSS synth_6170 synth_6388 synth_7274 VDD VDD VNB|VSS
+ sky130_fd_sc_hd__dfxtp_1
X$2018 VNB|VSS synth_7674 synth_7213 synth_7606 VDD VDD VNB|VSS
+ sky130_fd_sc_hd__dfxtp_1
X$2019 VNB|VSS synth_9592 synth_9370 synth_9590 VDD VDD VNB|VSS
+ sky130_fd_sc_hd__dfxtp_1
X$2020 VNB|VSS synth_4655 synth_4575 synth_4636 VDD VDD VNB|VSS
+ sky130_fd_sc_hd__dfxtp_1
X$2021 VNB|VSS synth_9870 synth_10021 synth_10033 VDD VDD VNB|VSS
+ sky130_fd_sc_hd__dfxtp_1
X$2022 VNB|VSS synth_12180 synth_11939 synth_12201 VDD VDD VNB|VSS
+ sky130_fd_sc_hd__dfxtp_1
X$2023 VNB|VSS synth_1965 synth_1810 synth_2255 VDD VDD VNB|VSS
+ sky130_fd_sc_hd__dfxtp_1
X$2024 VNB|VSS synth_11189 synth_10806 synth_10754 VDD VDD VNB|VSS
+ sky130_fd_sc_hd__dfxtp_1
X$2025 VNB|VSS synth_7269 synth_7213 synth_7283 VDD VDD VNB|VSS
+ sky130_fd_sc_hd__dfxtp_1
X$2026 VNB|VSS synth_9805 synth_9370 synth_9803 VDD VDD VNB|VSS
+ sky130_fd_sc_hd__dfxtp_1
X$2027 VNB|VSS synth_9340 synth_9256 synth_9257 VDD VDD VNB|VSS
+ sky130_fd_sc_hd__dfxtp_1
X$2028 VNB|VSS synth_3366 synth_3263 synth_3289 VDD VDD VNB|VSS
+ sky130_fd_sc_hd__dfxtp_1
X$2029 VNB|VSS synth_3831 synth_3397 synth_3966 VDD VDD VNB|VSS
+ sky130_fd_sc_hd__dfxtp_1
X$2030 VNB|VSS synth_3757 synth_3462 synth_3821 VDD VDD VNB|VSS
+ sky130_fd_sc_hd__dfxtp_1
X$2031 VNB|VSS synth_8476 synth_8413 synth_8503 VDD VDD VNB|VSS
+ sky130_fd_sc_hd__dfxtp_1
X$2032 VNB|VSS synth_5211 synth_4505 synth_5081 VDD VDD VNB|VSS
+ sky130_fd_sc_hd__dfxtp_1
X$2033 VNB|VSS synth_1003 synth_450 synth_1030 VDD VDD VNB|VSS
+ sky130_fd_sc_hd__dfxtp_1
X$2034 VNB|VSS synth_11024 synth_10802 synth_11043 VDD VDD VNB|VSS
+ sky130_fd_sc_hd__dfxtp_1
X$2035 VNB|VSS synth_9778 synth_9702 synth_9813 VDD VDD VNB|VSS
+ sky130_fd_sc_hd__dfxtp_1
X$2036 VNB|VSS synth_8431 synth_8082 synth_4817 VDD VDD VNB|VSS
+ sky130_fd_sc_hd__dfxtp_1
X$2037 VNB|VSS synth_1798 synth_1345 synth_1845 VDD VDD VNB|VSS
+ sky130_fd_sc_hd__dfxtp_1
X$2038 VNB|VSS synth_8010 synth_8391 synth_4631 VDD VDD VNB|VSS
+ sky130_fd_sc_hd__dfxtp_1
X$2039 VNB|VSS synth_1722 synth_1432 synth_1799 VDD VDD VNB|VSS
+ sky130_fd_sc_hd__dfxtp_1
X$2040 VNB|VSS synth_9184 synth_9127 synth_9137 VDD VDD VNB|VSS
+ sky130_fd_sc_hd__dfxtp_1
X$2041 VNB|VSS synth_10529 synth_10021 synth_10587 VDD VDD VNB|VSS
+ sky130_fd_sc_hd__dfxtp_1
X$2042 VNB|VSS synth_1194 synth_640 synth_1316 VDD VDD VNB|VSS
+ sky130_fd_sc_hd__dfxtp_1
X$2043 VNB|VSS synth_8335 synth_8650 synth_8336 VDD VDD VNB|VSS
+ sky130_fd_sc_hd__dfxtp_1
X$2044 VNB|VSS synth_8627 synth_8315 synth_8708 VDD VDD VNB|VSS
+ sky130_fd_sc_hd__dfxtp_1
X$2045 VNB|VSS synth_8583 synth_8479 synth_8582 VDD VDD VNB|VSS
+ sky130_fd_sc_hd__dfxtp_1
X$2046 VNB|VSS synth_8626 synth_8863 synth_8925 VDD VDD VNB|VSS
+ sky130_fd_sc_hd__dfxtp_1
X$2047 VNB|VSS synth_11237 synth_11495 synth_11659 VDD VDD VNB|VSS
+ sky130_fd_sc_hd__dfxtp_1
X$2048 VNB|VSS synth_10188 synth_10025 synth_10194 VDD VDD VNB|VSS
+ sky130_fd_sc_hd__dfxtp_1
X$2049 VNB|VSS synth_7128 synth_6388 synth_7426 VDD VDD VNB|VSS
+ sky130_fd_sc_hd__dfxtp_1
X$2050 VNB|VSS synth_922 synth_640 synth_921 VDD VDD VNB|VSS
+ sky130_fd_sc_hd__dfxtp_1
X$2051 VNB|VSS synth_7033 synth_7115 synth_7311 VDD VDD VNB|VSS
+ sky130_fd_sc_hd__dfxtp_1
X$2052 VNB|VSS synth_8478 synth_8413 synth_8660 VDD VDD VNB|VSS
+ sky130_fd_sc_hd__dfxtp_1
X$2053 VNB|VSS synth_6972 synth_7115 synth_7116 VDD VDD VNB|VSS
+ sky130_fd_sc_hd__dfxtp_1
X$2054 VNB|VSS synth_1720 synth_1345 synth_1621 VDD VDD VNB|VSS
+ sky130_fd_sc_hd__dfxtp_1
X$2055 VNB|VSS synth_7590 synth_7588 synth_7878 VDD VDD VNB|VSS
+ sky130_fd_sc_hd__dfxtp_1
X$2056 VNB|VSS synth_10605 synth_10269 synth_11048 VDD VDD VNB|VSS
+ sky130_fd_sc_hd__dfxtp_1
X$2057 VNB|VSS synth_10023 synth_10021 synth_10183 VDD VDD VNB|VSS
+ sky130_fd_sc_hd__dfxtp_1
X$2058 VNB|VSS synth_9072 synth_8479 synth_9026 VDD VDD VNB|VSS
+ sky130_fd_sc_hd__dfxtp_1
X$2059 VNB|VSS synth_1591 synth_1453 synth_1765 VDD VDD VNB|VSS
+ sky130_fd_sc_hd__dfxtp_1
X$2060 VNB|VSS synth_12309 synth_12311 synth_12377 VDD VDD VNB|VSS
+ sky130_fd_sc_hd__dfxtp_1
X$2061 VNB|VSS synth_3401 synth_3043 synth_3341 VDD VDD VNB|VSS
+ sky130_fd_sc_hd__dfxtp_1
X$2062 VNB|VSS synth_11671 synth_11719 synth_11926 VDD VDD VNB|VSS
+ sky130_fd_sc_hd__dfxtp_1
X$2063 VNB|VSS synth_859 synth_450 synth_776 VDD VDD VNB|VSS
+ sky130_fd_sc_hd__dfxtp_1
X$2064 VNB|VSS synth_5733 synth_5658 synth_5660 VDD VDD VNB|VSS
+ sky130_fd_sc_hd__dfxtp_1
X$2065 VNB|VSS synth_11251 synth_10808 synth_11262 VDD VDD VNB|VSS
+ sky130_fd_sc_hd__dfxtp_1
X$2066 VNB|VSS synth_11680 synth_11117 synth_11710 VDD VDD VNB|VSS
+ sky130_fd_sc_hd__dfxtp_1
X$2067 VNB|VSS synth_6759 synth_7588 synth_7603 VDD VDD VNB|VSS
+ sky130_fd_sc_hd__dfxtp_1
X$2068 VDD synth_7807 synth_7590 synth_7589 VDD synth_6471 VNB|VSS VNB|VSS
+ sky130_fd_sc_hd__a21oi_2
X$2069 VNB|VSS synth_9868 synth_10021 synth_10035 VDD VDD VNB|VSS
+ sky130_fd_sc_hd__dfxtp_1
X$2070 VNB|VSS synth_4245 synth_3820 synth_4327 VDD VDD VNB|VSS
+ sky130_fd_sc_hd__dfxtp_1
X$2071 VNB|VSS synth_4022 synth_3820 synth_4002 VDD VDD VNB|VSS
+ sky130_fd_sc_hd__dfxtp_1
X$2072 VNB|VSS synth_6061 synth_5658 synth_6259 VDD VDD VNB|VSS
+ sky130_fd_sc_hd__dfxtp_1
X$2073 VNB|VSS synth_6291 synth_5450 synth_6662 VDD VDD VNB|VSS
+ sky130_fd_sc_hd__dfxtp_1
X$2074 VNB|VSS synth_9865 synth_9702 synth_10135 VDD VDD VNB|VSS
+ sky130_fd_sc_hd__dfxtp_1
X$2075 VNB|VSS synth_10450 synth_10106 synth_10481 VDD VDD VNB|VSS
+ sky130_fd_sc_hd__dfxtp_1
X$2076 VNB|VSS synth_6962 synth_6961 synth_6995 VDD VDD VNB|VSS
+ sky130_fd_sc_hd__dfxtp_1
X$2077 VNB|VSS synth_11235 synth_10628 synth_11418 VDD VDD VNB|VSS
+ sky130_fd_sc_hd__dfxtp_1
X$2078 VNB|VSS synth_4203 synth_4293 synth_4473 VDD VDD VNB|VSS
+ sky130_fd_sc_hd__dfxtp_1
X$2079 VNB|VSS synth_5731 synth_5658 synth_5844 VDD VDD VNB|VSS
+ sky130_fd_sc_hd__dfxtp_1
X$2080 VNB|VSS synth_10380 synth_9702 synth_10338 VDD VDD VNB|VSS
+ sky130_fd_sc_hd__dfxtp_1
X$2081 VNB|VSS synth_8606 synth_8082 synth_6418 VDD VDD VNB|VSS
+ sky130_fd_sc_hd__dfxtp_1
X$2082 VNB|VSS synth_10241 synth_10025 synth_10242 VDD VDD VNB|VSS
+ sky130_fd_sc_hd__dfxtp_1
X$2083 VNB|VSS synth_5504 synth_5478 synth_5727 VDD VDD VNB|VSS
+ sky130_fd_sc_hd__dfxtp_1
X$2084 VNB|VSS synth_9524 synth_9127 synth_9794 VDD VDD VNB|VSS
+ sky130_fd_sc_hd__dfxtp_1
X$2085 VNB|VSS synth_7240 synth_7334 synth_7624 VDD VDD VNB|VSS
+ sky130_fd_sc_hd__dfxtp_1
X$2086 VNB|VSS synth_11193 synth_11527 synth_11562 VDD VDD VNB|VSS
+ sky130_fd_sc_hd__dfxtp_1
X$2087 VNB|VSS synth_7264 synth_6815 synth_7242 VDD VDD VNB|VSS
+ sky130_fd_sc_hd__dfxtp_1
X$2088 VNB|VSS synth_8427 synth_8391 synth_8324 VDD VDD VNB|VSS
+ sky130_fd_sc_hd__dfxtp_1
X$2089 VNB|VSS synth_8412 synth_8479 synth_8721 VDD VDD VNB|VSS
+ sky130_fd_sc_hd__dfxtp_1
X$2090 VNB|VSS synth_3432 synth_3397 synth_3470 VDD VDD VNB|VSS
+ sky130_fd_sc_hd__dfxtp_1
X$2091 VNB|VSS synth_11999 synth_11470 synth_11951 VDD VDD VNB|VSS
+ sky130_fd_sc_hd__dfxtp_1
X$2092 VNB|VSS synth_11944 synth_11549 synth_11941 VDD VDD VNB|VSS
+ sky130_fd_sc_hd__dfxtp_1
X$2093 VNB|VSS synth_12416 synth_12311 synth_12259 VDD VDD VNB|VSS
+ sky130_fd_sc_hd__dfxtp_1
X$2094 VNB|VSS synth_9093 synth_8778 synth_9816 VDD VDD VNB|VSS
+ sky130_fd_sc_hd__dfxtp_1
X$2095 VNB|VSS synth_1947 synth_1795 synth_2004 VDD VDD VNB|VSS
+ sky130_fd_sc_hd__dfxtp_1
X$2096 VNB|VSS synth_10954 synth_10806 synth_10751 VDD VDD VNB|VSS
+ sky130_fd_sc_hd__dfxtp_1
X$2097 VNB|VSS synth_7265 synth_7334 synth_7540 VDD VDD VNB|VSS
+ sky130_fd_sc_hd__dfxtp_1
X$2098 VNB|VSS synth_3745 synth_3462 synth_3638 VDD VDD VNB|VSS
+ sky130_fd_sc_hd__dfxtp_1
X$2099 VNB|VSS synth_11099 synth_10802 synth_11116 VDD VDD VNB|VSS
+ sky130_fd_sc_hd__dfxtp_1
X$2100 VNB|VSS synth_8498 synth_8479 synth_8499 VDD VDD VNB|VSS
+ sky130_fd_sc_hd__dfxtp_1
X$2101 VNB|VSS synth_8701 synth_8380 synth_8625 VDD VDD VNB|VSS
+ sky130_fd_sc_hd__dfxtp_1
X$2102 VNB|VSS synth_12330 synth_12311 synth_12328 VDD VDD VNB|VSS
+ sky130_fd_sc_hd__dfxtp_1
X$2103 VNB|VSS synth_3841 synth_3576 synth_3715 VDD VDD VNB|VSS
+ sky130_fd_sc_hd__dfxtp_1
X$2104 VNB|VSS synth_6538 synth_6734 synth_7092 VDD VDD VNB|VSS
+ sky130_fd_sc_hd__dfxtp_1
X$2105 VNB|VSS synth_11475 synth_11549 synth_11557 VDD VDD VNB|VSS
+ sky130_fd_sc_hd__dfxtp_1
X$2106 VNB|VSS synth_9333 synth_9370 synth_9246 VDD VDD VNB|VSS
+ sky130_fd_sc_hd__dfxtp_1
X$2107 VNB|VSS synth_12605 synth_12311 synth_12694 VDD VDD VNB|VSS
+ sky130_fd_sc_hd__dfxtp_1
X$2108 VNB|VSS synth_1789 synth_1810 synth_1812 VDD VDD VNB|VSS
+ sky130_fd_sc_hd__dfxtp_1
X$2109 VNB|VSS synth_4041 synth_3478 synth_3986 VDD VDD VNB|VSS
+ sky130_fd_sc_hd__dfxtp_1
X$2110 VNB|VSS synth_11669 synth_12024 synth_12088 VDD VDD VNB|VSS
+ sky130_fd_sc_hd__dfxtp_1
X$2111 VNB|VSS synth_8556 synth_8595 synth_8505 VDD VDD VNB|VSS
+ sky130_fd_sc_hd__dfxtp_1
X$2112 VNB|VSS synth_9593 synth_9256 synth_9647 VDD VDD VNB|VSS
+ sky130_fd_sc_hd__dfxtp_1
X$2113 VNB|VSS synth_12077 synth_11939 synth_11953 VDD VDD VNB|VSS
+ sky130_fd_sc_hd__dfxtp_1
X$2114 VNB|VSS synth_8653 synth_7808 synth_8718 VDD VDD VNB|VSS
+ sky130_fd_sc_hd__dfxtp_1
X$2115 VNB|VSS synth_11309 synth_10910 synth_11573 VDD VDD VNB|VSS
+ sky130_fd_sc_hd__dfxtp_1
X$2116 VNB|VSS synth_9543 synth_8778 synth_9280 VDD VDD VNB|VSS
+ sky130_fd_sc_hd__dfxtp_1
X$2117 VNB|VSS synth_11478 synth_11549 synth_11551 VDD VDD VNB|VSS
+ sky130_fd_sc_hd__dfxtp_1
X$2118 VNB|VSS synth_5420 synth_5478 synth_5654 VDD VDD VNB|VSS
+ sky130_fd_sc_hd__dfxtp_1
X$2119 VNB|VSS synth_6834 synth_7213 synth_7137 VDD VDD VNB|VSS
+ sky130_fd_sc_hd__dfxtp_1
X$2120 VNB|VSS synth_5645 synth_5753 synth_5952 VDD VDD VNB|VSS
+ sky130_fd_sc_hd__dfxtp_1
X$2121 VNB|VSS synth_4108 synth_3569 synth_4110 VDD VDD VNB|VSS
+ sky130_fd_sc_hd__dfxtp_1
X$2122 VNB|VSS synth_9021 synth_7808 synth_9129 VDD VDD VNB|VSS
+ sky130_fd_sc_hd__dfxtp_1
X$2123 VNB|VSS synth_10874 synth_10806 synth_10875 VDD VDD VNB|VSS
+ sky130_fd_sc_hd__dfxtp_1
X$2124 VNB|VSS synth_7423 synth_7588 synth_7607 VDD VDD VNB|VSS
+ sky130_fd_sc_hd__dfxtp_1
X$2125 VNB|VSS synth_6309 synth_6388 synth_6467 VDD VDD VNB|VSS
+ sky130_fd_sc_hd__dfxtp_1
X$2126 VNB|VSS synth_8736 synth_8391 synth_8508 VDD VDD VNB|VSS
+ sky130_fd_sc_hd__dfxtp_1
X$2127 VNB|VSS synth_9220 synth_9270 synth_9412 VDD VDD VNB|VSS
+ sky130_fd_sc_hd__dfxtp_1
X$2128 VNB|VSS synth_8724 synth_8413 synth_8825 VDD VDD VNB|VSS
+ sky130_fd_sc_hd__dfxtp_1
X$2129 VNB|VSS synth_6310 synth_6388 synth_6474 VDD VDD VNB|VSS
+ sky130_fd_sc_hd__dfxtp_1
X$2130 VNB|VSS synth_9451 synth_9370 synth_9454 VDD VDD VNB|VSS
+ sky130_fd_sc_hd__dfxtp_1
X$2131 VNB|VSS synth_5156 synth_4505 synth_5080 VDD VDD VNB|VSS
+ sky130_fd_sc_hd__dfxtp_1
X$2132 VNB|VSS synth_6758 synth_6388 synth_6839 VDD VDD VNB|VSS
+ sky130_fd_sc_hd__dfxtp_1
X$2133 VNB|VSS synth_6540 synth_6734 synth_6843 VDD VDD VNB|VSS
+ sky130_fd_sc_hd__dfxtp_1
X$2134 VNB|VSS synth_1704 synth_1423 synth_1606 VDD VDD VNB|VSS
+ sky130_fd_sc_hd__dfxtp_1
X$2135 VNB|VSS synth_3748 synth_3263 synth_3857 VDD VDD VNB|VSS
+ sky130_fd_sc_hd__dfxtp_1
X$2136 VNB|VSS synth_11105 synth_10806 synth_11254 VDD VDD VNB|VSS
+ sky130_fd_sc_hd__dfxtp_1
X$2137 VNB|VSS synth_6595 synth_6853 synth_6791 VDD VDD VNB|VSS
+ sky130_fd_sc_hd__dfxtp_1
X$2138 VNB|VSS synth_10267 synth_9702 synth_10012 VDD VDD VNB|VSS
+ sky130_fd_sc_hd__dfxtp_1
X$2139 VNB|VSS synth_8646 synth_8413 synth_8723 VDD VDD VNB|VSS
+ sky130_fd_sc_hd__dfxtp_1
X$2140 VNB|VSS synth_8808 synth_8595 synth_9121 VDD VDD VNB|VSS
+ sky130_fd_sc_hd__dfxtp_1
X$2141 VNB|VSS synth_4275 synth_3462 synth_4501 VDD VDD VNB|VSS
+ sky130_fd_sc_hd__dfxtp_1
X$2142 VNB|VSS synth_1310 synth_1453 synth_1474 VDD VDD VNB|VSS
+ sky130_fd_sc_hd__dfxtp_1
X$2143 VNB|VSS synth_11403 synth_10806 synth_11404 VDD VDD VNB|VSS
+ sky130_fd_sc_hd__dfxtp_1
X$2144 VNB|VSS synth_1212 synth_571 synth_1193 VDD VDD VNB|VSS
+ sky130_fd_sc_hd__dfxtp_1
X$2145 VNB|VSS synth_12312 synth_11939 synth_12323 VDD VDD VNB|VSS
+ sky130_fd_sc_hd__dfxtp_1
X$2146 VNB|VSS synth_11339 synth_10806 synth_11259 VDD VDD VNB|VSS
+ sky130_fd_sc_hd__dfxtp_1
X$2147 VNB|VSS synth_8885 synth_8479 synth_8823 VDD VDD VNB|VSS
+ sky130_fd_sc_hd__dfxtp_1
X$2148 VNB|VSS synth_10041 synth_9702 synth_10042 VDD VDD VNB|VSS
+ sky130_fd_sc_hd__dfxtp_1
X$2149 VNB|VSS synth_11301 synth_11495 synth_11625 VDD VDD VNB|VSS
+ sky130_fd_sc_hd__dfxtp_1
X$2150 VNB|VSS synth_11104 synth_10806 synth_11103 VDD VDD VNB|VSS
+ sky130_fd_sc_hd__dfxtp_1
X$2151 VNB|VSS synth_11397 synth_10802 synth_11265 VDD VDD VNB|VSS
+ sky130_fd_sc_hd__dfxtp_1
X$2152 VDD synth_3468 VDD VNB|VSS synth_3632 VNB|VSS sky130_fd_sc_hd__buf_4
X$2153 VDD synth_6211 VDD VNB|VSS synth_850 VNB|VSS sky130_fd_sc_hd__buf_4
X$2154 VDD synth_8710 VDD VNB|VSS synth_9062 VNB|VSS sky130_fd_sc_hd__buf_4
X$2155 VDD synth_10004 VDD VNB|VSS synth_9923 VNB|VSS sky130_fd_sc_hd__buf_4
X$2156 VDD synth_8461 VDD VNB|VSS synth_8314 VNB|VSS sky130_fd_sc_hd__buf_4
X$2157 VDD synth_4253 VDD VNB|VSS synth_37 VNB|VSS sky130_fd_sc_hd__buf_4
X$2158 VDD synth_8914 VDD VNB|VSS synth_8764 VNB|VSS sky130_fd_sc_hd__buf_4
X$2159 VDD synth_2277 VDD VNB|VSS synth_2056 VNB|VSS sky130_fd_sc_hd__buf_4
X$2160 VDD synth_11221 VDD VNB|VSS synth_11017 VNB|VSS sky130_fd_sc_hd__buf_4
X$2161 VDD synth_387 VDD VNB|VSS synth_5329 VNB|VSS sky130_fd_sc_hd__buf_4
X$2162 VDD synth_9850 VDD VNB|VSS synth_9695 VNB|VSS sky130_fd_sc_hd__buf_4
X$2163 VDD synth_4623 VDD VNB|VSS synth_2125 VNB|VSS sky130_fd_sc_hd__buf_4
X$2164 VDD synth_8949 VDD VNB|VSS synth_8981 VNB|VSS sky130_fd_sc_hd__buf_4
X$2165 VDD synth_9434 VDD VNB|VSS synth_9629 VNB|VSS sky130_fd_sc_hd__buf_4
X$2166 VDD synth_4747 VDD VNB|VSS synth_1353 VNB|VSS sky130_fd_sc_hd__buf_4
X$2167 VDD synth_12239 VDD VNB|VSS synth_8945 VNB|VSS sky130_fd_sc_hd__buf_4
X$2168 VDD synth_12409 VDD VNB|VSS synth_9926 VNB|VSS sky130_fd_sc_hd__buf_4
X$2169 VDD synth_7183 VDD VNB|VSS synth_6597 VNB|VSS sky130_fd_sc_hd__buf_4
X$2170 VDD synth_8036 VDD VNB|VSS synth_4747 VNB|VSS sky130_fd_sc_hd__buf_4
X$2171 VDD synth_2860 VDD VNB|VSS synth_6987 VNB|VSS sky130_fd_sc_hd__buf_4
X$2172 VDD synth_5787 VDD VNB|VSS synth_6699 VNB|VSS sky130_fd_sc_hd__buf_4
X$2173 VDD synth_382 VDD VNB|VSS synth_3656 VNB|VSS sky130_fd_sc_hd__buf_4
X$2174 VDD synth_7955 VDD VNB|VSS synth_7196 VNB|VSS sky130_fd_sc_hd__buf_4
X$2175 VDD synth_8738 VDD VNB|VSS synth_8806 VNB|VSS sky130_fd_sc_hd__buf_4
X$2176 VDD synth_8633 VDD VNB|VSS synth_8805 VNB|VSS sky130_fd_sc_hd__buf_4
X$2177 VDD synth_4629 VDD VNB|VSS synth_4042 VNB|VSS sky130_fd_sc_hd__buf_4
X$2178 VDD synth_4747 VDD VNB|VSS synth_7743 VNB|VSS sky130_fd_sc_hd__buf_4
X$2179 VDD synth_8764 VDD VNB|VSS synth_10793 VNB|VSS sky130_fd_sc_hd__buf_4
X$2180 VDD synth_7440 VDD VNB|VSS synth_7495 VNB|VSS sky130_fd_sc_hd__buf_4
X$2181 VDD synth_1353 VDD VNB|VSS synth_66 VNB|VSS sky130_fd_sc_hd__buf_4
X$2182 VDD synth_12756 VDD VNB|VSS synth_10169 VNB|VSS sky130_fd_sc_hd__buf_4
X$2183 VDD synth_657 VDD VNB|VSS synth_1015 VNB|VSS sky130_fd_sc_hd__buf_4
X$2184 VDD synth_7758 VDD VNB|VSS synth_4527 VNB|VSS sky130_fd_sc_hd__buf_4
X$2185 VDD synth_4747 VDD VNB|VSS synth_4961 VNB|VSS sky130_fd_sc_hd__buf_4
X$2186 VDD synth_9626 VDD VNB|VSS synth_9699 VNB|VSS sky130_fd_sc_hd__buf_4
X$2187 VDD synth_9063 VDD VNB|VSS synth_10285 VNB|VSS sky130_fd_sc_hd__buf_4
X$2188 VDD synth_8000 VDD VNB|VSS synth_9762 VNB|VSS sky130_fd_sc_hd__buf_4
X$2189 VDD synth_7183 VDD VNB|VSS synth_7089 VNB|VSS sky130_fd_sc_hd__buf_4
X$2190 VDD synth_474 VDD VNB|VSS synth_3527 VNB|VSS sky130_fd_sc_hd__buf_4
X$2191 VDD synth_12404 VDD VNB|VSS synth_10840 VNB|VSS sky130_fd_sc_hd__buf_4
X$2192 VDD synth_4747 VDD VNB|VSS synth_3468 VNB|VSS sky130_fd_sc_hd__buf_4
X$2193 VDD synth_7435 VDD VNB|VSS synth_9049 VNB|VSS sky130_fd_sc_hd__buf_4
X$2194 VDD synth_3632 VDD VNB|VSS synth_1067 VNB|VSS sky130_fd_sc_hd__buf_4
X$2195 VDD synth_1335 VDD VNB|VSS synth_501 VNB|VSS sky130_fd_sc_hd__buf_4
X$2196 VDD synth_8987 VDD VNB|VSS synth_8946 VNB|VSS sky130_fd_sc_hd__buf_4
X$2197 VDD synth_6211 VDD VNB|VSS synth_3964 VNB|VSS sky130_fd_sc_hd__buf_4
X$2198 VDD synth_581 VDD VNB|VSS synth_408 VNB|VSS sky130_fd_sc_hd__buf_4
X$2199 VDD synth_9231 VDD VNB|VSS synth_9172 VNB|VSS sky130_fd_sc_hd__buf_4
X$2200 VDD synth_8764 VDD VNB|VSS synth_9387 VNB|VSS sky130_fd_sc_hd__buf_4
X$2201 VDD synth_11190 VDD VNB|VSS synth_8887 VNB|VSS sky130_fd_sc_hd__buf_4
X$2202 VDD synth_9513 VDD VNB|VSS synth_9379 VNB|VSS sky130_fd_sc_hd__buf_4
X$2203 VDD synth_7111 VDD VNB|VSS synth_7183 VNB|VSS sky130_fd_sc_hd__buf_4
X$2204 VDD synth_10234 VDD VNB|VSS synth_9895 VNB|VSS sky130_fd_sc_hd__buf_4
X$2205 VDD synth_9904 VDD VNB|VSS synth_9483 VNB|VSS sky130_fd_sc_hd__buf_4
X$2206 VDD synth_10489 VDD VNB|VSS synth_10440 VNB|VSS sky130_fd_sc_hd__buf_4
X$2207 VDD synth_8196 VDD VNB|VSS synth_6211 VNB|VSS sky130_fd_sc_hd__buf_4
X$2208 VDD synth_8738 VDD VNB|VSS synth_9677 VNB|VSS sky130_fd_sc_hd__buf_4
X$2209 VDD synth_2860 VDD VNB|VSS synth_4467 VNB|VSS sky130_fd_sc_hd__buf_4
X$2210 VDD synth_8000 VDD VNB|VSS synth_10164 VNB|VSS sky130_fd_sc_hd__buf_4
X$2211 VDD synth_3632 VDD VNB|VSS synth_1338 VNB|VSS sky130_fd_sc_hd__buf_4
X$2212 VDD synth_8764 VDD VNB|VSS synth_9119 VNB|VSS sky130_fd_sc_hd__buf_4
X$2213 VDD synth_10290 VDD VNB|VSS synth_9927 VNB|VSS sky130_fd_sc_hd__buf_4
X$2214 VDD synth_8604 VDD VNB|VSS synth_10212 VNB|VSS sky130_fd_sc_hd__buf_4
X$2215 VDD synth_1081 VDD VNB|VSS synth_346 VNB|VSS sky130_fd_sc_hd__buf_4
X$2216 VDD synth_66 VDD VNB|VSS synth_151 VNB|VSS sky130_fd_sc_hd__buf_4
X$2217 VDD synth_581 VDD VNB|VSS synth_1081 VNB|VSS sky130_fd_sc_hd__buf_4
X$2218 VDD synth_4968 VDD VNB|VSS synth_4710 VNB|VSS sky130_fd_sc_hd__buf_4
X$2219 VDD synth_10576 VDD VNB|VSS synth_10697 VNB|VSS sky130_fd_sc_hd__buf_4
X$2220 VDD synth_11598 VDD VNB|VSS synth_9235 VNB|VSS sky130_fd_sc_hd__buf_4
X$2221 VDD synth_1459 VDD VNB|VSS synth_4566 VNB|VSS sky130_fd_sc_hd__buf_4
X$2222 VDD synth_4961 VDD VNB|VSS synth_167 VNB|VSS sky130_fd_sc_hd__buf_4
X$2223 VDD synth_3632 VDD VNB|VSS synth_3544 VNB|VSS sky130_fd_sc_hd__buf_4
X$2224 VDD synth_9481 VDD VNB|VSS synth_9427 VNB|VSS sky130_fd_sc_hd__buf_4
X$2225 VDD synth_7435 VDD VNB|VSS synth_8230 VNB|VSS sky130_fd_sc_hd__buf_4
X$2226 VDD synth_2043 VDD VNB|VSS synth_2190 VNB|VSS sky130_fd_sc_hd__buf_4
X$2227 VDD synth_382 VDD VNB|VSS synth_478 VNB|VSS sky130_fd_sc_hd__buf_4
X$2228 VDD synth_1338 VDD VNB|VSS synth_659 VNB|VSS sky130_fd_sc_hd__buf_4
X$2229 VDD synth_8734 VDD VNB|VSS synth_8910 VNB|VSS sky130_fd_sc_hd__buf_4
X$2230 VDD synth_8976 VDD VNB|VSS synth_9117 VNB|VSS sky130_fd_sc_hd__buf_4
X$2231 VDD synth_9833 VDD VNB|VSS synth_9696 VNB|VSS sky130_fd_sc_hd__buf_4
X$2232 VDD synth_6211 VDD VNB|VSS synth_5286 VNB|VSS sky130_fd_sc_hd__buf_4
X$2233 VDD synth_9906 VDD VNB|VSS synth_9983 VNB|VSS sky130_fd_sc_hd__buf_4
X$2234 VDD synth_5286 VDD VNB|VSS synth_7435 VNB|VSS sky130_fd_sc_hd__buf_4
X$2235 VDD synth_9037 VDD VNB|VSS synth_9036 VNB|VSS sky130_fd_sc_hd__buf_4
X$2236 VDD synth_8427 VDD VNB|VSS synth_8710 VNB|VSS sky130_fd_sc_hd__buf_4
X$2237 VDD synth_12755 VDD VNB|VSS synth_9824 VNB|VSS sky130_fd_sc_hd__buf_4
X$2238 VDD synth_4235 VDD VNB|VSS synth_2059 VNB|VSS sky130_fd_sc_hd__buf_4
X$2239 VDD synth_11793 VDD VNB|VSS synth_10003 VNB|VSS sky130_fd_sc_hd__buf_4
X$2240 VDD synth_9105 VDD VNB|VSS synth_9396 VNB|VSS sky130_fd_sc_hd__buf_4
X$2241 VDD synth_8831 VDD VNB|VSS synth_8870 VNB|VSS sky130_fd_sc_hd__buf_4
X$2242 VDD synth_8807 VDD VNB|VSS synth_8872 VNB|VSS sky130_fd_sc_hd__buf_4
X$2243 VDD synth_474 VDD VNB|VSS synth_1213 VNB|VSS sky130_fd_sc_hd__buf_4
X$2244 VDD synth_387 VDD VNB|VSS synth_183 VNB|VSS sky130_fd_sc_hd__buf_4
X$2245 VDD synth_10286 VDD VNB|VSS synth_10441 VNB|VSS sky130_fd_sc_hd__buf_4
X$2246 VDD synth_4724 VDD VNB|VSS synth_4725 VNB|VSS sky130_fd_sc_hd__buf_4
X$2247 VDD synth_1695 VDD VNB|VSS synth_6564 VNB|VSS sky130_fd_sc_hd__buf_4
X$2248 VDD synth_10212 VDD VNB|VSS synth_9474 VNB|VSS sky130_fd_sc_hd__buf_4
X$2249 VDD synth_387 VDD VNB|VSS synth_1908 VNB|VSS sky130_fd_sc_hd__buf_4
X$2250 VDD synth_11095 VDD VNB|VSS synth_9738 VNB|VSS sky130_fd_sc_hd__buf_4
X$2251 VDD synth_9119 VDD VNB|VSS synth_10652 VNB|VSS sky130_fd_sc_hd__buf_4
X$2252 VDD synth_10898 VDD VNB|VSS synth_9063 VNB|VSS sky130_fd_sc_hd__buf_4
X$2253 VDD synth_1335 VDD VNB|VSS synth_1459 VNB|VSS sky130_fd_sc_hd__buf_4
X$2254 VDD synth_9629 VDD VNB|VSS synth_10578 VNB|VSS sky130_fd_sc_hd__buf_4
X$2255 VDD synth_7111 VDD VNB|VSS synth_8000 VNB|VSS sky130_fd_sc_hd__buf_4
X$2256 VDD synth_8000 VDD VNB|VSS synth_9423 VNB|VSS sky130_fd_sc_hd__buf_4
X$2257 VDD synth_10940 VDD VNB|VSS synth_10511 VNB|VSS sky130_fd_sc_hd__buf_4
X$2258 VDD synth_3964 VDD VNB|VSS synth_474 VNB|VSS sky130_fd_sc_hd__buf_4
X$2259 VDD synth_9230 VDD VNB|VSS synth_9322 VNB|VSS sky130_fd_sc_hd__buf_4
X$2260 VDD synth_4747 VDD VNB|VSS synth_7111 VNB|VSS sky130_fd_sc_hd__buf_4
X$2261 VDD synth_3544 VDD VNB|VSS synth_3541 VNB|VSS sky130_fd_sc_hd__buf_4
X$2262 VDD synth_9619 VDD VNB|VSS synth_9559 VNB|VSS sky130_fd_sc_hd__buf_4
X$2263 VDD synth_9428 VDD VNB|VSS synth_9234 VNB|VSS sky130_fd_sc_hd__buf_4
X$2264 VDD synth_10307 VDD VNB|VSS synth_10232 VNB|VSS sky130_fd_sc_hd__buf_4
X$2265 VDD synth_5787 VDD VNB|VSS synth_6198 VNB|VSS sky130_fd_sc_hd__buf_4
X$2266 VDD synth_88 VDD VNB|VSS synth_1181 VNB|VSS sky130_fd_sc_hd__buf_4
X$2267 VDD synth_8736 VDD VNB|VSS synth_8873 VNB|VSS sky130_fd_sc_hd__buf_4
X$2268 VDD synth_8803 VDD VNB|VSS synth_9292 VNB|VSS sky130_fd_sc_hd__buf_4
X$2269 VDD synth_10773 VDD VNB|VSS synth_9851 VNB|VSS sky130_fd_sc_hd__buf_4
X$2270 VDD synth_9232 VDD VNB|VSS synth_9112 VNB|VSS sky130_fd_sc_hd__buf_4
X$2271 VDD synth_8910 VDD VNB|VSS synth_9434 VNB|VSS sky130_fd_sc_hd__buf_4
X$2272 VDD synth_12348 VDD VNB|VSS synth_10007 VNB|VSS sky130_fd_sc_hd__buf_4
X$2273 VDD synth_5329 VDD VNB|VSS synth_4111 VNB|VSS sky130_fd_sc_hd__buf_4
X$2274 VDD synth_9550 VDD VNB|VSS synth_9700 VNB|VSS sky130_fd_sc_hd__buf_4
X$2275 VDD synth_4586 VDD VNB|VSS synth_4184 VNB|VSS sky130_fd_sc_hd__buf_4
X$2276 VDD synth_9384 VDD VNB|VSS synth_9239 VNB|VSS sky130_fd_sc_hd__buf_4
X$2277 VDD synth_2850 VDD VNB|VSS synth_2777 VNB|VSS sky130_fd_sc_hd__buf_4
X$2278 VDD synth_9432 VDD VNB|VSS synth_9931 VNB|VSS sky130_fd_sc_hd__buf_4
X$2279 VDD synth_3468 VDD VNB|VSS synth_2116 VNB|VSS sky130_fd_sc_hd__buf_4
X$2280 VDD synth_12724 VDD VNB|VSS synth_10849 VNB|VSS sky130_fd_sc_hd__buf_4
X$2281 VDD synth_4253 VDD VNB|VSS synth_2860 VNB|VSS sky130_fd_sc_hd__buf_4
X$2282 VDD synth_657 VDD VNB|VSS synth_214 VNB|VSS sky130_fd_sc_hd__buf_4
X$2283 VDD synth_8805 VDD VNB|VSS synth_8803 VNB|VSS sky130_fd_sc_hd__buf_4
X$2284 VDD synth_8831 VDD VNB|VSS synth_10312 VNB|VSS sky130_fd_sc_hd__buf_4
X$2285 VDD synth_1181 VDD VNB|VSS synth_449 VNB|VSS sky130_fd_sc_hd__buf_4
X$2286 VDD synth_11255 VDD VNB|VSS synth_8956 VNB|VSS sky130_fd_sc_hd__buf_4
X$2287 VDD synth_2860 VDD VNB|VSS synth_382 VNB|VSS sky130_fd_sc_hd__buf_4
X$2288 VDD synth_9049 VDD VNB|VSS synth_9691 VNB|VSS sky130_fd_sc_hd__buf_4
X$2289 VDD synth_9008 VDD VNB|VSS synth_8948 VNB|VSS sky130_fd_sc_hd__buf_4
X$2290 VDD synth_2777 VDD VNB|VSS synth_8337 VNB|VSS sky130_fd_sc_hd__buf_4
X$2291 VDD synth_9849 VDD VNB|VSS synth_9730 VNB|VSS sky130_fd_sc_hd__buf_4
X$2292 VDD synth_6211 VDD VNB|VSS synth_581 VNB|VSS sky130_fd_sc_hd__buf_4
X$2293 VDD synth_1353 VDD VNB|VSS synth_194 VNB|VSS sky130_fd_sc_hd__buf_4
X$2294 VDD synth_8312 VDD VNB|VSS synth_2107 VNB|VSS sky130_fd_sc_hd__buf_4
X$2295 VDD synth_10096 VDD VNB|VSS synth_9042 VNB|VSS sky130_fd_sc_hd__buf_4
X$2296 VDD synth_7089 VDD VNB|VSS synth_8746 VNB|VSS sky130_fd_sc_hd__buf_4
X$2297 VDD synth_11247 VDD VNB|VSS synth_9901 VNB|VSS sky130_fd_sc_hd__buf_4
X$2298 VDD synth_8188 VDD VNB|VSS synth_6695 VNB|VSS sky130_fd_sc_hd__buf_4
X$2299 VDD synth_7269 VDD VNB|VSS synth_4598 VNB|VSS sky130_fd_sc_hd__buf_4
X$2300 VDD synth_5286 VDD VNB|VSS synth_6476 VNB|VSS sky130_fd_sc_hd__buf_4
X$2301 VDD synth_7955 VDD VNB|VSS synth_657 VNB|VSS sky130_fd_sc_hd__buf_4
X$2302 VDD synth_8230 VDD VNB|VSS synth_9297 VNB|VSS sky130_fd_sc_hd__buf_4
X$2303 VDD synth_4961 VDD VNB|VSS synth_927 VNB|VSS sky130_fd_sc_hd__buf_4
X$2304 VDD synth_12306 VDD VNB|VSS synth_11504 VNB|VSS sky130_fd_sc_hd__buf_4
X$2305 VDD synth_258 VDD VNB|VSS synth_966 VNB|VSS sky130_fd_sc_hd__buf_4
X$2306 VDD synth_2202 VDD VNB|VSS synth_1294 VNB|VSS sky130_fd_sc_hd__buf_4
X$2307 VDD synth_4711 VDD VNB|VSS synth_4808 VNB|VSS sky130_fd_sc_hd__buf_4
X$2308 VNB|VSS synth_1437 VDD VDD VNB|VSS sky130_fd_sc_hd__bufinv_16
X$2309 VNB|VSS synth_2845 VDD VDD VNB|VSS sky130_fd_sc_hd__bufinv_16
X$2310 VNB|VSS synth_699 VDD VDD VNB|VSS sky130_fd_sc_hd__bufinv_16
X$2311 VNB|VSS synth_3025 VDD VDD VNB|VSS sky130_fd_sc_hd__bufinv_16
X$2312 VNB|VSS synth_10106 VDD VDD VNB|VSS sky130_fd_sc_hd__bufinv_16
X$2313 VNB|VSS synth_10047 VDD VDD VNB|VSS sky130_fd_sc_hd__bufinv_16
X$2314 VNB|VSS synth_5531 VDD VDD VNB|VSS sky130_fd_sc_hd__bufinv_16
X$2315 VNB|VSS synth_4505 VDD VDD VNB|VSS sky130_fd_sc_hd__bufinv_16
X$2316 VNB|VSS synth_12315 VDD VDD VNB|VSS sky130_fd_sc_hd__bufinv_16
X$2317 VNB|VSS synth_1011 VDD VDD VNB|VSS sky130_fd_sc_hd__bufinv_16
X$2318 VNB|VSS synth_5400 VDD VDD VNB|VSS sky130_fd_sc_hd__bufinv_16
X$2319 VNB|VSS synth_5753 VDD VDD VNB|VSS sky130_fd_sc_hd__bufinv_16
X$2320 VNB|VSS synth_8315 VDD VDD VNB|VSS sky130_fd_sc_hd__bufinv_16
X$2321 VNB|VSS synth_7826 VDD VDD VNB|VSS sky130_fd_sc_hd__bufinv_16
X$2322 VNB|VSS synth_4299 VDD VDD VNB|VSS sky130_fd_sc_hd__bufinv_16
X$2323 VNB|VSS synth_8553 VDD VDD VNB|VSS sky130_fd_sc_hd__bufinv_16
X$2324 VNB|VSS synth_4264 VDD VDD VNB|VSS sky130_fd_sc_hd__bufinv_16
X$2325 VNB|VSS synth_6531 VDD VDD VNB|VSS sky130_fd_sc_hd__bufinv_16
X$2326 VNB|VSS synth_3950 VDD VDD VNB|VSS sky130_fd_sc_hd__bufinv_16
X$2327 VDD synth_1122 synth_984 synth_151 synth_987 VNB|VSS synth_986 VDD
+ VNB|VSS sky130_fd_sc_hd__a2bb2oi_1
X$2328 VDD synth_8990 synth_8944 synth_8989 synth_9174 VNB|VSS synth_8871 VDD
+ VNB|VSS sky130_fd_sc_hd__a2bb2oi_1
X$2329 VDD synth_4226 synth_4200 synth_1353 synth_4224 VNB|VSS synth_4225 VDD
+ VNB|VSS sky130_fd_sc_hd__a2bb2oi_1
X$2330 VDD synth_10285 synth_11589 synth_9615 synth_10441 VNB|VSS synth_12243
+ VDD VNB|VSS sky130_fd_sc_hd__a2bb2oi_1
X$2331 VDD synth_900 synth_958 synth_194 synth_978 VNB|VSS synth_1032 VDD
+ VNB|VSS sky130_fd_sc_hd__a2bb2oi_1
X$2332 VDD synth_8803 synth_11595 synth_10232 synth_10840 VNB|VSS synth_11596
+ VDD VNB|VSS sky130_fd_sc_hd__a2bb2oi_1
X$2333 VDD synth_2007 synth_2006 synth_1890 synth_1444 VNB|VSS synth_1972 VDD
+ VNB|VSS sky130_fd_sc_hd__a2bb2oi_1
X$2334 VDD synth_1368 synth_1490 synth_66 synth_1487 VNB|VSS synth_1489 VDD
+ VNB|VSS sky130_fd_sc_hd__a2bb2oi_1
X$2335 VDD synth_4493 synth_4436 synth_1338 synth_4437 VNB|VSS synth_4352 VDD
+ VNB|VSS sky130_fd_sc_hd__a2bb2oi_1
X$2336 VNB|VSS synth_10021 VDD VDD VNB|VSS sky130_fd_sc_hd__clkbuf_8
X$2337 VNB|VSS synth_3569 VDD VDD VNB|VSS sky130_fd_sc_hd__clkbuf_8
X$2338 VNB|VSS synth_6733 VDD VDD VNB|VSS sky130_fd_sc_hd__clkbuf_8
X$2339 VNB|VSS synth_2533 VDD VDD VNB|VSS sky130_fd_sc_hd__clkbuf_8
X$2340 VNB|VSS synth_756 VDD VDD VNB|VSS sky130_fd_sc_hd__clkbuf_8
X$2341 VNB|VSS synth_5057 VDD VDD VNB|VSS sky130_fd_sc_hd__clkbuf_8
X$2342 VNB|VSS synth_3543 VDD VDD VNB|VSS sky130_fd_sc_hd__clkbuf_8
X$2343 VNB|VSS synth_7868 VDD VDD VNB|VSS sky130_fd_sc_hd__clkbuf_8
X$2344 VNB|VSS synth_30 VDD VDD VNB|VSS sky130_fd_sc_hd__clkbuf_8
X$2345 VNB|VSS synth_4019 VDD VDD VNB|VSS sky130_fd_sc_hd__clkbuf_8
X$2346 VNB|VSS synth_9370 VDD VDD VNB|VSS sky130_fd_sc_hd__clkbuf_8
X$2347 VNB|VSS synth_10081 VDD VDD VNB|VSS sky130_fd_sc_hd__clkbuf_8
X$2348 VNB|VSS synth_6929 VDD VDD VNB|VSS sky130_fd_sc_hd__clkbuf_8
X$2349 VNB|VSS synth_11851 VDD VDD VNB|VSS sky130_fd_sc_hd__clkbuf_8
X$2350 VNB|VSS synth_4934 VDD VDD VNB|VSS sky130_fd_sc_hd__clkbuf_8
X$2351 VNB|VSS synth_470 VDD VDD VNB|VSS sky130_fd_sc_hd__clkbuf_8
X$2352 VNB|VSS synth_9256 VDD VDD VNB|VSS sky130_fd_sc_hd__clkbuf_8
X$2353 VNB|VSS synth_6897 VDD VDD VNB|VSS sky130_fd_sc_hd__clkbuf_8
X$2354 VNB|VSS synth_2268 VDD VDD VNB|VSS sky130_fd_sc_hd__clkbuf_8
X$2355 VNB|VSS synth_6853 VDD VDD VNB|VSS sky130_fd_sc_hd__clkbuf_8
X$2356 VNB|VSS synth_5715 VDD VDD VNB|VSS sky130_fd_sc_hd__clkbuf_8
X$2357 VNB|VSS synth_63 VDD VDD VNB|VSS sky130_fd_sc_hd__clkbuf_8
X$2358 VNB|VSS synth_4461 VDD VDD VNB|VSS sky130_fd_sc_hd__clkbuf_8
X$2359 VNB|VSS synth_8380 VDD VDD VNB|VSS sky130_fd_sc_hd__clkbuf_8
X$2360 VNB|VSS synth_5515 VDD VDD VNB|VSS sky130_fd_sc_hd__clkbuf_8
X$2361 VNB|VSS synth_1898 VDD VDD VNB|VSS sky130_fd_sc_hd__clkbuf_8
X$2362 VNB|VSS synth_10806 VDD VDD VNB|VSS sky130_fd_sc_hd__clkbuf_8
X$2363 VNB|VSS synth_5303 VDD VDD VNB|VSS sky130_fd_sc_hd__clkbuf_8
X$2364 VNB|VSS synth_5172 VDD VDD VNB|VSS sky130_fd_sc_hd__clkbuf_8
X$2365 VNB|VSS synth_2205 VDD VDD VNB|VSS sky130_fd_sc_hd__clkbuf_8
X$2366 VNB|VSS synth_9270 VDD VDD VNB|VSS sky130_fd_sc_hd__clkbuf_8
X$2367 VNB|VSS synth_3385 VDD VDD VNB|VSS sky130_fd_sc_hd__clkbuf_8
X$2368 VNB|VSS synth_3318 VDD VDD VNB|VSS sky130_fd_sc_hd__clkbuf_8
X$2369 VDD synth_360 synth_296 synth_167 synth_460 VDD VNB|VSS VNB|VSS
+ sky130_fd_sc_hd__nand3_1
X$2370 VDD synth_6820 synth_6751 synth_6750 synth_4675 VDD VNB|VSS VNB|VSS
+ sky130_fd_sc_hd__nand3_1
X$2371 VDD synth_8314 synth_8467 synth_8311 synth_8756 VDD VNB|VSS VNB|VSS
+ sky130_fd_sc_hd__nand3_1
X$2372 VDD synth_12658 synth_12567 synth_10164 synth_12566 VDD VNB|VSS VNB|VSS
+ sky130_fd_sc_hd__nand3_1
X$2373 VDD synth_12356 synth_12437 synth_9762 synth_12355 VDD VNB|VSS VNB|VSS
+ sky130_fd_sc_hd__nand3_1
X$2374 VDD synth_3539 synth_3392 synth_2116 synth_3393 VDD VNB|VSS VNB|VSS
+ sky130_fd_sc_hd__nand3_1
X$2375 VDD synth_3232 synth_3220 synth_2116 synth_3231 VDD VNB|VSS VNB|VSS
+ sky130_fd_sc_hd__nand3_1
X$2376 VDD synth_559 synth_269 synth_194 synth_558 VDD VNB|VSS VNB|VSS
+ sky130_fd_sc_hd__nand3_1
X$2377 VDD synth_6876 synth_6526 synth_6597 synth_6782 VDD VNB|VSS VNB|VSS
+ sky130_fd_sc_hd__nand3_1
X$2378 VDD synth_1244 synth_1131 synth_1338 synth_1243 VDD VNB|VSS VNB|VSS
+ sky130_fd_sc_hd__nand3_1
X$2379 VDD synth_442 synth_284 synth_151 synth_441 VDD VNB|VSS VNB|VSS
+ sky130_fd_sc_hd__nand3_1
X$2380 VDD synth_6820 synth_4675 synth_4808 synth_6771 VDD VNB|VSS VNB|VSS
+ sky130_fd_sc_hd__nand3_1
X$2381 VDD synth_1164 synth_868 synth_1067 synth_1134 VDD VNB|VSS VNB|VSS
+ sky130_fd_sc_hd__nand3_1
X$2382 VDD synth_9119 synth_8948 synth_10104 synth_10177 VDD VNB|VSS VNB|VSS
+ sky130_fd_sc_hd__nand3_1
X$2383 VDD synth_394 synth_45 synth_151 synth_438 VDD VNB|VSS VNB|VSS
+ sky130_fd_sc_hd__nand3_1
X$2384 VDD synth_9058 synth_8783 synth_8000 synth_9106 VDD VNB|VSS VNB|VSS
+ sky130_fd_sc_hd__nand3_1
X$2385 VDD synth_7456 synth_7292 synth_7394 synth_7019 VDD VNB|VSS VNB|VSS
+ sky130_fd_sc_hd__nand3_1
X$2386 VDD synth_10003 synth_10177 synth_10213 synth_10209 VDD VNB|VSS VNB|VSS
+ sky130_fd_sc_hd__nand3_1
X$2387 VDD synth_7792 synth_7626 synth_7111 synth_7838 VDD VNB|VSS VNB|VSS
+ sky130_fd_sc_hd__nand3_1
X$2388 VDD synth_8885 synth_8810 synth_8898 synth_8884 VDD VNB|VSS VNB|VSS
+ sky130_fd_sc_hd__nand3_1
X$2389 VDD synth_5745 synth_5744 synth_3632 synth_5743 VDD VNB|VSS VNB|VSS
+ sky130_fd_sc_hd__nand3_1
X$2390 VDD synth_623 synth_224 synth_151 synth_569 VDD VNB|VSS VNB|VSS
+ sky130_fd_sc_hd__nand3_1
X$2391 VDD synth_5343 synth_5342 synth_5263 synth_5265 VDD VNB|VSS VNB|VSS
+ sky130_fd_sc_hd__nand3_1
X$2392 VDD synth_3148 synth_3026 synth_1067 synth_3104 VDD VNB|VSS VNB|VSS
+ sky130_fd_sc_hd__nand3_1
X$2393 VDD synth_9474 synth_9580 synth_9322 synth_9557 VDD VNB|VSS VNB|VSS
+ sky130_fd_sc_hd__nand3_1
X$2394 VDD synth_6647 synth_6345 synth_6546 synth_6544 VDD VNB|VSS VNB|VSS
+ sky130_fd_sc_hd__nand3_1
X$2395 VDD synth_5011 synth_4887 synth_3632 synth_5137 VDD VNB|VSS VNB|VSS
+ sky130_fd_sc_hd__nand3_1
X$2396 VDD synth_2729 synth_2726 synth_2116 synth_2653 VDD VNB|VSS VNB|VSS
+ sky130_fd_sc_hd__nand3_1
X$2397 VDD synth_12104 synth_12229 synth_9423 synth_12298 VDD VNB|VSS VNB|VSS
+ sky130_fd_sc_hd__nand3_1
X$2398 VDD synth_9298 synth_9133 synth_8746 synth_9295 VDD VNB|VSS VNB|VSS
+ sky130_fd_sc_hd__nand3_1
X$2399 VDD synth_7896 synth_7855 synth_7183 synth_7919 VDD VNB|VSS VNB|VSS
+ sky130_fd_sc_hd__nand3_1
X$2400 VDD synth_563 synth_561 synth_194 synth_597 VDD VNB|VSS VNB|VSS
+ sky130_fd_sc_hd__nand3_1
X$2401 VDD synth_2059 synth_2424 synth_2536 synth_2632 VDD VNB|VSS VNB|VSS
+ sky130_fd_sc_hd__nand3_1
X$2402 VDD synth_8074 synth_7969 synth_7183 synth_8073 VDD VNB|VSS VNB|VSS
+ sky130_fd_sc_hd__nand3_1
X$2403 VDD synth_9693 synth_9315 synth_8000 synth_9735 VDD VNB|VSS VNB|VSS
+ sky130_fd_sc_hd__nand3_1
X$2404 VDD synth_9072 synth_9273 synth_9337 synth_9339 VDD VNB|VSS VNB|VSS
+ sky130_fd_sc_hd__nand3_1
X$2405 VDD synth_8675 synth_7743 synth_8950 synth_8976 VDD VNB|VSS VNB|VSS
+ sky130_fd_sc_hd__nand3_1
X$2406 VDD synth_10605 synth_10606 synth_10659 synth_10658 VDD VNB|VSS VNB|VSS
+ sky130_fd_sc_hd__nand3_1
X$2407 VDD synth_7200 synth_7031 synth_7111 synth_7247 VDD VNB|VSS VNB|VSS
+ sky130_fd_sc_hd__nand3_1
X$2408 VDD synth_9072 synth_9269 synth_9087 synth_9266 VDD VNB|VSS VNB|VSS
+ sky130_fd_sc_hd__nand3_1
X$2409 VDD synth_5826 synth_5680 synth_4747 synth_5769 VDD VNB|VSS VNB|VSS
+ sky130_fd_sc_hd__nand3_1
X$2410 VDD synth_8241 synth_8240 synth_8285 synth_8218 VDD VNB|VSS VNB|VSS
+ sky130_fd_sc_hd__nand3_1
X$2411 VDD synth_8943 synth_8780 synth_8000 synth_8868 VDD VNB|VSS VNB|VSS
+ sky130_fd_sc_hd__nand3_1
X$2412 VDD synth_950 synth_835 synth_66 synth_1033 VDD VNB|VSS VNB|VSS
+ sky130_fd_sc_hd__nand3_1
X$2413 VDD synth_7026 synth_6744 synth_6597 synth_7109 VDD VNB|VSS VNB|VSS
+ sky130_fd_sc_hd__nand3_1
X$2414 VDD synth_2671 synth_2603 synth_167 synth_2810 VDD VNB|VSS VNB|VSS
+ sky130_fd_sc_hd__nand3_1
X$2415 VDD synth_8502 synth_8540 synth_8666 synth_8624 VDD VNB|VSS VNB|VSS
+ sky130_fd_sc_hd__nand3_1
X$2416 VDD synth_8238 synth_8314 synth_8703 synth_9098 VDD VNB|VSS VNB|VSS
+ sky130_fd_sc_hd__nand3_1
X$2417 VDD synth_8858 synth_8857 synth_7183 synth_8908 VDD VNB|VSS VNB|VSS
+ sky130_fd_sc_hd__nand3_1
X$2418 VDD synth_9053 synth_9054 synth_9055 synth_8504 VDD VNB|VSS VNB|VSS
+ sky130_fd_sc_hd__nand3_1
X$2419 VDD synth_8805 synth_9427 synth_9233 synth_9332 VDD VNB|VSS VNB|VSS
+ sky130_fd_sc_hd__nand3_1
X$2420 VDD synth_7172 synth_6747 synth_6597 synth_7027 VDD VNB|VSS VNB|VSS
+ sky130_fd_sc_hd__nand3_1
X$2421 VDD synth_6931 synth_6790 synth_6992 synth_6860 VDD VNB|VSS VNB|VSS
+ sky130_fd_sc_hd__nand3_1
X$2422 VDD synth_7408 synth_7260 synth_6597 synth_7333 VDD VNB|VSS VNB|VSS
+ sky130_fd_sc_hd__nand3_1
X$2423 VDD synth_8183 synth_8184 synth_8334 synth_8560 VDD VNB|VSS VNB|VSS
+ sky130_fd_sc_hd__nand3_1
X$2424 VDD synth_12584 synth_12497 synth_9423 synth_12585 VDD VNB|VSS VNB|VSS
+ sky130_fd_sc_hd__nand3_1
X$2425 VDD synth_8184 synth_8334 synth_8185 synth_8257 VDD VNB|VSS VNB|VSS
+ sky130_fd_sc_hd__nand3_1
X$2426 VDD synth_7002 synth_7100 synth_6597 synth_7021 VDD VNB|VSS VNB|VSS
+ sky130_fd_sc_hd__nand3_1
X$2427 VDD synth_9793 synth_9789 synth_8746 synth_9749 VDD VNB|VSS VNB|VSS
+ sky130_fd_sc_hd__nand3_1
X$2428 VDD synth_8085 synth_8168 synth_7111 synth_8055 VDD VNB|VSS VNB|VSS
+ sky130_fd_sc_hd__nand3_1
X$2429 VDD synth_4980 synth_5048 synth_3632 synth_5221 VDD VNB|VSS VNB|VSS
+ sky130_fd_sc_hd__nand3_1
X$2430 VDD synth_7858 synth_7835 synth_7183 synth_7923 VDD VNB|VSS VNB|VSS
+ sky130_fd_sc_hd__nand3_1
X$2431 VDD synth_12579 synth_12634 synth_9423 synth_12580 VDD VNB|VSS VNB|VSS
+ sky130_fd_sc_hd__nand3_1
X$2432 VDD synth_11584 synth_11655 synth_10164 synth_11764 VDD VNB|VSS VNB|VSS
+ sky130_fd_sc_hd__nand3_1
X$2433 VDD synth_3346 synth_3518 synth_1067 synth_3435 VDD VNB|VSS VNB|VSS
+ sky130_fd_sc_hd__nand3_1
X$2434 VDD synth_9535 synth_9489 synth_8746 synth_9534 VDD VNB|VSS VNB|VSS
+ sky130_fd_sc_hd__nand3_1
X$2435 VDD synth_5503 synth_5339 synth_3468 synth_5535 VDD VNB|VSS VNB|VSS
+ sky130_fd_sc_hd__nand3_1
X$2436 VDD synth_4375 synth_4453 synth_4042 synth_4374 VDD VNB|VSS VNB|VSS
+ sky130_fd_sc_hd__nand3_1
X$2437 VDD synth_1233 synth_1348 synth_194 synth_1072 VDD VNB|VSS VNB|VSS
+ sky130_fd_sc_hd__nand3_1
X$2438 VDD synth_8764 synth_8981 synth_10092 synth_10093 VDD VNB|VSS VNB|VSS
+ sky130_fd_sc_hd__nand3_1
X$2439 VDD synth_2961 synth_3076 synth_66 synth_3046 VDD VNB|VSS VNB|VSS
+ sky130_fd_sc_hd__nand3_1
X$2440 VDD synth_5035 synth_5165 synth_4747 synth_5198 VDD VNB|VSS VNB|VSS
+ sky130_fd_sc_hd__nand3_1
X$2441 VDD synth_9062 synth_8805 synth_8806 synth_9659 VDD VNB|VSS VNB|VSS
+ sky130_fd_sc_hd__nand3_1
X$2442 VDD synth_1289 synth_1286 synth_66 synth_1443 VDD VNB|VSS VNB|VSS
+ sky130_fd_sc_hd__nand3_1
X$2443 VDD synth_6615 synth_6575 synth_4747 synth_6630 VDD VNB|VSS VNB|VSS
+ sky130_fd_sc_hd__nand3_1
X$2444 VDD synth_8232 synth_8064 synth_7089 synth_8264 VDD VNB|VSS VNB|VSS
+ sky130_fd_sc_hd__nand3_1
X$2445 VDD synth_6167 synth_6263 synth_4961 synth_6400 VDD VNB|VSS VNB|VSS
+ sky130_fd_sc_hd__nand3_1
X$2446 VDD synth_6914 synth_7090 synth_7089 synth_7013 VDD VNB|VSS VNB|VSS
+ sky130_fd_sc_hd__nand3_1
X$2447 VDD synth_8996 synth_9052 synth_7089 synth_9051 VDD VNB|VSS VNB|VSS
+ sky130_fd_sc_hd__nand3_1
X$2448 VDD synth_5977 synth_6146 synth_3544 synth_6118 VDD VNB|VSS VNB|VSS
+ sky130_fd_sc_hd__nand3_1
X$2449 VDD synth_2460 synth_2581 synth_2116 synth_2561 VDD VNB|VSS VNB|VSS
+ sky130_fd_sc_hd__nand3_1
X$2450 VDD synth_10634 synth_10507 synth_9762 synth_10762 VDD VNB|VSS VNB|VSS
+ sky130_fd_sc_hd__nand3_1
X$2451 VDD synth_2056 synth_2052 synth_2010 synth_1886 VDD VNB|VSS VNB|VSS
+ sky130_fd_sc_hd__nand3_1
X$2452 VDD synth_4878 synth_5060 synth_3544 synth_5376 VDD VNB|VSS VNB|VSS
+ sky130_fd_sc_hd__nand3_1
X$2453 VDD synth_3395 synth_3237 synth_3468 synth_3396 VDD VNB|VSS VNB|VSS
+ sky130_fd_sc_hd__nand3_1
X$2454 VDD synth_3960 synth_4095 synth_3882 synth_3822 VDD VNB|VSS VNB|VSS
+ sky130_fd_sc_hd__nand3_1
X$2455 VDD synth_1894 synth_1823 synth_66 synth_1911 VDD VNB|VSS VNB|VSS
+ sky130_fd_sc_hd__nand3_1
X$2456 VDD synth_5128 synth_5054 synth_3541 synth_5031 VDD VNB|VSS VNB|VSS
+ sky130_fd_sc_hd__nand3_1
X$2457 VDD synth_10624 synth_10532 synth_10164 synth_10501 VDD VNB|VSS VNB|VSS
+ sky130_fd_sc_hd__nand3_1
X$2458 VDD synth_3788 synth_3587 synth_1353 synth_3721 VDD VNB|VSS VNB|VSS
+ sky130_fd_sc_hd__nand3_1
X$2459 VDD synth_4209 synth_4211 synth_927 synth_4208 VDD VNB|VSS VNB|VSS
+ sky130_fd_sc_hd__nand3_1
X$2460 VDD synth_10638 synth_10554 synth_9423 synth_10843 VDD VNB|VSS VNB|VSS
+ sky130_fd_sc_hd__nand3_1
X$2461 VDD synth_3352 synth_3353 synth_2116 synth_3448 VDD VNB|VSS VNB|VSS
+ sky130_fd_sc_hd__nand3_1
X$2462 VDD synth_3910 synth_3843 synth_927 synth_3976 VDD VNB|VSS VNB|VSS
+ sky130_fd_sc_hd__nand3_1
X$2463 VDD synth_1238 synth_1128 synth_659 synth_1237 VDD VNB|VSS VNB|VSS
+ sky130_fd_sc_hd__nand3_1
X$2464 VDD synth_2448 synth_2447 synth_1338 synth_2329 VDD VNB|VSS VNB|VSS
+ sky130_fd_sc_hd__nand3_1
X$2465 VDD synth_2107 synth_4256 synth_5098 synth_5196 VDD VNB|VSS VNB|VSS
+ sky130_fd_sc_hd__nand3_1
X$2466 VDD synth_3655 synth_3491 synth_3541 synth_3712 VDD VNB|VSS VNB|VSS
+ sky130_fd_sc_hd__nand3_1
X$2467 VDD synth_6831 synth_6830 synth_4961 synth_6762 VDD VNB|VSS VNB|VSS
+ sky130_fd_sc_hd__nand3_1
X$2468 VDD synth_5526 synth_5371 synth_3541 synth_5603 VDD VNB|VSS VNB|VSS
+ sky130_fd_sc_hd__nand3_1
X$2469 VDD synth_10323 synth_10464 synth_10461 synth_10119 VDD VNB|VSS VNB|VSS
+ sky130_fd_sc_hd__nand3_1
X$2470 VDD synth_3614 synth_3947 synth_3896 synth_3948 VDD VNB|VSS VNB|VSS
+ sky130_fd_sc_hd__nand3_1
X$2471 VDD synth_4336 synth_4427 synth_3541 synth_4544 VDD VNB|VSS VNB|VSS
+ sky130_fd_sc_hd__nand3_1
X$2472 VDD synth_10371 synth_9700 synth_9234 synth_10407 VDD VNB|VSS VNB|VSS
+ sky130_fd_sc_hd__nand3_1
X$2473 VDD synth_9677 synth_9474 synth_8870 synth_10483 VDD VNB|VSS VNB|VSS
+ sky130_fd_sc_hd__nand3_1
X$2474 VDD synth_9915 synth_10043 synth_8000 synth_9965 VDD VNB|VSS VNB|VSS
+ sky130_fd_sc_hd__nand3_1
X$2475 VDD synth_2059 synth_2190 synth_3898 synth_3823 VDD VNB|VSS VNB|VSS
+ sky130_fd_sc_hd__nand3_1
X$2476 VDD synth_11475 synth_11474 synth_11473 synth_11483 VDD VNB|VSS VNB|VSS
+ sky130_fd_sc_hd__nand3_1
X$2477 VDD synth_10340 synth_10425 synth_10164 synth_10403 VDD VNB|VSS VNB|VSS
+ sky130_fd_sc_hd__nand3_1
X$2478 VDD synth_2059 synth_2123 synth_2058 synth_2006 VDD VNB|VSS VNB|VSS
+ sky130_fd_sc_hd__nand3_1
X$2479 VDD synth_660 synth_456 synth_659 synth_846 VDD VNB|VSS VNB|VSS
+ sky130_fd_sc_hd__nand3_1
X$2480 VDD synth_2778 synth_2855 synth_659 synth_2824 VDD VNB|VSS VNB|VSS
+ sky130_fd_sc_hd__nand3_1
X$2481 VDD synth_3602 synth_3601 synth_1338 synth_3692 VDD VNB|VSS VNB|VSS
+ sky130_fd_sc_hd__nand3_1
X$2482 VDD synth_1750 synth_1754 synth_927 synth_1751 VDD VNB|VSS VNB|VSS
+ sky130_fd_sc_hd__nand3_1
X$2483 VDD synth_8803 synth_12027 synth_12221 synth_12151 VDD VNB|VSS VNB|VSS
+ sky130_fd_sc_hd__nand3_1
X$2484 VDD synth_10933 synth_10822 synth_10164 synth_10931 VDD VNB|VSS VNB|VSS
+ sky130_fd_sc_hd__nand3_1
X$2485 VDD synth_11076 synth_11073 synth_9109 synth_11147 VDD VNB|VSS VNB|VSS
+ sky130_fd_sc_hd__nand3_1
X$2486 VDD synth_4043 synth_4042 synth_4117 synth_3975 VDD VNB|VSS VNB|VSS
+ sky130_fd_sc_hd__nand3_1
X$2487 VDD synth_10814 synth_10887 synth_10164 synth_10971 VDD VNB|VSS VNB|VSS
+ sky130_fd_sc_hd__nand3_1
X$2488 VDD synth_2883 synth_2752 synth_167 synth_2989 VDD VNB|VSS VNB|VSS
+ sky130_fd_sc_hd__nand3_1
X$2489 VDD synth_2260 synth_2412 synth_659 synth_2184 VDD VNB|VSS VNB|VSS
+ sky130_fd_sc_hd__nand3_1
X$2490 VDD synth_4555 synth_4582 synth_3544 synth_4516 VDD VNB|VSS VNB|VSS
+ sky130_fd_sc_hd__nand3_1
X$2491 VDD synth_2757 synth_2912 synth_66 synth_2831 VDD VNB|VSS VNB|VSS
+ sky130_fd_sc_hd__nand3_1
X$2492 VDD synth_2356 synth_2354 synth_66 synth_2380 VDD VNB|VSS VNB|VSS
+ sky130_fd_sc_hd__nand3_1
X$2493 VDD synth_6609 synth_6642 synth_3468 synth_6554 VDD VNB|VSS VNB|VSS
+ sky130_fd_sc_hd__nand3_1
X$2494 VDD synth_10996 synth_9549 synth_11073 synth_10895 VDD VNB|VSS VNB|VSS
+ sky130_fd_sc_hd__nand3_1
X$2495 VDD synth_3916 synth_3851 synth_3541 synth_4008 VDD VNB|VSS VNB|VSS
+ sky130_fd_sc_hd__nand3_1
X$2496 VDD synth_6185 synth_5969 synth_3544 synth_6184 VDD VNB|VSS VNB|VSS
+ sky130_fd_sc_hd__nand3_1
X$2497 VDD synth_10079 synth_10043 synth_10139 synth_9890 VDD VNB|VSS VNB|VSS
+ sky130_fd_sc_hd__nand3_1
X$2498 VDD synth_5427 synth_5509 synth_4747 synth_5584 VDD VNB|VSS VNB|VSS
+ sky130_fd_sc_hd__nand3_1
X$2499 VDD synth_9868 synth_9866 synth_9783 synth_9942 VDD VNB|VSS VNB|VSS
+ sky130_fd_sc_hd__nand3_1
X$2500 VDD synth_6620 synth_6395 synth_3541 synth_6534 VDD VNB|VSS VNB|VSS
+ sky130_fd_sc_hd__nand3_1
X$2501 VDD synth_3563 synth_3594 synth_3642 synth_3595 VDD VNB|VSS VNB|VSS
+ sky130_fd_sc_hd__nand3_1
X$2502 VDD synth_4598 synth_7340 synth_7518 synth_7342 VDD VNB|VSS VNB|VSS
+ sky130_fd_sc_hd__nand3_1
X$2503 VDD synth_2446 synth_2263 synth_1338 synth_2327 VDD VNB|VSS VNB|VSS
+ sky130_fd_sc_hd__nand3_1
X$2504 VDD synth_2851 synth_2553 synth_2892 synth_2669 VDD VNB|VSS VNB|VSS
+ sky130_fd_sc_hd__nand3_1
X$2505 VDD synth_1703 synth_1579 synth_659 synth_1702 VDD VNB|VSS VNB|VSS
+ sky130_fd_sc_hd__nand3_1
X$2506 VDD synth_10087 synth_9998 synth_9762 synth_10151 VDD VNB|VSS VNB|VSS
+ sky130_fd_sc_hd__nand3_1
X$2507 VDD synth_8270 synth_8117 synth_7089 synth_8266 VDD VNB|VSS VNB|VSS
+ sky130_fd_sc_hd__nand3_1
X$2508 VDD synth_10303 synth_10428 synth_8000 synth_10359 VDD VNB|VSS VNB|VSS
+ sky130_fd_sc_hd__nand3_1
X$2509 VDD synth_5214 synth_4890 synth_3632 synth_5213 VDD VNB|VSS VNB|VSS
+ sky130_fd_sc_hd__nand3_1
X$2510 VDD synth_6427 synth_6354 synth_3541 synth_6535 VDD VNB|VSS VNB|VSS
+ sky130_fd_sc_hd__nand3_1
X$2511 VDD synth_6784 synth_6670 synth_6597 synth_6896 VDD VNB|VSS VNB|VSS
+ sky130_fd_sc_hd__nand3_1
X$2512 VDD synth_2935 synth_2895 synth_659 synth_2934 VDD VNB|VSS VNB|VSS
+ sky130_fd_sc_hd__nand3_1
X$2513 VDD synth_7124 synth_6993 synth_4961 synth_7210 VDD VNB|VSS VNB|VSS
+ sky130_fd_sc_hd__nand3_1
X$2514 VDD synth_9947 synth_10022 synth_10023 synth_10533 VDD VNB|VSS VNB|VSS
+ sky130_fd_sc_hd__nand3_1
X$2515 VDD synth_9947 synth_10519 synth_7743 synth_10520 VDD VNB|VSS VNB|VSS
+ sky130_fd_sc_hd__nand3_1
X$2516 VDD synth_447 synth_243 synth_66 synth_576 VDD VNB|VSS VNB|VSS
+ sky130_fd_sc_hd__nand3_1
X$2517 VDD synth_7913 synth_7848 synth_7089 synth_7914 VDD VNB|VSS VNB|VSS
+ sky130_fd_sc_hd__nand3_1
X$2518 VDD synth_5169 synth_5352 synth_4961 synth_5293 VDD VNB|VSS VNB|VSS
+ sky130_fd_sc_hd__nand3_1
X$2519 VDD synth_1513 synth_1271 synth_1353 synth_1510 VDD VNB|VSS VNB|VSS
+ sky130_fd_sc_hd__nand3_1
X$2520 VDD synth_2858 synth_2938 synth_1067 synth_3102 VDD VNB|VSS VNB|VSS
+ sky130_fd_sc_hd__nand3_1
X$2521 VDD synth_2712 synth_2553 synth_659 synth_2932 VDD VNB|VSS VNB|VSS
+ sky130_fd_sc_hd__nand3_1
X$2522 VDD synth_7501 synth_7340 synth_7500 synth_7587 VDD VNB|VSS VNB|VSS
+ sky130_fd_sc_hd__nand3_1
X$2523 VDD synth_9144 synth_9110 synth_9054 synth_6634 VDD VNB|VSS VNB|VSS
+ sky130_fd_sc_hd__nand3_1
X$2524 VDD synth_9063 synth_9983 synth_10170 synth_10488 VDD VNB|VSS VNB|VSS
+ sky130_fd_sc_hd__nand3_1
X$2525 VDD synth_1026 synth_1024 synth_1067 synth_1247 VDD VNB|VSS VNB|VSS
+ sky130_fd_sc_hd__nand3_1
X$2526 VDD synth_1940 synth_1730 synth_1353 synth_1885 VDD VNB|VSS VNB|VSS
+ sky130_fd_sc_hd__nand3_1
X$2527 VDD synth_7063 synth_6737 synth_6597 synth_7018 VDD VNB|VSS VNB|VSS
+ sky130_fd_sc_hd__nand3_1
X$2528 VDD synth_10889 synth_10605 synth_10948 synth_11019 VDD VNB|VSS VNB|VSS
+ sky130_fd_sc_hd__nand3_1
X$2529 VDD synth_4338 synth_4341 synth_3544 synth_4395 VDD VNB|VSS VNB|VSS
+ sky130_fd_sc_hd__nand3_1
X$2530 VDD synth_9410 synth_9365 synth_7089 synth_9492 VDD VNB|VSS VNB|VSS
+ sky130_fd_sc_hd__nand3_1
X$2531 VDD synth_4087 synth_4013 synth_1338 synth_4178 VDD VNB|VSS VNB|VSS
+ sky130_fd_sc_hd__nand3_1
X$2532 VDD synth_1809 synth_1807 synth_1353 synth_1808 VDD VNB|VSS VNB|VSS
+ sky130_fd_sc_hd__nand3_1
X$2533 VDD synth_1177 synth_1253 synth_1067 synth_1255 VDD VNB|VSS VNB|VSS
+ sky130_fd_sc_hd__nand3_1
X$2534 VDD synth_4633 synth_4813 synth_2116 synth_4839 VDD VNB|VSS VNB|VSS
+ sky130_fd_sc_hd__nand3_1
X$2535 VDD synth_10519 synth_7743 synth_10392 synth_10256 VDD VNB|VSS VNB|VSS
+ sky130_fd_sc_hd__nand3_1
X$2536 VDD synth_11478 synth_11403 synth_11477 synth_11405 VDD VNB|VSS VNB|VSS
+ sky130_fd_sc_hd__nand3_1
X$2537 VDD synth_9160 synth_10178 synth_10058 synth_10238 VDD VNB|VSS VNB|VSS
+ sky130_fd_sc_hd__nand3_1
X$2538 VDD synth_7127 synth_7128 synth_6909 synth_7272 VDD VNB|VSS VNB|VSS
+ sky130_fd_sc_hd__nand3_1
X$2539 VDD synth_4750 synth_4751 synth_167 synth_4849 VDD VNB|VSS VNB|VSS
+ sky130_fd_sc_hd__nand3_1
X$2540 VDD synth_3987 synth_3974 synth_167 synth_4053 VDD VNB|VSS VNB|VSS
+ sky130_fd_sc_hd__nand3_1
X$2541 VDD synth_12592 synth_12710 synth_9423 synth_12783 VDD VNB|VSS VNB|VSS
+ sky130_fd_sc_hd__nand3_1
X$2542 VDD synth_6710 synth_6790 synth_6597 synth_7065 VDD VNB|VSS VNB|VSS
+ sky130_fd_sc_hd__nand3_1
X$2543 VDD synth_5283 synth_5183 synth_927 synth_5178 VDD VNB|VSS VNB|VSS
+ sky130_fd_sc_hd__nand3_1
X$2544 VDD synth_3246 synth_3317 synth_167 synth_3326 VDD VNB|VSS VNB|VSS
+ sky130_fd_sc_hd__nand3_1
X$2545 VDD synth_2236 synth_4908 synth_3858 synth_4347 VDD VNB|VSS VNB|VSS
+ sky130_fd_sc_hd__nand3_1
X$2546 VDD synth_7383 synth_7434 synth_7089 synth_7771 VDD VNB|VSS VNB|VSS
+ sky130_fd_sc_hd__nand3_1
X$2547 VDD synth_7316 synth_7319 synth_7089 synth_7639 VDD VNB|VSS VNB|VSS
+ sky130_fd_sc_hd__nand3_1
X$2548 VDD synth_4663 synth_4594 synth_2116 synth_4734 VDD VNB|VSS VNB|VSS
+ sky130_fd_sc_hd__nand3_1
X$2549 VDD synth_10882 synth_10991 synth_8746 synth_10958 VDD VNB|VSS VNB|VSS
+ sky130_fd_sc_hd__nand3_1
X$2550 VDD synth_10133 synth_10072 synth_10164 synth_10332 VDD VNB|VSS VNB|VSS
+ sky130_fd_sc_hd__nand3_1
X$2551 VDD synth_7853 synth_7855 synth_7851 synth_7852 VDD VNB|VSS VNB|VSS
+ sky130_fd_sc_hd__nand3_1
X$2552 VDD synth_5994 synth_5993 synth_3468 synth_5991 VDD VNB|VSS VNB|VSS
+ sky130_fd_sc_hd__nand3_1
X$2553 VDD synth_12033 synth_12034 synth_10164 synth_12123 VDD VNB|VSS VNB|VSS
+ sky130_fd_sc_hd__nand3_1
X$2554 VDD synth_8146 synth_7787 synth_8000 synth_8081 VDD VNB|VSS VNB|VSS
+ sky130_fd_sc_hd__nand3_1
X$2555 VDD synth_2107 synth_2033 synth_2108 synth_1632 VDD VNB|VSS VNB|VSS
+ sky130_fd_sc_hd__nand3_1
X$2556 VDD synth_8787 synth_8314 synth_8311 synth_8794 VDD VNB|VSS VNB|VSS
+ sky130_fd_sc_hd__nand3_1
X$2557 VDD synth_1575 synth_1539 synth_659 synth_1698 VDD VNB|VSS VNB|VSS
+ sky130_fd_sc_hd__nand3_1
X$2558 VDD synth_2284 synth_2211 synth_66 synth_2351 VDD VNB|VSS VNB|VSS
+ sky130_fd_sc_hd__nand3_1
X$2559 VDD synth_1363 synth_1274 synth_151 synth_1441 VDD VNB|VSS VNB|VSS
+ sky130_fd_sc_hd__nand3_1
X$2560 VDD synth_2086 synth_2242 synth_66 synth_2127 VDD VNB|VSS VNB|VSS
+ sky130_fd_sc_hd__nand3_1
X$2561 VDD synth_11854 synth_11923 synth_9762 synth_11989 VDD VNB|VSS VNB|VSS
+ sky130_fd_sc_hd__nand3_1
X$2562 VDD synth_11987 synth_11891 synth_9762 synth_12136 VDD VNB|VSS VNB|VSS
+ sky130_fd_sc_hd__nand3_1
X$2563 VDD synth_10767 synth_10860 synth_9423 synth_10914 VDD VNB|VSS VNB|VSS
+ sky130_fd_sc_hd__nand3_1
X$2564 VDD synth_11243 synth_11084 synth_11081 synth_11242 VDD VNB|VSS VNB|VSS
+ sky130_fd_sc_hd__nand3_1
X$2565 VDD synth_3407 synth_3480 synth_167 synth_3406 VDD VNB|VSS VNB|VSS
+ sky130_fd_sc_hd__nand3_1
X$2566 VDD synth_519 synth_309 synth_167 synth_577 VDD VNB|VSS VNB|VSS
+ sky130_fd_sc_hd__nand3_1
X$2567 VDD synth_6520 synth_6345 synth_6597 synth_6672 VDD VNB|VSS VNB|VSS
+ sky130_fd_sc_hd__nand3_1
X$2568 VDD synth_12791 synth_12461 synth_9423 synth_12720 VDD VNB|VSS VNB|VSS
+ sky130_fd_sc_hd__nand3_1
X$2569 VDD synth_10120 synth_9987 synth_8746 synth_10162 VDD VNB|VSS VNB|VSS
+ sky130_fd_sc_hd__nand3_1
X$2570 VDD synth_8775 synth_8895 synth_8746 synth_8963 VDD VNB|VSS VNB|VSS
+ sky130_fd_sc_hd__nand3_1
X$2571 VDD synth_7591 synth_7670 synth_7214 synth_7507 VDD VNB|VSS VNB|VSS
+ sky130_fd_sc_hd__nand3_1
X$2572 VDD synth_2107 synth_6137 synth_4649 synth_6631 VDD VNB|VSS VNB|VSS
+ sky130_fd_sc_hd__nand3_1
X$2573 VDD synth_7485 synth_7486 synth_7183 synth_7487 VDD VNB|VSS VNB|VSS
+ sky130_fd_sc_hd__nand3_1
X$2574 VDD synth_8024 synth_8107 synth_8116 synth_8191 VDD VNB|VSS VNB|VSS
+ sky130_fd_sc_hd__nand3_1
X$2575 VDD synth_4749 synth_4705 synth_4747 synth_4748 VDD VNB|VSS VNB|VSS
+ sky130_fd_sc_hd__nand3_1
X$2576 VDD synth_12327 synth_12326 synth_9762 synth_12325 VDD VNB|VSS VNB|VSS
+ sky130_fd_sc_hd__nand3_1
X$2577 VDD synth_9188 synth_9187 synth_9340 synth_9258 VDD VNB|VSS VNB|VSS
+ sky130_fd_sc_hd__nand3_1
X$2578 VDD synth_10578 synth_10099 synth_8802 synth_10579 VDD VNB|VSS VNB|VSS
+ sky130_fd_sc_hd__nand3_1
X$2579 VDD synth_2492 synth_2365 synth_927 synth_2491 VDD VNB|VSS VNB|VSS
+ sky130_fd_sc_hd__nand3_1
X$2580 VDD synth_9292 synth_8981 synth_9324 synth_11651 VDD VNB|VSS VNB|VSS
+ sky130_fd_sc_hd__nand3_1
X$2581 VDD synth_12690 synth_12567 synth_12540 synth_11830 VDD VNB|VSS VNB|VSS
+ sky130_fd_sc_hd__nand3_1
X$2582 VDD synth_8574 synth_8528 synth_7089 synth_8698 VDD VNB|VSS VNB|VSS
+ sky130_fd_sc_hd__nand3_1
X$2583 VDD synth_4271 synth_4268 synth_1338 synth_4413 VDD VNB|VSS VNB|VSS
+ sky130_fd_sc_hd__nand3_1
X$2584 VDD synth_4397 synth_4743 synth_4808 synth_4392 VDD VNB|VSS VNB|VSS
+ sky130_fd_sc_hd__nand3_1
X$2585 VDD synth_6137 synth_6138 synth_6136 synth_6361 VDD VNB|VSS VNB|VSS
+ sky130_fd_sc_hd__nand3_1
X$2586 VDD synth_4424 synth_4077 synth_2116 synth_4358 VDD VNB|VSS VNB|VSS
+ sky130_fd_sc_hd__nand3_1
X$2587 VDD synth_677 synth_617 synth_151 synth_676 VDD VNB|VSS VNB|VSS
+ sky130_fd_sc_hd__nand3_1
X$2588 VDD synth_5321 synth_5155 synth_3468 synth_5257 VDD VNB|VSS VNB|VSS
+ sky130_fd_sc_hd__nand3_1
X$2589 VDD synth_6367 synth_6797 synth_6597 synth_6893 VDD VNB|VSS VNB|VSS
+ sky130_fd_sc_hd__nand3_1
X$2590 VDD synth_7988 synth_8122 synth_7089 synth_8344 VDD VNB|VSS VNB|VSS
+ sky130_fd_sc_hd__nand3_1
X$2591 VDD synth_9764 synth_9425 synth_9423 synth_9763 VDD VNB|VSS VNB|VSS
+ sky130_fd_sc_hd__nand3_1
X$2592 VDD synth_2059 synth_2123 synth_2058 synth_2249 VDD VNB|VSS VNB|VSS
+ sky130_fd_sc_hd__nand3_1
X$2593 VDD synth_5987 synth_5858 synth_3468 synth_5954 VDD VNB|VSS VNB|VSS
+ sky130_fd_sc_hd__nand3_1
X$2594 VDD synth_8458 synth_8540 synth_7089 synth_8539 VDD VNB|VSS VNB|VSS
+ sky130_fd_sc_hd__nand3_1
X$2595 VDD synth_11083 synth_11084 synth_11081 synth_11129 VDD VNB|VSS VNB|VSS
+ sky130_fd_sc_hd__nand3_1
X$2596 VDD synth_5263 synth_5262 synth_4993 synth_5268 VDD VNB|VSS VNB|VSS
+ sky130_fd_sc_hd__nand3_1
X$2597 VDD synth_9232 synth_8870 synth_9553 synth_9905 VDD VNB|VSS VNB|VSS
+ sky130_fd_sc_hd__nand3_1
X$2598 VDD synth_2105 synth_2102 synth_659 synth_2222 VDD VNB|VSS VNB|VSS
+ sky130_fd_sc_hd__nand3_1
X$2599 VDD synth_9759 synth_9610 synth_8000 synth_9732 VDD VNB|VSS VNB|VSS
+ sky130_fd_sc_hd__nand3_1
X$2600 VDD synth_8314 synth_8703 synth_8350 synth_6441 VDD VNB|VSS VNB|VSS
+ sky130_fd_sc_hd__nand3_1
X$2601 VDD synth_2107 synth_6224 synth_6292 synth_6190 VDD VNB|VSS VNB|VSS
+ sky130_fd_sc_hd__nand3_1
X$2602 VDD synth_1427 synth_1425 synth_1067 synth_1503 VDD VNB|VSS VNB|VSS
+ sky130_fd_sc_hd__nand3_1
X$2603 VDD synth_12290 synth_12289 synth_10164 synth_12321 VDD VNB|VSS VNB|VSS
+ sky130_fd_sc_hd__nand3_1
X$2604 VDD synth_2059 synth_4741 synth_4675 synth_4671 VDD VNB|VSS VNB|VSS
+ sky130_fd_sc_hd__nand3_1
X$2605 VDD synth_6393 synth_6310 synth_6693 synth_6694 VDD VNB|VSS VNB|VSS
+ sky130_fd_sc_hd__nand3_1
X$2606 VDD synth_3836 synth_3971 synth_1353 synth_4059 VDD VNB|VSS VNB|VSS
+ sky130_fd_sc_hd__nand3_1
X$2607 VDD synth_2107 synth_2125 synth_2243 synth_2400 VDD VNB|VSS VNB|VSS
+ sky130_fd_sc_hd__nand3_1
X$2608 VDD synth_2059 synth_2123 synth_2124 synth_1969 VDD VNB|VSS VNB|VSS
+ sky130_fd_sc_hd__nand3_1
X$2609 VDD synth_7397 synth_7292 synth_6597 synth_7396 VDD VNB|VSS VNB|VSS
+ sky130_fd_sc_hd__nand3_1
X$2610 VDD synth_3484 synth_3254 synth_927 synth_3577 VDD VNB|VSS VNB|VSS
+ sky130_fd_sc_hd__nand3_1
X$2611 VDD synth_2890 synth_2668 synth_927 synth_2974 VDD VNB|VSS VNB|VSS
+ sky130_fd_sc_hd__nand3_1
X$2612 VDD synth_9434 synth_9239 synth_8981 synth_11316 VDD VNB|VSS VNB|VSS
+ sky130_fd_sc_hd__nand3_1
X$2613 VDD synth_5452 synth_5382 synth_3544 synth_5451 VDD VNB|VSS VNB|VSS
+ sky130_fd_sc_hd__nand3_1
X$2614 VDD synth_10652 synth_9983 synth_10092 synth_11389 VDD VNB|VSS VNB|VSS
+ sky130_fd_sc_hd__nand3_1
X$2615 VDD synth_11266 synth_11342 synth_10164 synth_11341 VDD VNB|VSS VNB|VSS
+ sky130_fd_sc_hd__nand3_1
X$2616 VDD synth_11052 synth_11157 synth_9762 synth_11051 VDD VNB|VSS VNB|VSS
+ sky130_fd_sc_hd__nand3_1
X$2617 VDD synth_4684 synth_4758 synth_927 synth_4854 VDD VNB|VSS VNB|VSS
+ sky130_fd_sc_hd__nand3_1
X$2618 VDD synth_2499 synth_2296 synth_167 synth_2488 VDD VNB|VSS VNB|VSS
+ sky130_fd_sc_hd__nand3_1
X$2619 VDD synth_7214 synth_7215 synth_7126 synth_7131 VDD VNB|VSS VNB|VSS
+ sky130_fd_sc_hd__nand3_1
X$2620 VDD synth_6621 synth_6465 synth_4961 synth_6394 VDD VNB|VSS VNB|VSS
+ sky130_fd_sc_hd__nand3_1
X$2621 VDD synth_7530 synth_7359 synth_7183 synth_7775 VDD VNB|VSS VNB|VSS
+ sky130_fd_sc_hd__nand3_1
X$2622 VDD synth_2039 synth_1878 synth_1067 synth_2014 VDD VNB|VSS VNB|VSS
+ sky130_fd_sc_hd__nand3_1
X$2623 VDD synth_5413 synth_5225 synth_3632 synth_5497 VDD VNB|VSS VNB|VSS
+ sky130_fd_sc_hd__nand3_1
X$2624 VDD synth_440 synth_84 synth_151 synth_566 VDD VNB|VSS VNB|VSS
+ sky130_fd_sc_hd__nand3_1
X$2625 VDD synth_5998 synth_5685 synth_4961 synth_5997 VDD VNB|VSS VNB|VSS
+ sky130_fd_sc_hd__nand3_1
X$2626 VDD synth_6758 synth_6838 synth_6909 synth_6700 VDD VNB|VSS VNB|VSS
+ sky130_fd_sc_hd__nand3_1
X$2627 VDD synth_3957 synth_4017 synth_1338 synth_3936 VDD VNB|VSS VNB|VSS
+ sky130_fd_sc_hd__nand3_1
X$2628 VDD synth_9387 synth_9580 synth_9322 synth_10943 VDD VNB|VSS VNB|VSS
+ sky130_fd_sc_hd__nand3_1
X$2629 VDD synth_12721 synth_12587 synth_9423 synth_12753 VDD VNB|VSS VNB|VSS
+ sky130_fd_sc_hd__nand3_1
X$2630 VDD synth_333 synth_430 synth_194 synth_555 VDD VNB|VSS VNB|VSS
+ sky130_fd_sc_hd__nand3_1
X$2631 VDD synth_622 synth_620 synth_151 synth_681 VDD VNB|VSS VNB|VSS
+ sky130_fd_sc_hd__nand3_1
X$2632 VDD synth_2107 synth_6137 synth_6138 synth_5889 VDD VNB|VSS VNB|VSS
+ sky130_fd_sc_hd__nand3_1
X$2633 VDD synth_2107 synth_2125 synth_2190 synth_4020 VDD VNB|VSS VNB|VSS
+ sky130_fd_sc_hd__nand3_1
X$2634 VDD synth_12161 synth_12011 synth_10164 synth_12128 VDD VNB|VSS VNB|VSS
+ sky130_fd_sc_hd__nand3_1
X$2635 VDD synth_9304 synth_9405 synth_7089 synth_9406 VDD VNB|VSS VNB|VSS
+ sky130_fd_sc_hd__nand3_1
X$2636 VDD synth_9868 synth_9870 synth_9944 synth_9945 VDD VNB|VSS VNB|VSS
+ sky130_fd_sc_hd__nand3_1
X$2637 VDD synth_1717 VNB|VSS VDD VNB|VSS sky130_fd_sc_hd__clkbuf_1
X$2638 VDD synth_2465 VNB|VSS VDD VNB|VSS sky130_fd_sc_hd__clkbuf_1
X$2639 VDD synth_2201 VNB|VSS VDD VNB|VSS sky130_fd_sc_hd__clkbuf_1
X$2640 VDD synth_8413 VNB|VSS VDD VNB|VSS sky130_fd_sc_hd__clkbuf_1
X$2641 VDD synth_2208 VNB|VSS VDD VNB|VSS sky130_fd_sc_hd__clkbuf_1
X$2642 VDD synth_4541 VNB|VSS VDD VNB|VSS sky130_fd_sc_hd__clkbuf_1
X$2643 VDD synth_6950 VNB|VSS VDD VNB|VSS sky130_fd_sc_hd__clkbuf_1
X$2644 VDD synth_7190 VNB|VSS VDD VNB|VSS sky130_fd_sc_hd__clkbuf_1
X$2645 VDD synth_1423 VNB|VSS VDD VNB|VSS sky130_fd_sc_hd__clkbuf_1
X$2646 VDD synth_9912 VNB|VSS VDD VNB|VSS sky130_fd_sc_hd__clkbuf_1
X$2647 VDD synth_4836 VNB|VSS VDD VNB|VSS sky130_fd_sc_hd__clkbuf_1
X$2648 VDD synth_7334 VNB|VSS VDD VNB|VSS sky130_fd_sc_hd__clkbuf_1
X$2649 VDD synth_9986 VNB|VSS VDD VNB|VSS sky130_fd_sc_hd__clkbuf_1
X$2650 VDD synth_8928 VNB|VSS VDD VNB|VSS sky130_fd_sc_hd__clkbuf_1
X$2651 VDD synth_10025 VNB|VSS VDD VNB|VSS sky130_fd_sc_hd__clkbuf_1
X$2652 VDD synth_51 VNB|VSS VDD VNB|VSS sky130_fd_sc_hd__clkbuf_1
X$2653 VDD synth_517 VNB|VSS VDD VNB|VSS sky130_fd_sc_hd__clkbuf_1
X$2654 VDD synth_276 VNB|VSS VDD VNB|VSS sky130_fd_sc_hd__clkbuf_1
X$2655 VDD synth_521 VNB|VSS VDD VNB|VSS sky130_fd_sc_hd__clkbuf_1
X$2656 VDD synth_1518 VNB|VSS VDD VNB|VSS sky130_fd_sc_hd__clkbuf_1
X$2657 VDD synth_11527 VNB|VSS VDD VNB|VSS sky130_fd_sc_hd__clkbuf_1
X$2658 VDD synth_10802 VNB|VSS VDD VNB|VSS sky130_fd_sc_hd__clkbuf_1
X$2659 VDD synth_12024 VNB|VSS VDD VNB|VSS sky130_fd_sc_hd__clkbuf_1
X$2660 VDD synth_89 VNB|VSS VDD VNB|VSS sky130_fd_sc_hd__clkbuf_1
X$2661 VDD synth_6454 VNB|VSS VDD VNB|VSS sky130_fd_sc_hd__clkbuf_1
X$2662 VDD synth_10804 VNB|VSS VDD VNB|VSS sky130_fd_sc_hd__clkbuf_1
X$2663 VDD synth_6815 VNB|VSS VDD VNB|VSS sky130_fd_sc_hd__clkbuf_1
X$2664 VDD synth_3413 VNB|VSS VDD VNB|VSS sky130_fd_sc_hd__clkbuf_1
X$2665 VDD synth_282 VNB|VSS VDD VNB|VSS sky130_fd_sc_hd__clkbuf_1
X$2666 VDD synth_6939 VNB|VSS VDD VNB|VSS sky130_fd_sc_hd__clkbuf_1
X$2667 VDD synth_10628 VNB|VSS VDD VNB|VSS sky130_fd_sc_hd__clkbuf_1
X$2668 VDD synth_1906 VNB|VSS VDD VNB|VSS sky130_fd_sc_hd__clkbuf_1
X$2669 VDD synth_2080 VNB|VSS VDD VNB|VSS sky130_fd_sc_hd__clkbuf_1
X$2670 VDD synth_640 VNB|VSS VDD VNB|VSS sky130_fd_sc_hd__clkbuf_1
X$2671 VDD synth_7637 VNB|VSS VDD VNB|VSS sky130_fd_sc_hd__clkbuf_1
X$2672 VDD synth_571 VNB|VSS VDD VNB|VSS sky130_fd_sc_hd__clkbuf_1
X$2673 VDD synth_4422 VNB|VSS VDD VNB|VSS sky130_fd_sc_hd__clkbuf_1
X$2674 VDD synth_1872 VNB|VSS VDD VNB|VSS sky130_fd_sc_hd__clkbuf_1
X$2675 VDD synth_11846 VNB|VSS VDD VNB|VSS sky130_fd_sc_hd__clkbuf_1
X$2676 VDD synth_1149 VNB|VSS VDD VNB|VSS sky130_fd_sc_hd__clkbuf_1
X$2677 VDD synth_8082 VNB|VSS VDD VNB|VSS sky130_fd_sc_hd__clkbuf_1
X$2678 VDD synth_3043 VNB|VSS VDD VNB|VSS sky130_fd_sc_hd__clkbuf_1
X$2679 VDD synth_48 VNB|VSS VDD VNB|VSS sky130_fd_sc_hd__clkbuf_1
X$2680 VDD synth_5953 VNB|VSS VDD VNB|VSS sky130_fd_sc_hd__clkbuf_1
X$2681 VDD synth_6347 VNB|VSS VDD VNB|VSS sky130_fd_sc_hd__clkbuf_1
X$2682 VDD synth_2602 VNB|VSS VDD VNB|VSS sky130_fd_sc_hd__clkbuf_1
X$2683 VDD synth_11495 VNB|VSS VDD VNB|VSS sky130_fd_sc_hd__clkbuf_1
X$2684 VDD synth_54 VNB|VSS VDD VNB|VSS sky130_fd_sc_hd__clkbuf_1
X$2685 VDD synth_484 VNB|VSS VDD VNB|VSS sky130_fd_sc_hd__clkbuf_1
X$2686 VDD synth_3818 VNB|VSS VDD VNB|VSS sky130_fd_sc_hd__clkbuf_1
X$2687 VDD synth_1727 VNB|VSS VDD VNB|VSS sky130_fd_sc_hd__clkbuf_1
X$2688 VDD synth_2179 VNB|VSS VDD VNB|VSS sky130_fd_sc_hd__clkbuf_1
X$2689 VDD synth_8479 VNB|VSS VDD VNB|VSS sky130_fd_sc_hd__clkbuf_1
X$2690 VDD synth_1833 VNB|VSS VDD VNB|VSS sky130_fd_sc_hd__clkbuf_1
X$2691 VDD synth_8864 VNB|VSS VDD VNB|VSS sky130_fd_sc_hd__clkbuf_1
X$2692 VDD synth_10090 VNB|VSS VDD VNB|VSS sky130_fd_sc_hd__clkbuf_1
X$2693 VDD synth_8650 VNB|VSS VDD VNB|VSS sky130_fd_sc_hd__clkbuf_1
X$2694 VDD synth_8391 VNB|VSS VDD VNB|VSS sky130_fd_sc_hd__clkbuf_1
X$2695 VDD synth_6824 VNB|VSS VDD VNB|VSS sky130_fd_sc_hd__clkbuf_1
X$2696 VDD synth_10226 VNB|VSS VDD VNB|VSS sky130_fd_sc_hd__clkbuf_1
X$2697 VDD synth_568 VNB|VSS VDD VNB|VSS sky130_fd_sc_hd__clkbuf_1
X$2698 VDD synth_9760 VNB|VSS VDD VNB|VSS sky130_fd_sc_hd__clkbuf_1
X$2699 VDD synth_8778 VNB|VSS VDD VNB|VSS sky130_fd_sc_hd__clkbuf_1
X$2700 VDD synth_3462 VNB|VSS VDD VNB|VSS sky130_fd_sc_hd__clkbuf_1
X$2701 VDD synth_10616 VNB|VSS VDD VNB|VSS sky130_fd_sc_hd__clkbuf_1
X$2702 VDD synth_450 VNB|VSS VDD VNB|VSS sky130_fd_sc_hd__clkbuf_1
X$2703 VDD synth_2339 VNB|VSS VDD VNB|VSS sky130_fd_sc_hd__clkbuf_1
X$2704 VDD synth_443 VDD VNB|VSS synth_12795 VNB|VSS sky130_fd_sc_hd__clkinv_1
X$2705 VDD synth_10467 VDD VNB|VSS synth_12796 VNB|VSS sky130_fd_sc_hd__clkinv_1
X$2706 VDD synth_5008 VDD VNB|VSS synth_12797 VNB|VSS sky130_fd_sc_hd__clkinv_1
X$2707 VDD synth_4657 VDD VNB|VSS synth_12798 VNB|VSS sky130_fd_sc_hd__clkinv_1
X$2708 VDD synth_4293 VDD VNB|VSS synth_12799 VNB|VSS sky130_fd_sc_hd__clkinv_1
X$2709 VDD synth_11840 VDD VNB|VSS synth_12800 VNB|VSS sky130_fd_sc_hd__clkinv_1
X$2710 VDD synth_3247 VDD VNB|VSS synth_12801 VNB|VSS sky130_fd_sc_hd__clkinv_1
X$2711 VDD synth_446 VDD VNB|VSS synth_12802 VNB|VSS sky130_fd_sc_hd__clkinv_1
X$2712 VDD synth_1280 VDD VNB|VSS synth_12803 VNB|VSS sky130_fd_sc_hd__clkinv_1
X$2713 VDD synth_9717 VDD VNB|VSS synth_12804 VNB|VSS sky130_fd_sc_hd__clkinv_1
X$2714 VDD synth_1576 VDD VNB|VSS synth_12805 VNB|VSS sky130_fd_sc_hd__clkinv_1
X$2715 VDD synth_2468 VDD VNB|VSS synth_12806 VNB|VSS sky130_fd_sc_hd__clkinv_1
X$2716 VDD synth_5166 VDD VNB|VSS synth_12807 VNB|VSS sky130_fd_sc_hd__clkinv_1
X$2717 VDD synth_2800 VDD VNB|VSS synth_12808 VNB|VSS sky130_fd_sc_hd__clkinv_1
X$2718 VDD synth_5450 VDD VNB|VSS synth_12809 VNB|VSS sky130_fd_sc_hd__clkinv_1
X$2719 VDD synth_5082 VDD VNB|VSS synth_12810 VNB|VSS sky130_fd_sc_hd__clkinv_1
X$2720 VDD synth_840 VDD VNB|VSS synth_12811 VNB|VSS sky130_fd_sc_hd__clkinv_1
X$2721 VDD synth_9045 VDD VNB|VSS synth_12812 VNB|VSS sky130_fd_sc_hd__clkinv_1
X$2722 VDD synth_7644 VDD VNB|VSS synth_12813 VNB|VSS sky130_fd_sc_hd__clkinv_1
X$2723 VDD synth_8659 VDD VNB|VSS synth_12814 VNB|VSS sky130_fd_sc_hd__clkinv_1
X$2724 VDD synth_3221 VDD VNB|VSS synth_12815 VNB|VSS sky130_fd_sc_hd__clkinv_1
X$2725 VDD synth_6794 VDD VNB|VSS synth_12816 VNB|VSS sky130_fd_sc_hd__clkinv_1
X$2726 VDD synth_2643 VDD VNB|VSS synth_12817 VNB|VSS sky130_fd_sc_hd__clkinv_1
X$2727 VDD synth_11294 VDD VNB|VSS synth_12818 VNB|VSS sky130_fd_sc_hd__clkinv_1
X$2728 VDD synth_1265 VDD VNB|VSS synth_12819 VNB|VSS sky130_fd_sc_hd__clkinv_1
X$2729 VDD synth_2432 VDD VNB|VSS synth_12820 VNB|VSS sky130_fd_sc_hd__clkinv_1
X$2730 VDD synth_8764 VDD VNB|VSS synth_10898 VNB|VSS sky130_fd_sc_hd__clkinv_1
X$2731 VDD synth_11961 VDD VNB|VSS synth_12821 VNB|VSS sky130_fd_sc_hd__clkinv_1
X$2732 VDD synth_3806 VDD VNB|VSS synth_12822 VNB|VSS sky130_fd_sc_hd__clkinv_1
X$2733 VDD synth_11849 VDD VNB|VSS synth_12824 VNB|VSS sky130_fd_sc_hd__clkinv_1
X$2734 VDD synth_7576 VDD VNB|VSS synth_12825 VNB|VSS sky130_fd_sc_hd__clkinv_1
X$2735 VDD synth_6059 VDD VNB|VSS synth_12826 VNB|VSS sky130_fd_sc_hd__clkinv_1
X$2736 VDD synth_3263 VDD VNB|VSS synth_12827 VNB|VSS sky130_fd_sc_hd__clkinv_1
X$2737 VDD synth_9811 VDD VNB|VSS synth_12828 VNB|VSS sky130_fd_sc_hd__clkinv_1
X$2738 VDD synth_2320 VDD VNB|VSS synth_12829 VNB|VSS sky130_fd_sc_hd__clkinv_1
X$2739 VDD synth_1276 VDD VNB|VSS synth_12830 VNB|VSS sky130_fd_sc_hd__clkinv_1
X$2740 VDD synth_4575 VDD VNB|VSS synth_12831 VNB|VSS sky130_fd_sc_hd__clkinv_1
X$2741 VDD synth_6069 VDD VNB|VSS synth_12832 VNB|VSS sky130_fd_sc_hd__clkinv_1
X$2742 VDD synth_11536 VDD VNB|VSS synth_12833 VNB|VSS sky130_fd_sc_hd__clkinv_1
X$2743 VDD synth_4651 VDD VNB|VSS synth_12834 VNB|VSS sky130_fd_sc_hd__clkinv_1
X$2744 VDD synth_6241 VDD VNB|VSS synth_12835 VNB|VSS sky130_fd_sc_hd__clkinv_1
X$2745 VDD synth_5217 VDD VNB|VSS synth_12836 VNB|VSS sky130_fd_sc_hd__clkinv_1
X$2746 VDD synth_9754 VDD VNB|VSS synth_12837 VNB|VSS sky130_fd_sc_hd__clkinv_1
X$2747 VDD synth_1136 VDD VNB|VSS synth_12838 VNB|VSS sky130_fd_sc_hd__clkinv_1
X$2748 VDD synth_10143 synth_10228 synth_9891 VDD VNB|VSS VNB|VSS
+ sky130_fd_sc_hd__or2_2
X$2749 VDD synth_10636 synth_10792 synth_10635 VDD VNB|VSS VNB|VSS
+ sky130_fd_sc_hd__or2_2
X$2750 VDD synth_2870 synth_3112 synth_3111 VDD VNB|VSS VNB|VSS
+ sky130_fd_sc_hd__or2_2
X$2751 VDD synth_12511 synth_12660 synth_11658 VDD VNB|VSS VNB|VSS
+ sky130_fd_sc_hd__or2_2
X$2752 VDD synth_4478 synth_4429 synth_4303 VDD VNB|VSS VNB|VSS
+ sky130_fd_sc_hd__or2_2
X$2753 VDD synth_10214 synth_10284 synth_10229 VDD VNB|VSS VNB|VSS
+ sky130_fd_sc_hd__or2_2
X$2754 VDD synth_7562 synth_7561 synth_7250 VDD VNB|VSS VNB|VSS
+ sky130_fd_sc_hd__or2_2
X$2755 VDD synth_1254 synth_1257 synth_1506 VDD VNB|VSS VNB|VSS
+ sky130_fd_sc_hd__or2_2
X$2756 VDD synth_3481 synth_3661 synth_3772 VDD VNB|VSS VNB|VSS
+ sky130_fd_sc_hd__or2_2
X$2757 VDD synth_7320 synth_7441 synth_7094 VDD VNB|VSS VNB|VSS
+ sky130_fd_sc_hd__or2_2
X$2758 VDD synth_2265 synth_2307 synth_2420 VDD VNB|VSS VNB|VSS
+ sky130_fd_sc_hd__or2_2
X$2759 VDD synth_1875 synth_1794 synth_1630 VDD VNB|VSS VNB|VSS
+ sky130_fd_sc_hd__or2_2
X$2760 VDD synth_1707 synth_1944 synth_1912 synth_2033 synth_2034 VDD VNB|VSS
+ VNB|VSS sky130_fd_sc_hd__o211ai_1
X$2761 VDD synth_1504 synth_1470 synth_1615 VDD VNB|VSS VNB|VSS
+ sky130_fd_sc_hd__or2_2
X$2762 VDD synth_7989 synth_8154 synth_7146 VDD VNB|VSS VNB|VSS
+ sky130_fd_sc_hd__or2_2
X$2763 VDD synth_12583 synth_12520 synth_12043 VDD VNB|VSS VNB|VSS
+ sky130_fd_sc_hd__or2_2
X$2764 VDD synth_11848 synth_11957 synth_11768 VDD VNB|VSS VNB|VSS
+ sky130_fd_sc_hd__or2_2
X$2765 VDD synth_7321 synth_7567 synth_7255 VDD VNB|VSS VNB|VSS
+ sky130_fd_sc_hd__or2_2
X$2766 VDD synth_5170 synth_5274 synth_4615 VDD VNB|VSS VNB|VSS
+ sky130_fd_sc_hd__or2_2
X$2767 VDD synth_7915 synth_8069 synth_8156 VDD VNB|VSS VNB|VSS
+ sky130_fd_sc_hd__or2_2
X$2768 VDD synth_8196 synth_8812 synth_8768 VDD VNB|VSS VNB|VSS
+ sky130_fd_sc_hd__or2_2
X$2769 VDD synth_11006 synth_11246 synth_11215 VDD VNB|VSS VNB|VSS
+ sky130_fd_sc_hd__or2_2
X$2770 VDD synth_5624 synth_5628 synth_5026 VDD VNB|VSS VNB|VSS
+ sky130_fd_sc_hd__or2_2
X$2771 VDD synth_9677 synth_9474 synth_10344 VDD VNB|VSS VNB|VSS
+ sky130_fd_sc_hd__or2_2
X$2772 VDD synth_8196 synth_8259 synth_8109 VDD VNB|VSS VNB|VSS
+ sky130_fd_sc_hd__or2_2
X$2773 VDD synth_7011 synth_7015 synth_6018 VDD VNB|VSS VNB|VSS
+ sky130_fd_sc_hd__or2_2
X$2774 VDD synth_5947 synth_6079 synth_5856 VDD VNB|VSS VNB|VSS
+ sky130_fd_sc_hd__or2_2
X$2775 VDD synth_4354 synth_4420 synth_4330 VDD VNB|VSS VNB|VSS
+ sky130_fd_sc_hd__or2_2
X$2776 VDD synth_2959 synth_3047 synth_3118 VDD VNB|VSS VNB|VSS
+ sky130_fd_sc_hd__or2_2
X$2777 VDD synth_11947 synth_12068 synth_11699 VDD VNB|VSS VNB|VSS
+ sky130_fd_sc_hd__or2_2
X$2778 VDD synth_3030 synth_3029 synth_2723 VDD VNB|VSS VNB|VSS
+ sky130_fd_sc_hd__or2_2
X$2779 VDD synth_831 synth_996 synth_997 VDD VNB|VSS VNB|VSS
+ sky130_fd_sc_hd__or2_2
X$2780 VDD synth_10793 synth_8870 synth_9900 VDD VNB|VSS VNB|VSS
+ sky130_fd_sc_hd__or2_2
X$2781 VDD synth_10064 synth_10224 synth_9910 VDD VNB|VSS VNB|VSS
+ sky130_fd_sc_hd__or2_2
X$2782 VDD synth_366 synth_502 synth_431 VDD VNB|VSS VNB|VSS
+ sky130_fd_sc_hd__or2_2
X$2783 VDD synth_5406 synth_5780 synth_5776 VDD VNB|VSS VNB|VSS
+ sky130_fd_sc_hd__or2_2
X$2784 VDD synth_5665 synth_5740 synth_5808 VDD VNB|VSS VNB|VSS
+ sky130_fd_sc_hd__or2_2
X$2785 VDD synth_199 synth_499 synth_426 VDD VNB|VSS VNB|VSS
+ sky130_fd_sc_hd__or2_2
X$2786 VDD synth_8830 synth_8933 synth_8854 VDD VNB|VSS VNB|VSS
+ sky130_fd_sc_hd__or2_2
X$2787 VDD synth_9302 synth_9455 synth_9300 VDD VNB|VSS VNB|VSS
+ sky130_fd_sc_hd__or2_2
X$2788 VDD synth_6153 synth_6300 synth_6049 VDD VNB|VSS VNB|VSS
+ sky130_fd_sc_hd__or2_2
X$2789 VDD synth_9712 synth_9752 synth_9459 VDD VNB|VSS VNB|VSS
+ sky130_fd_sc_hd__or2_2
X$2790 VDD synth_9629 synth_8831 synth_10104 VDD VNB|VSS VNB|VSS
+ sky130_fd_sc_hd__or2_2
X$2791 VDD synth_7666 synth_7744 synth_7416 VDD VNB|VSS VNB|VSS
+ sky130_fd_sc_hd__or2_2
X$2792 VDD synth_7081 synth_7104 synth_7191 VDD VNB|VSS VNB|VSS
+ sky130_fd_sc_hd__or2_2
X$2793 VDD synth_4104 synth_4030 synth_4194 VDD VNB|VSS VNB|VSS
+ sky130_fd_sc_hd__or2_2
X$2794 VDD synth_826 synth_1047 synth_991 VDD VNB|VSS VNB|VSS
+ sky130_fd_sc_hd__or2_2
X$2795 VDD synth_8287 synth_8329 synth_7545 VDD VNB|VSS VNB|VSS
+ sky130_fd_sc_hd__or2_2
X$2796 VDD synth_9918 synth_9920 synth_9757 VDD VNB|VSS VNB|VSS
+ sky130_fd_sc_hd__or2_2
X$2797 VDD synth_11452 synth_11451 synth_11307 VDD VNB|VSS VNB|VSS
+ sky130_fd_sc_hd__or2_2
X$2798 VDD synth_1374 synth_1296 synth_1449 VDD VNB|VSS VNB|VSS
+ sky130_fd_sc_hd__or2_2
X$2799 VDD synth_5428 synth_5426 synth_5161 VDD VNB|VSS VNB|VSS
+ sky130_fd_sc_hd__or2_2
X$2800 VDD synth_11031 synth_11033 synth_11143 VDD VNB|VSS VNB|VSS
+ sky130_fd_sc_hd__or2_2
X$2801 VDD synth_8196 synth_8956 synth_10952 VDD VNB|VSS VNB|VSS
+ sky130_fd_sc_hd__or2_2
X$2802 VDD synth_6640 synth_6741 synth_6596 VDD VNB|VSS VNB|VSS
+ sky130_fd_sc_hd__or2_2
X$2803 VDD synth_3828 synth_3997 synth_3942 VDD VNB|VSS VNB|VSS
+ sky130_fd_sc_hd__or2_2
X$2804 VDD synth_8621 synth_8727 synth_7142 VDD VNB|VSS VNB|VSS
+ sky130_fd_sc_hd__or2_2
X$2805 VDD synth_1294 synth_1373 synth_1031 VDD VNB|VSS VNB|VSS
+ sky130_fd_sc_hd__or2_2
X$2806 VDD synth_9474 synth_8831 synth_9233 VDD VNB|VSS VNB|VSS
+ sky130_fd_sc_hd__or2_2
X$2807 VDD synth_7327 synth_7403 synth_7488 VDD VNB|VSS VNB|VSS
+ sky130_fd_sc_hd__or2_2
X$2808 VDD synth_5552 synth_5605 synth_5485 VDD VNB|VSS VNB|VSS
+ sky130_fd_sc_hd__or2_2
X$2809 VDD synth_9272 synth_9495 synth_9305 VDD VNB|VSS VNB|VSS
+ sky130_fd_sc_hd__or2_2
X$2810 VDD synth_3040 synth_2872 synth_2951 VDD VNB|VSS VNB|VSS
+ sky130_fd_sc_hd__or2_2
X$2811 VDD synth_2486 synth_2504 synth_2545 VDD VNB|VSS VNB|VSS
+ sky130_fd_sc_hd__or2_2
X$2812 VDD synth_838 synth_924 synth_941 VDD VNB|VSS VNB|VSS
+ sky130_fd_sc_hd__or2_2
X$2813 VDD synth_8904 synth_9098 synth_9308 VDD VNB|VSS VNB|VSS
+ sky130_fd_sc_hd__or2_2
X$2814 VDD synth_8873 synth_8765 synth_9101 VDD VNB|VSS VNB|VSS
+ sky130_fd_sc_hd__or2_2
X$2815 VDD synth_9947 synth_10455 synth_10530 VDD VNB|VSS VNB|VSS
+ sky130_fd_sc_hd__or2_2
X$2816 VDD synth_1587 synth_1781 synth_1817 VDD VNB|VSS VNB|VSS
+ sky130_fd_sc_hd__or2_2
X$2817 VDD synth_8198 synth_8309 synth_7910 VDD VNB|VSS VNB|VSS
+ sky130_fd_sc_hd__or2_2
X$2818 VDD synth_2806 synth_2881 synth_2969 VDD VNB|VSS VNB|VSS
+ sky130_fd_sc_hd__or2_2
X$2819 VDD synth_2323 synth_2415 synth_2466 VDD VNB|VSS VNB|VSS
+ sky130_fd_sc_hd__or2_2
X$2820 VDD synth_9988 synth_10131 synth_9808 VDD VNB|VSS VNB|VSS
+ sky130_fd_sc_hd__or2_2
X$2821 VDD synth_2109 synth_2236 synth_2386 VDD VNB|VSS VNB|VSS
+ sky130_fd_sc_hd__or2_2
X$2822 VDD synth_2664 synth_2896 synth_2884 VDD VNB|VSS VNB|VSS
+ sky130_fd_sc_hd__or2_2
X$2823 VDD synth_1533 synth_1592 synth_1527 VDD VNB|VSS VNB|VSS
+ sky130_fd_sc_hd__or2_2
X$2824 VDD synth_930 synth_928 synth_1021 VDD VNB|VSS VNB|VSS
+ sky130_fd_sc_hd__or2_2
X$2825 VDD synth_12466 synth_12524 synth_12274 VDD VNB|VSS VNB|VSS
+ sky130_fd_sc_hd__or2_2
X$2826 VDD synth_8860 synth_8935 synth_8859 VDD VNB|VSS VNB|VSS
+ sky130_fd_sc_hd__or2_2
X$2827 VDD synth_12213 synth_12210 synth_11574 VDD VNB|VSS VNB|VSS
+ sky130_fd_sc_hd__or2_2
X$2828 VDD synth_2718 synth_2909 synth_2646 VDD VNB|VSS VNB|VSS
+ sky130_fd_sc_hd__or2_2
X$2829 VDD synth_1434 synth_1488 synth_1557 VDD VNB|VSS VNB|VSS
+ sky130_fd_sc_hd__or2_2
X$2830 VDD synth_2780 synth_2681 synth_2937 VDD VNB|VSS VNB|VSS
+ sky130_fd_sc_hd__or2_2
X$2831 VDD synth_11921 synth_11965 synth_11567 VDD VNB|VSS VNB|VSS
+ sky130_fd_sc_hd__or2_2
X$2832 VDD synth_8682 synth_8735 synth_8677 VDD VNB|VSS VNB|VSS
+ sky130_fd_sc_hd__or2_2
X$2833 VDD synth_6469 synth_8889 synth_8815 VDD VNB|VSS VNB|VSS
+ sky130_fd_sc_hd__or2_2
X$2834 VDD synth_7400 synth_7467 synth_7652 VDD VNB|VSS VNB|VSS
+ sky130_fd_sc_hd__or2_2
X$2835 VDD synth_10531 synth_10563 synth_10703 VDD VNB|VSS VNB|VSS
+ sky130_fd_sc_hd__or2_2
X$2836 VDD synth_8196 synth_8769 synth_9873 VDD VNB|VSS VNB|VSS
+ sky130_fd_sc_hd__or2_2
X$2837 VDD synth_5010 synth_5107 synth_4913 VDD VNB|VSS VNB|VSS
+ sky130_fd_sc_hd__or2_2
X$2838 VDD synth_7582 synth_7701 synth_7305 VDD VNB|VSS VNB|VSS
+ sky130_fd_sc_hd__or2_2
X$2839 VDD synth_2429 synth_2698 synth_2802 VDD VNB|VSS VNB|VSS
+ sky130_fd_sc_hd__or2_2
X$2840 VDD synth_773 synth_938 synth_1170 VDD VNB|VSS VNB|VSS
+ sky130_fd_sc_hd__or2_2
X$2841 VDD synth_8196 synth_8811 synth_9186 VDD VNB|VSS VNB|VSS
+ sky130_fd_sc_hd__or2_2
X$2842 VDD synth_8196 synth_8887 synth_11022 VDD VNB|VSS VNB|VSS
+ sky130_fd_sc_hd__or2_2
X$2843 VDD synth_8471 synth_8552 synth_8384 VDD VNB|VSS VNB|VSS
+ sky130_fd_sc_hd__or2_2
X$2844 VDD synth_2509 synth_2507 synth_2641 VDD VNB|VSS VNB|VSS
+ sky130_fd_sc_hd__or2_2
X$2845 VDD synth_7938 synth_8009 synth_7309 VDD VNB|VSS VNB|VSS
+ sky130_fd_sc_hd__or2_2
X$2846 VDD synth_6818 synth_6821 synth_6683 VDD VNB|VSS VNB|VSS
+ sky130_fd_sc_hd__or2_2
X$2847 VDD synth_7922 synth_7856 synth_7897 VDD VNB|VSS VNB|VSS
+ sky130_fd_sc_hd__or2_2
X$2848 VDD synth_2722 synth_2694 synth_2695 VDD VNB|VSS VNB|VSS
+ sky130_fd_sc_hd__or2_2
X$2849 VDD synth_6007 synth_6004 synth_5570 VDD VNB|VSS VNB|VSS
+ sky130_fd_sc_hd__or2_2
X$2850 VDD synth_2021 synth_2118 synth_2192 VDD VNB|VSS VNB|VSS
+ sky130_fd_sc_hd__or2_2
X$2851 VDD synth_5897 synth_5983 synth_4803 VDD VNB|VSS VNB|VSS
+ sky130_fd_sc_hd__or2_2
X$2852 VDD synth_8806 synth_8831 synth_9615 VDD VNB|VSS VNB|VSS
+ sky130_fd_sc_hd__or2_2
X$2853 VDD synth_4922 synth_4924 synth_4796 VDD VNB|VSS VNB|VSS
+ sky130_fd_sc_hd__or2_2
X$2854 VDD synth_358 synth_628 synth_451 VDD VNB|VSS VNB|VSS
+ sky130_fd_sc_hd__or2_2
X$2855 VDD synth_11856 synth_11925 synth_11922 VDD VNB|VSS VNB|VSS
+ sky130_fd_sc_hd__or2_2
X$2856 VDD synth_3300 synth_3513 synth_2625 VDD VNB|VSS VNB|VSS
+ sky130_fd_sc_hd__or2_2
X$2857 VDD synth_3464 synth_3466 synth_3463 VDD VNB|VSS VNB|VSS
+ sky130_fd_sc_hd__or2_2
X$2858 VDD synth_4829 synth_5038 synth_5100 VDD VNB|VSS VNB|VSS
+ sky130_fd_sc_hd__or2_2
X$2859 VDD synth_7392 synth_7391 synth_7289 VDD VNB|VSS VNB|VSS
+ sky130_fd_sc_hd__or2_2
X$2860 VDD synth_2540 synth_2406 synth_2276 VDD VNB|VSS VNB|VSS
+ sky130_fd_sc_hd__or2_2
X$2861 VDD synth_11368 synth_11367 synth_11364 VDD VNB|VSS VNB|VSS
+ sky130_fd_sc_hd__or2_2
X$2862 VDD synth_7939 synth_8090 synth_7759 VDD VNB|VSS VNB|VSS
+ sky130_fd_sc_hd__or2_2
X$2863 VDD synth_1199 synth_1300 synth_1378 VDD VNB|VSS VNB|VSS
+ sky130_fd_sc_hd__or2_2
X$2864 VDD synth_6637 synth_6821 synth_6823 VDD VNB|VSS VNB|VSS
+ sky130_fd_sc_hd__or2_2
X$2865 VDD synth_10415 synth_8764 synth_10308 synth_10483 synth_10231 VNB|VSS
+ VDD VNB|VSS sky130_fd_sc_hd__o22ai_1
X$2866 VDD synth_4751 synth_581 synth_4622 synth_4620 synth_4698 VNB|VSS VDD
+ VNB|VSS sky130_fd_sc_hd__o22ai_1
X$2867 VDD synth_12437 synth_9691 synth_12383 synth_12266 synth_12354 VNB|VSS
+ VDD VNB|VSS sky130_fd_sc_hd__o22ai_1
X$2868 VDD synth_9049 synth_12587 synth_12445 synth_12588 synth_12754 VNB|VSS
+ VDD VNB|VSS sky130_fd_sc_hd__o22ai_1
X$2869 VDD synth_6476 synth_7090 synth_7088 synth_7011 synth_7181 VNB|VSS VDD
+ VNB|VSS sky130_fd_sc_hd__o22ai_1
X$2870 VDD synth_8168 synth_6211 synth_8084 synth_8170 synth_8083 VNB|VSS VDD
+ VNB|VSS sky130_fd_sc_hd__o22ai_1
X$2871 VDD synth_1213 synth_1425 synth_1391 synth_1504 synth_1424 VNB|VSS VDD
+ VNB|VSS sky130_fd_sc_hd__o22ai_1
X$2872 VDD synth_346 synth_45 synth_437 synth_141 synth_490 VNB|VSS VDD VNB|VSS
+ sky130_fd_sc_hd__o22ai_1
X$2873 VDD synth_7435 synth_7855 synth_7369 synth_7696 synth_7971 VNB|VSS VDD
+ VNB|VSS sky130_fd_sc_hd__o22ai_1
X$2874 VDD synth_6712 synth_6443 synth_6361 synth_6293 synth_6362 VNB|VSS VDD
+ VNB|VSS sky130_fd_sc_hd__o22ai_1
X$2875 VDD synth_3392 synth_1081 synth_3391 synth_3087 synth_3538 VNB|VSS VDD
+ VNB|VSS sky130_fd_sc_hd__o22ai_1
X$2876 VDD synth_1909 synth_2036 synth_2081 synth_2109 synth_2232 VNB|VSS VDD
+ VNB|VSS sky130_fd_sc_hd__o22ai_1
X$2877 VDD synth_309 synth_408 synth_466 synth_106 synth_467 VNB|VSS VDD
+ VNB|VSS sky130_fd_sc_hd__o22ai_1
X$2878 VDD synth_5685 synth_581 synth_5914 synth_5759 synth_5932 VNB|VSS VDD
+ VNB|VSS sky130_fd_sc_hd__o22ai_1
X$2879 VDD synth_3076 synth_1081 synth_2918 synth_2959 synth_3002 VNB|VSS VDD
+ VNB|VSS sky130_fd_sc_hd__o22ai_1
X$2880 VDD synth_6476 synth_6354 synth_6173 synth_6429 synth_6397 VNB|VSS VDD
+ VNB|VSS sky130_fd_sc_hd__o22ai_1
X$2881 VDD synth_1081 synth_3237 synth_3236 synth_3015 synth_3394 VNB|VSS VDD
+ VNB|VSS sky130_fd_sc_hd__o22ai_1
X$2882 VDD synth_850 synth_4582 synth_4514 synth_4583 synth_4513 VNB|VSS VDD
+ VNB|VSS sky130_fd_sc_hd__o22ai_1
X$2883 VDD synth_850 synth_3491 synth_3542 synth_3364 synth_3452 VNB|VSS VDD
+ VNB|VSS sky130_fd_sc_hd__o22ai_1
X$2884 VDD synth_10507 synth_9691 synth_10613 synth_10504 synth_10633 VNB|VSS
+ VDD VNB|VSS sky130_fd_sc_hd__o22ai_1
X$2885 VDD synth_10425 synth_8230 synth_10263 synth_10265 synth_10337 VNB|VSS
+ VDD VNB|VSS sky130_fd_sc_hd__o22ai_1
X$2886 VDD synth_3317 synth_408 synth_3123 synth_3197 synth_3245 VNB|VSS VDD
+ VNB|VSS sky130_fd_sc_hd__o22ai_1
X$2887 VDD synth_408 synth_2354 synth_2287 synth_2486 synth_2355 VNB|VSS VDD
+ VNB|VSS sky130_fd_sc_hd__o22ai_1
X$2888 VDD synth_2912 synth_408 synth_2682 synth_2879 synth_2759 VNB|VSS VDD
+ VNB|VSS sky130_fd_sc_hd__o22ai_1
X$2889 VDD synth_7435 synth_7319 synth_7513 synth_7318 synth_7474 VNB|VSS VDD
+ VNB|VSS sky130_fd_sc_hd__o22ai_1
X$2890 VDD synth_1274 synth_346 synth_1416 synth_1361 synth_1440 VNB|VSS VDD
+ VNB|VSS sky130_fd_sc_hd__o22ai_1
X$2891 VDD synth_7435 synth_7969 synth_8072 synth_7995 synth_8162 VNB|VSS VDD
+ VNB|VSS sky130_fd_sc_hd__o22ai_1
X$2892 VDD synth_243 synth_408 synth_448 synth_171 synth_400 VNB|VSS VDD
+ VNB|VSS sky130_fd_sc_hd__o22ai_1
X$2893 VDD synth_474 synth_3220 synth_3155 synth_3109 synth_3110 VNB|VSS VDD
+ VNB|VSS sky130_fd_sc_hd__o22ai_1
X$2894 VDD synth_10866 synth_10652 synth_10977 synth_10212 synth_10868 VNB|VSS
+ VDD VNB|VSS sky130_fd_sc_hd__o22ai_1
X$2895 VDD synth_5286 synth_5371 synth_5602 synth_5552 synth_5698 VNB|VSS VDD
+ VNB|VSS sky130_fd_sc_hd__o22ai_1
X$2896 VDD synth_6476 synth_6395 synth_6533 synth_6425 synth_6567 VNB|VSS VDD
+ VNB|VSS sky130_fd_sc_hd__o22ai_1
X$2897 VDD synth_850 synth_5060 synth_5201 synth_4829 synth_5133 VNB|VSS VDD
+ VNB|VSS sky130_fd_sc_hd__o22ai_1
X$2898 VDD synth_5165 synth_581 synth_5164 synth_5086 synth_5200 VNB|VSS VDD
+ VNB|VSS sky130_fd_sc_hd__o22ai_1
X$2899 VDD synth_5286 synth_7100 synth_7020 synth_7081 synth_7099 VNB|VSS VDD
+ VNB|VSS sky130_fd_sc_hd__o22ai_1
X$2900 VDD synth_4705 synth_581 synth_5037 synth_4795 synth_4940 VNB|VSS VDD
+ VNB|VSS sky130_fd_sc_hd__o22ai_1
X$2901 VDD synth_9297 synth_10887 synth_10815 synth_10886 synth_10970 VNB|VSS
+ VDD VNB|VSS sky130_fd_sc_hd__o22ai_1
X$2902 VDD synth_11655 synth_9297 synth_11653 synth_11654 synth_11734 VNB|VSS
+ VDD VNB|VSS sky130_fd_sc_hd__o22ai_1
X$2903 VDD synth_12305 synth_11934 synth_9851 synth_10312 synth_12241 VNB|VSS
+ VDD VNB|VSS sky130_fd_sc_hd__o22ai_1
X$2904 VDD synth_850 synth_4887 synth_5135 synth_5010 synth_5207 VNB|VSS VDD
+ VNB|VSS sky130_fd_sc_hd__o22ai_1
X$2905 VDD synth_1213 synth_1024 synth_946 synth_807 synth_1158 VNB|VSS VDD
+ VNB|VSS sky130_fd_sc_hd__o22ai_1
X$2906 VDD synth_9297 synth_9365 synth_9364 synth_9272 synth_9457 VNB|VSS VDD
+ VNB|VSS sky130_fd_sc_hd__o22ai_1
X$2907 VDD synth_8981 synth_9292 synth_9239 synth_8764 synth_9512 VNB|VSS VDD
+ VNB|VSS sky130_fd_sc_hd__o22ai_1
X$2908 VDD synth_474 synth_4077 synth_4278 synth_4098 synth_4251 VNB|VSS VDD
+ VNB|VSS sky130_fd_sc_hd__o22ai_1
X$2909 VDD synth_5286 synth_6146 synth_5975 synth_6067 synth_5976 VNB|VSS VDD
+ VNB|VSS sky130_fd_sc_hd__o22ai_1
X$2910 VDD synth_11015 synth_9117 synth_10984 synth_9101 synth_11018 VNB|VSS
+ VDD VNB|VSS sky130_fd_sc_hd__o22ai_1
X$2911 VDD synth_9207 synth_9101 synth_9176 synth_9117 synth_9099 VNB|VSS VDD
+ VNB|VSS sky130_fd_sc_hd__o22ai_1
X$2912 VDD synth_9567 synth_8764 synth_9323 synth_8604 synth_9326 VNB|VSS VDD
+ VNB|VSS sky130_fd_sc_hd__o22ai_1
X$2913 VDD synth_2296 synth_408 synth_2359 synth_2290 synth_2445 VNB|VSS VDD
+ VNB|VSS sky130_fd_sc_hd__o22ai_1
X$2914 VDD synth_296 synth_581 synth_579 synth_164 synth_459 VNB|VSS VDD
+ VNB|VSS sky130_fd_sc_hd__o22ai_1
X$2915 VDD synth_5286 synth_6670 synth_6895 synth_6721 synth_6943 VNB|VSS VDD
+ VNB|VSS sky130_fd_sc_hd__o22ai_1
X$2916 VDD synth_12034 synth_9297 synth_11947 synth_12100 synth_12188 VNB|VSS
+ VDD VNB|VSS sky130_fd_sc_hd__o22ai_1
X$2917 VDD synth_5183 synth_581 synth_5177 synth_5173 synth_5175 VNB|VSS VDD
+ VNB|VSS sky130_fd_sc_hd__o22ai_1
X$2918 VDD synth_5286 synth_6526 synth_6785 synth_6527 synth_6805 VNB|VSS VDD
+ VNB|VSS sky130_fd_sc_hd__o22ai_1
X$2919 VDD synth_9048 synth_9240 synth_8948 synth_9233 synth_9202 VNB|VSS VDD
+ VNB|VSS sky130_fd_sc_hd__o22ai_1
X$2920 VDD synth_224 synth_346 synth_486 synth_321 synth_592 VNB|VSS VDD
+ VNB|VSS sky130_fd_sc_hd__o22ai_1
X$2921 VDD synth_5286 synth_5382 synth_5381 synth_5491 synth_5403 VNB|VSS VDD
+ VNB|VSS sky130_fd_sc_hd__o22ai_1
X$2922 VDD synth_9297 synth_11342 synth_11295 synth_11368 synth_11366 VNB|VSS
+ VDD VNB|VSS sky130_fd_sc_hd__o22ai_1
X$2923 VDD synth_9297 synth_9789 synth_9878 synth_9712 synth_9955 VNB|VSS VDD
+ VNB|VSS sky130_fd_sc_hd__o22ai_1
X$2924 VDD synth_1878 synth_1213 synth_1879 synth_1952 synth_1877 VNB|VSS VDD
+ VNB|VSS sky130_fd_sc_hd__o22ai_1
X$2925 VDD synth_7435 synth_7835 synth_7975 synth_7922 synth_8054 VNB|VSS VDD
+ VNB|VSS sky130_fd_sc_hd__o22ai_1
X$2926 VDD synth_9133 synth_9297 synth_9294 synth_9161 synth_9352 VNB|VSS VDD
+ VNB|VSS sky130_fd_sc_hd__o22ai_1
X$2927 VDD synth_3527 synth_4013 synth_4063 synth_4012 synth_4144 VNB|VSS VDD
+ VNB|VSS sky130_fd_sc_hd__o22ai_1
X$2928 VDD synth_9049 synth_12497 synth_12143 synth_12583 synth_12641 VNB|VSS
+ VDD VNB|VSS sky130_fd_sc_hd__o22ai_1
X$2929 VDD synth_1213 synth_868 synth_1175 synth_1069 synth_1249 VNB|VSS VDD
+ VNB|VSS sky130_fd_sc_hd__o22ai_1
X$2930 VDD synth_850 synth_1539 synth_1574 synth_1625 synth_1573 VNB|VSS VDD
+ VNB|VSS sky130_fd_sc_hd__o22ai_1
X$2931 VDD synth_2938 synth_1213 synth_2990 synth_2718 synth_2939 VNB|VSS VDD
+ VNB|VSS sky130_fd_sc_hd__o22ai_1
X$2932 VDD synth_8230 synth_8117 synth_8233 synth_8198 synth_8305 VNB|VSS VDD
+ VNB|VSS sky130_fd_sc_hd__o22ai_1
X$2933 VDD synth_6465 synth_581 synth_6385 synth_6482 synth_6479 VNB|VSS VDD
+ VNB|VSS sky130_fd_sc_hd__o22ai_1
X$2934 VDD synth_11898 synth_10652 synth_11894 synth_10212 synth_11817 VNB|VSS
+ VDD VNB|VSS sky130_fd_sc_hd__o22ai_1
X$2935 VDD synth_850 synth_1128 synth_1014 synth_972 synth_1127 VNB|VSS VDD
+ VNB|VSS sky130_fd_sc_hd__o22ai_1
X$2936 VDD synth_8230 synth_8857 synth_8594 synth_8860 synth_8982 VNB|VSS VDD
+ VNB|VSS sky130_fd_sc_hd__o22ai_1
X$2937 VDD synth_9049 synth_12710 synth_12451 synth_12466 synth_12652 VNB|VSS
+ VDD VNB|VSS sky130_fd_sc_hd__o22ai_1
X$2938 VDD synth_6830 synth_581 synth_6756 synth_6829 synth_6757 VNB|VSS VDD
+ VNB|VSS sky130_fd_sc_hd__o22ai_1
X$2939 VDD synth_4813 synth_474 synth_4738 synth_4637 synth_4668 VNB|VSS VDD
+ VNB|VSS sky130_fd_sc_hd__o22ai_1
X$2940 VDD synth_9297 synth_9489 synth_9398 synth_9532 synth_9401 VNB|VSS VDD
+ VNB|VSS sky130_fd_sc_hd__o22ai_1
X$2941 VDD synth_850 synth_5744 synth_5742 synth_5649 synth_5875 VNB|VSS VDD
+ VNB|VSS sky130_fd_sc_hd__o22ai_1
X$2942 VDD synth_1807 synth_346 synth_1936 synth_1961 synth_1806 VNB|VSS VDD
+ VNB|VSS sky130_fd_sc_hd__o22ai_1
X$2943 VDD synth_9049 synth_12461 synth_12519 synth_12443 synth_12719 VNB|VSS
+ VDD VNB|VSS sky130_fd_sc_hd__o22ai_1
X$2944 VDD synth_10554 synth_9049 synth_10508 synth_10636 synth_10639 VNB|VSS
+ VDD VNB|VSS sky130_fd_sc_hd__o22ai_1
X$2945 VDD synth_5680 synth_581 synth_5642 synth_5709 synth_6027 VNB|VSS VDD
+ VNB|VSS sky130_fd_sc_hd__o22ai_1
X$2946 VDD synth_3964 synth_5993 synth_6038 synth_6161 synth_6159 VNB|VSS VDD
+ VNB|VSS sky130_fd_sc_hd__o22ai_1
X$2947 VDD synth_8313 synth_6634 synth_6499 synth_6631 synth_4702 VNB|VSS VDD
+ VNB|VSS sky130_fd_sc_hd__o22ai_1
X$2948 VDD synth_10377 synth_10212 synth_9850 synth_10376 synth_10378 VNB|VSS
+ VDD VNB|VSS sky130_fd_sc_hd__o22ai_1
X$2949 VDD synth_8895 synth_8230 synth_8820 synth_8621 synth_8852 VNB|VSS VDD
+ VNB|VSS sky130_fd_sc_hd__o22ai_1
X$2950 VDD synth_346 synth_561 synth_595 synth_562 synth_599 VNB|VSS VDD
+ VNB|VSS sky130_fd_sc_hd__o22ai_1
X$2951 VDD synth_7435 synth_7787 synth_7931 synth_7932 synth_8003 VNB|VSS VDD
+ VNB|VSS sky130_fd_sc_hd__o22ai_1
X$2952 VDD synth_581 synth_3254 synth_3414 synth_3256 synth_3488 VNB|VSS VDD
+ VNB|VSS sky130_fd_sc_hd__o22ai_1
X$2953 VDD synth_7435 synth_7434 synth_7770 synth_7562 synth_7640 VNB|VSS VDD
+ VNB|VSS sky130_fd_sc_hd__o22ai_1
X$2954 VDD synth_1213 synth_1131 synth_1132 synth_1173 synth_1390 VNB|VSS VDD
+ VNB|VSS sky130_fd_sc_hd__o22ai_1
X$2955 VDD synth_9772 synth_9774 synth_9828 synth_8873 synth_9517 VNB|VSS VDD
+ VNB|VSS sky130_fd_sc_hd__o22ai_1
X$2956 VDD synth_850 synth_4427 synth_4385 synth_4335 synth_4426 VNB|VSS VDD
+ VNB|VSS sky130_fd_sc_hd__o22ai_1
X$2957 VDD synth_9742 synth_9559 synth_9662 synth_9434 synth_9433 VNB|VSS VDD
+ VNB|VSS sky130_fd_sc_hd__o22ai_1
X$2958 VDD synth_7435 synth_8122 synth_7881 synth_7989 synth_8271 VNB|VSS VDD
+ VNB|VSS sky130_fd_sc_hd__o22ai_1
X$2959 VDD synth_10404 synth_8806 synth_9047 synth_9900 synth_10310 VNB|VSS VDD
+ VNB|VSS sky130_fd_sc_hd__o22ai_1
X$2960 VDD synth_9998 synth_9691 synth_10084 synth_9918 synth_10088 VNB|VSS VDD
+ VNB|VSS sky130_fd_sc_hd__o22ai_1
X$2961 VDD synth_9558 synth_8805 synth_9582 synth_9850 synth_9666 VNB|VSS VDD
+ VNB|VSS sky130_fd_sc_hd__o22ai_1
X$2962 VDD synth_11891 synth_9691 synth_11921 synth_12018 synth_12082 VNB|VSS
+ VDD VNB|VSS sky130_fd_sc_hd__o22ai_1
X$2963 VDD synth_3480 synth_408 synth_3331 synth_3481 synth_3405 VNB|VSS VDD
+ VNB|VSS sky130_fd_sc_hd__o22ai_1
X$2964 VDD synth_8230 synth_8540 synth_8455 synth_8457 synth_8456 VNB|VSS VDD
+ VNB|VSS sky130_fd_sc_hd__o22ai_1
X$2965 VDD synth_9315 synth_9691 synth_9210 synth_9420 synth_9692 VNB|VSS VDD
+ VNB|VSS sky130_fd_sc_hd__o22ai_1
X$2966 VDD synth_4758 synth_581 synth_4685 synth_4759 synth_4857 VNB|VSS VDD
+ VNB|VSS sky130_fd_sc_hd__o22ai_1
X$2967 VDD synth_1081 synth_3353 synth_3282 synth_3464 synth_3532 VNB|VSS VDD
+ VNB|VSS sky130_fd_sc_hd__o22ai_1
X$2968 VDD synth_3527 synth_4268 synth_4411 synth_4183 synth_4351 VNB|VSS VDD
+ VNB|VSS sky130_fd_sc_hd__o22ai_1
X$2969 VDD synth_3843 synth_581 synth_3915 synth_3908 synth_3844 VNB|VSS VDD
+ VNB|VSS sky130_fd_sc_hd__o22ai_1
X$2970 VDD synth_581 synth_5352 synth_5351 synth_5170 synth_5354 VNB|VSS VDD
+ VNB|VSS sky130_fd_sc_hd__o22ai_1
X$2971 VDD synth_1213 synth_2263 synth_2299 synth_2377 synth_2419 VNB|VSS VDD
+ VNB|VSS sky130_fd_sc_hd__o22ai_1
X$2972 VDD synth_850 synth_4341 synth_4337 synth_4478 synth_4475 VNB|VSS VDD
+ VNB|VSS sky130_fd_sc_hd__o22ai_1
X$2973 VDD synth_9101 synth_12381 synth_12380 synth_9117 synth_12361 VNB|VSS
+ VDD VNB|VSS sky130_fd_sc_hd__o22ai_1
X$2974 VDD synth_3233 synth_2249 synth_4712 synth_4671 synth_4672 VNB|VSS VDD
+ VNB|VSS sky130_fd_sc_hd__o22ai_1
X$2975 VDD synth_5286 synth_5054 synth_5000 synth_5126 synth_5125 VNB|VSS VDD
+ VNB|VSS sky130_fd_sc_hd__o22ai_1
X$2976 VDD synth_12634 synth_9049 synth_12268 synth_12635 synth_12746 VNB|VSS
+ VDD VNB|VSS sky130_fd_sc_hd__o22ai_1
X$2977 VDD synth_850 synth_2553 synth_2819 synth_2369 synth_2820 VNB|VSS VDD
+ VNB|VSS sky130_fd_sc_hd__o22ai_1
X$2978 VDD synth_7031 synth_6211 synth_7199 synth_7032 synth_7248 VNB|VSS VDD
+ VNB|VSS sky130_fd_sc_hd__o22ai_1
X$2979 VDD synth_1286 synth_346 synth_1284 synth_1190 synth_1367 VNB|VSS VDD
+ VNB|VSS sky130_fd_sc_hd__o22ai_1
X$2980 VDD synth_2211 synth_1081 synth_2283 synth_2348 synth_2350 VNB|VSS VDD
+ VNB|VSS sky130_fd_sc_hd__o22ai_1
X$2981 VDD synth_6263 synth_581 synth_6260 synth_6102 synth_6252 VNB|VSS VDD
+ VNB|VSS sky130_fd_sc_hd__o22ai_1
X$2982 VDD synth_9825 synth_9434 synth_9820 synth_8948 synth_9821 VNB|VSS VDD
+ VNB|VSS sky130_fd_sc_hd__o22ai_1
X$2983 VDD synth_8230 synth_8528 synth_8697 synth_8696 synth_8719 VNB|VSS VDD
+ VNB|VSS sky130_fd_sc_hd__o22ai_1
X$2984 VDD synth_8488 VNB|VSS VDD VNB|VSS sky130_fd_sc_hd__inv_4
X$2985 VDD synth_10289 synth_9565 synth_10233 synth_8981 synth_10288 VNB|VSS
+ VDD VNB|VSS sky130_fd_sc_hd__o22ai_1
X$2986 VDD synth_5286 synth_5969 synth_6063 synth_6024 synth_6064 VNB|VSS VDD
+ VNB|VSS sky130_fd_sc_hd__o22ai_1
X$2987 VDD synth_79 synth_474 synth_476 synth_339 synth_432 VNB|VSS VDD VNB|VSS
+ sky130_fd_sc_hd__o22ai_1
X$2988 VDD synth_2752 synth_408 synth_2992 synth_2806 synth_3062 VNB|VSS VDD
+ VNB|VSS sky130_fd_sc_hd__o22ai_1
X$2989 VDD synth_9297 synth_10822 synth_10537 synth_10856 synth_10932 VNB|VSS
+ VDD VNB|VSS sky130_fd_sc_hd__o22ai_1
X$2990 VDD synth_2095 synth_2054 synth_2092 synth_1968 synth_2053 VNB|VSS VDD
+ VNB|VSS sky130_fd_sc_hd__o22ai_1
X$2991 VDD synth_9700 synth_11538 synth_10840 synth_9695 synth_12395 VNB|VSS
+ VDD VNB|VSS sky130_fd_sc_hd__o22ai_1
X$2992 VDD synth_10005 synth_8764 synth_10160 synth_9677 synth_9113 VNB|VSS VDD
+ VNB|VSS sky130_fd_sc_hd__o22ai_1
X$2993 VDD synth_9297 synth_9405 synth_9540 synth_9302 synth_9538 VNB|VSS VDD
+ VNB|VSS sky130_fd_sc_hd__o22ai_1
X$2994 VDD synth_12289 synth_9297 synth_12369 synth_12286 synth_12288 VNB|VSS
+ VDD VNB|VSS sky130_fd_sc_hd__o22ai_1
X$2995 VDD synth_7435 synth_7292 synth_7393 synth_7395 synth_7536 VNB|VSS VDD
+ VNB|VSS sky130_fd_sc_hd__o22ai_1
X$2996 VDD synth_9565 synth_9695 synth_9700 synth_8910 synth_9769 VNB|VSS VDD
+ VNB|VSS sky130_fd_sc_hd__o22ai_1
X$2997 VDD synth_6747 synth_6211 synth_6287 synth_6899 synth_7173 VNB|VSS VDD
+ VNB|VSS sky130_fd_sc_hd__o22ai_1
X$2998 VDD synth_474 synth_1348 synth_1071 synth_1179 synth_1322 VNB|VSS VDD
+ VNB|VSS sky130_fd_sc_hd__o22ai_1
X$2999 VDD synth_1213 synth_2447 synth_2328 synth_2509 synth_2470 VNB|VSS VDD
+ VNB|VSS sky130_fd_sc_hd__o22ai_1
X$3000 VDD synth_11063 synth_10312 synth_10510 synth_9324 synth_11013 VNB|VSS
+ VDD VNB|VSS sky130_fd_sc_hd__o22ai_1
X$3001 VDD synth_6993 synth_6211 synth_7224 synth_7122 synth_7211 VNB|VSS VDD
+ VNB|VSS sky130_fd_sc_hd__o22ai_1
X$3002 VDD synth_9691 synth_11157 synth_11207 synth_10900 synth_11125 VNB|VSS
+ VDD VNB|VSS sky130_fd_sc_hd__o22ai_1
X$3003 VDD synth_408 synth_2603 synth_2809 synth_2664 synth_2979 VNB|VSS VDD
+ VNB|VSS sky130_fd_sc_hd__o22ai_1
X$3004 VDD synth_430 synth_474 synth_554 synth_172 synth_556 VNB|VSS VDD
+ VNB|VSS sky130_fd_sc_hd__o22ai_1
X$3005 VDD synth_4017 synth_3527 synth_3956 synth_4018 synth_4015 VNB|VSS VDD
+ VNB|VSS sky130_fd_sc_hd__o22ai_1
X$3006 VDD synth_1730 synth_346 synth_1334 synth_1640 synth_1787 VNB|VSS VDD
+ VNB|VSS sky130_fd_sc_hd__o22ai_1
X$3007 VDD synth_10532 synth_9297 synth_10500 synth_10565 synth_10567 VNB|VSS
+ VDD VNB|VSS sky130_fd_sc_hd__o22ai_1
X$3008 VDD synth_10580 synth_8805 synth_9233 synth_9119 synth_10688 VNB|VSS VDD
+ VNB|VSS sky130_fd_sc_hd__o22ai_1
X$3009 VDD synth_9297 synth_12011 synth_12038 synth_12071 synth_12223 VNB|VSS
+ VDD VNB|VSS sky130_fd_sc_hd__o22ai_1
X$3010 VDD synth_4141 synth_4218 synth_4220 synth_4082 synth_4219 VNB|VSS VDD
+ VNB|VSS sky130_fd_sc_hd__o22ai_1
X$3011 VDD synth_9297 synth_10072 synth_10130 synth_9988 synth_10132 VNB|VSS
+ VDD VNB|VSS sky130_fd_sc_hd__o22ai_1
X$3012 VDD synth_10690 synth_10212 synth_10689 synth_9582 synth_10901 VNB|VSS
+ VDD VNB|VSS sky130_fd_sc_hd__o22ai_1
X$3013 VDD synth_6797 synth_6476 synth_6796 synth_6640 synth_6894 VNB|VSS VDD
+ VNB|VSS sky130_fd_sc_hd__o22ai_1
X$3014 VDD synth_850 synth_456 synth_800 synth_498 synth_732 VNB|VSS VDD
+ VNB|VSS sky130_fd_sc_hd__o22ai_1
X$3015 VDD synth_3518 synth_1213 synth_3459 synth_3345 synth_3376 VNB|VSS VDD
+ VNB|VSS sky130_fd_sc_hd__o22ai_1
X$3016 VDD synth_850 synth_4890 synth_5248 synth_4974 synth_5063 VNB|VSS VDD
+ VNB|VSS sky130_fd_sc_hd__o22ai_1
X$3017 VDD synth_3527 synth_3601 synth_3625 synth_3672 synth_3722 VNB|VSS VDD
+ VNB|VSS sky130_fd_sc_hd__o22ai_1
X$3018 VDD synth_5225 synth_850 synth_5308 synth_5496 synth_5411 VNB|VSS VDD
+ VNB|VSS sky130_fd_sc_hd__o22ai_1
X$3019 VDD synth_850 synth_2102 synth_2103 synth_2104 synth_2182 VNB|VSS VDD
+ VNB|VSS sky130_fd_sc_hd__o22ai_1
X$3020 VDD synth_10860 synth_9049 synth_10842 synth_10791 synth_10719 VNB|VSS
+ VDD VNB|VSS sky130_fd_sc_hd__o22ai_1
X$3021 VDD synth_850 synth_2412 synth_2259 synth_2323 synth_2322 VNB|VSS VDD
+ VNB|VSS sky130_fd_sc_hd__o22ai_1
X$3022 VDD synth_12052 synth_10285 synth_12051 synth_9677 synth_11867 VNB|VSS
+ VDD VNB|VSS sky130_fd_sc_hd__o22ai_1
X$3023 VDD synth_12326 synth_9691 synth_12352 synth_12257 synth_12292 VNB|VSS
+ VDD VNB|VSS sky130_fd_sc_hd__o22ai_1
X$3024 VDD synth_11895 synth_10212 synth_11869 synth_10312 synth_11725 VNB|VSS
+ VDD VNB|VSS sky130_fd_sc_hd__o22ai_1
X$3025 VDD synth_3971 synth_1081 synth_3931 synth_3930 synth_4058 VNB|VSS VDD
+ VNB|VSS sky130_fd_sc_hd__o22ai_1
X$3026 VDD synth_9691 synth_10428 synth_10358 synth_10143 synth_10430 VNB|VSS
+ VDD VNB|VSS sky130_fd_sc_hd__o22ai_1
X$3027 VDD synth_850 synth_3851 synth_4007 synth_3978 synth_4079 VNB|VSS VDD
+ VNB|VSS sky130_fd_sc_hd__o22ai_1
X$3028 VDD synth_3974 synth_581 synth_4114 synth_4040 synth_3990 VNB|VSS VDD
+ VNB|VSS sky130_fd_sc_hd__o22ai_1
X$3029 VDD synth_2365 synth_581 synth_2366 synth_2360 synth_2489 VNB|VSS VDD
+ VNB|VSS sky130_fd_sc_hd__o22ai_1
X$3030 VDD synth_8230 synth_8064 synth_8231 synth_7908 synth_8229 VNB|VSS VDD
+ VNB|VSS sky130_fd_sc_hd__o22ai_1
X$3031 VDD synth_9049 synth_11923 synth_11924 synth_11856 synth_11990 VNB|VSS
+ VDD VNB|VSS sky130_fd_sc_hd__o22ai_1
X$3032 VDD synth_1213 synth_1579 synth_1700 synth_1628 synth_1701 VNB|VSS VDD
+ VNB|VSS sky130_fd_sc_hd__o22ai_1
X$3033 VDD synth_9691 synth_12567 synth_12505 synth_12351 synth_12689 VNB|VSS
+ VDD VNB|VSS sky130_fd_sc_hd__o22ai_1
X$3034 VDD synth_3026 synth_1213 synth_3027 synth_3030 synth_3145 VNB|VSS VDD
+ VNB|VSS sky130_fd_sc_hd__o22ai_1
X$3035 VDD synth_5339 synth_474 synth_5389 synth_5317 synth_5537 VNB|VSS VDD
+ VNB|VSS sky130_fd_sc_hd__o22ai_1
X$3036 VDD synth_9049 synth_8783 synth_9004 synth_8744 synth_9107 VNB|VSS VDD
+ VNB|VSS sky130_fd_sc_hd__o22ai_1
X$3037 VDD synth_581 synth_1754 synth_1749 synth_1662 synth_1899 VNB|VSS VDD
+ VNB|VSS sky130_fd_sc_hd__o22ai_1
X$3038 VDD synth_12028 synth_10793 synth_10170 synth_9042 synth_12157 VNB|VSS
+ VDD VNB|VSS sky130_fd_sc_hd__o22ai_1
X$3039 VDD synth_6476 synth_6790 synth_6326 synth_6859 synth_6930 VNB|VSS VDD
+ VNB|VSS sky130_fd_sc_hd__o22ai_1
X$3040 VDD synth_620 synth_346 synth_759 synth_717 synth_876 VNB|VSS VDD
+ VNB|VSS sky130_fd_sc_hd__o22ai_1
X$3041 VDD synth_3587 synth_1081 synth_3510 synth_3643 synth_3770 VNB|VSS VDD
+ VNB|VSS sky130_fd_sc_hd__o22ai_1
X$3042 VDD synth_5858 synth_474 synth_5907 synth_5985 synth_6075 VNB|VSS VDD
+ VNB|VSS sky130_fd_sc_hd__o22ai_1
X$3043 VDD synth_7435 synth_8780 synth_8801 synth_8869 synth_8923 VNB|VSS VDD
+ VNB|VSS sky130_fd_sc_hd__o22ai_1
X$3044 VDD synth_5048 synth_850 synth_5065 synth_4922 synth_5066 VNB|VSS VDD
+ VNB|VSS sky130_fd_sc_hd__o22ai_1
X$3045 VDD synth_9691 synth_9610 synth_9731 synth_9665 synth_9823 VNB|VSS VDD
+ VNB|VSS sky130_fd_sc_hd__o22ai_1
X$3046 VDD synth_850 synth_2895 synth_2933 synth_2977 synth_3099 VNB|VSS VDD
+ VNB|VSS sky130_fd_sc_hd__o22ai_1
X$3047 VDD synth_10170 synth_9292 synth_10099 synth_8910 synth_10159 VNB|VSS
+ VDD VNB|VSS sky130_fd_sc_hd__o22ai_1
X$3048 VDD synth_11812 synth_10793 synth_10006 synth_9233 synth_11910 VNB|VSS
+ VDD VNB|VSS sky130_fd_sc_hd__o22ai_1
X$3049 VDD synth_9061 synth_9042 synth_10095 synth_9695 synth_10009 VNB|VSS VDD
+ VNB|VSS sky130_fd_sc_hd__o22ai_1
X$3050 VDD synth_8230 synth_10043 synth_10078 synth_10076 synth_10080 VNB|VSS
+ VDD VNB|VSS sky130_fd_sc_hd__o22ai_1
X$3051 VDD synth_5286 synth_6345 synth_6722 synth_6519 synth_6947 VNB|VSS VDD
+ VNB|VSS sky130_fd_sc_hd__o22ai_1
X$3052 VDD synth_10157 synth_8805 synth_9983 synth_9063 synth_9038 VNB|VSS VDD
+ VNB|VSS sky130_fd_sc_hd__o22ai_1
X$3053 VDD synth_6476 synth_6737 synth_7017 synth_6788 synth_7060 VNB|VSS VDD
+ VNB|VSS sky130_fd_sc_hd__o22ai_1
X$3054 VDD synth_5155 synth_474 synth_5256 synth_5154 synth_5340 VNB|VSS VDD
+ VNB|VSS sky130_fd_sc_hd__o22ai_1
X$3055 VDD synth_850 synth_2855 synth_2854 synth_2780 synth_2981 VNB|VSS VDD
+ VNB|VSS sky130_fd_sc_hd__o22ai_1
X$3056 VDD synth_2242 synth_346 synth_2126 synth_2207 synth_2062 VNB|VSS VDD
+ VNB|VSS sky130_fd_sc_hd__o22ai_1
X$3057 VDD synth_12026 synth_9112 synth_11912 synth_9387 synth_11930 VNB|VSS
+ VDD VNB|VSS sky130_fd_sc_hd__o22ai_1
X$3058 VDD synth_408 synth_1823 synth_1766 synth_1824 synth_1826 VNB|VSS VDD
+ VNB|VSS sky130_fd_sc_hd__o22ai_1
X$3059 VDD synth_12527 synth_12636 synth_12638 synth_9101 synth_11963 VNB|VSS
+ VDD VNB|VSS sky130_fd_sc_hd__o22ai_1
X$3060 VDD synth_4211 synth_581 synth_4206 synth_4122 synth_4210 VNB|VSS VDD
+ VNB|VSS sky130_fd_sc_hd__o22ai_1
X$3061 VDD synth_9052 synth_8230 synth_8896 synth_8830 synth_8972 VNB|VSS VDD
+ VNB|VSS sky130_fd_sc_hd__o22ai_1
X$3062 VDD synth_11901 synth_10212 synth_11637 synth_10652 synth_11786 VNB|VSS
+ VDD VNB|VSS sky130_fd_sc_hd__o22ai_1
X$3063 VDD synth_7260 synth_6211 synth_7261 synth_7259 synth_7368 VNB|VSS VDD
+ VNB|VSS sky130_fd_sc_hd__o22ai_1
X$3064 VDD synth_11571 synth_10652 synth_9177 synth_9233 synth_11791 VNB|VSS
+ VDD VNB|VSS sky130_fd_sc_hd__o22ai_1
X$3065 VDD synth_3817 synth_4062 synth_4076 synth_4020 synth_4231 VNB|VSS VDD
+ VNB|VSS sky130_fd_sc_hd__o22ai_1
X$3066 VDD synth_617 synth_346 synth_618 synth_619 synth_793 VNB|VSS VDD
+ VNB|VSS sky130_fd_sc_hd__o22ai_1
X$3067 VDD synth_9425 synth_9049 synth_9171 synth_9577 synth_9832 VNB|VSS VDD
+ VNB|VSS sky130_fd_sc_hd__o22ai_1
X$3068 VDD synth_2668 synth_581 synth_2972 synth_2889 synth_2973 VNB|VSS VDD
+ VNB|VSS sky130_fd_sc_hd__o22ai_1
X$3069 VDD synth_9852 synth_8806 synth_10101 synth_9233 synth_10057 VNB|VSS VDD
+ VNB|VSS sky130_fd_sc_hd__o22ai_1
X$3070 VDD synth_10846 synth_9427 synth_11315 synth_10793 synth_11358 VNB|VSS
+ VDD VNB|VSS sky130_fd_sc_hd__o22ai_1
X$3071 VDD synth_7486 synth_5286 synth_7400 synth_7378 synth_7551 VNB|VSS VDD
+ VNB|VSS sky130_fd_sc_hd__o22ai_1
X$3072 VDD synth_7848 synth_7435 synth_7849 synth_7915 synth_7960 VNB|VSS VDD
+ VNB|VSS sky130_fd_sc_hd__o22ai_1
X$3073 VDD synth_9987 synth_9297 synth_10064 synth_10116 synth_10117 VNB|VSS
+ VDD VNB|VSS sky130_fd_sc_hd__o22ai_1
X$3074 VDD synth_474 synth_269 synth_589 synth_137 synth_507 VNB|VSS VDD
+ VNB|VSS sky130_fd_sc_hd__o22ai_1
X$3075 VDD synth_12559 synth_10793 synth_12595 synth_9112 synth_12653 VNB|VSS
+ VDD VNB|VSS sky130_fd_sc_hd__o22ai_1
X$3076 VDD synth_7435 synth_7359 synth_7774 synth_7321 synth_7688 VNB|VSS VDD
+ VNB|VSS sky130_fd_sc_hd__o22ai_1
X$3077 VDD synth_346 synth_1271 synth_1165 synth_1358 synth_1512 VNB|VSS VDD
+ VNB|VSS sky130_fd_sc_hd__o22ai_1
X$3078 VDD synth_5509 synth_581 synth_5567 synth_5428 synth_5617 VNB|VSS VDD
+ VNB|VSS sky130_fd_sc_hd__o22ai_1
X$3079 VDD synth_1253 synth_474 synth_1254 synth_1224 synth_1222 VNB|VSS VDD
+ VNB|VSS sky130_fd_sc_hd__o22ai_1
X$3080 VDD synth_84 synth_346 synth_397 synth_146 synth_493 VNB|VSS VDD VNB|VSS
+ sky130_fd_sc_hd__o22ai_1
X$3081 VDD synth_474 synth_2726 synth_2652 synth_2866 synth_2867 VNB|VSS VDD
+ VNB|VSS sky130_fd_sc_hd__o22ai_1
X$3082 VDD synth_835 synth_408 synth_1002 synth_919 synth_920 VNB|VSS VDD
+ VNB|VSS sky130_fd_sc_hd__o22ai_1
X$3083 VDD synth_10991 synth_9297 synth_11031 synth_10919 synth_11032 VNB|VSS
+ VDD VNB|VSS sky130_fd_sc_hd__o22ai_1
X$3084 VDD synth_6744 synth_6211 synth_6236 synth_6807 synth_7024 VNB|VSS VDD
+ VNB|VSS sky130_fd_sc_hd__o22ai_1
X$3085 VDD synth_6575 synth_6211 synth_6689 synth_6691 synth_6713 VNB|VSS VDD
+ VNB|VSS sky130_fd_sc_hd__o22ai_1
X$3086 VDD synth_10485 synth_8764 synth_10725 synth_9677 synth_10844 VNB|VSS
+ VDD VNB|VSS sky130_fd_sc_hd__o22ai_1
X$3087 VDD synth_6642 synth_6211 synth_6339 synth_6680 synth_6682 VNB|VSS VDD
+ VNB|VSS sky130_fd_sc_hd__o22ai_1
X$3088 VDD synth_7626 synth_6211 synth_7761 synth_7736 synth_7737 VNB|VSS VDD
+ VNB|VSS sky130_fd_sc_hd__o22ai_1
X$3089 VDD synth_2581 synth_474 synth_2582 synth_2407 synth_2705 VNB|VSS VDD
+ VNB|VSS sky130_fd_sc_hd__o22ai_1
X$3090 VDD synth_4594 synth_474 synth_4837 synth_4662 synth_4902 VNB|VSS VDD
+ VNB|VSS sky130_fd_sc_hd__o22ai_1
X$3091 VDD synth_12229 synth_9049 synth_12213 synth_12211 synth_12342 VNB|VSS
+ VDD VNB|VSS sky130_fd_sc_hd__o22ai_1
X$3092 VDD synth_270 VDD VNB|VSS VNB|VSS sky130_fd_sc_hd__clkinv_2
X$3093 VDD synth_3557 VDD VNB|VSS VNB|VSS sky130_fd_sc_hd__clkinv_2
X$3094 VDD synth_9291 VDD VNB|VSS VNB|VSS sky130_fd_sc_hd__clkinv_2
X$3095 VDD synth_4487 VDD VNB|VSS VNB|VSS sky130_fd_sc_hd__clkinv_2
X$3096 VDD synth_61 VDD VNB|VSS VNB|VSS sky130_fd_sc_hd__clkinv_2
X$3097 VDD synth_11489 VDD VNB|VSS VNB|VSS sky130_fd_sc_hd__clkinv_2
X$3098 VDD synth_8533 VDD VNB|VSS VNB|VSS sky130_fd_sc_hd__clkinv_2
X$3099 VDD synth_36 VDD VNB|VSS VNB|VSS sky130_fd_sc_hd__clkinv_2
X$3100 VDD synth_8165 VDD VNB|VSS VNB|VSS sky130_fd_sc_hd__clkinv_2
X$3101 VDD synth_2077 VDD VNB|VSS VNB|VSS sky130_fd_sc_hd__clkinv_2
X$3102 VDD synth_3169 VDD VNB|VSS VNB|VSS sky130_fd_sc_hd__clkinv_2
X$3103 VDD synth_2193 VDD VNB|VSS VNB|VSS sky130_fd_sc_hd__clkinv_2
X$3104 VDD synth_8228 VDD VNB|VSS VNB|VSS sky130_fd_sc_hd__clkinv_2
X$3105 VDD synth_5089 VDD VNB|VSS VNB|VSS sky130_fd_sc_hd__clkinv_2
X$3106 VDD synth_2804 VDD VNB|VSS VNB|VSS sky130_fd_sc_hd__clkinv_2
X$3107 VDD synth_7588 VDD VNB|VSS VNB|VSS sky130_fd_sc_hd__clkinv_2
X$3108 VDD synth_3397 VDD VNB|VSS VNB|VSS sky130_fd_sc_hd__clkinv_2
X$3109 VDD synth_5227 VDD VNB|VSS VNB|VSS sky130_fd_sc_hd__clkinv_2
X$3110 VDD synth_10355 VDD VNB|VSS VNB|VSS sky130_fd_sc_hd__clkinv_2
X$3111 VDD synth_1795 VDD VNB|VSS VNB|VSS sky130_fd_sc_hd__clkinv_2
X$3112 VDD synth_6583 VDD VNB|VSS VNB|VSS sky130_fd_sc_hd__clkinv_2
X$3113 VDD synth_1432 VDD VNB|VSS VNB|VSS sky130_fd_sc_hd__clkinv_2
X$3114 VDD synth_5159 VDD VNB|VSS VNB|VSS sky130_fd_sc_hd__clkinv_2
X$3115 VDD synth_4833 VDD VNB|VSS VNB|VSS sky130_fd_sc_hd__clkinv_2
X$3116 VDD synth_8863 VDD VNB|VSS VNB|VSS sky130_fd_sc_hd__clkinv_2
X$3117 VDD synth_3122 VDD VNB|VSS VNB|VSS sky130_fd_sc_hd__clkinv_2
X$3118 VDD synth_7335 VDD VNB|VSS VNB|VSS sky130_fd_sc_hd__clkinv_2
X$3119 VDD synth_3284 VDD VNB|VSS VNB|VSS sky130_fd_sc_hd__clkinv_2
X$3120 VDD synth_7213 VDD VNB|VSS VNB|VSS sky130_fd_sc_hd__clkinv_2
X$3121 VDD synth_9702 VDD VNB|VSS VNB|VSS sky130_fd_sc_hd__clkinv_2
X$3122 VDD synth_5658 VDD VNB|VSS VNB|VSS sky130_fd_sc_hd__clkinv_2
X$3123 VDD synth_7645 VDD VNB|VSS VNB|VSS sky130_fd_sc_hd__clkinv_2
X$3124 VDD synth_5327 VDD VNB|VSS VNB|VSS sky130_fd_sc_hd__clkinv_2
X$3125 VDD synth_6927 VDD VNB|VSS VNB|VSS sky130_fd_sc_hd__clkinv_2
X$3126 VDD synth_4600 VDD VNB|VSS VNB|VSS sky130_fd_sc_hd__clkinv_2
X$3127 VDD synth_6611 VDD VNB|VSS VNB|VSS sky130_fd_sc_hd__clkinv_2
X$3128 VDD synth_10030 VDD VNB|VSS VNB|VSS sky130_fd_sc_hd__clkinv_2
X$3129 VDD synth_11939 VDD VNB|VSS VNB|VSS sky130_fd_sc_hd__clkinv_2
X$3130 VDD synth_2750 VDD VNB|VSS VNB|VSS sky130_fd_sc_hd__clkinv_2
X$3131 VDD synth_9402 VDD VNB|VSS VNB|VSS sky130_fd_sc_hd__clkinv_2
X$3132 VDD synth_5407 VDD VNB|VSS VNB|VSS sky130_fd_sc_hd__clkinv_2
X$3133 VDD synth_6459 VDD VNB|VSS VNB|VSS sky130_fd_sc_hd__clkinv_2
X$3134 VDD synth_3374 VDD VNB|VSS VNB|VSS sky130_fd_sc_hd__clkinv_2
X$3135 VDD synth_1657 VDD VNB|VSS VNB|VSS sky130_fd_sc_hd__clkinv_2
X$3136 VDD synth_10538 VDD VNB|VSS VNB|VSS sky130_fd_sc_hd__clkinv_2
X$3137 VDD synth_8367 VDD VNB|VSS VNB|VSS sky130_fd_sc_hd__clkinv_2
X$3138 VDD synth_12311 VDD VNB|VSS VNB|VSS sky130_fd_sc_hd__clkinv_2
X$3139 VDD synth_7023 VDD VNB|VSS VNB|VSS sky130_fd_sc_hd__clkinv_2
X$3140 VDD synth_7022 VDD VNB|VSS VNB|VSS sky130_fd_sc_hd__clkinv_2
X$3141 VDD synth_8103 VDD VNB|VSS VNB|VSS sky130_fd_sc_hd__clkinv_2
X$3142 VDD synth_7490 VDD VNB|VSS VNB|VSS sky130_fd_sc_hd__clkinv_2
X$3143 VDD synth_11470 VDD VNB|VSS VNB|VSS sky130_fd_sc_hd__clkinv_2
X$3144 VDD synth_11284 synth_11374 synth_9691 synth_11569 VDD VNB|VSS VNB|VSS
+ sky130_fd_sc_hd__or3_1
X$3145 VDD synth_197 synth_199 synth_474 synth_428 VDD VNB|VSS VNB|VSS
+ sky130_fd_sc_hd__or3_1
X$3146 VDD synth_12479 synth_12473 synth_12767 synth_12765 VDD VNB|VSS VNB|VSS
+ sky130_fd_sc_hd__or3_1
X$3147 VDD synth_3800 synth_3738 synth_3964 synth_4071 VDD VNB|VSS VNB|VSS
+ sky130_fd_sc_hd__or3_1
X$3148 VDD synth_3310 synth_3273 synth_3272 synth_3399 VDD VNB|VSS VNB|VSS
+ sky130_fd_sc_hd__or3_1
X$3149 VDD synth_8873 synth_9062 synth_8805 synth_10513 VDD VNB|VSS VNB|VSS
+ sky130_fd_sc_hd__or3_1
X$3150 VDD synth_7796 synth_7798 synth_6211 synth_7942 VDD VNB|VSS VNB|VSS
+ sky130_fd_sc_hd__or3_1
X$3151 VDD synth_5254 synth_5150 synth_474 synth_5237 VDD VNB|VSS VNB|VSS
+ sky130_fd_sc_hd__or3_1
X$3152 VDD synth_8516 synth_8441 synth_7435 synth_8387 VDD VNB|VSS VNB|VSS
+ sky130_fd_sc_hd__or3_1
X$3153 VDD synth_11085 synth_11160 synth_11129 synth_11430 VDD VNB|VSS VNB|VSS
+ sky130_fd_sc_hd__or3_1
X$3154 VDD synth_733 synth_662 synth_474 synth_661 VDD VNB|VSS VNB|VSS
+ sky130_fd_sc_hd__or3_1
X$3155 VDD synth_5007 synth_5006 synth_5286 synth_5130 VDD VNB|VSS VNB|VSS
+ sky130_fd_sc_hd__or3_1
X$3156 VDD synth_2768 synth_2647 synth_1213 synth_2786 VDD VNB|VSS VNB|VSS
+ sky130_fd_sc_hd__or3_1
X$3157 VDD synth_5632 synth_5733 synth_5732 synth_5794 VDD VNB|VSS VNB|VSS
+ sky130_fd_sc_hd__or3_1
X$3158 VDD synth_9062 synth_11914 synth_12653 synth_12597 VDD VNB|VSS VNB|VSS
+ sky130_fd_sc_hd__or3_1
X$3159 VDD synth_12120 synth_12118 synth_12119 synth_12186 VDD VNB|VSS VNB|VSS
+ sky130_fd_sc_hd__or3_1
X$3160 VDD synth_11724 synth_11726 synth_9049 synth_11792 VDD VNB|VSS VNB|VSS
+ sky130_fd_sc_hd__or3_1
X$3161 VDD synth_3033 synth_2849 synth_1081 synth_3151 VDD VNB|VSS VNB|VSS
+ sky130_fd_sc_hd__or3_1
X$3162 VDD synth_6819 synth_6903 synth_6874 synth_6821 VDD VNB|VSS VNB|VSS
+ sky130_fd_sc_hd__or3_1
X$3163 VDD synth_1588 synth_1589 synth_1294 synth_1828 VDD VNB|VSS VNB|VSS
+ sky130_fd_sc_hd__or3_1
X$3164 VDD synth_5966 synth_5848 synth_5734 synth_6220 VDD VNB|VSS VNB|VSS
+ sky130_fd_sc_hd__or3_1
X$3165 VDD synth_2430 synth_2343 synth_1081 synth_2344 VDD VNB|VSS VNB|VSS
+ sky130_fd_sc_hd__or3_1
X$3166 VDD synth_9622 synth_9670 synth_9691 synth_9669 VDD VNB|VSS VNB|VSS
+ sky130_fd_sc_hd__or3_1
X$3167 VDD synth_4592 synth_4655 synth_4591 synth_4420 VDD VNB|VSS VNB|VSS
+ sky130_fd_sc_hd__or3_1
X$3168 VDD synth_5144 synth_5071 synth_850 synth_5148 VDD VNB|VSS VNB|VSS
+ sky130_fd_sc_hd__or3_1
X$3169 VDD synth_3795 synth_3519 synth_3432 synth_3564 VDD VNB|VSS VNB|VSS
+ sky130_fd_sc_hd__or3_1
X$3170 VDD synth_3746 synth_3689 synth_850 synth_3784 VDD VNB|VSS VNB|VSS
+ sky130_fd_sc_hd__or3_1
X$3171 VDD synth_3815 synth_3689 synth_3746 synth_3814 VNB|VSS VDD VNB|VSS
+ sky130_fd_sc_hd__or3b_2
X$3172 VDD synth_2422 synth_2334 synth_1213 synth_2454 VDD VNB|VSS VNB|VSS
+ sky130_fd_sc_hd__or3_1
X$3173 VDD synth_10260 synth_10387 synth_10453 synth_10317 VDD VNB|VSS VNB|VSS
+ sky130_fd_sc_hd__or3_1
X$3174 VDD synth_7564 synth_7563 synth_7435 synth_7751 VDD VNB|VSS VNB|VSS
+ sky130_fd_sc_hd__or3_1
X$3175 VDD synth_1722 synth_1724 synth_1723 synth_1721 VDD VNB|VSS VNB|VSS
+ sky130_fd_sc_hd__or3_1
X$3176 VDD synth_7929 synth_7928 synth_7435 synth_8059 VDD VNB|VSS VNB|VSS
+ sky130_fd_sc_hd__or3_1
X$3177 VDD synth_5899 synth_5814 synth_850 synth_5960 VDD VNB|VSS VNB|VSS
+ sky130_fd_sc_hd__or3_1
X$3178 VDD synth_1722 synth_1955 synth_1954 synth_2699 VDD VNB|VSS VNB|VSS
+ sky130_fd_sc_hd__or3_1
X$3179 VDD synth_1266 synth_1268 synth_346 synth_1267 VDD VNB|VSS VNB|VSS
+ sky130_fd_sc_hd__or3_1
X$3180 VDD synth_1607 synth_1587 synth_346 synth_1682 VDD VNB|VSS VNB|VSS
+ sky130_fd_sc_hd__or3_1
X$3181 VDD synth_922 synth_1003 synth_1031 synth_765 VDD VNB|VSS VNB|VSS
+ sky130_fd_sc_hd__or3_1
X$3182 VDD synth_8646 synth_8478 synth_8824 synth_8588 VDD VNB|VSS VNB|VSS
+ sky130_fd_sc_hd__or3_1
X$3183 VDD synth_5817 synth_5818 synth_6211 synth_6072 VDD VNB|VSS VNB|VSS
+ sky130_fd_sc_hd__or3_1
X$3184 VDD synth_4022 synth_4023 synth_4021 synth_3894 VDD VNB|VSS VNB|VSS
+ sky130_fd_sc_hd__or3_1
X$3185 VDD synth_4675 synth_4674 synth_4676 synth_4199 VDD VNB|VSS VNB|VSS
+ sky130_fd_sc_hd__or3_1
X$3186 VDD synth_6972 synth_7033 synth_4671 synth_7163 VDD VNB|VSS VNB|VSS
+ sky130_fd_sc_hd__or3_1
X$3187 VDD synth_5989 synth_5947 synth_474 synth_6115 VDD VNB|VSS VNB|VSS
+ sky130_fd_sc_hd__or3_1
X$3188 VDD synth_2120 synth_2048 synth_1965 synth_2050 VDD VNB|VSS VNB|VSS
+ sky130_fd_sc_hd__or3_1
X$3189 VDD synth_1212 synth_1194 synth_1290 synth_1485 VDD VNB|VSS VNB|VSS
+ sky130_fd_sc_hd__or3_1
X$3190 VDD synth_3860 synth_3859 synth_3858 synth_3552 VDD VNB|VSS VNB|VSS
+ sky130_fd_sc_hd__or3_1
X$3191 VDD synth_721 synth_888 synth_346 synth_980 VDD VNB|VSS VNB|VSS
+ sky130_fd_sc_hd__or3_1
X$3192 VDD synth_11684 synth_11546 synth_11683 synth_11769 VDD VNB|VSS VNB|VSS
+ sky130_fd_sc_hd__or3_1
X$3193 VDD synth_8333 synth_8414 synth_8332 synth_8357 VDD VNB|VSS VNB|VSS
+ sky130_fd_sc_hd__or3_1
X$3194 VDD synth_3042 synth_3116 synth_1081 synth_3117 VDD VNB|VSS VNB|VSS
+ sky130_fd_sc_hd__or3_1
X$3195 VDD synth_3631 synth_3698 synth_1213 synth_3682 VDD VNB|VSS VNB|VSS
+ sky130_fd_sc_hd__or3_1
X$3196 VDD synth_11959 synth_11955 synth_9691 synth_12133 VDD VNB|VSS VNB|VSS
+ sky130_fd_sc_hd__or3_1
X$3197 VDD synth_5398 synth_5242 synth_5286 synth_5399 VDD VNB|VSS VNB|VSS
+ sky130_fd_sc_hd__or3_1
X$3198 VDD synth_10495 synth_10531 synth_9297 synth_10561 VDD VNB|VSS VNB|VSS
+ sky130_fd_sc_hd__or3_1
X$3199 VDD synth_6962 synth_4185 synth_4650 synth_7186 VDD VNB|VSS VNB|VSS
+ sky130_fd_sc_hd__or3_1
X$3200 VDD synth_4365 synth_4361 synth_3964 synth_4364 VDD VNB|VSS VNB|VSS
+ sky130_fd_sc_hd__or3_1
X$3201 VDD synth_2196 synth_2174 synth_346 synth_2195 VDD VNB|VSS VNB|VSS
+ sky130_fd_sc_hd__or3_1
X$3202 VDD synth_12601 synth_12672 synth_12600 synth_12729 VDD VNB|VSS VNB|VSS
+ sky130_fd_sc_hd__or3_1
X$3203 VDD synth_8361 synth_8437 synth_8440 synth_8466 VDD VNB|VSS VNB|VSS
+ sky130_fd_sc_hd__or3_1
X$3204 VDD synth_12602 synth_12672 synth_12603 synth_12730 VDD VNB|VSS VNB|VSS
+ sky130_fd_sc_hd__or3_1
X$3205 VDD synth_8873 synth_9062 synth_9042 synth_10833 VDD VNB|VSS VNB|VSS
+ sky130_fd_sc_hd__or3_1
X$3206 VDD synth_9999 synth_10168 synth_9049 synth_10091 VDD VNB|VSS VNB|VSS
+ sky130_fd_sc_hd__or3_1
X$3207 VDD synth_6240 synth_6200 synth_474 synth_6152 VDD VNB|VSS VNB|VSS
+ sky130_fd_sc_hd__or3_1
X$3208 VDD synth_11162 synth_11006 synth_9049 synth_11089 VDD VNB|VSS VNB|VSS
+ sky130_fd_sc_hd__or3_1
X$3209 VDD synth_12183 synth_12118 synth_12116 synth_12247 VDD VNB|VSS VNB|VSS
+ sky130_fd_sc_hd__or3_1
X$3210 VDD synth_12620 synth_12511 synth_9691 synth_12573 VDD VNB|VSS VNB|VSS
+ sky130_fd_sc_hd__or3_1
X$3211 VDD synth_8558 synth_8414 synth_8557 synth_8559 VDD VNB|VSS VNB|VSS
+ sky130_fd_sc_hd__or3_1
X$3212 VDD synth_11394 synth_11546 synth_11547 synth_11560 VDD VNB|VSS VNB|VSS
+ sky130_fd_sc_hd__or3_1
X$3213 VDD synth_8873 synth_9062 synth_9698 synth_9737 VDD VNB|VSS VNB|VSS
+ sky130_fd_sc_hd__or3_1
X$3214 VDD synth_178 synth_366 synth_474 synth_503 VDD VNB|VSS VNB|VSS
+ sky130_fd_sc_hd__or3_1
X$3215 VDD synth_8910 synth_8738 synth_8604 synth_9060 VDD VNB|VSS VNB|VSS
+ sky130_fd_sc_hd__or3_1
X$3216 VDD synth_8806 synth_8604 synth_8831 synth_8802 VDD VNB|VSS VNB|VSS
+ sky130_fd_sc_hd__or3_1
X$3217 VDD synth_12368 synth_12473 synth_12419 synth_12420 VDD VNB|VSS VNB|VSS
+ sky130_fd_sc_hd__or3_1
X$3218 VDD synth_4458 synth_4538 synth_4392 synth_4943 VDD VNB|VSS VNB|VSS
+ sky130_fd_sc_hd__or3_1
X$3219 VDD synth_3294 synth_3167 synth_3527 synth_3369 VDD VNB|VSS VNB|VSS
+ sky130_fd_sc_hd__or3_1
X$3220 VDD synth_3367 synth_3366 synth_3291 synth_3368 VDD VNB|VSS VNB|VSS
+ sky130_fd_sc_hd__or3_1
X$3221 VDD synth_5627 synth_5624 synth_581 synth_5689 VDD VNB|VSS VNB|VSS
+ sky130_fd_sc_hd__or3_1
X$3222 VDD synth_5911 synth_5912 synth_581 synth_5937 VDD VNB|VSS VNB|VSS
+ sky130_fd_sc_hd__or3_1
X$3223 VDD synth_2091 synth_2043 synth_1955 synth_1723 VDD VNB|VSS VNB|VSS
+ sky130_fd_sc_hd__or3_1
X$3224 VDD synth_10715 synth_10718 synth_9691 synth_10716 VDD VNB|VSS VNB|VSS
+ sky130_fd_sc_hd__or3_1
X$3225 VDD synth_5791 synth_5730 synth_5286 synth_5839 VDD VNB|VSS VNB|VSS
+ sky130_fd_sc_hd__or3_1
X$3226 VDD synth_6818 synth_6750 synth_4674 synth_5900 VDD VNB|VSS VNB|VSS
+ sky130_fd_sc_hd__or3_1
X$3227 VDD synth_7326 synth_7327 synth_5286 synth_7375 VDD VNB|VSS VNB|VSS
+ sky130_fd_sc_hd__or3_1
X$3228 VDD synth_7601 synth_7590 synth_7805 synth_6727 VDD VNB|VSS VNB|VSS
+ sky130_fd_sc_hd__or3_1
X$3229 VDD synth_5668 synth_5646 synth_5286 synth_5667 VDD VNB|VSS VNB|VSS
+ sky130_fd_sc_hd__or3_1
X$3230 VDD synth_1968 synth_2005 synth_1969 synth_1736 VDD VNB|VSS VNB|VSS
+ sky130_fd_sc_hd__or3_1
X$3231 VDD synth_5557 synth_5593 synth_5286 synth_5644 VDD VNB|VSS VNB|VSS
+ sky130_fd_sc_hd__or3_1
X$3232 VDD synth_3619 synth_3365 synth_850 synth_3546 VDD VNB|VSS VNB|VSS
+ sky130_fd_sc_hd__or3_1
X$3233 VDD synth_7119 synth_7209 synth_6211 synth_7207 VDD VNB|VSS VNB|VSS
+ sky130_fd_sc_hd__or3_1
X$3234 VDD synth_7481 synth_7612 synth_7435 synth_7569 VDD VNB|VSS VNB|VSS
+ sky130_fd_sc_hd__or3_1
X$3235 VDD synth_6663 synth_6595 synth_6268 synth_6774 VDD VNB|VSS VNB|VSS
+ sky130_fd_sc_hd__or3_1
X$3236 VDD synth_8603 synth_8514 synth_7435 synth_8599 VDD VNB|VSS VNB|VSS
+ sky130_fd_sc_hd__or3_1
X$3237 VDD synth_6683 synth_4743 synth_4674 synth_6685 VDD VNB|VSS VNB|VSS
+ sky130_fd_sc_hd__or3_1
X$3238 VDD synth_5267 synth_5346 synth_5211 synth_5266 VDD VNB|VSS VNB|VSS
+ sky130_fd_sc_hd__or3_1
X$3239 VDD synth_3889 synth_3888 synth_3859 VNB|VSS VDD VNB|VSS
+ sky130_fd_sc_hd__nand2b_1
X$3240 VDD synth_1579 synth_1628 synth_1762 VNB|VSS VDD VNB|VSS
+ sky130_fd_sc_hd__nand2b_1
X$3241 VDD synth_4705 synth_4795 synth_4845 VNB|VSS VDD VNB|VSS
+ sky130_fd_sc_hd__nand2b_1
X$3242 VDD synth_4948 synth_4851 synth_4613 VNB|VSS VDD VNB|VSS
+ sky130_fd_sc_hd__nand2b_1
X$3243 VDD synth_1675 synth_1546 synth_2002 VNB|VSS VDD VNB|VSS
+ sky130_fd_sc_hd__nand2b_1
X$3244 VDD synth_11466 synth_8873 synth_11570 VNB|VSS VDD VNB|VSS
+ sky130_fd_sc_hd__nand2b_1
X$3245 VDD synth_5627 synth_5573 synth_5628 VNB|VSS VDD VNB|VSS
+ sky130_fd_sc_hd__nand2b_1
X$3246 VDD synth_10793 synth_10312 synth_10778 VNB|VSS VDD VNB|VSS
+ sky130_fd_sc_hd__nand2b_1
X$3247 VDD synth_3662 synth_3858 synth_3291 VNB|VSS VDD VNB|VSS
+ sky130_fd_sc_hd__nand2b_1
X$3248 VDD synth_3843 synth_3908 synth_3905 VNB|VSS VDD VNB|VSS
+ sky130_fd_sc_hd__nand2b_1
X$3249 VDD synth_2211 synth_2283 synth_2347 VNB|VSS VDD VNB|VSS
+ sky130_fd_sc_hd__nand2b_1
X$3250 VDD synth_2296 synth_2290 synth_2358 VNB|VSS VDD VNB|VSS
+ sky130_fd_sc_hd__nand2b_1
X$3251 VDD synth_6695 synth_8197 synth_8654 VNB|VSS VDD VNB|VSS
+ sky130_fd_sc_hd__nand2b_1
X$3252 VDD synth_3491 synth_3364 synth_3617 VNB|VSS VDD VNB|VSS
+ sky130_fd_sc_hd__nand2b_1
X$3253 VDD synth_10495 synth_10466 synth_10563 VNB|VSS VDD VNB|VSS
+ sky130_fd_sc_hd__nand2b_1
X$3254 VDD synth_3258 synth_3482 synth_3412 VNB|VSS VDD VNB|VSS
+ sky130_fd_sc_hd__nand2b_1
X$3255 VDD synth_4291 synth_4376 synth_4474 VNB|VSS VDD VNB|VSS
+ sky130_fd_sc_hd__nand2b_1
X$3256 VDD synth_6395 synth_6425 synth_6589 VNB|VSS VDD VNB|VSS
+ sky130_fd_sc_hd__nand2b_1
X$3257 VDD synth_11157 synth_11207 synth_11206 VNB|VSS VDD VNB|VSS
+ sky130_fd_sc_hd__nand2b_1
X$3258 VDD synth_10507 synth_10504 synth_10572 VNB|VSS VDD VNB|VSS
+ sky130_fd_sc_hd__nand2b_1
X$3259 VDD synth_3254 synth_3256 synth_3482 VNB|VSS VDD VNB|VSS
+ sky130_fd_sc_hd__nand2b_1
X$3260 VDD synth_754 synth_730 synth_792 VNB|VSS VDD VNB|VSS
+ sky130_fd_sc_hd__nand2b_1
X$3261 VDD synth_2895 synth_2977 synth_3053 VNB|VSS VDD VNB|VSS
+ sky130_fd_sc_hd__nand2b_1
X$3262 VDD synth_3451 synth_3617 synth_3584 VNB|VSS VDD VNB|VSS
+ sky130_fd_sc_hd__nand2b_1
X$3263 VDD synth_1348 synth_1179 synth_1260 VNB|VSS VDD VNB|VSS
+ sky130_fd_sc_hd__nand2b_1
X$3264 VDD synth_2056 synth_2012 synth_2164 VNB|VSS VDD VNB|VSS
+ sky130_fd_sc_hd__nand2b_1
X$3265 VDD synth_11126 synth_11206 synth_11078 VNB|VSS VDD VNB|VSS
+ sky130_fd_sc_hd__nand2b_1
X$3266 VDD synth_3237 synth_3236 synth_3439 VNB|VSS VDD VNB|VSS
+ sky130_fd_sc_hd__nand2b_1
X$3267 VDD synth_10532 synth_10565 synth_10750 VNB|VSS VDD VNB|VSS
+ sky130_fd_sc_hd__nand2b_1
X$3268 VDD synth_4846 synth_4845 synth_4844 VNB|VSS VDD VNB|VSS
+ sky130_fd_sc_hd__nand2b_1
X$3269 VDD synth_84 synth_146 synth_281 VNB|VSS VDD VNB|VSS
+ sky130_fd_sc_hd__nand2b_1
X$3270 VDD synth_6240 synth_6200 synth_6300 VNB|VSS VDD VNB|VSS
+ sky130_fd_sc_hd__nand2b_1
X$3271 VDD synth_620 synth_759 synth_823 VNB|VSS VDD VNB|VSS
+ sky130_fd_sc_hd__nand2b_1
X$3272 VDD synth_5668 synth_5646 synth_5740 VNB|VSS VDD VNB|VSS
+ sky130_fd_sc_hd__nand2b_1
X$3273 VDD synth_161 synth_529 synth_356 VNB|VSS VDD VNB|VSS
+ sky130_fd_sc_hd__nand2b_1
X$3274 VDD synth_1131 synth_1173 synth_1241 VNB|VSS VDD VNB|VSS
+ sky130_fd_sc_hd__nand2b_1
X$3275 VDD synth_5225 synth_5308 synth_5330 VNB|VSS VDD VNB|VSS
+ sky130_fd_sc_hd__nand2b_1
X$3276 VDD synth_5331 synth_5330 synth_4325 VNB|VSS VDD VNB|VSS
+ sky130_fd_sc_hd__nand2b_1
X$3277 VDD synth_1172 synth_1241 synth_1313 VNB|VSS VDD VNB|VSS
+ sky130_fd_sc_hd__nand2b_1
X$3278 VDD synth_9563 synth_9509 synth_8939 VNB|VSS VDD VNB|VSS
+ sky130_fd_sc_hd__nand2b_1
X$3279 VDD synth_3373 synth_3375 synth_3513 VNB|VSS VDD VNB|VSS
+ sky130_fd_sc_hd__nand2b_1
X$3280 VDD synth_1731 synth_1729 synth_1641 VNB|VSS VDD VNB|VSS
+ sky130_fd_sc_hd__nand2b_1
X$3281 VDD synth_5858 synth_5985 synth_5904 VNB|VSS VDD VNB|VSS
+ sky130_fd_sc_hd__nand2b_1
X$3282 VDD synth_1530 synth_1656 synth_1592 VNB|VSS VDD VNB|VSS
+ sky130_fd_sc_hd__nand2b_1
X$3283 VDD synth_9062 synth_8873 synth_9039 VNB|VSS VDD VNB|VSS
+ sky130_fd_sc_hd__nand2b_1
X$3284 VDD synth_3033 synth_2849 synth_3112 VNB|VSS VDD VNB|VSS
+ sky130_fd_sc_hd__nand2b_1
X$3285 VDD synth_246 synth_541 synth_336 VNB|VSS VDD VNB|VSS
+ sky130_fd_sc_hd__nand2b_1
X$3286 VDD synth_4660 synth_4806 synth_4526 VNB|VSS VDD VNB|VSS
+ sky130_fd_sc_hd__nand2b_1
X$3287 VDD synth_178 synth_179 synth_502 VNB|VSS VDD VNB|VSS
+ sky130_fd_sc_hd__nand2b_1
X$3288 VDD synth_269 synth_137 synth_541 VNB|VSS VDD VNB|VSS
+ sky130_fd_sc_hd__nand2b_1
X$3289 VDD synth_1360 synth_1516 synth_1494 VNB|VSS VDD VNB|VSS
+ sky130_fd_sc_hd__nand2b_1
X$3290 VDD synth_5986 synth_5904 synth_5724 VNB|VSS VDD VNB|VSS
+ sky130_fd_sc_hd__nand2b_1
X$3291 VDD synth_851 synth_839 synth_924 VNB|VSS VDD VNB|VSS
+ sky130_fd_sc_hd__nand2b_1
X$3292 VDD synth_1953 synth_1949 synth_1951 VNB|VSS VDD VNB|VSS
+ sky130_fd_sc_hd__nand2b_1
X$3293 VDD synth_5155 synth_5154 synth_5151 VNB|VSS VDD VNB|VSS
+ sky130_fd_sc_hd__nand2b_1
X$3294 VDD synth_2422 synth_2334 synth_2307 VNB|VSS VDD VNB|VSS
+ sky130_fd_sc_hd__nand2b_1
X$3295 VDD synth_1278 synth_1220 synth_1857 VNB|VSS VDD VNB|VSS
+ sky130_fd_sc_hd__nand2b_1
X$3296 VDD synth_10425 synth_10265 synth_10502 VNB|VSS VDD VNB|VSS
+ sky130_fd_sc_hd__nand2b_1
X$3297 VDD synth_4268 synth_4183 synth_4320 VNB|VSS VDD VNB|VSS
+ sky130_fd_sc_hd__nand2b_1
X$3298 VDD synth_2365 synth_2360 synth_2368 VNB|VSS VDD VNB|VSS
+ sky130_fd_sc_hd__nand2b_1
X$3299 VDD synth_10356 synth_10502 synth_9723 VNB|VSS VDD VNB|VSS
+ sky130_fd_sc_hd__nand2b_1
X$3300 VDD synth_918 synth_1084 synth_1112 VNB|VSS VDD VNB|VSS
+ sky130_fd_sc_hd__nand2b_1
X$3301 VDD synth_10566 synth_10750 synth_10497 VNB|VSS VDD VNB|VSS
+ sky130_fd_sc_hd__nand2b_1
X$3302 VDD synth_5013 synth_5012 synth_4914 VNB|VSS VDD VNB|VSS
+ sky130_fd_sc_hd__nand2b_1
X$3303 VDD synth_5382 synth_5491 synth_5488 VNB|VSS VDD VNB|VSS
+ sky130_fd_sc_hd__nand2b_1
X$3304 VDD synth_9489 synth_9532 synth_9397 VNB|VSS VDD VNB|VSS
+ sky130_fd_sc_hd__nand2b_1
X$3305 VDD synth_185 synth_281 synth_280 VNB|VSS VDD VNB|VSS
+ sky130_fd_sc_hd__nand2b_1
X$3306 VDD synth_2768 synth_2647 synth_2694 VNB|VSS VDD VNB|VSS
+ sky130_fd_sc_hd__nand2b_1
X$3307 VDD synth_976 synth_1029 synth_974 VNB|VSS VDD VNB|VSS
+ sky130_fd_sc_hd__nand2b_1
X$3308 VDD synth_296 synth_164 synth_529 VNB|VSS VDD VNB|VSS
+ sky130_fd_sc_hd__nand2b_1
X$3309 VDD synth_6224 synth_6139 synth_6501 VNB|VSS VDD VNB|VSS
+ sky130_fd_sc_hd__nand2b_1
X$3310 VDD synth_4027 synth_4192 synth_4025 VNB|VSS VDD VNB|VSS
+ sky130_fd_sc_hd__nand2b_1
X$3311 VDD synth_868 synth_1069 synth_1029 VNB|VSS VDD VNB|VSS
+ sky130_fd_sc_hd__nand2b_1
X$3312 VDD synth_4890 synth_4974 synth_5012 VNB|VSS VDD VNB|VSS
+ sky130_fd_sc_hd__nand2b_1
X$3313 VDD synth_5419 synth_5075 synth_5318 VNB|VSS VDD VNB|VSS
+ sky130_fd_sc_hd__nand2b_1
X$3314 VDD synth_4758 synth_4759 synth_4851 VNB|VSS VDD VNB|VSS
+ sky130_fd_sc_hd__nand2b_1
X$3315 VDD synth_8091 synth_8013 synth_8090 VNB|VSS VDD VNB|VSS
+ sky130_fd_sc_hd__nand2b_1
X$3316 VDD synth_354 synth_290 synth_289 VNB|VSS VDD VNB|VSS
+ sky130_fd_sc_hd__nand2b_1
X$3317 VDD synth_758 synth_823 synth_910 VNB|VSS VDD VNB|VSS
+ sky130_fd_sc_hd__nand2b_1
X$3318 VDD synth_992 synth_826 synth_994 VNB|VSS VDD VNB|VSS
+ sky130_fd_sc_hd__nand2b_1
X$3319 VDD synth_994 synth_1124 synth_151 synth_993 VNB|VSS VDD synth_959
+ VNB|VSS sky130_fd_sc_hd__a31oi_1
X$3320 VDD synth_12326 synth_12352 synth_12430 VNB|VSS VDD VNB|VSS
+ sky130_fd_sc_hd__nand2b_1
X$3321 VDD synth_12293 synth_12430 synth_12375 VNB|VSS VDD VNB|VSS
+ sky130_fd_sc_hd__nand2b_1
X$3322 VDD synth_7655 synth_7581 synth_7701 VNB|VSS VDD VNB|VSS
+ sky130_fd_sc_hd__nand2b_1
X$3323 VDD synth_835 synth_919 synth_1084 VNB|VSS VDD VNB|VSS
+ sky130_fd_sc_hd__nand2b_1
X$3324 VDD synth_7481 synth_7612 synth_7391 VNB|VSS VDD VNB|VSS
+ sky130_fd_sc_hd__nand2b_1
X$3325 VDD synth_7930 synth_8002 synth_7979 VNB|VSS VDD VNB|VSS
+ sky130_fd_sc_hd__nand2b_1
X$3326 VDD synth_7787 synth_7932 synth_8002 VNB|VSS VDD VNB|VSS
+ sky130_fd_sc_hd__nand2b_1
X$3327 VDD synth_7969 synth_7995 synth_8159 VNB|VSS VDD VNB|VSS
+ sky130_fd_sc_hd__nand2b_1
X$3328 VDD synth_9315 synth_9420 synth_9417 VNB|VSS VDD VNB|VSS
+ sky130_fd_sc_hd__nand2b_1
X$3329 VDD synth_7312 synth_7407 synth_7171 VNB|VSS VDD VNB|VSS
+ sky130_fd_sc_hd__nand2b_1
X$3330 VDD synth_4813 synth_4637 synth_4992 VNB|VSS VDD VNB|VSS
+ sky130_fd_sc_hd__nand2b_1
X$3331 VDD synth_1286 synth_1190 synth_1366 VNB|VSS VDD VNB|VSS
+ sky130_fd_sc_hd__nand2b_1
X$3332 VDD synth_6809 synth_6806 synth_5988 VNB|VSS VDD VNB|VSS
+ sky130_fd_sc_hd__nand2b_1
X$3333 VDD synth_12011 synth_12038 synth_12037 VNB|VSS VDD VNB|VSS
+ sky130_fd_sc_hd__nand2b_1
X$3334 VDD synth_243 synth_171 synth_290 VNB|VSS VDD VNB|VSS
+ sky130_fd_sc_hd__nand2b_1
X$3335 VDD synth_1274 synth_1361 synth_1516 VNB|VSS VDD VNB|VSS
+ sky130_fd_sc_hd__nand2b_1
X$3336 VDD synth_7662 synth_7660 synth_7414 VNB|VSS VDD VNB|VSS
+ sky130_fd_sc_hd__nand2b_1
X$3337 VDD synth_4086 synth_4312 synth_4261 VNB|VSS VDD VNB|VSS
+ sky130_fd_sc_hd__nand2b_1
X$3338 VDD synth_4013 synth_4012 synth_4312 VNB|VSS VDD VNB|VSS
+ sky130_fd_sc_hd__nand2b_1
X$3339 VDD synth_3989 synth_4221 synth_4113 VNB|VSS VDD VNB|VSS
+ sky130_fd_sc_hd__nand2b_1
X$3340 VDD synth_8087 synth_7899 synth_8009 VNB|VSS VDD VNB|VSS
+ sky130_fd_sc_hd__nand2b_1
X$3341 VDD synth_9474 synth_9434 synth_9906 VNB|VSS VDD VNB|VSS
+ sky130_fd_sc_hd__nand2b_1
X$3342 VDD synth_8835 synth_8942 synth_8383 VNB|VSS VDD VNB|VSS
+ sky130_fd_sc_hd__nand2b_1
X$3343 VDD synth_8617 synth_8618 synth_6888 VNB|VSS VDD VNB|VSS
+ sky130_fd_sc_hd__nand2b_1
X$3344 VDD synth_1271 synth_1358 synth_1354 VNB|VSS VDD VNB|VSS
+ sky130_fd_sc_hd__nand2b_1
X$3345 VDD synth_5339 synth_5317 synth_5075 VNB|VSS VDD VNB|VSS
+ sky130_fd_sc_hd__nand2b_1
X$3346 VDD synth_12620 synth_12574 synth_12660 VNB|VSS VDD VNB|VSS
+ sky130_fd_sc_hd__nand2b_1
X$3347 VDD synth_9133 synth_9161 synth_9214 VNB|VSS VDD VNB|VSS
+ sky130_fd_sc_hd__nand2b_1
X$3348 VDD synth_4077 synth_4098 synth_4192 VNB|VSS VDD VNB|VSS
+ sky130_fd_sc_hd__nand2b_1
X$3349 VDD synth_1356 synth_1354 synth_1509 VNB|VSS VDD VNB|VSS
+ sky130_fd_sc_hd__nand2b_1
X$3350 VDD synth_99 synth_298 synth_628 VNB|VSS VDD VNB|VSS
+ sky130_fd_sc_hd__nand2b_1
X$3351 VDD synth_830 synth_917 synth_996 VNB|VSS VDD VNB|VSS
+ sky130_fd_sc_hd__nand2b_1
X$3352 VDD synth_9610 synth_9665 synth_9620 VNB|VSS VDD VNB|VSS
+ sky130_fd_sc_hd__nand2b_1
X$3353 VDD synth_2538 synth_2703 synth_2457 VNB|VSS VDD VNB|VSS
+ sky130_fd_sc_hd__nand2b_1
X$3354 VDD synth_6670 synth_6721 synth_6966 VNB|VSS VDD VNB|VSS
+ sky130_fd_sc_hd__nand2b_1
X$3355 VDD synth_8516 synth_8441 synth_8552 VNB|VSS VDD VNB|VSS
+ sky130_fd_sc_hd__nand2b_1
X$3356 VDD synth_8783 synth_8744 synth_8865 VNB|VSS VDD VNB|VSS
+ sky130_fd_sc_hd__nand2b_1
X$3357 VDD synth_5992 synth_6160 synth_5585 VNB|VSS VDD VNB|VSS
+ sky130_fd_sc_hd__nand2b_1
X$3358 VDD synth_9434 synth_10793 synth_10510 VNB|VSS VDD VNB|VSS
+ sky130_fd_sc_hd__nand2b_1
X$3359 VDD synth_11284 synth_11374 synth_11451 VNB|VSS VDD VNB|VSS
+ sky130_fd_sc_hd__nand2b_1
X$3360 VDD synth_2403 synth_2540 synth_2587 VNB|VSS VDD VNB|VSS
+ sky130_fd_sc_hd__nand2b_1
X$3361 VDD synth_733 synth_662 synth_938 VNB|VSS VDD VNB|VSS
+ sky130_fd_sc_hd__nand2b_1
X$3362 VDD synth_5757 synth_5678 synth_5679 VNB|VSS VDD VNB|VSS
+ sky130_fd_sc_hd__nand2b_1
X$3363 VDD synth_9343 synth_9341 synth_9189 VNB|VSS VDD VNB|VSS
+ sky130_fd_sc_hd__nand2b_1
X$3364 VDD synth_1626 synth_1697 synth_1624 VNB|VSS VDD VNB|VSS
+ sky130_fd_sc_hd__nand2b_1
X$3365 VDD synth_11162 synth_10986 synth_11246 VNB|VSS VDD VNB|VSS
+ sky130_fd_sc_hd__nand2b_1
X$3366 VDD synth_1730 synth_1640 synth_1729 VNB|VSS VDD VNB|VSS
+ sky130_fd_sc_hd__nand2b_1
X$3367 VDD synth_6644 synth_6608 synth_5726 VNB|VSS VDD VNB|VSS
+ sky130_fd_sc_hd__nand2b_1
X$3368 VDD synth_5405 synth_5488 synth_5737 VNB|VSS VDD VNB|VSS
+ sky130_fd_sc_hd__nand2b_1
X$3369 VDD synth_7601 synth_7590 synth_6696 VNB|VSS VDD VNB|VSS
+ sky130_fd_sc_hd__nand2b_1
X$3370 VDD synth_6826 synth_6905 synth_6717 VNB|VSS VDD VNB|VSS
+ sky130_fd_sc_hd__nand2b_1
X$3371 VDD synth_10785 synth_10854 synth_9806 VNB|VSS VDD VNB|VSS
+ sky130_fd_sc_hd__nand2b_1
X$3372 VDD synth_3587 synth_3643 synth_3570 VNB|VSS VDD VNB|VSS
+ sky130_fd_sc_hd__nand2b_1
X$3373 VDD synth_6465 synth_6482 synth_6558 VNB|VSS VDD VNB|VSS
+ sky130_fd_sc_hd__nand2b_1
X$3374 VDD synth_8528 synth_8696 synth_8618 VNB|VSS VDD VNB|VSS
+ sky130_fd_sc_hd__nand2b_1
X$3375 VDD synth_1093 synth_1058 synth_1207 VNB|VSS VDD VNB|VSS
+ sky130_fd_sc_hd__nand2b_1
X$3376 VDD synth_1128 synth_972 synth_1058 VNB|VSS VDD VNB|VSS
+ sky130_fd_sc_hd__nand2b_1
X$3377 VDD synth_6464 synth_6558 synth_6556 VNB|VSS VDD VNB|VSS
+ sky130_fd_sc_hd__nand2b_1
X$3378 VDD synth_6789 synth_6891 synth_6738 VNB|VSS VDD VNB|VSS
+ sky130_fd_sc_hd__nand2b_1
X$3379 VDD synth_6737 synth_6788 synth_6891 VNB|VSS VDD VNB|VSS
+ sky130_fd_sc_hd__nand2b_1
X$3380 VDD synth_3572 synth_3570 synth_3509 VNB|VSS VDD VNB|VSS
+ sky130_fd_sc_hd__nand2b_1
X$3381 VDD synth_1303 synth_1198 synth_1300 VNB|VSS VDD VNB|VSS
+ sky130_fd_sc_hd__nand2b_1
X$3382 VDD synth_6003 synth_6006 synth_6004 VNB|VSS VDD VNB|VSS
+ sky130_fd_sc_hd__nand2b_1
X$3383 VDD synth_3518 synth_3345 synth_3681 VNB|VSS VDD VNB|VSS
+ sky130_fd_sc_hd__nand2b_1
X$3384 VDD synth_6428 synth_6590 synth_6317 VNB|VSS VDD VNB|VSS
+ sky130_fd_sc_hd__nand2b_1
X$3385 VDD synth_9690 synth_9620 synth_9500 VNB|VSS VDD VNB|VSS
+ sky130_fd_sc_hd__nand2b_1
X$3386 VDD synth_12587 synth_12588 synth_12586 VNB|VSS VDD VNB|VSS
+ sky130_fd_sc_hd__nand2b_1
X$3387 VDD synth_6354 synth_6429 synth_6590 VNB|VSS VDD VNB|VSS
+ sky130_fd_sc_hd__nand2b_1
X$3388 VDD synth_7880 synth_7805 synth_7345 VNB|VSS VDD VNB|VSS
+ sky130_fd_sc_hd__nand2b_1
X$3389 VDD synth_10023 synth_10022 synth_9948 VNB|VSS VDD VNB|VSS
+ sky130_fd_sc_hd__nand2b_1
X$3390 VDD synth_12518 synth_12517 synth_12087 VNB|VSS VDD VNB|VSS
+ sky130_fd_sc_hd__nand2b_1
X$3391 VDD synth_5680 synth_5709 synth_5678 VNB|VSS VDD VNB|VSS
+ sky130_fd_sc_hd__nand2b_1
X$3392 VDD synth_6747 synth_6899 synth_6678 VNB|VSS VDD VNB|VSS
+ sky130_fd_sc_hd__nand2b_1
X$3393 VDD synth_10822 synth_10856 synth_10854 VNB|VSS VDD VNB|VSS
+ sky130_fd_sc_hd__nand2b_1
X$3394 VDD synth_2581 synth_2407 synth_2703 VNB|VSS VDD VNB|VSS
+ sky130_fd_sc_hd__nand2b_1
X$3395 VDD synth_338 synth_475 synth_391 VNB|VSS VDD VNB|VSS
+ sky130_fd_sc_hd__nand2b_1
X$3396 VDD synth_10505 synth_10572 synth_10632 VNB|VSS VDD VNB|VSS
+ sky130_fd_sc_hd__nand2b_1
X$3397 VDD synth_12437 synth_12383 synth_12399 VNB|VSS VDD VNB|VSS
+ sky130_fd_sc_hd__nand2b_1
X$3398 VDD synth_9947 synth_10022 synth_10187 VNB|VSS VDD VNB|VSS
+ sky130_fd_sc_hd__nand2b_1
X$3399 VDD synth_6720 synth_6966 synth_6800 VNB|VSS VDD VNB|VSS
+ sky130_fd_sc_hd__nand2b_1
X$3400 VDD synth_5184 synth_5185 synth_5171 VNB|VSS VDD VNB|VSS
+ sky130_fd_sc_hd__nand2b_1
X$3401 VDD synth_79 synth_339 synth_475 VNB|VSS VDD VNB|VSS
+ sky130_fd_sc_hd__nand2b_1
X$3402 VDD synth_1627 synth_1762 synth_1501 VNB|VSS VDD VNB|VSS
+ sky130_fd_sc_hd__nand2b_1
X$3403 VDD synth_10022 synth_9947 synth_10122 VNB|VSS VDD VNB|VSS
+ sky130_fd_sc_hd__nand2b_1
X$3404 VDD synth_6732 synth_6678 synth_5612 VNB|VSS VDD VNB|VSS
+ sky130_fd_sc_hd__nand2b_1
X$3405 VDD synth_617 synth_619 synth_730 VNB|VSS VDD VNB|VSS
+ sky130_fd_sc_hd__nand2b_1
X$3406 VDD synth_9677 synth_9474 synth_10576 VNB|VSS VDD VNB|VSS
+ sky130_fd_sc_hd__nand2b_1
X$3407 VDD synth_5183 synth_5173 synth_5185 VNB|VSS VDD VNB|VSS
+ sky130_fd_sc_hd__nand2b_1
X$3408 VDD synth_4582 synth_4583 synth_4695 VNB|VSS VDD VNB|VSS
+ sky130_fd_sc_hd__nand2b_1
X$3409 VDD synth_4584 synth_4695 synth_4581 VNB|VSS VDD VNB|VSS
+ sky130_fd_sc_hd__nand2b_1
X$3410 VDD synth_2264 synth_2262 synth_2301 VNB|VSS VDD VNB|VSS
+ sky130_fd_sc_hd__nand2b_1
X$3411 VDD synth_226 synth_158 synth_352 VNB|VSS VDD VNB|VSS
+ sky130_fd_sc_hd__nand2b_1
X$3412 VDD synth_1944 synth_1871 synth_1875 VNB|VSS VDD VNB|VSS
+ sky130_fd_sc_hd__nand2b_1
X$3413 VDD synth_45 synth_141 synth_436 VNB|VSS VDD VNB|VSS
+ sky130_fd_sc_hd__nand2b_1
X$3414 VDD synth_5969 synth_6024 synth_5970 VNB|VSS VDD VNB|VSS
+ sky130_fd_sc_hd__nand2b_1
X$3415 VDD synth_3907 synth_3905 synth_3918 VNB|VSS VDD VNB|VSS
+ sky130_fd_sc_hd__nand2b_1
X$3416 VDD synth_6526 synth_6527 synth_6674 VNB|VSS VDD VNB|VSS
+ sky130_fd_sc_hd__nand2b_1
X$3417 VDD synth_11959 synth_11955 synth_11957 VNB|VSS VDD VNB|VSS
+ sky130_fd_sc_hd__nand2b_1
X$3418 VDD synth_7031 synth_7032 synth_7112 VNB|VSS VDD VNB|VSS
+ sky130_fd_sc_hd__nand2b_1
X$3419 VDD synth_7326 synth_7401 synth_7403 VNB|VSS VDD VNB|VSS
+ sky130_fd_sc_hd__nand2b_1
X$3420 VDD synth_5888 synth_5970 synth_5968 VNB|VSS VDD VNB|VSS
+ sky130_fd_sc_hd__nand2b_1
X$3421 VDD synth_2776 synth_2947 synth_2946 VNB|VSS VDD VNB|VSS
+ sky130_fd_sc_hd__nand2b_1
X$3422 VDD synth_2726 synth_2866 synth_2947 VNB|VSS VDD VNB|VSS
+ sky130_fd_sc_hd__nand2b_1
X$3423 VDD synth_1823 synth_1824 synth_1821 VNB|VSS VDD VNB|VSS
+ sky130_fd_sc_hd__nand2b_1
X$3424 VDD synth_12400 synth_12399 synth_12103 VNB|VSS VDD VNB|VSS
+ sky130_fd_sc_hd__nand2b_1
X$3425 VDD synth_8910 synth_8738 synth_9580 VNB|VSS VDD VNB|VSS
+ sky130_fd_sc_hd__nand2b_1
X$3426 VDD synth_8780 synth_8801 synth_8942 VNB|VSS VDD VNB|VSS
+ sky130_fd_sc_hd__nand2b_1
X$3427 VDD synth_4103 synth_4193 synth_4030 VNB|VSS VDD VNB|VSS
+ sky130_fd_sc_hd__nand2b_1
X$3428 VDD synth_8064 synth_7908 synth_8149 VNB|VSS VDD VNB|VSS
+ sky130_fd_sc_hd__nand2b_1
X$3429 VDD synth_6426 synth_6589 synth_6130 VNB|VSS VDD VNB|VSS
+ sky130_fd_sc_hd__nand2b_1
X$3430 VDD synth_8171 synth_8169 synth_7313 VNB|VSS VDD VNB|VSS
+ sky130_fd_sc_hd__nand2b_1
X$3431 VDD synth_8168 synth_8170 synth_8169 VNB|VSS VDD VNB|VSS
+ sky130_fd_sc_hd__nand2b_1
X$3432 VDD synth_2540 synth_2403 synth_2624 VNB|VSS VDD VNB|VSS
+ sky130_fd_sc_hd__nand2b_1
X$3433 VDD synth_3974 synth_4040 synth_4221 VNB|VSS VDD VNB|VSS
+ sky130_fd_sc_hd__nand2b_1
X$3434 VDD synth_6675 synth_6674 synth_6673 VNB|VSS VDD VNB|VSS
+ sky130_fd_sc_hd__nand2b_1
X$3435 VDD synth_5993 synth_6161 synth_6160 VNB|VSS VDD VNB|VSS
+ sky130_fd_sc_hd__nand2b_1
X$3436 VDD synth_1262 synth_1260 synth_1258 VNB|VSS VDD VNB|VSS
+ sky130_fd_sc_hd__nand2b_1
X$3437 VDD synth_12522 synth_12586 synth_12089 VNB|VSS VDD VNB|VSS
+ sky130_fd_sc_hd__nand2b_1
X$3438 VDD synth_4211 synth_4122 synth_4294 VNB|VSS VDD VNB|VSS
+ sky130_fd_sc_hd__nand2b_1
X$3439 VDD synth_3389 synth_3306 synth_3386 VNB|VSS VDD VNB|VSS
+ sky130_fd_sc_hd__nand2b_1
X$3440 VDD synth_611 synth_668 synth_712 VNB|VSS VDD VNB|VSS
+ sky130_fd_sc_hd__nand2b_1
X$3441 VDD synth_8603 synth_8514 synth_8735 VNB|VSS VDD VNB|VSS
+ sky130_fd_sc_hd__nand2b_1
X$3442 VDD synth_4665 synth_4992 synth_4931 VNB|VSS VDD VNB|VSS
+ sky130_fd_sc_hd__nand2b_1
X$3443 VDD synth_2840 synth_2952 synth_2872 VNB|VSS VDD VNB|VSS
+ sky130_fd_sc_hd__nand2b_1
X$3444 VDD synth_1285 synth_1366 synth_1442 VNB|VSS VDD VNB|VSS
+ sky130_fd_sc_hd__nand2b_1
X$3445 VDD synth_9419 synth_9417 synth_9153 VNB|VSS VDD VNB|VSS
+ sky130_fd_sc_hd__nand2b_1
X$3446 VDD synth_7260 synth_7259 synth_7407 VNB|VSS VDD VNB|VSS
+ sky130_fd_sc_hd__nand2b_1
X$3447 VDD synth_4295 synth_4294 synth_4129 VNB|VSS VDD VNB|VSS
+ sky130_fd_sc_hd__nand2b_1
X$3448 VDD synth_7564 synth_7563 synth_7441 VNB|VSS VDD VNB|VSS
+ sky130_fd_sc_hd__nand2b_1
X$3449 VDD synth_8604 synth_8738 synth_8918 VNB|VSS VDD VNB|VSS
+ sky130_fd_sc_hd__nand2b_1
X$3450 VDD synth_1607 synth_1645 synth_1781 VNB|VSS VDD VNB|VSS
+ sky130_fd_sc_hd__nand2b_1
X$3451 VDD synth_224 synth_321 synth_516 VNB|VSS VDD VNB|VSS
+ sky130_fd_sc_hd__nand2b_1
X$3452 VDD synth_1932 synth_2094 synth_2118 VNB|VSS VDD VNB|VSS
+ sky130_fd_sc_hd__nand2b_1
X$3453 VDD synth_350 synth_516 synth_444 VNB|VSS VDD VNB|VSS
+ sky130_fd_sc_hd__nand2b_1
X$3454 VDD synth_2403 synth_2586 synth_2406 VNB|VSS VDD VNB|VSS
+ sky130_fd_sc_hd__nand2b_1
X$3455 VDD synth_6744 synth_6807 synth_6806 VNB|VSS VDD VNB|VSS
+ sky130_fd_sc_hd__nand2b_1
X$3456 VDD synth_3308 synth_3439 synth_3469 VNB|VSS VDD VNB|VSS
+ sky130_fd_sc_hd__nand2b_1
X$3457 VDD synth_1539 synth_1625 synth_1697 VNB|VSS VDD VNB|VSS
+ sky130_fd_sc_hd__nand2b_1
X$3458 VDD synth_1807 synth_1961 synth_1803 VNB|VSS VDD VNB|VSS
+ sky130_fd_sc_hd__nand2b_1
X$3459 VDD synth_826 synth_992 synth_1124 VNB|VSS VDD VNB|VSS
+ sky130_fd_sc_hd__nand2b_1
X$3460 VDD synth_6642 synth_6680 synth_6608 VNB|VSS VDD VNB|VSS
+ sky130_fd_sc_hd__nand2b_1
X$3461 VDD synth_2288 synth_2358 synth_1978 VNB|VSS VDD VNB|VSS
+ sky130_fd_sc_hd__nand2b_1
X$3462 VDD synth_2263 synth_2377 synth_2262 VNB|VSS VDD VNB|VSS
+ sky130_fd_sc_hd__nand2b_1
X$3463 VDD synth_10793 synth_10578 synth_11382 VNB|VSS VDD VNB|VSS
+ sky130_fd_sc_hd__nand2b_1
X$3464 VDD synth_768 synth_842 synth_928 VNB|VSS VDD VNB|VSS
+ sky130_fd_sc_hd__nand2b_1
X$3465 VDD synth_7745 synth_7667 synth_7744 VNB|VSS VDD VNB|VSS
+ sky130_fd_sc_hd__nand2b_1
X$3466 VDD synth_7907 synth_8149 synth_7981 VNB|VSS VDD VNB|VSS
+ sky130_fd_sc_hd__nand2b_1
X$3467 VDD synth_992 synth_827 synth_1047 VNB|VSS VDD VNB|VSS
+ sky130_fd_sc_hd__nand2b_1
X$3468 VDD synth_1805 synth_1803 synth_1884 VNB|VSS VDD VNB|VSS
+ sky130_fd_sc_hd__nand2b_1
X$3469 VDD synth_5685 synth_5759 synth_5827 VNB|VSS VDD VNB|VSS
+ sky130_fd_sc_hd__nand2b_1
X$3470 VDD synth_7894 synth_8159 synth_8070 VNB|VSS VDD VNB|VSS
+ sky130_fd_sc_hd__nand2b_1
X$3471 VDD synth_5557 synth_5593 synth_5780 VNB|VSS VDD VNB|VSS
+ sky130_fd_sc_hd__nand2b_1
X$3472 VDD synth_12289 synth_12369 synth_12398 VNB|VSS VDD VNB|VSS
+ sky130_fd_sc_hd__nand2b_1
X$3473 VDD synth_1878 synth_1952 synth_1949 VNB|VSS VDD VNB|VSS
+ sky130_fd_sc_hd__nand2b_1
X$3474 VDD synth_9016 synth_8965 synth_9017 VNB|VSS VDD VNB|VSS
+ sky130_fd_sc_hd__nand2b_1
X$3475 VDD synth_9425 synth_9577 synth_9509 VNB|VSS VDD VNB|VSS
+ sky130_fd_sc_hd__nand2b_1
X$3476 VDD synth_2668 synth_2889 synth_2971 VNB|VSS VDD VNB|VSS
+ sky130_fd_sc_hd__nand2b_1
X$3477 VDD synth_197 synth_169 synth_499 VNB|VSS VDD VNB|VSS
+ sky130_fd_sc_hd__nand2b_1
X$3478 VDD synth_8831 synth_9474 synth_9384 VNB|VSS VDD VNB|VSS
+ sky130_fd_sc_hd__nand2b_1
X$3479 VDD synth_4655 synth_4592 synth_4642 VNB|VSS VDD VNB|VSS
+ sky130_fd_sc_hd__nand2b_1
X$3480 VDD synth_309 synth_106 synth_402 VNB|VSS VDD VNB|VSS
+ sky130_fd_sc_hd__nand2b_1
X$3481 VDD synth_8784 synth_8865 synth_8758 VNB|VSS VDD VNB|VSS
+ sky130_fd_sc_hd__nand2b_1
X$3482 VDD synth_5053 synth_5127 synth_5240 VNB|VSS VDD VNB|VSS
+ sky130_fd_sc_hd__nand2b_1
X$3483 VDD synth_2815 synth_2971 synth_2885 VNB|VSS VDD VNB|VSS
+ sky130_fd_sc_hd__nand2b_1
X$3484 VDD synth_4427 synth_4335 synth_4425 VNB|VSS VDD VNB|VSS
+ sky130_fd_sc_hd__nand2b_1
X$3485 VDD synth_2362 synth_2368 synth_1979 VNB|VSS VDD VNB|VSS
+ sky130_fd_sc_hd__nand2b_1
X$3486 VDD synth_8870 synth_9434 synth_10171 VNB|VSS VDD VNB|VSS
+ sky130_fd_sc_hd__nand2b_1
X$3487 VDD synth_5812 synth_5894 synth_4499 VNB|VSS VDD VNB|VSS
+ sky130_fd_sc_hd__nand2b_1
X$3488 VDD synth_1822 synth_1821 synth_1674 VNB|VSS VDD VNB|VSS
+ sky130_fd_sc_hd__nand2b_1
X$3489 VDD synth_3392 synth_3391 synth_3306 VNB|VSS VDD VNB|VSS
+ sky130_fd_sc_hd__nand2b_1
X$3490 VDD synth_5989 synth_6076 synth_6079 VNB|VSS VDD VNB|VSS
+ sky130_fd_sc_hd__nand2b_1
X$3491 VDD synth_8326 synth_8328 synth_8329 VNB|VSS VDD VNB|VSS
+ sky130_fd_sc_hd__nand2b_1
X$3492 VDD synth_8910 synth_8870 synth_9619 VNB|VSS VDD VNB|VSS
+ sky130_fd_sc_hd__nand2b_1
X$3493 VDD synth_11505 synth_11453 synth_11663 VNB|VSS VDD VNB|VSS
+ sky130_fd_sc_hd__nand2b_1
X$3494 VDD synth_2282 synth_2347 synth_2280 VNB|VSS VDD VNB|VSS
+ sky130_fd_sc_hd__nand2b_1
X$3495 VDD synth_284 synth_153 synth_218 VNB|VSS VDD VNB|VSS
+ sky130_fd_sc_hd__nand2b_1
X$3496 VDD synth_4386 synth_4425 synth_4399 VNB|VSS VDD VNB|VSS
+ sky130_fd_sc_hd__nand2b_1
X$3497 VDD synth_10887 synth_10886 synth_10850 VNB|VSS VDD VNB|VSS
+ sky130_fd_sc_hd__nand2b_1
X$3498 VDD synth_1195 synth_1292 synth_1371 VNB|VSS VDD VNB|VSS
+ sky130_fd_sc_hd__nand2b_1
X$3499 VDD synth_10925 synth_10850 synth_10921 VNB|VSS VDD VNB|VSS
+ sky130_fd_sc_hd__nand2b_1
X$3500 VDD synth_9400 synth_9397 synth_7058 VNB|VSS VDD VNB|VSS
+ sky130_fd_sc_hd__nand2b_1
X$3501 VDD synth_9215 synth_9214 synth_6842 VNB|VSS VDD VNB|VSS
+ sky130_fd_sc_hd__nand2b_1
X$3502 VDD synth_3519 synth_3432 synth_4064 VNB|VSS VDD VNB|VSS
+ sky130_fd_sc_hd__nand2b_1
X$3503 VDD synth_8769 synth_8812 synth_8819 VNB|VSS VDD VNB|VSS
+ sky130_fd_sc_hd__nand2b_1
X$3504 VDD synth_7030 synth_7112 synth_7164 VNB|VSS VDD VNB|VSS
+ sky130_fd_sc_hd__nand2b_1
X$3505 VDD synth_8806 synth_8831 synth_9550 VNB|VSS VDD VNB|VSS
+ sky130_fd_sc_hd__nand2b_1
X$3506 VDD synth_231 synth_402 synth_355 VNB|VSS VDD VNB|VSS
+ sky130_fd_sc_hd__nand2b_1
X$3507 VDD synth_8738 synth_8910 synth_9230 VNB|VSS VDD VNB|VSS
+ sky130_fd_sc_hd__nand2b_1
X$3508 VDD synth_1661 synth_1659 synth_1760 VNB|VSS VDD VNB|VSS
+ sky130_fd_sc_hd__nand2b_1
X$3509 VDD synth_3460 synth_3681 synth_3694 VNB|VSS VDD VNB|VSS
+ sky130_fd_sc_hd__nand2b_1
X$3510 VDD synth_7626 synth_7736 synth_7660 VNB|VSS VDD VNB|VSS
+ sky130_fd_sc_hd__nand2b_1
X$3511 VDD synth_4594 synth_4662 synth_4806 VNB|VSS VDD VNB|VSS
+ sky130_fd_sc_hd__nand2b_1
X$3512 VDD synth_456 synth_498 synth_604 VNB|VSS VDD VNB|VSS
+ sky130_fd_sc_hd__nand2b_1
X$3513 VDD synth_1266 synth_1268 synth_1488 VNB|VSS VDD VNB|VSS
+ sky130_fd_sc_hd__nand2b_1
X$3514 VDD synth_222 synth_218 synth_345 VNB|VSS VDD VNB|VSS
+ sky130_fd_sc_hd__nand2b_1
X$3515 VDD synth_5054 synth_5126 synth_5127 VNB|VSS VDD VNB|VSS
+ sky130_fd_sc_hd__nand2b_1
X$3516 VDD synth_561 synth_562 synth_668 VNB|VSS VDD VNB|VSS
+ sky130_fd_sc_hd__nand2b_1
X$3517 VDD synth_12461 synth_12519 synth_12517 VNB|VSS VDD VNB|VSS
+ sky130_fd_sc_hd__nand2b_1
X$3518 VDD synth_6830 synth_6829 synth_6905 VNB|VSS VDD VNB|VSS
+ sky130_fd_sc_hd__nand2b_1
X$3519 VDD synth_142 synth_436 synth_279 VNB|VSS VDD VNB|VSS
+ sky130_fd_sc_hd__nand2b_1
X$3520 VDD synth_5220 synth_5151 synth_5076 VNB|VSS VDD VNB|VSS
+ sky130_fd_sc_hd__nand2b_1
X$3521 VDD synth_8190 synth_8195 synth_8108 VNB|VSS VDD VNB|VSS
+ sky130_fd_sc_hd__nand2b_1
X$3522 VDD synth_553 synth_604 synth_603 VNB|VSS VDD VNB|VSS
+ sky130_fd_sc_hd__nand2b_1
X$3523 VDD synth_3800 synth_3738 synth_3997 VNB|VSS VDD VNB|VSS
+ sky130_fd_sc_hd__nand2b_1
X$3524 VDD synth_12350 synth_12398 synth_11829 VNB|VSS VDD VNB|VSS
+ sky130_fd_sc_hd__nand2b_1
X$3525 VDD synth_5899 synth_5814 synth_5983 VNB|VSS VDD VNB|VSS
+ sky130_fd_sc_hd__nand2b_1
X$3526 VDD synth_4270 synth_4320 synth_4188 VNB|VSS VDD VNB|VSS
+ sky130_fd_sc_hd__nand2b_1
X$3527 VDD synth_11401 synth_11486 synth_11485 VNB|VSS VDD VNB|VSS
+ sky130_fd_sc_hd__nand2b_1
X$3528 VDD synth_3021 synth_3053 synth_3018 VNB|VSS VDD VNB|VSS
+ sky130_fd_sc_hd__nand2b_1
X$3529 VDD synth_5828 synth_5827 synth_5093 VNB|VSS VDD VNB|VSS
+ sky130_fd_sc_hd__nand2b_1
X$3530 VDD synth_12039 synth_12037 synth_11587 VNB|VSS VDD VNB|VSS
+ sky130_fd_sc_hd__nand2b_1
X$3531 VDD synth_7039 synth_6979 synth_7069 VNB|VSS VDD VNB|VSS
+ sky130_fd_sc_hd__nand2b_1
X$3532 VDD synth_2430 synth_2343 synth_2698 VNB|VSS VDD VNB|VSS
+ sky130_fd_sc_hd__nand2b_1
X$3533 VDD synth_5744 synth_5649 synth_5894 VNB|VSS VDD VNB|VSS
+ sky130_fd_sc_hd__nand2b_1
X$3534 VDD synth_9999 synth_10168 synth_10284 VNB|VSS VDD VNB|VSS
+ sky130_fd_sc_hd__nand2b_1
X$3535 VDD synth_1754 synth_1662 synth_1659 VNB|VSS VDD VNB|VSS
+ sky130_fd_sc_hd__nand2b_1
X$3536 VDD synth_6993 synth_7122 synth_6979 VNB|VSS VDD VNB|VSS
+ sky130_fd_sc_hd__nand2b_1
X$3537 VNB|VSS synth_1759 synth_1662 synth_1747 synth_1755 synth_1661
+ synth_1748 VDD VDD VNB|VSS sky130_fd_sc_hd__a41o_1
X$3538 VNB|VSS synth_881 synth_714 synth_747 synth_713 synth_611 synth_562 VDD
+ VDD VNB|VSS sky130_fd_sc_hd__a41o_1
X$3539 VNB|VSS synth_4807 synth_4733 synth_4661 synth_4659 synth_4660
+ synth_4662 VDD VDD VNB|VSS sky130_fd_sc_hd__a41o_1
X$3540 VNB|VSS synth_5958 synth_5979 synth_5895 synth_5896 synth_5812
+ synth_5649 VDD VDD VNB|VSS sky130_fd_sc_hd__a41o_1
X$3541 VNB|VSS synth_4404 synth_4040 synth_3973 synth_4039 synth_3989
+ synth_4038 VDD VDD VNB|VSS sky130_fd_sc_hd__a41o_1
X$3542 VNB|VSS synth_12569 synth_12693 synth_12352 synth_12568 synth_12293
+ synth_12714 VDD VDD VNB|VSS sky130_fd_sc_hd__a41o_1
X$3543 VNB|VSS synth_5195 synth_6134 synth_6622 synth_6403 synth_6404
+ synth_6356 VDD VDD VNB|VSS sky130_fd_sc_hd__a41o_1
X$3544 VNB|VSS synth_3670 synth_3643 synth_3586 synth_3571 synth_3572
+ synth_3475 VDD VDD VNB|VSS sky130_fd_sc_hd__a41o_1
X$3545 VNB|VSS synth_415 synth_339 synth_78 synth_271 synth_338 synth_43 VDD
+ VDD VNB|VSS sky130_fd_sc_hd__a41o_1
X$3546 VNB|VSS synth_5934 synth_5759 synth_5684 synth_5758 synth_5828
+ synth_5683 VDD VDD VNB|VSS sky130_fd_sc_hd__a41o_1
X$3547 VNB|VSS synth_2927 synth_2866 synth_2928 synth_2799 synth_2776
+ synth_2774 VDD VDD VNB|VSS sky130_fd_sc_hd__a41o_1
X$3548 VNB|VSS synth_2888 synth_2889 synth_2737 synth_2814 synth_2815
+ synth_2817 VDD VDD VNB|VSS sky130_fd_sc_hd__a41o_1
X$3549 VNB|VSS synth_973 synth_1069 synth_897 synth_975 synth_976 synth_811 VDD
+ VDD VNB|VSS sky130_fd_sc_hd__a41o_1
X$3550 VNB|VSS synth_5489 synth_5588 synth_5490 synth_5534 synth_5405
+ synth_5491 VDD VDD VNB|VSS sky130_fd_sc_hd__a41o_1
X$3551 VNB|VSS synth_5320 synth_5078 synth_5077 synth_5153 synth_5220
+ synth_5154 VDD VDD VNB|VSS sky130_fd_sc_hd__a41o_1
X$3552 VNB|VSS synth_6616 synth_6482 synth_6463 synth_6569 synth_6464
+ synth_6480 VDD VDD VNB|VSS sky130_fd_sc_hd__a41o_1
X$3553 VNB|VSS synth_4812 synth_4637 synth_4715 synth_4666 synth_4665
+ synth_4737 VDD VDD VNB|VSS sky130_fd_sc_hd__a41o_1
X$3554 VNB|VSS synth_4168 synth_4098 synth_3880 synth_4028 synth_4027
+ synth_4029 VDD VDD VNB|VSS sky130_fd_sc_hd__a41o_1
X$3555 VNB|VSS synth_12705 synth_12707 synth_12588 synth_12706 synth_12522
+ synth_12589 VDD VDD VNB|VSS sky130_fd_sc_hd__a41o_1
X$3556 VNB|VSS synth_9116 synth_8805 synth_9063 synth_9101 synth_9062
+ synth_9064 VDD VDD VNB|VSS sky130_fd_sc_hd__a41o_1
X$3557 VNB|VSS synth_5755 synth_5709 synth_5767 synth_5756 synth_5757
+ synth_5681 VDD VDD VNB|VSS sky130_fd_sc_hd__a41o_1
X$3558 VNB|VSS synth_7008 synth_6899 synth_6746 synth_6900 synth_6732
+ synth_6879 VDD VDD VNB|VSS sky130_fd_sc_hd__a41o_1
X$3559 VNB|VSS synth_2022 synth_1961 synth_1960 synth_1883 synth_1805
+ synth_1958 VDD VDD VNB|VSS sky130_fd_sc_hd__a41o_1
X$3560 VNB|VSS synth_971 synth_972 synth_1235 synth_1018 synth_1093 synth_1236
+ VDD VDD VNB|VSS sky130_fd_sc_hd__a41o_1
X$3561 VNB|VSS synth_5886 synth_5941 synth_5940 synth_5887 synth_5888
+ synth_6024 VDD VDD VNB|VSS sky130_fd_sc_hd__a41o_1
X$3562 VNB|VSS synth_1283 synth_1190 synth_1318 synth_1319 synth_1285
+ synth_1288 VDD VDD VNB|VSS sky130_fd_sc_hd__a41o_1
X$3563 VNB|VSS synth_2579 synth_2649 synth_2580 synth_2539 synth_2538
+ synth_2407 VDD VDD VNB|VSS sky130_fd_sc_hd__a41o_1
X$3564 VNB|VSS synth_7167 synth_7032 synth_6971 synth_7029 synth_7030
+ synth_7006 VDD VDD VNB|VSS sky130_fd_sc_hd__a41o_1
X$3565 VNB|VSS synth_10923 synth_10886 synth_10966 synth_10969 synth_10925
+ synth_10924 VDD VDD VNB|VSS sky130_fd_sc_hd__a41o_1
X$3566 VNB|VSS synth_10614 synth_10551 synth_10433 synth_10506 synth_10505
+ synth_10504 VDD VDD VNB|VSS sky130_fd_sc_hd__a41o_1
X$3567 VNB|VSS synth_379 synth_321 synth_286 synth_285 synth_350 synth_116 VDD
+ VDD VNB|VSS sky130_fd_sc_hd__a41o_1
X$3568 VNB|VSS synth_5284 synth_5126 synth_5123 synth_5186 synth_5053
+ synth_5124 VDD VDD VNB|VSS sky130_fd_sc_hd__a41o_1
X$3569 VNB|VSS synth_8941 synth_8781 synth_8838 synth_8927 synth_8835
+ synth_8801 VDD VDD VNB|VSS sky130_fd_sc_hd__a41o_1
X$3570 VNB|VSS synth_4410 synth_4348 synth_4349 synth_4350 synth_4270
+ synth_4183 VDD VDD VNB|VSS sky130_fd_sc_hd__a41o_1
X$3571 VNB|VSS synth_1410 synth_1358 synth_1333 synth_1269 synth_1356
+ synth_1270 VDD VDD VNB|VSS sky130_fd_sc_hd__a41o_1
X$3572 VNB|VSS synth_12734 synth_12609 synth_12610 synth_12563 synth_12350
+ synth_12369 VDD VDD VNB|VSS sky130_fd_sc_hd__a41o_1
X$3573 VNB|VSS synth_4262 synth_4012 synth_4180 synth_4179 synth_4086
+ synth_4263 VDD VDD VNB|VSS sky130_fd_sc_hd__a41o_1
X$3574 VNB|VSS synth_3980 synth_3908 synth_3845 synth_3906 synth_3907
+ synth_3842 VDD VDD VNB|VSS sky130_fd_sc_hd__a41o_1
X$3575 VNB|VSS synth_3653 synth_3364 synth_3490 synth_3579 synth_3451
+ synth_3363 VDD VDD VNB|VSS sky130_fd_sc_hd__a41o_1
X$3576 VNB|VSS synth_2435 synth_2360 synth_2363 synth_2361 synth_2362
+ synth_2364 VDD VDD VNB|VSS sky130_fd_sc_hd__a41o_1
X$3577 VNB|VSS synth_12697 synth_12662 synth_12699 synth_12698 synth_12400
+ synth_12383 VDD VDD VNB|VSS sky130_fd_sc_hd__a41o_1
X$3578 VNB|VSS synth_3534 synth_3177 synth_3235 synth_3234 synth_3308
+ synth_3236 VDD VDD VNB|VSS sky130_fd_sc_hd__a41o_1
X$3579 VNB|VSS synth_7892 synth_7893 synth_7918 synth_7823 synth_7894
+ synth_7995 VDD VDD VNB|VSS sky130_fd_sc_hd__a41o_1
X$3580 VNB|VSS synth_3251 synth_3252 synth_3255 synth_3415 synth_3258
+ synth_3256 VDD VDD VNB|VSS sky130_fd_sc_hd__a41o_1
X$3581 VNB|VSS synth_6867 synth_6643 synth_6669 synth_6719 synth_6720
+ synth_6721 VDD VDD VNB|VSS sky130_fd_sc_hd__a41o_1
X$3582 VNB|VSS synth_5287 synth_5173 synth_5358 synth_5281 synth_5184
+ synth_5182 VDD VDD VNB|VSS sky130_fd_sc_hd__a41o_1
X$3583 VNB|VSS synth_4775 synth_4583 synth_4906 synth_4867 synth_4584
+ synth_4868 VDD VDD VNB|VSS sky130_fd_sc_hd__a41o_1
X$3584 VNB|VSS synth_1791 synth_1640 synth_1733 synth_1732 synth_1731
+ synth_1692 VDD VDD VNB|VSS sky130_fd_sc_hd__a41o_1
X$3585 VNB|VSS synth_1915 synth_1824 synth_1976 synth_1893 synth_1822
+ synth_1987 VDD VDD VNB|VSS sky130_fd_sc_hd__a41o_1
X$3586 VNB|VSS synth_4462 synth_4122 synth_4542 synth_4380 synth_4295
+ synth_4459 VDD VDD VNB|VSS sky130_fd_sc_hd__a41o_1
X$3587 VNB|VSS synth_6056 synth_5985 synth_5906 synth_5905 synth_5986
+ synth_5774 VDD VDD VNB|VSS sky130_fd_sc_hd__a41o_1
X$3588 VNB|VSS synth_7121 synth_7122 synth_7041 synth_7040 synth_7039
+ synth_7062 VDD VDD VNB|VSS sky130_fd_sc_hd__a41o_1
X$3589 VNB|VSS synth_7735 synth_7736 synth_7546 synth_7661 synth_7662
+ synth_7583 VDD VDD VNB|VSS sky130_fd_sc_hd__a41o_1
X$3590 VNB|VSS synth_8112 synth_8030 synth_7982 synth_7906 synth_7907
+ synth_7908 VDD VDD VNB|VSS sky130_fd_sc_hd__a41o_1
X$3591 VNB|VSS synth_6898 synth_6807 synth_6745 synth_6948 synth_6809
+ synth_6677 VDD VDD VNB|VSS sky130_fd_sc_hd__a41o_1
X$3592 VNB|VSS synth_1312 synth_1173 synth_1157 synth_1240 synth_1172
+ synth_1130 VDD VDD VNB|VSS sky130_fd_sc_hd__a41o_1
X$3593 VNB|VSS synth_6565 synth_6425 synth_6353 synth_6473 synth_6426
+ synth_6352 VDD VDD VNB|VSS sky130_fd_sc_hd__a41o_1
X$3594 VNB|VSS synth_9663 synth_9504 synth_9554 synth_9664 synth_9690
+ synth_9665 VDD VDD VNB|VSS sky130_fd_sc_hd__a41o_1
X$3595 VNB|VSS synth_7980 synth_7785 synth_7786 synth_7862 synth_7930
+ synth_7932 VDD VDD VNB|VSS sky130_fd_sc_hd__a41o_1
X$3596 VNB|VSS synth_5465 synth_5226 synth_5140 synth_5387 synth_5331
+ synth_5308 VDD VDD VNB|VSS sky130_fd_sc_hd__a41o_1
X$3597 VNB|VSS synth_4763 synth_4759 synth_5027 synth_4852 synth_4948
+ synth_4949 VDD VDD VNB|VSS sky130_fd_sc_hd__a41o_1
X$3598 VNB|VSS synth_3629 synth_3345 synth_3733 synth_3695 synth_3460
+ synth_3797 VDD VDD VNB|VSS sky130_fd_sc_hd__a41o_1
X$3599 VNB|VSS synth_584 synth_498 synth_497 synth_552 synth_553 synth_425 VDD
+ VDD VNB|VSS sky130_fd_sc_hd__a41o_1
X$3600 VNB|VSS synth_98 synth_171 synth_228 synth_473 synth_354 synth_292 VDD
+ VDD VNB|VSS sky130_fd_sc_hd__a41o_1
X$3601 VNB|VSS synth_1439 synth_1361 synth_1275 synth_1328 synth_1360
+ synth_1327 VDD VDD VNB|VSS sky130_fd_sc_hd__a41o_1
X$3602 VNB|VSS synth_6783 synth_6527 synth_6525 synth_6588 synth_6675
+ synth_6602 VDD VDD VNB|VSS sky130_fd_sc_hd__a41o_1
X$3603 VNB|VSS synth_4972 synth_4891 synth_4917 synth_5043 synth_5013
+ synth_4974 VDD VDD VNB|VSS sky130_fd_sc_hd__a41o_1
X$3604 VNB|VSS synth_152 synth_153 synth_283 synth_221 synth_222 synth_253 VDD
+ VDD VNB|VSS sky130_fd_sc_hd__a41o_1
X$3605 VNB|VSS synth_7328 synth_7259 synth_7331 synth_7330 synth_7312
+ synth_7332 VDD VDD VNB|VSS sky130_fd_sc_hd__a41o_1
X$3606 VNB|VSS synth_1950 synth_1952 synth_1920 synth_2088 synth_1953
+ synth_1921 VDD VDD VNB|VSS sky130_fd_sc_hd__a41o_1
X$3607 VNB|VSS synth_6924 synth_6660 synth_6661 synth_6892 synth_6789
+ synth_6788 VDD VDD VNB|VSS sky130_fd_sc_hd__a41o_1
X$3608 VNB|VSS synth_10897 synth_10783 synth_10784 synth_10855 synth_10785
+ synth_10856 VDD VDD VNB|VSS sky130_fd_sc_hd__a41o_1
X$3609 VNB|VSS synth_8694 synth_8696 synth_8529 synth_8695 synth_8617
+ synth_8615 VDD VDD VNB|VSS sky130_fd_sc_hd__a41o_1
X$3610 VNB|VSS synth_9488 synth_9532 synth_9529 synth_9645 synth_9400
+ synth_9639 VDD VDD VNB|VSS sky130_fd_sc_hd__a41o_1
X$3611 VNB|VSS synth_9576 synth_9577 synth_9564 synth_9578 synth_9563
+ synth_9424 VDD VDD VNB|VSS sky130_fd_sc_hd__a41o_1
X$3612 VNB|VSS synth_964 synth_759 synth_716 synth_757 synth_758 synth_718 VDD
+ VDD VNB|VSS sky130_fd_sc_hd__a41o_1
X$3613 VNB|VSS synth_11281 synth_11156 synth_11239 synth_11305 synth_11126
+ synth_11207 VDD VDD VNB|VSS sky130_fd_sc_hd__a41o_1
X$3614 VNB|VSS synth_7054 synth_6829 synth_6851 synth_6919 synth_6826
+ synth_6918 VDD VDD VNB|VSS sky130_fd_sc_hd__a41o_1
X$3615 VNB|VSS synth_2373 synth_2290 synth_2223 synth_2370 synth_2288
+ synth_2289 VDD VDD VNB|VSS sky130_fd_sc_hd__a41o_1
X$3616 VNB|VSS synth_3562 synth_3467 synth_3391 synth_3535 synth_3389
+ synth_3347 VDD VDD VNB|VSS sky130_fd_sc_hd__a41o_1
X$3617 VNB|VSS synth_2485 synth_2281 synth_2237 synth_2349 synth_2282
+ synth_2283 VDD VDD VNB|VSS sky130_fd_sc_hd__a41o_1
X$3618 VNB|VSS synth_1758 synth_1625 synth_1420 synth_1696 synth_1626
+ synth_1538 VDD VDD VNB|VSS sky130_fd_sc_hd__a41o_1
X$3619 VNB|VSS synth_213 synth_141 synth_125 synth_215 synth_142 synth_124 VDD
+ VDD VNB|VSS sky130_fd_sc_hd__a41o_1
X$3620 VNB|VSS synth_2418 synth_2467 synth_2417 synth_2502 synth_2264
+ synth_2377 VDD VDD VNB|VSS sky130_fd_sc_hd__a41o_1
X$3621 VNB|VSS synth_6407 synth_6161 synth_6305 synth_6381 synth_5992
+ synth_6382 VDD VDD VNB|VSS sky130_fd_sc_hd__a41o_1
X$3622 VNB|VSS synth_241 synth_106 synth_294 synth_230 synth_231 synth_166 VDD
+ VDD VNB|VSS sky130_fd_sc_hd__a41o_1
X$3623 VNB|VSS synth_260 synth_146 synth_144 synth_145 synth_185 synth_187 VDD
+ VDD VNB|VSS sky130_fd_sc_hd__a41o_1
X$3624 VNB|VSS synth_9353 synth_9161 synth_9163 synth_9296 synth_9215
+ synth_9162 VDD VDD VNB|VSS sky130_fd_sc_hd__a41o_1
X$3625 VNB|VSS synth_10600 synth_10565 synth_10498 synth_10622 synth_10566
+ synth_10499 VDD VDD VNB|VSS sky130_fd_sc_hd__a41o_1
X$3626 VNB|VSS synth_12190 synth_12072 synth_11982 synth_12101 synth_12039
+ synth_12038 VDD VDD VNB|VSS sky130_fd_sc_hd__a41o_1
X$3627 VNB|VSS synth_6725 synth_6680 synth_6681 synth_6724 synth_6644
+ synth_6749 VDD VDD VNB|VSS sky130_fd_sc_hd__a41o_1
X$3628 VNB|VSS synth_4881 synth_4795 synth_4704 synth_4880 synth_4846
+ synth_4746 VDD VDD VNB|VSS sky130_fd_sc_hd__a41o_1
X$3629 VNB|VSS synth_9416 synth_9420 synth_9418 synth_9506 synth_9419
+ synth_9314 VDD VDD VNB|VSS sky130_fd_sc_hd__a41o_1
X$3630 VNB|VSS synth_4334 synth_4335 synth_4765 synth_4688 synth_4386
+ synth_4720 VDD VDD VNB|VSS sky130_fd_sc_hd__a41o_1
X$3631 VNB|VSS synth_1000 synth_919 synth_777 synth_1001 synth_918 synth_834
+ VDD VDD VNB|VSS sky130_fd_sc_hd__a41o_1
X$3632 VNB|VSS synth_8389 synth_8170 synth_8511 synth_8436 synth_8171
+ synth_8320 VDD VDD VNB|VSS sky130_fd_sc_hd__a41o_1
X$3633 VNB|VSS synth_8799 synth_8744 synth_8688 synth_8745 synth_8784
+ synth_8761 VDD VDD VNB|VSS sky130_fd_sc_hd__a41o_1
X$3634 VNB|VSS synth_305 synth_164 synth_103 synth_233 synth_161 synth_70 VDD
+ VDD VNB|VSS sky130_fd_sc_hd__a41o_1
X$3635 VNB|VSS synth_3051 synth_2977 synth_3158 synth_3019 synth_3021
+ synth_3020 VDD VDD VNB|VSS sky130_fd_sc_hd__a41o_1
X$3636 VNB|VSS synth_5338 synth_5317 synth_5475 synth_5418 synth_5419
+ synth_5476 VDD VDD VNB|VSS sky130_fd_sc_hd__a41o_1
X$3637 VNB|VSS synth_1346 synth_1179 synth_1264 synth_1429 synth_1262
+ synth_1263 VDD VDD VNB|VSS sky130_fd_sc_hd__a41o_1
X$3638 VNB|VSS synth_10570 synth_10832 synth_10708 synth_10629 synth_10356
+ synth_10265 VDD VDD VNB|VSS sky130_fd_sc_hd__a41o_1
X$3639 VNB|VSS synth_6570 synth_6429 synth_6401 synth_6537 synth_6428
+ synth_6355 VDD VDD VNB|VSS sky130_fd_sc_hd__a41o_1
X$3640 VNB|VSS synth_1838 synth_1628 synth_1577 synth_1699 synth_1627
+ synth_1578 VDD VDD VNB|VSS sky130_fd_sc_hd__a41o_1
X$3641 VNB|VSS synth_753 synth_619 synth_729 synth_728 synth_754 synth_731 VDD
+ VDD VNB|VSS sky130_fd_sc_hd__a41o_1
X$3642 VNB|VSS synth_12516 synth_12493 synth_12494 synth_12582 synth_12518
+ synth_12519 VDD VDD VNB|VSS sky130_fd_sc_hd__a41o_1
X$3643 VDD synth_9944 synth_9868 synth_9943 VDD VNB|VSS VNB|VSS
+ sky130_fd_sc_hd__xnor2_1
X$3644 VDD synth_2180 synth_2104 synth_2219 VDD VNB|VSS VNB|VSS
+ sky130_fd_sc_hd__xnor2_1
X$3645 VDD synth_3373 synth_3300 synth_3431 VDD VNB|VSS VNB|VSS
+ sky130_fd_sc_hd__xnor2_1
X$3646 VDD synth_6371 synth_6519 synth_6517 VDD VNB|VSS VNB|VSS
+ sky130_fd_sc_hd__xnor2_1
X$3647 VDD synth_8087 synth_7938 synth_7936 VDD VNB|VSS VNB|VSS
+ sky130_fd_sc_hd__xnor2_1
X$3648 VDD synth_8091 synth_7939 synth_7941 VDD VNB|VSS VNB|VSS
+ sky130_fd_sc_hd__xnor2_1
X$3649 VDD synth_8585 synth_8583 synth_8647 VDD VNB|VSS VNB|VSS
+ sky130_fd_sc_hd__xnor2_1
X$3650 VDD synth_9591 synth_9634 synth_9633 VDD VNB|VSS VNB|VSS
+ sky130_fd_sc_hd__xnor2_1
X$3651 VDD synth_6629 synth_6691 synth_6825 VDD VNB|VSS VNB|VSS
+ sky130_fd_sc_hd__xnor2_1
X$3652 VDD synth_2967 synth_2879 synth_2965 VDD VNB|VSS VNB|VSS
+ sky130_fd_sc_hd__xnor2_1
X$3653 VDD synth_10593 synth_10595 synth_10667 VDD VNB|VSS VNB|VSS
+ sky130_fd_sc_hd__xnor2_1
X$3654 VDD synth_10544 synth_10610 synth_10655 VDD VNB|VSS VNB|VSS
+ sky130_fd_sc_hd__xnor2_1
X$3655 VDD synth_12604 synth_12605 synth_12673 VDD VNB|VSS VNB|VSS
+ sky130_fd_sc_hd__xnor2_1
X$3656 VDD synth_3929 synth_3931 synth_3834 VDD VNB|VSS VNB|VSS
+ sky130_fd_sc_hd__xnor2_1
X$3657 VDD synth_12772 synth_12606 synth_12676 VDD VNB|VSS VNB|VSS
+ sky130_fd_sc_hd__xnor2_1
X$3658 VDD synth_9189 synth_9188 synth_9345 VDD VNB|VSS VNB|VSS
+ sky130_fd_sc_hd__xnor2_1
X$3659 VDD synth_8662 synth_8646 synth_8645 VDD VNB|VSS VNB|VSS
+ sky130_fd_sc_hd__xnor2_1
X$3660 VDD synth_99 synth_358 synth_582 VDD VNB|VSS VNB|VSS
+ sky130_fd_sc_hd__xnor2_1
X$3661 VDD synth_12192 synth_12246 synth_12320 VDD VNB|VSS VNB|VSS
+ sky130_fd_sc_hd__xnor2_1
X$3662 VDD synth_12005 synth_11944 synth_12003 VDD VNB|VSS VNB|VSS
+ sky130_fd_sc_hd__xnor2_1
X$3663 VDD synth_1446 synth_1559 synth_1487 VDD VNB|VSS VNB|VSS
+ sky130_fd_sc_hd__xnor2_1
X$3664 VDD synth_10788 synth_10789 synth_10710 VDD VNB|VSS VNB|VSS
+ sky130_fd_sc_hd__xnor2_1
X$3665 VDD synth_9726 synth_9724 synth_9657 VDD VNB|VSS VNB|VSS
+ sky130_fd_sc_hd__xnor2_1
X$3666 VDD synth_10077 synth_10076 synth_10074 VDD VNB|VSS VNB|VSS
+ sky130_fd_sc_hd__xnor2_1
X$3667 VDD synth_3261 synth_3262 synth_3224 VDD VNB|VSS VNB|VSS
+ sky130_fd_sc_hd__xnor2_1
X$3668 VDD synth_9935 synth_9725 synth_9632 VDD VNB|VSS VNB|VSS
+ sky130_fd_sc_hd__xnor2_1
X$3669 VDD synth_11338 synth_11408 synth_11556 VDD VNB|VSS VNB|VSS
+ sky130_fd_sc_hd__xnor2_1
X$3670 VDD synth_11882 synth_11998 synth_12057 VDD VNB|VSS VNB|VSS
+ sky130_fd_sc_hd__xnor2_1
X$3671 VDD synth_12427 synth_12366 synth_12367 VDD VNB|VSS VNB|VSS
+ sky130_fd_sc_hd__xnor2_1
X$3672 VDD synth_8643 synth_8724 synth_8766 VDD VNB|VSS VNB|VSS
+ sky130_fd_sc_hd__xnor2_1
X$3673 VDD synth_10948 synth_10605 synth_10947 VDD VNB|VSS VNB|VSS
+ sky130_fd_sc_hd__xnor2_1
X$3674 VDD synth_3229 synth_3109 synth_3108 VDD VNB|VSS VNB|VSS
+ sky130_fd_sc_hd__xnor2_1
X$3675 VDD synth_7675 synth_7674 synth_7669 VDD VNB|VSS VNB|VSS
+ sky130_fd_sc_hd__xnor2_1
X$3676 VDD synth_6186 synth_5825 synth_5939 VDD VNB|VSS VNB|VSS
+ sky130_fd_sc_hd__xnor2_1
X$3677 VDD synth_988 synth_989 synth_987 VDD VNB|VSS VNB|VSS
+ sky130_fd_sc_hd__xnor2_1
X$3678 VDD synth_4782 synth_4620 synth_4780 VDD VNB|VSS VNB|VSS
+ sky130_fd_sc_hd__xnor2_1
X$3679 VDD synth_12546 synth_12362 synth_12469 VDD VNB|VSS VNB|VSS
+ sky130_fd_sc_hd__xnor2_1
X$3680 VDD synth_11583 synth_11654 synth_11799 VDD VNB|VSS VNB|VSS
+ sky130_fd_sc_hd__xnor2_1
X$3681 VDD synth_5962 synth_5901 synth_5902 VDD VNB|VSS VNB|VSS
+ sky130_fd_sc_hd__xnor2_1
X$3682 VDD synth_8415 synth_8476 synth_8398 VDD VNB|VSS VNB|VSS
+ sky130_fd_sc_hd__xnor2_1
X$3683 VDD synth_11788 synth_11745 synth_11742 VDD VNB|VSS VNB|VSS
+ sky130_fd_sc_hd__xnor2_1
X$3684 VDD synth_12607 synth_12678 synth_12682 VDD VNB|VSS VNB|VSS
+ sky130_fd_sc_hd__xnor2_1
X$3685 VDD synth_889 synth_904 synth_820 VDD VNB|VSS VNB|VSS
+ sky130_fd_sc_hd__xnor2_1
X$3686 VDD synth_11274 synth_11390 synth_11327 VDD VNB|VSS VNB|VSS
+ sky130_fd_sc_hd__xnor2_1
X$3687 VDD synth_9938 synth_9936 synth_9937 VDD VNB|VSS VNB|VSS
+ sky130_fd_sc_hd__xnor2_1
X$3688 VDD synth_1530 synth_1533 synth_1743 VDD VNB|VSS VNB|VSS
+ sky130_fd_sc_hd__xnor2_1
X$3689 VDD synth_9739 synth_9507 synth_9561 VDD VNB|VSS VNB|VSS
+ sky130_fd_sc_hd__xnor2_1
X$3690 VDD synth_12675 synth_12688 synth_12674 VDD VNB|VSS VNB|VSS
+ sky130_fd_sc_hd__xnor2_1
X$3691 VDD synth_3756 synth_3633 synth_3683 VDD VNB|VSS VNB|VSS
+ sky130_fd_sc_hd__xnor2_1
X$3692 VDD synth_226 synth_157 synth_317 VDD VNB|VSS VNB|VSS
+ sky130_fd_sc_hd__xnor2_1
X$3693 VDD synth_9087 synth_9072 synth_8879 VDD VNB|VSS VNB|VSS
+ sky130_fd_sc_hd__xnor2_1
X$3694 VDD synth_11045 synth_11200 synth_11199 VDD VNB|VSS VNB|VSS
+ sky130_fd_sc_hd__xnor2_1
X$3695 VDD synth_7745 synth_7666 synth_7799 VDD VNB|VSS VNB|VSS
+ sky130_fd_sc_hd__xnor2_1
X$3696 VDD synth_9181 synth_9182 synth_9196 VDD VNB|VSS VNB|VSS
+ sky130_fd_sc_hd__xnor2_1
X$3697 VDD synth_2530 synth_2369 synth_2529 VDD VNB|VSS VNB|VSS
+ sky130_fd_sc_hd__xnor2_1
X$3698 VDD synth_5483 synth_5362 synth_5522 VDD VNB|VSS VNB|VSS
+ sky130_fd_sc_hd__xnor2_1
X$3699 VDD synth_9245 synth_9243 synth_9179 VDD VNB|VSS VNB|VSS
+ sky130_fd_sc_hd__xnor2_1
X$3700 VDD synth_7793 synth_7794 synth_7741 VDD VNB|VSS VNB|VSS
+ sky130_fd_sc_hd__xnor2_1
X$3701 VDD synth_12474 synth_12475 synth_12536 VDD VNB|VSS VNB|VSS
+ sky130_fd_sc_hd__xnor2_1
X$3702 VDD synth_7323 synth_7395 synth_7322 VDD VNB|VSS VNB|VSS
+ sky130_fd_sc_hd__xnor2_1
X$3703 VDD synth_10957 synth_11178 synth_11179 VDD VNB|VSS VNB|VSS
+ sky130_fd_sc_hd__xnor2_1
X$3704 VDD synth_12112 synth_12207 synth_12206 VDD VNB|VSS VNB|VSS
+ sky130_fd_sc_hd__xnor2_1
X$3705 VDD synth_8015 synth_8580 synth_8480 VDD VNB|VSS VNB|VSS
+ sky130_fd_sc_hd__xnor2_1
X$3706 VDD synth_8655 synth_8399 synth_8649 VDD VNB|VSS VNB|VSS
+ sky130_fd_sc_hd__xnor2_1
X$3707 VDD synth_6769 synth_6859 synth_6852 VDD VNB|VSS VNB|VSS
+ sky130_fd_sc_hd__xnor2_1
X$3708 VDD synth_4070 synth_4018 synth_4230 VDD VNB|VSS VNB|VSS
+ sky130_fd_sc_hd__xnor2_1
X$3709 VDD synth_948 synth_807 synth_805 VDD VNB|VSS VNB|VSS
+ sky130_fd_sc_hd__xnor2_1
X$3710 VDD synth_12199 synth_12245 synth_12313 VDD VNB|VSS VNB|VSS
+ sky130_fd_sc_hd__xnor2_1
X$3711 VDD synth_2398 synth_2207 synth_2399 VDD VNB|VSS VNB|VSS
+ sky130_fd_sc_hd__xnor2_1
X$3712 VDD synth_8094 synth_8183 synth_8182 VDD VNB|VSS VNB|VSS
+ sky130_fd_sc_hd__xnor2_1
X$3713 VDD synth_2527 synth_2272 synth_2408 VDD VNB|VSS VNB|VSS
+ sky130_fd_sc_hd__xnor2_1
X$3714 VDD synth_11500 synth_11601 synth_11712 VDD VNB|VSS VNB|VSS
+ sky130_fd_sc_hd__xnor2_1
X$3715 VDD synth_8254 synth_8180 synth_8253 VDD VNB|VSS VNB|VSS
+ sky130_fd_sc_hd__xnor2_1
X$3716 VDD synth_8278 synth_8256 synth_8255 VDD VNB|VSS VNB|VSS
+ sky130_fd_sc_hd__xnor2_1
X$3717 VDD synth_11485 synth_11474 synth_11613 VDD VNB|VSS VNB|VSS
+ sky130_fd_sc_hd__xnor2_1
X$3718 VDD synth_8404 synth_8408 synth_8409 VDD VNB|VSS VNB|VSS
+ sky130_fd_sc_hd__xnor2_1
X$3719 VDD synth_7231 synth_7208 synth_7205 VDD VNB|VSS VNB|VSS
+ sky130_fd_sc_hd__xnor2_1
X$3720 VDD synth_7828 synth_7696 synth_7778 VDD VNB|VSS VNB|VSS
+ sky130_fd_sc_hd__xnor2_1
X$3721 VDD synth_11774 synth_11682 synth_11753 VDD VNB|VSS VNB|VSS
+ sky130_fd_sc_hd__xnor2_1
X$3722 VDD synth_10383 synth_10335 synth_10401 VDD VNB|VSS VNB|VSS
+ sky130_fd_sc_hd__xnor2_1
X$3723 VDD synth_11820 synth_11821 synth_11876 VDD VNB|VSS VNB|VSS
+ sky130_fd_sc_hd__xnor2_1
X$3724 VDD synth_5005 synth_4770 synth_4904 VDD VNB|VSS VNB|VSS
+ sky130_fd_sc_hd__xnor2_1
X$3725 VDD synth_11886 synth_11605 synth_11770 VDD VNB|VSS VNB|VSS
+ sky130_fd_sc_hd__xnor2_1
X$3726 VDD synth_9011 synth_8952 synth_9032 VDD VNB|VSS VNB|VSS
+ sky130_fd_sc_hd__xnor2_1
X$3727 VDD synth_10447 synth_10382 synth_10448 VDD VNB|VSS VNB|VSS
+ sky130_fd_sc_hd__xnor2_1
X$3728 VDD synth_62 synth_342 synth_489 VDD VNB|VSS VNB|VSS
+ sky130_fd_sc_hd__xnor2_1
X$3729 VDD synth_10036 synth_10020 synth_10019 VDD VNB|VSS VNB|VSS
+ sky130_fd_sc_hd__xnor2_1
X$3730 VDD synth_2021 synth_1932 synth_2252 VDD VNB|VSS VNB|VSS
+ sky130_fd_sc_hd__xnor2_1
X$3731 VDD synth_12712 synth_12505 synth_12612 VDD VNB|VSS VNB|VSS
+ sky130_fd_sc_hd__xnor2_1
X$3732 VDD synth_12364 synth_12363 synth_12433 VDD VNB|VSS VNB|VSS
+ sky130_fd_sc_hd__xnor2_1
X$3733 VDD synth_11395 synth_11413 synth_11396 VDD VNB|VSS VNB|VSS
+ sky130_fd_sc_hd__xnor2_1
X$3734 VDD synth_10262 synth_10386 synth_10400 VDD VNB|VSS VNB|VSS
+ sky130_fd_sc_hd__xnor2_1
X$3735 VDD synth_9017 synth_8810 synth_8882 VDD VNB|VSS VNB|VSS
+ sky130_fd_sc_hd__xnor2_1
X$3736 VDD synth_191 synth_210 synth_208 VDD VNB|VSS VNB|VSS
+ sky130_fd_sc_hd__xnor2_1
X$3737 VDD synth_11256 synth_11252 synth_11186 VDD VNB|VSS VNB|VSS
+ sky130_fd_sc_hd__xnor2_1
X$3738 VDD synth_12251 synth_12185 synth_12248 VDD VNB|VSS VNB|VSS
+ sky130_fd_sc_hd__xnor2_1
X$3739 VDD synth_1303 synth_1199 synth_1380 VDD VNB|VSS VNB|VSS
+ sky130_fd_sc_hd__xnor2_1
X$3740 VDD synth_11039 synth_11101 synth_11041 VDD VNB|VSS VNB|VSS
+ sky130_fd_sc_hd__xnor2_1
X$3741 VDD synth_3135 synth_3137 synth_3226 VDD VNB|VSS VNB|VSS
+ sky130_fd_sc_hd__xnor2_1
X$3742 VDD synth_3418 synth_3197 synth_3328 VDD VNB|VSS VNB|VSS
+ sky130_fd_sc_hd__xnor2_1
X$3743 VDD synth_10665 synth_10739 synth_10740 VDD VNB|VSS VNB|VSS
+ sky130_fd_sc_hd__xnor2_1
X$3744 VDD synth_8108 synth_8107 synth_8114 VDD VNB|VSS VNB|VSS
+ sky130_fd_sc_hd__xnor2_1
X$3745 VDD synth_7672 synth_7318 synth_7559 VDD VNB|VSS VNB|VSS
+ sky130_fd_sc_hd__xnor2_1
X$3746 VDD synth_10460 synth_10459 synth_10522 VDD VNB|VSS VNB|VSS
+ sky130_fd_sc_hd__xnor2_1
X$3747 VDD synth_8636 synth_8634 synth_8637 VDD VNB|VSS VNB|VSS
+ sky130_fd_sc_hd__xnor2_1
X$3748 VDD synth_2093 synth_2094 synth_2096 VDD VNB|VSS VNB|VSS
+ sky130_fd_sc_hd__xnor2_1
X$3749 VDD synth_1741 synth_1649 synth_1648 VDD VNB|VSS VNB|VSS
+ sky130_fd_sc_hd__xnor2_1
X$3750 VDD synth_816 synth_744 synth_978 VDD VNB|VSS VNB|VSS
+ sky130_fd_sc_hd__xnor2_1
X$3751 VDD synth_4372 synth_4222 synth_4224 VDD VNB|VSS VNB|VSS
+ sky130_fd_sc_hd__xnor2_1
X$3752 VDD synth_969 synth_885 synth_1044 VDD VNB|VSS VNB|VSS
+ sky130_fd_sc_hd__xnor2_1
X$3753 VDD synth_7655 synth_7582 synth_7732 VDD VNB|VSS VNB|VSS
+ sky130_fd_sc_hd__xnor2_1
X$3754 VDD synth_8668 synth_8713 synth_8712 VDD VNB|VSS VNB|VSS
+ sky130_fd_sc_hd__xnor2_1
X$3755 VDD synth_9923 synth_9042 synth_10002 VDD VNB|VSS VNB|VSS
+ sky130_fd_sc_hd__xnor2_1
X$3756 VDD synth_12178 synth_12179 synth_12329 VDD VNB|VSS VNB|VSS
+ sky130_fd_sc_hd__xnor2_1
X$3757 VDD synth_4103 synth_4104 synth_4102 VDD VNB|VSS VNB|VSS
+ sky130_fd_sc_hd__xnor2_1
X$3758 VDD synth_8326 synth_8287 synth_8289 VDD VNB|VSS VNB|VSS
+ sky130_fd_sc_hd__xnor2_1
X$3759 VDD synth_2840 synth_3040 synth_3114 VDD VNB|VSS VNB|VSS
+ sky130_fd_sc_hd__xnor2_1
X$3760 VDD synth_9068 synth_9028 synth_9012 VDD VNB|VSS VNB|VSS
+ sky130_fd_sc_hd__xnor2_1
X$3761 VDD synth_5023 synth_5086 synth_5163 VDD VNB|VSS VNB|VSS
+ sky130_fd_sc_hd__xnor2_1
X$3762 VDD synth_817 synth_644 synth_814 VDD VNB|VSS VNB|VSS
+ sky130_fd_sc_hd__xnor2_1
X$3763 VDD synth_5924 synth_5790 synth_5836 VDD VNB|VSS VNB|VSS
+ sky130_fd_sc_hd__xnor2_1
X$3764 VDD synth_9071 synth_9013 synth_9014 VDD VNB|VSS VNB|VSS
+ sky130_fd_sc_hd__xnor2_1
X$3765 VDD synth_9635 synth_9599 synth_9596 VDD VNB|VSS VNB|VSS
+ sky130_fd_sc_hd__xnor2_1
X$3766 VDD synth_9124 synth_9122 synth_9145 VDD VNB|VSS VNB|VSS
+ sky130_fd_sc_hd__xnor2_1
X$3767 VDD synth_8661 synth_8824 synth_8878 VDD VNB|VSS VNB|VSS
+ sky130_fd_sc_hd__xnor2_1
X$3768 VDD synth_8880 synth_9015 synth_9083 VDD VNB|VSS VNB|VSS
+ sky130_fd_sc_hd__xnor2_1
X$3769 VDD synth_8700 synth_8457 synth_8590 VDD VNB|VSS VNB|VSS
+ sky130_fd_sc_hd__xnor2_1
X$3770 VDD synth_851 synth_838 synth_837 VDD VNB|VSS VNB|VSS
+ sky130_fd_sc_hd__xnor2_1
X$3771 VDD synth_12740 synth_12417 synth_12771 VDD VNB|VSS VNB|VSS
+ sky130_fd_sc_hd__xnor2_1
X$3772 VDD synth_6003 synth_6007 synth_6005 VDD VNB|VSS VNB|VSS
+ sky130_fd_sc_hd__xnor2_1
X$3773 VDD synth_12578 synth_12635 synth_12513 VDD VNB|VSS VNB|VSS
+ sky130_fd_sc_hd__xnor2_1
X$3774 VDD synth_768 synth_930 synth_1008 VDD VNB|VSS VNB|VSS
+ sky130_fd_sc_hd__xnor2_1
X$3775 VDD synth_5394 synth_5074 synth_5253 VDD VNB|VSS VNB|VSS
+ sky130_fd_sc_hd__xnor2_1
X$3776 VDD synth_4353 synth_4439 synth_4437 VDD VNB|VSS VNB|VSS
+ sky130_fd_sc_hd__xnor2_1
X$3777 VDD synth_4417 synth_4236 synth_4416 VDD VNB|VSS VNB|VSS
+ sky130_fd_sc_hd__xnor2_1
X$3778 VDD synth_4055 synth_3815 synth_4010 VDD VNB|VSS VNB|VSS
+ sky130_fd_sc_hd__xnor2_1
X$3779 VDD synth_6147 synth_6067 synth_6144 VDD VNB|VSS VNB|VSS
+ sky130_fd_sc_hd__xnor2_1
X$3780 VDD synth_11497 synth_11416 synth_11469 VDD VNB|VSS VNB|VSS
+ sky130_fd_sc_hd__xnor2_1
X$3781 VDD synth_8362 synth_8251 synth_8179 VDD VNB|VSS VNB|VSS
+ sky130_fd_sc_hd__xnor2_1
X$3782 VDD synth_12700 synth_12529 synth_12727 VDD VNB|VSS VNB|VSS
+ sky130_fd_sc_hd__xnor2_1
X$3783 VDD synth_11002 synth_10842 synth_10936 VDD VNB|VSS VNB|VSS
+ sky130_fd_sc_hd__xnor2_1
X$3784 VDD synth_8497 synth_8577 synth_8481 VDD VNB|VSS VNB|VSS
+ sky130_fd_sc_hd__xnor2_1
X$3785 VDD synth_8144 synth_7901 synth_8079 VDD VNB|VSS VNB|VSS
+ sky130_fd_sc_hd__xnor2_1
X$3786 VDD synth_5145 synth_5146 synth_5232 VDD VNB|VSS VNB|VSS
+ sky130_fd_sc_hd__xnor2_1
X$3787 VDD synth_3671 synth_3672 synth_3690 VDD VNB|VSS VNB|VSS
+ sky130_fd_sc_hd__xnor2_1
X$3788 VDD synth_3004 synth_2957 synth_2958 VDD VNB|VSS VNB|VSS
+ sky130_fd_sc_hd__xnor2_1
X$3789 VDD synth_6180 synth_6102 synth_6249 VDD VNB|VSS VNB|VSS
+ sky130_fd_sc_hd__xnor2_1
X$3790 VDD synth_830 synth_831 synth_1040 VDD VNB|VSS VNB|VSS
+ sky130_fd_sc_hd__xnor2_1
X$3791 VDD synth_3979 synth_3978 synth_4048 VDD VNB|VSS VNB|VSS
+ sky130_fd_sc_hd__xnor2_1
X$3792 VDD synth_1587 synth_1818 synth_1645 synth_1846 VNB|VSS VDD VNB|VSS
+ sky130_fd_sc_hd__nand3b_1
X$3793 VDD synth_366 synth_266 synth_179 synth_313 VNB|VSS VDD VNB|VSS
+ sky130_fd_sc_hd__nand3b_1
X$3794 VDD synth_838 synth_1089 synth_839 synth_935 VNB|VSS VDD VNB|VSS
+ sky130_fd_sc_hd__nand3b_1
X$3795 VDD synth_7128 synth_7127 synth_7049 synth_7428 VNB|VSS VDD VNB|VSS
+ sky130_fd_sc_hd__nand3b_1
X$3796 VDD synth_2124 synth_1141 synth_1452 synth_2089 VNB|VSS VDD VNB|VSS
+ sky130_fd_sc_hd__nand3b_1
X$3797 VDD synth_7666 synth_7611 synth_7667 synth_7752 VNB|VSS VDD VNB|VSS
+ sky130_fd_sc_hd__nand3b_1
X$3798 VDD synth_3300 synth_3456 synth_3375 synth_3433 VNB|VSS VDD VNB|VSS
+ sky130_fd_sc_hd__nand3b_1
X$3799 VDD synth_5947 synth_6157 synth_6076 synth_6082 VNB|VSS VDD VNB|VSS
+ sky130_fd_sc_hd__nand3b_1
X$3800 VDD synth_5624 synth_5690 synth_5573 synth_5629 VNB|VSS VDD VNB|VSS
+ sky130_fd_sc_hd__nand3b_1
X$3801 VDD synth_1533 synth_1531 synth_1656 synth_1593 VNB|VSS VDD VNB|VSS
+ sky130_fd_sc_hd__nand3b_1
X$3802 VDD synth_7327 synth_7180 synth_7401 synth_7469 VNB|VSS VDD VNB|VSS
+ sky130_fd_sc_hd__nand3b_1
X$3803 VDD synth_9677 synth_10578 synth_9474 synth_12560 VNB|VSS VDD VNB|VSS
+ sky130_fd_sc_hd__nand3b_1
X$3804 VDD synth_1517 synth_1862 synth_2055 synth_2054 VNB|VSS VDD VNB|VSS
+ sky130_fd_sc_hd__nand3b_1
X$3805 VDD synth_342 synth_20 synth_193 synth_324 VNB|VSS VDD VNB|VSS
+ sky130_fd_sc_hd__nand3b_1
X$3806 VDD synth_10531 synth_10621 synth_10466 synth_10672 VNB|VSS VDD VNB|VSS
+ sky130_fd_sc_hd__nand3b_1
X$3807 VDD synth_5157 synth_5341 synth_5343 synth_5344 VNB|VSS VDD VNB|VSS
+ sky130_fd_sc_hd__nand3b_1
X$3808 VDD synth_7582 synth_7700 synth_7581 synth_7659 VNB|VSS VDD VNB|VSS
+ sky130_fd_sc_hd__nand3b_1
X$3809 VDD synth_831 synth_829 synth_917 synth_1039 VNB|VSS VDD VNB|VSS
+ sky130_fd_sc_hd__nand3b_1
X$3810 VDD synth_12511 synth_12661 synth_12574 synth_12743 VNB|VSS VDD VNB|VSS
+ sky130_fd_sc_hd__nand3b_1
X$3811 VDD synth_3040 synth_2873 synth_2952 synth_2954 VNB|VSS VDD VNB|VSS
+ sky130_fd_sc_hd__nand3b_1
X$3812 VDD synth_8604 synth_9434 synth_8870 synth_10092 VNB|VSS VDD VNB|VSS
+ sky130_fd_sc_hd__nand3b_1
X$3813 VDD synth_6007 synth_6091 synth_6006 synth_6255 VNB|VSS VDD VNB|VSS
+ sky130_fd_sc_hd__nand3b_1
X$3814 VDD synth_7939 synth_8249 synth_8013 synth_8178 VNB|VSS VDD VNB|VSS
+ sky130_fd_sc_hd__nand3b_1
X$3815 VDD synth_8287 synth_8393 synth_8328 synth_8421 VNB|VSS VDD VNB|VSS
+ sky130_fd_sc_hd__nand3b_1
X$3816 VDD synth_7938 synth_8086 synth_7899 synth_8051 VNB|VSS VDD VNB|VSS
+ sky130_fd_sc_hd__nand3b_1
X$3817 VDD synth_358 synth_297 synth_298 synth_454 VNB|VSS VDD VNB|VSS
+ sky130_fd_sc_hd__nand3b_1
X$3818 VDD synth_4104 synth_4282 synth_4193 synth_4243 VNB|VSS VDD VNB|VSS
+ sky130_fd_sc_hd__nand3b_1
X$3819 VDD synth_11006 synth_11163 synth_10986 synth_11005 VNB|VSS VDD VNB|VSS
+ sky130_fd_sc_hd__nand3b_1
X$3820 VDD synth_930 synth_841 synth_842 synth_1012 VNB|VSS VDD VNB|VSS
+ sky130_fd_sc_hd__nand3b_1
X$3821 VDD synth_157 synth_155 synth_158 synth_244 VNB|VSS VDD VNB|VSS
+ sky130_fd_sc_hd__nand3b_1
X$3822 VDD synth_1199 synth_1302 synth_1198 synth_1305 VNB|VSS VDD VNB|VSS
+ sky130_fd_sc_hd__nand3b_1
X$3823 VDD synth_7501 synth_7674 synth_7495 synth_7817 VNB|VSS VDD VNB|VSS
+ sky130_fd_sc_hd__nand3b_1
X$3824 VDD synth_7435 synth_9153 synth_8991 VNB|VSS VDD synth_9046 VNB|VSS
+ sky130_fd_sc_hd__a21oi_1
X$3825 VDD synth_4951 synth_3541 synth_5127 VNB|VSS VDD synth_5239 VNB|VSS
+ sky130_fd_sc_hd__a21oi_1
X$3826 VDD synth_7176 synth_6732 synth_7173 VNB|VSS VDD synth_7085 VNB|VSS
+ sky130_fd_sc_hd__a21oi_1
X$3827 VDD synth_2400 synth_2017 synth_2535 VNB|VSS VDD synth_2534 VNB|VSS
+ sky130_fd_sc_hd__a21oi_1
X$3828 VDD synth_633 synth_167 synth_628 VNB|VSS VDD synth_455 VNB|VSS
+ sky130_fd_sc_hd__a21oi_1
X$3829 VDD synth_8143 synth_7111 synth_8008 VNB|VSS VDD synth_7900 VNB|VSS
+ sky130_fd_sc_hd__a21oi_1
X$3830 VDD synth_7025 synth_6809 synth_7024 VNB|VSS VDD synth_7084 VNB|VSS
+ sky130_fd_sc_hd__a21oi_1
X$3831 VDD synth_7435 synth_7979 synth_8526 VNB|VSS VDD synth_8443 VNB|VSS
+ sky130_fd_sc_hd__a21oi_1
X$3832 VDD synth_1081 synth_2276 synth_2278 VNB|VSS VDD synth_2121 VNB|VSS
+ sky130_fd_sc_hd__a21oi_1
X$3833 VDD synth_9292 synth_9239 synth_9580 VNB|VSS VDD synth_12153 VNB|VSS
+ sky130_fd_sc_hd__a21oi_1
X$3834 VDD synth_7736 synth_7662 synth_7625 VNB|VSS VDD synth_7661 VNB|VSS
+ sky130_fd_sc_hd__a21oi_1
X$3835 VDD synth_11119 synth_10785 synth_10932 VNB|VSS VDD synth_10974 VNB|VSS
+ sky130_fd_sc_hd__a21oi_1
X$3836 VDD synth_1840 synth_167 synth_1743 VNB|VSS VDD synth_1839 VNB|VSS
+ sky130_fd_sc_hd__a21oi_1
X$3837 VDD synth_6024 synth_5888 synth_5857 VNB|VSS VDD synth_5887 VNB|VSS
+ sky130_fd_sc_hd__a21oi_1
X$3838 VDD synth_11727 synth_8950 synth_11817 VNB|VSS VDD synth_11752 VNB|VSS
+ sky130_fd_sc_hd__a21oi_1
X$3839 VDD synth_6899 synth_6732 synth_7007 VNB|VSS VDD synth_6900 VNB|VSS
+ sky130_fd_sc_hd__a21oi_1
X$3840 VDD synth_10959 synth_10960 synth_11032 VNB|VSS VDD synth_10881 VNB|VSS
+ sky130_fd_sc_hd__a21oi_1
X$3841 VDD synth_9112 synth_8981 synth_9103 VNB|VSS VDD synth_9104 VNB|VSS
+ sky130_fd_sc_hd__a21oi_1
X$3842 VDD synth_12050 synth_9629 synth_12528 VNB|VSS VDD synth_12488 VNB|VSS
+ sky130_fd_sc_hd__a21oi_1
X$3843 VDD synth_8230 synth_8854 synth_8855 VNB|VSS VDD synth_8903 VNB|VSS
+ sky130_fd_sc_hd__a21oi_1
X$3844 VDD synth_1213 synth_2301 synth_2187 VNB|VSS VDD synth_2186 VNB|VSS
+ sky130_fd_sc_hd__a21oi_1
X$3845 VDD synth_7005 synth_6597 synth_6898 VNB|VSS VDD synth_6949 VNB|VSS
+ sky130_fd_sc_hd__a21oi_1
X$3846 VDD synth_1961 synth_1805 synth_2020 VNB|VSS VDD synth_1883 VNB|VSS
+ sky130_fd_sc_hd__a21oi_1
X$3847 VDD synth_6251 synth_6261 synth_6252 VNB|VSS VDD synth_6168 VNB|VSS
+ sky130_fd_sc_hd__a21oi_1
X$3848 VDD synth_1433 synth_1324 synth_346 VNB|VSS VDD synth_1508 VNB|VSS
+ sky130_fd_sc_hd__a21oi_1
X$3849 VDD synth_4302 synth_4301 synth_850 VNB|VSS VDD synth_4213 VNB|VSS
+ sky130_fd_sc_hd__a21oi_1
X$3850 VDD synth_346 synth_1641 synth_2119 VNB|VSS VDD synth_2173 VNB|VSS
+ sky130_fd_sc_hd__a21oi_1
X$3851 VDD synth_1081 synth_2545 synth_3337 VNB|VSS VDD synth_3521 VNB|VSS
+ sky130_fd_sc_hd__a21oi_1
X$3852 VDD synth_4340 synth_4430 synth_4475 VNB|VSS VDD synth_4339 VNB|VSS
+ sky130_fd_sc_hd__a21oi_1
X$3853 VDD synth_1654 synth_167 synth_1592 VNB|VSS VDD synth_1598 VNB|VSS
+ sky130_fd_sc_hd__a21oi_1
X$3854 VDD synth_7555 synth_7183 synth_7328 VNB|VSS VDD synth_7307 VNB|VSS
+ sky130_fd_sc_hd__a21oi_1
X$3855 VDD synth_6476 synth_7019 synth_7147 VNB|VSS VDD synth_7072 VNB|VSS
+ sky130_fd_sc_hd__a21oi_1
X$3856 VDD synth_8744 synth_8784 synth_8762 VNB|VSS VDD synth_8745 VNB|VSS
+ sky130_fd_sc_hd__a21oi_1
X$3857 VDD synth_2627 synth_6221 synth_6262 VNB|VSS VDD synth_6327 VNB|VSS
+ sky130_fd_sc_hd__a21oi_1
X$3858 VDD synth_7435 synth_9572 synth_8608 VNB|VSS VDD synth_8737 VNB|VSS
+ sky130_fd_sc_hd__a21oi_1
X$3859 VDD synth_3785 synth_3266 synth_408 VNB|VSS VDD synth_3716 VNB|VSS
+ sky130_fd_sc_hd__a21oi_1
X$3860 VDD synth_1169 synth_1093 synth_1127 VNB|VSS VDD synth_1151 VNB|VSS
+ sky130_fd_sc_hd__a21oi_1
X$3861 VDD synth_540 synth_194 synth_541 VNB|VSS VDD synth_471 VNB|VSS
+ sky130_fd_sc_hd__a21oi_1
X$3862 VDD synth_2760 synth_2662 synth_2759 VNB|VSS VDD synth_2732 VNB|VSS
+ sky130_fd_sc_hd__a21oi_1
X$3863 VDD synth_10007 synth_9701 synth_9927 VNB|VSS VDD synth_9980 VNB|VSS
+ sky130_fd_sc_hd__a21oi_1
X$3864 VDD synth_537 synth_194 synth_502 VNB|VSS VDD synth_469 VNB|VSS
+ sky130_fd_sc_hd__a21oi_1
X$3865 VDD synth_5649 synth_5812 synth_5980 VNB|VSS VDD synth_5896 VNB|VSS
+ sky130_fd_sc_hd__a21oi_1
X$3866 VDD synth_8765 synth_11631 synth_12109 VNB|VSS VDD synth_11754 VNB|VSS
+ sky130_fd_sc_hd__a21oi_1
X$3867 VDD synth_1361 synth_1360 synth_1417 VNB|VSS VDD synth_1328 VNB|VSS
+ sky130_fd_sc_hd__a21oi_1
X$3868 VDD synth_5936 synth_5757 synth_6027 VNB|VSS VDD synth_6028 VNB|VSS
+ sky130_fd_sc_hd__a21oi_1
X$3869 VDD synth_4667 synth_4665 synth_4668 VNB|VSS VDD synth_4596 VNB|VSS
+ sky130_fd_sc_hd__a21oi_1
X$3870 VDD synth_6618 synth_3541 synth_6589 VNB|VSS VDD synth_6532 VNB|VSS
+ sky130_fd_sc_hd__a21oi_1
X$3871 VDD synth_7435 synth_8383 synth_8844 VNB|VSS VDD synth_8925 VNB|VSS
+ sky130_fd_sc_hd__a21oi_1
X$3872 VDD synth_7435 synth_8384 synth_8922 VNB|VSS VDD synth_8937 VNB|VSS
+ sky130_fd_sc_hd__a21oi_1
X$3873 VDD synth_6182 synth_3544 synth_5970 VNB|VSS VDD synth_6135 VNB|VSS
+ sky130_fd_sc_hd__a21oi_1
X$3874 VDD synth_850 synth_4303 synth_4214 VNB|VSS VDD synth_4170 VNB|VSS
+ sky130_fd_sc_hd__a21oi_1
X$3875 VDD synth_9474 synth_10728 synth_10620 VNB|VSS VDD synth_10642 VNB|VSS
+ sky130_fd_sc_hd__a21oi_1
X$3876 VDD synth_6135 synth_3544 synth_5886 VNB|VSS VDD synth_6062 VNB|VSS
+ sky130_fd_sc_hd__a21oi_1
X$3877 VDD synth_9126 synth_9253 synth_9262 VNB|VSS VDD synth_9074 VNB|VSS
+ sky130_fd_sc_hd__a21oi_1
X$3878 VDD synth_10699 synth_9232 synth_10794 VNB|VSS VDD synth_10847 VNB|VSS
+ sky130_fd_sc_hd__a21oi_1
X$3879 VDD synth_2379 synth_2434 synth_2355 VNB|VSS VDD synth_2298 VNB|VSS
+ sky130_fd_sc_hd__a21oi_1
X$3880 VDD synth_9773 synth_8805 synth_11017 VNB|VSS VDD synth_11050 VNB|VSS
+ sky130_fd_sc_hd__a21oi_1
X$3881 VDD synth_8909 synth_8856 synth_8982 VNB|VSS VDD synth_8906 VNB|VSS
+ sky130_fd_sc_hd__a21oi_1
X$3882 VDD synth_7033 synth_7160 synth_7241 VNB|VSS VDD synth_7079 VNB|VSS
+ sky130_fd_sc_hd__a21oi_1
X$3883 VDD synth_10642 synth_10724 synth_10777 VNB|VSS VDD synth_10643 VNB|VSS
+ sky130_fd_sc_hd__a21oi_1
X$3884 VDD synth_7653 synth_6597 synth_7701 VNB|VSS VDD synth_7656 VNB|VSS
+ sky130_fd_sc_hd__a21oi_1
X$3885 VDD synth_6994 synth_4961 synth_6979 VNB|VSS VDD synth_6925 VNB|VSS
+ sky130_fd_sc_hd__a21oi_1
X$3886 VDD synth_6960 synth_6931 synth_6930 VNB|VSS VDD synth_6855 VNB|VSS
+ sky130_fd_sc_hd__a21oi_1
X$3887 VDD synth_4040 synth_3989 synth_4143 VNB|VSS VDD synth_4039 VNB|VSS
+ sky130_fd_sc_hd__a21oi_1
X$3888 VDD synth_171 synth_354 synth_291 VNB|VSS VDD synth_473 VNB|VSS
+ sky130_fd_sc_hd__a21oi_1
X$3889 VDD synth_6213 synth_5817 synth_6073 VNB|VSS VDD synth_6212 VNB|VSS
+ sky130_fd_sc_hd__a21oi_1
X$3890 VDD synth_3321 synth_927 synth_3251 VNB|VSS VDD synth_3320 VNB|VSS
+ sky130_fd_sc_hd__a21oi_1
X$3891 VDD synth_8097 synth_8096 synth_8186 VNB|VSS VDD synth_8034 VNB|VSS
+ sky130_fd_sc_hd__a21oi_1
X$3892 VDD synth_850 synth_3018 synth_3290 VNB|VSS VDD synth_3495 VNB|VSS
+ sky130_fd_sc_hd__a21oi_1
X$3893 VDD synth_10652 synth_10212 synth_10104 VNB|VSS VDD synth_11600 VNB|VSS
+ sky130_fd_sc_hd__a21oi_1
X$3894 VDD synth_581 synth_5093 synth_5092 VNB|VSS VDD synth_5025 VNB|VSS
+ sky130_fd_sc_hd__a21oi_1
X$3895 VDD synth_593 synth_194 synth_668 VNB|VSS VDD synth_594 VNB|VSS
+ sky130_fd_sc_hd__a21oi_1
X$3896 VDD synth_7122 synth_7039 synth_7042 VNB|VSS VDD synth_7040 VNB|VSS
+ sky130_fd_sc_hd__a21oi_1
X$3897 VDD synth_4662 synth_4660 synth_4572 VNB|VSS VDD synth_4659 VNB|VSS
+ sky130_fd_sc_hd__a21oi_1
X$3898 VDD synth_7932 synth_7930 synth_7903 VNB|VSS VDD synth_7862 VNB|VSS
+ sky130_fd_sc_hd__a21oi_1
X$3899 VDD synth_8230 synth_8624 synth_8749 VNB|VSS VDD synth_8748 VNB|VSS
+ sky130_fd_sc_hd__a21oi_1
X$3900 VDD synth_650 synth_611 synth_599 VNB|VSS VDD synth_598 VNB|VSS
+ sky130_fd_sc_hd__a21oi_1
X$3901 VDD synth_9078 synth_7089 synth_8618 VNB|VSS VDD synth_8693 VNB|VSS
+ sky130_fd_sc_hd__a21oi_1
X$3902 VDD synth_6476 synth_7146 synth_7070 VNB|VSS VDD synth_7064 VNB|VSS
+ sky130_fd_sc_hd__a21oi_1
X$3903 VDD synth_433 synth_338 synth_432 VNB|VSS VDD synth_477 VNB|VSS
+ sky130_fd_sc_hd__a21oi_1
X$3904 VDD synth_435 synth_79 synth_194 synth_434 VDD VNB|VSS VNB|VSS
+ sky130_fd_sc_hd__nand3_1
X$3905 VDD synth_4809 synth_4660 synth_4902 VNB|VSS VDD synth_4641 VNB|VSS
+ sky130_fd_sc_hd__a21oi_1
X$3906 VDD synth_11566 synth_11601 synth_11714 VNB|VSS VDD synth_11563 VNB|VSS
+ sky130_fd_sc_hd__a21oi_1
X$3907 VDD synth_6532 synth_3541 synth_6565 VNB|VSS VDD synth_6562 VNB|VSS
+ sky130_fd_sc_hd__a21oi_1
X$3908 VDD synth_8485 synth_8483 synth_8486 VNB|VSS VDD synth_8105 VNB|VSS
+ sky130_fd_sc_hd__a21oi_1
X$3909 VDD synth_6183 synth_5888 synth_6064 VNB|VSS VDD synth_6103 VNB|VSS
+ sky130_fd_sc_hd__a21oi_1
X$3910 VDD synth_474 synth_274 synth_1690 VNB|VSS VDD synth_1585 VNB|VSS
+ sky130_fd_sc_hd__a21oi_1
X$3911 VDD synth_8230 synth_8677 synth_8753 VNB|VSS VDD synth_8730 VNB|VSS
+ sky130_fd_sc_hd__a21oi_1
X$3912 VDD synth_410 synth_66 synth_290 VNB|VSS VDD synth_109 VNB|VSS
+ sky130_fd_sc_hd__a21oi_1
X$3913 VDD synth_6765 synth_6863 synth_6713 VNB|VSS VDD synth_6766 VNB|VSS
+ sky130_fd_sc_hd__a21oi_1
X$3914 VDD synth_8693 synth_7089 synth_8694 VNB|VSS VDD synth_8818 VNB|VSS
+ sky130_fd_sc_hd__a21oi_1
X$3915 VDD synth_3643 synth_3572 synth_3588 VNB|VSS VDD synth_3571 VNB|VSS
+ sky130_fd_sc_hd__a21oi_1
X$3916 VDD synth_2917 synth_2721 synth_1213 VNB|VSS VDD synth_2789 VNB|VSS
+ sky130_fd_sc_hd__a21oi_1
X$3917 VDD synth_10849 synth_9387 synth_8945 VNB|VSS VDD synth_11864 VNB|VSS
+ sky130_fd_sc_hd__a21oi_1
X$3918 VDD synth_6476 synth_7255 synth_7185 VNB|VSS VDD synth_7184 VNB|VSS
+ sky130_fd_sc_hd__a21oi_1
X$3919 VDD synth_1635 synth_2015 synth_1798 VNB|VSS VDD synth_1880 VNB|VSS
+ sky130_fd_sc_hd__a21oi_1
X$3920 VDD synth_1924 synth_2040 synth_1923 synth_1798 synth_1687 VDD
+ synth_2017 VNB|VSS VNB|VSS sky130_fd_sc_hd__o311ai_0
X$3921 VDD synth_9297 synth_11699 synth_11657 VNB|VSS VDD synth_11625 VNB|VSS
+ sky130_fd_sc_hd__a21oi_1
X$3922 VDD synth_972 synth_1093 synth_1017 VNB|VSS VDD synth_1018 VNB|VSS
+ sky130_fd_sc_hd__a21oi_1
X$3923 VDD synth_3125 synth_659 synth_3051 VNB|VSS VDD synth_2976 VNB|VSS
+ sky130_fd_sc_hd__a21oi_1
X$3924 VDD synth_9297 synth_11829 synth_11623 VNB|VSS VDD synth_11735 VNB|VSS
+ sky130_fd_sc_hd__a21oi_1
X$3925 VDD synth_10089 synth_10150 synth_10088 VNB|VSS VDD synth_10210 VNB|VSS
+ sky130_fd_sc_hd__a21oi_1
X$3926 VDD synth_6758 synth_6838 synth_7049 VNB|VSS VDD synth_6913 VNB|VSS
+ sky130_fd_sc_hd__a21oi_1
X$3927 VDD synth_11350 synth_11565 synth_11530 VNB|VSS VDD synth_11494 VNB|VSS
+ sky130_fd_sc_hd__a21oi_1
X$3928 VDD synth_10795 synth_10578 synth_10232 VNB|VSS VDD synth_12156 VNB|VSS
+ sky130_fd_sc_hd__a21oi_1
X$3929 VDD synth_10652 synth_12107 synth_12137 VNB|VSS VDD synth_12209 VNB|VSS
+ sky130_fd_sc_hd__a21oi_1
X$3930 VDD synth_4978 synth_4846 synth_4940 VNB|VSS VDD synth_4792 VNB|VSS
+ sky130_fd_sc_hd__a21oi_1
X$3931 VDD synth_3168 synth_3105 synth_3145 VNB|VSS VDD synth_3143 VNB|VSS
+ sky130_fd_sc_hd__a21oi_1
X$3932 VDD synth_7052 synth_6834 synth_7125 VNB|VSS VDD synth_7046 VNB|VSS
+ sky130_fd_sc_hd__a21oi_1
X$3933 VDD synth_1662 synth_1661 synth_1900 VNB|VSS VDD synth_1755 VNB|VSS
+ sky130_fd_sc_hd__a21oi_1
X$3934 VDD synth_9691 synth_12103 synth_11448 VNB|VSS VDD synth_11418 VNB|VSS
+ sky130_fd_sc_hd__a21oi_1
X$3935 VDD synth_9049 synth_10229 synth_11057 VNB|VSS VDD synth_10790 VNB|VSS
+ sky130_fd_sc_hd__a21oi_1
X$3936 VDD synth_8672 synth_8638 synth_8555 VNB|VSS VDD synth_8414 VNB|VSS
+ sky130_fd_sc_hd__a21oi_1
X$3937 VDD synth_9665 synth_9690 synth_9733 VNB|VSS VDD synth_9664 VNB|VSS
+ sky130_fd_sc_hd__a21oi_1
X$3938 VDD synth_9734 synth_9419 synth_9692 VNB|VSS VDD synth_9667 VNB|VSS
+ sky130_fd_sc_hd__a21oi_1
X$3939 VDD synth_3527 synth_3750 synth_3993 VNB|VSS VDD synth_3816 VNB|VSS
+ sky130_fd_sc_hd__a21oi_1
X$3940 VDD synth_9895 synth_9042 synth_9036 VNB|VSS VDD synth_9852 VNB|VSS
+ sky130_fd_sc_hd__a21oi_1
X$3941 VDD synth_2360 synth_2362 synth_2436 VNB|VSS VDD synth_2361 VNB|VSS
+ sky130_fd_sc_hd__a21oi_1
X$3942 VDD synth_1407 synth_151 synth_1283 VNB|VSS VDD synth_1187 VNB|VSS
+ sky130_fd_sc_hd__a21oi_1
X$3943 VDD synth_11732 synth_10285 synth_11646 VNB|VSS VDD synth_11649 VNB|VSS
+ sky130_fd_sc_hd__a21oi_1
X$3944 VDD synth_1082 synth_66 synth_998 VNB|VSS VDD synth_1083 VNB|VSS
+ sky130_fd_sc_hd__a21oi_1
X$3945 VDD synth_12334 synth_12307 synth_12332 VNB|VSS VDD synth_12376 VNB|VSS
+ sky130_fd_sc_hd__a21oi_1
X$3946 VDD synth_1242 synth_1172 synth_1390 VNB|VSS VDD synth_1211 VNB|VSS
+ sky130_fd_sc_hd__a21oi_1
X$3947 VDD synth_9297 synth_11830 synth_11706 VNB|VSS VDD synth_11736 VNB|VSS
+ sky130_fd_sc_hd__a21oi_1
X$3948 VDD synth_4335 synth_4386 synth_4646 VNB|VSS VDD synth_4688 VNB|VSS
+ sky130_fd_sc_hd__a21oi_1
X$3949 VDD synth_715 synth_758 synth_876 VNB|VSS VDD synth_652 VNB|VSS
+ sky130_fd_sc_hd__a21oi_1
X$3950 VDD synth_3502 synth_3294 synth_3371 VNB|VSS VDD synth_3370 VNB|VSS
+ sky130_fd_sc_hd__a21oi_1
X$3951 VDD synth_7966 synth_7111 synth_7941 VNB|VSS VDD synth_7964 VNB|VSS
+ sky130_fd_sc_hd__a21oi_1
X$3952 VDD synth_2309 synth_2626 synth_2337 VNB|VSS VDD synth_2696 VNB|VSS
+ sky130_fd_sc_hd__a21oi_1
X$3953 VDD synth_8561 synth_8412 synth_8015 VNB|VSS VDD synth_8581 VNB|VSS
+ sky130_fd_sc_hd__a21oi_1
X$3954 VDD synth_408 synth_941 synth_1085 VNB|VSS VDD synth_1030 VNB|VSS
+ sky130_fd_sc_hd__a21oi_1
X$3955 VDD synth_5286 synth_5485 synth_5845 VNB|VSS VDD synth_5844 VNB|VSS
+ sky130_fd_sc_hd__a21oi_1
X$3956 VDD synth_10780 synth_10578 synth_10643 VNB|VSS VDD synth_10350 VNB|VSS
+ sky130_fd_sc_hd__a21oi_1
X$3957 VDD synth_1640 synth_1731 synth_1693 VNB|VSS VDD synth_1732 VNB|VSS
+ sky130_fd_sc_hd__a21oi_1
X$3958 VDD synth_5272 synth_5350 synth_581 VNB|VSS VDD synth_5372 VNB|VSS
+ sky130_fd_sc_hd__a21oi_1
X$3959 VDD synth_6211 synth_7494 synth_7584 VNB|VSS VDD synth_7540 VNB|VSS
+ sky130_fd_sc_hd__a21oi_1
X$3960 VDD synth_2812 synth_927 synth_2888 VNB|VSS VDD synth_2818 VNB|VSS
+ sky130_fd_sc_hd__a21oi_1
X$3961 VDD synth_3527 synth_2641 synth_3623 VNB|VSS VDD synth_3501 VNB|VSS
+ sky130_fd_sc_hd__a21oi_1
X$3962 VDD synth_2889 synth_2815 synth_2739 VNB|VSS VDD synth_2814 VNB|VSS
+ sky130_fd_sc_hd__a21oi_1
X$3963 VDD synth_8230 synth_8156 synth_8667 VNB|VSS VDD synth_8625 VNB|VSS
+ sky130_fd_sc_hd__a21oi_1
X$3964 VDD synth_9297 synth_11652 synth_11705 VNB|VSS VDD synth_11703 VNB|VSS
+ sky130_fd_sc_hd__a21oi_1
X$3965 VDD synth_10252 synth_9947 synth_10107 VNB|VSS VDD synth_10125 VNB|VSS
+ sky130_fd_sc_hd__a21oi_1
X$3966 VDD synth_970 synth_659 synth_971 VNB|VSS VDD synth_1016 VNB|VSS
+ sky130_fd_sc_hd__a21oi_1
X$3967 VDD synth_8089 synth_7111 synth_8090 VNB|VSS VDD synth_8211 VNB|VSS
+ sky130_fd_sc_hd__a21oi_1
X$3968 VDD synth_2887 synth_927 synth_2971 VNB|VSS VDD synth_2812 VNB|VSS
+ sky130_fd_sc_hd__a21oi_1
X$3969 VDD synth_6058 synth_3468 synth_5904 VNB|VSS VDD synth_5903 VNB|VSS
+ sky130_fd_sc_hd__a21oi_1
X$3970 VDD synth_8211 synth_7111 synth_8092 VNB|VSS VDD synth_8041 VNB|VSS
+ sky130_fd_sc_hd__a21oi_1
X$3971 VDD synth_4664 synth_2116 synth_4812 VNB|VSS VDD synth_4640 VNB|VSS
+ sky130_fd_sc_hd__a21oi_1
X$3972 VDD synth_1406 synth_1285 synth_1367 VNB|VSS VDD synth_1405 VNB|VSS
+ sky130_fd_sc_hd__a21oi_1
X$3973 VDD synth_3384 synth_3465 synth_3532 VNB|VSS VDD synth_3304 VNB|VSS
+ sky130_fd_sc_hd__a21oi_1
X$3974 VDD synth_1213 synth_2420 synth_2423 VNB|VSS VDD synth_2516 VNB|VSS
+ sky130_fd_sc_hd__a21oi_1
X$3975 VDD synth_8765 synth_11570 synth_11349 VNB|VSS VDD synth_11502 VNB|VSS
+ sky130_fd_sc_hd__a21oi_1
X$3976 VDD synth_7048 synth_7126 synth_7049 VNB|VSS VDD synth_7217 VNB|VSS
+ sky130_fd_sc_hd__a21oi_1
X$3977 VDD synth_7032 synth_7030 synth_7004 VNB|VSS VDD synth_7029 VNB|VSS
+ sky130_fd_sc_hd__a21oi_1
X$3978 VDD synth_10514 synth_10544 synth_10894 VNB|VSS VDD synth_10447 VNB|VSS
+ sky130_fd_sc_hd__a21oi_1
X$3979 VDD synth_2613 synth_2433 synth_408 VNB|VSS VDD synth_2546 VNB|VSS
+ sky130_fd_sc_hd__a21oi_1
X$3980 VDD synth_11870 synth_9483 synth_10007 VNB|VSS VDD synth_11898 VNB|VSS
+ sky130_fd_sc_hd__a21oi_1
X$3981 VDD synth_1213 synth_1951 synth_2189 VNB|VSS VDD synth_2165 VNB|VSS
+ sky130_fd_sc_hd__a21oi_1
X$3982 VDD synth_7643 synth_7564 synth_7682 VNB|VSS VDD synth_7680 VNB|VSS
+ sky130_fd_sc_hd__a21oi_1
X$3983 VDD synth_11956 synth_11920 synth_9691 VNB|VSS VDD synth_11847 VNB|VSS
+ sky130_fd_sc_hd__a21oi_1
X$3984 VDD synth_339 synth_338 synth_372 VNB|VSS VDD synth_271 VNB|VSS
+ sky130_fd_sc_hd__a21oi_1
X$3985 VDD synth_10663 synth_9947 synth_10107 VNB|VSS VDD synth_10664 VNB|VSS
+ sky130_fd_sc_hd__a21oi_1
X$3986 VDD synth_11289 synth_9423 synth_11246 VNB|VSS VDD synth_11132 VNB|VSS
+ sky130_fd_sc_hd__a21oi_1
X$3987 VDD synth_5872 synth_5899 synth_5871 VNB|VSS VDD synth_5783 VNB|VSS
+ sky130_fd_sc_hd__a21oi_1
X$3988 VDD synth_3688 synth_3746 synth_3783 VNB|VSS VDD synth_3659 VNB|VSS
+ sky130_fd_sc_hd__a21oi_1
X$3989 VDD synth_10381 synth_10379 synth_10608 VNB|VSS VDD synth_10383 VNB|VSS
+ sky130_fd_sc_hd__a21oi_1
X$3990 VDD synth_12193 synth_11959 synth_12194 VNB|VSS VDD synth_12131 VNB|VSS
+ sky130_fd_sc_hd__a21oi_1
X$3991 VDD synth_5874 synth_5812 synth_5875 VNB|VSS VDD synth_5711 VNB|VSS
+ sky130_fd_sc_hd__a21oi_1
X$3992 VDD synth_9947 synth_10022 synth_10023 VNB|VSS VDD synth_10128 VNB|VSS
+ sky130_fd_sc_hd__a21oi_1
X$3993 VDD synth_6944 synth_6597 synth_7008 VNB|VSS VDD synth_6945 VNB|VSS
+ sky130_fd_sc_hd__a21oi_1
X$3994 VDD synth_11132 synth_9423 synth_11003 VNB|VSS VDD synth_11061 VNB|VSS
+ sky130_fd_sc_hd__a21oi_1
X$3995 VDD synth_6211 synth_7171 synth_7170 VNB|VSS VDD synth_6969 VNB|VSS
+ sky130_fd_sc_hd__a21oi_1
X$3996 VDD synth_9434 synth_10099 synth_11650 VNB|VSS VDD synth_11591 VNB|VSS
+ sky130_fd_sc_hd__a21oi_1
X$3997 VDD synth_10455 synth_9947 synth_10392 VNB|VSS VDD synth_9136 VNB|VSS
+ sky130_fd_sc_hd__a21oi_1
X$3998 VDD synth_6211 synth_7759 synth_7542 VNB|VSS VDD synth_7624 VNB|VSS
+ sky130_fd_sc_hd__a21oi_1
X$3999 VNB|VSS synth_7738 synth_4821 synth_7423 synth_7501 VDD VDD VNB|VSS
+ sky130_fd_sc_hd__nor3b_4
X$4000 VNB|VSS synth_7758 synth_7423 synth_7738 synth_7501 VDD VDD VNB|VSS
+ sky130_fd_sc_hd__nor3b_2
X$4001 VDD synth_3854 synth_4050 synth_3841 VNB|VSS VDD synth_4051 VNB|VSS
+ sky130_fd_sc_hd__a21oi_1
X$4002 VDD synth_1598 synth_167 synth_1655 VNB|VSS VDD synth_1597 VNB|VSS
+ sky130_fd_sc_hd__a21oi_1
X$4003 VDD synth_474 synth_2192 synth_2314 VNB|VSS VDD synth_2312 VNB|VSS
+ sky130_fd_sc_hd__a21oi_1
X$4004 VDD synth_5759 synth_5828 synth_5765 VNB|VSS VDD synth_5758 VNB|VSS
+ sky130_fd_sc_hd__a21oi_1
X$4005 VDD synth_3911 synth_3907 synth_3844 VNB|VSS VDD synth_3909 VNB|VSS
+ sky130_fd_sc_hd__a21oi_1
X$4006 VDD synth_8932 synth_8827 synth_8230 VNB|VSS VDD synth_8900 VNB|VSS
+ sky130_fd_sc_hd__a21oi_1
X$4007 VDD synth_9092 synth_8974 synth_8972 VNB|VSS VDD synth_8899 VNB|VSS
+ sky130_fd_sc_hd__a21oi_1
X$4008 VDD synth_4952 synth_5053 synth_5125 VNB|VSS VDD synth_5241 VNB|VSS
+ sky130_fd_sc_hd__a21oi_1
X$4009 VDD synth_1252 synth_1225 synth_474 VNB|VSS VDD synth_1397 VNB|VSS
+ sky130_fd_sc_hd__a21oi_1
X$4010 VDD synth_1326 synth_1266 synth_1329 VNB|VSS VDD synth_1325 VNB|VSS
+ sky130_fd_sc_hd__a21oi_1
X$4011 VDD synth_4324 synth_2116 synth_4281 VNB|VSS VDD synth_4323 VNB|VSS
+ sky130_fd_sc_hd__a21oi_1
X$4012 VDD synth_5985 synth_5986 synth_5955 VNB|VSS VDD synth_5905 VNB|VSS
+ sky130_fd_sc_hd__a21oi_1
X$4013 VDD synth_9297 synth_11587 synth_11702 VNB|VSS VDD synth_11562 VNB|VSS
+ sky130_fd_sc_hd__a21oi_1
X$4014 VDD synth_9375 synth_9469 synth_9169 VNB|VSS VDD synth_9374 VNB|VSS
+ sky130_fd_sc_hd__a21oi_1
X$4015 VDD synth_1081 synth_1674 synth_1651 VNB|VSS VDD synth_1556 VNB|VSS
+ sky130_fd_sc_hd__a21oi_1
X$4016 VDD synth_850 synth_3618 synth_3621 VNB|VSS VDD synth_3499 VNB|VSS
+ sky130_fd_sc_hd__a21oi_1
X$4017 VDD synth_10504 synth_10505 synth_10476 VNB|VSS VDD synth_10506 VNB|VSS
+ sky130_fd_sc_hd__a21oi_1
X$4018 VDD synth_8230 synth_9500 synth_9468 VNB|VSS VDD synth_9414 VNB|VSS
+ sky130_fd_sc_hd__a21oi_1
X$4019 VDD synth_3545 synth_3619 synth_3589 VNB|VSS VDD synth_3494 VNB|VSS
+ sky130_fd_sc_hd__a21oi_1
X$4020 VDD synth_11747 synth_9062 synth_11748 VNB|VSS VDD synth_11796 VNB|VSS
+ sky130_fd_sc_hd__a21oi_1
X$4021 VDD synth_3964 synth_3386 synth_4197 VNB|VSS VDD synth_4196 VNB|VSS
+ sky130_fd_sc_hd__a21oi_1
X$4022 VDD synth_109 synth_66 synth_98 VNB|VSS VDD synth_76 VNB|VSS
+ sky130_fd_sc_hd__a21oi_1
X$4023 VDD synth_9637 synth_9635 synth_9704 VNB|VSS VDD synth_9528 VNB|VSS
+ sky130_fd_sc_hd__a21oi_1
X$4024 VDD synth_474 synth_2457 synth_2425 VNB|VSS VDD synth_2402 VNB|VSS
+ sky130_fd_sc_hd__a21oi_1
X$4025 VDD synth_12235 synth_9292 synth_9677 VNB|VSS VDD synth_12233 VNB|VSS
+ sky130_fd_sc_hd__a21oi_1
X$4026 VDD synth_8672 synth_8638 synth_8670 VNB|VSS VDD synth_8397 VNB|VSS
+ sky130_fd_sc_hd__a21oi_1
X$4027 VDD synth_1922 synth_66 synth_1974 VNB|VSS VDD synth_1849 VNB|VSS
+ sky130_fd_sc_hd__a21oi_1
X$4028 VDD synth_5563 synth_5419 synth_5537 VNB|VSS VDD synth_5502 VNB|VSS
+ sky130_fd_sc_hd__a21oi_1
X$4029 VDD synth_1081 synth_1445 synth_1447 VNB|VSS VDD synth_1486 VNB|VSS
+ sky130_fd_sc_hd__a21oi_1
X$4030 VDD synth_6476 synth_6596 synth_6963 VNB|VSS VDD synth_6995 VNB|VSS
+ sky130_fd_sc_hd__a21oi_1
X$4031 VDD synth_10597 synth_8746 synth_10563 VNB|VSS VDD synth_10526 VNB|VSS
+ sky130_fd_sc_hd__a21oi_1
X$4032 VDD synth_7165 synth_7102 synth_7099 VNB|VSS VDD synth_7001 VNB|VSS
+ sky130_fd_sc_hd__a21oi_1
X$4033 VDD synth_2421 synth_2422 synth_2394 VNB|VSS VDD synth_2513 VNB|VSS
+ sky130_fd_sc_hd__a21oi_1
X$4034 VDD synth_9490 synth_9409 synth_9538 VNB|VSS VDD synth_9491 VNB|VSS
+ sky130_fd_sc_hd__a21oi_1
X$4035 VDD synth_10193 synth_10063 synth_9297 VNB|VSS VDD synth_10114 VNB|VSS
+ sky130_fd_sc_hd__a21oi_1
X$4036 VDD synth_12575 synth_9762 synth_12742 VNB|VSS VDD synth_12621 VNB|VSS
+ sky130_fd_sc_hd__a21oi_1
X$4037 VDD synth_9387 synth_10312 synth_8948 VNB|VSS VDD synth_11069 VNB|VSS
+ sky130_fd_sc_hd__a21oi_1
X$4038 VDD synth_6740 synth_6774 synth_6933 VNB|VSS VDD synth_6502 VNB|VSS
+ sky130_fd_sc_hd__a21oi_1
X$4039 VDD synth_9901 synth_9042 synth_11167 VNB|VSS VDD synth_11227 VNB|VSS
+ sky130_fd_sc_hd__a21oi_1
X$4040 VDD synth_5487 synth_3544 synth_5488 VNB|VSS VDD synth_5554 VNB|VSS
+ sky130_fd_sc_hd__a21oi_1
X$4041 VDD synth_9939 synth_9940 synth_10018 VNB|VSS VDD synth_9941 VNB|VSS
+ sky130_fd_sc_hd__a21oi_1
X$4042 VDD synth_9350 synth_8746 synth_9353 VNB|VSS VDD synth_9403 VNB|VSS
+ sky130_fd_sc_hd__a21oi_1
X$4043 VDD synth_7435 synth_7897 synth_8359 VNB|VSS VDD synth_8286 VNB|VSS
+ sky130_fd_sc_hd__a21oi_1
X$4044 VDD synth_9036 synth_9677 synth_9900 VNB|VSS VDD synth_12598 VNB|VSS
+ sky130_fd_sc_hd__a21oi_1
X$4045 VDD synth_6571 synth_4961 synth_6616 VNB|VSS VDD synth_6572 VNB|VSS
+ sky130_fd_sc_hd__a21oi_1
X$4046 VDD synth_2250 synth_2116 synth_2252 VNB|VSS VDD synth_2251 VNB|VSS
+ sky130_fd_sc_hd__a21oi_1
X$4047 VDD synth_7898 synth_7781 synth_7435 VNB|VSS VDD synth_7833 VNB|VSS
+ sky130_fd_sc_hd__a21oi_1
X$4048 VDD synth_8230 synth_9459 synth_9274 VNB|VSS VDD synth_9219 VNB|VSS
+ sky130_fd_sc_hd__a21oi_1
X$4049 VDD synth_408 synth_3772 synth_4052 VNB|VSS VDD synth_3839 VNB|VSS
+ sky130_fd_sc_hd__a21oi_1
X$4050 VDD synth_9066 synth_9146 synth_9123 VNB|VSS VDD synth_9068 VNB|VSS
+ sky130_fd_sc_hd__a21oi_1
X$4051 VDD synth_8158 synth_7183 synth_8159 VNB|VSS VDD synth_8160 VNB|VSS
+ sky130_fd_sc_hd__a21oi_1
X$4052 VDD synth_8160 synth_7183 synth_7892 VNB|VSS VDD synth_8071 VNB|VSS
+ sky130_fd_sc_hd__a21oi_1
X$4053 VDD synth_408 synth_355 synth_860 VNB|VSS VDD synth_776 VNB|VSS
+ sky130_fd_sc_hd__a21oi_1
X$4054 VDD synth_822 synth_151 synth_823 VNB|VSS VDD synth_824 VNB|VSS
+ sky130_fd_sc_hd__a21oi_1
X$4055 VDD synth_9049 synth_11086 synth_11161 VNB|VSS VDD synth_11159 VNB|VSS
+ sky130_fd_sc_hd__a21oi_1
X$4056 VDD synth_9699 synth_9235 synth_9696 VNB|VSS VDD synth_9391 VNB|VSS
+ sky130_fd_sc_hd__a21oi_1
X$4057 VDD synth_10697 synth_9559 synth_10220 VNB|VSS VDD synth_11518 VNB|VSS
+ sky130_fd_sc_hd__a21oi_1
X$4058 VDD synth_3424 synth_3404 synth_3405 VNB|VSS VDD synth_3425 VNB|VSS
+ sky130_fd_sc_hd__a21oi_1
X$4059 VDD synth_8910 synth_9239 synth_8981 VNB|VSS VDD synth_9985 VNB|VSS
+ sky130_fd_sc_hd__a21oi_1
X$4060 VDD synth_8230 synth_9305 synth_9306 VNB|VSS VDD synth_9412 VNB|VSS
+ sky130_fd_sc_hd__a21oi_1
X$4061 VDD synth_727 synth_151 synth_753 VNB|VSS VDD synth_658 VNB|VSS
+ sky130_fd_sc_hd__a21oi_1
X$4062 VDD synth_8870 synth_10697 synth_9044 VNB|VSS VDD synth_11318 VNB|VSS
+ sky130_fd_sc_hd__a21oi_1
X$4063 VDD synth_1358 synth_1356 synth_1412 VNB|VSS VDD synth_1269 VNB|VSS
+ sky130_fd_sc_hd__a21oi_1
X$4064 VDD synth_5337 synth_3468 synth_5338 VNB|VSS VDD synth_5315 VNB|VSS
+ sky130_fd_sc_hd__a21oi_1
X$4065 VDD synth_5285 synth_5007 synth_5192 VNB|VSS VDD synth_5095 VNB|VSS
+ sky130_fd_sc_hd__a21oi_1
X$4066 VDD synth_12487 synth_9762 synth_12697 VNB|VSS VDD synth_12624 VNB|VSS
+ sky130_fd_sc_hd__a21oi_1
X$4067 VDD synth_850 synth_4581 synth_4585 VNB|VSS VDD synth_4517 VNB|VSS
+ sky130_fd_sc_hd__a21oi_1
X$4068 VDD synth_1081 synth_4287 synth_4285 VNB|VSS VDD synth_4314 VNB|VSS
+ sky130_fd_sc_hd__a21oi_1
X$4069 VDD synth_9493 synth_9687 synth_9297 VNB|VSS VDD synth_9542 VNB|VSS
+ sky130_fd_sc_hd__a21oi_1
X$4070 VDD synth_520 synth_161 synth_459 VNB|VSS VDD synth_404 VNB|VSS
+ sky130_fd_sc_hd__a21oi_1
X$4071 VDD synth_12334 synth_12307 synth_12261 VNB|VSS VDD synth_12672 VNB|VSS
+ sky130_fd_sc_hd__a21oi_1
X$4072 VDD synth_9456 synth_9411 synth_9457 VNB|VSS VDD synth_9363 VNB|VSS
+ sky130_fd_sc_hd__a21oi_1
X$4073 VDD synth_530 synth_167 synth_529 VNB|VSS VDD synth_463 VNB|VSS
+ sky130_fd_sc_hd__a21oi_1
X$4074 VDD synth_824 synth_151 synth_964 VNB|VSS VDD synth_883 VNB|VSS
+ sky130_fd_sc_hd__a21oi_1
X$4075 VDD synth_708 synth_66 synth_996 VNB|VSS VDD synth_1082 VNB|VSS
+ sky130_fd_sc_hd__a21oi_1
X$4076 VDD synth_10527 synth_10495 synth_10746 VNB|VSS VDD synth_10704 VNB|VSS
+ sky130_fd_sc_hd__a21oi_1
X$4077 VDD synth_11080 synth_11073 synth_9609 VNB|VSS VDD synth_11054 VNB|VSS
+ sky130_fd_sc_hd__a21oi_1
X$4078 VDD synth_8866 synth_8000 synth_8865 VNB|VSS VDD synth_8798 VNB|VSS
+ sky130_fd_sc_hd__a21oi_1
X$4079 VDD synth_5554 synth_3544 synth_5489 VNB|VSS VDD synth_5449 VNB|VSS
+ sky130_fd_sc_hd__a21oi_1
X$4080 VDD synth_8764 synth_9833 synth_9848 VNB|VSS VDD synth_9765 VNB|VSS
+ sky130_fd_sc_hd__a21oi_1
X$4081 VDD synth_9112 synth_8981 synth_10728 VNB|VSS VDD synth_10293 VNB|VSS
+ sky130_fd_sc_hd__a21oi_1
X$4082 VDD synth_7925 synth_7929 synth_7927 VNB|VSS VDD synth_7977 VNB|VSS
+ sky130_fd_sc_hd__a21oi_1
X$4083 VDD synth_10761 synth_10505 synth_10633 VNB|VSS VDD synth_10573 VNB|VSS
+ sky130_fd_sc_hd__a21oi_1
X$4084 VDD synth_7943 synth_7796 synth_7957 VNB|VSS VDD synth_7944 VNB|VSS
+ sky130_fd_sc_hd__a21oi_1
X$4085 VDD synth_12379 synth_9762 synth_12660 VNB|VSS VDD synth_12575 VNB|VSS
+ sky130_fd_sc_hd__a21oi_1
X$4086 VDD synth_7466 synth_7575 synth_7551 VNB|VSS VDD synth_7550 VNB|VSS
+ sky130_fd_sc_hd__a21oi_1
X$4087 VDD synth_6846 synth_6393 synth_6833 VNB|VSS VDD synth_6617 VNB|VSS
+ sky130_fd_sc_hd__a21oi_1
X$4088 VDD synth_3711 synth_3541 synth_3653 VNB|VSS VDD synth_3319 VNB|VSS
+ sky130_fd_sc_hd__a21oi_1
X$4089 VDD synth_2183 synth_2293 synth_2182 VNB|VSS VDD synth_2181 VNB|VSS
+ sky130_fd_sc_hd__a21oi_1
X$4090 VDD synth_12353 synth_12400 synth_12354 VNB|VSS VDD synth_12333 VNB|VSS
+ sky130_fd_sc_hd__a21oi_1
X$4091 VDD synth_8080 synth_8000 synth_8002 VNB|VSS VDD synth_8062 VNB|VSS
+ sky130_fd_sc_hd__a21oi_1
X$4092 VDD synth_1003 synth_1206 synth_859 VNB|VSS VDD synth_1150 VNB|VSS
+ sky130_fd_sc_hd__a21oi_1
X$4093 VDD synth_12365 synth_12363 synth_12371 VNB|VSS VDD synth_12471 VNB|VSS
+ sky130_fd_sc_hd__a21oi_1
X$4094 VDD synth_850 synth_2029 synth_2106 VNB|VSS VDD synth_2030 VNB|VSS
+ sky130_fd_sc_hd__a21oi_1
X$4095 VDD synth_6095 synth_4961 synth_6172 VNB|VSS VDD synth_6093 VNB|VSS
+ sky130_fd_sc_hd__a21oi_1
X$4096 VDD synth_3964 synth_5856 synth_5754 VNB|VSS VDD synth_5728 VNB|VSS
+ sky130_fd_sc_hd__a21oi_1
X$4097 VDD synth_474 synth_4894 synth_4713 VNB|VSS VDD synth_5773 VNB|VSS
+ sky130_fd_sc_hd__a21oi_1
X$4098 VDD synth_3095 synth_1353 synth_3039 VNB|VSS VDD synth_3013 VNB|VSS
+ sky130_fd_sc_hd__a21oi_1
X$4099 VDD synth_9387 synth_10099 synth_9060 VNB|VSS VDD synth_12238 VNB|VSS
+ sky130_fd_sc_hd__a21oi_1
X$4100 VDD synth_7890 synth_7743 synth_7799 VNB|VSS VDD synth_7827 VNB|VSS
+ sky130_fd_sc_hd__a21oi_1
X$4101 VDD synth_11591 synth_11248 synth_11643 VNB|VSS VDD synth_11646 VNB|VSS
+ sky130_fd_sc_hd__a21oi_1
X$4102 VDD synth_8803 synth_11093 synth_11319 VNB|VSS VDD synth_11320 VNB|VSS
+ sky130_fd_sc_hd__a21oi_1
X$4103 VDD synth_11012 synth_10848 synth_11011 VNB|VSS VDD synth_10984 VNB|VSS
+ sky130_fd_sc_hd__a21oi_1
X$4104 VDD synth_10232 synth_10793 synth_9695 VNB|VSS VDD synth_11383 VNB|VSS
+ sky130_fd_sc_hd__a21oi_1
X$4105 VDD synth_5313 synth_5254 synth_5236 VNB|VSS VDD synth_5149 VNB|VSS
+ sky130_fd_sc_hd__a21oi_1
X$4106 VDD synth_7679 synth_7743 synth_7744 VNB|VSS VDD synth_7681 VNB|VSS
+ sky130_fd_sc_hd__a21oi_1
X$4107 VDD synth_3068 synth_2940 synth_2939 VNB|VSS VDD synth_2941 VNB|VSS
+ sky130_fd_sc_hd__a21oi_1
X$4108 VDD synth_7435 synth_7191 synth_7921 VNB|VSS VDD synth_7920 VNB|VSS
+ sky130_fd_sc_hd__a21oi_1
X$4109 VDD synth_11160 synth_11429 synth_11309 VNB|VSS VDD synth_11308 VNB|VSS
+ sky130_fd_sc_hd__a21oi_1
X$4110 VDD synth_5291 synth_5202 synth_5133 VNB|VSS VDD synth_5102 VNB|VSS
+ sky130_fd_sc_hd__a21oi_1
X$4111 VDD synth_6965 synth_6597 synth_6966 VNB|VSS VDD synth_6938 VNB|VSS
+ sky130_fd_sc_hd__a21oi_1
X$4112 VDD synth_9677 synth_11287 synth_9559 VNB|VSS VDD synth_11094 VNB|VSS
+ sky130_fd_sc_hd__a21oi_1
X$4113 VDD synth_474 synth_5724 synth_5725 VNB|VSS VDD synth_5589 VNB|VSS
+ sky130_fd_sc_hd__a21oi_1
X$4114 VDD synth_10738 synth_10739 synth_10747 VNB|VSS VDD synth_10589 VNB|VSS
+ sky130_fd_sc_hd__a21oi_1
X$4115 VDD synth_11790 synth_11724 synth_11789 VNB|VSS VDD synth_11746 VNB|VSS
+ sky130_fd_sc_hd__a21oi_1
X$4116 VDD synth_9675 synth_9292 synth_9483 VNB|VSS VDD synth_9676 VNB|VSS
+ sky130_fd_sc_hd__a21oi_1
X$4117 VDD synth_850 synth_603 synth_1869 VNB|VSS VDD synth_1868 VNB|VSS
+ sky130_fd_sc_hd__a21oi_1
X$4118 VDD synth_2407 synth_2538 synth_2562 VNB|VSS VDD synth_2539 VNB|VSS
+ sky130_fd_sc_hd__a21oi_1
X$4119 VDD synth_9407 synth_9408 synth_9297 VNB|VSS VDD synth_9303 VNB|VSS
+ sky130_fd_sc_hd__a21oi_1
X$4120 VDD synth_474 synth_4670 synth_4894 VNB|VSS VDD synth_7459 VNB|VSS
+ sky130_fd_sc_hd__a21oi_1
X$4121 VDD synth_2578 synth_2116 synth_2579 VNB|VSS VDD synth_2404 VNB|VSS
+ sky130_fd_sc_hd__a21oi_1
X$4122 VDD synth_2511 synth_2333 synth_1213 VNB|VSS VDD synth_2392 VNB|VSS
+ sky130_fd_sc_hd__a21oi_1
X$4123 VDD synth_11409 synth_11365 synth_11366 VNB|VSS VDD synth_11263 VNB|VSS
+ sky130_fd_sc_hd__a21oi_1
X$4124 VDD synth_321 synth_350 synth_378 VNB|VSS VDD synth_285 VNB|VSS
+ sky130_fd_sc_hd__a21oi_1
X$4125 VDD synth_4098 synth_4027 synth_4167 VNB|VSS VDD synth_4028 VNB|VSS
+ sky130_fd_sc_hd__a21oi_1
X$4126 VDD synth_6536 synth_3541 synth_6570 VNB|VSS VDD synth_6841 VNB|VSS
+ sky130_fd_sc_hd__a21oi_1
X$4127 VDD synth_5770 synth_4747 synth_5755 VNB|VSS VDD synth_5847 VNB|VSS
+ sky130_fd_sc_hd__a21oi_1
X$4128 VDD synth_8849 synth_8848 synth_8609 VNB|VSS VDD synth_8707 VNB|VSS
+ sky130_fd_sc_hd__a21oi_1
X$4129 VDD synth_1935 synth_1353 synth_2022 VNB|VSS VDD synth_1934 VNB|VSS
+ sky130_fd_sc_hd__a21oi_1
X$4130 VDD synth_8250 synth_8358 synth_8357 VNB|VSS VDD synth_8252 VNB|VSS
+ sky130_fd_sc_hd__a21oi_1
X$4131 VDD synth_10862 synth_10849 synth_10939 VNB|VSS VDD synth_10005 VNB|VSS
+ sky130_fd_sc_hd__a21oi_1
X$4132 VDD synth_9487 synth_8746 synth_9488 VNB|VSS VDD synth_9531 VNB|VSS
+ sky130_fd_sc_hd__a21oi_1
X$4133 VDD synth_1438 synth_151 synth_1439 VNB|VSS VDD synth_1495 VNB|VSS
+ sky130_fd_sc_hd__a21oi_1
X$4134 VDD synth_581 synth_4605 synth_4606 VNB|VSS VDD synth_4482 VNB|VSS
+ sky130_fd_sc_hd__a21oi_1
X$4135 VDD synth_6061 synth_6096 synth_6060 VNB|VSS VDD synth_6097 VNB|VSS
+ sky130_fd_sc_hd__a21oi_1
X$4136 VDD synth_2388 synth_2282 synth_2350 VNB|VSS VDD synth_2387 VNB|VSS
+ sky130_fd_sc_hd__a21oi_1
X$4137 VDD synth_6256 synth_3541 synth_6590 VNB|VSS VDD synth_6536 VNB|VSS
+ sky130_fd_sc_hd__a21oi_1
X$4138 VDD synth_2859 synth_2911 synth_1213 VNB|VSS VDD synth_2832 VNB|VSS
+ sky130_fd_sc_hd__a21oi_1
X$4139 VDD synth_7767 synth_7111 synth_7732 VNB|VSS VDD synth_7654 VNB|VSS
+ sky130_fd_sc_hd__a21oi_1
X$4140 VDD synth_6211 synth_7309 synth_7244 VNB|VSS VDD synth_7202 VNB|VSS
+ sky130_fd_sc_hd__a21oi_1
X$4141 VDD synth_6829 synth_6826 synth_6907 VNB|VSS VDD synth_6919 VNB|VSS
+ sky130_fd_sc_hd__a21oi_1
X$4142 VDD synth_5795 synth_6020 synth_5731 VNB|VSS VDD synth_6021 VNB|VSS
+ sky130_fd_sc_hd__a21oi_1
X$4143 VDD synth_10233 synth_10232 synth_8945 VNB|VSS VDD synth_11462 VNB|VSS
+ sky130_fd_sc_hd__a21oi_1
X$4144 VDD synth_10060 synth_9387 synth_9927 VNB|VSS VDD synth_11750 VNB|VSS
+ sky130_fd_sc_hd__a21oi_1
X$4145 VDD synth_11056 synth_11426 synth_11245 VNB|VSS VDD synth_11427 VNB|VSS
+ sky130_fd_sc_hd__a21oi_1
X$4146 VDD synth_9112 synth_8764 synth_8802 VNB|VSS VDD synth_9209 VNB|VSS
+ sky130_fd_sc_hd__a21oi_1
X$4147 VDD synth_11733 synth_9427 synth_11677 VNB|VSS VDD synth_11595 VNB|VSS
+ sky130_fd_sc_hd__a21oi_1
X$4148 VDD synth_8230 synth_9723 synth_9689 VNB|VSS VDD synth_9810 VNB|VSS
+ sky130_fd_sc_hd__a21oi_1
X$4149 VDD synth_10007 synth_9042 synth_9923 VNB|VSS VDD synth_9924 VNB|VSS
+ sky130_fd_sc_hd__a21oi_1
X$4150 VDD synth_7656 synth_7111 synth_7657 VNB|VSS VDD synth_7634 VNB|VSS
+ sky130_fd_sc_hd__a21oi_1
X$4151 VDD synth_4463 synth_4386 synth_4426 VNB|VSS VDD synth_4383 VNB|VSS
+ sky130_fd_sc_hd__a21oi_1
X$4152 VDD synth_5286 synth_6018 synth_5965 VNB|VSS VDD synth_6016 VNB|VSS
+ sky130_fd_sc_hd__a21oi_1
X$4153 VDD synth_2914 synth_2768 synth_2787 VNB|VSS VDD synth_2833 VNB|VSS
+ sky130_fd_sc_hd__a21oi_1
X$4154 VDD synth_474 synth_1506 synth_1686 VNB|VSS VDD synth_1620 VNB|VSS
+ sky130_fd_sc_hd__a21oi_1
X$4155 VDD synth_474 synth_340 synth_1637 VNB|VSS VDD synth_1621 VNB|VSS
+ sky130_fd_sc_hd__a21oi_1
X$4156 VDD synth_848 synth_659 synth_1058 VNB|VSS VDD synth_970 VNB|VSS
+ sky130_fd_sc_hd__a21oi_1
X$4157 VDD synth_3011 synth_2950 synth_1081 VNB|VSS VDD synth_3012 VNB|VSS
+ sky130_fd_sc_hd__a21oi_1
X$4158 VDD synth_508 synth_194 synth_415 VNB|VSS VDD synth_472 VNB|VSS
+ sky130_fd_sc_hd__a21oi_1
X$4159 VDD synth_4927 synth_2116 synth_4807 VNB|VSS VDD synth_4928 VNB|VSS
+ sky130_fd_sc_hd__a21oi_1
X$4160 VDD synth_7934 synth_7111 synth_7936 VNB|VSS VDD synth_7973 VNB|VSS
+ sky130_fd_sc_hd__a21oi_1
X$4161 VDD synth_9387 synth_11676 synth_9060 VNB|VSS VDD synth_11593 VNB|VSS
+ sky130_fd_sc_hd__a21oi_1
X$4162 VDD synth_7435 synth_8758 synth_8757 VNB|VSS VDD synth_8708 VNB|VSS
+ sky130_fd_sc_hd__a21oi_1
X$4163 VDD synth_8288 synth_7111 synth_8395 VNB|VSS VDD synth_8392 VNB|VSS
+ sky130_fd_sc_hd__a21oi_1
X$4164 VDD synth_8056 synth_8171 synth_8083 VNB|VSS VDD synth_8005 VNB|VSS
+ sky130_fd_sc_hd__a21oi_1
X$4165 VDD synth_672 synth_151 synth_730 VNB|VSS VDD synth_727 VNB|VSS
+ sky130_fd_sc_hd__a21oi_1
X$4166 VDD synth_8097 synth_8209 synth_8035 VNB|VSS VDD synth_8016 VNB|VSS
+ sky130_fd_sc_hd__a21oi_1
X$4167 VDD synth_4003 synth_2116 synth_4030 VNB|VSS VDD synth_4324 VNB|VSS
+ sky130_fd_sc_hd__a21oi_1
X$4168 VDD synth_542 synth_194 synth_475 VNB|VSS VDD synth_508 VNB|VSS
+ sky130_fd_sc_hd__a21oi_1
X$4169 VDD synth_6476 synth_6738 synth_6739 VNB|VSS VDD synth_6662 VNB|VSS
+ sky130_fd_sc_hd__a21oi_1
X$4170 VDD synth_373 synth_66 synth_352 VNB|VSS VDD synth_248 VNB|VSS
+ sky130_fd_sc_hd__a21oi_1
X$4171 VDD synth_157 synth_352 synth_288 VDD VNB|VSS VNB|VSS
+ sky130_fd_sc_hd__or2_2
X$4172 VDD synth_8196 synth_10949 synth_10801 VNB|VSS VDD synth_10885 VNB|VSS
+ sky130_fd_sc_hd__a21oi_1
X$4173 VDD synth_10724 synth_8764 synth_10232 VNB|VSS VDD synth_10725 VNB|VSS
+ sky130_fd_sc_hd__a21oi_1
X$4174 VDD synth_619 synth_754 synth_795 VNB|VSS VDD synth_728 VNB|VSS
+ sky130_fd_sc_hd__a21oi_1
X$4175 VDD synth_408 synth_2885 synth_3780 VNB|VSS VDD synth_3715 VNB|VSS
+ sky130_fd_sc_hd__a21oi_1
X$4176 VDD synth_8215 synth_7853 synth_7971 VNB|VSS VDD synth_8137 VNB|VSS
+ sky130_fd_sc_hd__a21oi_1
X$4177 VDD synth_12532 synth_12470 synth_12541 VNB|VSS VDD synth_12418 VNB|VSS
+ sky130_fd_sc_hd__a21oi_1
X$4178 VDD synth_1848 synth_1607 synth_1819 VNB|VSS VDD synth_1646 VNB|VSS
+ sky130_fd_sc_hd__a21oi_1
X$4179 VDD synth_9019 synth_9947 synth_9948 VNB|VSS VDD synth_9784 VNB|VSS
+ sky130_fd_sc_hd__a21oi_1
X$4180 VDD synth_1824 synth_1822 synth_1989 VNB|VSS VDD synth_1893 VNB|VSS
+ sky130_fd_sc_hd__a21oi_1
X$4181 VDD synth_6680 synth_6644 synth_6878 VNB|VSS VDD synth_6724 VNB|VSS
+ sky130_fd_sc_hd__a21oi_1
X$4182 VDD synth_2013 synth_1953 synth_1877 VNB|VSS VDD synth_1919 VNB|VSS
+ sky130_fd_sc_hd__a21oi_1
X$4183 VDD synth_3173 synth_3283 synth_3110 VNB|VSS VDD synth_3156 VNB|VSS
+ sky130_fd_sc_hd__a21oi_1
X$4184 VDD synth_6085 synth_5911 synth_6086 VNB|VSS VDD synth_6163 VNB|VSS
+ sky130_fd_sc_hd__a21oi_1
X$4185 VDD synth_12352 synth_12293 synth_12570 VNB|VSS VDD synth_12568 VNB|VSS
+ sky130_fd_sc_hd__a21oi_1
X$4186 VDD synth_8230 synth_9300 synth_9307 VNB|VSS VDD synth_9461 VNB|VSS
+ sky130_fd_sc_hd__a21oi_1
X$4187 VDD synth_2866 synth_2776 synth_2798 VNB|VSS VDD synth_2799 VNB|VSS
+ sky130_fd_sc_hd__a21oi_1
X$4188 VDD synth_408 synth_1527 synth_1526 VNB|VSS VDD synth_1474 VNB|VSS
+ sky130_fd_sc_hd__a21oi_1
X$4189 VDD synth_4332 synth_2116 synth_4192 VNB|VSS VDD synth_4277 VNB|VSS
+ sky130_fd_sc_hd__a21oi_1
X$4190 VDD synth_4504 synth_4027 synth_4251 VNB|VSS VDD synth_4423 VNB|VSS
+ sky130_fd_sc_hd__a21oi_1
X$4191 VDD synth_12597 synth_10312 synth_12666 VNB|VSS VDD synth_12669 VNB|VSS
+ sky130_fd_sc_hd__a21oi_1
X$4192 VDD synth_5231 synth_3468 synth_5320 VNB|VSS VDD synth_5152 VNB|VSS
+ sky130_fd_sc_hd__a21oi_1
X$4193 VDD synth_596 synth_151 synth_379 VNB|VSS VDD synth_251 VNB|VSS
+ sky130_fd_sc_hd__a21oi_1
X$4194 VDD synth_5353 synth_5430 synth_5354 VNB|VSS VDD synth_5367 VNB|VSS
+ sky130_fd_sc_hd__a21oi_1
X$4195 VDD synth_9846 synth_9563 synth_9832 VNB|VSS VDD synth_9831 VNB|VSS
+ sky130_fd_sc_hd__a21oi_1
X$4196 VDD synth_4960 synth_4907 synth_850 VNB|VSS VDD synth_4828 VNB|VSS
+ sky130_fd_sc_hd__a21oi_1
X$4197 VDD synth_7175 synth_7183 synth_7403 VNB|VSS VDD synth_7376 VNB|VSS
+ sky130_fd_sc_hd__a21oi_1
X$4198 VDD synth_408 synth_2969 synth_3985 VNB|VSS VDD synth_3924 VNB|VSS
+ sky130_fd_sc_hd__a21oi_1
X$4199 VDD synth_10852 synth_11276 synth_11120 VNB|VSS VDD synth_11195 VNB|VSS
+ sky130_fd_sc_hd__a21oi_1
X$4200 VDD synth_9434 synth_10285 synth_9324 VNB|VSS VDD synth_11218 VNB|VSS
+ sky130_fd_sc_hd__a21oi_1
X$4201 VDD synth_9691 synth_11658 synth_11660 VNB|VSS VDD synth_11629 VNB|VSS
+ sky130_fd_sc_hd__a21oi_1
X$4202 VDD synth_8097 synth_8257 synth_8276 VNB|VSS VDD synth_8351 VNB|VSS
+ sky130_fd_sc_hd__a21oi_1
X$4203 VDD synth_6211 synth_7313 synth_7201 VNB|VSS VDD synth_7311 VNB|VSS
+ sky130_fd_sc_hd__a21oi_1
X$4204 VDD synth_1642 synth_2168 synth_2048 VNB|VSS VDD synth_2095 VNB|VSS
+ sky130_fd_sc_hd__a21oi_1
X$4205 VDD synth_1837 synth_659 synth_1838 VNB|VSS VDD synth_1904 VNB|VSS
+ sky130_fd_sc_hd__a21oi_1
X$4206 VDD synth_1069 synth_976 synth_867 VNB|VSS VDD synth_975 VNB|VSS
+ sky130_fd_sc_hd__a21oi_1
X$4207 VDD synth_4515 synth_4584 synth_4513 VNB|VSS VDD synth_4480 VNB|VSS
+ sky130_fd_sc_hd__a21oi_1
X$4208 VDD synth_2637 synth_2538 synth_2705 VNB|VSS VDD synth_2459 VNB|VSS
+ sky130_fd_sc_hd__a21oi_1
X$4209 VDD synth_4177 synth_1338 synth_4262 VNB|VSS VDD synth_4176 VNB|VSS
+ sky130_fd_sc_hd__a21oi_1
X$4210 VDD synth_871 synth_961 synth_346 VNB|VSS VDD synth_828 VNB|VSS
+ sky130_fd_sc_hd__a21oi_1
X$4211 VDD synth_2428 synth_2430 synth_2518 VNB|VSS VDD synth_2342 VNB|VSS
+ sky130_fd_sc_hd__a21oi_1
X$4212 VDD synth_408 synth_3493 synth_3775 VNB|VSS VDD synth_3706 VNB|VSS
+ sky130_fd_sc_hd__a21oi_1
X$4213 VDD synth_581 synth_4113 synth_4452 VNB|VSS VDD synth_4401 VNB|VSS
+ sky130_fd_sc_hd__a21oi_1
X$4214 VDD synth_7435 synth_6800 synth_8075 VNB|VSS VDD synth_8138 VNB|VSS
+ sky130_fd_sc_hd__a21oi_1
X$4215 VDD synth_9532 synth_9400 synth_9644 VNB|VSS VDD synth_9645 VNB|VSS
+ sky130_fd_sc_hd__a21oi_1
X$4216 VDD synth_1081 synth_997 synth_1369 VNB|VSS VDD synth_1316 VNB|VSS
+ sky130_fd_sc_hd__a21oi_1
X$4217 VDD synth_8870 synth_10793 synth_9474 VNB|VSS VDD synth_10846 VNB|VSS
+ sky130_fd_sc_hd__a21oi_1
X$4218 VDD synth_12532 synth_12470 synth_12431 VNB|VSS VDD synth_12473 VNB|VSS
+ sky130_fd_sc_hd__a21oi_1
X$4219 VDD synth_3327 synth_3325 synth_3245 VNB|VSS VDD synth_3183 VNB|VSS
+ sky130_fd_sc_hd__a21oi_1
X$4220 VDD synth_4311 synth_1338 synth_4312 VNB|VSS VDD synth_4177 VNB|VSS
+ sky130_fd_sc_hd__a21oi_1
X$4221 VDD synth_12383 synth_12400 synth_12550 VNB|VSS VDD synth_12698 VNB|VSS
+ sky130_fd_sc_hd__a21oi_1
X$4222 VDD synth_7435 synth_6544 synth_8076 VNB|VSS VDD synth_8140 VNB|VSS
+ sky130_fd_sc_hd__a21oi_1
X$4223 VDD synth_7435 synth_7852 synth_8216 VNB|VSS VDD synth_8163 VNB|VSS
+ sky130_fd_sc_hd__a21oi_1
X$4224 VDD synth_1570 synth_151 synth_1516 VNB|VSS VDD synth_1438 VNB|VSS
+ sky130_fd_sc_hd__a21oi_1
X$4225 VDD synth_8230 synth_9890 synth_9889 VNB|VSS VDD synth_9812 VNB|VSS
+ sky130_fd_sc_hd__a21oi_1
X$4226 VDD synth_10050 synth_9970 synth_9691 VNB|VSS VDD synth_9919 VNB|VSS
+ sky130_fd_sc_hd__a21oi_1
X$4227 VDD synth_3390 synth_3389 synth_3538 VNB|VSS VDD synth_3537 VNB|VSS
+ sky130_fd_sc_hd__a21oi_1
X$4228 VDD synth_3848 synth_927 synth_3905 VNB|VSS VDD synth_3981 VNB|VSS
+ sky130_fd_sc_hd__a21oi_1
X$4229 VDD synth_3387 synth_2116 synth_3562 VNB|VSS VDD synth_3533 VNB|VSS
+ sky130_fd_sc_hd__a21oi_1
X$4230 VDD synth_344 synth_151 synth_281 VNB|VSS VDD synth_261 VNB|VSS
+ sky130_fd_sc_hd__a21oi_1
X$4231 VDD synth_10513 synth_11212 synth_11016 VNB|VSS VDD synth_11053 VNB|VSS
+ sky130_fd_sc_hd__a21oi_1
X$4232 VDD synth_4635 synth_4438 synth_3527 VNB|VSS VDD synth_4520 VNB|VSS
+ sky130_fd_sc_hd__a21oi_1
X$4233 VDD synth_3527 synth_3699 synth_4638 VNB|VSS VDD synth_4636 VNB|VSS
+ sky130_fd_sc_hd__a21oi_1
X$4234 VDD synth_8196 synth_9703 synth_10477 VNB|VSS VDD synth_10334 VNB|VSS
+ sky130_fd_sc_hd__a21oi_1
X$4235 VDD synth_1245 synth_1246 synth_1158 VNB|VSS VDD synth_1340 VNB|VSS
+ sky130_fd_sc_hd__a21oi_1
X$4236 VDD synth_1037 synth_721 synth_982 VNB|VSS VDD synth_1036 VNB|VSS
+ sky130_fd_sc_hd__a21oi_1
X$4237 VDD synth_9434 synth_9474 synth_9550 VNB|VSS VDD synth_9516 VNB|VSS
+ sky130_fd_sc_hd__a21oi_1
X$4238 VDD synth_1007 synth_927 synth_1008 VNB|VSS VDD synth_1019 VNB|VSS
+ sky130_fd_sc_hd__a21oi_1
X$4239 VDD synth_9241 synth_8831 synth_9158 VNB|VSS VDD synth_9203 VNB|VSS
+ sky130_fd_sc_hd__a21oi_1
X$4240 VDD synth_12085 synth_11991 synth_11990 VNB|VSS VDD synth_12042 VNB|VSS
+ sky130_fd_sc_hd__a21oi_1
X$4241 VDD synth_6476 synth_6888 synth_6889 VNB|VSS VDD synth_6887 VNB|VSS
+ sky130_fd_sc_hd__a21oi_1
X$4242 VDD synth_11897 synth_11855 synth_9049 VNB|VSS VDD synth_11857 VNB|VSS
+ sky130_fd_sc_hd__a21oi_1
X$4243 VDD synth_6476 synth_6842 synth_6736 VNB|VSS VDD synth_6735 VNB|VSS
+ sky130_fd_sc_hd__a21oi_1
X$4244 VDD synth_1667 synth_1626 synth_1573 VNB|VSS VDD synth_1499 VNB|VSS
+ sky130_fd_sc_hd__a21oi_1
X$4245 VDD synth_12369 synth_12350 synth_12656 VNB|VSS VDD synth_12563 VNB|VSS
+ sky130_fd_sc_hd__a21oi_1
X$4246 VDD synth_11934 synth_10652 synth_11283 VNB|VSS VDD synth_11901 VNB|VSS
+ sky130_fd_sc_hd__a21oi_1
X$4247 VDD synth_346 synth_910 synth_1221 VNB|VSS VDD synth_1159 VNB|VSS
+ sky130_fd_sc_hd__a21oi_1
X$4248 VDD synth_11434 synth_10652 synth_11326 VNB|VSS VDD synth_11349 VNB|VSS
+ sky130_fd_sc_hd__a21oi_1
X$4249 VDD synth_1218 synth_976 synth_1249 VNB|VSS VDD synth_1068 VNB|VSS
+ sky130_fd_sc_hd__a21oi_1
X$4250 VDD synth_10438 synth_10285 synth_10363 VNB|VSS VDD synth_10416 VNB|VSS
+ sky130_fd_sc_hd__a21oi_1
X$4251 VDD synth_1162 synth_1067 synth_1029 VNB|VSS VDD synth_1066 VNB|VSS
+ sky130_fd_sc_hd__a21oi_1
X$4252 VDD synth_6476 synth_7250 synth_7143 VNB|VSS VDD synth_7093 VNB|VSS
+ sky130_fd_sc_hd__a21oi_1
X$4253 VDD synth_6476 synth_7910 synth_7220 VNB|VSS VDD synth_6957 VNB|VSS
+ sky130_fd_sc_hd__a21oi_1
X$4254 VDD synth_6476 synth_7142 synth_6917 VNB|VSS VDD synth_6990 VNB|VSS
+ sky130_fd_sc_hd__a21oi_1
X$4255 VDD synth_6225 synth_6507 synth_6139 VNB|VSS VDD synth_6506 VNB|VSS
+ sky130_fd_sc_hd__a21oi_1
X$4256 VDD synth_4937 synth_4747 synth_4881 VNB|VSS VDD synth_4797 VNB|VSS
+ sky130_fd_sc_hd__a21oi_1
X$4257 VDD synth_5101 synth_4747 synth_4845 VNB|VSS VDD synth_4937 VNB|VSS
+ sky130_fd_sc_hd__a21oi_1
X$4258 VDD synth_10652 synth_10212 synth_9550 VNB|VSS VDD synth_12020 VNB|VSS
+ sky130_fd_sc_hd__a21oi_1
X$4259 VDD synth_1550 synth_1505 synth_1424 VNB|VSS VDD synth_1468 VNB|VSS
+ sky130_fd_sc_hd__a21oi_1
X$4260 VDD synth_5286 synth_5776 synth_6191 VNB|VSS VDD synth_5890 VNB|VSS
+ sky130_fd_sc_hd__a21oi_1
X$4261 VDD synth_8926 synth_8835 synth_8923 VNB|VSS VDD synth_8924 VNB|VSS
+ sky130_fd_sc_hd__a21oi_1
X$4262 VDD synth_11934 synth_10652 synth_11933 VNB|VSS VDD synth_11869 VNB|VSS
+ sky130_fd_sc_hd__a21oi_1
X$4263 VDD synth_8246 synth_7111 synth_8329 VNB|VSS VDD synth_8288 VNB|VSS
+ sky130_fd_sc_hd__a21oi_1
X$4264 VDD synth_3391 synth_3389 synth_3388 VNB|VSS VDD synth_3535 VNB|VSS
+ sky130_fd_sc_hd__a21oi_1
X$4265 VDD synth_2290 synth_2288 synth_2443 VNB|VSS VDD synth_2370 VNB|VSS
+ sky130_fd_sc_hd__a21oi_1
X$4266 VDD synth_6956 synth_6954 synth_6476 VNB|VSS VDD synth_6886 VNB|VSS
+ sky130_fd_sc_hd__a21oi_1
X$4267 VDD synth_11392 synth_11561 synth_11560 VNB|VSS VDD synth_11498 VNB|VSS
+ sky130_fd_sc_hd__a21oi_1
X$4268 VDD synth_9629 synth_10212 synth_11214 VNB|VSS VDD synth_12627 VNB|VSS
+ sky130_fd_sc_hd__a21oi_1
X$4269 VDD synth_346 synth_991 synth_1786 VNB|VSS VDD synth_1609 VNB|VSS
+ sky130_fd_sc_hd__a21oi_1
X$4270 VDD synth_4456 synth_4616 synth_4201 VNB|VSS VDD synth_4539 VNB|VSS
+ sky130_fd_sc_hd__a21oi_1
X$4271 VDD synth_8962 synth_8930 synth_8852 VNB|VSS VDD synth_8893 VNB|VSS
+ sky130_fd_sc_hd__a21oi_1
X$4272 VDD synth_474 synth_6049 synth_5908 VNB|VSS VDD synth_5952 VNB|VSS
+ sky130_fd_sc_hd__a21oi_1
X$4273 VDD synth_10768 synth_10280 synth_9049 VNB|VSS VDD synth_10637 VNB|VSS
+ sky130_fd_sc_hd__a21oi_1
X$4274 VDD synth_346 synth_1494 synth_1691 VNB|VSS VDD synth_1863 VNB|VSS
+ sky130_fd_sc_hd__a21oi_1
X$4275 VDD synth_5250 synth_5144 synth_5251 VNB|VSS VDD synth_5233 VNB|VSS
+ sky130_fd_sc_hd__a21oi_1
X$4276 VDD synth_10692 synth_9119 synth_10440 VNB|VSS VDD synth_10558 VNB|VSS
+ sky130_fd_sc_hd__a21oi_1
X$4277 VDD synth_1567 synth_1353 synth_1729 VNB|VSS VDD synth_1859 VNB|VSS
+ sky130_fd_sc_hd__a21oi_1
X$4278 VDD synth_581 synth_4615 synth_4540 VNB|VSS VDD synth_4473 VNB|VSS
+ sky130_fd_sc_hd__a21oi_1
X$4279 VDD synth_1213 synth_426 synth_1873 VNB|VSS VDD synth_1874 VNB|VSS
+ sky130_fd_sc_hd__a21oi_1
X$4280 VDD synth_7604 synth_7438 synth_7435 VNB|VSS VDD synth_7522 VNB|VSS
+ sky130_fd_sc_hd__a21oi_1
X$4281 VDD synth_10272 synth_10342 synth_9691 VNB|VSS VDD synth_10271 VNB|VSS
+ sky130_fd_sc_hd__a21oi_1
X$4282 VDD synth_7959 synth_7991 synth_7960 VNB|VSS VDD synth_7961 VNB|VSS
+ sky130_fd_sc_hd__a21oi_1
X$4283 VDD synth_1752 synth_1661 synth_1899 VNB|VSS VDD synth_1753 VNB|VSS
+ sky130_fd_sc_hd__a21oi_1
X$4284 VDD synth_5709 synth_5757 synth_5843 VNB|VSS VDD synth_5756 VNB|VSS
+ sky130_fd_sc_hd__a21oi_1
X$4285 VDD synth_8196 synth_10760 synth_10662 VNB|VSS VDD synth_10759 VNB|VSS
+ sky130_fd_sc_hd__a21oi_1
X$4286 VDD synth_9691 synth_11078 synth_11356 VNB|VSS VDD synth_11285 VNB|VSS
+ sky130_fd_sc_hd__a21oi_1
X$4287 VDD synth_9112 synth_9470 synth_9332 VNB|VSS VDD synth_9331 VNB|VSS
+ sky130_fd_sc_hd__a21oi_1
X$4288 VDD synth_9331 synth_9473 synth_9379 VNB|VSS VDD synth_9201 VNB|VSS
+ sky130_fd_sc_hd__a21oi_1
X$4289 VDD synth_1388 synth_1338 synth_1241 VNB|VSS VDD synth_1239 VNB|VSS
+ sky130_fd_sc_hd__a21oi_1
X$4290 VDD synth_9443 synth_9526 synth_9527 VNB|VSS VDD synth_9440 VNB|VSS
+ sky130_fd_sc_hd__a21oi_1
X$4291 VDD synth_2159 synth_2157 synth_2062 VNB|VSS VDD synth_2061 VNB|VSS
+ sky130_fd_sc_hd__a21oi_1
X$4292 VDD synth_164 synth_161 synth_295 VNB|VSS VDD synth_233 VNB|VSS
+ sky130_fd_sc_hd__a21oi_1
X$4293 VDD synth_8259 synth_9023 synth_8819 VNB|VSS VDD synth_8888 VNB|VSS
+ sky130_fd_sc_hd__a21oi_1
X$4294 VDD synth_9773 synth_9119 synth_10045 VNB|VSS VDD synth_9934 VNB|VSS
+ sky130_fd_sc_hd__a21oi_1
X$4295 VDD synth_4122 synth_4295 synth_4543 VNB|VSS VDD synth_4380 VNB|VSS
+ sky130_fd_sc_hd__a21oi_1
X$4296 VDD synth_6078 synth_3468 synth_6079 VNB|VSS VDD synth_6080 VNB|VSS
+ sky130_fd_sc_hd__a21oi_1
X$4297 VDD synth_5047 synth_4921 synth_850 VNB|VSS VDD synth_4897 VNB|VSS
+ sky130_fd_sc_hd__a21oi_1
X$4298 VDD synth_1066 synth_1067 synth_973 VNB|VSS VDD synth_1217 VNB|VSS
+ sky130_fd_sc_hd__a21oi_1
X$4299 VDD synth_5903 synth_3468 synth_6056 VNB|VSS VDD synth_6057 VNB|VSS
+ sky130_fd_sc_hd__a21oi_1
X$4300 VDD synth_7447 synth_7566 synth_7435 VNB|VSS VDD synth_7387 VNB|VSS
+ sky130_fd_sc_hd__a21oi_1
X$4301 VDD synth_9860 synth_9725 synth_9861 VNB|VSS VDD synth_9726 VNB|VSS
+ sky130_fd_sc_hd__a21oi_1
X$4302 VDD synth_8620 synth_8532 synth_8230 VNB|VSS VDD synth_8578 VNB|VSS
+ sky130_fd_sc_hd__a21oi_1
X$4303 VDD synth_3527 synth_4325 synth_4158 VNB|VSS VDD synth_4187 VNB|VSS
+ sky130_fd_sc_hd__a21oi_1
X$4304 VDD synth_6204 synth_6240 synth_6298 VNB|VSS VDD synth_6281 VNB|VSS
+ sky130_fd_sc_hd__a21oi_1
X$4305 VDD synth_3527 synth_4499 synth_4440 VNB|VSS VDD synth_4500 VNB|VSS
+ sky130_fd_sc_hd__a21oi_1
X$4306 VDD synth_6080 synth_3468 synth_6156 VNB|VSS VDD synth_6040 VNB|VSS
+ sky130_fd_sc_hd__a21oi_1
X$4307 VDD synth_12099 synth_12035 synth_12188 VNB|VSS VDD synth_12098 VNB|VSS
+ sky130_fd_sc_hd__a21oi_1
X$4308 VDD synth_632 synth_167 synth_582 VNB|VSS VDD synth_583 VNB|VSS
+ sky130_fd_sc_hd__a21oi_1
X$4309 VDD synth_9893 synth_9119 synth_9775 VNB|VSS VDD synth_9820 VNB|VSS
+ sky130_fd_sc_hd__a21oi_1
X$4310 VDD synth_5807 synth_5596 synth_5286 VNB|VSS VDD synth_5782 VNB|VSS
+ sky130_fd_sc_hd__a21oi_1
X$4311 VDD synth_1680 synth_1393 synth_1213 VNB|VSS VDD synth_1616 VNB|VSS
+ sky130_fd_sc_hd__a21oi_1
X$4312 VDD synth_5785 synth_5668 synth_5741 VNB|VSS VDD synth_5869 VNB|VSS
+ sky130_fd_sc_hd__a21oi_1
X$4313 VDD synth_3236 synth_3308 synth_3343 VNB|VSS VDD synth_3234 VNB|VSS
+ sky130_fd_sc_hd__a21oi_1
X$4314 VDD synth_9112 synth_9284 synth_9177 VNB|VSS VDD synth_9204 VNB|VSS
+ sky130_fd_sc_hd__a21oi_1
X$4315 VDD synth_5154 synth_5220 synth_5223 VNB|VSS VDD synth_5153 VNB|VSS
+ sky130_fd_sc_hd__a21oi_1
X$4316 VDD synth_10218 synth_9434 synth_10158 VNB|VSS VDD synth_10100 VNB|VSS
+ sky130_fd_sc_hd__a21oi_1
X$4317 VDD synth_10100 synth_9235 synth_9172 VNB|VSS VDD synth_10102 VNB|VSS
+ sky130_fd_sc_hd__a21oi_1
X$4318 VDD synth_346 synth_1817 synth_1971 VNB|VSS VDD synth_2008 VNB|VSS
+ sky130_fd_sc_hd__a21oi_1
X$4319 VDD synth_9049 synth_12087 synth_12044 VNB|VSS VDD synth_11972 VNB|VSS
+ sky130_fd_sc_hd__a21oi_1
X$4320 VDD synth_9070 synth_9094 synth_9067 VNB|VSS VDD synth_9071 VNB|VSS
+ sky130_fd_sc_hd__a21oi_1
X$4321 VDD synth_4035 synth_4154 synth_4064 VNB|VSS VDD synth_4033 VNB|VSS
+ sky130_fd_sc_hd__a21oi_1
X$4322 VDD synth_527 synth_194 synth_499 VNB|VSS VDD synth_331 VNB|VSS
+ sky130_fd_sc_hd__a21oi_1
X$4323 VDD synth_942 synth_167 synth_837 VNB|VSS VDD synth_856 VNB|VSS
+ sky130_fd_sc_hd__a21oi_1
X$4324 VDD synth_10281 synth_10211 synth_9049 VNB|VSS VDD synth_10282 VNB|VSS
+ sky130_fd_sc_hd__a21oi_1
X$4325 VDD synth_10714 synth_10715 synth_10836 VNB|VSS VDD synth_10630 VNB|VSS
+ sky130_fd_sc_hd__a21oi_1
X$4326 VDD synth_9453 synth_9273 synth_9337 VNB|VSS VDD synth_9367 VNB|VSS
+ sky130_fd_sc_hd__a21oi_1
X$4327 VDD synth_427 synth_197 synth_461 VNB|VSS VDD synth_500 VNB|VSS
+ sky130_fd_sc_hd__a21oi_1
X$4328 VDD synth_331 synth_194 synth_332 VNB|VSS VDD synth_108 VNB|VSS
+ sky130_fd_sc_hd__a21oi_1
X$4329 VDD synth_9337 synth_9271 synth_9089 VNB|VSS VDD synth_9366 VNB|VSS
+ sky130_fd_sc_hd__a21oi_1
X$4330 VDD synth_11177 synth_11178 synth_11333 VNB|VSS VDD synth_11256 VNB|VSS
+ sky130_fd_sc_hd__a21oi_1
X$4331 VDD synth_2377 synth_2264 synth_2615 VNB|VSS VDD synth_2502 VNB|VSS
+ sky130_fd_sc_hd__a21oi_1
X$4332 VDD synth_7908 synth_7907 synth_8031 VNB|VSS VDD synth_7906 VNB|VSS
+ sky130_fd_sc_hd__a21oi_1
X$4333 VDD synth_474 synth_5612 synth_5613 VNB|VSS VDD synth_5654 VNB|VSS
+ sky130_fd_sc_hd__a21oi_1
X$4334 VDD synth_474 synth_5726 synth_5653 VNB|VSS VDD synth_5727 VNB|VSS
+ sky130_fd_sc_hd__a21oi_1
X$4335 VDD synth_11177 synth_11178 synth_10957 VNB|VSS VDD synth_11185 VNB|VSS
+ sky130_fd_sc_hd__a21oi_1
X$4336 VDD synth_10285 synth_9044 synth_10092 VNB|VSS VDD synth_11323 VNB|VSS
+ sky130_fd_sc_hd__a21oi_1
X$4337 VDD synth_4012 synth_4086 synth_4313 VNB|VSS VDD synth_4179 VNB|VSS
+ sky130_fd_sc_hd__a21oi_1
X$4338 VDD synth_9797 synth_9866 synth_9783 VNB|VSS VDD synth_9957 VNB|VSS
+ sky130_fd_sc_hd__a21oi_1
X$4339 VDD synth_2440 synth_927 synth_2435 VNB|VSS VDD synth_2670 VNB|VSS
+ sky130_fd_sc_hd__a21oi_1
X$4340 VDD synth_9049 synth_12089 synth_12045 VNB|VSS VDD synth_11926 VNB|VSS
+ sky130_fd_sc_hd__a21oi_1
X$4341 VDD synth_2376 synth_1338 synth_2418 VNB|VSS VDD synth_2326 VNB|VSS
+ sky130_fd_sc_hd__a21oi_1
X$4342 VDD synth_3964 synth_4283 synth_4032 VNB|VSS VDD synth_4031 VNB|VSS
+ sky130_fd_sc_hd__a21oi_1
X$4343 VDD synth_3429 synth_1353 synth_3570 VNB|VSS VDD synth_3673 VNB|VSS
+ sky130_fd_sc_hd__a21oi_1
X$4344 VDD synth_8803 synth_10376 synth_9615 VNB|VSS VDD synth_12526 VNB|VSS
+ sky130_fd_sc_hd__a21oi_1
X$4345 VDD synth_4267 synth_1338 synth_4410 VNB|VSS VDD synth_4233 VNB|VSS
+ sky130_fd_sc_hd__a21oi_1
X$4346 VDD synth_2325 synth_2264 synth_2419 VNB|VSS VDD synth_2375 VNB|VSS
+ sky130_fd_sc_hd__a21oi_1
X$4347 VDD synth_726 synth_754 synth_793 VNB|VSS VDD synth_725 VNB|VSS
+ sky130_fd_sc_hd__a21oi_1
X$4348 VDD synth_10212 synth_9700 synth_10142 VNB|VSS VDD synth_10650 VNB|VSS
+ sky130_fd_sc_hd__a21oi_1
X$4349 VDD synth_10650 synth_10371 synth_10728 VNB|VSS VDD synth_10649 VNB|VSS
+ sky130_fd_sc_hd__a21oi_1
X$4350 VDD synth_605 synth_733 synth_663 VNB|VSS VDD synth_697 VNB|VSS
+ sky130_fd_sc_hd__a21oi_1
X$4351 VDD synth_3769 synth_3572 synth_3770 VNB|VSS VDD synth_3723 VNB|VSS
+ sky130_fd_sc_hd__a21oi_1
X$4352 VDD synth_10286 synth_9119 synth_10232 VNB|VSS VDD synth_10157 VNB|VSS
+ sky130_fd_sc_hd__a21oi_1
X$4353 VDD synth_10541 synth_10164 synth_10502 VNB|VSS VDD synth_10542 VNB|VSS
+ sky130_fd_sc_hd__a21oi_1
X$4354 VDD synth_4759 synth_4948 synth_4954 VNB|VSS VDD synth_4852 VNB|VSS
+ sky130_fd_sc_hd__a21oi_1
X$4355 VDD synth_4853 synth_4948 synth_4857 VNB|VSS VDD synth_4611 VNB|VSS
+ sky130_fd_sc_hd__a21oi_1
X$4356 VDD synth_3964 synth_5018 synth_5216 VNB|VSS VDD synth_5017 VNB|VSS
+ sky130_fd_sc_hd__a21oi_1
X$4357 VDD synth_9049 synth_11574 synth_11509 VNB|VSS VDD synth_11573 VNB|VSS
+ sky130_fd_sc_hd__a21oi_1
X$4358 VDD synth_1228 synth_194 synth_1260 VNB|VSS VDD synth_1320 VNB|VSS
+ sky130_fd_sc_hd__a21oi_1
X$4359 VDD synth_10413 synth_9292 synth_10418 VNB|VSS VDD synth_10362 VNB|VSS
+ sky130_fd_sc_hd__a21oi_1
X$4360 VDD synth_4379 synth_927 synth_4462 VNB|VSS VDD synth_4384 VNB|VSS
+ sky130_fd_sc_hd__a21oi_1
X$4361 VDD synth_12065 synth_11979 synth_9297 VNB|VSS VDD synth_11978 VNB|VSS
+ sky130_fd_sc_hd__a21oi_1
X$4362 VDD synth_5297 synth_5136 synth_5207 VNB|VSS VDD synth_5247 VNB|VSS
+ sky130_fd_sc_hd__a21oi_1
X$4363 VDD synth_5176 synth_5184 synth_5175 VNB|VSS VDD synth_5179 VNB|VSS
+ sky130_fd_sc_hd__a21oi_1
X$4364 VDD synth_10285 synth_8806 synth_8981 VNB|VSS VDD synth_12360 VNB|VSS
+ sky130_fd_sc_hd__a21oi_1
X$4365 VDD synth_3964 synth_5585 synth_5466 VNB|VSS VDD synth_5424 VNB|VSS
+ sky130_fd_sc_hd__a21oi_1
X$4366 VDD synth_4795 synth_4846 synth_4679 VNB|VSS VDD synth_4880 VNB|VSS
+ sky130_fd_sc_hd__a21oi_1
X$4367 VDD synth_3964 synth_5161 synth_5314 VNB|VSS VDD synth_5158 VNB|VSS
+ sky130_fd_sc_hd__a21oi_1
X$4368 VDD synth_10236 synth_8806 synth_10237 VNB|VSS VDD synth_10235 VNB|VSS
+ sky130_fd_sc_hd__a21oi_1
X$4369 VDD synth_9049 synth_12043 synth_12025 VNB|VSS VDD synth_11992 VNB|VSS
+ sky130_fd_sc_hd__a21oi_1
X$4370 VDD synth_9049 synth_12460 synth_11971 VNB|VSS VDD synth_11859 VNB|VSS
+ sky130_fd_sc_hd__a21oi_1
X$4371 VDD synth_10521 synth_10588 synth_10670 VNB|VSS VDD synth_10528 VNB|VSS
+ sky130_fd_sc_hd__a21oi_1
X$4372 VDD synth_5306 synth_5375 synth_5200 VNB|VSS VDD synth_5349 VNB|VSS
+ sky130_fd_sc_hd__a21oi_1
X$4373 VDD synth_408 synth_1760 synth_1829 VNB|VSS VDD synth_1765 VNB|VSS
+ sky130_fd_sc_hd__a21oi_1
X$4374 VDD synth_3527 synth_4526 synth_4523 VNB|VSS VDD synth_4501 VNB|VSS
+ sky130_fd_sc_hd__a21oi_1
X$4375 VDD synth_2228 synth_167 synth_2358 VNB|VSS VDD synth_2357 VNB|VSS
+ sky130_fd_sc_hd__a21oi_1
X$4376 VDD synth_2357 synth_167 synth_2373 VNB|VSS VDD synth_2503 VNB|VSS
+ sky130_fd_sc_hd__a21oi_1
X$4377 VDD synth_4207 synth_4295 synth_4210 VNB|VSS VDD synth_4121 VNB|VSS
+ sky130_fd_sc_hd__a21oi_1
X$4378 VDD synth_5286 synth_4914 synth_6141 VNB|VSS VDD synth_6192 VNB|VSS
+ sky130_fd_sc_hd__a21oi_1
X$4379 VDD synth_4276 synth_4643 synth_4642 VNB|VSS VDD synth_4577 VNB|VSS
+ sky130_fd_sc_hd__a21oi_1
X$4380 VDD synth_5705 synth_5664 synth_5286 VNB|VSS VDD synth_5607 VNB|VSS
+ sky130_fd_sc_hd__a21oi_1
X$4381 VDD synth_10227 synth_10073 synth_10132 VNB|VSS VDD synth_10261 VNB|VSS
+ sky130_fd_sc_hd__a21oi_1
X$4382 VDD synth_9112 synth_10778 synth_10776 VNB|VSS VDD synth_10654 VNB|VSS
+ sky130_fd_sc_hd__a21oi_1
X$4383 VDD synth_9695 synth_9042 synth_9434 VNB|VSS VDD synth_10413 VNB|VSS
+ sky130_fd_sc_hd__a21oi_1
X$4384 VDD synth_7716 synth_7715 synth_7640 VNB|VSS VDD synth_7717 VNB|VSS
+ sky130_fd_sc_hd__a21oi_1
X$4385 VDD synth_11711 synth_11284 synth_11633 VNB|VSS VDD synth_11632 VNB|VSS
+ sky130_fd_sc_hd__a21oi_1
X$4386 VDD synth_2124 synth_1452 synth_1141 VNB|VSS VDD synth_2057 VNB|VSS
+ sky130_fd_sc_hd__a21oi_1
X$4387 VDD synth_11097 synth_10232 synth_8945 VNB|VSS VDD synth_10980 VNB|VSS
+ sky130_fd_sc_hd__a21oi_1
X$4388 VDD synth_1113 synth_1262 synth_1322 VNB|VSS VDD synth_1230 VNB|VSS
+ sky130_fd_sc_hd__a21oi_1
X$4389 VDD synth_1213 synth_2646 synth_2691 VNB|VSS VDD synth_2688 VNB|VSS
+ sky130_fd_sc_hd__a21oi_1
X$4390 VDD synth_4974 synth_5013 synth_5111 VNB|VSS VDD synth_5043 VNB|VSS
+ sky130_fd_sc_hd__a21oi_1
X$4391 VDD synth_10095 synth_10171 synth_10361 VNB|VSS VDD synth_10482 VNB|VSS
+ sky130_fd_sc_hd__a21oi_1
X$4392 VDD synth_5061 synth_3632 synth_5012 VNB|VSS VDD synth_5041 VNB|VSS
+ sky130_fd_sc_hd__a21oi_1
X$4393 VDD synth_10285 synth_10312 synth_9322 VNB|VSS VDD synth_12384 VNB|VSS
+ sky130_fd_sc_hd__a21oi_1
X$4394 VDD synth_10965 synth_10164 synth_10923 VNB|VSS VDD synth_10967 VNB|VSS
+ sky130_fd_sc_hd__a21oi_1
X$4395 VDD synth_7599 synth_7476 synth_7435 VNB|VSS VDD synth_7516 VNB|VSS
+ sky130_fd_sc_hd__a21oi_1
X$4396 VDD synth_8405 synth_8404 synth_8490 VNB|VSS VDD synth_8402 VNB|VSS
+ sky130_fd_sc_hd__a21oi_1
X$4397 VDD synth_8948 synth_9474 synth_10220 VNB|VSS VDD synth_10619 VNB|VSS
+ sky130_fd_sc_hd__a21oi_1
X$4398 VDD synth_7673 synth_7597 synth_7474 VNB|VSS VDD synth_7382 VNB|VSS
+ sky130_fd_sc_hd__a21oi_1
X$4399 VDD synth_3516 synth_3460 synth_3376 VNB|VSS VDD synth_3227 VNB|VSS
+ sky130_fd_sc_hd__a21oi_1
X$4400 VDD synth_3216 synth_3468 synth_3439 VNB|VSS VDD synth_3536 VNB|VSS
+ sky130_fd_sc_hd__a21oi_1
X$4401 VDD synth_3730 synth_1067 synth_3629 VNB|VSS VDD synth_3434 VNB|VSS
+ sky130_fd_sc_hd__a21oi_1
X$4402 VDD synth_10618 synth_10722 synth_10639 VNB|VSS VDD synth_10617 VNB|VSS
+ sky130_fd_sc_hd__a21oi_1
X$4403 VDD synth_3608 synth_1067 synth_3457 VNB|VSS VDD synth_3342 VNB|VSS
+ sky130_fd_sc_hd__a21oi_1
X$4404 VDD synth_9297 synth_10703 synth_10929 VNB|VSS VDD synth_10928 VNB|VSS
+ sky130_fd_sc_hd__a21oi_1
X$4405 VDD synth_10516 synth_10260 synth_10517 VNB|VSS VDD synth_10515 VNB|VSS
+ sky130_fd_sc_hd__a21oi_1
X$4406 VDD synth_3527 synth_3694 synth_3893 VNB|VSS VDD synth_3821 VNB|VSS
+ sky130_fd_sc_hd__a21oi_1
X$4407 VDD synth_6524 synth_3468 synth_6608 VNB|VSS VDD synth_6607 VNB|VSS
+ sky130_fd_sc_hd__a21oi_1
X$4408 VDD synth_10474 synth_10259 synth_10390 VNB|VSS VDD synth_10318 VNB|VSS
+ sky130_fd_sc_hd__a21oi_1
X$4409 VDD synth_9297 synth_10921 synth_10927 VNB|VSS VDD synth_10926 VNB|VSS
+ sky130_fd_sc_hd__a21oi_1
X$4410 VDD synth_8196 synth_10470 synth_10534 VNB|VSS VDD synth_10518 VNB|VSS
+ sky130_fd_sc_hd__a21oi_1
X$4411 VDD synth_9629 synth_9900 synth_9284 VNB|VSS VDD synth_9829 VNB|VSS
+ sky130_fd_sc_hd__a21oi_1
X$4412 VDD synth_474 synth_391 synth_1797 VNB|VSS VDD synth_1845 VNB|VSS
+ sky130_fd_sc_hd__a21oi_1
X$4413 VDD synth_2654 synth_2631 synth_1081 VNB|VSS VDD synth_2655 VNB|VSS
+ sky130_fd_sc_hd__a21oi_1
X$4414 VDD synth_12657 synth_12690 synth_12689 VNB|VSS VDD synth_12617 VNB|VSS
+ sky130_fd_sc_hd__a21oi_1
X$4415 VDD synth_581 synth_5026 synth_5032 VNB|VSS VDD synth_4772 VNB|VSS
+ sky130_fd_sc_hd__a21oi_1
X$4416 VDD synth_9297 synth_11364 synth_11272 VNB|VSS VDD synth_11271 VNB|VSS
+ sky130_fd_sc_hd__a21oi_1
X$4417 VDD synth_5308 synth_5331 synth_5141 VNB|VSS VDD synth_5387 VNB|VSS
+ sky130_fd_sc_hd__a21oi_1
X$4418 VDD synth_12650 synth_12463 synth_9049 VNB|VSS VDD synth_12464 VNB|VSS
+ sky130_fd_sc_hd__a21oi_1
X$4419 VDD synth_8339 synth_7907 synth_8229 VNB|VSS VDD synth_8263 VNB|VSS
+ sky130_fd_sc_hd__a21oi_1
X$4420 VDD synth_1213 synth_1170 synth_1629 VNB|VSS VDD synth_1606 VNB|VSS
+ sky130_fd_sc_hd__a21oi_1
X$4421 VDD synth_9691 synth_11307 synth_11376 VNB|VSS VDD synth_11375 VNB|VSS
+ sky130_fd_sc_hd__a21oi_1
X$4422 VDD synth_1239 synth_1338 synth_1312 VNB|VSS VDD synth_1339 VNB|VSS
+ sky130_fd_sc_hd__a21oi_1
X$4423 VDD synth_1462 synth_927 synth_1301 VNB|VSS VDD synth_1537 VNB|VSS
+ sky130_fd_sc_hd__a21oi_1
X$4424 VDD synth_8235 synth_8306 synth_8230 VNB|VSS VDD synth_8234 VNB|VSS
+ sky130_fd_sc_hd__a21oi_1
X$4425 VDD synth_10384 synth_10385 synth_10336 VNB|VSS VDD synth_10656 VNB|VSS
+ sky130_fd_sc_hd__a21oi_1
X$4426 VDD synth_9049 synth_12274 synth_12046 VNB|VSS VDD synth_12088 VNB|VSS
+ sky130_fd_sc_hd__a21oi_1
X$4427 VDD synth_4988 synth_2116 synth_4806 VNB|VSS VDD synth_4927 VNB|VSS
+ sky130_fd_sc_hd__a21oi_1
X$4428 VDD synth_12124 synth_10164 synth_12190 VNB|VSS VDD synth_12189 VNB|VSS
+ sky130_fd_sc_hd__a21oi_1
X$4429 VDD synth_1792 synth_659 synth_1697 VNB|VSS VDD synth_1901 VNB|VSS
+ sky130_fd_sc_hd__a21oi_1
X$4430 VDD synth_9019 synth_10392 synth_10187 VNB|VSS VDD synth_10873 VNB|VSS
+ sky130_fd_sc_hd__a21oi_1
X$4431 VDD synth_12191 synth_12039 synth_12223 VNB|VSS VDD synth_12254 VNB|VSS
+ sky130_fd_sc_hd__a21oi_1
X$4432 VDD synth_9019 synth_10187 synth_10530 VNB|VSS VDD synth_10878 VNB|VSS
+ sky130_fd_sc_hd__a21oi_1
X$4433 VDD synth_10863 synth_10285 synth_10371 VNB|VSS VDD synth_12145 VNB|VSS
+ sky130_fd_sc_hd__a21oi_1
X$4434 VDD synth_8738 synth_10104 synth_10092 VNB|VSS VDD synth_10287 VNB|VSS
+ sky130_fd_sc_hd__a21oi_1
X$4435 VDD synth_6786 synth_6597 synth_6674 VNB|VSS VDD synth_6601 VNB|VSS
+ sky130_fd_sc_hd__a21oi_1
X$4436 VDD synth_7389 synth_7390 synth_7435 VNB|VSS VDD synth_7480 VNB|VSS
+ sky130_fd_sc_hd__a21oi_1
X$4437 VDD synth_3527 synth_4025 synth_4096 VNB|VSS VDD synth_4191 VNB|VSS
+ sky130_fd_sc_hd__a21oi_1
X$4438 VDD synth_9907 synth_8803 synth_11164 VNB|VSS VDD synth_11228 VNB|VSS
+ sky130_fd_sc_hd__a21oi_1
X$4439 VDD synth_6619 synth_6426 synth_6567 VNB|VSS VDD synth_6840 VNB|VSS
+ sky130_fd_sc_hd__a21oi_1
X$4440 VDD synth_12704 synth_12522 synth_12754 VNB|VSS VDD synth_12792 VNB|VSS
+ sky130_fd_sc_hd__a21oi_1
X$4441 VDD synth_9880 synth_9790 synth_9955 VNB|VSS VDD synth_9839 VNB|VSS
+ sky130_fd_sc_hd__a21oi_1
X$4442 VDD synth_4000 synth_3875 synth_3964 VNB|VSS VDD synth_4072 VNB|VSS
+ sky130_fd_sc_hd__a21oi_1
X$4443 VDD synth_139 synth_194 synth_140 VNB|VSS VDD synth_127 VNB|VSS
+ sky130_fd_sc_hd__a21oi_1
X$4444 VDD synth_8302 synth_7111 synth_8389 VNB|VSS VDD synth_8373 VNB|VSS
+ sky130_fd_sc_hd__a21oi_1
X$4445 VDD synth_9873 synth_10326 synth_10463 VNB|VSS VDD synth_10246 VNB|VSS
+ sky130_fd_sc_hd__a21oi_1
X$4446 VDD synth_2844 synth_1353 synth_2872 VNB|VSS VDD synth_3095 VNB|VSS
+ sky130_fd_sc_hd__a21oi_1
X$4447 VDD synth_7265 synth_7302 synth_7267 VNB|VSS VDD synth_7204 VNB|VSS
+ sky130_fd_sc_hd__a21oi_1
X$4448 VDD synth_5913 synth_4961 synth_5934 VNB|VSS VDD synth_5935 VNB|VSS
+ sky130_fd_sc_hd__a21oi_1
X$4449 VDD synth_6641 synth_6644 synth_6682 VNB|VSS VDD synth_6772 VNB|VSS
+ sky130_fd_sc_hd__a21oi_1
X$4450 VDD synth_6050 synth_5986 synth_6075 VNB|VSS VDD synth_6197 VNB|VSS
+ sky130_fd_sc_hd__a21oi_1
X$4451 VDD synth_2117 synth_2116 synth_2118 VNB|VSS VDD synth_2250 VNB|VSS
+ sky130_fd_sc_hd__a21oi_1
X$4452 VDD synth_2224 synth_2295 synth_2322 VNB|VSS VDD synth_2294 VNB|VSS
+ sky130_fd_sc_hd__a21oi_1
X$4453 VDD synth_8515 synth_8516 synth_8472 VNB|VSS VDD synth_8473 VNB|VSS
+ sky130_fd_sc_hd__a21oi_1
X$4454 VDD synth_8170 synth_8171 synth_8374 VNB|VSS VDD synth_8436 VNB|VSS
+ sky130_fd_sc_hd__a21oi_1
X$4455 VDD synth_11544 synth_11543 synth_11545 VNB|VSS VDD synth_11546 VNB|VSS
+ sky130_fd_sc_hd__a21oi_1
X$4456 VDD synth_346 synth_1884 synth_2198 VNB|VSS VDD synth_2317 VNB|VSS
+ sky130_fd_sc_hd__a21oi_1
X$4457 VDD synth_1625 synth_1626 synth_1666 VNB|VSS VDD synth_1696 VNB|VSS
+ sky130_fd_sc_hd__a21oi_1
X$4458 VDD synth_3527 synth_4188 synth_4189 VNB|VSS VDD synth_4002 VNB|VSS
+ sky130_fd_sc_hd__a21oi_1
X$4459 VDD synth_594 synth_194 synth_881 VNB|VSS VDD synth_882 VNB|VSS
+ sky130_fd_sc_hd__a21oi_1
X$4460 VDD synth_6793 synth_6862 synth_6633 VNB|VSS VDD synth_6933 VNB|VSS
+ sky130_fd_sc_hd__a21oi_1
X$4461 VDD synth_3988 synth_3989 synth_3990 VNB|VSS VDD synth_4054 VNB|VSS
+ sky130_fd_sc_hd__a21oi_1
X$4462 VDD synth_8613 synth_8300 synth_7435 VNB|VSS VDD synth_8631 VNB|VSS
+ sky130_fd_sc_hd__a21oi_1
X$4463 VDD synth_5404 synth_5405 synth_5403 VNB|VSS VDD synth_5536 VNB|VSS
+ sky130_fd_sc_hd__a21oi_1
X$4464 VDD synth_7681 synth_7743 synth_7887 VNB|VSS VDD synth_7869 VNB|VSS
+ sky130_fd_sc_hd__a21oi_1
X$4465 VDD synth_844 synth_659 synth_584 VNB|VSS VDD synth_691 VNB|VSS
+ sky130_fd_sc_hd__a21oi_1
X$4466 VDD synth_1901 synth_659 synth_1758 VNB|VSS VDD synth_1756 VNB|VSS
+ sky130_fd_sc_hd__a21oi_1
X$4467 VDD synth_6211 synth_7164 synth_7114 VNB|VSS VDD synth_7116 VNB|VSS
+ sky130_fd_sc_hd__a21oi_1
X$4468 VDD synth_408 synth_3412 synth_3982 VNB|VSS VDD synth_4044 VNB|VSS
+ sky130_fd_sc_hd__a21oi_1
X$4469 VDD synth_6476 synth_7289 synth_7225 VNB|VSS VDD synth_7290 VNB|VSS
+ sky130_fd_sc_hd__a21oi_1
X$4470 VDD synth_8125 synth_7883 synth_7435 VNB|VSS VDD synth_8236 VNB|VSS
+ sky130_fd_sc_hd__a21oi_1
X$4471 VDD synth_3527 synth_4091 synth_4092 VNB|VSS VDD synth_4327 VNB|VSS
+ sky130_fd_sc_hd__a21oi_1
X$4472 VDD synth_9119 synth_10344 synth_10104 VNB|VSS VDD synth_10236 VNB|VSS
+ sky130_fd_sc_hd__a21oi_1
X$4473 VDD synth_6211 synth_7414 synth_6974 VNB|VSS VDD synth_6973 VNB|VSS
+ sky130_fd_sc_hd__a21oi_1
X$4474 VDD synth_7614 synth_7481 synth_7570 VNB|VSS VDD synth_7756 VNB|VSS
+ sky130_fd_sc_hd__a21oi_1
X$4475 VDD synth_8765 synth_10313 synth_10315 VNB|VSS VDD synth_9604 VNB|VSS
+ sky130_fd_sc_hd__a21oi_1
X$4476 VDD synth_8765 synth_10313 synth_10314 VNB|VSS VDD synth_10270 VNB|VSS
+ sky130_fd_sc_hd__a21oi_1
X$4477 VDD synth_543 synth_151 synth_516 VNB|VSS VDD synth_596 VNB|VSS
+ sky130_fd_sc_hd__a21oi_1
X$4478 VDD synth_5319 synth_5220 synth_5340 VNB|VSS VDD synth_5388 VNB|VSS
+ sky130_fd_sc_hd__a21oi_1
X$4479 VDD synth_4277 synth_2116 synth_4168 VNB|VSS VDD synth_4252 VNB|VSS
+ sky130_fd_sc_hd__a21oi_1
X$4480 VDD synth_2512 synth_66 synth_2485 VNB|VSS VDD synth_2455 VNB|VSS
+ sky130_fd_sc_hd__a21oi_1
X$4481 VDD synth_1213 synth_1258 synth_2308 VNB|VSS VDD synth_2112 VNB|VSS
+ sky130_fd_sc_hd__a21oi_1
X$4482 VDD synth_3093 synth_1353 synth_3114 VNB|VSS VDD synth_3144 VNB|VSS
+ sky130_fd_sc_hd__a21oi_1
X$4483 VDD synth_6721 synth_6720 synth_6671 VNB|VSS VDD synth_6719 VNB|VSS
+ sky130_fd_sc_hd__a21oi_1
X$4484 VDD synth_9629 synth_9119 synth_10312 VNB|VSS VDD synth_10377 VNB|VSS
+ sky130_fd_sc_hd__a21oi_1
X$4485 VDD synth_4930 synth_2116 synth_4992 VNB|VSS VDD synth_4664 VNB|VSS
+ sky130_fd_sc_hd__a21oi_1
X$4486 VDD synth_12507 synth_9762 synth_12569 VNB|VSS VDD synth_12619 VNB|VSS
+ sky130_fd_sc_hd__a21oi_1
X$4487 VDD synth_5286 synth_6130 synth_6177 VNB|VSS VDD synth_6316 VNB|VSS
+ sky130_fd_sc_hd__a21oi_1
X$4488 VDD synth_5110 synth_3468 synth_5151 VNB|VSS VDD synth_5231 VNB|VSS
+ sky130_fd_sc_hd__a21oi_1
X$4489 VDD synth_408 synth_2884 synth_3773 VNB|VSS VDD synth_3920 VNB|VSS
+ sky130_fd_sc_hd__a21oi_1
X$4490 VDD synth_1213 synth_1501 synth_1631 VNB|VSS VDD synth_1706 VNB|VSS
+ sky130_fd_sc_hd__a21oi_1
X$4491 VDD synth_5106 synth_5104 synth_850 VNB|VSS VDD synth_5134 VNB|VSS
+ sky130_fd_sc_hd__a21oi_1
X$4492 VDD synth_9792 synth_9684 synth_9297 VNB|VSS VDD synth_9791 VNB|VSS
+ sky130_fd_sc_hd__a21oi_1
X$4493 VDD synth_3861 synth_3992 synth_4058 VNB|VSS VDD synth_3928 VNB|VSS
+ sky130_fd_sc_hd__a21oi_1
X$4494 VDD synth_9691 synth_11567 synth_11531 VNB|VSS VDD synth_11447 VNB|VSS
+ sky130_fd_sc_hd__a21oi_1
X$4495 VDD synth_408 synth_451 synth_1004 VNB|VSS VDD synth_921 VNB|VSS
+ sky130_fd_sc_hd__a21oi_1
X$4496 VDD synth_581 synth_3918 synth_4205 VNB|VSS VDD synth_4204 VNB|VSS
+ sky130_fd_sc_hd__a21oi_1
X$4497 VDD synth_10726 synth_10697 synth_9175 VNB|VSS VDD synth_12595 VNB|VSS
+ sky130_fd_sc_hd__a21oi_1
X$4498 VDD synth_1745 synth_927 synth_1759 VNB|VSS VDD synth_1663 VNB|VSS
+ sky130_fd_sc_hd__a21oi_1
X$4499 VDD synth_3256 synth_3258 synth_3257 VNB|VSS VDD synth_3415 VNB|VSS
+ sky130_fd_sc_hd__a21oi_1
X$4500 VDD synth_5286 synth_6317 synth_6132 VNB|VSS VDD synth_6259 VNB|VSS
+ sky130_fd_sc_hd__a21oi_1
X$4501 VDD synth_474 synth_1038 synth_1726 VNB|VSS VDD synth_1725 VNB|VSS
+ sky130_fd_sc_hd__a21oi_1
X$4502 VDD synth_8250 synth_8593 synth_8559 VNB|VSS VDD synth_8665 VNB|VSS
+ sky130_fd_sc_hd__a21oi_1
X$4503 VDD synth_759 synth_758 synth_653 VNB|VSS VDD synth_757 VNB|VSS
+ sky130_fd_sc_hd__a21oi_1
X$4504 VDD synth_474 synth_1557 synth_1782 VNB|VSS VDD synth_1799 VNB|VSS
+ sky130_fd_sc_hd__a21oi_1
X$4505 VDD synth_7535 synth_7456 synth_7536 VNB|VSS VDD synth_7571 VNB|VSS
+ sky130_fd_sc_hd__a21oi_1
X$4506 VDD synth_10192 synth_10121 synth_10117 VNB|VSS VDD synth_10243 VNB|VSS
+ sky130_fd_sc_hd__a21oi_1
X$4507 VDD synth_6485 synth_4961 synth_6558 VNB|VSS VDD synth_6571 VNB|VSS
+ sky130_fd_sc_hd__a21oi_1
X$4508 VDD synth_10285 synth_8948 synth_11912 VNB|VSS VDD synth_12386 VNB|VSS
+ sky130_fd_sc_hd__a21oi_1
X$4509 VDD synth_5591 synth_5557 synth_5556 VNB|VSS VDD synth_5540 VNB|VSS
+ sky130_fd_sc_hd__a21oi_1
X$4510 VDD synth_10105 synth_10013 synth_10142 VNB|VSS VDD synth_9933 VNB|VSS
+ sky130_fd_sc_hd__a21oi_1
X$4511 VDD synth_648 synth_350 synth_592 VNB|VSS VDD synth_710 VNB|VSS
+ sky130_fd_sc_hd__a21oi_1
X$4512 VDD synth_9575 synth_9423 synth_9576 VNB|VSS VDD synth_9678 VNB|VSS
+ sky130_fd_sc_hd__a21oi_1
X$4513 VDD synth_10011 synth_8805 synth_9730 VNB|VSS VDD synth_10140 VNB|VSS
+ sky130_fd_sc_hd__a21oi_1
X$4514 VDD synth_2463 synth_2413 synth_850 VNB|VSS VDD synth_2498 VNB|VSS
+ sky130_fd_sc_hd__a21oi_1
X$4515 VDD synth_5286 synth_5879 synth_5792 VNB|VSS VDD synth_5840 VNB|VSS
+ sky130_fd_sc_hd__a21oi_1
X$4516 VDD synth_1081 synth_2962 synth_3311 VNB|VSS VDD synth_3517 VNB|VSS
+ sky130_fd_sc_hd__a21oi_1
X$4517 VDD synth_6425 synth_6426 synth_6475 VNB|VSS VDD synth_6473 VNB|VSS
+ sky130_fd_sc_hd__a21oi_1
X$4518 VDD synth_3652 synth_3541 synth_3617 VNB|VSS VDD synth_3711 VNB|VSS
+ sky130_fd_sc_hd__a21oi_1
X$4519 VDD synth_5234 synth_3468 synth_5075 VNB|VSS VDD synth_5337 VNB|VSS
+ sky130_fd_sc_hd__a21oi_1
X$4520 VDD synth_11100 synth_11101 synth_11175 VNB|VSS VDD synth_11194 VNB|VSS
+ sky130_fd_sc_hd__a21oi_1
X$4521 VDD synth_6607 synth_3468 synth_6725 VNB|VSS VDD synth_6775 VNB|VSS
+ sky130_fd_sc_hd__a21oi_1
X$4522 VDD synth_4597 synth_4822 synth_4707 VNB|VSS VDD synth_4996 VNB|VSS
+ sky130_fd_sc_hd__a21oi_1
X$4523 VDD synth_5789 synth_5791 synth_5880 VNB|VSS VDD synth_6014 VNB|VSS
+ sky130_fd_sc_hd__a21oi_1
X$4524 VDD synth_8133 synth_7894 synth_8162 VNB|VSS VDD synth_8161 VNB|VSS
+ sky130_fd_sc_hd__a21oi_1
X$4525 VDD synth_9292 synth_12107 synth_9615 VNB|VSS VDD synth_12234 VNB|VSS
+ sky130_fd_sc_hd__a21oi_1
X$4526 VDD synth_2744 synth_2734 synth_408 VNB|VSS VDD synth_2811 VNB|VSS
+ sky130_fd_sc_hd__a21oi_1
X$4527 VDD synth_3964 synth_4844 synth_5269 VNB|VSS VDD synth_5347 VNB|VSS
+ sky130_fd_sc_hd__a21oi_1
X$4528 VDD synth_2304 synth_66 synth_2347 VNB|VSS VDD synth_2512 VNB|VSS
+ sky130_fd_sc_hd__a21oi_1
X$4529 VDD synth_1176 synth_1178 synth_1222 VNB|VSS VDD synth_1226 VNB|VSS
+ sky130_fd_sc_hd__a21oi_1
X$4530 VDD synth_9475 synth_9423 synth_9509 VNB|VSS VDD synth_9575 VNB|VSS
+ sky130_fd_sc_hd__a21oi_1
X$4531 VDD synth_9041 synth_9431 synth_9743 VNB|VSS VDD synth_9558 VNB|VSS
+ sky130_fd_sc_hd__a21oi_1
X$4532 VDD synth_2383 synth_2469 synth_2470 VNB|VSS VDD synth_2449 VNB|VSS
+ sky130_fd_sc_hd__a21oi_1
X$4533 VDD synth_8696 synth_8617 synth_8573 VNB|VSS VDD synth_8695 VNB|VSS
+ sky130_fd_sc_hd__a21oi_1
X$4534 VDD synth_1213 synth_431 synth_1672 VNB|VSS VDD synth_1581 VNB|VSS
+ sky130_fd_sc_hd__a21oi_1
X$4535 VDD synth_7996 synth_7998 synth_8054 VNB|VSS VDD synth_8142 VNB|VSS
+ sky130_fd_sc_hd__a21oi_1
X$4536 VDD synth_934 synth_927 synth_928 VNB|VSS VDD synth_929 VNB|VSS
+ sky130_fd_sc_hd__a21oi_1
X$4537 VDD synth_12519 synth_12518 synth_12555 VNB|VSS VDD synth_12582 VNB|VSS
+ sky130_fd_sc_hd__a21oi_1
X$4538 VDD synth_5420 synth_5477 synth_5156 VNB|VSS VDD synth_5530 VNB|VSS
+ sky130_fd_sc_hd__a21oi_1
X$4539 VDD synth_6331 synth_3468 synth_6407 VNB|VSS VDD synth_6408 VNB|VSS
+ sky130_fd_sc_hd__a21oi_1
X$4540 VDD synth_2490 synth_2362 synth_2489 VNB|VSS VDD synth_2550 VNB|VSS
+ sky130_fd_sc_hd__a21oi_1
X$4541 VDD synth_5626 synth_4961 synth_5572 VNB|VSS VDD synth_5518 VNB|VSS
+ sky130_fd_sc_hd__a21oi_1
X$4542 VDD synth_3211 synth_3042 synth_3141 VNB|VSS VDD synth_3213 VNB|VSS
+ sky130_fd_sc_hd__a21oi_1
X$4543 VDD synth_2704 synth_2116 synth_2703 VNB|VSS VDD synth_2578 VNB|VSS
+ sky130_fd_sc_hd__a21oi_1
X$4544 VDD synth_5286 synth_4913 synth_5804 VNB|VSS VDD synth_5946 VNB|VSS
+ sky130_fd_sc_hd__a21oi_1
X$4545 VDD synth_106 synth_231 synth_232 VNB|VSS VDD synth_230 VNB|VSS
+ sky130_fd_sc_hd__a21oi_1
X$4546 VDD synth_3943 synth_3800 synth_3829 VNB|VSS VDD synth_3801 VNB|VSS
+ sky130_fd_sc_hd__a21oi_1
X$4547 VDD synth_7376 synth_7183 synth_7630 VNB|VSS VDD synth_7629 VNB|VSS
+ sky130_fd_sc_hd__a21oi_1
X$4548 VDD synth_532 synth_534 synth_556 VNB|VSS VDD synth_531 VNB|VSS
+ sky130_fd_sc_hd__a21oi_1
X$4549 VDD synth_1918 synth_1067 synth_1949 VNB|VSS VDD synth_1948 VNB|VSS
+ sky130_fd_sc_hd__a21oi_1
X$4550 VDD synth_9157 synth_8784 synth_9107 VNB|VSS VDD synth_9211 VNB|VSS
+ sky130_fd_sc_hd__a21oi_1
X$4551 VDD synth_6771 synth_6751 synth_6823 VNB|VSS VDD synth_4558 VNB|VSS
+ sky130_fd_sc_hd__a21oi_1
X$4552 VDD synth_3981 synth_927 synth_3980 VNB|VSS VDD synth_4047 VNB|VSS
+ sky130_fd_sc_hd__a21oi_1
X$4553 VDD synth_1948 synth_1067 synth_1950 VNB|VSS VDD synth_2087 VNB|VSS
+ sky130_fd_sc_hd__a21oi_1
X$4554 VDD synth_12477 synth_10164 synth_12734 VNB|VSS VDD synth_12502 VNB|VSS
+ sky130_fd_sc_hd__a21oi_1
X$4555 VDD synth_9699 synth_9112 synth_10411 VNB|VSS VDD synth_10354 VNB|VSS
+ sky130_fd_sc_hd__a21oi_1
X$4556 VDD synth_1952 synth_1953 synth_1844 VNB|VSS VDD synth_2088 VNB|VSS
+ sky130_fd_sc_hd__a21oi_1
X$4557 VDD synth_581 synth_5171 synth_4863 VNB|VSS VDD synth_4945 VNB|VSS
+ sky130_fd_sc_hd__a21oi_1
X$4558 VDD synth_12341 synth_12231 synth_12342 VNB|VSS VDD synth_12297 VNB|VSS
+ sky130_fd_sc_hd__a21oi_1
X$4559 VDD synth_12509 synth_12620 synth_12510 VNB|VSS VDD synth_12548 VNB|VSS
+ sky130_fd_sc_hd__a21oi_1
X$4560 VDD synth_9297 synth_11143 synth_11232 VNB|VSS VDD synth_11410 VNB|VSS
+ sky130_fd_sc_hd__a21oi_1
X$4561 VDD synth_6034 synth_6039 synth_5976 VNB|VSS VDD synth_6037 VNB|VSS
+ sky130_fd_sc_hd__a21oi_1
X$4562 VDD synth_1565 synth_1356 synth_1512 VNB|VSS VDD synth_1511 VNB|VSS
+ sky130_fd_sc_hd__a21oi_1
X$4563 VDD synth_850 synth_3952 synth_4171 VNB|VSS VDD synth_4136 VNB|VSS
+ sky130_fd_sc_hd__a21oi_1
X$4564 VDD synth_248 synth_66 synth_154 VNB|VSS VDD synth_114 VNB|VSS
+ sky130_fd_sc_hd__a21oi_1
X$4565 VDD synth_5696 synth_5627 synth_5694 VNB|VSS VDD synth_5761 VNB|VSS
+ sky130_fd_sc_hd__a21oi_1
X$4566 VDD synth_12287 synth_12350 synth_12288 VNB|VSS VDD synth_12317 VNB|VSS
+ sky130_fd_sc_hd__a21oi_1
X$4567 VDD synth_850 synth_1207 synth_1867 VNB|VSS VDD synth_1836 VNB|VSS
+ sky130_fd_sc_hd__a21oi_1
X$4568 VDD synth_3078 synth_3000 synth_3002 VNB|VSS VDD synth_3473 VNB|VSS
+ sky130_fd_sc_hd__a21oi_1
X$4569 VDD synth_2113 synth_1925 synth_2041 VNB|VSS VDD synth_2191 VNB|VSS
+ sky130_fd_sc_hd__a21oi_1
X$4570 VDD synth_7166 synth_7103 synth_5286 VNB|VSS VDD synth_7192 VNB|VSS
+ sky130_fd_sc_hd__a21oi_1
X$4571 VDD synth_3527 synth_4014 synth_4175 VNB|VSS VDD synth_4174 VNB|VSS
+ sky130_fd_sc_hd__a21oi_1
X$4572 VDD synth_4354 synth_4329 synth_4023 VNB|VSS VDD synth_4355 VNB|VSS
+ sky130_fd_sc_hd__a21oi_1
X$4573 VDD synth_11112 synth_11029 synth_9297 VNB|VSS VDD synth_11183 VNB|VSS
+ sky130_fd_sc_hd__a21oi_1
X$4574 VDD synth_4508 synth_4365 synth_4507 VNB|VSS VDD synth_4564 VNB|VSS
+ sky130_fd_sc_hd__a21oi_1
X$4575 VDD synth_4081 synth_4142 synth_4011 VNB|VSS VDD synth_4308 VNB|VSS
+ sky130_fd_sc_hd__a21oi_1
X$4576 VDD synth_850 synth_1624 synth_1793 VNB|VSS VDD synth_1985 VNB|VSS
+ sky130_fd_sc_hd__a21oi_1
X$4577 VDD synth_1115 synth_66 synth_1084 VNB|VSS VDD synth_1035 VNB|VSS
+ sky130_fd_sc_hd__a21oi_1
X$4578 VDD synth_11694 synth_11695 synth_11734 VNB|VSS VDD synth_11656 VNB|VSS
+ sky130_fd_sc_hd__a21oi_1
X$4579 VDD synth_6161 synth_5992 synth_6306 VNB|VSS VDD synth_6381 VNB|VSS
+ sky130_fd_sc_hd__a21oi_1
X$4580 VDD synth_9430 synth_9042 synth_9048 VNB|VSS VDD synth_9510 VNB|VSS
+ sky130_fd_sc_hd__a21oi_1
X$4581 VDD synth_9677 synth_9848 synth_11316 VNB|VSS VDD synth_11249 VNB|VSS
+ sky130_fd_sc_hd__a21oi_1
X$4582 VDD synth_8764 synth_9848 synth_10092 VNB|VSS VDD synth_10094 VNB|VSS
+ sky130_fd_sc_hd__a21oi_1
X$4583 VDD synth_6189 synth_3468 synth_6160 VNB|VSS VDD synth_6331 VNB|VSS
+ sky130_fd_sc_hd__a21oi_1
X$4584 VDD synth_6874 synth_6822 synth_6873 VNB|VSS VDD synth_6934 VNB|VSS
+ sky130_fd_sc_hd__a21oi_1
X$4585 VDD synth_10952 synth_11690 synth_11692 VNB|VSS VDD synth_11762 VNB|VSS
+ sky130_fd_sc_hd__a21oi_1
X$4586 VDD synth_9173 synth_8981 synth_9625 VNB|VSS VDD synth_9682 VNB|VSS
+ sky130_fd_sc_hd__a21oi_1
X$4587 VDD synth_6211 synth_6998 synth_6999 VNB|VSS VDD synth_6975 VNB|VSS
+ sky130_fd_sc_hd__a21oi_1
X$4588 VDD synth_153 synth_222 synth_223 VNB|VSS VDD synth_221 VNB|VSS
+ sky130_fd_sc_hd__a21oi_1
X$4589 VDD synth_1081 synth_3509 synth_3938 VNB|VSS VDD synth_3833 VNB|VSS
+ sky130_fd_sc_hd__a21oi_1
X$4590 VDD synth_3580 synth_3451 synth_3452 VNB|VSS VDD synth_3581 VNB|VSS
+ sky130_fd_sc_hd__a21oi_1
X$4591 VDD synth_6469 synth_8101 synth_8102 VNB|VSS VDD synth_8028 VNB|VSS
+ sky130_fd_sc_hd__a21oi_1
X$4592 VDD synth_10601 synth_10566 synth_10567 VNB|VSS VDD synth_10623 VNB|VSS
+ sky130_fd_sc_hd__a21oi_1
X$4593 VDD synth_5317 synth_5419 synth_5538 VNB|VSS VDD synth_5418 VNB|VSS
+ sky130_fd_sc_hd__a21oi_1
X$4594 VDD synth_6869 synth_6720 synth_6943 VNB|VSS VDD synth_6868 VNB|VSS
+ sky130_fd_sc_hd__a21oi_1
X$4595 VDD synth_5286 synth_5808 synth_6111 VNB|VSS VDD synth_6110 VNB|VSS
+ sky130_fd_sc_hd__a21oi_1
X$4596 VDD synth_1080 synth_66 synth_1040 VNB|VSS VDD synth_1153 VNB|VSS
+ sky130_fd_sc_hd__a21oi_1
X$4597 VDD synth_1664 synth_927 synth_1659 VNB|VSS VDD synth_1745 VNB|VSS
+ sky130_fd_sc_hd__a21oi_1
X$4598 VDD synth_6211 synth_7545 synth_7493 VNB|VSS VDD synth_7452 VNB|VSS
+ sky130_fd_sc_hd__a21oi_1
X$4599 VDD synth_6211 synth_7416 synth_7538 VNB|VSS VDD synth_7451 VNB|VSS
+ sky130_fd_sc_hd__a21oi_1
X$4600 VDD synth_6013 synth_4961 synth_6005 VNB|VSS VDD synth_6094 VNB|VSS
+ sky130_fd_sc_hd__a21oi_1
X$4601 VDD synth_1081 synth_2397 synth_3238 VNB|VSS VDD synth_3275 VNB|VSS
+ sky130_fd_sc_hd__a21oi_1
X$4602 VDD synth_10473 synth_10429 synth_10430 VNB|VSS VDD synth_10547 VNB|VSS
+ sky130_fd_sc_hd__a21oi_1
X$4603 VDD synth_9297 synth_10497 synth_11269 VNB|VSS VDD synth_11146 VNB|VSS
+ sky130_fd_sc_hd__a21oi_1
X$4604 VDD synth_9049 synth_11215 synth_11378 VNB|VSS VDD synth_11311 VNB|VSS
+ sky130_fd_sc_hd__a21oi_1
X$4605 VDD synth_408 synth_1378 synth_1376 VNB|VSS VDD synth_1549 VNB|VSS
+ sky130_fd_sc_hd__a21oi_1
X$4606 VDD synth_6938 synth_6597 synth_6867 VNB|VSS VDD synth_6942 VNB|VSS
+ sky130_fd_sc_hd__a21oi_1
X$4607 VDD synth_6601 synth_6597 synth_6783 VNB|VSS VDD synth_6522 VNB|VSS
+ sky130_fd_sc_hd__a21oi_1
X$4608 VDD synth_12794 synth_12593 synth_12652 VNB|VSS VDD synth_12784 VNB|VSS
+ sky130_fd_sc_hd__a21oi_1
X$4609 VDD synth_9349 synth_8746 synth_9214 VNB|VSS VDD synth_9350 VNB|VSS
+ sky130_fd_sc_hd__a21oi_1
X$4610 VDD synth_6798 synth_6865 synth_6894 VNB|VSS VDD synth_6510 VNB|VSS
+ sky130_fd_sc_hd__a21oi_1
X$4611 VDD synth_10631 synth_9762 synth_10614 VNB|VSS VDD synth_10691 VNB|VSS
+ sky130_fd_sc_hd__a21oi_1
X$4612 VDD synth_10886 synth_10925 synth_10922 VNB|VSS VDD synth_10969 VNB|VSS
+ sky130_fd_sc_hd__a21oi_1
X$4613 VDD synth_6429 synth_6428 synth_6430 VNB|VSS VDD synth_6537 VNB|VSS
+ sky130_fd_sc_hd__a21oi_1
X$4614 VDD synth_12263 synth_9762 synth_12399 VNB|VSS VDD synth_12487 VNB|VSS
+ sky130_fd_sc_hd__a21oi_1
X$4615 VDD synth_2987 synth_2882 synth_408 VNB|VSS VDD synth_2968 VNB|VSS
+ sky130_fd_sc_hd__a21oi_1
X$4616 VDD synth_8340 synth_8341 synth_8305 VNB|VSS VDD synth_8411 VNB|VSS
+ sky130_fd_sc_hd__a21oi_1
X$4617 VDD synth_9446 synth_9215 synth_9352 VNB|VSS VDD synth_9536 VNB|VSS
+ sky130_fd_sc_hd__a21oi_1
X$4618 VDD synth_9429 synth_8738 synth_9483 VNB|VSS VDD synth_9567 VNB|VSS
+ sky130_fd_sc_hd__a21oi_1
X$4619 VDD synth_5929 synth_4961 synth_6004 VNB|VSS VDD synth_6095 VNB|VSS
+ sky130_fd_sc_hd__a21oi_1
X$4620 VDD synth_10526 synth_8746 synth_10562 VNB|VSS VDD synth_10419 VNB|VSS
+ sky130_fd_sc_hd__a21oi_1
X$4621 VDD synth_3075 synth_3028 synth_1213 VNB|VSS VDD synth_3106 VNB|VSS
+ sky130_fd_sc_hd__a21oi_1
X$4622 VDD synth_1591 synth_1552 synth_1296 VNB|VSS VDD synth_1590 VNB|VSS
+ sky130_fd_sc_hd__a21oi_1
X$4623 VDD synth_5286 synth_6142 synth_6294 VNB|VSS VDD synth_6363 VNB|VSS
+ sky130_fd_sc_hd__a21oi_1
X$4624 VDD synth_10550 synth_9762 synth_10572 VNB|VSS VDD synth_10631 VNB|VSS
+ sky130_fd_sc_hd__a21oi_1
X$4625 VDD synth_11463 synth_9387 synth_9615 VNB|VSS VDD synth_12301 VNB|VSS
+ sky130_fd_sc_hd__a21oi_1
X$4626 VDD synth_4082 synth_3860 synth_4080 VNB|VSS VDD synth_4402 VNB|VSS
+ sky130_fd_sc_hd__a21oi_1
X$4627 VDD synth_1355 synth_194 synth_1410 VNB|VSS VDD synth_1357 VNB|VSS
+ sky130_fd_sc_hd__a21oi_1
X$4628 VDD synth_3888 synth_3860 synth_3889 VNB|VSS VDD synth_4215 VNB|VSS
+ sky130_fd_sc_hd__a21oi_1
X$4629 VDD synth_10659 synth_10679 synth_10733 VNB|VSS VDD synth_10734 VNB|VSS
+ sky130_fd_sc_hd__a21oi_1
X$4630 VDD synth_7135 synth_7014 synth_7181 VNB|VSS VDD synth_7012 VNB|VSS
+ sky130_fd_sc_hd__a21oi_1
X$4631 VDD synth_6211 synth_7069 synth_7236 VNB|VSS VDD synth_7159 VNB|VSS
+ sky130_fd_sc_hd__a21oi_1
X$4632 VDD synth_261 synth_151 synth_260 VNB|VSS VDD synth_121 VNB|VSS
+ sky130_fd_sc_hd__a21oi_1
X$4633 VDD synth_12664 synth_12663 synth_12641 VNB|VSS VDD synth_12778 VNB|VSS
+ sky130_fd_sc_hd__a21oi_1
X$4634 VDD synth_11537 synth_9833 synth_11538 VNB|VSS VDD synth_10640 VNB|VSS
+ sky130_fd_sc_hd__a21oi_1
X$4635 VDD synth_12521 synth_12271 synth_9049 VNB|VSS VDD synth_12640 VNB|VSS
+ sky130_fd_sc_hd__a21oi_1
X$4636 VDD synth_9387 synth_9322 synth_9514 VNB|VSS VDD synth_12394 VNB|VSS
+ sky130_fd_sc_hd__a21oi_1
X$4637 VDD synth_11049 synth_9762 synth_11206 VNB|VSS VDD synth_11240 VNB|VSS
+ sky130_fd_sc_hd__a21oi_1
X$4638 VDD synth_3344 synth_3308 synth_3394 VNB|VSS VDD synth_3307 VNB|VSS
+ sky130_fd_sc_hd__a21oi_1
X$4639 VDD synth_1081 synth_288 synth_1317 VNB|VSS VDD synth_1193 VNB|VSS
+ sky130_fd_sc_hd__a21oi_1
X$4640 VDD synth_6476 synth_7317 synth_7091 VNB|VSS VDD synth_7092 VNB|VSS
+ sky130_fd_sc_hd__a21oi_1
X$4641 VDD synth_3527 synth_4803 synth_4804 VNB|VSS VDD synth_4731 VNB|VSS
+ sky130_fd_sc_hd__a21oi_1
X$4642 VDD synth_9577 synth_9563 synth_9616 VNB|VSS VDD synth_9578 VNB|VSS
+ sky130_fd_sc_hd__a21oi_1
X$4643 VDD synth_3527 synth_3293 synth_3666 VNB|VSS VDD synth_3749 VNB|VSS
+ sky130_fd_sc_hd__a21oi_1
X$4644 VDD synth_3364 synth_3451 synth_3489 VNB|VSS VDD synth_3579 VNB|VSS
+ sky130_fd_sc_hd__a21oi_1
X$4645 VDD synth_3527 synth_4835 synth_4799 VNB|VSS VDD synth_4899 VNB|VSS
+ sky130_fd_sc_hd__a21oi_1
X$4646 VDD synth_9579 synth_8710 synth_9680 VNB|VSS VDD synth_9114 VNB|VSS
+ sky130_fd_sc_hd__a21oi_1
X$4647 VDD synth_3527 synth_4800 synth_4801 VNB|VSS VDD synth_4984 VNB|VSS
+ sky130_fd_sc_hd__a21oi_1
X$4648 VDD synth_7246 synth_7111 synth_7167 VNB|VSS VDD synth_7461 VNB|VSS
+ sky130_fd_sc_hd__a21oi_1
X$4649 VDD synth_7263 synth_7030 synth_7248 VNB|VSS VDD synth_7262 VNB|VSS
+ sky130_fd_sc_hd__a21oi_1
X$4650 VDD synth_5459 synth_5457 synth_581 VNB|VSS VDD synth_5525 VNB|VSS
+ sky130_fd_sc_hd__a21oi_1
X$4651 VDD synth_2283 synth_2282 synth_2390 VNB|VSS VDD synth_2349 VNB|VSS
+ sky130_fd_sc_hd__a21oi_1
X$4652 VDD synth_1213 synth_2625 synth_2574 VNB|VSS VDD synth_2573 VNB|VSS
+ sky130_fd_sc_hd__a21oi_1
X$4653 VDD synth_9049 synth_11807 synth_11806 VNB|VSS VDD synth_11860 VNB|VSS
+ sky130_fd_sc_hd__a21oi_1
X$4654 VDD synth_1213 synth_2695 synth_2396 VNB|VSS VDD synth_2572 VNB|VSS
+ sky130_fd_sc_hd__a21oi_1
X$4655 VDD synth_7169 synth_7111 synth_7112 VNB|VSS VDD synth_7246 VNB|VSS
+ sky130_fd_sc_hd__a21oi_1
X$4656 VDD synth_5710 synth_4747 synth_5678 VNB|VSS VDD synth_5770 VNB|VSS
+ sky130_fd_sc_hd__a21oi_1
X$4657 VDD synth_11521 synth_10232 synth_10840 VNB|VSS VDD synth_11592 VNB|VSS
+ sky130_fd_sc_hd__a21oi_1
X$4658 VDD synth_8230 synth_8859 synth_9222 VNB|VSS VDD synth_9282 VNB|VSS
+ sky130_fd_sc_hd__a21oi_1
X$4659 VDD synth_3751 synth_3789 synth_3722 VNB|VSS VDD synth_3752 VNB|VSS
+ sky130_fd_sc_hd__a21oi_1
X$4660 VDD synth_9119 synth_9474 synth_9615 VNB|VSS VDD synth_9928 VNB|VSS
+ sky130_fd_sc_hd__a21oi_1
X$4661 VDD synth_5116 synth_5067 synth_5066 VNB|VSS VDD synth_5222 VNB|VSS
+ sky130_fd_sc_hd__a21oi_1
X$4662 VDD synth_1179 synth_1262 synth_1347 VNB|VSS VDD synth_1429 VNB|VSS
+ sky130_fd_sc_hd__a21oi_1
X$4663 VDD synth_8230 synth_9891 synth_9962 VNB|VSS VDD synth_9843 VNB|VSS
+ sky130_fd_sc_hd__a21oi_1
X$4664 VDD synth_8230 synth_9757 synth_9728 VNB|VSS VDD synth_9729 VNB|VSS
+ sky130_fd_sc_hd__a21oi_1
X$4665 VDD synth_3994 synth_3995 synth_4015 VNB|VSS VDD synth_4067 VNB|VSS
+ sky130_fd_sc_hd__a21oi_1
X$4666 VDD synth_9297 synth_12375 synth_11369 VNB|VSS VDD synth_11446 VNB|VSS
+ sky130_fd_sc_hd__a21oi_1
X$4667 VDD synth_346 synth_2175 synth_2199 VNB|VSS VDD synth_2255 VNB|VSS
+ sky130_fd_sc_hd__a21oi_1
X$4668 VDD synth_5841 synth_4961 synth_5827 VNB|VSS VDD synth_5913 VNB|VSS
+ sky130_fd_sc_hd__a21oi_1
X$4669 VDD synth_3527 synth_3111 synth_3611 VNB|VSS VDD synth_3559 VNB|VSS
+ sky130_fd_sc_hd__a21oi_1
X$4670 VDD synth_9819 synth_8000 synth_9620 VNB|VSS VDD synth_9758 VNB|VSS
+ sky130_fd_sc_hd__a21oi_1
X$4671 VDD synth_5811 synth_3632 synth_5958 VNB|VSS VDD synth_5712 VNB|VSS
+ sky130_fd_sc_hd__a21oi_1
X$4672 VDD synth_10169 synth_9112 synth_10060 VNB|VSS VDD synth_10690 VNB|VSS
+ sky130_fd_sc_hd__a21oi_1
X$4673 VDD synth_9758 synth_8000 synth_9663 VNB|VSS VDD synth_9966 VNB|VSS
+ sky130_fd_sc_hd__a21oi_1
X$4674 VDD synth_9822 synth_9690 synth_9823 VNB|VSS VDD synth_10048 VNB|VSS
+ sky130_fd_sc_hd__a21oi_1
X$4675 VDD synth_8230 synth_8070 synth_9224 VNB|VSS VDD synth_9471 VNB|VSS
+ sky130_fd_sc_hd__a21oi_1
X$4676 VDD synth_2487 synth_2288 synth_2445 VNB|VSS VDD synth_2606 VNB|VSS
+ sky130_fd_sc_hd__a21oi_1
X$4677 VDD synth_6807 synth_6809 synth_6808 VNB|VSS VDD synth_6948 VNB|VSS
+ sky130_fd_sc_hd__a21oi_1
X$4678 VDD synth_8801 synth_8835 synth_8836 VNB|VSS VDD synth_8927 VNB|VSS
+ sky130_fd_sc_hd__a21oi_1
X$4679 VDD synth_12424 synth_10164 synth_12398 VNB|VSS VDD synth_12477 VNB|VSS
+ sky130_fd_sc_hd__a21oi_1
X$4680 VDD synth_8213 synth_7111 synth_8289 VNB|VSS VDD synth_8174 VNB|VSS
+ sky130_fd_sc_hd__a21oi_1
X$4681 VDD synth_9738 synth_9232 synth_10099 VNB|VSS VDD synth_12405 VNB|VSS
+ sky130_fd_sc_hd__a21oi_1
X$4682 VDD synth_11795 synth_10312 synth_11911 VNB|VSS VDD synth_11863 VNB|VSS
+ sky130_fd_sc_hd__a21oi_1
X$4683 VDD synth_5239 synth_3541 synth_5284 VNB|VSS VDD synth_5359 VNB|VSS
+ sky130_fd_sc_hd__a21oi_1
X$4684 VDD synth_6126 synth_6597 synth_6806 VNB|VSS VDD synth_7005 VNB|VSS
+ sky130_fd_sc_hd__a21oi_1
X$4685 VDD synth_12588 synth_12522 synth_12722 VNB|VSS VDD synth_12706 VNB|VSS
+ sky130_fd_sc_hd__a21oi_1
X$4686 VDD synth_11928 synth_11537 synth_11590 VNB|VSS VDD synth_12029 VNB|VSS
+ sky130_fd_sc_hd__a21oi_1
X$4687 VDD synth_2975 synth_2815 synth_2973 VNB|VSS VDD synth_3049 VNB|VSS
+ sky130_fd_sc_hd__a21oi_1
X$4688 VDD synth_7123 synth_7039 synth_7211 VNB|VSS VDD synth_7223 VNB|VSS
+ sky130_fd_sc_hd__a21oi_1
X$4689 VDD synth_3050 synth_659 synth_3053 VNB|VSS VDD synth_3125 VNB|VSS
+ sky130_fd_sc_hd__a21oi_1
X$4690 VDD synth_9062 synth_11818 synth_11627 VNB|VSS VDD synth_11889 VNB|VSS
+ sky130_fd_sc_hd__a21oi_1
X$4691 VDD synth_416 synth_151 synth_436 VNB|VSS VDD synth_257 VNB|VSS
+ sky130_fd_sc_hd__a21oi_1
X$4692 VDD synth_10057 synth_9119 synth_10009 VNB|VSS VDD synth_10158 VNB|VSS
+ sky130_fd_sc_hd__a21oi_1
X$4693 VDD synth_10542 synth_10164 synth_10570 VNB|VSS VDD synth_10687 VNB|VSS
+ sky130_fd_sc_hd__a21oi_1
X$4694 VDD synth_929 synth_927 synth_1010 VNB|VSS VDD synth_932 VNB|VSS
+ sky130_fd_sc_hd__a21oi_1
X$4695 VDD synth_257 synth_151 synth_213 VNB|VSS VDD synth_126 VNB|VSS
+ sky130_fd_sc_hd__a21oi_1
X$4696 VDD synth_2856 synth_2857 synth_2981 VNB|VSS VDD synth_2982 VNB|VSS
+ sky130_fd_sc_hd__a21oi_1
X$4697 VDD synth_5397 synth_5398 synth_5366 VNB|VSS VDD synth_5437 VNB|VSS
+ sky130_fd_sc_hd__a21oi_1
X$4698 VDD synth_7844 synth_7111 synth_7660 VNB|VSS VDD synth_7970 VNB|VSS
+ sky130_fd_sc_hd__a21oi_1
X$4699 VDD synth_8720 synth_8617 synth_8719 VNB|VSS VDD synth_8452 VNB|VSS
+ sky130_fd_sc_hd__a21oi_1
X$4700 VDD synth_591 synth_246 synth_507 VNB|VSS VDD synth_590 VNB|VSS
+ sky130_fd_sc_hd__a21oi_1
X$4701 VDD synth_6422 synth_6597 synth_6678 VNB|VSS VDD synth_6944 VNB|VSS
+ sky130_fd_sc_hd__a21oi_1
X$4702 VDD synth_5286 synth_5240 synth_5659 VNB|VSS VDD synth_5601 VNB|VSS
+ sky130_fd_sc_hd__a21oi_1
X$4703 VDD synth_5286 synth_5576 synth_5842 VNB|VSS VDD synth_6019 VNB|VSS
+ sky130_fd_sc_hd__a21oi_1
X$4704 VDD synth_3964 synth_3942 synth_3967 VNB|VSS VDD synth_3966 VNB|VSS
+ sky130_fd_sc_hd__a21oi_1
X$4705 VDD synth_8912 synth_8506 synth_8230 VNB|VSS VDD synth_8913 VNB|VSS
+ sky130_fd_sc_hd__a21oi_1
X$4706 VDD synth_1081 synth_289 synth_1315 VNB|VSS VDD synth_1291 VNB|VSS
+ sky130_fd_sc_hd__a21oi_1
X$4707 VDD synth_4597 synth_4630 synth_4560 VNB|VSS VDD synth_4631 VNB|VSS
+ sky130_fd_sc_hd__a21oi_1
X$4708 VDD synth_12314 synth_12732 synth_12765 VNB|VSS VDD synth_12766 VNB|VSS
+ sky130_fd_sc_hd__a21oi_1
X$4709 VDD synth_4458 synth_4691 synth_4549 VNB|VSS VDD synth_4692 VNB|VSS
+ sky130_fd_sc_hd__a21oi_1
X$4710 VDD synth_2221 synth_927 synth_2368 VNB|VSS VDD synth_2440 VNB|VSS
+ sky130_fd_sc_hd__a21oi_1
X$4711 VDD synth_9761 synth_9622 synth_9694 VNB|VSS VDD synth_9827 VNB|VSS
+ sky130_fd_sc_hd__a21oi_1
X$4712 VDD synth_5412 synth_3632 synth_5465 VNB|VSS VDD synth_5548 VNB|VSS
+ sky130_fd_sc_hd__a21oi_1
X$4713 VDD synth_229 synth_167 synth_241 VNB|VSS VDD synth_107 VNB|VSS
+ sky130_fd_sc_hd__a21oi_1
X$4714 VDD synth_2556 synth_2621 synth_1081 VNB|VSS VDD synth_2658 VNB|VSS
+ sky130_fd_sc_hd__a21oi_1
X$4715 VDD synth_12070 synth_10164 synth_12037 VNB|VSS VDD synth_12124 VNB|VSS
+ sky130_fd_sc_hd__a21oi_1
X$4716 VDD synth_12038 synth_12039 synth_12073 VNB|VSS VDD synth_12101 VNB|VSS
+ sky130_fd_sc_hd__a21oi_1
X$4717 VDD synth_6664 synth_6598 synth_6476 VNB|VSS VDD synth_6715 VNB|VSS
+ sky130_fd_sc_hd__a21oi_1
X$4718 VDD synth_408 synth_1978 synth_2213 VNB|VSS VDD synth_2147 VNB|VSS
+ sky130_fd_sc_hd__a21oi_1
X$4719 VDD synth_6466 synth_6836 synth_6837 VNB|VSS VDD synth_6915 VNB|VSS
+ sky130_fd_sc_hd__a21oi_1
X$4720 VDD synth_4127 synth_4128 synth_4079 VNB|VSS VDD synth_3953 VNB|VSS
+ sky130_fd_sc_hd__a21oi_1
X$4721 VDD synth_408 synth_1021 synth_1395 VNB|VSS VDD synth_1295 VNB|VSS
+ sky130_fd_sc_hd__a21oi_1
X$4722 VDD synth_474 synth_5318 synth_5259 VNB|VSS VDD synth_5258 VNB|VSS
+ sky130_fd_sc_hd__a21oi_1
X$4723 VDD synth_9629 synth_9615 synth_10653 VNB|VSS VDD synth_10864 VNB|VSS
+ sky130_fd_sc_hd__a21oi_1
X$4724 VDD synth_4755 synth_927 synth_4763 VNB|VSS VDD synth_4764 VNB|VSS
+ sky130_fd_sc_hd__a21oi_1
X$4725 VDD synth_3964 synth_4931 synth_5079 VNB|VSS VDD synth_5080 VNB|VSS
+ sky130_fd_sc_hd__a21oi_1
X$4726 VDD synth_10565 synth_10566 synth_10469 VNB|VSS VDD synth_10622 VNB|VSS
+ sky130_fd_sc_hd__a21oi_1
X$4727 VDD synth_498 synth_553 synth_457 VNB|VSS VDD synth_552 VNB|VSS
+ sky130_fd_sc_hd__a21oi_1
X$4728 VDD synth_1081 synth_1112 synth_1314 VNB|VSS VDD synth_1398 VNB|VSS
+ sky130_fd_sc_hd__a21oi_1
X$4729 VDD synth_4766 synth_927 synth_4851 VNB|VSS VDD synth_4755 VNB|VSS
+ sky130_fd_sc_hd__a21oi_1
X$4730 VDD synth_12094 synth_10793 synth_9895 VNB|VSS VDD synth_12051 VNB|VSS
+ sky130_fd_sc_hd__a21oi_1
X$4731 VDD synth_9691 synth_10632 synth_10979 VNB|VSS VDD synth_10859 VNB|VSS
+ sky130_fd_sc_hd__a21oi_1
X$4732 VDD synth_8850 synth_8674 synth_8230 VNB|VSS VDD synth_8916 VNB|VSS
+ sky130_fd_sc_hd__a21oi_1
X$4733 VDD synth_1081 synth_3970 synth_3969 VNB|VSS VDD synth_4037 VNB|VSS
+ sky130_fd_sc_hd__a21oi_1
X$4734 VDD synth_546 synth_185 synth_493 VNB|VSS VDD synth_547 VNB|VSS
+ sky130_fd_sc_hd__a21oi_1
X$4735 VDD synth_11675 synth_9677 synth_12160 VNB|VSS VDD synth_10410 VNB|VSS
+ sky130_fd_sc_hd__a21oi_1
X$4736 VDD synth_3908 synth_3907 synth_3777 VNB|VSS VDD synth_3906 VNB|VSS
+ sky130_fd_sc_hd__a21oi_1
X$4737 VDD synth_5786 synth_3632 synth_5894 VNB|VSS VDD synth_5811 VNB|VSS
+ sky130_fd_sc_hd__a21oi_1
X$4738 VDD synth_4435 synth_4270 synth_4351 VNB|VSS VDD synth_4491 VNB|VSS
+ sky130_fd_sc_hd__a21oi_1
X$4739 VDD synth_8501 synth_8502 synth_8456 VNB|VSS VDD synth_8459 VNB|VSS
+ sky130_fd_sc_hd__a21oi_1
X$4740 VDD synth_9420 synth_9419 synth_9316 VNB|VSS VDD synth_9506 VNB|VSS
+ sky130_fd_sc_hd__a21oi_1
X$4741 VDD synth_4269 synth_1338 synth_4320 VNB|VSS VDD synth_4267 VNB|VSS
+ sky130_fd_sc_hd__a21oi_1
X$4742 VDD synth_4183 synth_4270 synth_4319 VNB|VSS VDD synth_4350 VNB|VSS
+ sky130_fd_sc_hd__a21oi_1
X$4743 VDD synth_5126 synth_5053 synth_5052 VNB|VSS VDD synth_5186 VNB|VSS
+ sky130_fd_sc_hd__a21oi_1
X$4744 VDD synth_8765 synth_11787 synth_11931 VNB|VSS VDD synth_11890 VNB|VSS
+ sky130_fd_sc_hd__a21oi_1
X$4745 VDD synth_2630 synth_1353 synth_2406 VNB|VSS VDD synth_2706 VNB|VSS
+ sky130_fd_sc_hd__a21oi_1
X$4746 VDD synth_9286 synth_8000 synth_9417 VNB|VSS VDD synth_9415 VNB|VSS
+ sky130_fd_sc_hd__a21oi_1
X$4747 VDD synth_9415 synth_8000 synth_9416 VNB|VSS VDD synth_9556 VNB|VSS
+ sky130_fd_sc_hd__a21oi_1
X$4748 VDD synth_12050 synth_10793 synth_10169 VNB|VSS VDD synth_12049 VNB|VSS
+ sky130_fd_sc_hd__a21oi_1
X$4749 VDD synth_10598 synth_10164 synth_10600 VNB|VSS VDD synth_10675 VNB|VSS
+ sky130_fd_sc_hd__a21oi_1
X$4750 VDD synth_10863 synth_12452 synth_9559 VNB|VSS VDD synth_12411 VNB|VSS
+ sky130_fd_sc_hd__a21oi_1
X$4751 VDD synth_5173 synth_5184 synth_5282 VNB|VSS VDD synth_5281 VNB|VSS
+ sky130_fd_sc_hd__a21oi_1
X$4752 VDD synth_2977 synth_3021 synth_3098 VNB|VSS VDD synth_3019 VNB|VSS
+ sky130_fd_sc_hd__a21oi_1
X$4753 VDD synth_6482 synth_6464 synth_6481 VNB|VSS VDD synth_6569 VNB|VSS
+ sky130_fd_sc_hd__a21oi_1
X$4754 VDD synth_1190 synth_1285 synth_1191 VNB|VSS VDD synth_1319 VNB|VSS
+ sky130_fd_sc_hd__a21oi_1
X$4755 VDD synth_915 synth_151 synth_1047 VNB|VSS VDD synth_993 VNB|VSS
+ sky130_fd_sc_hd__a21oi_1
X$4756 VDD synth_4869 synth_4964 synth_4698 VNB|VSS VDD synth_4848 VNB|VSS
+ sky130_fd_sc_hd__a21oi_1
X$4757 VDD synth_5996 synth_5828 synth_5932 VNB|VSS VDD synth_6178 VNB|VSS
+ sky130_fd_sc_hd__a21oi_1
X$4758 VDD synth_10265 synth_10356 synth_10834 VNB|VSS VDD synth_10629 VNB|VSS
+ sky130_fd_sc_hd__a21oi_1
X$4759 VDD synth_9783 synth_9721 synth_9798 VNB|VSS VDD synth_9799 VNB|VSS
+ sky130_fd_sc_hd__a21oi_1
X$4760 VDD synth_408 synth_1979 synth_1910 VNB|VSS VDD synth_1986 VNB|VSS
+ sky130_fd_sc_hd__a21oi_1
X$4761 VDD synth_2146 synth_1338 synth_2262 VNB|VSS VDD synth_2376 VNB|VSS
+ sky130_fd_sc_hd__a21oi_1
X$4762 VDD synth_3673 synth_1353 synth_3670 VNB|VSS VDD synth_3644 VNB|VSS
+ sky130_fd_sc_hd__a21oi_1
X$4763 VDD synth_1409 synth_151 synth_1366 VNB|VSS VDD synth_1407 VNB|VSS
+ sky130_fd_sc_hd__a21oi_1
X$4764 VDD synth_11450 synth_11449 synth_9691 VNB|VSS VDD synth_11535 VNB|VSS
+ sky130_fd_sc_hd__a21oi_1
X$4765 VDD synth_8193 synth_7089 synth_8149 VNB|VSS VDD synth_8262 VNB|VSS
+ sky130_fd_sc_hd__a21oi_1
X$4766 VDD synth_581 synth_5570 synth_4866 VNB|VSS VDD synth_4944 VNB|VSS
+ sky130_fd_sc_hd__a21oi_1
X$4767 VDD synth_9161 synth_9215 synth_9134 VNB|VSS VDD synth_9296 VNB|VSS
+ sky130_fd_sc_hd__a21oi_1
X$4768 VDD synth_1382 synth_927 synth_1380 VNB|VSS VDD synth_1381 VNB|VSS
+ sky130_fd_sc_hd__a21oi_1
X$4769 VDD synth_11479 synth_11550 synth_11552 VNB|VSS VDD synth_11608 VNB|VSS
+ sky130_fd_sc_hd__a21oi_1
X$4770 VDD synth_6211 synth_7305 synth_7303 VNB|VSS VDD synth_7304 VNB|VSS
+ sky130_fd_sc_hd__a21oi_1
X$4771 VDD synth_4612 synth_3541 synth_4425 VNB|VSS VDD synth_4296 VNB|VSS
+ sky130_fd_sc_hd__a21oi_1
X$4772 VDD synth_3455 synth_1067 synth_3513 VNB|VSS VDD synth_3608 VNB|VSS
+ sky130_fd_sc_hd__a21oi_1
X$4773 VDD synth_10186 synth_9947 synth_10024 VNB|VSS VDD synth_10126 VNB|VSS
+ sky130_fd_sc_hd__a21oi_1
X$4774 VDD synth_10095 synth_9730 synth_10170 VNB|VSS VDD synth_10559 VNB|VSS
+ sky130_fd_sc_hd__a21oi_1
X$4775 VDD synth_11579 synth_11010 synth_11504 VNB|VSS VDD synth_11794 VNB|VSS
+ sky130_fd_sc_hd__a21oi_1
X$4776 VDD synth_3748 synth_3453 synth_3862 VNB|VSS VDD synth_4218 VNB|VSS
+ sky130_fd_sc_hd__a21oi_1
X$4777 VDD synth_2716 synth_2749 synth_850 VNB|VSS VDD synth_2779 VNB|VSS
+ sky130_fd_sc_hd__a21oi_1
X$4778 VDD synth_8798 synth_8000 synth_8799 VNB|VSS VDD synth_8742 VNB|VSS
+ sky130_fd_sc_hd__a21oi_1
X$4779 VDD synth_5062 synth_5013 synth_5063 VNB|VSS VDD synth_5300 VNB|VSS
+ sky130_fd_sc_hd__a21oi_1
X$4780 VDD synth_7435 synth_8939 synth_8938 VNB|VSS VDD synth_9057 VNB|VSS
+ sky130_fd_sc_hd__a21oi_1
X$4781 VDD synth_474 synth_5748 synth_5674 VNB|VSS VDD synth_5673 VNB|VSS
+ sky130_fd_sc_hd__a21oi_1
X$4782 VDD synth_12755 synth_9629 synth_10697 VNB|VSS VDD synth_12702 VNB|VSS
+ sky130_fd_sc_hd__a21oi_1
X$4783 VDD synth_3417 synth_927 synth_3482 VNB|VSS VDD synth_3321 VNB|VSS
+ sky130_fd_sc_hd__a21oi_1
X$4784 VDD synth_12058 synth_11998 synth_11881 VNB|VSS VDD synth_12060 VNB|VSS
+ sky130_fd_sc_hd__a21oi_1
X$4785 VDD synth_1946 synth_2003 synth_2002 VNB|VSS VDD synth_2154 VNB|VSS
+ sky130_fd_sc_hd__a21oi_1
X$4786 VDD synth_4296 synth_3541 synth_4334 VNB|VSS VDD synth_4382 VNB|VSS
+ sky130_fd_sc_hd__a21oi_1
X$4787 VDD synth_12429 synth_9762 synth_12430 VNB|VSS VDD synth_12507 VNB|VSS
+ sky130_fd_sc_hd__a21oi_1
X$4788 VDD synth_12310 synth_12695 synth_12730 VNB|VSS VDD synth_12777 VNB|VSS
+ sky130_fd_sc_hd__a21oi_1
X$4789 VDD synth_1213 synth_1615 synth_2188 VNB|VSS VDD synth_2158 VNB|VSS
+ sky130_fd_sc_hd__a21oi_1
X$4790 VDD synth_12095 synth_9062 synth_12359 VNB|VSS VDD synth_12097 VNB|VSS
+ sky130_fd_sc_hd__a21oi_1
X$4791 VDD synth_1854 synth_1353 synth_1803 VNB|VSS VDD synth_1935 VNB|VSS
+ sky130_fd_sc_hd__a21oi_1
X$4792 VDD synth_2571 synth_2569 synth_1213 VNB|VSS VDD synth_2645 VNB|VSS
+ sky130_fd_sc_hd__a21oi_1
X$4793 VDD synth_12749 synth_12518 synth_12719 VNB|VSS VDD synth_12750 VNB|VSS
+ sky130_fd_sc_hd__a21oi_1
X$4794 VDD synth_8196 synth_11606 synth_10755 VNB|VSS VDD synth_10810 VNB|VSS
+ sky130_fd_sc_hd__a21oi_1
X$4795 VDD synth_8196 synth_8728 synth_10182 VNB|VSS VDD synth_10181 VNB|VSS
+ sky130_fd_sc_hd__a21oi_1
X$4796 VDD synth_399 synth_354 synth_400 VNB|VSS VDD synth_409 VNB|VSS
+ sky130_fd_sc_hd__a21oi_1
X$4797 VDD synth_9387 synth_11465 synth_9044 VNB|VSS VDD synth_11733 VNB|VSS
+ sky130_fd_sc_hd__a21oi_1
X$4798 VDD synth_8806 synth_10486 synth_11388 VNB|VSS VDD synth_11723 VNB|VSS
+ sky130_fd_sc_hd__a21oi_1
X$4799 VDD synth_12645 synth_9423 synth_12705 VNB|VSS VDD synth_12779 VNB|VSS
+ sky130_fd_sc_hd__a21oi_1
X$4800 VDD synth_1081 synth_3041 synth_3276 VNB|VSS VDD synth_3341 VNB|VSS
+ sky130_fd_sc_hd__a21oi_1
X$4801 VDD synth_2847 synth_2116 synth_3306 VNB|VSS VDD synth_3387 VNB|VSS
+ sky130_fd_sc_hd__a21oi_1
X$4802 VDD synth_9677 synth_9474 synth_9559 VNB|VSS VDD synth_12168 VNB|VSS
+ sky130_fd_sc_hd__a21oi_1
X$4803 VDD synth_10339 synth_10356 synth_10337 VNB|VSS VDD synth_10302 VNB|VSS
+ sky130_fd_sc_hd__a21oi_1
X$4804 VDD synth_6477 synth_6464 synth_6479 VNB|VSS VDD synth_6566 VNB|VSS
+ sky130_fd_sc_hd__a21oi_1
X$4805 VDD synth_10290 synth_9232 synth_9324 VNB|VSS VDD synth_11589 VNB|VSS
+ sky130_fd_sc_hd__a21oi_1
X$4806 VDD synth_10212 synth_10943 synth_10142 VNB|VSS VDD synth_11064 VNB|VSS
+ sky130_fd_sc_hd__a21oi_1
X$4807 VDD synth_11392 synth_11827 synth_11769 VNB|VSS VDD synth_11884 VNB|VSS
+ sky130_fd_sc_hd__a21oi_1
X$4808 VDD synth_6478 synth_6428 synth_6397 VNB|VSS VDD synth_6568 VNB|VSS
+ sky130_fd_sc_hd__a21oi_1
X$4809 VDD synth_11128 synth_9387 synth_11096 VNB|VSS VDD synth_11223 VNB|VSS
+ sky130_fd_sc_hd__a21oi_1
X$4810 VDD synth_3536 synth_3468 synth_3534 VNB|VSS VDD synth_3600 VNB|VSS
+ sky130_fd_sc_hd__a21oi_1
X$4811 VDD synth_12498 synth_9423 synth_12586 VNB|VSS VDD synth_12645 VNB|VSS
+ sky130_fd_sc_hd__a21oi_1
X$4812 VDD synth_3339 synth_1067 synth_3431 VNB|VSS VDD synth_3340 VNB|VSS
+ sky130_fd_sc_hd__a21oi_1
X$4813 VDD synth_4162 synth_2116 synth_4102 VNB|VSS VDD synth_4444 VNB|VSS
+ sky130_fd_sc_hd__a21oi_1
X$4814 VDD synth_12557 synth_10578 synth_12596 VNB|VSS VDD synth_12558 VNB|VSS
+ sky130_fd_sc_hd__a21oi_1
X$4815 VDD synth_8765 synth_9737 synth_9830 VNB|VSS VDD synth_9892 VNB|VSS
+ sky130_fd_sc_hd__a21oi_1
X$4816 VDD synth_10129 synth_10127 synth_9297 VNB|VSS VDD synth_10199 VNB|VSS
+ sky130_fd_sc_hd__a21oi_1
X$4817 VDD synth_8262 synth_7089 synth_8112 VNB|VSS VDD synth_8113 VNB|VSS
+ sky130_fd_sc_hd__a21oi_1
X$4818 VDD synth_12324 synth_12293 synth_12292 VNB|VSS VDD synth_12373 VNB|VSS
+ sky130_fd_sc_hd__a21oi_1
X$4819 VDD synth_8765 synth_11873 synth_11819 VNB|VSS VDD synth_11964 VNB|VSS
+ sky130_fd_sc_hd__a21oi_1
X$4820 VDD synth_8222 synth_7111 synth_8169 VNB|VSS VDD synth_8302 VNB|VSS
+ sky130_fd_sc_hd__a21oi_1
X$4821 VDD synth_3964 synth_5679 synth_5721 VNB|VSS VDD synth_5677 VNB|VSS
+ sky130_fd_sc_hd__a21oi_1
X$4822 VDD synth_10156 synth_9978 synth_10152 VNB|VSS VDD synth_10442 VNB|VSS
+ sky130_fd_sc_hd__a21oi_1
X$4823 VDD synth_7435 synth_6673 synth_8920 VNB|VSS VDD synth_8988 VNB|VSS
+ sky130_fd_sc_hd__a21oi_1
X$4824 VDD synth_3085 synth_3033 synth_3034 VNB|VSS VDD synth_3153 VNB|VSS
+ sky130_fd_sc_hd__a21oi_1
X$4825 VDD synth_5409 synth_3632 synth_5330 VNB|VSS VDD synth_5412 VNB|VSS
+ sky130_fd_sc_hd__a21oi_1
X$4826 VDD synth_7406 synth_6597 synth_7407 VNB|VSS VDD synth_7555 VNB|VSS
+ sky130_fd_sc_hd__a21oi_1
X$4827 VDD synth_346 synth_1442 synth_1688 VNB|VSS VDD synth_1689 VNB|VSS
+ sky130_fd_sc_hd__a21oi_1
X$4828 VDD synth_1220 synth_1278 synth_1279 synth_1517 VDD VNB|VSS synth_1572
+ VNB|VSS sky130_fd_sc_hd__o31ai_1
X$4829 VDD synth_1856 synth_1805 synth_1806 VNB|VSS VDD synth_1855 VNB|VSS
+ sky130_fd_sc_hd__a21oi_1
X$4830 VDD synth_7259 synth_7312 synth_7371 VNB|VSS VDD synth_7330 VNB|VSS
+ sky130_fd_sc_hd__a21oi_1
X$4831 VDD synth_9926 synth_9387 synth_10099 VNB|VSS VDD synth_12026 VNB|VSS
+ sky130_fd_sc_hd__a21oi_1
X$4832 VDD synth_7464 synth_7312 synth_7368 VNB|VSS VDD synth_7558 VNB|VSS
+ sky130_fd_sc_hd__a21oi_1
X$4833 VDD synth_10856 synth_10785 synth_10825 VNB|VSS VDD synth_10855 VNB|VSS
+ sky130_fd_sc_hd__a21oi_1
X$4834 VDD synth_5410 synth_5331 synth_5411 VNB|VSS VDD synth_5547 VNB|VSS
+ sky130_fd_sc_hd__a21oi_1
X$4835 VDD synth_3680 synth_1067 synth_3681 VNB|VSS VDD synth_3730 VNB|VSS
+ sky130_fd_sc_hd__a21oi_1
X$4836 VDD synth_2978 synth_3021 synth_3099 VNB|VSS VDD synth_3052 VNB|VSS
+ sky130_fd_sc_hd__a21oi_1
X$4837 VDD synth_3209 synth_2834 synth_1081 VNB|VSS VDD synth_3001 VNB|VSS
+ sky130_fd_sc_hd__a21oi_1
X$4838 VDD synth_2891 synth_2851 synth_2820 VNB|VSS VDD synth_2743 VNB|VSS
+ sky130_fd_sc_hd__a21oi_1
X$4839 VDD synth_1081 synth_3118 synth_4232 VNB|VSS VDD synth_4110 VNB|VSS
+ sky130_fd_sc_hd__a21oi_1
X$4840 VDD synth_4637 synth_4665 synth_4814 VNB|VSS VDD synth_4666 VNB|VSS
+ sky130_fd_sc_hd__a21oi_1
X$4841 VDD synth_3964 synth_5076 synth_5215 VNB|VSS VDD synth_5081 VNB|VSS
+ sky130_fd_sc_hd__a21oi_1
X$4842 VDD synth_8151 synth_8152 synth_8271 VNB|VSS VDD synth_8343 VNB|VSS
+ sky130_fd_sc_hd__a21oi_1
X$4843 VDD synth_393 synth_142 synth_490 VNB|VSS VDD synth_343 VNB|VSS
+ sky130_fd_sc_hd__a21oi_1
X$4844 VDD synth_9159 synth_8000 synth_8942 VNB|VSS VDD synth_8940 VNB|VSS
+ sky130_fd_sc_hd__a21oi_1
X$4845 VDD synth_1213 synth_2723 synth_2576 VNB|VSS VDD synth_2771 VNB|VSS
+ sky130_fd_sc_hd__a21oi_1
X$4846 VDD synth_4085 synth_4086 synth_4144 VNB|VSS VDD synth_4146 VNB|VSS
+ sky130_fd_sc_hd__a21oi_1
X$4847 VDD synth_12069 synth_12061 synth_12062 VNB|VSS VDD synth_12117 VNB|VSS
+ sky130_fd_sc_hd__a21oi_1
X$4848 VDD synth_141 synth_142 synth_259 VNB|VSS VDD synth_215 VNB|VSS
+ sky130_fd_sc_hd__a21oi_1
X$4849 VDD synth_8940 synth_8000 synth_8941 VNB|VSS VDD synth_9059 VNB|VSS
+ sky130_fd_sc_hd__a21oi_1
X$4850 VDD synth_12069 synth_12061 synth_12059 VNB|VSS VDD synth_12118 VNB|VSS
+ sky130_fd_sc_hd__a21oi_1
X$4851 VDD synth_8052 synth_7111 synth_8009 VNB|VSS VDD synth_8143 VNB|VSS
+ sky130_fd_sc_hd__a21oi_1
X$4852 VDD synth_9629 synth_9239 synth_10101 VNB|VSS VDD synth_11539 VNB|VSS
+ sky130_fd_sc_hd__a21oi_1
X$4853 VDD synth_3483 synth_3258 synth_3488 VNB|VSS VDD synth_3578 VNB|VSS
+ sky130_fd_sc_hd__a21oi_1
X$4854 VDD synth_9049 synth_11922 synth_11663 VNB|VSS VDD synth_11713 VNB|VSS
+ sky130_fd_sc_hd__a21oi_1
X$4855 VDD synth_6723 synth_6647 synth_6947 VNB|VSS VDD synth_6515 VNB|VSS
+ sky130_fd_sc_hd__a21oi_1
X$4856 VDD synth_4126 synth_927 synth_4294 VNB|VSS VDD synth_4379 VNB|VSS
+ sky130_fd_sc_hd__a21oi_1
X$4857 VDD synth_10000 synth_9999 synth_10215 VNB|VSS VDD synth_10155 VNB|VSS
+ sky130_fd_sc_hd__a21oi_1
X$4858 VDD synth_8062 synth_8000 synth_7980 VNB|VSS VDD synth_8227 VNB|VSS
+ sky130_fd_sc_hd__a21oi_1
X$4859 VDD synth_8060 synth_7930 synth_8003 VNB|VSS VDD synth_8301 VNB|VSS
+ sky130_fd_sc_hd__a21oi_1
X$4860 VDD synth_7995 synth_7894 synth_8136 VNB|VSS VDD synth_7823 VNB|VSS
+ sky130_fd_sc_hd__a21oi_1
X$4861 VDD synth_581 synth_4129 synth_4115 VNB|VSS VDD synth_3986 VNB|VSS
+ sky130_fd_sc_hd__a21oi_1
X$4862 VDD synth_6925 synth_4961 synth_7121 VNB|VSS VDD synth_7226 VNB|VSS
+ sky130_fd_sc_hd__a21oi_1
X$4863 VDD synth_11402 synth_11408 synth_11337 VNB|VSS VDD synth_11481 VNB|VSS
+ sky130_fd_sc_hd__a21oi_1
X$4864 VDD synth_3964 synth_6717 synth_6688 VNB|VSS VDD synth_6768 VNB|VSS
+ sky130_fd_sc_hd__a21oi_1
X$4865 VDD synth_3964 synth_6556 synth_6870 VNB|VSS VDD synth_6871 VNB|VSS
+ sky130_fd_sc_hd__a21oi_1
X$4866 VDD synth_2051 synth_1789 synth_1963 VNB|VSS VDD synth_2100 VNB|VSS
+ sky130_fd_sc_hd__a21oi_1
X$4867 VDD synth_10652 synth_9559 synth_9061 VNB|VSS VDD synth_11513 VNB|VSS
+ sky130_fd_sc_hd__a21oi_1
X$4868 VDD synth_7760 synth_7662 synth_7737 VNB|VSS VDD synth_7791 VNB|VSS
+ sky130_fd_sc_hd__a21oi_1
X$4869 VDD synth_9091 synth_9125 synth_9069 VNB|VSS VDD synth_9335 VNB|VSS
+ sky130_fd_sc_hd__a21oi_1
X$4870 VDD synth_2171 synth_2196 synth_2254 VNB|VSS VDD synth_2047 VNB|VSS
+ sky130_fd_sc_hd__a21oi_1
X$4871 VDD synth_8437 synth_8519 synth_8382 VNB|VSS VDD synth_8607 VNB|VSS
+ sky130_fd_sc_hd__a21oi_1
X$4872 VDD synth_3964 synth_6613 synth_6687 VNB|VSS VDD synth_6610 VNB|VSS
+ sky130_fd_sc_hd__a21oi_1
X$4873 VDD synth_9177 synth_9233 synth_9696 VNB|VSS VDD synth_11872 VNB|VSS
+ sky130_fd_sc_hd__a21oi_1
X$4874 VDD synth_8513 synth_8603 synth_8601 VNB|VSS VDD synth_8512 VNB|VSS
+ sky130_fd_sc_hd__a21oi_1
X$4875 VDD synth_12310 synth_12751 synth_12729 VNB|VSS VDD synth_12780 VNB|VSS
+ sky130_fd_sc_hd__a21oi_1
X$4876 VDD synth_6469 synth_7429 synth_7428 VNB|VSS VDD synth_7426 VNB|VSS
+ sky130_fd_sc_hd__a21oi_1
X$4877 VDD synth_407 synth_167 synth_402 VNB|VSS VDD synth_229 VNB|VSS
+ sky130_fd_sc_hd__a21oi_1
X$4878 VDD synth_923 synth_167 synth_924 VNB|VSS VDD synth_1005 VNB|VSS
+ sky130_fd_sc_hd__a21oi_1
X$4879 VDD synth_1320 synth_194 synth_1346 VNB|VSS VDD synth_1479 VNB|VSS
+ sky130_fd_sc_hd__a21oi_1
X$4880 VDD synth_12081 synth_11988 synth_12082 VNB|VSS VDD synth_12138 VNB|VSS
+ sky130_fd_sc_hd__a21oi_1
X$4881 VDD synth_7970 synth_7111 synth_7735 VNB|VSS VDD synth_7843 VNB|VSS
+ sky130_fd_sc_hd__a21oi_1
X$4882 VDD synth_11133 synth_11162 synth_11134 VNB|VSS VDD synth_11136 VNB|VSS
+ sky130_fd_sc_hd__a21oi_1
X$4883 VDD synth_12053 synth_9629 synth_11017 VNB|VSS VDD synth_12108 VNB|VSS
+ sky130_fd_sc_hd__a21oi_1
X$4884 VDD synth_536 synth_231 synth_467 VNB|VSS VDD synth_637 VNB|VSS
+ sky130_fd_sc_hd__a21oi_1
X$4885 VDD synth_2991 synth_3063 synth_3062 VNB|VSS VDD synth_3126 VNB|VSS
+ sky130_fd_sc_hd__a21oi_1
X$4886 VDD synth_4307 synth_167 synth_4221 VNB|VSS VDD synth_4289 VNB|VSS
+ sky130_fd_sc_hd__a21oi_1
X$4887 VDD synth_4289 synth_167 synth_4404 VNB|VSS VDD synth_4306 VNB|VSS
+ sky130_fd_sc_hd__a21oi_1
X$4888 VDD synth_7435 synth_8242 synth_8363 VNB|VSS VDD synth_8525 VNB|VSS
+ sky130_fd_sc_hd__a21oi_1
X$4889 VDD synth_8033 synth_7422 synth_8022 VNB|VSS VDD synth_8124 VNB|VSS
+ sky130_fd_sc_hd__a21oi_1
X$4890 VDD synth_8230 synth_9806 synth_9756 VNB|VSS VDD synth_9720 VNB|VSS
+ sky130_fd_sc_hd__a21oi_1
X$4891 VDD synth_1081 synth_3469 synth_3596 VNB|VSS VDD synth_3470 VNB|VSS
+ sky130_fd_sc_hd__a21oi_1
X$4892 VDD synth_10764 synth_10766 synth_10719 VNB|VSS VDD synth_10763 VNB|VSS
+ sky130_fd_sc_hd__a21oi_1
X$4893 VDD synth_5633 synth_5551 synth_5698 VNB|VSS VDD synth_5661 VNB|VSS
+ sky130_fd_sc_hd__a21oi_1
X$4894 VDD synth_1386 synth_927 synth_1300 VNB|VSS VDD synth_1462 VNB|VSS
+ sky130_fd_sc_hd__a21oi_1
X$4895 VDD synth_10513 synth_8806 synth_11216 VNB|VSS VDD synth_11217 VNB|VSS
+ sky130_fd_sc_hd__a21oi_1
X$4896 VDD synth_2775 synth_2776 synth_2867 VNB|VSS VDD synth_2728 VNB|VSS
+ sky130_fd_sc_hd__a21oi_1
X$4897 VDD synth_5041 synth_3632 synth_4972 VNB|VSS VDD synth_4975 VNB|VSS
+ sky130_fd_sc_hd__a21oi_1
X$4898 VDD synth_3527 synth_4261 synth_4260 VNB|VSS VDD synth_4259 VNB|VSS
+ sky130_fd_sc_hd__a21oi_1
X$4899 VDD synth_7435 synth_7488 synth_8527 VNB|VSS VDD synth_8317 VNB|VSS
+ sky130_fd_sc_hd__a21oi_1
X$4900 VDD synth_3964 synth_6248 synth_6513 VNB|VSS VDD synth_6639 VNB|VSS
+ sky130_fd_sc_hd__a21oi_1
X$4901 VDD synth_850 synth_4399 synth_4342 VNB|VSS VDD synth_4304 VNB|VSS
+ sky130_fd_sc_hd__a21oi_1
X$4902 VDD synth_919 synth_918 synth_953 VNB|VSS VDD synth_1001 VNB|VSS
+ sky130_fd_sc_hd__a21oi_1
X$4903 VDD synth_12336 synth_9423 synth_12517 VNB|VSS VDD synth_12581 VNB|VSS
+ sky130_fd_sc_hd__a21oi_1
X$4904 VDD synth_1668 synth_659 synth_1762 VNB|VSS VDD synth_1837 VNB|VSS
+ sky130_fd_sc_hd__a21oi_1
X$4905 VDD synth_955 synth_918 synth_920 VNB|VSS VDD synth_954 VNB|VSS
+ sky130_fd_sc_hd__a21oi_1
X$4906 VDD synth_11630 synth_8950 synth_11786 VNB|VSS VDD synth_11819 VNB|VSS
+ sky130_fd_sc_hd__a21oi_1
X$4907 VDD synth_1742 synth_66 synth_1915 VNB|VSS VDD synth_1767 VNB|VSS
+ sky130_fd_sc_hd__a21oi_1
X$4908 VDD synth_1081 synth_2280 synth_3592 VNB|VSS VDD synth_3520 VNB|VSS
+ sky130_fd_sc_hd__a21oi_1
X$4909 VDD synth_10312 synth_8803 synth_9474 VNB|VSS VDD synth_12525 VNB|VSS
+ sky130_fd_sc_hd__a21oi_1
X$4910 VDD synth_11940 synth_12184 synth_12247 VNB|VSS VDD synth_12253 VNB|VSS
+ sky130_fd_sc_hd__a21oi_1
X$4911 VDD synth_10584 synth_10606 synth_10659 VNB|VSS VDD synth_10657 VNB|VSS
+ sky130_fd_sc_hd__a21oi_1
X$4912 VDD synth_10891 synth_10925 synth_10970 VNB|VSS VDD synth_10813 VNB|VSS
+ sky130_fd_sc_hd__a21oi_1
X$4913 VDD synth_256 synth_151 synth_218 VNB|VSS VDD synth_148 VNB|VSS
+ sky130_fd_sc_hd__a21oi_1
X$4914 VDD synth_7294 synth_7119 synth_7353 VNB|VSS VDD synth_7448 VNB|VSS
+ sky130_fd_sc_hd__a21oi_1
X$4915 VDD synth_7435 synth_7652 synth_8316 VNB|VSS VDD synth_8360 VNB|VSS
+ sky130_fd_sc_hd__a21oi_1
X$4916 VDD synth_471 synth_194 synth_245 VNB|VSS VDD synth_120 VNB|VSS
+ sky130_fd_sc_hd__a21oi_1
X$4917 VDD synth_474 synth_712 synth_1719 VNB|VSS VDD synth_1636 VNB|VSS
+ sky130_fd_sc_hd__a21oi_1
X$4918 VDD synth_9923 synth_10285 synth_9696 VNB|VSS VDD synth_10509 VNB|VSS
+ sky130_fd_sc_hd__a21oi_1
X$4919 VDD synth_10017 synth_10016 synth_9885 VNB|VSS VDD synth_10036 VNB|VSS
+ sky130_fd_sc_hd__a21oi_1
X$4920 VDD synth_692 synth_659 synth_604 VNB|VSS VDD synth_844 VNB|VSS
+ sky130_fd_sc_hd__a21oi_1
X$4921 VDD synth_474 synth_5988 synth_6047 VNB|VSS VDD synth_6048 VNB|VSS
+ sky130_fd_sc_hd__a21oi_1
X$4922 VDD synth_9255 synth_9181 synth_9355 VNB|VSS VDD synth_9180 VNB|VSS
+ sky130_fd_sc_hd__a21oi_1
X$4923 VDD synth_1213 synth_336 synth_1710 VNB|VSS VDD synth_1709 VNB|VSS
+ sky130_fd_sc_hd__a21oi_1
X$4924 VDD synth_12450 synth_10312 synth_12446 VNB|VSS VDD synth_12491 VNB|VSS
+ sky130_fd_sc_hd__a21oi_1
X$4925 VDD synth_852 synth_775 synth_474 VNB|VSS VDD synth_857 VNB|VSS
+ sky130_fd_sc_hd__a21oi_1
X$4926 VDD synth_8196 synth_9250 synth_10333 VNB|VSS VDD synth_10240 VNB|VSS
+ sky130_fd_sc_hd__a21oi_1
X$4927 VDD synth_9232 synth_9233 synth_10483 VNB|VSS VDD synth_11460 VNB|VSS
+ sky130_fd_sc_hd__a21oi_1
X$4928 VDD synth_10312 synth_10212 synth_9240 VNB|VSS VDD synth_11170 VNB|VSS
+ sky130_fd_sc_hd__a21oi_1
X$4929 VDD synth_8040 synth_8038 synth_7435 VNB|VSS VDD synth_8130 VNB|VSS
+ sky130_fd_sc_hd__a21oi_1
X$4930 VDD synth_7300 synth_7301 synth_5286 VNB|VSS VDD synth_7377 VNB|VSS
+ sky130_fd_sc_hd__a21oi_1
X$4931 VDD synth_11170 synth_8806 synth_9483 VNB|VSS VDD synth_11171 VNB|VSS
+ sky130_fd_sc_hd__a21oi_1
X$4932 VDD synth_850 synth_3814 synth_3954 VNB|VSS VDD synth_3857 VNB|VSS
+ sky130_fd_sc_hd__a21oi_1
X$4933 VDD synth_4397 synth_3563 synth_3732 VNB|VSS VDD synth_4562 VNB|VSS
+ sky130_fd_sc_hd__a21oi_1
X$4934 VDD synth_8230 synth_9808 synth_9688 VNB|VSS VDD synth_9807 VNB|VSS
+ sky130_fd_sc_hd__a21oi_1
X$4935 VDD synth_1035 synth_66 synth_1000 VNB|VSS VDD synth_999 VNB|VSS
+ sky130_fd_sc_hd__a21oi_1
X$4936 VDD synth_12175 synth_12207 synth_12176 VNB|VSS VDD synth_12308 VNB|VSS
+ sky130_fd_sc_hd__a21oi_1
X$4937 VDD synth_9112 synth_9427 synth_9233 VNB|VSS VDD synth_9854 VNB|VSS
+ sky130_fd_sc_hd__a21oi_1
X$4938 VDD synth_771 synth_553 synth_732 VNB|VSS VDD synth_933 VNB|VSS
+ sky130_fd_sc_hd__a21oi_1
X$4939 VDD synth_474 synth_813 synth_1634 VNB|VSS VDD synth_1779 VNB|VSS
+ sky130_fd_sc_hd__a21oi_1
X$4940 VDD synth_9672 synth_9984 synth_9908 VNB|VSS VDD synth_10156 VNB|VSS
+ sky130_fd_sc_hd__a21oi_1
X$4941 VDD synth_9019 synth_9947 synth_10028 VNB|VSS VDD synth_10029 VNB|VSS
+ sky130_fd_sc_hd__a21oi_1
X$4942 VDD synth_481 synth_66 synth_317 VNB|VSS VDD synth_371 VNB|VSS
+ sky130_fd_sc_hd__a21oi_1
X$4943 VDD synth_8990 synth_11581 synth_11582 VNB|VSS VDD synth_11645 VNB|VSS
+ sky130_fd_sc_hd__a21oi_1
X$4944 VDD synth_463 synth_167 synth_305 VNB|VSS VDD synth_403 VNB|VSS
+ sky130_fd_sc_hd__a21oi_1
X$4945 VDD synth_469 synth_194 synth_136 VNB|VSS VDD synth_118 VNB|VSS
+ sky130_fd_sc_hd__a21oi_1
X$4946 VDD synth_1673 synth_66 synth_1821 VNB|VSS VDD synth_1742 VNB|VSS
+ sky130_fd_sc_hd__a21oi_1
X$4947 VDD synth_1362 synth_1360 synth_1440 VNB|VSS VDD synth_1277 VNB|VSS
+ sky130_fd_sc_hd__a21oi_1
X$4948 VDD synth_418 synth_194 synth_211 VNB|VSS VDD synth_139 VNB|VSS
+ sky130_fd_sc_hd__a21oi_1
X$4949 VDD synth_62 synth_193 synth_211 VNB|VSS VDD VNB|VSS
+ sky130_fd_sc_hd__nand2b_1
X$4950 VDD synth_3527 synth_4796 synth_4798 VNB|VSS VDD synth_4730 VNB|VSS
+ sky130_fd_sc_hd__a21oi_1
X$4951 VDD synth_6788 synth_6789 synth_6767 VNB|VSS VDD synth_6892 VNB|VSS
+ sky130_fd_sc_hd__a21oi_1
X$4952 VDD synth_1081 synth_2951 synth_3436 VNB|VSS VDD synth_3437 VNB|VSS
+ sky130_fd_sc_hd__a21oi_1
X$4953 VDD synth_538 synth_178 synth_504 VNB|VSS VDD synth_607 VNB|VSS
+ sky130_fd_sc_hd__a21oi_1
X$4954 VDD synth_11207 synth_11126 synth_11204 VNB|VSS VDD synth_11305 VNB|VSS
+ sky130_fd_sc_hd__a21oi_1
X$4955 VDD synth_9474 synth_9322 synth_9581 VNB|VSS VDD synth_9668 VNB|VSS
+ sky130_fd_sc_hd__a21oi_1
X$4956 VDD synth_850 synth_3584 synth_3620 VNB|VSS VDD synth_3660 VNB|VSS
+ sky130_fd_sc_hd__a21oi_1
X$4957 VDD synth_5581 synth_5484 synth_5286 VNB|VSS VDD synth_5636 VNB|VSS
+ sky130_fd_sc_hd__a21oi_1
X$4958 VDD synth_850 synth_2466 synth_3264 VNB|VSS VDD synth_3201 VNB|VSS
+ sky130_fd_sc_hd__a21oi_1
X$4959 VDD synth_9427 synth_9900 synth_12467 VNB|VSS VDD synth_12217 VNB|VSS
+ sky130_fd_sc_hd__a21oi_1
X$4960 VDD synth_5286 synth_5100 synth_5942 VNB|VSS VDD synth_6025 VNB|VSS
+ sky130_fd_sc_hd__a21oi_1
X$4961 VDD synth_3964 synth_4194 synth_4367 VNB|VSS VDD synth_4366 VNB|VSS
+ sky130_fd_sc_hd__a21oi_1
X$4962 VDD synth_3531 synth_3447 synth_1081 VNB|VSS VDD synth_3561 VNB|VSS
+ sky130_fd_sc_hd__a21oi_1
X$4963 VDD synth_11540 synth_10652 synth_10344 VNB|VSS VDD synth_11599 VNB|VSS
+ sky130_fd_sc_hd__a21oi_1
X$4964 VDD synth_581 synth_4613 synth_4682 VNB|VSS VDD synth_4614 VNB|VSS
+ sky130_fd_sc_hd__a21oi_1
X$4965 VDD synth_9691 synth_10858 synth_10934 VNB|VSS VDD synth_11055 VNB|VSS
+ sky130_fd_sc_hd__a21oi_1
X$4966 VDD synth_346 synth_280 synth_1814 VNB|VSS VDD synth_1864 VNB|VSS
+ sky130_fd_sc_hd__a21oi_1
X$4967 VDD synth_1081 synth_2802 synth_3398 VNB|VSS VDD synth_3530 VNB|VSS
+ sky130_fd_sc_hd__a21oi_1
X$4968 VDD synth_5286 synth_5968 synth_5971 VNB|VSS VDD synth_6107 VNB|VSS
+ sky130_fd_sc_hd__a21oi_1
X$4969 VDD synth_10779 synth_9112 synth_11599 VNB|VSS VDD synth_11630 VNB|VSS
+ sky130_fd_sc_hd__a21oi_1
X$4970 VDD synth_3964 synth_5910 synth_5772 VNB|VSS VDD synth_5822 VNB|VSS
+ sky130_fd_sc_hd__a21oi_1
X$4971 VDD synth_5491 synth_5405 synth_5643 VNB|VSS VDD synth_5534 VNB|VSS
+ sky130_fd_sc_hd__a21oi_1
X$4972 VDD synth_8635 synth_8634 synth_8711 VNB|VSS VDD synth_8673 VNB|VSS
+ sky130_fd_sc_hd__a21oi_1
X$4973 VDD synth_491 synth_222 synth_398 VNB|VSS VDD synth_492 VNB|VSS
+ sky130_fd_sc_hd__a21oi_1
X$4974 VDD synth_148 synth_151 synth_152 VNB|VSS VDD synth_119 VNB|VSS
+ sky130_fd_sc_hd__a21oi_1
X$4975 VDD synth_9019 synth_10028 synth_10122 VNB|VSS VDD synth_10108 VNB|VSS
+ sky130_fd_sc_hd__a21oi_1
X$4976 VDD synth_4694 synth_3544 synth_4775 VNB|VSS VDD synth_4865 VNB|VSS
+ sky130_fd_sc_hd__a21oi_1
X$4977 VDD synth_3345 synth_3460 synth_3734 VNB|VSS VDD synth_3695 VNB|VSS
+ sky130_fd_sc_hd__a21oi_1
X$4978 VDD synth_1851 synth_66 synth_1781 VNB|VSS VDD synth_1922 VNB|VSS
+ sky130_fd_sc_hd__a21oi_1
X$4979 VDD synth_10674 synth_10164 synth_10750 VNB|VSS VDD synth_10598 VNB|VSS
+ sky130_fd_sc_hd__a21oi_1
X$4980 VDD synth_9585 synth_9042 synth_10373 VNB|VSS VDD synth_9519 VNB|VSS
+ sky130_fd_sc_hd__a21oi_1
X$4981 VDD synth_1212 synth_1370 synth_1371 VNB|VSS VDD synth_1448 VNB|VSS
+ sky130_fd_sc_hd__a21oi_1
X$4982 VDD synth_10536 synth_10164 synth_10854 VNB|VSS VDD synth_10853 VNB|VSS
+ sky130_fd_sc_hd__a21oi_1
X$4983 VDD synth_11940 synth_12187 synth_12186 VNB|VSS VDD synth_12249 VNB|VSS
+ sky130_fd_sc_hd__a21oi_1
X$4984 VDD synth_9863 synth_9862 synth_9961 VNB|VSS VDD synth_9938 VNB|VSS
+ sky130_fd_sc_hd__a21oi_1
X$4985 VDD synth_11559 synth_11525 synth_9297 VNB|VSS VDD synth_11586 VNB|VSS
+ sky130_fd_sc_hd__a21oi_1
X$4986 VDD synth_9399 synth_9400 synth_9401 VNB|VSS VDD synth_9600 VNB|VSS
+ sky130_fd_sc_hd__a21oi_1
X$4987 VDD synth_1763 synth_1627 synth_1701 VNB|VSS VDD synth_1764 VNB|VSS
+ sky130_fd_sc_hd__a21oi_1
X$4988 VDD synth_11123 synth_11126 synth_11125 VNB|VSS VDD synth_11124 VNB|VSS
+ sky130_fd_sc_hd__a21oi_1
X$4989 VDD synth_12149 synth_12167 synth_9049 VNB|VSS VDD synth_12230 VNB|VSS
+ sky130_fd_sc_hd__a21oi_1
X$4990 VDD synth_10811 synth_10164 synth_10850 VNB|VSS VDD synth_10965 VNB|VSS
+ sky130_fd_sc_hd__a21oi_1
X$4991 VDD synth_850 synth_2937 synth_3265 VNB|VSS VDD synth_3225 VNB|VSS
+ sky130_fd_sc_hd__a21oi_1
X$4992 VDD synth_4551 synth_3544 synth_4695 VNB|VSS VDD synth_4694 VNB|VSS
+ sky130_fd_sc_hd__a21oi_1
X$4993 VDD synth_12164 synth_12040 synth_9691 VNB|VSS VDD synth_12264 VNB|VSS
+ sky130_fd_sc_hd__a21oi_1
X$4994 VDD synth_8196 synth_10872 synth_10884 VNB|VSS VDD synth_10950 VNB|VSS
+ sky130_fd_sc_hd__a21oi_1
X$4995 VDD synth_10726 synth_10697 synth_10441 VNB|VSS VDD synth_10730 VNB|VSS
+ sky130_fd_sc_hd__a21oi_1
X$4996 VDD synth_6763 synth_4961 synth_6905 VNB|VSS VDD synth_7045 VNB|VSS
+ sky130_fd_sc_hd__a21oi_1
X$4997 VDD synth_9348 synth_8746 synth_9397 VNB|VSS VDD synth_9487 VNB|VSS
+ sky130_fd_sc_hd__a21oi_1
X$4998 VDD synth_12581 synth_9423 synth_12516 VNB|VSS VDD synth_12637 VNB|VSS
+ sky130_fd_sc_hd__a21oi_1
X$4999 VDD synth_3366 synth_3496 synth_3292 VNB|VSS VDD synth_3549 VNB|VSS
+ sky130_fd_sc_hd__a21oi_1
X$5000 VDD synth_4597 synth_6227 synth_4673 VNB|VSS VDD synth_6418 VNB|VSS
+ sky130_fd_sc_hd__a21oi_1
X$5001 VDD synth_6527 synth_6675 synth_6448 VNB|VSS VDD synth_6588 VNB|VSS
+ sky130_fd_sc_hd__a21oi_1
X$5002 VDD synth_9691 synth_11768 synth_11564 VNB|VSS VDD synth_11659 VNB|VSS
+ sky130_fd_sc_hd__a21oi_1
X$5003 VDD synth_7045 synth_4961 synth_7054 VNB|VSS VDD synth_7055 VNB|VSS
+ sky130_fd_sc_hd__a21oi_1
X$5004 VDD synth_6202 synth_6203 synth_474 VNB|VSS VDD synth_6421 VNB|VSS
+ sky130_fd_sc_hd__a21oi_1
X$5005 VDD synth_346 synth_279 synth_1937 VNB|VSS VDD synth_1734 VNB|VSS
+ sky130_fd_sc_hd__a21oi_1
X$5006 VDD synth_5797 synth_5798 synth_5799 VNB|VSS VDD synth_5194 VNB|VSS
+ sky130_fd_sc_hd__a21oi_1
X$5007 VDD synth_9629 synth_10728 synth_9470 VNB|VSS VDD synth_12053 VNB|VSS
+ sky130_fd_sc_hd__a21oi_1
X$5008 VDD synth_137 synth_246 synth_206 VNB|VSS VDD synth_205 VNB|VSS
+ sky130_fd_sc_hd__a21oi_1
X$5009 VDD synth_6035 synth_5992 synth_6159 VNB|VSS VDD synth_6036 VNB|VSS
+ sky130_fd_sc_hd__a21oi_1
X$5010 VDD synth_346 synth_345 synth_1572 VNB|VSS VDD synth_1571 VNB|VSS
+ sky130_fd_sc_hd__a21oi_1
X$5011 VDD synth_1737 synth_1860 synth_1857 VNB|VSS VDD synth_1933 VNB|VSS
+ sky130_fd_sc_hd__a21oi_1
X$5012 VDD synth_10864 synth_9629 synth_10489 VNB|VSS VDD synth_11637 VNB|VSS
+ sky130_fd_sc_hd__a21oi_1
X$5013 VDD synth_346 synth_1076 synth_1790 VNB|VSS VDD synth_1865 VNB|VSS
+ sky130_fd_sc_hd__a21oi_1
X$5014 VDD synth_9586 synth_11716 synth_11718 VNB|VSS VDD synth_11785 VNB|VSS
+ sky130_fd_sc_hd__a21oi_1
X$5015 VDD synth_3700 synth_3631 synth_3871 VNB|VSS VDD synth_3874 VNB|VSS
+ sky130_fd_sc_hd__a21oi_1
X$5016 VDD synth_4292 synth_4377 synth_4474 VNB|VSS VDD synth_4454 VNB|VSS
+ sky130_fd_sc_hd__a21oi_1
X$5017 VDD synth_1173 synth_1172 synth_1210 VNB|VSS VDD synth_1240 VNB|VSS
+ sky130_fd_sc_hd__a21oi_1
X$5018 VDD synth_4583 synth_4584 synth_4776 VNB|VSS VDD synth_4867 VNB|VSS
+ sky130_fd_sc_hd__a21oi_1
X$5019 VDD synth_5286 synth_5737 synth_5803 VNB|VSS VDD synth_6026 VNB|VSS
+ sky130_fd_sc_hd__a21oi_1
X$5020 VDD synth_10793 synth_8918 synth_10170 VNB|VSS VDD synth_10917 VNB|VSS
+ sky130_fd_sc_hd__a21oi_1
X$5021 VDD synth_346 synth_444 synth_1323 VNB|VSS VDD synth_1223 VNB|VSS
+ sky130_fd_sc_hd__a21oi_1
X$5022 VDD synth_8990 synth_9434 synth_10440 VNB|VSS VDD synth_10439 VNB|VSS
+ sky130_fd_sc_hd__a21oi_1
X$5023 VDD synth_9297 synth_9910 synth_10851 VNB|VSS VDD synth_10817 VNB|VSS
+ sky130_fd_sc_hd__a21oi_1
X$5024 VDD synth_4309 synth_4223 synth_581 VNB|VSS VDD synth_4373 VNB|VSS
+ sky130_fd_sc_hd__a21oi_1
X$5025 VDD synth_7754 synth_7609 synth_7688 VNB|VSS VDD synth_7720 VNB|VSS
+ sky130_fd_sc_hd__a21oi_1
X$5026 VDD synth_6476 synth_6860 synth_6792 VNB|VSS VDD synth_6791 VNB|VSS
+ sky130_fd_sc_hd__a21oi_1
X$5027 VDD synth_1724 synth_1847 synth_1619 VNB|VSS VDD synth_1954 VNB|VSS
+ sky130_fd_sc_hd__a21oi_1
X$5028 VDD synth_10853 synth_10164 synth_10897 VNB|VSS VDD synth_11047 VNB|VSS
+ sky130_fd_sc_hd__a21oi_1
X$5029 VDD synth_146 synth_185 synth_42 VNB|VSS VDD synth_145 VNB|VSS
+ sky130_fd_sc_hd__a21oi_1
X$5030 VDD synth_562 synth_611 synth_612 VNB|VSS VDD synth_713 VNB|VSS
+ sky130_fd_sc_hd__a21oi_1
X$5031 VDD synth_10206 synth_10205 synth_10179 VNB|VSS VDD synth_10262 VNB|VSS
+ sky130_fd_sc_hd__a21oi_1
X$5032 VDD synth_6476 synth_7094 synth_7095 VNB|VSS VDD synth_7096 VNB|VSS
+ sky130_fd_sc_hd__a21oi_1
X$5033 VDD synth_10095 synth_9434 synth_10778 VNB|VSS VDD synth_10641 VNB|VSS
+ sky130_fd_sc_hd__a21oi_1
X$5034 VDD synth_6476 synth_7981 synth_6657 VNB|VSS VDD synth_6591 VNB|VSS
+ sky130_fd_sc_hd__a21oi_1
X$5035 VDD synth_2842 synth_2116 synth_2947 VNB|VSS VDD synth_2865 VNB|VSS
+ sky130_fd_sc_hd__a21oi_1
X$5036 VDD synth_1005 synth_167 synth_925 VNB|VSS VDD synth_1097 VNB|VSS
+ sky130_fd_sc_hd__a21oi_1
X$5037 VDD synth_3527 synth_3463 synth_3637 VNB|VSS VDD synth_3638 VNB|VSS
+ sky130_fd_sc_hd__a21oi_1
X$5038 VDD synth_4490 synth_4448 synth_4372 VNB|VSS VDD synth_4489 VNB|VSS
+ sky130_fd_sc_hd__a21oi_1
X$5039 VDD synth_5280 synth_927 synth_5287 VNB|VSS VDD synth_5434 VNB|VSS
+ sky130_fd_sc_hd__a21oi_1
X$5040 VDD synth_1279 synth_1858 synth_2164 VNB|VSS VDD synth_2200 VNB|VSS
+ sky130_fd_sc_hd__a21oi_1
X$5041 VDD synth_1825 synth_1822 synth_1826 VNB|VSS VDD synth_1913 VNB|VSS
+ sky130_fd_sc_hd__a21oi_1
X$5042 VDD synth_5583 synth_5510 synth_5617 VNB|VSS VDD synth_5616 VNB|VSS
+ sky130_fd_sc_hd__a21oi_1
X$5043 VDD synth_1213 synth_1133 synth_1676 VNB|VSS VDD synth_1612 VNB|VSS
+ sky130_fd_sc_hd__a21oi_1
X$5044 VDD synth_346 synth_792 synth_1811 VNB|VSS VDD synth_1812 VNB|VSS
+ sky130_fd_sc_hd__a21oi_1
X$5045 VDD synth_11399 synth_11398 synth_11261 VNB|VSS VDD synth_11471 VNB|VSS
+ sky130_fd_sc_hd__a21oi_1
X$5046 VDD synth_1859 synth_1353 synth_1791 VNB|VSS VDD synth_1938 VNB|VSS
+ sky130_fd_sc_hd__a21oi_1
X$5047 VDD synth_5279 synth_927 synth_5185 VNB|VSS VDD synth_5280 VNB|VSS
+ sky130_fd_sc_hd__a21oi_1
X$5048 VDD synth_6045 synth_5989 synth_6113 VNB|VSS VDD synth_6041 VNB|VSS
+ sky130_fd_sc_hd__a21oi_1
X$5049 VDD synth_12748 synth_12747 synth_12746 VNB|VSS VDD synth_12776 VNB|VSS
+ sky130_fd_sc_hd__a21oi_1
X$5050 VDD synth_1861 synth_1731 synth_1787 VNB|VSS VDD synth_1939 VNB|VSS
+ sky130_fd_sc_hd__a21oi_1
X$5051 VDD synth_474 synth_3378 synth_3702 VNB|VSS VDD synth_3805 VNB|VSS
+ sky130_fd_sc_hd__a21oi_1
X$5052 VDD synth_346 synth_1509 synth_2256 VNB|VSS VDD synth_1962 VNB|VSS
+ sky130_fd_sc_hd__a21oi_1
X$5053 VDD synth_1408 synth_1353 synth_1354 VNB|VSS VDD synth_1355 VNB|VSS
+ sky130_fd_sc_hd__a21oi_1
X$5054 VDD synth_1628 synth_1627 synth_1669 VNB|VSS VDD synth_1699 VNB|VSS
+ sky130_fd_sc_hd__a21oi_1
X$5055 VDD synth_2865 synth_2116 synth_2927 VNB|VSS VDD synth_3003 VNB|VSS
+ sky130_fd_sc_hd__a21oi_1
X$5056 VDD synth_12314 synth_12481 synth_12420 VNB|VSS VDD synth_12426 VNB|VSS
+ sky130_fd_sc_hd__a21oi_1
X$5057 VDD synth_5517 synth_4961 synth_5628 VNB|VSS VDD synth_5626 VNB|VSS
+ sky130_fd_sc_hd__a21oi_1
X$5058 VDD synth_2900 synth_2970 synth_2979 VNB|VSS VDD synth_3054 VNB|VSS
+ sky130_fd_sc_hd__a21oi_1
X$5059 VDD synth_3757 synth_3745 synth_3807 VNB|VSS VDD synth_3895 VNB|VSS
+ sky130_fd_sc_hd__a21oi_1
X$5060 VDD synth_11240 synth_9762 synth_11281 VNB|VSS VDD synth_11352 VNB|VSS
+ sky130_fd_sc_hd__a21oi_1
X$5061 VDD synth_6476 synth_7058 synth_6916 VNB|VSS VDD synth_6843 VNB|VSS
+ sky130_fd_sc_hd__a21oi_1
X$5062 VDD synth_10285 synth_9550 synth_9240 VNB|VSS VDD synth_11936 VNB|VSS
+ sky130_fd_sc_hd__a21oi_1
X$5063 VDD synth_1213 synth_1313 synth_1611 VNB|VSS VDD synth_1502 VNB|VSS
+ sky130_fd_sc_hd__a21oi_1
X$5064 VDD synth_9482 synth_8764 synth_9614 VNB|VSS VDD synth_8947 VNB|VSS
+ sky130_fd_sc_hd__a21oi_1
X$5065 VDD synth_9244 synth_9243 synth_9372 VNB|VSS VDD synth_9124 VNB|VSS
+ sky130_fd_sc_hd__a21oi_1
X$5066 VDD synth_10285 synth_11093 synth_11384 VNB|VSS VDD synth_11521 VNB|VSS
+ sky130_fd_sc_hd__a21oi_1
X$5067 VDD synth_474 synth_2946 synth_3635 VNB|VSS VDD synth_3634 VNB|VSS
+ sky130_fd_sc_hd__a21oi_1
X$5068 VDD synth_7280 synth_7214 synth_7271 VNB|VSS VDD synth_7346 VNB|VSS
+ sky130_fd_sc_hd__a21oi_1
X$5069 VDD synth_6959 synth_6789 synth_7060 VNB|VSS VDD synth_7061 VNB|VSS
+ sky130_fd_sc_hd__a21oi_1
X$5070 VDD synth_6827 synth_6826 synth_6757 VNB|VSS VDD synth_6849 VNB|VSS
+ sky130_fd_sc_hd__a21oi_1
X$5071 VDD synth_1213 synth_974 synth_2155 VNB|VSS VDD synth_2004 VNB|VSS
+ sky130_fd_sc_hd__a21oi_1
X$5072 VDD synth_10046 synth_10079 synth_10080 VNB|VSS VDD synth_9993 VNB|VSS
+ sky130_fd_sc_hd__a21oi_1
X$5073 VDD synth_11670 synth_11715 synth_11666 VNB|VSS VDD synth_11780 VNB|VSS
+ sky130_fd_sc_hd__a21oi_1
X$5074 VDD synth_5286 synth_5004 synth_5697 VNB|VSS VDD synth_5660 VNB|VSS
+ sky130_fd_sc_hd__a21oi_1
X$5075 VDD synth_455 synth_167 synth_453 VNB|VSS VDD synth_163 VNB|VSS
+ sky130_fd_sc_hd__a21oi_1
X$5076 VDD synth_11544 synth_11543 synth_11542 VNB|VSS VDD synth_11499 VNB|VSS
+ sky130_fd_sc_hd__a21oi_1
X$5077 VDD synth_9474 synth_8831 synth_9582 VNB|VSS VDD synth_9630 VNB|VSS
+ sky130_fd_sc_hd__a21oi_1
X$5078 VDD synth_9387 synth_10099 synth_10219 VNB|VSS VDD synth_10174 VNB|VSS
+ sky130_fd_sc_hd__a21oi_1
X$5079 VDD synth_3472 synth_3594 synth_3524 VNB|VSS VDD synth_3565 VNB|VSS
+ sky130_fd_sc_hd__a21oi_1
X$5080 VDD synth_6958 synth_6597 synth_6924 VNB|VSS VDD synth_7059 VNB|VSS
+ sky130_fd_sc_hd__a21oi_1
X$5081 VDD synth_408 synth_356 synth_625 VNB|VSS VDD synth_624 VNB|VSS
+ sky130_fd_sc_hd__a21oi_1
X$5082 VDD synth_12217 synth_9427 synth_11910 VNB|VSS VDD synth_12242 VNB|VSS
+ sky130_fd_sc_hd__a21oi_1
X$5083 VDD synth_6875 synth_6675 synth_6805 VNB|VSS VDD synth_6804 VNB|VSS
+ sky130_fd_sc_hd__a21oi_1
X$5084 VDD synth_1213 synth_429 synth_1544 VNB|VSS VDD synth_1580 VNB|VSS
+ sky130_fd_sc_hd__a21oi_1
X$5085 VDD synth_6210 synth_6149 synth_6211 VNB|VSS VDD synth_6128 VNB|VSS
+ sky130_fd_sc_hd__a21oi_1
X$5086 VDD synth_9062 synth_8805 synth_9202 VNB|VSS VDD synth_9120 VNB|VSS
+ sky130_fd_sc_hd__a21oi_1
X$5087 VDD synth_850 synth_2669 synth_3288 VNB|VSS VDD synth_3289 VNB|VSS
+ sky130_fd_sc_hd__a21oi_1
X$5088 VDD synth_7470 synth_7326 synth_7402 VNB|VSS VDD synth_7628 VNB|VSS
+ sky130_fd_sc_hd__a21oi_1
X$5089 VDD synth_9009 synth_8950 synth_9238 VNB|VSS VDD synth_9830 VNB|VSS
+ sky130_fd_sc_hd__a21oi_1
X$5090 VDD synth_6403 synth_6404 synth_6764 VNB|VSS VDD synth_6484 VNB|VSS
+ sky130_fd_sc_hd__a21oi_1
X$5091 VDD synth_6991 synth_6597 synth_6891 VNB|VSS VDD synth_6958 VNB|VSS
+ sky130_fd_sc_hd__a21oi_1
X$5092 VDD synth_4088 synth_3996 synth_3957 synth_4070 VNB|VSS VDD VNB|VSS
+ sky130_fd_sc_hd__nor3_1
X$5093 VDD synth_8646 synth_8478 synth_8560 synth_8661 VNB|VSS VDD VNB|VSS
+ sky130_fd_sc_hd__nor3_1
X$5094 VDD synth_2101 synth_1941 synth_2105 synth_2180 VNB|VSS VDD VNB|VSS
+ sky130_fd_sc_hd__nor3_1
X$5095 VDD synth_11523 synth_11484 synth_11584 synth_11583 VNB|VSS VDD VNB|VSS
+ sky130_fd_sc_hd__nor3_1
X$5096 VDD synth_11085 synth_11129 synth_11308 synth_11507 VNB|VSS VDD VNB|VSS
+ sky130_fd_sc_hd__nor3_1
X$5097 VDD synth_9112 synth_9427 synth_9036 synth_12408 VNB|VSS VDD VNB|VSS
+ sky130_fd_sc_hd__nor3_1
X$5098 VDD synth_8109 synth_8403 synth_8401 synth_8493 VNB|VSS VDD VNB|VSS
+ sky130_fd_sc_hd__nor3_1
X$5099 VDD synth_11022 synth_11472 synth_11491 synth_11558 VNB|VSS VDD VNB|VSS
+ sky130_fd_sc_hd__nor3_1
X$5100 VDD synth_9947 synth_10186 synth_10107 synth_10663 VNB|VSS VDD VNB|VSS
+ sky130_fd_sc_hd__nor3_1
X$5101 VDD synth_6405 synth_6458 synth_6615 synth_6629 VNB|VSS VDD VNB|VSS
+ sky130_fd_sc_hd__nor3_1
X$5102 VDD synth_9629 synth_8806 synth_10232 synth_11870 VNB|VSS VDD VNB|VSS
+ sky130_fd_sc_hd__nor3_1
X$5103 VDD synth_2122 synth_2011 synth_2053 synth_3233 VNB|VSS VDD VNB|VSS
+ sky130_fd_sc_hd__nor3_1
X$5104 VDD synth_3640 synth_3564 synth_3565 synth_3566 VNB|VSS VDD VNB|VSS
+ sky130_fd_sc_hd__nor3_1
X$5105 VDD synth_3566 synth_4065 synth_3310 synth_3568 synth_3523 synth_3567
+ VNB|VSS VDD VNB|VSS sky130_fd_sc_hd__a311o_1
X$5106 VDD synth_3472 synth_3640 synth_3564 synth_3563 VNB|VSS VDD VNB|VSS
+ sky130_fd_sc_hd__nor3_1
X$5107 VDD synth_8109 synth_8106 synth_8104 synth_8023 VNB|VSS VDD VNB|VSS
+ sky130_fd_sc_hd__nor3_1
X$5108 VDD synth_2109 synth_2037 synth_2083 synth_2038 VNB|VSS VDD VNB|VSS
+ sky130_fd_sc_hd__nor3_1
X$5109 VDD synth_8196 synth_10388 synth_10453 synth_10258 VNB|VSS VDD VNB|VSS
+ sky130_fd_sc_hd__nor3_1
X$5110 VDD synth_4457 synth_4456 synth_4396 synth_4549 VNB|VSS VDD VNB|VSS
+ sky130_fd_sc_hd__nor3_1
X$5111 VDD synth_4042 synth_3946 synth_4347 synth_4634 VNB|VSS VDD VNB|VSS
+ sky130_fd_sc_hd__nor3_1
X$5112 VDD synth_11022 synth_11332 synth_11331 synth_11262 VNB|VSS VDD VNB|VSS
+ sky130_fd_sc_hd__nor3_1
X$5113 VDD synth_4203 synth_4201 synth_4292 synth_4202 VNB|VSS VDD VNB|VSS
+ sky130_fd_sc_hd__nor3_1
X$5114 VDD synth_6140 synth_6225 synth_5973 synth_6224 VNB|VSS VDD VNB|VSS
+ sky130_fd_sc_hd__nor3_1
X$5115 VDD synth_8223 synth_8145 synth_7928 synth_8144 VNB|VSS VDD VNB|VSS
+ sky130_fd_sc_hd__nor3_1
X$5116 VDD synth_12786 synth_12613 synth_12658 synth_12712 VNB|VSS VDD VNB|VSS
+ sky130_fd_sc_hd__nor3_1
X$5117 VDD synth_1601 synth_1559 synth_1740 synth_1741 VNB|VSS VDD VNB|VSS
+ sky130_fd_sc_hd__nor3_1
X$5118 VDD synth_3697 synth_3698 synth_3630 synth_3756 VNB|VSS VDD VNB|VSS
+ sky130_fd_sc_hd__nor3_1
X$5119 VDD synth_11299 synth_11301 synth_11348 synth_11298 VNB|VSS VDD VNB|VSS
+ sky130_fd_sc_hd__nor3_1
X$5120 VDD synth_4811 synth_4818 synth_5105 synth_5103 VNB|VSS VDD VNB|VSS
+ sky130_fd_sc_hd__nor3_1
X$5121 VDD synth_7189 synth_7158 synth_7397 synth_7323 VNB|VSS VDD VNB|VSS
+ sky130_fd_sc_hd__nor3_1
X$5122 VDD synth_2462 synth_2712 synth_2438 synth_2530 VNB|VSS VDD VNB|VSS
+ sky130_fd_sc_hd__nor3_1
X$5123 VDD synth_3719 synth_3888 synth_3890 synth_3662 VNB|VSS VDD VNB|VSS
+ sky130_fd_sc_hd__nor3_1
X$5124 VDD synth_3297 synth_3602 synth_3430 synth_3671 VNB|VSS VDD VNB|VSS
+ sky130_fd_sc_hd__nor3_1
X$5125 VDD synth_3411 synth_3246 synth_3492 synth_3418 VNB|VSS VDD VNB|VSS
+ sky130_fd_sc_hd__nor3_1
X$5126 VDD synth_2038 synth_2110 synth_2001 synth_2156 VNB|VSS VDD VNB|VSS
+ sky130_fd_sc_hd__nor3_1
X$5127 VDD synth_10787 synth_10718 synth_10835 synth_10788 VNB|VSS VDD VNB|VSS
+ sky130_fd_sc_hd__nor3_1
X$5128 VDD synth_4811 synth_5504 synth_5533 synth_5505 VNB|VSS VDD VNB|VSS
+ sky130_fd_sc_hd__nor3_1
X$5129 VDD synth_7698 synth_7779 synth_7896 synth_7828 VNB|VSS VDD VNB|VSS
+ sky130_fd_sc_hd__nor3_1
X$5130 VDD synth_1785 synth_1802 synth_2021 synth_2093 VNB|VSS VDD VNB|VSS
+ sky130_fd_sc_hd__nor3_1
X$5131 VDD synth_4871 synth_5035 synth_4941 synth_5023 VNB|VSS VDD VNB|VSS
+ sky130_fd_sc_hd__nor3_1
X$5132 VDD synth_10516 synth_10399 synth_10478 synth_10452 VNB|VSS VDD VNB|VSS
+ sky130_fd_sc_hd__nor3_1
X$5133 VDD synth_9186 synth_9342 synth_9442 synth_9257 VNB|VSS VDD VNB|VSS
+ sky130_fd_sc_hd__nor3_1
X$5134 VDD synth_4445 synth_4509 synth_4361 synth_4417 VNB|VSS VDD VNB|VSS
+ sky130_fd_sc_hd__nor3_1
X$5135 VDD synth_1813 synth_1866 synth_2099 synth_1964 VNB|VSS VDD VNB|VSS
+ sky130_fd_sc_hd__nor3_1
X$5136 VDD synth_1722 synth_1724 synth_1881 synth_1923 VNB|VSS VDD VNB|VSS
+ sky130_fd_sc_hd__nor3_1
X$5137 VDD synth_9474 synth_11094 synth_11069 synth_11068 VNB|VSS VDD VNB|VSS
+ sky130_fd_sc_hd__nor3_1
X$5138 VDD synth_10293 synth_10233 synth_9429 synth_9392 VNB|VSS VDD VNB|VSS
+ sky130_fd_sc_hd__nor3_1
X$5139 VDD synth_4552 synth_4675 synth_4674 synth_4629 VNB|VSS VDD VNB|VSS
+ sky130_fd_sc_hd__nor3_1
X$5140 VDD synth_3757 synth_3894 synth_3945 synth_3896 VNB|VSS VDD VNB|VSS
+ sky130_fd_sc_hd__nor3_1
X$5141 VDD synth_2424 synth_3960 synth_3945 synth_2123 VNB|VSS VDD VNB|VSS
+ sky130_fd_sc_hd__nor3_2
X$5142 VDD synth_3884 synth_3916 synth_3883 synth_3979 VNB|VSS VDD VNB|VSS
+ sky130_fd_sc_hd__nor3_1
X$5143 VDD synth_11722 synth_11641 synth_11726 synth_11788 VNB|VSS VDD VNB|VSS
+ sky130_fd_sc_hd__nor3_1
X$5144 VDD synth_3894 synth_3945 synth_3895 synth_3897 VNB|VSS VDD VNB|VSS
+ sky130_fd_sc_hd__nor3_1
X$5145 VDD synth_8417 synth_8458 synth_8538 synth_8700 VNB|VSS VDD VNB|VSS
+ sky130_fd_sc_hd__nor3_1
X$5146 VDD synth_2877 synth_2757 synth_3048 synth_2967 VNB|VSS VDD VNB|VSS
+ sky130_fd_sc_hd__nor3_1
X$5147 VDD synth_7240 synth_7265 synth_7360 synth_7203 VNB|VSS VDD VNB|VSS
+ sky130_fd_sc_hd__nor3_1
X$5148 VDD synth_6972 synth_7033 synth_7161 synth_6937 VNB|VSS VDD VNB|VSS
+ sky130_fd_sc_hd__nor3_1
X$5149 VDD synth_8752 synth_8904 synth_8978 synth_8977 VNB|VSS VDD VNB|VSS
+ sky130_fd_sc_hd__nor3_1
X$5150 VDD synth_8997 synth_8833 synth_8980 VNB|VSS VDD VNB|VSS
+ sky130_fd_sc_hd__and2b_1
X$5151 VDD synth_7348 synth_7315 synth_7316 synth_7672 VNB|VSS VDD VNB|VSS
+ sky130_fd_sc_hd__nor3_1
X$5152 VDD synth_8956 synth_8654 synth_8888 synth_8957 VNB|VSS VDD VNB|VSS
+ sky130_fd_sc_hd__nor3_1
X$5153 VDD synth_9101 synth_9205 synth_9206 synth_9279 VNB|VSS VDD VNB|VSS
+ sky130_fd_sc_hd__nor3_1
X$5154 VDD synth_9142 synth_9166 synth_8934 synth_9167 VNB|VSS VDD VNB|VSS
+ sky130_fd_sc_hd__nor3_1
X$5155 VNB|VSS synth_9055 synth_9167 synth_9278 synth_9277 synth_9035
+ synth_9110 VDD VDD VNB|VSS sky130_fd_sc_hd__a32o_1
X$5156 VDD synth_1546 synth_1675 synth_1708 synth_1912 VNB|VSS VDD VNB|VSS
+ sky130_fd_sc_hd__nor3_1
X$5157 VDD synth_6432 synth_6538 synth_6431 synth_6539 VNB|VSS VDD VNB|VSS
+ sky130_fd_sc_hd__nor3_1
X$5158 VDD synth_2956 synth_2955 synth_3116 synth_3004 VNB|VSS VDD VNB|VSS
+ sky130_fd_sc_hd__nor3_1
X$5159 VDD synth_3832 synth_3830 synth_3831 synth_3594 VNB|VSS VDD VNB|VSS
+ sky130_fd_sc_hd__nor3_1
X$5160 VDD synth_5528 synth_5564 synth_5645 synth_5615 VNB|VSS VDD VNB|VSS
+ sky130_fd_sc_hd__nor3_1
X$5161 VDD synth_8710 synth_11514 synth_11437 synth_11747 VNB|VSS VDD VNB|VSS
+ sky130_fd_sc_hd__nor3_1
X$5162 VDD synth_1588 synth_1589 synth_1294 synth_1890 VNB|VSS VDD VNB|VSS
+ sky130_fd_sc_hd__nor3_1
X$5163 VDD synth_3358 synth_3232 synth_3230 synth_3229 VNB|VSS VDD VNB|VSS
+ sky130_fd_sc_hd__nor3_1
X$5164 VDD synth_9624 synth_9623 synth_9670 synth_9739 VNB|VSS VDD VNB|VSS
+ sky130_fd_sc_hd__nor3_1
X$5165 VDD synth_4185 synth_4184 synth_2424 synth_3882 VNB|VSS VDD VNB|VSS
+ sky130_fd_sc_hd__nor3_1
X$5166 VDD synth_6346 synth_6520 synth_6201 synth_6371 VNB|VSS VDD VNB|VSS
+ sky130_fd_sc_hd__nor3_1
X$5167 VDD synth_7684 synth_7798 synth_7685 synth_7793 VNB|VSS VDD VNB|VSS
+ sky130_fd_sc_hd__nor3_1
X$5168 VDD synth_5877 synth_5730 synth_5878 synth_5924 VNB|VSS VDD VNB|VSS
+ sky130_fd_sc_hd__nor3_1
X$5169 VDD synth_5549 synth_5242 synth_5550 synth_5483 VNB|VSS VDD VNB|VSS
+ sky130_fd_sc_hd__nor3_1
X$5170 VDD synth_73 synth_333 synth_307 synth_308 VNB|VSS VDD VNB|VSS
+ sky130_fd_sc_hd__nor3_1
X$5171 VDD synth_9814 synth_9915 synth_9913 synth_10077 VNB|VSS VDD VNB|VSS
+ sky130_fd_sc_hd__nor3_1
X$5172 VDD synth_3024 synth_3023 synth_3167 synth_3135 VNB|VSS VDD VNB|VSS
+ sky130_fd_sc_hd__nor3_1
X$5173 VDD synth_6686 synth_6684 synth_6821 synth_6750 VNB|VSS VDD VNB|VSS
+ sky130_fd_sc_hd__nor3_1
X$5174 VDD synth_10552 synth_11053 synth_10975 synth_10945 VNB|VSS VDD VNB|VSS
+ sky130_fd_sc_hd__nor3_1
X$5175 VDD synth_8768 synth_8883 synth_9081 synth_8966 VNB|VSS VDD VNB|VSS
+ sky130_fd_sc_hd__nor3_1
X$5176 VDD synth_5344 synth_5506 synth_5565 synth_5507 VNB|VSS VDD VNB|VSS
+ sky130_fd_sc_hd__nor3_1
X$5177 VDD synth_723 synth_613 synth_888 synth_889 VNB|VSS VDD VNB|VSS
+ sky130_fd_sc_hd__nor3_1
X$5178 VDD synth_3550 synth_3554 synth_3553 synth_3862 VNB|VSS VDD VNB|VSS
+ sky130_fd_sc_hd__nor3_1
X$5179 VDD synth_10412 synth_10287 synth_10482 synth_10560 VNB|VSS VDD VNB|VSS
+ sky130_fd_sc_hd__nor3_1
X$5180 VDD synth_8410 synth_8399 synth_8562 synth_8482 VNB|VSS VDD VNB|VSS
+ sky130_fd_sc_hd__nor3_1
X$5181 VDD synth_5718 synth_5719 synth_5818 synth_5962 VNB|VSS VDD VNB|VSS
+ sky130_fd_sc_hd__nor3_1
X$5182 VDD synth_2526 synth_2585 synth_2174 synth_2527 VNB|VSS VDD VNB|VSS
+ sky130_fd_sc_hd__nor3_1
X$5183 VDD synth_8811 synth_8887 synth_8482 synth_8400 VNB|VSS VDD VNB|VSS
+ sky130_fd_sc_hd__nor3_1
X$5184 VDD synth_10952 synth_11480 synth_11689 synth_11404 VNB|VSS VDD VNB|VSS
+ sky130_fd_sc_hd__nor3_1
X$5185 VDD synth_6498 synth_6710 synth_6439 synth_6769 VNB|VSS VDD VNB|VSS
+ sky130_fd_sc_hd__nor3_1
X$5186 VDD synth_9947 synth_10023 synth_9019 synth_10321 VNB|VSS VDD VNB|VSS
+ sky130_fd_sc_hd__nor3_1
X$5187 VDD synth_5564 synth_5645 synth_5529 synth_5587 VNB|VSS VDD VNB|VSS
+ sky130_fd_sc_hd__nor3_1
X$5188 VNB|VSS synth_5675 synth_4818 synth_5529 synth_5645 synth_5564 VDD VDD
+ VNB|VSS sky130_fd_sc_hd__or4_4
X$5189 VDD synth_5416 synth_5471 synth_5150 synth_5394 VNB|VSS VDD VNB|VSS
+ sky130_fd_sc_hd__nor3_1
X$5190 VDD synth_9186 synth_9444 synth_9594 synth_9647 VNB|VSS VDD VNB|VSS
+ sky130_fd_sc_hd__nor3_1
X$5191 VDD synth_6247 synth_5995 synth_5912 synth_6186 VNB|VSS VDD VNB|VSS
+ sky130_fd_sc_hd__nor3_1
X$5192 VDD synth_2109 synth_2236 synth_2156 synth_2385 VNB|VSS VDD VNB|VSS
+ sky130_fd_sc_hd__nor3_1
X$5193 VDD synth_6928 synth_7209 synth_7036 synth_7231 VNB|VSS VDD VNB|VSS
+ sky130_fd_sc_hd__nor3_1
X$5194 VDD synth_908 synth_989 synth_907 synth_969 VNB|VSS VDD VNB|VSS
+ sky130_fd_sc_hd__nor3_1
X$5195 VDD synth_3129 synth_3100 synth_3365 synth_3261 VNB|VSS VDD VNB|VSS
+ sky130_fd_sc_hd__nor3_1
X$5196 VDD synth_2245 synth_2086 synth_2060 synth_2398 VNB|VSS VDD VNB|VSS
+ sky130_fd_sc_hd__nor3_1
X$5197 VDD synth_6834 synth_6696 synth_6832 synth_7052 VNB|VSS VDD VNB|VSS
+ sky130_fd_sc_hd__nor3_1
X$5198 VDD synth_1761 synth_1870 synth_1942 synth_1944 VNB|VSS VDD VNB|VSS
+ sky130_fd_sc_hd__nor3_1
X$5199 VDD synth_12440 synth_12579 synth_12514 synth_12578 VNB|VSS VDD VNB|VSS
+ sky130_fd_sc_hd__nor3_1
X$5200 VDD synth_10260 synth_10387 synth_10453 synth_10534 VNB|VSS VDD VNB|VSS
+ sky130_fd_sc_hd__nor3_1
X$5201 VDD synth_5070 synth_5072 synth_5071 synth_5145 VNB|VSS VDD VNB|VSS
+ sky130_fd_sc_hd__nor3_1
X$5202 VDD synth_10985 synth_11087 synth_10767 synth_11002 VNB|VSS VDD VNB|VSS
+ sky130_fd_sc_hd__nor3_1
X$5203 VDD synth_1704 synth_1705 synth_1610 synth_1996 VNB|VSS VDD VNB|VSS
+ sky130_fd_sc_hd__nor3_1
X$5204 VDD synth_6637 synth_6752 synth_6753 synth_6873 VNB|VSS VDD VNB|VSS
+ sky130_fd_sc_hd__nor3_1
X$5205 VDD synth_4036 synth_4035 synth_4109 synth_4284 VNB|VSS VDD VNB|VSS
+ sky130_fd_sc_hd__nor3_1
X$5206 VDD synth_922 synth_1373 synth_1150 synth_1524 VNB|VSS VDD VNB|VSS
+ sky130_fd_sc_hd__nor3_1
X$5207 VDD synth_4392 synth_4680 synth_4681 synth_4696 VNB|VSS VDD VNB|VSS
+ sky130_fd_sc_hd__nor3_1
X$5208 VDD synth_6962 synth_8238 synth_4650 synth_8350 VNB|VSS VDD VNB|VSS
+ sky130_fd_sc_hd__nor3_1
X$5209 VDD synth_6166 synth_6167 synth_6165 synth_6180 VNB|VSS VDD VNB|VSS
+ sky130_fd_sc_hd__nor3_1
X$5210 VDD synth_7601 synth_7590 synth_7608 synth_8022 VNB|VSS VDD VNB|VSS
+ sky130_fd_sc_hd__nor3_1
X$5211 VDD synth_9119 synth_9775 synth_10097 synth_10349 VNB|VSS VDD VNB|VSS
+ sky130_fd_sc_hd__nor3_1
X$5212 VDD synth_9062 synth_10349 synth_10350 synth_10348 VNB|VSS VDD VNB|VSS
+ sky130_fd_sc_hd__nor3_1
X$5213 VDD synth_6816 synth_6937 synth_6817 synth_4896 VNB|VSS VDD VNB|VSS
+ sky130_fd_sc_hd__nor3_1
X$5214 VDD synth_4779 synth_4536 synth_4750 synth_4782 VNB|VSS VDD VNB|VSS
+ sky130_fd_sc_hd__nor3_1
X$5215 VDD synth_3757 synth_3894 synth_3876 synth_4004 VNB|VSS VDD VNB|VSS
+ sky130_fd_sc_hd__nor3_1
X$5216 VDD synth_8710 synth_9679 synth_9618 synth_9579 VNB|VSS VDD VNB|VSS
+ sky130_fd_sc_hd__nor3_1
X$5217 VDD synth_3400 synth_3641 synth_3399 synth_3732 VNB|VSS VDD VNB|VSS
+ sky130_fd_sc_hd__nor3_1
X$5218 VDD synth_3774 synth_3841 synth_3707 synth_4043 VNB|VSS VDD VNB|VSS
+ sky130_fd_sc_hd__nor3_1
X$5219 VDD synth_9434 synth_10288 synth_10174 synth_10218 VNB|VSS VDD VNB|VSS
+ sky130_fd_sc_hd__nor3_1
X$5220 VDD synth_1310 synth_1311 synth_1372 synth_1480 VNB|VSS VDD VNB|VSS
+ sky130_fd_sc_hd__nor3_1
X$5221 VDD synth_2166 synth_2337 synth_2476 synth_2475 VNB|VSS VDD VNB|VSS
+ sky130_fd_sc_hd__nor3_1
X$5222 VDD synth_7423 synth_1711 synth_7817 synth_7815 VNB|VSS VDD VNB|VSS
+ sky130_fd_sc_hd__nor3_1
X$5223 VDD synth_7080 synth_7117 synth_7203 synth_7161 VNB|VSS VDD VNB|VSS
+ sky130_fd_sc_hd__nor3_1
X$5224 VDD synth_3639 synth_3636 synth_3614 synth_3807 VNB|VSS VDD VNB|VSS
+ sky130_fd_sc_hd__nor3_1
X$5225 VDD synth_3724 synth_3836 synth_3674 synth_3929 VNB|VSS VDD VNB|VSS
+ sky130_fd_sc_hd__nor3_1
X$5226 VDD synth_10312 synth_12239 synth_12386 synth_12450 VNB|VSS VDD VNB|VSS
+ sky130_fd_sc_hd__nor3_1
X$5227 VDD synth_5264 synth_5266 synth_5265 synth_4742 VNB|VSS VDD VNB|VSS
+ sky130_fd_sc_hd__nor3_1
X$5228 VDD synth_1813 synth_1866 synth_1815 synth_1963 VNB|VSS VDD VNB|VSS
+ sky130_fd_sc_hd__nor3_1
X$5229 VDD synth_10451 synth_8196 synth_10452 synth_10320 VNB|VSS VDD VNB|VSS
+ sky130_fd_sc_hd__nor3_1
X$5230 VDD synth_8768 synth_9139 synth_9140 synth_9264 VNB|VSS VDD VNB|VSS
+ sky130_fd_sc_hd__nor3_1
X$5231 VDD synth_9119 synth_11017 synth_10511 synth_11097 VNB|VSS VDD VNB|VSS
+ sky130_fd_sc_hd__nor3_1
X$5232 VDD synth_1968 synth_2005 synth_1967 synth_1966 VNB|VSS VDD VNB|VSS
+ sky130_fd_sc_hd__nor3_1
X$5233 VDD synth_4454 synth_4608 synth_4692 synth_4680 VNB|VSS VDD VNB|VSS
+ sky130_fd_sc_hd__nor3_1
X$5234 VDD synth_10652 synth_10312 synth_8946 synth_11540 VNB|VSS VDD VNB|VSS
+ sky130_fd_sc_hd__nor3_1
X$5235 VDD synth_9873 synth_10669 synth_10591 synth_10596 VNB|VSS VDD VNB|VSS
+ sky130_fd_sc_hd__nor3_1
X$5236 VDD synth_6686 synth_6684 synth_6683 synth_4743 VNB|VSS VDD VNB|VSS
+ sky130_fd_sc_hd__nor3_1
X$5237 VDD synth_896 synth_1026 synth_664 synth_948 VNB|VSS VDD VNB|VSS
+ sky130_fd_sc_hd__nor3_1
X$5238 VDD synth_8849 synth_8465 synth_8847 synth_9002 VNB|VSS VDD VNB|VSS
+ sky130_fd_sc_hd__nor3_1
X$5239 VDD synth_11723 synth_10833 synth_11725 synth_11727 VNB|VSS VDD VNB|VSS
+ sky130_fd_sc_hd__nor3_1
X$5240 VDD synth_6696 synth_6697 synth_6698 synth_6702 VNB|VSS VDD VNB|VSS
+ sky130_fd_sc_hd__nor3_1
X$5241 VDD synth_9062 synth_12397 synth_11067 synth_12357 VNB|VSS VDD VNB|VSS
+ sky130_fd_sc_hd__nor3_1
X$5242 VDD synth_3921 synth_3923 synth_3689 synth_4055 VNB|VSS VDD VNB|VSS
+ sky130_fd_sc_hd__nor3_1
X$5243 VDD synth_667 synth_815 synth_744 synth_817 VNB|VSS VDD VNB|VSS
+ sky130_fd_sc_hd__nor3_1
X$5244 VDD synth_4619 synth_5006 synth_4721 synth_5005 VNB|VSS VDD VNB|VSS
+ sky130_fd_sc_hd__nor3_1
X$5245 VDD synth_6230 synth_6231 synth_5977 synth_6147 VNB|VSS VDD VNB|VSS
+ sky130_fd_sc_hd__nor3_1
X$5246 VDD synth_4592 synth_4655 synth_4639 synth_4576 VNB|VSS VDD VNB|VSS
+ sky130_fd_sc_hd__nor3_1
X$5247 VDD synth_8180 synth_8093 synth_8132 synth_8278 VNB|VSS VDD VNB|VSS
+ sky130_fd_sc_hd__nor3_1
X$5248 VDD synth_2005 synth_1737 synth_1735 synth_2090 VNB|VSS VDD VNB|VSS
+ sky130_fd_sc_hd__nor3_1
X$5249 VDD synth_6696 synth_6908 synth_6832 synth_6692 VNB|VSS VDD VNB|VSS
+ sky130_fd_sc_hd__nor3_1
X$5250 VDD synth_5267 synth_5346 synth_5211 synth_5423 VNB|VSS VDD VNB|VSS
+ sky130_fd_sc_hd__nor3_1
X$5251 VDD synth_3468 synth_3942 synth_3824 VDD VNB|VSS VNB|VSS
+ sky130_fd_sc_hd__nand2_1
X$5252 VDD synth_1067 synth_1506 synth_1428 VDD VNB|VSS VNB|VSS
+ sky130_fd_sc_hd__nand2_1
X$5253 VDD synth_6614 synth_6457 synth_6578 VDD VNB|VSS VNB|VSS
+ sky130_fd_sc_hd__nand2_1
X$5254 VDD synth_1888 synth_1738 synth_1926 VDD VNB|VSS VNB|VSS
+ sky130_fd_sc_hd__nand2_1
X$5255 VDD synth_9423 synth_10635 synth_10305 VDD VNB|VSS VNB|VSS
+ sky130_fd_sc_hd__nand2_1
X$5256 VDD synth_6139 synth_6190 synth_6111 VDD VNB|VSS VNB|VSS
+ sky130_fd_sc_hd__nand2_1
X$5257 VDD synth_5171 synth_364 synth_5277 VDD VNB|VSS VNB|VSS
+ sky130_fd_sc_hd__nand2_1
X$5258 VDD synth_329 synth_102 synth_262 VDD VNB|VSS VNB|VSS
+ sky130_fd_sc_hd__nand2_1
X$5259 VDD synth_1506 synth_214 synth_1135 VDD VNB|VSS VNB|VSS
+ sky130_fd_sc_hd__nand2_1
X$5260 VDD synth_2656 synth_2588 synth_2657 VDD VNB|VSS VNB|VSS
+ sky130_fd_sc_hd__nand2_1
X$5261 VDD synth_6597 synth_6596 synth_6411 VDD VNB|VSS VNB|VSS
+ sky130_fd_sc_hd__nand2_1
X$5262 VDD synth_2059 synth_2424 synth_2310 VDD VNB|VSS VNB|VSS
+ sky130_fd_sc_hd__nand2_1
X$5263 VDD synth_7089 synth_7910 synth_7985 VDD VNB|VSS VNB|VSS
+ sky130_fd_sc_hd__nand2_1
X$5264 VDD synth_11852 synth_11850 synth_12022 VDD VNB|VSS VNB|VSS
+ sky130_fd_sc_hd__nand2_1
X$5265 VDD synth_927 synth_1979 synth_2136 VDD VNB|VSS VNB|VSS
+ sky130_fd_sc_hd__nand2_1
X$5266 VDD synth_384 synth_217 synth_327 VDD VNB|VSS VNB|VSS
+ sky130_fd_sc_hd__nand2_1
X$5267 VDD synth_2522 synth_2273 synth_2409 VDD VNB|VSS VNB|VSS
+ sky130_fd_sc_hd__nand2_1
X$5268 VDD synth_151 synth_280 synth_217 VDD VNB|VSS VNB|VSS
+ sky130_fd_sc_hd__nand2_1
X$5269 VDD synth_194 synth_431 synth_201 VDD VNB|VSS VNB|VSS
+ sky130_fd_sc_hd__nand2_1
X$5270 VDD synth_6695 synth_7507 synth_7592 VDD VNB|VSS VNB|VSS
+ sky130_fd_sc_hd__nand2_1
X$5271 VDD synth_214 synth_431 synth_177 VDD VNB|VSS VNB|VSS
+ sky130_fd_sc_hd__nand2_1
X$5272 VDD synth_8803 synth_10778 synth_12670 VDD VNB|VSS VNB|VSS
+ sky130_fd_sc_hd__nand2_1
X$5273 VDD synth_3616 synth_8156 synth_7992 VDD VNB|VSS VNB|VSS
+ sky130_fd_sc_hd__nand2_1
X$5274 VDD synth_9931 synth_10868 synth_10944 VDD VNB|VSS VNB|VSS
+ sky130_fd_sc_hd__nand2_1
X$5275 VDD synth_2434 synth_2354 synth_2504 VDD VNB|VSS VNB|VSS
+ sky130_fd_sc_hd__nand2_1
X$5276 VDD synth_3541 synth_5004 synth_4823 VDD VNB|VSS VNB|VSS
+ sky130_fd_sc_hd__nand2_1
X$5277 VDD synth_4109 synth_4198 synth_4197 VDD VNB|VSS VNB|VSS
+ sky130_fd_sc_hd__nand2_1
X$5278 VDD synth_11180 synth_11141 synth_11140 VDD VNB|VSS VNB|VSS
+ sky130_fd_sc_hd__nand2_1
X$5279 VDD synth_11307 synth_5738 synth_11127 VDD VNB|VSS VNB|VSS
+ sky130_fd_sc_hd__nand2_1
X$5280 VDD synth_2686 synth_3044 synth_3081 VDD VNB|VSS VNB|VSS
+ sky130_fd_sc_hd__nand2_1
X$5281 VDD synth_8746 synth_11143 synth_11141 VDD VNB|VSS VNB|VSS
+ sky130_fd_sc_hd__nand2_1
X$5282 VDD synth_4042 synth_4117 synth_3840 VDD VNB|VSS VNB|VSS
+ sky130_fd_sc_hd__nand2_1
X$5283 VDD synth_4747 synth_5161 synth_5160 VDD VNB|VSS VNB|VSS
+ sky130_fd_sc_hd__nand2_1
X$5284 VDD synth_1760 synth_364 synth_1660 VDD VNB|VSS VNB|VSS
+ sky130_fd_sc_hd__nand2_1
X$5285 VDD synth_10635 synth_5738 synth_10480 VDD VNB|VSS VNB|VSS
+ sky130_fd_sc_hd__nand2_1
X$5286 VDD synth_8576 synth_8530 synth_8774 VDD VNB|VSS VNB|VSS
+ sky130_fd_sc_hd__nand2_1
X$5287 VDD synth_4632 synth_4345 synth_4571 VDD VNB|VSS VNB|VSS
+ sky130_fd_sc_hd__nand2_1
X$5288 VDD synth_6695 synth_8197 synth_8101 VDD VNB|VSS VNB|VSS
+ sky130_fd_sc_hd__nand2_1
X$5289 VDD synth_7590 synth_7807 synth_7805 VDD VNB|VSS synth_8196 VNB|VSS
+ sky130_fd_sc_hd__or3_2
X$5290 VDD synth_7715 synth_7434 synth_7561 VDD VNB|VSS VNB|VSS
+ sky130_fd_sc_hd__nand2_1
X$5291 VDD synth_3639 synth_3685 synth_3611 VDD VNB|VSS VNB|VSS
+ sky130_fd_sc_hd__nand2_1
X$5292 VDD synth_1665 synth_1744 synth_1746 VDD VNB|VSS VNB|VSS
+ sky130_fd_sc_hd__nand2_1
X$5293 VDD synth_7984 synth_7985 synth_7909 VDD VNB|VSS VNB|VSS
+ sky130_fd_sc_hd__nand2_1
X$5294 VDD synth_8746 synth_7142 synth_8530 VDD VNB|VSS VNB|VSS
+ sky130_fd_sc_hd__nand2_1
X$5295 VDD synth_2107 synth_2108 synth_2236 VDD VNB|VSS VNB|VSS
+ sky130_fd_sc_hd__nand2_1
X$5296 VDD synth_10073 synth_10072 synth_10131 VDD VNB|VSS VNB|VSS
+ sky130_fd_sc_hd__nand2_1
X$5297 VDD synth_4844 synth_657 synth_4497 VDD VNB|VSS VNB|VSS
+ sky130_fd_sc_hd__nand2_1
X$5298 VDD synth_214 synth_4526 synth_4442 VDD VNB|VSS VNB|VSS
+ sky130_fd_sc_hd__nand2_1
X$5299 VDD synth_5161 synth_657 synth_4939 VDD VNB|VSS VNB|VSS
+ sky130_fd_sc_hd__nand2_1
X$5300 VDD synth_927 synth_4613 synth_4753 VDD VNB|VSS VNB|VSS
+ sky130_fd_sc_hd__nand2_1
X$5301 VDD synth_9239 synth_8981 synth_9775 VDD VNB|VSS VNB|VSS
+ sky130_fd_sc_hd__nand2_1
X$5302 VDD synth_9177 synth_9740 synth_9628 VDD VNB|VSS VNB|VSS
+ sky130_fd_sc_hd__nand2_1
X$5303 VDD synth_5162 synth_5160 synth_5209 VDD VNB|VSS VNB|VSS
+ sky130_fd_sc_hd__nand2_1
X$5304 VDD synth_3971 synth_4060 synth_3970 VDD VNB|VSS VNB|VSS
+ sky130_fd_sc_hd__nand2_1
X$5305 VDD synth_4447 synth_4369 synth_4556 VDD VNB|VSS VNB|VSS
+ sky130_fd_sc_hd__nand2_1
X$5306 VDD synth_3404 synth_3480 synth_3661 VDD VNB|VSS VNB|VSS
+ sky130_fd_sc_hd__nand2_1
X$5307 VDD synth_12457 synth_12456 synth_12537 VDD VNB|VSS VNB|VSS
+ sky130_fd_sc_hd__nand2_1
X$5308 VDD synth_7804 synth_7946 synth_7738 VDD VNB|VSS VNB|VSS
+ sky130_fd_sc_hd__nand2_1
X$5309 VDD synth_4961 synth_6248 synth_6264 VDD VNB|VSS VNB|VSS
+ sky130_fd_sc_hd__nand2_1
X$5310 VDD synth_10756 synth_10711 synth_10905 VDD VNB|VSS VNB|VSS
+ sky130_fd_sc_hd__nand2_1
X$5311 VDD synth_4570 synth_4345 synth_4346 VDD VNB|VSS VNB|VSS
+ sky130_fd_sc_hd__nand2_1
X$5312 VDD synth_8803 synth_11282 synth_12671 VDD VNB|VSS VNB|VSS
+ sky130_fd_sc_hd__nand2_1
X$5313 VDD synth_10202 synth_9914 synth_10075 VDD VNB|VSS VNB|VSS
+ sky130_fd_sc_hd__nand2_1
X$5314 VDD synth_5510 synth_5509 synth_5426 VDD VNB|VSS VNB|VSS
+ sky130_fd_sc_hd__nand2_1
X$5315 VDD synth_1338 synth_3750 synth_3555 VDD VNB|VSS VNB|VSS
+ sky130_fd_sc_hd__nand2_1
X$5316 VDD synth_6556 synth_657 synth_6312 VDD VNB|VSS VNB|VSS
+ sky130_fd_sc_hd__nand2_1
X$5317 VDD synth_927 synth_2885 synth_2665 VDD VNB|VSS VNB|VSS
+ sky130_fd_sc_hd__nand2_1
X$5318 VDD synth_2542 synth_2588 synth_2589 VDD VNB|VSS VNB|VSS
+ sky130_fd_sc_hd__nand2_1
X$5319 VDD synth_6370 synth_6232 synth_6416 VDD VNB|VSS VNB|VSS
+ sky130_fd_sc_hd__nand2_1
X$5320 VDD synth_2893 synth_2665 synth_2813 VDD VNB|VSS VNB|VSS
+ sky130_fd_sc_hd__nand2_1
X$5321 VDD synth_6597 synth_6544 synth_6232 VDD VNB|VSS VNB|VSS
+ sky130_fd_sc_hd__nand2_1
X$5322 VDD synth_4094 synth_3876 synth_3960 VDD VNB|VSS VNB|VSS
+ sky130_fd_sc_hd__nand2_1
X$5323 VDD synth_927 synth_1760 synth_1744 VDD VNB|VSS VNB|VSS
+ sky130_fd_sc_hd__nand2_1
X$5324 VDD synth_3601 synth_3691 synth_3750 VDD VNB|VSS VNB|VSS
+ sky130_fd_sc_hd__nand2_1
X$5325 VDD synth_7089 synth_7250 synth_7436 VDD VNB|VSS VNB|VSS
+ sky130_fd_sc_hd__nand2_1
X$5326 VDD synth_357 synth_234 synth_303 VDD VNB|VSS VNB|VSS
+ sky130_fd_sc_hd__nand2_1
X$5327 VDD synth_2196 synth_2197 synth_2175 VDD VNB|VSS VNB|VSS
+ sky130_fd_sc_hd__nand2_1
X$5328 VDD synth_1024 synth_1174 synth_1133 VDD VNB|VSS VNB|VSS
+ sky130_fd_sc_hd__nand2_1
X$5329 VDD synth_2747 synth_2548 synth_2674 VDD VNB|VSS VNB|VSS
+ sky130_fd_sc_hd__nand2_1
X$5330 VDD synth_1258 synth_214 synth_1232 VDD VNB|VSS VNB|VSS
+ sky130_fd_sc_hd__nand2_1
X$5331 VDD synth_10429 synth_10428 synth_10228 VDD VNB|VSS VNB|VSS
+ sky130_fd_sc_hd__nand2_1
X$5332 VDD synth_1813 synth_1886 synth_1937 VDD VNB|VSS VNB|VSS
+ sky130_fd_sc_hd__nand2_1
X$5333 VDD synth_2033 synth_1999 synth_2036 VDD VNB|VSS VNB|VSS
+ sky130_fd_sc_hd__nand2_1
X$5334 VDD synth_10285 synth_9112 synth_10376 VDD VNB|VSS VNB|VSS
+ sky130_fd_sc_hd__nand2_1
X$5335 VDD synth_11143 synth_3616 synth_10880 VDD VNB|VSS VNB|VSS
+ sky130_fd_sc_hd__nand2_1
X$5336 VDD synth_4484 synth_4149 synth_4433 VDD VNB|VSS VNB|VSS
+ sky130_fd_sc_hd__nand2_1
X$5337 VDD synth_3616 synth_7146 synth_7885 VDD VNB|VSS VNB|VSS
+ sky130_fd_sc_hd__nand2_1
X$5338 VDD synth_9423 synth_10229 synth_9921 VDD VNB|VSS VNB|VSS
+ sky130_fd_sc_hd__nand2_1
X$5339 VDD synth_3365 synth_3544 synth_3590 VDD VNB|VSS VNB|VSS
+ sky130_fd_sc_hd__nand2_1
X$5340 VDD synth_6518 synth_6379 synth_6380 VDD VNB|VSS VNB|VSS
+ sky130_fd_sc_hd__nand2_1
X$5341 VDD synth_7979 synth_7196 synth_7729 VDD VNB|VSS VNB|VSS
+ sky130_fd_sc_hd__nand2_1
X$5342 VDD synth_1231 synth_1259 synth_1261 VDD VNB|VSS VNB|VSS
+ sky130_fd_sc_hd__nand2_1
X$5343 VDD synth_9868 synth_9797 synth_9867 VDD VNB|VSS VNB|VSS
+ sky130_fd_sc_hd__nand2_1
X$5344 VDD synth_1463 synth_1421 synth_1540 VDD VNB|VSS VNB|VSS
+ sky130_fd_sc_hd__nand2_1
X$5345 VDD synth_3970 synth_364 synth_3676 VDD VNB|VSS VNB|VSS
+ sky130_fd_sc_hd__nand2_1
X$5346 VDD synth_1500 synth_1421 synth_1422 VDD VNB|VSS VNB|VSS
+ sky130_fd_sc_hd__nand2_1
X$5347 VDD synth_5343 synth_4993 synth_4709 VDD VNB|VSS VNB|VSS
+ sky130_fd_sc_hd__nand2_1
X$5348 VDD synth_6551 synth_6603 synth_6587 VDD VNB|VSS VNB|VSS
+ sky130_fd_sc_hd__nand2_1
X$5349 VDD synth_5211 synth_5268 synth_5215 VDD VNB|VSS VNB|VSS
+ sky130_fd_sc_hd__nand2_1
X$5350 VDD synth_7473 synth_7472 synth_7508 VDD VNB|VSS VNB|VSS
+ sky130_fd_sc_hd__nand2_1
X$5351 VDD synth_4747 synth_4844 synth_4678 VDD VNB|VSS VNB|VSS
+ sky130_fd_sc_hd__nand2_1
X$5352 VDD synth_5738 synth_5737 synth_5294 VDD VNB|VSS VNB|VSS
+ sky130_fd_sc_hd__nand2_1
X$5353 VDD synth_3309 synth_3595 synth_3276 VDD VNB|VSS VNB|VSS
+ sky130_fd_sc_hd__nand2_1
X$5354 VDD synth_1338 synth_4261 synth_4407 VDD VNB|VSS VNB|VSS
+ sky130_fd_sc_hd__nand2_1
X$5355 VDD synth_5632 synth_5732 synth_5659 VDD VNB|VSS VNB|VSS
+ sky130_fd_sc_hd__nand2_1
X$5356 VDD synth_6597 synth_6738 synth_6659 VDD VNB|VSS VNB|VSS
+ sky130_fd_sc_hd__nand2_1
X$5357 VDD synth_4745 synth_4678 synth_4802 VDD VNB|VSS VNB|VSS
+ sky130_fd_sc_hd__nand2_1
X$5358 VDD synth_8803 synth_9387 synth_10233 VDD VNB|VSS VNB|VSS
+ sky130_fd_sc_hd__nand2_1
X$5359 VDD synth_3544 synth_3814 synth_3887 VDD VNB|VSS VNB|VSS
+ sky130_fd_sc_hd__nand2_1
X$5360 VDD synth_12084 synth_11850 synth_11853 VDD VNB|VSS VNB|VSS
+ sky130_fd_sc_hd__nand2_1
X$5361 VDD synth_2685 synth_2642 synth_2783 VDD VNB|VSS VNB|VSS
+ sky130_fd_sc_hd__nand2_1
X$5362 VDD synth_4911 synth_4727 synth_4882 VDD VNB|VSS VNB|VSS
+ sky130_fd_sc_hd__nand2_1
X$5363 VDD synth_5823 synth_5851 synth_5824 VDD VNB|VSS VNB|VSS
+ sky130_fd_sc_hd__nand2_1
X$5364 VDD synth_4962 synth_4727 synth_4884 VDD VNB|VSS VNB|VSS
+ sky130_fd_sc_hd__nand2_1
X$5365 VDD synth_2782 synth_2642 synth_2827 VDD VNB|VSS VNB|VSS
+ sky130_fd_sc_hd__nand2_1
X$5366 VDD synth_194 synth_1258 synth_1259 VDD VNB|VSS VNB|VSS
+ sky130_fd_sc_hd__nand2_1
X$5367 VDD synth_659 synth_1170 synth_1059 VDD VNB|VSS VNB|VSS
+ sky130_fd_sc_hd__nand2_1
X$5368 VDD synth_11455 synth_11669 synth_12046 VDD VNB|VSS VNB|VSS
+ sky130_fd_sc_hd__nand2_1
X$5369 VDD synth_5645 synth_5383 synth_5908 VDD VNB|VSS VNB|VSS
+ sky130_fd_sc_hd__nand2_1
X$5370 VDD synth_10274 synth_10431 synth_10405 VDD VNB|VSS VNB|VSS
+ sky130_fd_sc_hd__nand2_1
X$5371 VDD synth_3544 synth_4499 synth_5809 VDD VNB|VSS VNB|VSS
+ sky130_fd_sc_hd__nand2_1
X$5372 VDD synth_10360 synth_10431 synth_10475 VDD VNB|VSS VNB|VSS
+ sky130_fd_sc_hd__nand2_1
X$5373 VDD synth_779 synth_763 synth_833 VDD VNB|VSS VNB|VSS
+ sky130_fd_sc_hd__nand2_1
X$5374 VDD synth_2969 synth_364 synth_2595 VDD VNB|VSS VNB|VSS
+ sky130_fd_sc_hd__nand2_1
X$5375 VDD synth_2116 synth_4526 synth_4524 VDD VNB|VSS VNB|VSS
+ sky130_fd_sc_hd__nand2_1
X$5376 VDD synth_194 synth_1557 synth_1352 VDD VNB|VSS VNB|VSS
+ sky130_fd_sc_hd__nand2_1
X$5377 VDD synth_7595 synth_7472 synth_7509 VDD VNB|VSS VNB|VSS
+ sky130_fd_sc_hd__nand2_1
X$5378 VDD synth_2107 synth_2125 synth_2091 VDD VNB|VSS VNB|VSS
+ sky130_fd_sc_hd__nand2_1
X$5379 VDD synth_10254 synth_10163 synth_10329 VDD VNB|VSS VNB|VSS
+ sky130_fd_sc_hd__nand2_1
X$5380 VDD synth_7014 synth_7090 synth_7015 VDD VNB|VSS VNB|VSS
+ sky130_fd_sc_hd__nand2_1
X$5381 VDD synth_10858 synth_5738 synth_10717 VDD VNB|VSS VNB|VSS
+ sky130_fd_sc_hd__nand2_1
X$5382 VDD synth_684 synth_765 synth_625 VDD VNB|VSS VNB|VSS
+ sky130_fd_sc_hd__nand2_1
X$5383 VDD synth_2808 synth_2548 synth_2673 VDD VNB|VSS VNB|VSS
+ sky130_fd_sc_hd__nand2_1
X$5384 VDD synth_662 synth_659 synth_696 VDD VNB|VSS VNB|VSS
+ sky130_fd_sc_hd__nand2_1
X$5385 VDD synth_1015 synth_1207 synth_1056 VDD VNB|VSS VNB|VSS
+ sky130_fd_sc_hd__nand2_1
X$5386 VDD synth_6029 synth_5805 synth_5948 VDD VNB|VSS VNB|VSS
+ sky130_fd_sc_hd__nand2_1
X$5387 VDD synth_280 synth_657 synth_95 VDD VNB|VSS VNB|VSS
+ sky130_fd_sc_hd__nand2_1
X$5388 VDD synth_194 synth_429 synth_263 VDD VNB|VSS VNB|VSS
+ sky130_fd_sc_hd__nand2_1
X$5389 VDD synth_6233 synth_6232 synth_6234 VDD VNB|VSS VNB|VSS
+ sky130_fd_sc_hd__nand2_1
X$5390 VDD synth_2227 synth_2064 synth_2065 VDD VNB|VSS VNB|VSS
+ sky130_fd_sc_hd__nand2_1
X$5391 VDD synth_782 synth_263 synth_464 VDD VNB|VSS VNB|VSS
+ sky130_fd_sc_hd__nand2_1
X$5392 VDD synth_4119 synth_4133 synth_3982 VDD VNB|VSS VNB|VSS
+ sky130_fd_sc_hd__nand2_1
X$5393 VDD synth_214 synth_429 synth_10 VDD VNB|VSS VNB|VSS
+ sky130_fd_sc_hd__nand2_1
X$5394 VDD synth_9427 synth_9895 synth_10372 VDD VNB|VSS VNB|VSS
+ sky130_fd_sc_hd__nand2_1
X$5395 VDD synth_816 synth_901 synth_813 VDD VNB|VSS VNB|VSS
+ sky130_fd_sc_hd__nand2_1
X$5396 VDD synth_364 synth_1979 synth_2139 VDD VNB|VSS VNB|VSS
+ sky130_fd_sc_hd__nand2_1
X$5397 VDD synth_1112 synth_364 synth_575 VDD VNB|VSS VNB|VSS
+ sky130_fd_sc_hd__nand2_1
X$5398 VDD synth_4316 synth_4149 synth_4229 VDD VNB|VSS VNB|VSS
+ sky130_fd_sc_hd__nand2_1
X$5399 VDD synth_4625 synth_4407 synth_4561 VDD VNB|VSS VNB|VSS
+ sky130_fd_sc_hd__nand2_1
X$5400 VDD synth_3619 synth_3548 synth_3618 VDD VNB|VSS VNB|VSS
+ sky130_fd_sc_hd__nand2_1
X$5401 VDD synth_3465 synth_3353 synth_3466 VDD VNB|VSS VNB|VSS
+ sky130_fd_sc_hd__nand2_1
X$5402 VDD synth_167 synth_2969 synth_2679 VDD VNB|VSS VNB|VSS
+ sky130_fd_sc_hd__nand2_1
X$5403 VDD synth_9550 synth_10728 synth_11214 VDD VNB|VSS VNB|VSS
+ sky130_fd_sc_hd__nand2_1
X$5404 VDD synth_1067 synth_1133 synth_802 VDD VNB|VSS VNB|VSS
+ sky130_fd_sc_hd__nand2_1
X$5405 VDD synth_3082 synth_2948 synth_3008 VDD VNB|VSS VNB|VSS
+ sky130_fd_sc_hd__nand2_1
X$5406 VDD synth_451 synth_364 synth_23 VDD VNB|VSS VNB|VSS
+ sky130_fd_sc_hd__nand2_1
X$5407 VDD synth_6263 synth_6250 synth_6248 VDD VNB|VSS VNB|VSS
+ sky130_fd_sc_hd__nand2_1
X$5408 VDD synth_3202 synth_3368 synth_3264 VDD VNB|VSS VNB|VSS
+ sky130_fd_sc_hd__nand2_1
X$5409 VDD synth_2010 synth_1964 synth_1887 VDD VNB|VSS VNB|VSS
+ sky130_fd_sc_hd__nand2_1
X$5410 VDD synth_11444 synth_11443 synth_11445 VDD VNB|VSS VNB|VSS
+ sky130_fd_sc_hd__nand2_1
X$5411 VDD synth_1268 synth_194 synth_1330 VDD VNB|VSS VNB|VSS
+ sky130_fd_sc_hd__nand2_1
X$5412 VDD synth_3919 synth_3887 synth_3922 VDD VNB|VSS VNB|VSS
+ sky130_fd_sc_hd__nand2_1
X$5413 VDD synth_6083 synth_5851 synth_6187 VDD VNB|VSS VNB|VSS
+ sky130_fd_sc_hd__nand2_1
X$5414 VDD synth_6613 synth_657 synth_6319 VDD VNB|VSS VNB|VSS
+ sky130_fd_sc_hd__nand2_1
X$5415 VDD synth_4265 synth_4149 synth_4228 VDD VNB|VSS VNB|VSS
+ sky130_fd_sc_hd__nand2_1
X$5416 VDD synth_2906 synth_2679 synth_2880 VDD VNB|VSS VNB|VSS
+ sky130_fd_sc_hd__nand2_1
X$5417 VDD synth_6208 synth_5982 synth_6282 VDD VNB|VSS VNB|VSS
+ sky130_fd_sc_hd__nand2_1
X$5418 VDD synth_334 synth_263 synth_264 VDD VNB|VSS VNB|VSS
+ sky130_fd_sc_hd__nand2_1
X$5419 VDD synth_6194 synth_6143 synth_6229 VDD VNB|VSS VNB|VSS
+ sky130_fd_sc_hd__nand2_1
X$5420 VDD synth_10051 synth_9921 synth_10053 VDD VNB|VSS VNB|VSS
+ sky130_fd_sc_hd__nand2_1
X$5421 VDD synth_5431 synth_5276 synth_5361 VDD VNB|VSS VNB|VSS
+ sky130_fd_sc_hd__nand2_1
X$5422 VDD synth_7861 synth_7783 synth_7841 VDD VNB|VSS VNB|VSS
+ sky130_fd_sc_hd__nand2_1
X$5423 VDD synth_1978 synth_364 synth_2133 VDD VNB|VSS VNB|VSS
+ sky130_fd_sc_hd__nand2_1
X$5424 VDD synth_5738 synth_6142 synth_6033 VDD VNB|VSS VNB|VSS
+ sky130_fd_sc_hd__nand2_1
X$5425 VDD synth_3544 synth_6142 synth_6143 VDD VNB|VSS VNB|VSS
+ sky130_fd_sc_hd__nand2_1
X$5426 VDD synth_8000 synth_9891 synth_10268 VDD VNB|VSS VNB|VSS
+ sky130_fd_sc_hd__nand2_1
X$5427 VDD synth_9762 synth_11307 synth_11306 VDD VNB|VSS VNB|VSS
+ sky130_fd_sc_hd__nand2_1
X$5428 VDD synth_8806 synth_11098 synth_11016 VDD VNB|VSS VNB|VSS
+ sky130_fd_sc_hd__nand2_1
X$5429 VDD synth_3378 synth_214 synth_3172 VDD VNB|VSS VNB|VSS
+ sky130_fd_sc_hd__nand2_1
X$5430 VDD synth_6200 synth_3632 synth_6239 VDD VNB|VSS VNB|VSS
+ sky130_fd_sc_hd__nand2_1
X$5431 VDD synth_4415 synth_4157 synth_4241 VDD VNB|VSS VNB|VSS
+ sky130_fd_sc_hd__nand2_1
X$5432 VDD synth_1338 synth_2641 synth_2642 VDD VNB|VSS VNB|VSS
+ sky130_fd_sc_hd__nand2_1
X$5433 VDD synth_9062 synth_8831 synth_9205 VDD VNB|VSS VNB|VSS
+ sky130_fd_sc_hd__nand2_1
X$5434 VDD synth_4156 synth_4157 synth_4239 VDD VNB|VSS VNB|VSS
+ sky130_fd_sc_hd__nand2_1
X$5435 VDD synth_8806 synth_10234 synth_9583 VDD VNB|VSS VNB|VSS
+ sky130_fd_sc_hd__nand2_1
X$5436 VDD synth_3386 synth_214 synth_3219 VDD VNB|VSS VNB|VSS
+ sky130_fd_sc_hd__nand2_1
X$5437 VDD synth_3632 synth_6049 synth_6349 VDD VNB|VSS VNB|VSS
+ sky130_fd_sc_hd__nand2_1
X$5438 VDD synth_7089 synth_7981 synth_7949 VDD VNB|VSS VNB|VSS
+ sky130_fd_sc_hd__nand2_1
X$5439 VDD synth_10571 synth_10268 synth_10503 VDD VNB|VSS VNB|VSS
+ sky130_fd_sc_hd__nand2_1
X$5440 VDD synth_9115 synth_9285 synth_9118 VDD VNB|VSS VNB|VSS
+ sky130_fd_sc_hd__nand2_1
X$5441 VDD synth_3509 synth_364 synth_3180 VDD VNB|VSS VNB|VSS
+ sky130_fd_sc_hd__nand2_1
X$5442 VDD synth_3631 synth_3701 synth_3699 VDD VNB|VSS VNB|VSS
+ sky130_fd_sc_hd__nand2_1
X$5443 VDD synth_5064 synth_5014 synth_5045 VDD VNB|VSS VNB|VSS
+ sky130_fd_sc_hd__nand2_1
X$5444 VDD synth_5020 synth_5083 synth_5022 VDD VNB|VSS VNB|VSS
+ sky130_fd_sc_hd__nand2_1
X$5445 VDD synth_2625 synth_1015 synth_3298 VDD VNB|VSS VNB|VSS
+ sky130_fd_sc_hd__nand2_1
X$5446 VDD synth_10606 synth_10679 synth_10680 VDD VNB|VSS VNB|VSS
+ sky130_fd_sc_hd__nand2_1
X$5447 VDD synth_2206 synth_2204 synth_2248 VDD VNB|VSS VNB|VSS
+ sky130_fd_sc_hd__nand2_1
X$5448 VDD synth_1015 synth_3699 synth_3755 VDD VNB|VSS VNB|VSS
+ sky130_fd_sc_hd__nand2_1
X$5449 VDD synth_10944 synth_10546 synth_11021 VDD VNB|VSS VNB|VSS
+ sky130_fd_sc_hd__nand2_1
X$5450 VDD synth_3632 synth_4091 synth_4157 VDD VNB|VSS VNB|VSS
+ sky130_fd_sc_hd__nand2_1
X$5451 VDD synth_944 synth_802 synth_804 VDD VNB|VSS VNB|VSS
+ sky130_fd_sc_hd__nand2_1
X$5452 VDD synth_3526 synth_3228 synth_3615 VDD VNB|VSS VNB|VSS
+ sky130_fd_sc_hd__nand2_1
X$5453 VDD synth_1167 synth_1092 synth_1126 VDD VNB|VSS VNB|VSS
+ sky130_fd_sc_hd__nand2_1
X$5454 VDD synth_9629 synth_10511 synth_10013 VDD VNB|VSS VNB|VSS
+ sky130_fd_sc_hd__nand2_1
X$5455 VDD synth_8930 synth_8895 synth_8727 VDD VNB|VSS VNB|VSS
+ sky130_fd_sc_hd__nand2_1
X$5456 VDD synth_5646 synth_3544 synth_5784 VDD VNB|VSS VNB|VSS
+ sky130_fd_sc_hd__nand2_1
X$5457 VDD synth_819 synth_614 synth_902 VDD VNB|VSS VNB|VSS
+ sky130_fd_sc_hd__nand2_1
X$5458 VDD synth_9119 synth_10212 synth_10580 VDD VNB|VSS VNB|VSS
+ sky130_fd_sc_hd__nand2_1
X$5459 VDD synth_10678 synth_10625 synth_10681 VDD VNB|VSS VNB|VSS
+ sky130_fd_sc_hd__nand2_1
X$5460 VDD synth_10361 synth_10437 synth_10365 VDD VNB|VSS VNB|VSS
+ sky130_fd_sc_hd__nand2_1
X$5461 VDD synth_11374 synth_9762 synth_11533 VDD VNB|VSS VNB|VSS
+ sky130_fd_sc_hd__nand2_1
X$5462 VDD synth_3616 synth_7317 synth_7249 VDD VNB|VSS VNB|VSS
+ sky130_fd_sc_hd__nand2_1
X$5463 VDD synth_6195 synth_6143 synth_6145 VDD VNB|VSS VNB|VSS
+ sky130_fd_sc_hd__nand2_1
X$5464 VDD synth_1015 synth_4913 synth_4787 VDD VNB|VSS VNB|VSS
+ sky130_fd_sc_hd__nand2_1
X$5465 VDD synth_341 synth_60 synth_93 VDD VNB|VSS VNB|VSS
+ sky130_fd_sc_hd__nand2_1
X$5466 VDD synth_5458 synth_5492 synth_5493 VDD VNB|VSS VNB|VSS
+ sky130_fd_sc_hd__nand2_1
X$5467 VDD synth_1587 synth_66 synth_1778 VDD VNB|VSS VNB|VSS
+ sky130_fd_sc_hd__nand2_1
X$5468 VDD synth_9434 synth_9895 synth_10361 VDD VNB|VSS VNB|VSS
+ sky130_fd_sc_hd__nand2_1
X$5469 VDD synth_659 synth_1624 synth_1496 VDD VNB|VSS VNB|VSS
+ sky130_fd_sc_hd__nand2_1
X$5470 VDD synth_3057 synth_3058 synth_3101 VDD VNB|VSS VNB|VSS
+ sky130_fd_sc_hd__nand2_1
X$5471 VDD synth_3164 synth_3058 synth_3130 VDD VNB|VSS VNB|VSS
+ sky130_fd_sc_hd__nand2_1
X$5472 VDD synth_8029 synth_7815 synth_7589 VDD VNB|VSS VNB|VSS
+ sky130_fd_sc_hd__nand2_1
X$5473 VDD synth_6403 synth_5196 synth_6889 VDD VNB|VSS VNB|VSS
+ sky130_fd_sc_hd__nand2_1
X$5474 VDD synth_396 synth_217 synth_328 VDD VNB|VSS VNB|VSS
+ sky130_fd_sc_hd__nand2_1
X$5475 VDD synth_4357 synth_4441 synth_4274 VDD VNB|VSS VNB|VSS
+ sky130_fd_sc_hd__nand2_1
X$5476 VDD synth_167 synth_2884 synth_2548 VDD VNB|VSS VNB|VSS
+ sky130_fd_sc_hd__nand2_1
X$5477 VDD synth_9024 synth_8958 synth_9079 VDD VNB|VSS VNB|VSS
+ sky130_fd_sc_hd__nand2_1
X$5478 VDD synth_4091 synth_1015 synth_3958 VDD VNB|VSS VNB|VSS
+ sky130_fd_sc_hd__nand2_1
X$5479 VDD synth_785 synth_802 synth_806 VDD VNB|VSS VNB|VSS
+ sky130_fd_sc_hd__nand2_1
X$5480 VDD synth_214 synth_1133 synth_736 VDD VNB|VSS VNB|VSS
+ sky130_fd_sc_hd__nand2_1
X$5481 VDD synth_10285 synth_10362 synth_10412 VDD VNB|VSS VNB|VSS
+ sky130_fd_sc_hd__nand2_1
X$5482 VDD synth_9992 synth_9914 synth_10136 VDD VNB|VSS VNB|VSS
+ sky130_fd_sc_hd__nand2_1
X$5483 VDD synth_12503 synth_12504 synth_12564 VDD VNB|VSS VNB|VSS
+ sky130_fd_sc_hd__nand2_1
X$5484 VDD synth_194 synth_274 synth_60 VDD VNB|VSS VNB|VSS
+ sky130_fd_sc_hd__nand2_1
X$5485 VDD synth_2397 synth_364 synth_1973 VDD VNB|VSS VNB|VSS
+ sky130_fd_sc_hd__nand2_1
X$5486 VDD synth_5738 synth_9757 synth_9917 VDD VNB|VSS VNB|VSS
+ sky130_fd_sc_hd__nand2_1
X$5487 VDD synth_8806 synth_9036 synth_11465 VDD VNB|VSS VNB|VSS
+ sky130_fd_sc_hd__nand2_1
X$5488 VDD synth_1452 synth_1196 synth_1373 VDD VNB|VSS VNB|VSS
+ sky130_fd_sc_hd__nand2_1
X$5489 VDD synth_1067 synth_974 synth_737 VDD VNB|VSS VNB|VSS
+ sky130_fd_sc_hd__nand2_1
X$5490 VDD synth_9629 synth_11095 synth_9514 VDD VNB|VSS VNB|VSS
+ sky130_fd_sc_hd__nand2_1
X$5491 VDD synth_5328 synth_5492 synth_5597 VDD VNB|VSS VNB|VSS
+ sky130_fd_sc_hd__nand2_1
X$5492 VDD synth_4796 synth_1015 synth_4793 VDD VNB|VSS VNB|VSS
+ sky130_fd_sc_hd__nand2_1
X$5493 VDD synth_5862 synth_5750 synth_5751 VDD VNB|VSS VNB|VSS
+ sky130_fd_sc_hd__nand2_1
X$5494 VDD synth_4592 synth_4656 synth_4798 VDD VNB|VSS VNB|VSS
+ sky130_fd_sc_hd__nand2_1
X$5495 VDD synth_5860 synth_5750 synth_5777 VDD VNB|VSS VNB|VSS
+ sky130_fd_sc_hd__nand2_1
X$5496 VDD synth_3616 synth_9300 synth_9164 VDD VNB|VSS VNB|VSS
+ sky130_fd_sc_hd__nand2_1
X$5497 VDD synth_6597 synth_5988 synth_6603 VDD VNB|VSS VNB|VSS
+ sky130_fd_sc_hd__nand2_1
X$5498 VDD synth_1178 synth_1253 synth_1257 VDD VNB|VSS VNB|VSS
+ sky130_fd_sc_hd__nand2_1
X$5499 VDD synth_5724 synth_1015 synth_5611 VDD VNB|VSS VNB|VSS
+ sky130_fd_sc_hd__nand2_1
X$5500 VDD synth_12231 synth_12229 synth_12210 VDD VNB|VSS VNB|VSS
+ sky130_fd_sc_hd__nand2_1
X$5501 VDD synth_4310 synth_4369 synth_4368 VDD VNB|VSS VNB|VSS
+ sky130_fd_sc_hd__nand2_1
X$5502 VDD synth_10285 synth_8870 synth_10220 VDD VNB|VSS VNB|VSS
+ sky130_fd_sc_hd__nand2_1
X$5503 VDD synth_3468 synth_5724 synth_5750 VDD VNB|VSS VNB|VSS
+ sky130_fd_sc_hd__nand2_1
X$5504 VDD synth_11829 synth_5738 synth_12318 VDD VNB|VSS VNB|VSS
+ sky130_fd_sc_hd__nand2_1
X$5505 VDD synth_1623 synth_1496 synth_1596 VDD VNB|VSS VNB|VSS
+ sky130_fd_sc_hd__nand2_1
X$5506 VDD synth_5816 synth_5747 synth_5749 VDD VNB|VSS VNB|VSS
+ sky130_fd_sc_hd__nand2_1
X$5507 VDD synth_1028 synth_737 synth_810 VDD VNB|VSS VNB|VSS
+ sky130_fd_sc_hd__nand2_1
X$5508 VDD synth_1015 synth_1624 synth_1383 VDD VNB|VSS VNB|VSS
+ sky130_fd_sc_hd__nand2_1
X$5509 VDD synth_11944 synth_12001 synth_12119 VDD VNB|VSS VNB|VSS
+ sky130_fd_sc_hd__nand2_1
X$5510 VDD synth_214 synth_974 synth_740 VDD VNB|VSS VNB|VSS
+ sky130_fd_sc_hd__nand2_1
X$5511 VDD synth_5067 synth_5048 synth_4924 VDD VNB|VSS VNB|VSS
+ sky130_fd_sc_hd__nand2_1
X$5512 VDD synth_3632 synth_4325 synth_5068 VDD VNB|VSS VNB|VSS
+ sky130_fd_sc_hd__nand2_1
X$5513 VDD synth_5463 synth_5160 synth_5380 VDD VNB|VSS VNB|VSS
+ sky130_fd_sc_hd__nand2_1
X$5514 VDD synth_11321 synth_11217 synth_11438 VDD VNB|VSS VNB|VSS
+ sky130_fd_sc_hd__nand2_1
X$5515 VDD synth_3189 synth_3248 synth_3188 VDD VNB|VSS VNB|VSS
+ sky130_fd_sc_hd__nand2_1
X$5516 VDD synth_2857 synth_2855 synth_2681 VDD VNB|VSS VNB|VSS
+ sky130_fd_sc_hd__nand2_1
X$5517 VDD synth_1227 synth_1272 synth_1273 VDD VNB|VSS VNB|VSS
+ sky130_fd_sc_hd__nand2_1
X$5518 VDD synth_3468 synth_5726 synth_6606 VDD VNB|VSS VNB|VSS
+ sky130_fd_sc_hd__nand2_1
X$5519 VDD synth_11512 synth_11312 synth_11361 VDD VNB|VSS VNB|VSS
+ sky130_fd_sc_hd__nand2_1
X$5520 VDD synth_1015 synth_1501 synth_1336 VDD VNB|VSS VNB|VSS
+ sky130_fd_sc_hd__nand2_1
X$5521 VDD synth_9773 synth_9930 synth_9435 VDD VNB|VSS VNB|VSS
+ sky130_fd_sc_hd__nand2_1
X$5522 VDD synth_750 synth_614 synth_720 VDD VNB|VSS VNB|VSS
+ sky130_fd_sc_hd__nand2_1
X$5523 VDD synth_10357 synth_10268 synth_10341 VDD VNB|VSS VNB|VSS
+ sky130_fd_sc_hd__nand2_1
X$5524 VDD synth_941 synth_364 synth_766 VDD VNB|VSS VNB|VSS
+ sky130_fd_sc_hd__nand2_1
X$5525 VDD synth_5119 synth_5068 synth_5015 VDD VNB|VSS VNB|VSS
+ sky130_fd_sc_hd__nand2_1
X$5526 VDD synth_6717 synth_657 synth_6850 VDD VNB|VSS VNB|VSS
+ sky130_fd_sc_hd__nand2_1
X$5527 VDD synth_167 synth_941 synth_1086 VDD VNB|VSS VNB|VSS
+ sky130_fd_sc_hd__nand2_1
X$5528 VDD synth_5355 synth_5276 synth_5356 VDD VNB|VSS VNB|VSS
+ sky130_fd_sc_hd__nand2_1
X$5529 VDD synth_888 synth_194 synth_981 VDD VNB|VSS VNB|VSS
+ sky130_fd_sc_hd__nand2_1
X$5530 VDD synth_721 synth_1116 synth_1038 VDD VNB|VSS VNB|VSS
+ sky130_fd_sc_hd__nand2_1
X$5531 VDD synth_5651 synth_5121 synth_5332 VDD VNB|VSS VNB|VSS
+ sky130_fd_sc_hd__nand2_1
X$5532 VDD synth_1546 synth_1632 synth_1611 VDD VNB|VSS VNB|VSS
+ sky130_fd_sc_hd__nand2_1
X$5533 VDD synth_11423 synth_11306 synth_11422 VDD VNB|VSS VNB|VSS
+ sky130_fd_sc_hd__nand2_1
X$5534 VDD synth_3598 synth_3555 synth_3597 VDD VNB|VSS VNB|VSS
+ sky130_fd_sc_hd__nand2_1
X$5535 VDD synth_3616 synth_7910 synth_7772 VDD VNB|VSS VNB|VSS
+ sky130_fd_sc_hd__nand2_1
X$5536 VDD synth_8619 synth_8530 synth_8531 VDD VNB|VSS VNB|VSS
+ sky130_fd_sc_hd__nand2_1
X$5537 VDD synth_853 synth_1059 synth_1095 VDD VNB|VSS VNB|VSS
+ sky130_fd_sc_hd__nand2_1
X$5538 VDD synth_10285 synth_10170 synth_12385 VDD VNB|VSS VNB|VSS
+ sky130_fd_sc_hd__nand2_1
X$5539 VDD synth_2116 synth_3378 synth_3228 VDD VNB|VSS VNB|VSS
+ sky130_fd_sc_hd__nand2_1
X$5540 VDD synth_1737 synth_1736 synth_1786 VDD VNB|VSS VNB|VSS
+ sky130_fd_sc_hd__nand2_1
X$5541 VDD synth_1038 synth_214 synth_655 VDD VNB|VSS VNB|VSS
+ sky130_fd_sc_hd__nand2_1
X$5542 VDD synth_1015 synth_1313 synth_1105 VDD VNB|VSS VNB|VSS
+ sky130_fd_sc_hd__nand2_1
X$5543 VDD synth_2240 synth_2310 synth_2423 VDD VNB|VSS VNB|VSS
+ sky130_fd_sc_hd__nand2_1
X$5544 VDD synth_8604 synth_8831 synth_9850 VDD VNB|VSS VNB|VSS
+ sky130_fd_sc_hd__nand2_1
X$5545 VDD synth_6612 synth_6457 synth_6580 VDD VNB|VSS VNB|VSS
+ sky130_fd_sc_hd__nand2_1
X$5546 VDD synth_1229 synth_1259 synth_1481 VDD VNB|VSS VNB|VSS
+ sky130_fd_sc_hd__nand2_1
X$5547 VDD synth_7089 synth_6018 synth_7009 VDD VNB|VSS VNB|VSS
+ sky130_fd_sc_hd__nand2_1
X$5548 VDD synth_199 synth_194 synth_462 VDD VNB|VSS VNB|VSS
+ sky130_fd_sc_hd__nand2_1
X$5549 VDD synth_3669 synth_3555 synth_3556 VDD VNB|VSS VNB|VSS
+ sky130_fd_sc_hd__nand2_1
X$5550 VDD synth_1020 synth_1059 synth_1096 VDD VNB|VSS VNB|VSS
+ sky130_fd_sc_hd__nand2_1
X$5551 VDD synth_7319 synth_7381 synth_7317 VDD VNB|VSS VNB|VSS
+ sky130_fd_sc_hd__nand2_1
X$5552 VDD synth_10096 synth_8738 synth_10095 VDD VNB|VSS VNB|VSS
+ sky130_fd_sc_hd__nand2_1
X$5553 VDD synth_3616 synth_6596 synth_6335 VDD VNB|VSS VNB|VSS
+ sky130_fd_sc_hd__nand2_1
X$5554 VDD synth_2005 synth_2006 synth_1971 VDD VNB|VSS VNB|VSS
+ sky130_fd_sc_hd__nand2_1
X$5555 VDD synth_214 synth_426 synth_8 VDD VNB|VSS VNB|VSS
+ sky130_fd_sc_hd__nand2_1
X$5556 VDD synth_3882 synth_3898 synth_4163 VDD VNB|VSS VNB|VSS
+ sky130_fd_sc_hd__nand2_1
X$5557 VDD synth_3694 synth_1015 synth_3301 VDD VNB|VSS VNB|VSS
+ sky130_fd_sc_hd__nand2_1
X$5558 VDD synth_2037 synth_2386 synth_2691 VDD VNB|VSS VNB|VSS
+ sky130_fd_sc_hd__nand2_1
X$5559 VDD synth_7743 synth_8649 synth_8345 VDD VNB|VSS VNB|VSS
+ sky130_fd_sc_hd__nand2_1
X$5560 VDD synth_194 synth_1038 synth_614 VDD VNB|VSS VNB|VSS
+ sky130_fd_sc_hd__nand2_1
X$5561 VDD synth_5467 synth_5121 synth_5391 VDD VNB|VSS VNB|VSS
+ sky130_fd_sc_hd__nand2_1
X$5562 VDD synth_11922 synth_5738 synth_11804 VDD VNB|VSS VNB|VSS
+ sky130_fd_sc_hd__nand2_1
X$5563 VDD synth_3269 synth_2829 synth_2985 VDD VNB|VSS VNB|VSS
+ sky130_fd_sc_hd__nand2_1
X$5564 VDD synth_10722 synth_10554 synth_10792 VDD VNB|VSS VNB|VSS
+ sky130_fd_sc_hd__nand2_1
X$5565 VDD synth_10164 synth_9806 synth_10625 VDD VNB|VSS VNB|VSS
+ sky130_fd_sc_hd__nand2_1
X$5566 VDD synth_3632 synth_4800 synth_5121 VDD VNB|VSS VNB|VSS
+ sky130_fd_sc_hd__nand2_1
X$5567 VDD synth_1104 synth_1086 synth_1087 VDD VNB|VSS VNB|VSS
+ sky130_fd_sc_hd__nand2_1
X$5568 VDD synth_1505 synth_1425 synth_1470 VDD VNB|VSS VNB|VSS
+ sky130_fd_sc_hd__nand2_1
X$5569 VDD synth_2426 synth_2273 synth_2275 VDD VNB|VSS VNB|VSS
+ sky130_fd_sc_hd__nand2_1
X$5570 VDD synth_2740 synth_2665 synth_2666 VDD VNB|VSS VNB|VSS
+ sky130_fd_sc_hd__nand2_1
X$5571 VDD synth_5071 synth_3632 synth_5235 VDD VNB|VSS VNB|VSS
+ sky130_fd_sc_hd__nand2_1
X$5572 VDD synth_1457 synth_1297 synth_1298 VDD VNB|VSS VNB|VSS
+ sky130_fd_sc_hd__nand2_1
X$5573 VDD synth_7545 synth_7196 synth_8175 VDD VNB|VSS VNB|VSS
+ sky130_fd_sc_hd__nand2_1
X$5574 VDD synth_10658 synth_10677 synth_10820 VDD VNB|VSS VNB|VSS
+ sky130_fd_sc_hd__nand2_1
X$5575 VDD synth_1220 synth_1279 synth_1323 VDD VNB|VSS VNB|VSS
+ sky130_fd_sc_hd__nand2_1
X$5576 VDD synth_5219 synth_5014 synth_5046 VDD VNB|VSS VNB|VSS
+ sky130_fd_sc_hd__nand2_1
X$5577 VDD synth_1067 synth_3699 synth_3461 VDD VNB|VSS VNB|VSS
+ sky130_fd_sc_hd__nand2_1
X$5578 VDD synth_10446 synth_10378 synth_10315 VDD VNB|VSS VNB|VSS
+ sky130_fd_sc_hd__nand2_1
X$5579 VDD synth_8873 synth_8872 synth_9774 VDD VNB|VSS VNB|VSS
+ sky130_fd_sc_hd__nand2_1
X$5580 VDD synth_3891 synth_3793 synth_3892 VDD VNB|VSS VNB|VSS
+ sky130_fd_sc_hd__nand2_1
X$5581 VDD synth_4017 synth_4016 synth_4014 VDD VNB|VSS VNB|VSS
+ sky130_fd_sc_hd__nand2_1
X$5582 VDD synth_6638 synth_6411 synth_6582 VDD VNB|VSS VNB|VSS
+ sky130_fd_sc_hd__nand2_1
X$5583 VDD synth_3946 synth_3896 synth_3685 VDD VNB|VSS VNB|VSS
+ sky130_fd_sc_hd__nand2_1
X$5584 VDD synth_422 synth_495 synth_423 VDD VNB|VSS VNB|VSS
+ sky130_fd_sc_hd__nand2_1
X$5585 VDD synth_5546 synth_5252 synth_5594 VDD VNB|VSS VNB|VSS
+ sky130_fd_sc_hd__nand2_1
X$5586 VDD synth_1015 synth_4014 synth_3998 VDD VNB|VSS VNB|VSS
+ sky130_fd_sc_hd__nand2_1
X$5587 VDD synth_1338 synth_4014 synth_4149 VDD VNB|VSS VNB|VSS
+ sky130_fd_sc_hd__nand2_1
X$5588 VDD synth_5498 synth_5121 synth_5229 VDD VNB|VSS VNB|VSS
+ sky130_fd_sc_hd__nand2_1
X$5589 VDD synth_3616 synth_6018 synth_6953 VDD VNB|VSS VNB|VSS
+ sky130_fd_sc_hd__nand2_1
X$5590 VDD synth_420 synth_495 synth_496 VDD VNB|VSS VNB|VSS
+ sky130_fd_sc_hd__nand2_1
X$5591 VDD synth_3350 synth_3461 synth_3558 VDD VNB|VSS VNB|VSS
+ sky130_fd_sc_hd__nand2_1
X$5592 VDD synth_4683 synth_4753 synth_4754 VDD VNB|VSS VNB|VSS
+ sky130_fd_sc_hd__nand2_1
X$5593 VDD synth_4973 synth_5083 synth_5096 VDD VNB|VSS VNB|VSS
+ sky130_fd_sc_hd__nand2_1
X$5594 VDD synth_8206 synth_7956 synth_8207 VDD VNB|VSS VNB|VSS
+ sky130_fd_sc_hd__nand2_1
X$5595 VDD synth_4946 synth_4753 synth_4947 VDD VNB|VSS VNB|VSS
+ sky130_fd_sc_hd__nand2_1
X$5596 VDD synth_9432 synth_9547 synth_9606 VDD VNB|VSS VNB|VSS
+ sky130_fd_sc_hd__nand2_1
X$5597 VDD synth_6584 synth_6349 synth_6653 VDD VNB|VSS VNB|VSS
+ sky130_fd_sc_hd__nand2_1
X$5598 VDD synth_712 synth_214 synth_512 VDD VNB|VSS VNB|VSS
+ sky130_fd_sc_hd__nand2_1
X$5599 VDD synth_5144 synth_5143 synth_4800 VDD VNB|VSS VNB|VSS
+ sky130_fd_sc_hd__nand2_1
X$5600 VDD synth_1067 synth_3694 synth_3793 VDD VNB|VSS VNB|VSS
+ sky130_fd_sc_hd__nand2_1
X$5601 VDD synth_2902 synth_2852 synth_2980 VDD VNB|VSS VNB|VSS
+ sky130_fd_sc_hd__nand2_1
X$5602 VDD synth_8803 synth_10578 synth_10308 VDD VNB|VSS VNB|VSS
+ sky130_fd_sc_hd__nand2_1
X$5603 VDD synth_9474 synth_8948 synth_12236 VDD VNB|VSS VNB|VSS
+ sky130_fd_sc_hd__nand2_1
X$5604 VDD synth_4108 synth_4199 synth_4232 VDD VNB|VSS VNB|VSS
+ sky130_fd_sc_hd__nand2_1
X$5605 VDD synth_3616 synth_9305 synth_9218 VDD VNB|VSS VNB|VSS
+ sky130_fd_sc_hd__nand2_1
X$5606 VDD synth_8476 synth_8331 synth_8332 VDD VNB|VSS VNB|VSS
+ sky130_fd_sc_hd__nand2_1
X$5607 VDD synth_2762 synth_3044 synth_3080 VDD VNB|VSS VNB|VSS
+ sky130_fd_sc_hd__nand2_1
X$5608 VDD synth_12075 synth_11984 synth_11986 VDD VNB|VSS VNB|VSS
+ sky130_fd_sc_hd__nand2_1
X$5609 VDD synth_8738 synth_8870 synth_9324 VDD VNB|VSS VNB|VSS
+ sky130_fd_sc_hd__nand2_1
X$5610 VDD synth_167 synth_3772 synth_3476 VDD VNB|VSS VNB|VSS
+ sky130_fd_sc_hd__nand2_1
X$5611 VDD synth_2115 synth_1882 synth_2169 VDD VNB|VSS VNB|VSS
+ sky130_fd_sc_hd__nand2_1
X$5612 VDD synth_5520 synth_5691 synth_5831 VDD VNB|VSS VNB|VSS
+ sky130_fd_sc_hd__nand2_1
X$5613 VDD synth_7188 synth_7187 synth_7257 VDD VNB|VSS VNB|VSS
+ sky130_fd_sc_hd__nand2_1
X$5614 VDD synth_9762 synth_11658 synth_12572 VDD VNB|VSS VNB|VSS
+ sky130_fd_sc_hd__nand2_1
X$5615 VDD synth_1442 synth_364 synth_1188 VDD VNB|VSS VNB|VSS
+ sky130_fd_sc_hd__nand2_1
X$5616 VDD synth_12432 synth_12572 synth_12571 VDD VNB|VSS VNB|VSS
+ sky130_fd_sc_hd__nand2_1
X$5617 VDD synth_10201 synth_9914 synth_9991 VDD VNB|VSS VNB|VSS
+ sky130_fd_sc_hd__nand2_1
X$5618 VDD synth_8423 synth_8754 synth_8792 VDD VNB|VSS VNB|VSS
+ sky130_fd_sc_hd__nand2_1
X$5619 VDD synth_8671 synth_8754 synth_8843 VDD VNB|VSS VNB|VSS
+ sky130_fd_sc_hd__nand2_1
X$5620 VDD synth_8384 synth_7196 synth_8386 VDD VNB|VSS VNB|VSS
+ sky130_fd_sc_hd__nand2_1
X$5621 VDD synth_7296 synth_7035 synth_7206 VDD VNB|VSS VNB|VSS
+ sky130_fd_sc_hd__nand2_1
X$5622 VDD synth_2056 synth_2052 synth_2099 VDD VNB|VSS VNB|VSS
+ sky130_fd_sc_hd__nand2_1
X$5623 VDD synth_2192 synth_214 synth_1638 VDD VNB|VSS VNB|VSS
+ sky130_fd_sc_hd__nand2_1
X$5624 VDD synth_6553 synth_6606 synth_6646 VDD VNB|VSS VNB|VSS
+ sky130_fd_sc_hd__nand2_1
X$5625 VDD synth_9387 synth_10060 synth_11319 VDD VNB|VSS VNB|VSS
+ sky130_fd_sc_hd__nand2_1
X$5626 VDD synth_6799 synth_6665 synth_6718 VDD VNB|VSS VNB|VSS
+ sky130_fd_sc_hd__nand2_1
X$5627 VDD synth_4931 synth_214 synth_4595 VDD VNB|VSS VNB|VSS
+ sky130_fd_sc_hd__nand2_1
X$5628 VDD synth_8752 synth_8750 synth_8855 VDD VNB|VSS VNB|VSS
+ sky130_fd_sc_hd__nand2_1
X$5629 VDD synth_8764 synth_8870 synth_9048 VDD VNB|VSS VNB|VSS
+ sky130_fd_sc_hd__nand2_1
X$5630 VDD synth_10069 synth_10067 synth_10068 VDD VNB|VSS VNB|VSS
+ sky130_fd_sc_hd__nand2_1
X$5631 VDD synth_364 synth_444 synth_14 VDD VNB|VSS VNB|VSS
+ sky130_fd_sc_hd__nand2_1
X$5632 VDD synth_2302 synth_2209 synth_2238 VDD VNB|VSS VNB|VSS
+ sky130_fd_sc_hd__nand2_1
X$5633 VDD synth_7183 synth_8070 synth_7916 VDD VNB|VSS VNB|VSS
+ sky130_fd_sc_hd__nand2_1
X$5634 VDD synth_151 synth_910 synth_678 VDD VNB|VSS VNB|VSS
+ sky130_fd_sc_hd__nand2_1
X$5635 VDD synth_8997 synth_9056 synth_8750 VDD VNB|VSS VNB|VSS
+ sky130_fd_sc_hd__nand2_1
X$5636 VDD synth_1997 synth_2209 synth_2239 VDD VNB|VSS VNB|VSS
+ sky130_fd_sc_hd__nand2_1
X$5637 VDD synth_874 synth_666 synth_743 VDD VNB|VSS VNB|VSS
+ sky130_fd_sc_hd__nand2_1
X$5638 VDD synth_3616 synth_8070 synth_7757 VDD VNB|VSS VNB|VSS
+ sky130_fd_sc_hd__nand2_1
X$5639 VDD synth_1446 synth_1561 synth_1445 VDD VNB|VSS VNB|VSS
+ sky130_fd_sc_hd__nand2_1
X$5640 VDD synth_7994 synth_7916 synth_7917 VDD VNB|VSS VNB|VSS
+ sky130_fd_sc_hd__nand2_1
X$5641 VDD synth_2802 synth_657 synth_2427 VDD VNB|VSS VNB|VSS
+ sky130_fd_sc_hd__nand2_1
X$5642 VDD synth_3071 synth_2994 synth_3103 VDD VNB|VSS VNB|VSS
+ sky130_fd_sc_hd__nand2_1
X$5643 VDD synth_7089 synth_9305 synth_9686 VDD VNB|VSS VNB|VSS
+ sky130_fd_sc_hd__nand2_1
X$5644 VDD synth_9322 synth_12560 synth_12345 VDD VNB|VSS VNB|VSS
+ sky130_fd_sc_hd__nand2_1
X$5645 VDD synth_5180 synth_5050 synth_5181 VDD VNB|VSS VNB|VSS
+ sky130_fd_sc_hd__nand2_1
X$5646 VDD synth_5473 synth_5336 synth_5474 VDD VNB|VSS VNB|VSS
+ sky130_fd_sc_hd__nand2_1
X$5647 VDD synth_7610 synth_7691 synth_7776 VDD VNB|VSS VNB|VSS
+ sky130_fd_sc_hd__nand2_1
X$5648 VDD synth_8000 synth_9890 synth_9914 VDD VNB|VSS VNB|VSS
+ sky130_fd_sc_hd__nand2_1
X$5649 VDD synth_151 synth_279 synth_278 VDD VNB|VSS VNB|VSS
+ sky130_fd_sc_hd__nand2_1
X$5650 VDD synth_11739 synth_11707 synth_11771 VDD VNB|VSS VNB|VSS
+ sky130_fd_sc_hd__nand2_1
X$5651 VDD synth_3468 synth_5318 synth_5336 VDD VNB|VSS VNB|VSS
+ sky130_fd_sc_hd__nand2_1
X$5652 VDD synth_1722 synth_1723 synth_1782 VDD VNB|VSS VNB|VSS
+ sky130_fd_sc_hd__nand2_1
X$5653 VDD synth_5730 synth_3541 synth_5927 VDD VNB|VSS VNB|VSS
+ sky130_fd_sc_hd__nand2_1
X$5654 VDD synth_11833 synth_11707 synth_11738 VDD VNB|VSS VNB|VSS
+ sky130_fd_sc_hd__nand2_1
X$5655 VDD synth_10793 synth_12236 synth_12285 VDD VNB|VSS VNB|VSS
+ sky130_fd_sc_hd__nand2_1
X$5656 VDD synth_3933 synth_3767 synth_3902 VDD VNB|VSS VNB|VSS
+ sky130_fd_sc_hd__nand2_1
X$5657 VDD synth_5738 synth_9890 synth_9842 VDD VNB|VSS VNB|VSS
+ sky130_fd_sc_hd__nand2_1
X$5658 VDD synth_3468 synth_4283 synth_4359 VDD VNB|VSS VNB|VSS
+ sky130_fd_sc_hd__nand2_1
X$5659 VDD synth_356 synth_364 synth_9 VDD VNB|VSS VNB|VSS
+ sky130_fd_sc_hd__nand2_1
X$5660 VDD synth_8000 synth_9500 synth_9501 VDD VNB|VSS VNB|VSS
+ sky130_fd_sc_hd__nand2_1
X$5661 VDD synth_9042 synth_9427 synth_9565 VDD VNB|VSS VNB|VSS
+ sky130_fd_sc_hd__nand2_1
X$5662 VDD synth_10164 synth_10497 synth_10295 VDD VNB|VSS VNB|VSS
+ sky130_fd_sc_hd__nand2_1
X$5663 VDD synth_5334 synth_5336 synth_5393 VDD VNB|VSS VNB|VSS
+ sky130_fd_sc_hd__nand2_1
X$5664 VDD synth_2636 synth_2537 synth_2563 VDD VNB|VSS VNB|VSS
+ sky130_fd_sc_hd__nand2_1
X$5665 VDD synth_1015 synth_2029 synth_1982 VDD VNB|VSS VNB|VSS
+ sky130_fd_sc_hd__nand2_1
X$5666 VDD synth_4747 synth_5910 synth_5851 VDD VNB|VSS VNB|VSS
+ sky130_fd_sc_hd__nand2_1
X$5667 VDD synth_9502 synth_9501 synth_9551 VDD VNB|VSS VNB|VSS
+ sky130_fd_sc_hd__nand2_1
X$5668 VDD synth_5190 synth_4823 synth_4859 VDD VNB|VSS VNB|VSS
+ sky130_fd_sc_hd__nand2_1
X$5669 VDD synth_9449 synth_9299 synth_9359 VDD VNB|VSS VNB|VSS
+ sky130_fd_sc_hd__nand2_1
X$5670 VDD synth_5360 synth_5479 synth_5480 VDD VNB|VSS VNB|VSS
+ sky130_fd_sc_hd__nand2_1
X$5671 VDD synth_10312 synth_12348 synth_12107 VDD VNB|VSS VNB|VSS
+ sky130_fd_sc_hd__nand2_1
X$5672 VDD synth_9514 synth_12644 synth_12666 VDD VNB|VSS VNB|VSS
+ sky130_fd_sc_hd__nand2_1
X$5673 VDD synth_5398 synth_5482 synth_5576 VDD VNB|VSS VNB|VSS
+ sky130_fd_sc_hd__nand2_1
X$5674 VDD synth_7494 synth_7196 synth_7616 VDD VNB|VSS VNB|VSS
+ sky130_fd_sc_hd__nand2_1
X$5675 VDD synth_110 synth_97 synth_111 VDD VNB|VSS VNB|VSS
+ sky130_fd_sc_hd__nand2_1
X$5676 VDD synth_4824 synth_4823 synth_4905 VDD VNB|VSS VNB|VSS
+ sky130_fd_sc_hd__nand2_1
X$5677 VDD synth_3016 synth_3175 synth_3217 VDD VNB|VSS VNB|VSS
+ sky130_fd_sc_hd__nand2_1
X$5678 VDD synth_12593 synth_12710 synth_12524 VDD VNB|VSS VNB|VSS
+ sky130_fd_sc_hd__nand2_1
X$5679 VDD synth_7928 synth_8000 synth_7978 VDD VNB|VSS VNB|VSS
+ sky130_fd_sc_hd__nand2_1
X$5680 VDD synth_1015 synth_2466 synth_2185 VDD VNB|VSS VNB|VSS
+ sky130_fd_sc_hd__nand2_1
X$5681 VDD synth_9404 synth_9299 synth_9357 VDD VNB|VSS VNB|VSS
+ sky130_fd_sc_hd__nand2_1
X$5682 VDD synth_8974 synth_9052 synth_8933 VDD VNB|VSS VNB|VSS
+ sky130_fd_sc_hd__nand2_1
X$5683 VDD synth_7089 synth_9300 synth_9299 VDD VNB|VSS VNB|VSS
+ sky130_fd_sc_hd__nand2_1
X$5684 VDD synth_2693 synth_2590 synth_2660 VDD VNB|VSS VNB|VSS
+ sky130_fd_sc_hd__nand2_1
X$5685 VDD synth_5663 synth_5606 synth_5641 VDD VNB|VSS VNB|VSS
+ sky130_fd_sc_hd__nand2_1
X$5686 VDD synth_1015 synth_2669 synth_2292 VDD VNB|VSS VNB|VSS
+ sky130_fd_sc_hd__nand2_1
X$5687 VDD synth_7739 synth_7586 synth_7663 VDD VNB|VSS VNB|VSS
+ sky130_fd_sc_hd__nand2_1
X$5688 VDD synth_7796 synth_7866 synth_7494 VDD VNB|VSS VNB|VSS
+ sky130_fd_sc_hd__nand2_1
X$5689 VDD synth_8910 synth_8870 synth_9833 VDD VNB|VSS VNB|VSS
+ sky130_fd_sc_hd__nand2_1
X$5690 VDD synth_6865 synth_6797 synth_6741 VDD VNB|VSS VNB|VSS
+ sky130_fd_sc_hd__nand2_1
X$5691 VDD synth_4811 synth_4818 synth_5725 VDD VNB|VSS VNB|VSS
+ sky130_fd_sc_hd__nand2_1
X$5692 VDD synth_5695 synth_5479 synth_5599 VDD VNB|VSS VNB|VSS
+ sky130_fd_sc_hd__nand2_1
X$5693 VDD synth_10632 synth_5738 synth_10277 VDD VNB|VSS VNB|VSS
+ sky130_fd_sc_hd__nand2_1
X$5694 VDD synth_1389 synth_1297 synth_1308 VDD VNB|VSS VNB|VSS
+ sky130_fd_sc_hd__nand2_1
X$5695 VDD synth_6742 synth_6665 synth_6667 VDD VNB|VSS VNB|VSS
+ sky130_fd_sc_hd__nand2_1
X$5696 VDD synth_10164 synth_11652 synth_11443 VDD VNB|VSS VNB|VSS
+ sky130_fd_sc_hd__nand2_1
X$5697 VDD synth_3541 synth_5576 synth_5479 VDD VNB|VSS VNB|VSS
+ sky130_fd_sc_hd__nand2_1
X$5698 VDD synth_5738 synth_6800 synth_6445 VDD VNB|VSS VNB|VSS
+ sky130_fd_sc_hd__nand2_1
X$5699 VDD synth_348 synth_347 synth_349 VDD VNB|VSS VNB|VSS
+ sky130_fd_sc_hd__nand2_1
X$5700 VDD synth_3111 synth_214 synth_2869 VDD VNB|VSS VNB|VSS
+ sky130_fd_sc_hd__nand2_1
X$5701 VDD synth_6597 synth_6800 synth_6665 VDD VNB|VSS VNB|VSS
+ sky130_fd_sc_hd__nand2_1
X$5702 VDD synth_997 synth_364 synth_645 VDD VNB|VSS VNB|VSS
+ sky130_fd_sc_hd__nand2_1
X$5703 VDD synth_7743 synth_9703 synth_9589 VDD VNB|VSS VNB|VSS
+ sky130_fd_sc_hd__nand2_1
X$5704 VDD synth_7575 synth_7486 synth_7467 VDD VNB|VSS VNB|VSS
+ sky130_fd_sc_hd__nand2_1
X$5705 VDD synth_2295 synth_2412 synth_2415 VDD VNB|VSS VNB|VSS
+ sky130_fd_sc_hd__nand2_1
X$5706 VDD synth_9841 synth_9686 synth_9801 VDD VNB|VSS VNB|VSS
+ sky130_fd_sc_hd__nand2_1
X$5707 VDD synth_7327 synth_7183 synth_7552 VDD VNB|VSS VNB|VSS
+ sky130_fd_sc_hd__nand2_1
X$5708 VDD synth_651 synth_347 synth_380 VDD VNB|VSS VNB|VSS
+ sky130_fd_sc_hd__nand2_1
X$5709 VDD synth_7488 synth_7196 synth_7179 VDD VNB|VSS VNB|VSS
+ sky130_fd_sc_hd__nand2_1
X$5710 VDD synth_3544 synth_5100 synth_5132 VDD VNB|VSS VNB|VSS
+ sky130_fd_sc_hd__nand2_1
X$5711 VDD synth_3544 synth_3618 synth_3161 VDD VNB|VSS VNB|VSS
+ sky130_fd_sc_hd__nand2_1
X$5712 VDD synth_5246 synth_5132 synth_5131 VDD VNB|VSS VNB|VSS
+ sky130_fd_sc_hd__nand2_1
X$5713 VDD synth_770 synth_686 synth_688 VDD VNB|VSS VNB|VSS
+ sky130_fd_sc_hd__nand2_1
X$5714 VDD synth_2647 synth_1067 synth_2765 VDD VNB|VSS VNB|VSS
+ sky130_fd_sc_hd__nand2_1
X$5715 VDD synth_10397 synth_10700 synth_10743 VDD VNB|VSS VNB|VSS
+ sky130_fd_sc_hd__nand2_1
X$5716 VDD synth_890 synth_752 synth_673 VDD VNB|VSS VNB|VSS
+ sky130_fd_sc_hd__nand2_1
X$5717 VDD synth_9818 synth_9501 synth_9503 VDD VNB|VSS VNB|VSS
+ sky130_fd_sc_hd__nand2_1
X$5718 VDD synth_4056 synth_3927 synth_3903 VDD VNB|VSS VNB|VSS
+ sky130_fd_sc_hd__nand2_1
X$5719 VDD synth_4145 synth_3927 synth_4112 VDD VNB|VSS VNB|VSS
+ sky130_fd_sc_hd__nand2_1
X$5720 VDD synth_1968 synth_1969 synth_2278 VDD VNB|VSS VNB|VSS
+ sky130_fd_sc_hd__nand2_1
X$5721 VDD synth_879 synth_745 synth_669 VDD VNB|VSS VNB|VSS
+ sky130_fd_sc_hd__nand2_1
X$5722 VDD synth_983 synth_906 synth_1043 VDD VNB|VSS VNB|VSS
+ sky130_fd_sc_hd__nand2_1
X$5723 VDD synth_8862 synth_8795 synth_8922 VDD VNB|VSS VNB|VSS
+ sky130_fd_sc_hd__nand2_1
X$5724 VDD synth_2055 synth_2010 synth_1279 VDD VNB|VSS VNB|VSS
+ sky130_fd_sc_hd__nand2_1
X$5725 VDD synth_2055 synth_1858 synth_2052 VDD VNB|VSS VNB|VSS
+ sky130_fd_sc_hd__and2_1
X$5726 VDD synth_8000 synth_8383 synth_8709 VDD VNB|VSS VNB|VSS
+ sky130_fd_sc_hd__nand2_1
X$5727 VDD synth_326 synth_278 synth_383 VDD VNB|VSS VNB|VSS
+ sky130_fd_sc_hd__nand2_1
X$5728 VDD synth_1353 synth_2802 synth_2588 VDD VNB|VSS VNB|VSS
+ sky130_fd_sc_hd__nand2_1
X$5729 VDD synth_2027 synth_1902 synth_2028 VDD VNB|VSS VNB|VSS
+ sky130_fd_sc_hd__nand2_1
X$5730 VDD synth_66 synth_2962 synth_2876 VDD VNB|VSS VNB|VSS
+ sky130_fd_sc_hd__nand2_1
X$5731 VDD synth_2026 synth_1902 synth_2142 VDD VNB|VSS VNB|VSS
+ sky130_fd_sc_hd__nand2_1
X$5732 VDD synth_4751 synth_4777 synth_4605 VDD VNB|VSS VNB|VSS
+ sky130_fd_sc_hd__nand2_1
X$5733 VDD synth_873 synth_666 synth_707 VDD VNB|VSS VNB|VSS
+ sky130_fd_sc_hd__nand2_1
X$5734 VDD synth_10793 synth_9240 synth_10988 VDD VNB|VSS VNB|VSS
+ sky130_fd_sc_hd__nand2_1
X$5735 VDD synth_9423 synth_12089 synth_12403 VDD VNB|VSS VNB|VSS
+ sky130_fd_sc_hd__nand2_1
X$5736 VDD synth_8183 synth_8018 synth_8205 VDD VNB|VSS VNB|VSS
+ sky130_fd_sc_hd__nand2_1
X$5737 VDD synth_353 synth_97 synth_315 VDD VNB|VSS VNB|VSS
+ sky130_fd_sc_hd__nand2_1
X$5738 VDD synth_167 synth_1527 synth_1454 VDD VNB|VSS VNB|VSS
+ sky130_fd_sc_hd__nand2_1
X$5739 VDD synth_1140 synth_906 synth_1161 VDD VNB|VSS VNB|VSS
+ sky130_fd_sc_hd__nand2_1
X$5740 VDD synth_167 synth_4113 synth_3927 VDD VNB|VSS VNB|VSS
+ sky130_fd_sc_hd__nand2_1
X$5741 VDD synth_9292 synth_9677 synth_10097 VDD VNB|VSS VNB|VSS
+ sky130_fd_sc_hd__nand2_1
X$5742 VDD synth_6311 synth_6214 synth_6215 VDD VNB|VSS VNB|VSS
+ sky130_fd_sc_hd__nand2_1
X$5743 VDD synth_364 synth_910 synth_515 VDD VNB|VSS VNB|VSS
+ sky130_fd_sc_hd__nand2_1
X$5744 VDD synth_8535 synth_8536 synth_8584 VDD VNB|VSS VNB|VSS
+ sky130_fd_sc_hd__nand2_1
X$5745 VDD synth_5793 synth_5794 synth_5965 VDD VNB|VSS VNB|VSS
+ sky130_fd_sc_hd__nand2_1
X$5746 VDD synth_8000 synth_8758 synth_8759 VDD VNB|VSS VNB|VSS
+ sky130_fd_sc_hd__nand2_1
X$5747 VDD synth_3412 synth_364 synth_3185 VDD VNB|VSS VNB|VSS
+ sky130_fd_sc_hd__nand2_1
X$5748 VDD synth_2601 synth_2437 synth_2411 VDD VNB|VSS VNB|VSS
+ sky130_fd_sc_hd__nand2_1
X$5749 VDD synth_8514 synth_7183 synth_8546 VDD VNB|VSS VNB|VSS
+ sky130_fd_sc_hd__nand2_1
X$5750 VDD synth_151 synth_1076 synth_906 VDD VNB|VSS VNB|VSS
+ sky130_fd_sc_hd__nand2_1
X$5751 VDD synth_1613 synth_1435 synth_1515 VDD VNB|VSS VNB|VSS
+ sky130_fd_sc_hd__nand2_1
X$5752 VDD synth_8678 synth_8462 synth_8542 VDD VNB|VSS VNB|VSS
+ sky130_fd_sc_hd__nand2_1
X$5753 VDD synth_167 synth_355 synth_29 VDD VNB|VSS VNB|VSS
+ sky130_fd_sc_hd__nand2_1
X$5754 VDD synth_2916 synth_2876 synth_2963 VDD VNB|VSS VNB|VSS
+ sky130_fd_sc_hd__nand2_1
X$5755 VDD synth_8467 synth_8464 synth_8517 VDD VNB|VSS VNB|VSS
+ sky130_fd_sc_hd__nand2_1
X$5756 VDD synth_4718 synth_4645 synth_4761 VDD VNB|VSS VNB|VSS
+ sky130_fd_sc_hd__nand2_1
X$5757 VDD synth_1282 synth_1281 synth_1365 VDD VNB|VSS VNB|VSS
+ sky130_fd_sc_hd__nand2_1
X$5758 VDD synth_8241 synth_8463 synth_8704 VDD VNB|VSS VNB|VSS
+ sky130_fd_sc_hd__nand2_1
X$5759 VDD synth_2837 synth_2803 synth_2919 VDD VNB|VSS VNB|VSS
+ sky130_fd_sc_hd__nand2_1
X$5760 VDD synth_11371 synth_11588 synth_11623 VDD VNB|VSS VNB|VSS
+ sky130_fd_sc_hd__nand2_1
X$5761 VDD synth_825 synth_912 synth_963 VDD VNB|VSS VNB|VSS
+ sky130_fd_sc_hd__nand2_1
X$5762 VDD synth_66 synth_289 synth_97 VDD VNB|VSS VNB|VSS
+ sky130_fd_sc_hd__nand2_1
X$5763 VDD synth_2528 synth_2437 synth_2549 VDD VNB|VSS VNB|VSS
+ sky130_fd_sc_hd__nand2_1
X$5764 VDD synth_927 synth_3412 synth_3248 VDD VNB|VSS VNB|VSS
+ sky130_fd_sc_hd__nand2_1
X$5765 VDD synth_1075 synth_906 synth_1045 VDD VNB|VSS VNB|VSS
+ sky130_fd_sc_hd__nand2_1
X$5766 VDD synth_2175 synth_214 synth_2172 VDD VNB|VSS VNB|VSS
+ sky130_fd_sc_hd__nand2_1
X$5767 VDD synth_5044 synth_4840 synth_4841 VDD VNB|VSS VNB|VSS
+ sky130_fd_sc_hd__nand2_1
X$5768 VDD synth_2565 synth_2437 synth_2566 VDD VNB|VSS VNB|VSS
+ sky130_fd_sc_hd__nand2_1
X$5769 VDD synth_5738 synth_9806 synth_10604 VDD VNB|VSS VNB|VSS
+ sky130_fd_sc_hd__nand2_1
X$5770 VDD synth_549 synth_278 synth_277 VDD VNB|VSS VNB|VSS
+ sky130_fd_sc_hd__nand2_1
X$5771 VDD synth_3541 synth_4399 synth_4645 VDD VNB|VSS VNB|VSS
+ sky130_fd_sc_hd__nand2_1
X$5772 VDD synth_4621 synth_4602 synth_4554 VDD VNB|VSS VNB|VSS
+ sky130_fd_sc_hd__nand2_1
X$5773 VDD synth_11575 synth_11312 synth_11456 VDD VNB|VSS VNB|VSS
+ sky130_fd_sc_hd__nand2_1
X$5774 VDD synth_2921 synth_2803 synth_2922 VDD VNB|VSS VNB|VSS
+ sky130_fd_sc_hd__nand2_1
X$5775 VDD synth_2107 synth_4184 synth_4670 VDD VNB|VSS VNB|VSS
+ sky130_fd_sc_hd__nand2_1
X$5776 VDD synth_4675 synth_4808 synth_4740 VDD VNB|VSS VNB|VSS
+ sky130_fd_sc_hd__nand2_1
X$5777 VDD synth_1527 synth_364 synth_1377 VDD VNB|VSS VNB|VSS
+ sky130_fd_sc_hd__nand2_1
X$5778 VDD synth_7305 synth_7196 synth_7410 VDD VNB|VSS VNB|VSS
+ sky130_fd_sc_hd__nand2_1
X$5779 VDD synth_4535 synth_4602 synth_4553 VDD VNB|VSS VNB|VSS
+ sky130_fd_sc_hd__nand2_1
X$5780 VDD synth_9212 synth_9421 synth_9671 VDD VNB|VSS VNB|VSS
+ sky130_fd_sc_hd__nand2_1
X$5781 VDD synth_340 synth_214 synth_50 VDD VNB|VSS VNB|VSS
+ sky130_fd_sc_hd__nand2_1
X$5782 VDD synth_10145 synth_9844 synth_10085 VDD VNB|VSS VNB|VSS
+ sky130_fd_sc_hd__nand2_1
X$5783 VDD synth_1411 synth_1281 synth_1321 VDD VNB|VSS VNB|VSS
+ sky130_fd_sc_hd__nand2_1
X$5784 VDD synth_7214 synth_7215 synth_6698 VDD VNB|VSS VNB|VSS
+ sky130_fd_sc_hd__nand2_1
X$5785 VDD synth_3468 synth_5076 synth_4840 VDD VNB|VSS VNB|VSS
+ sky130_fd_sc_hd__nand2_1
X$5786 VDD synth_3210 synth_2994 synth_3142 VDD VNB|VSS VNB|VSS
+ sky130_fd_sc_hd__nand2_1
X$5787 VDD synth_8053 synth_8218 synth_8076 VDD VNB|VSS VNB|VSS
+ sky130_fd_sc_hd__nand2_1
X$5788 VDD synth_194 synth_813 synth_666 VDD VNB|VSS VNB|VSS
+ sky130_fd_sc_hd__nand2_1
X$5789 VDD synth_11985 synth_11984 synth_12014 VDD VNB|VSS VNB|VSS
+ sky130_fd_sc_hd__nand2_1
X$5790 VDD synth_9156 synth_8759 synth_8550 VDD VNB|VSS VNB|VSS
+ sky130_fd_sc_hd__nand2_1
X$5791 VDD synth_3410 synth_3243 synth_3408 VDD VNB|VSS VNB|VSS
+ sky130_fd_sc_hd__nand2_1
X$5792 VDD synth_7632 synth_7370 synth_7557 VDD VNB|VSS VNB|VSS
+ sky130_fd_sc_hd__nand2_1
X$5793 VDD synth_3541 synth_3584 synth_3360 VDD VNB|VSS VNB|VSS
+ sky130_fd_sc_hd__nand2_1
X$5794 VDD synth_3485 synth_3360 synth_3540 VDD VNB|VSS VNB|VSS
+ sky130_fd_sc_hd__nand2_1
X$5795 VDD synth_7633 synth_7370 synth_7489 VDD VNB|VSS VNB|VSS
+ sky130_fd_sc_hd__nand2_1
X$5796 VDD synth_5912 synth_4747 synth_6104 VDD VNB|VSS VNB|VSS
+ sky130_fd_sc_hd__nand2_1
X$5797 VDD synth_2019 synth_1882 synth_1928 VDD VNB|VSS VNB|VSS
+ sky130_fd_sc_hd__nand2_1
X$5798 VDD synth_375 synth_132 synth_272 VDD VNB|VSS VNB|VSS
+ sky130_fd_sc_hd__nand2_1
X$5799 VDD synth_370 synth_123 synth_316 VDD VNB|VSS VNB|VSS
+ sky130_fd_sc_hd__nand2_1
X$5800 VDD synth_194 synth_340 synth_132 VDD VNB|VSS VNB|VSS
+ sky130_fd_sc_hd__nand2_1
X$5801 VDD synth_8856 synth_8857 synth_8935 VDD VNB|VSS VNB|VSS
+ sky130_fd_sc_hd__nand2_1
X$5802 VDD synth_3191 synth_3124 synth_3096 VDD VNB|VSS VNB|VSS
+ sky130_fd_sc_hd__nand2_1
X$5803 VDD synth_7746 synth_7337 synth_7803 VDD VNB|VSS VNB|VSS
+ sky130_fd_sc_hd__nand2_1
X$5804 VDD synth_3541 synth_5240 synth_5050 VDD VNB|VSS VNB|VSS
+ sky130_fd_sc_hd__nand2_1
X$5805 VDD synth_194 synth_391 synth_123 VDD VNB|VSS VNB|VSS
+ sky130_fd_sc_hd__nand2_1
X$5806 VDD synth_7768 synth_7578 synth_7705 VDD VNB|VSS VNB|VSS
+ sky130_fd_sc_hd__nand2_1
X$5807 VDD synth_7183 synth_7171 synth_7370 VDD VNB|VSS VNB|VSS
+ sky130_fd_sc_hd__nand2_1
X$5808 VDD synth_7196 synth_8182 synth_8131 VDD VNB|VSS VNB|VSS
+ sky130_fd_sc_hd__nand2_1
X$5809 VDD synth_8758 synth_5738 synth_8628 VDD VNB|VSS VNB|VSS
+ sky130_fd_sc_hd__nand2_1
X$5810 VDD synth_9234 synth_9044 synth_11644 VDD VNB|VSS VNB|VSS
+ sky130_fd_sc_hd__nand2_1
X$5811 VDD synth_66 synth_1445 synth_1519 VDD VNB|VSS VNB|VSS
+ sky130_fd_sc_hd__nand2_1
X$5812 VDD synth_3616 synth_8677 synth_8356 VDD VNB|VSS VNB|VSS
+ sky130_fd_sc_hd__nand2_1
X$5813 VDD synth_3157 synth_3124 synth_3195 VDD VNB|VSS VNB|VSS
+ sky130_fd_sc_hd__nand2_1
X$5814 VDD synth_7309 synth_7196 synth_7864 VDD VNB|VSS VNB|VSS
+ sky130_fd_sc_hd__nand2_1
X$5815 VDD synth_1436 synth_1435 synth_1514 VDD VNB|VSS VNB|VSS
+ sky130_fd_sc_hd__nand2_1
X$5816 VDD synth_8626 synth_8756 synth_8844 VDD VNB|VSS VNB|VSS
+ sky130_fd_sc_hd__nand2_1
X$5817 VDD synth_2638 synth_2568 synth_2639 VDD VNB|VSS VNB|VSS
+ sky130_fd_sc_hd__nand2_1
X$5818 VDD synth_9318 synth_9228 synth_9320 VDD VNB|VSS VNB|VSS
+ sky130_fd_sc_hd__nand2_1
X$5819 VDD synth_8220 synth_8172 synth_8221 VDD VNB|VSS VNB|VSS
+ sky130_fd_sc_hd__nand2_1
X$5820 VDD synth_391 synth_214 synth_90 VDD VNB|VSS VNB|VSS
+ sky130_fd_sc_hd__nand2_1
X$5821 VDD synth_214 synth_4025 synth_3809 VDD VNB|VSS VNB|VSS
+ sky130_fd_sc_hd__nand2_1
X$5822 VDD synth_2116 synth_4025 synth_3899 VDD VNB|VSS VNB|VSS
+ sky130_fd_sc_hd__nand2_1
X$5823 VDD synth_8786 synth_8759 synth_8743 VDD VNB|VSS VNB|VSS
+ sky130_fd_sc_hd__nand2_1
X$5824 VDD synth_2962 synth_364 synth_2758 VDD VNB|VSS VNB|VSS
+ sky130_fd_sc_hd__nand2_1
X$5825 VDD synth_7089 synth_8854 synth_8931 VDD VNB|VSS VNB|VSS
+ sky130_fd_sc_hd__nand2_1
X$5826 VDD synth_3616 synth_8854 synth_8790 VDD VNB|VSS VNB|VSS
+ sky130_fd_sc_hd__nand2_1
X$5827 VDD synth_57 synth_132 synth_56 VDD VNB|VSS VNB|VSS
+ sky130_fd_sc_hd__nand2_1
X$5828 VDD synth_1212 synth_1290 synth_1317 VDD VNB|VSS VNB|VSS
+ sky130_fd_sc_hd__nand2_1
X$5829 VDD synth_7183 synth_7852 synth_7572 VDD VNB|VSS VNB|VSS
+ sky130_fd_sc_hd__nand2_1
X$5830 VDD synth_8918 synth_12107 synth_12152 VDD VNB|VSS VNB|VSS
+ sky130_fd_sc_hd__nand2_1
X$5831 VDD synth_7974 synth_8219 synth_7921 VDD VNB|VSS VNB|VSS
+ sky130_fd_sc_hd__nand2_1
X$5832 VDD synth_4290 synth_4374 synth_4452 VDD VNB|VSS VNB|VSS
+ sky130_fd_sc_hd__nand2_1
X$5833 VDD synth_10793 synth_9427 synth_11537 VDD VNB|VSS VNB|VSS
+ sky130_fd_sc_hd__nand2_1
X$5834 VDD synth_1892 synth_1891 synth_1994 VDD VNB|VSS VNB|VSS
+ sky130_fd_sc_hd__nand2_1
X$5835 VDD synth_4113 synth_364 synth_3771 VDD VNB|VSS VNB|VSS
+ sky130_fd_sc_hd__nand2_1
X$5836 VDD synth_3616 synth_6860 synth_6440 VDD VNB|VSS VNB|VSS
+ sky130_fd_sc_hd__nand2_1
X$5837 VDD synth_10478 synth_10451 synth_10801 VDD VNB|VSS VNB|VSS
+ sky130_fd_sc_hd__nand2_1
X$5838 VDD synth_4078 synth_3951 synth_4046 VDD VNB|VSS VNB|VSS
+ sky130_fd_sc_hd__nand2_1
X$5839 VDD synth_9150 synth_9170 synth_9382 VDD VNB|VSS VNB|VSS
+ sky130_fd_sc_hd__nand2_1
X$5840 VDD synth_288 synth_364 synth_96 VDD VNB|VSS VNB|VSS
+ sky130_fd_sc_hd__nand2_1
X$5841 VDD synth_3222 synth_3161 synth_3223 VDD VNB|VSS VNB|VSS
+ sky130_fd_sc_hd__nand2_1
X$5842 VDD synth_66 synth_288 synth_351 VDD VNB|VSS VNB|VSS
+ sky130_fd_sc_hd__nand2_1
X$5843 VDD synth_10703 synth_3616 synth_10465 VDD VNB|VSS VNB|VSS
+ sky130_fd_sc_hd__nand2_1
X$5844 VDD synth_376 synth_351 synth_287 VDD VNB|VSS VNB|VSS
+ sky130_fd_sc_hd__nand2_1
X$5845 VDD synth_3303 synth_3381 synth_3380 VDD VNB|VSS VNB|VSS
+ sky130_fd_sc_hd__nand2_1
X$5846 VDD synth_9195 synth_9486 synth_9485 VDD VNB|VSS VNB|VSS
+ sky130_fd_sc_hd__nand2_1
X$5847 VDD synth_3105 synth_3026 synth_3029 VDD VNB|VSS VNB|VSS
+ sky130_fd_sc_hd__nand2_1
X$5848 VDD synth_6714 synth_6457 synth_6754 VDD VNB|VSS VNB|VSS
+ sky130_fd_sc_hd__nand2_1
X$5849 VDD synth_3322 synth_3248 synth_3250 VDD VNB|VSS VNB|VSS
+ sky130_fd_sc_hd__nand2_1
X$5850 VDD synth_7753 synth_7182 synth_7354 VDD VNB|VSS VNB|VSS
+ sky130_fd_sc_hd__nand2_1
X$5851 VDD synth_10718 synth_9762 synth_10838 VDD VNB|VSS VNB|VSS
+ sky130_fd_sc_hd__nand2_1
X$5852 VDD synth_7111 synth_7414 synth_7491 VDD VNB|VSS VNB|VSS
+ sky130_fd_sc_hd__nand2_1
X$5853 VDD synth_5093 synth_364 synth_5445 VDD VNB|VSS VNB|VSS
+ sky130_fd_sc_hd__nand2_1
X$5854 VDD synth_12482 synth_12504 synth_12539 VDD VNB|VSS VNB|VSS
+ sky130_fd_sc_hd__nand2_1
X$5855 VDD synth_1773 synth_1633 synth_1618 VDD VNB|VSS VNB|VSS
+ sky130_fd_sc_hd__nand2_1
X$5856 VDD synth_485 synth_60 synth_323 VDD VNB|VSS VNB|VSS
+ sky130_fd_sc_hd__nand2_1
X$5857 VDD synth_528 synth_67 synth_306 VDD VNB|VSS VNB|VSS
+ sky130_fd_sc_hd__nand2_1
X$5858 VDD synth_2594 synth_2352 synth_2554 VDD VNB|VSS VNB|VSS
+ sky130_fd_sc_hd__nand2_1
X$5859 VDD synth_12552 synth_12459 synth_12458 VDD VNB|VSS VNB|VSS
+ sky130_fd_sc_hd__nand2_1
X$5860 VDD synth_7444 synth_7182 synth_7356 VDD VNB|VSS VNB|VSS
+ sky130_fd_sc_hd__nand2_1
X$5861 VDD synth_7361 synth_7491 synth_7492 VDD VNB|VSS VNB|VSS
+ sky130_fd_sc_hd__nand2_1
X$5862 VDD synth_9312 synth_9170 synth_9226 VDD VNB|VSS VNB|VSS
+ sky130_fd_sc_hd__nand2_1
X$5863 VDD synth_6101 synth_5801 synth_5883 VDD VNB|VSS VNB|VSS
+ sky130_fd_sc_hd__nand2_1
X$5864 VDD synth_4742 synth_4562 synth_4676 VDD VNB|VSS VNB|VSS
+ sky130_fd_sc_hd__nand2_1
X$5865 VDD synth_4283 synth_657 synth_4105 VDD VNB|VSS VNB|VSS
+ sky130_fd_sc_hd__nand2_1
X$5866 VDD synth_8746 synth_7058 synth_9486 VDD VNB|VSS VNB|VSS
+ sky130_fd_sc_hd__nand2_1
X$5867 VDD synth_6695 synth_6693 synth_6761 VDD VNB|VSS VNB|VSS
+ sky130_fd_sc_hd__nand2_1
X$5868 VDD synth_2116 synth_2946 synth_2843 VDD VNB|VSS VNB|VSS
+ sky130_fd_sc_hd__nand2_1
X$5869 VDD synth_11693 synth_11443 synth_11610 VDD VNB|VSS VNB|VSS
+ sky130_fd_sc_hd__nand2_1
X$5870 VDD synth_3616 synth_4303 synth_4476 VDD VNB|VSS VNB|VSS
+ sky130_fd_sc_hd__nand2_1
X$5871 VDD synth_10998 synth_10999 synth_11000 VDD VNB|VSS VNB|VSS
+ sky130_fd_sc_hd__nand2_1
X$5872 VDD synth_5818 synth_3632 synth_6123 VDD VNB|VSS VNB|VSS
+ sky130_fd_sc_hd__nand2_1
X$5873 VDD synth_7196 synth_8645 synth_8723 VDD VNB|VSS VNB|VSS
+ sky130_fd_sc_hd__nand2_1
X$5874 VDD synth_1015 synth_4581 synth_4481 VDD VNB|VSS VNB|VSS
+ sky130_fd_sc_hd__nand2_1
X$5875 VDD synth_11085 synth_11129 synth_11057 VDD VNB|VSS VNB|VSS
+ sky130_fd_sc_hd__nand2_1
X$5876 VDD synth_6054 synth_5747 synth_5964 VDD VNB|VSS VNB|VSS
+ sky130_fd_sc_hd__nand2_1
X$5877 VDD synth_11084 synth_11081 synth_10997 VDD VNB|VSS VNB|VSS
+ sky130_fd_sc_hd__nand2_1
X$5878 VDD synth_7196 synth_8255 synth_8355 VDD VNB|VSS VNB|VSS
+ sky130_fd_sc_hd__nand2_1
X$5879 VDD synth_8870 synth_12157 synth_12158 VDD VNB|VSS VNB|VSS
+ sky130_fd_sc_hd__nand2_1
X$5880 VDD synth_12140 synth_12459 synth_12577 VDD VNB|VSS VNB|VSS
+ sky130_fd_sc_hd__nand2_1
X$5881 VDD synth_7196 synth_8253 synth_8280 VDD VNB|VSS VNB|VSS
+ sky130_fd_sc_hd__nand2_1
X$5882 VDD synth_8910 synth_9235 synth_8944 VDD VNB|VSS VNB|VSS
+ sky130_fd_sc_hd__nand2_1
X$5883 VDD synth_927 synth_1021 synth_686 VDD VNB|VSS VNB|VSS
+ sky130_fd_sc_hd__nand2_1
X$5884 VDD synth_11741 synth_11740 synth_11743 VDD VNB|VSS VNB|VSS
+ sky130_fd_sc_hd__nand2_1
X$5885 VDD synth_4747 synth_6613 synth_6457 VDD VNB|VSS VNB|VSS
+ sky130_fd_sc_hd__nand2_1
X$5886 VDD synth_1353 synth_1641 synth_1435 VDD VNB|VSS VNB|VSS
+ sky130_fd_sc_hd__nand2_1
X$5887 VDD synth_6487 synth_6356 synth_6133 VDD VNB|VSS VNB|VSS
+ sky130_fd_sc_hd__nand2_1
X$5888 VDD synth_12087 synth_5738 synth_12441 VDD VNB|VSS VNB|VSS
+ sky130_fd_sc_hd__nand2_1
X$5889 VDD synth_3616 synth_7058 synth_9601 VDD VNB|VSS VNB|VSS
+ sky130_fd_sc_hd__nand2_1
X$5890 VDD synth_5242 synth_3541 synth_5365 VDD VNB|VSS VNB|VSS
+ sky130_fd_sc_hd__nand2_1
X$5891 VDD synth_3357 synth_3228 synth_3278 VDD VNB|VSS VNB|VSS
+ sky130_fd_sc_hd__nand2_1
X$5892 VDD synth_5829 synth_5760 synth_5832 VDD VNB|VSS VNB|VSS
+ sky130_fd_sc_hd__nand2_1
X$5893 VDD synth_659 synth_2466 synth_2568 VDD VNB|VSS VNB|VSS
+ sky130_fd_sc_hd__nand2_1
X$5894 VDD synth_1674 synth_364 synth_1820 VDD VNB|VSS VNB|VSS
+ sky130_fd_sc_hd__nand2_1
X$5895 VDD synth_2792 synth_2793 synth_2923 VDD VNB|VSS VNB|VSS
+ sky130_fd_sc_hd__nand2_1
X$5896 VDD synth_9423 synth_11215 synth_11312 VDD VNB|VSS VNB|VSS
+ sky130_fd_sc_hd__nand2_1
X$5897 VDD synth_4961 synth_7069 synth_7038 VDD VNB|VSS VNB|VSS
+ sky130_fd_sc_hd__nand2_1
X$5898 VDD synth_365 synth_29 synth_28 VDD VNB|VSS VNB|VSS
+ sky130_fd_sc_hd__nand2_1
X$5899 VDD synth_7069 synth_657 synth_7068 VDD VNB|VSS VNB|VSS
+ sky130_fd_sc_hd__nand2_1
X$5900 VDD synth_5624 synth_4961 synth_5625 VDD VNB|VSS VNB|VSS
+ sky130_fd_sc_hd__nand2_1
X$5901 VDD synth_6597 synth_5612 synth_6450 VDD VNB|VSS VNB|VSS
+ sky130_fd_sc_hd__nand2_1
X$5902 VDD synth_698 synth_67 synth_238 VDD VNB|VSS VNB|VSS
+ sky130_fd_sc_hd__nand2_1
X$5903 VDD synth_788 synth_678 synth_680 VDD VNB|VSS VNB|VSS
+ sky130_fd_sc_hd__nand2_1
X$5904 VDD synth_3616 synth_8624 synth_8348 VDD VNB|VSS VNB|VSS
+ sky130_fd_sc_hd__nand2_1
X$5905 VDD synth_1509 synth_214 synth_1073 VDD VNB|VSS VNB|VSS
+ sky130_fd_sc_hd__nand2_1
X$5906 VDD synth_7183 synth_8677 synth_8462 VDD VNB|VSS VNB|VSS
+ sky130_fd_sc_hd__nand2_1
X$5907 VDD synth_3616 synth_6738 synth_6491 VDD VNB|VSS VNB|VSS
+ sky130_fd_sc_hd__nand2_1
X$5908 VDD synth_6847 synth_6659 synth_6848 VDD VNB|VSS VNB|VSS
+ sky130_fd_sc_hd__nand2_1
X$5909 VDD synth_5298 synth_5088 synth_5271 VDD VNB|VSS VNB|VSS
+ sky130_fd_sc_hd__nand2_1
X$5910 VDD synth_10387 synth_10453 synth_10755 VDD VNB|VSS VNB|VSS
+ sky130_fd_sc_hd__nand2_1
X$5911 VDD synth_4234 synth_3642 synth_3471 VDD VNB|VSS VNB|VSS
+ sky130_fd_sc_hd__nand2_1
X$5912 VDD synth_3544 synth_5968 synth_5801 VDD VNB|VSS VNB|VSS
+ sky130_fd_sc_hd__nand2_1
X$5913 VDD synth_2107 synth_4256 synth_5855 VDD VNB|VSS VNB|VSS
+ sky130_fd_sc_hd__nand2_1
X$5914 VDD synth_4598 synth_4531 synth_7425 VDD VNB|VSS VNB|VSS
+ sky130_fd_sc_hd__nand2_1
X$5915 VDD synth_9423 synth_11574 synth_11973 VDD VNB|VSS VNB|VSS
+ sky130_fd_sc_hd__nand2_1
X$5916 VDD synth_956 synth_763 synth_863 VDD VNB|VSS VNB|VSS
+ sky130_fd_sc_hd__nand2_1
X$5917 VDD synth_5167 synth_5088 synth_5033 VDD VNB|VSS VNB|VSS
+ sky130_fd_sc_hd__nand2_1
X$5918 VDD synth_10519 synth_7743 synth_9019 VDD VNB|VSS VNB|VSS
+ sky130_fd_sc_hd__nand2_1
X$5919 VDD synth_1653 synth_1454 synth_1545 VDD VNB|VSS VNB|VSS
+ sky130_fd_sc_hd__nand2_1
X$5920 VDD synth_8950 synth_11791 synth_11787 VDD VNB|VSS VNB|VSS
+ sky130_fd_sc_hd__nand2_1
X$5921 VDD synth_11861 synth_11740 synth_11905 VDD VNB|VSS VNB|VSS
+ sky130_fd_sc_hd__nand2_1
X$5922 VDD synth_8623 synth_8536 synth_8586 VDD VNB|VSS VNB|VSS
+ sky130_fd_sc_hd__nand2_1
X$5923 VDD synth_12267 synth_12459 synth_12632 VDD VNB|VSS VNB|VSS
+ sky130_fd_sc_hd__nand2_1
X$5924 VDD synth_4430 synth_4341 synth_4429 VDD VNB|VSS VNB|VSS
+ sky130_fd_sc_hd__nand2_1
X$5925 VDD synth_6376 synth_6603 synth_6731 VDD VNB|VSS VNB|VSS
+ sky130_fd_sc_hd__nand2_1
X$5926 VDD synth_8000 synth_9153 synth_9170 VDD VNB|VSS VNB|VSS
+ sky130_fd_sc_hd__nand2_1
X$5927 VDD synth_9423 synth_12460 synth_12459 VDD VNB|VSS VNB|VSS
+ sky130_fd_sc_hd__nand2_1
X$5928 VDD synth_9112 synth_11017 synth_9044 VDD VNB|VSS VNB|VSS
+ sky130_fd_sc_hd__nand2_1
X$5929 VDD synth_3616 synth_5968 synth_5802 VDD VNB|VSS VNB|VSS
+ sky130_fd_sc_hd__nand2_1
X$5930 VDD synth_66 synth_997 synth_682 VDD VNB|VSS VNB|VSS
+ sky130_fd_sc_hd__nand2_1
X$5931 VDD synth_1338 synth_3293 synth_3058 VDD VNB|VSS VNB|VSS
+ sky130_fd_sc_hd__nand2_1
X$5932 VDD synth_9153 synth_5738 synth_9152 VDD VNB|VSS VNB|VSS
+ sky130_fd_sc_hd__nand2_1
X$5933 VDD synth_7183 synth_7255 synth_7182 VDD VNB|VSS VNB|VSS
+ sky130_fd_sc_hd__nand2_1
X$5934 VDD synth_792 synth_214 synth_565 VDD VNB|VSS VNB|VSS
+ sky130_fd_sc_hd__nand2_1
X$5935 VDD synth_5837 synth_5999 synth_6099 VDD VNB|VSS VNB|VSS
+ sky130_fd_sc_hd__nand2_1
X$5936 VDD synth_3851 synth_4009 synth_3952 VDD VNB|VSS VNB|VSS
+ sky130_fd_sc_hd__nand2_1
X$5937 VDD synth_167 synth_356 synth_67 VDD VNB|VSS VNB|VSS
+ sky130_fd_sc_hd__nand2_1
X$5938 VDD synth_3616 synth_7255 synth_7222 VDD VNB|VSS VNB|VSS
+ sky130_fd_sc_hd__nand2_1
X$5939 VDD synth_4511 synth_4359 synth_4360 VDD VNB|VSS VNB|VSS
+ sky130_fd_sc_hd__nand2_1
X$5940 VDD synth_4291 synth_4376 synth_4453 VDD VNB|VSS VNB|VSS
+ sky130_fd_sc_hd__nand2_1
X$5941 VDD synth_7240 synth_6771 synth_7542 VDD VNB|VSS VNB|VSS
+ sky130_fd_sc_hd__nand2_1
X$5942 VDD synth_62 synth_275 synth_274 VDD VNB|VSS VNB|VSS
+ sky130_fd_sc_hd__nand2_1
X$5943 VDD synth_7089 synth_8624 synth_8536 VDD VNB|VSS VNB|VSS
+ sky130_fd_sc_hd__nand2_1
X$5944 VDD synth_1353 synth_3509 synth_3239 VDD VNB|VSS VNB|VSS
+ sky130_fd_sc_hd__nand2_1
X$5945 VDD synth_3474 synth_3239 synth_3403 VDD VNB|VSS VNB|VSS
+ sky130_fd_sc_hd__nand2_1
X$5946 VDD synth_5921 synth_5760 synth_5763 VDD VNB|VSS VNB|VSS
+ sky130_fd_sc_hd__nand2_1
X$5947 VDD synth_608 synth_204 synth_314 VDD VNB|VSS VNB|VSS
+ sky130_fd_sc_hd__nand2_1
X$5948 VDD synth_194 synth_336 synth_204 VDD VNB|VSS VNB|VSS
+ sky130_fd_sc_hd__nand2_1
X$5949 VDD synth_368 synth_204 synth_367 VDD VNB|VSS VNB|VSS
+ sky130_fd_sc_hd__nand2_1
X$5950 VDD synth_4238 synth_4359 synth_4569 VDD VNB|VSS VNB|VSS
+ sky130_fd_sc_hd__nand2_1
X$5951 VDD synth_1015 synth_5100 synth_4723 VDD VNB|VSS VNB|VSS
+ sky130_fd_sc_hd__nand2_1
X$5952 VDD synth_8243 synth_8077 synth_8446 VDD VNB|VSS VNB|VSS
+ sky130_fd_sc_hd__nand2_1
X$5953 VDD synth_8292 synth_8077 synth_8244 VDD VNB|VSS VNB|VSS
+ sky130_fd_sc_hd__nand2_1
X$5954 VDD synth_9220 synth_9308 synth_9306 VDD VNB|VSS VNB|VSS
+ sky130_fd_sc_hd__nand2_1
X$5955 VDD synth_5441 synth_5243 synth_5368 VDD VNB|VSS VNB|VSS
+ sky130_fd_sc_hd__nand2_1
X$5956 VDD synth_11121 synth_11077 synth_11154 VDD VNB|VSS VNB|VSS
+ sky130_fd_sc_hd__nand2_1
X$5957 VDD synth_214 synth_1615 synth_1341 VDD VNB|VSS VNB|VSS
+ sky130_fd_sc_hd__nand2_1
X$5958 VDD synth_8241 synth_8285 synth_8219 VDD VNB|VSS VNB|VSS
+ sky130_fd_sc_hd__nand2_1
X$5959 VDD synth_9909 synth_9836 synth_9952 VDD VNB|VSS VNB|VSS
+ sky130_fd_sc_hd__nand2_1
X$5960 VDD synth_7437 synth_7422 synth_7519 VDD VNB|VSS VNB|VSS
+ sky130_fd_sc_hd__nand2_1
X$5961 VDD synth_5499 synth_5252 synth_5544 VDD VNB|VSS VNB|VSS
+ sky130_fd_sc_hd__nand2_1
X$5962 VDD synth_8746 synth_9910 synth_9836 VDD VNB|VSS VNB|VSS
+ sky130_fd_sc_hd__nand2_1
X$5963 VDD synth_2545 synth_364 synth_2235 VDD VNB|VSS VNB|VSS
+ sky130_fd_sc_hd__nand2_1
X$5964 VDD synth_7168 synth_6901 synth_6941 VDD VNB|VSS VNB|VSS
+ sky130_fd_sc_hd__nand2_1
X$5965 VDD synth_3616 synth_5004 synth_4617 VDD VNB|VSS VNB|VSS
+ sky130_fd_sc_hd__nand2_1
X$5966 VDD synth_9322 synth_11093 synth_11166 VDD VNB|VSS VNB|VSS
+ sky130_fd_sc_hd__nand2_1
X$5967 VDD synth_9622 synth_9621 synth_9572 VDD VNB|VSS VNB|VSS
+ sky130_fd_sc_hd__nand2_1
X$5968 VDD synth_3810 synth_3899 synth_3900 VDD VNB|VSS VNB|VSS
+ sky130_fd_sc_hd__nand2_1
X$5969 VDD synth_5579 synth_5621 synth_5702 VDD VNB|VSS VNB|VSS
+ sky130_fd_sc_hd__nand2_1
X$5970 VDD synth_4747 synth_5679 synth_5511 VDD VNB|VSS VNB|VSS
+ sky130_fd_sc_hd__nand2_1
X$5971 VDD synth_6188 synth_5851 synth_6084 VDD VNB|VSS VNB|VSS
+ sky130_fd_sc_hd__nand2_1
X$5972 VDD synth_7196 synth_8383 synth_8469 VDD VNB|VSS VNB|VSS
+ sky130_fd_sc_hd__nand2_1
X$5973 VDD synth_4961 synth_5570 synth_5999 VDD VNB|VSS VNB|VSS
+ sky130_fd_sc_hd__nand2_1
X$5974 VDD synth_5768 synth_5801 synth_5884 VDD VNB|VSS VNB|VSS
+ sky130_fd_sc_hd__nand2_1
X$5975 VDD synth_7183 synth_7191 synth_7324 VDD VNB|VSS VNB|VSS
+ sky130_fd_sc_hd__nand2_1
X$5976 VDD synth_7398 synth_7324 synth_7325 VDD VNB|VSS VNB|VSS
+ sky130_fd_sc_hd__nand2_1
X$5977 VDD synth_5007 synth_5056 synth_5004 VDD VNB|VSS VNB|VSS
+ sky130_fd_sc_hd__nand2_1
X$5978 VDD synth_1067 synth_2420 synth_2332 VDD VNB|VSS VNB|VSS
+ sky130_fd_sc_hd__nand2_1
X$5979 VDD synth_5738 synth_7191 synth_6967 VDD VNB|VSS VNB|VSS
+ sky130_fd_sc_hd__nand2_1
X$5980 VDD synth_5622 synth_5621 synth_5766 VDD VNB|VSS VNB|VSS
+ sky130_fd_sc_hd__nand2_1
X$5981 VDD synth_7196 synth_7652 synth_7623 VDD VNB|VSS VNB|VSS
+ sky130_fd_sc_hd__nand2_1
X$5982 VDD synth_2116 synth_3111 synth_2948 VDD VNB|VSS VNB|VSS
+ sky130_fd_sc_hd__nand2_1
X$5983 VDD synth_12215 synth_12105 synth_11729 VDD VNB|VSS VNB|VSS
+ sky130_fd_sc_hd__nand2_1
X$5984 VDD synth_6836 synth_6909 synth_6910 VDD VNB|VSS VNB|VSS
+ sky130_fd_sc_hd__nand2_1
X$5985 VDD synth_6001 synth_5999 synth_6100 VDD VNB|VSS VNB|VSS
+ sky130_fd_sc_hd__nand2_1
X$5986 VDD synth_6820 synth_6751 synth_6818 VDD VNB|VSS VNB|VSS
+ sky130_fd_sc_hd__nand2_1
X$5987 VDD synth_11076 synth_11074 synth_9549 VDD VNB|VSS VNB|VSS
+ sky130_fd_sc_hd__nand2_1
X$5988 VDD synth_10995 synth_11076 synth_8467 synth_8544 synth_10994 VDD
+ VNB|VSS VNB|VSS sky130_fd_sc_hd__a31o_2
X$5989 VDD synth_6243 synth_6108 synth_6330 VDD VNB|VSS VNB|VSS
+ sky130_fd_sc_hd__nand2_1
X$5990 VDD synth_6304 synth_6108 synth_6244 VDD VNB|VSS VNB|VSS
+ sky130_fd_sc_hd__nand2_1
X$5991 VDD synth_7840 synth_7783 synth_7784 VDD VNB|VSS VNB|VSS
+ sky130_fd_sc_hd__nand2_1
X$5992 VDD synth_2116 synth_2457 synth_2537 VDD VNB|VSS VNB|VSS
+ sky130_fd_sc_hd__nand2_1
X$5993 VDD synth_2334 synth_1067 synth_2395 VDD VNB|VSS VNB|VSS
+ sky130_fd_sc_hd__nand2_1
X$5994 VDD synth_1118 synth_1137 synth_1138 VDD VNB|VSS VNB|VSS
+ sky130_fd_sc_hd__nand2_1
X$5995 VDD synth_1678 synth_1712 synth_1713 VDD VNB|VSS VNB|VSS
+ sky130_fd_sc_hd__nand2_1
X$5996 VDD synth_3616 synth_9459 synth_9711 VDD VNB|VSS VNB|VSS
+ sky130_fd_sc_hd__nand2_1
X$5997 VDD synth_7743 synth_7416 synth_7418 VDD VNB|VSS VNB|VSS
+ sky130_fd_sc_hd__nand2_1
X$5998 VDD synth_4129 synth_364 synth_4123 VDD VNB|VSS VNB|VSS
+ sky130_fd_sc_hd__nand2_1
X$5999 VDD synth_2102 synth_2144 synth_2029 VDD VNB|VSS VNB|VSS
+ sky130_fd_sc_hd__nand2_1
X$6000 VDD synth_11093 synth_11070 synth_11138 VDD VNB|VSS VNB|VSS
+ sky130_fd_sc_hd__nand2_1
X$6001 VDD synth_5453 synth_5511 synth_5512 VDD VNB|VSS VNB|VSS
+ sky130_fd_sc_hd__nand2_1
X$6002 VDD synth_6695 synth_6910 synth_6911 VDD VNB|VSS VNB|VSS
+ sky130_fd_sc_hd__nand2_1
X$6003 VDD synth_927 synth_3918 synth_3647 VDD VNB|VSS VNB|VSS
+ sky130_fd_sc_hd__nand2_1
X$6004 VDD synth_3632 synth_4835 synth_5252 VDD VNB|VSS VNB|VSS
+ sky130_fd_sc_hd__nand2_1
X$6005 VDD synth_7998 synth_7835 synth_7856 VDD VNB|VSS VNB|VSS
+ sky130_fd_sc_hd__nand2_1
X$6006 VDD synth_7650 synth_7648 synth_7726 VDD VNB|VSS VNB|VSS
+ sky130_fd_sc_hd__nand2_1
X$6007 VDD synth_7649 synth_7648 synth_7727 VDD VNB|VSS VNB|VSS
+ sky130_fd_sc_hd__nand2_1
X$6008 VDD synth_2276 synth_657 synth_2274 VDD VNB|VSS VNB|VSS
+ sky130_fd_sc_hd__nand2_1
X$6009 VDD synth_7183 synth_7897 synth_7648 VDD VNB|VSS VNB|VSS
+ sky130_fd_sc_hd__nand2_1
X$6010 VDD synth_7183 synth_7652 synth_7574 VDD VNB|VSS VNB|VSS
+ sky130_fd_sc_hd__nand2_1
X$6011 VDD synth_4361 synth_3468 synth_4412 VDD VNB|VSS VNB|VSS
+ sky130_fd_sc_hd__nand2_1
X$6012 VDD synth_9746 synth_9836 synth_9748 VDD VNB|VSS VNB|VSS
+ sky130_fd_sc_hd__nand2_1
X$6013 VDD synth_8299 synth_8385 synth_8449 VDD VNB|VSS VNB|VSS
+ sky130_fd_sc_hd__nand2_1
X$6014 VDD synth_151 synth_991 synth_912 VDD VNB|VSS VNB|VSS
+ sky130_fd_sc_hd__nand2_1
X$6015 VDD synth_11845 synth_11841 synth_11844 VDD VNB|VSS VNB|VSS
+ sky130_fd_sc_hd__nand2_1
X$6016 VDD synth_845 synth_686 synth_687 VDD VNB|VSS VNB|VSS
+ sky130_fd_sc_hd__nand2_1
X$6017 VDD synth_12225 synth_12224 synth_12272 VDD VNB|VSS VNB|VSS
+ sky130_fd_sc_hd__nand2_1
X$6018 VDD synth_7417 synth_7418 synth_7525 VDD VNB|VSS VNB|VSS
+ sky130_fd_sc_hd__nand2_1
X$6019 VDD synth_11807 synth_5738 synth_11672 VDD VNB|VSS VNB|VSS
+ sky130_fd_sc_hd__nand2_1
X$6020 VDD synth_11351 synth_11370 synth_11236 VDD VNB|VSS VNB|VSS
+ sky130_fd_sc_hd__nand2_1
X$6021 VDD synth_1991 synth_1891 synth_1917 VDD VNB|VSS VNB|VSS
+ sky130_fd_sc_hd__nand2_1
X$6022 VDD synth_11950 synth_11841 synth_11842 VDD VNB|VSS VNB|VSS
+ sky130_fd_sc_hd__nand2_1
X$6023 VDD synth_1353 synth_1509 synth_1137 VDD VNB|VSS VNB|VSS
+ sky130_fd_sc_hd__nand2_1
X$6024 VDD synth_8000 synth_8384 synth_8385 VDD VNB|VSS VNB|VSS
+ sky130_fd_sc_hd__nand2_1
X$6025 VDD synth_10285 synth_9677 synth_10101 VDD VNB|VSS VNB|VSS
+ sky130_fd_sc_hd__nand2_1
X$6026 VDD synth_3316 synth_3243 synth_3244 VDD VNB|VSS VNB|VSS
+ sky130_fd_sc_hd__nand2_1
X$6027 VDD synth_9310 synth_9208 synth_9889 VDD VNB|VSS VNB|VSS
+ sky130_fd_sc_hd__nand2_1
X$6028 VDD synth_3541 synth_5485 synth_5243 VDD VNB|VSS VNB|VSS
+ sky130_fd_sc_hd__nand2_1
X$6029 VDD synth_12339 synth_12224 synth_12273 VDD VNB|VSS VNB|VSS
+ sky130_fd_sc_hd__nand2_1
X$6030 VDD synth_9042 synth_11358 synth_11439 VDD VNB|VSS VNB|VSS
+ sky130_fd_sc_hd__nand2_1
X$6031 VDD synth_10372 synth_11465 synth_9473 VDD VNB|VSS VNB|VSS
+ sky130_fd_sc_hd__nand2_1
X$6032 VDD synth_12382 synth_12512 synth_12486 VDD VNB|VSS VNB|VSS
+ sky130_fd_sc_hd__nand2_1
X$6033 VDD synth_11373 synth_11306 synth_11353 VDD VNB|VSS VNB|VSS
+ sky130_fd_sc_hd__nand2_1
X$6034 VDD synth_9762 synth_12103 synth_12512 VDD VNB|VSS VNB|VSS
+ sky130_fd_sc_hd__nand2_1
X$6035 VDD synth_1876 synth_1633 synth_1715 VDD VNB|VSS VNB|VSS
+ sky130_fd_sc_hd__nand2_1
X$6036 VDD synth_9858 synth_9776 synth_9466 VDD VNB|VSS VNB|VSS
+ sky130_fd_sc_hd__nand2_1
X$6037 VDD synth_9947 synth_10107 synth_10123 VDD VNB|VSS VNB|VSS
+ sky130_fd_sc_hd__nand2_1
X$6038 VDD synth_3675 synth_3767 synth_3705 VDD VNB|VSS VNB|VSS
+ sky130_fd_sc_hd__nand2_1
X$6039 VDD synth_10531 synth_8746 synth_10496 VDD VNB|VSS VNB|VSS
+ sky130_fd_sc_hd__nand2_1
X$6040 VDD synth_9423 synth_12043 synth_12224 VDD VNB|VSS VNB|VSS
+ sky130_fd_sc_hd__nand2_1
X$6041 VDD synth_3772 synth_364 synth_3479 VDD VNB|VSS VNB|VSS
+ sky130_fd_sc_hd__nand2_1
X$6042 VDD synth_988 synth_968 synth_1076 VDD VNB|VSS VNB|VSS
+ sky130_fd_sc_hd__nand2_1
X$6043 VDD synth_2391 synth_2332 synth_2389 VDD VNB|VSS VNB|VSS
+ sky130_fd_sc_hd__nand2_1
X$6044 VDD synth_9427 synth_9036 synth_9284 VDD VNB|VSS VNB|VSS
+ sky130_fd_sc_hd__nand2_1
X$6045 VDD synth_8710 synth_8803 synth_9672 VDD VNB|VSS VNB|VSS
+ sky130_fd_sc_hd__nand2_1
X$6046 VDD synth_4173 synth_4257 synth_4585 VDD VNB|VSS VNB|VSS
+ sky130_fd_sc_hd__nand2_1
X$6047 VDD synth_5738 synth_6544 synth_6279 VDD VNB|VSS VNB|VSS
+ sky130_fd_sc_hd__nand2_1
X$6048 VDD synth_7148 synth_7038 synth_7071 VDD VNB|VSS VNB|VSS
+ sky130_fd_sc_hd__nand2_1
X$6049 VDD synth_1331 synth_1137 synth_1332 VDD VNB|VSS VNB|VSS
+ sky130_fd_sc_hd__nand2_1
X$6050 VDD synth_151 synth_345 synth_149 VDD VNB|VSS VNB|VSS
+ sky130_fd_sc_hd__nand2_1
X$6051 VDD synth_284 synth_346 synth_180 synth_153 synth_398 VNB|VSS VDD
+ VNB|VSS sky130_fd_sc_hd__o22ai_1
X$6052 VDD synth_7183 synth_7488 synth_7197 VDD VNB|VSS VNB|VSS
+ sky130_fd_sc_hd__nand2_1
X$6053 VDD synth_4701 synth_4407 synth_4784 VDD VNB|VSS VNB|VSS
+ sky130_fd_sc_hd__nand2_1
X$6054 VDD synth_11724 synth_11744 synth_11807 VDD VNB|VSS VNB|VSS
+ sky130_fd_sc_hd__nand2_1
X$6055 VDD synth_7341 synth_7340 synth_7338 VDD VNB|VSS VNB|VSS
+ sky130_fd_sc_hd__nand2_1
X$6056 VDD synth_5679 synth_657 synth_5569 VDD VNB|VSS VNB|VSS
+ sky130_fd_sc_hd__nand2_1
X$6057 VDD synth_10569 synth_10568 synth_10686 VDD VNB|VSS VNB|VSS
+ sky130_fd_sc_hd__nand2_1
X$6058 VDD synth_10421 synth_10295 synth_10328 VDD VNB|VSS VNB|VSS
+ sky130_fd_sc_hd__nand2_1
X$6059 VDD synth_3118 synth_364 synth_3312 VDD VNB|VSS VNB|VSS
+ sky130_fd_sc_hd__nand2_1
X$6060 VDD synth_10685 synth_10568 synth_10684 VDD VNB|VSS VNB|VSS
+ sky130_fd_sc_hd__nand2_1
X$6061 VDD synth_6490 synth_6461 synth_6489 VDD VNB|VSS VNB|VSS
+ sky130_fd_sc_hd__nand2_1
X$6062 VDD synth_8746 synth_9459 synth_10067 VDD VNB|VSS VNB|VSS
+ sky130_fd_sc_hd__nand2_1
X$6063 VDD synth_6834 synth_6393 synth_6908 VDD VNB|VSS VNB|VSS
+ sky130_fd_sc_hd__nand2_1
X$6064 VDD synth_8746 synth_10703 synth_10700 VDD VNB|VSS VNB|VSS
+ sky130_fd_sc_hd__nand2_1
X$6065 VDD synth_6402 synth_6264 synth_6383 VDD VNB|VSS VNB|VSS
+ sky130_fd_sc_hd__nand2_1
X$6066 VDD synth_58 synth_194 synth_254 VDD VNB|VSS VNB|VSS
+ sky130_fd_sc_hd__nand2_1
X$6067 VDD synth_1353 synth_3118 synth_3044 VDD VNB|VSS VNB|VSS
+ sky130_fd_sc_hd__nand2_1
X$6068 VDD synth_6466 synth_6836 synth_6912 VDD VNB|VSS VNB|VSS
+ sky130_fd_sc_hd__nand2_1
X$6069 VDD synth_138 synth_123 synth_247 VDD VNB|VSS VNB|VSS
+ sky130_fd_sc_hd__nand2_1
X$6070 VDD synth_6759 synth_6760 synth_7133 VDD VNB|VSS VNB|VSS
+ sky130_fd_sc_hd__nand2_1
X$6071 VDD synth_10296 synth_10295 synth_10297 VDD VNB|VSS VNB|VSS
+ sky130_fd_sc_hd__nand2_1
X$6072 VDD synth_3768 synth_3767 synth_3835 VDD VNB|VSS VNB|VSS
+ sky130_fd_sc_hd__nand2_1
X$6073 VDD synth_5638 synth_5511 synth_5618 VDD VNB|VSS VNB|VSS
+ sky130_fd_sc_hd__nand2_1
X$6074 VDD synth_10164 synth_11364 synth_11487 VDD VNB|VSS VNB|VSS
+ sky130_fd_sc_hd__nand2_1
X$6075 VDD synth_6695 synth_7131 synth_7219 VDD VNB|VSS VNB|VSS
+ sky130_fd_sc_hd__nand2_1
X$6076 VDD synth_6495 synth_6264 synth_6384 VDD VNB|VSS VNB|VSS
+ sky130_fd_sc_hd__nand2_1
X$6077 VDD synth_10032 synth_10067 synth_10124 VDD VNB|VSS VNB|VSS
+ sky130_fd_sc_hd__nand2_1
X$6078 VDD synth_5738 synth_9723 synth_10301 VDD VNB|VSS VNB|VSS
+ sky130_fd_sc_hd__nand2_1
X$6079 VDD synth_1185 synth_1272 synth_1186 VDD VNB|VSS VNB|VSS
+ sky130_fd_sc_hd__nand2_1
X$6080 VDD synth_7743 synth_8015 synth_8097 VDD VNB|VSS VNB|VSS
+ sky130_fd_sc_hd__nand2_1
X$6081 VDD synth_3000 synth_3076 synth_3047 VDD VNB|VSS VNB|VSS
+ sky130_fd_sc_hd__nand2_1
X$6082 VDD synth_10960 synth_10991 synth_11033 VDD VNB|VSS VNB|VSS
+ sky130_fd_sc_hd__nand2_1
X$6083 VDD synth_3149 synth_3175 synth_3281 VDD VNB|VSS VNB|VSS
+ sky130_fd_sc_hd__nand2_1
X$6084 VDD synth_9423 synth_12274 synth_12590 VDD VNB|VSS VNB|VSS
+ sky130_fd_sc_hd__nand2_1
X$6085 VDD synth_7056 synth_6920 synth_6984 VDD VNB|VSS VNB|VSS
+ sky130_fd_sc_hd__nand2_1
X$6086 VDD synth_7209 synth_7111 synth_7352 VDD VNB|VSS VNB|VSS
+ sky130_fd_sc_hd__nand2_1
X$6087 VDD synth_6998 synth_657 synth_6976 VDD VNB|VSS VNB|VSS
+ sky130_fd_sc_hd__nand2_1
X$6088 VDD synth_3432 synth_3471 synth_3596 VDD VNB|VSS VNB|VSS
+ sky130_fd_sc_hd__nand2_1
X$6089 VDD synth_4961 synth_6717 synth_6920 VDD VNB|VSS VNB|VSS
+ sky130_fd_sc_hd__nand2_1
X$6090 VDD synth_9858 synth_9964 synth_9859 VDD VNB|VSS VNB|VSS
+ sky130_fd_sc_hd__nand2_1
X$6091 VDD synth_4961 synth_6556 synth_6461 VDD VNB|VSS VNB|VSS
+ sky130_fd_sc_hd__nand2_1
X$6092 VDD synth_11351 synth_9109 synth_11529 VDD VNB|VSS VNB|VSS
+ sky130_fd_sc_hd__nand2_1
X$6093 VDD synth_11142 synth_11141 synth_11182 VDD VNB|VSS VNB|VSS
+ sky130_fd_sc_hd__nand2_1
X$6094 VDD synth_2056 synth_2012 synth_2257 VDD VNB|VSS VNB|VSS
+ sky130_fd_sc_hd__nand2_1
X$6095 VDD synth_9499 synth_6634 synth_9688 VDD VNB|VSS VNB|VSS
+ sky130_fd_sc_hd__nand2_1
X$6096 VDD synth_11879 synth_11915 synth_12004 VDD VNB|VSS VNB|VSS
+ sky130_fd_sc_hd__nand2_1
X$6097 VDD synth_11075 synth_9109 synth_11588 VDD VNB|VSS VNB|VSS
+ sky130_fd_sc_hd__nand2_1
X$6098 VDD synth_11652 synth_3616 synth_11363 VDD VNB|VSS VNB|VSS
+ sky130_fd_sc_hd__nand2_1
X$6099 VDD synth_2174 synth_1353 synth_2253 VDD VNB|VSS VNB|VSS
+ sky130_fd_sc_hd__nand2_1
X$6100 VDD synth_10164 synth_9723 synth_10568 VDD VNB|VSS VNB|VSS
+ sky130_fd_sc_hd__nand2_1
X$6101 VDD synth_7807 synth_7590 synth_8102 VDD VNB|VSS VNB|VSS
+ sky130_fd_sc_hd__nand2_1
X$6102 VDD synth_3616 synth_6842 synth_8929 VDD VNB|VSS VNB|VSS
+ sky130_fd_sc_hd__nand2_1
X$6103 VDD synth_4457 synth_4943 synth_5032 VDD VNB|VSS VNB|VSS
+ sky130_fd_sc_hd__nand2_1
X$6104 VDD synth_7111 synth_7494 synth_7586 VDD VNB|VSS VNB|VSS
+ sky130_fd_sc_hd__nand2_1
X$6105 VDD synth_7740 synth_7586 synth_7795 VDD VNB|VSS VNB|VSS
+ sky130_fd_sc_hd__nand2_1
X$6106 VDD synth_11365 synth_11342 synth_11367 VDD VNB|VSS VNB|VSS
+ sky130_fd_sc_hd__nand2_1
X$6107 VDD synth_8746 synth_6842 synth_8958 VDD VNB|VSS VNB|VSS
+ sky130_fd_sc_hd__nand2_1
X$6108 VDD synth_7686 synth_7586 synth_7962 VDD VNB|VSS VNB|VSS
+ sky130_fd_sc_hd__nand2_1
X$6109 VDD synth_11655 synth_11696 synth_11652 VDD VNB|VSS VNB|VSS
+ sky130_fd_sc_hd__nand2_1
X$6110 VDD synth_3616 synth_7142 synth_8453 VDD VNB|VSS VNB|VSS
+ sky130_fd_sc_hd__nand2_1
X$6111 VDD synth_10497 synth_5738 synth_10250 VDD VNB|VSS VNB|VSS
+ sky130_fd_sc_hd__nand2_1
X$6112 VDD synth_3272 synth_3274 synth_3337 VDD VNB|VSS VNB|VSS
+ sky130_fd_sc_hd__nand2_1
X$6113 VDD synth_7743 synth_8728 synth_8250 VDD VNB|VSS VNB|VSS
+ sky130_fd_sc_hd__nand2_1
X$6114 VDD synth_9347 synth_9486 synth_9642 VDD VNB|VSS VNB|VSS
+ sky130_fd_sc_hd__nand2_1
X$6115 VDD synth_11522 synth_11443 synth_11611 VDD VNB|VSS VNB|VSS
+ sky130_fd_sc_hd__nand2_1
X$6116 VDD synth_7416 synth_657 synth_7445 VDD VNB|VSS VNB|VSS
+ sky130_fd_sc_hd__nand2_1
X$6117 VDD synth_4365 synth_4363 synth_4283 VDD VNB|VSS VNB|VSS
+ sky130_fd_sc_hd__nand2_1
X$6118 VDD synth_7215 synth_6695 synth_7270 VDD VNB|VSS VNB|VSS
+ sky130_fd_sc_hd__nand2_1
X$6119 VDD synth_12393 synth_12590 synth_12647 VDD VNB|VSS VNB|VSS
+ sky130_fd_sc_hd__nand2_1
X$6120 VDD synth_3642 synth_3523 synth_3274 VDD VNB|VSS VNB|VSS
+ sky130_fd_sc_hd__nand2_1
X$6121 VDD synth_10525 synth_10700 synth_10744 VDD VNB|VSS VNB|VSS
+ sky130_fd_sc_hd__nand2_1
X$6122 VDD synth_151 synth_1494 synth_1272 VDD VNB|VSS VNB|VSS
+ sky130_fd_sc_hd__nand2_1
X$6123 VDD synth_8997 synth_8833 synth_9168 VDD VNB|VSS VNB|VSS
+ sky130_fd_sc_hd__nand2_1
X$6124 VDD synth_3616 synth_6888 synth_8451 VDD VNB|VSS VNB|VSS
+ sky130_fd_sc_hd__nand2_1
X$6125 VDD synth_7089 synth_6888 synth_8450 VDD VNB|VSS VNB|VSS
+ sky130_fd_sc_hd__nand2_1
X$6126 VDD synth_1557 synth_214 synth_1404 VDD VNB|VSS VNB|VSS
+ sky130_fd_sc_hd__nand2_1
X$6127 VDD synth_1815 synth_1887 synth_1814 VDD VNB|VSS VNB|VSS
+ sky130_fd_sc_hd__nand2_1
X$6128 VDD synth_11260 synth_11487 synth_11585 VDD VNB|VSS VNB|VSS
+ sky130_fd_sc_hd__nand2_1
X$6129 VDD synth_1641 synth_214 synth_1359 VDD VNB|VSS VNB|VSS
+ sky130_fd_sc_hd__nand2_1
X$6130 VDD synth_10819 synth_10895 synth_10851 VDD VNB|VSS VNB|VSS
+ sky130_fd_sc_hd__nand2_1
X$6131 VDD synth_11488 synth_11487 synth_11618 VDD VNB|VSS VNB|VSS
+ sky130_fd_sc_hd__nand2_1
X$6132 VDD synth_1378 synth_364 synth_1197 VDD VNB|VSS VNB|VSS
+ sky130_fd_sc_hd__nand2_1
X$6133 VDD synth_11824 synth_11915 synth_11977 VDD VNB|VSS VNB|VSS
+ sky130_fd_sc_hd__nand2_1
X$6134 VDD synth_7119 synth_7232 synth_6998 VDD VNB|VSS VNB|VSS
+ sky130_fd_sc_hd__nand2_1
X$6135 VDD synth_7613 synth_7418 synth_7497 VDD VNB|VSS VNB|VSS
+ sky130_fd_sc_hd__nand2_1
X$6136 VDD synth_3563 synth_3642 synth_3940 VDD VNB|VSS VNB|VSS
+ sky130_fd_sc_hd__nand2_1
X$6137 VDD synth_657 synth_1494 synth_909 VDD VNB|VSS VNB|VSS
+ sky130_fd_sc_hd__nand2_1
X$6138 VDD synth_9022 synth_8450 synth_8692 VDD VNB|VSS VNB|VSS
+ sky130_fd_sc_hd__nand2_1
X$6139 VDD synth_274 synth_214 synth_18 VDD VNB|VSS VNB|VSS
+ sky130_fd_sc_hd__nand2_1
X$6140 VDD synth_7422 synth_7502 synth_7514 VDD VNB|VSS VNB|VSS
+ sky130_fd_sc_hd__nand2_1
X$6141 VDD synth_1076 synth_657 synth_755 VDD VNB|VSS VNB|VSS
+ sky130_fd_sc_hd__nand2_1
X$6142 VDD synth_11191 synth_11147 synth_11232 VDD VNB|VSS VNB|VSS
+ sky130_fd_sc_hd__nand2_1
X$6143 VDD synth_2116 synth_3463 synth_3381 VDD VNB|VSS VNB|VSS
+ sky130_fd_sc_hd__nand2_1
X$6144 VDD synth_1342 synth_1428 synth_1471 VDD VNB|VSS VNB|VSS
+ sky130_fd_sc_hd__nand2_1
X$6145 VDD synth_1166 synth_1352 synth_1483 VDD VNB|VSS VNB|VSS
+ sky130_fd_sc_hd__nand2_1
X$6146 VDD synth_10164 synth_11699 synth_11915 VDD VNB|VSS VNB|VSS
+ sky130_fd_sc_hd__nand2_1
X$6147 VDD synth_927 synth_1378 synth_1297 VDD VNB|VSS VNB|VSS
+ sky130_fd_sc_hd__nand2_1
X$6148 VDD synth_1403 synth_1352 synth_1430 VDD VNB|VSS VNB|VSS
+ sky130_fd_sc_hd__nand2_1
X$6149 VDD synth_6977 synth_7038 synth_7120 VDD VNB|VSS VNB|VSS
+ sky130_fd_sc_hd__nand2_1
X$6150 VDD synth_8817 synth_8450 synth_8652 VDD VNB|VSS VNB|VSS
+ sky130_fd_sc_hd__nand2_1
X$6151 VDD synth_12035 synth_12034 synth_12068 VDD VNB|VSS VNB|VSS
+ sky130_fd_sc_hd__nand2_1
X$6152 VDD synth_1021 synth_364 synth_523 VDD VNB|VSS VNB|VSS
+ sky130_fd_sc_hd__nand2_1
X$6153 VDD synth_8341 synth_8117 synth_8309 VDD VNB|VSS VNB|VSS
+ sky130_fd_sc_hd__nand2_1
X$6154 VDD synth_7003 synth_6548 synth_6447 VDD VNB|VSS VNB|VSS
+ sky130_fd_sc_hd__nand2_1
X$6155 VDD synth_10921 synth_5738 synth_10812 VDD VNB|VSS VNB|VSS
+ sky130_fd_sc_hd__nand2_1
X$6156 VDD synth_8826 synth_8931 synth_9084 VDD VNB|VSS VNB|VSS
+ sky130_fd_sc_hd__nand2_1
X$6157 VDD synth_9086 synth_8931 synth_9027 VDD VNB|VSS VNB|VSS
+ sky130_fd_sc_hd__nand2_1
X$6158 VDD synth_1353 synth_3970 synth_3767 VDD VNB|VSS VNB|VSS
+ sky130_fd_sc_hd__nand2_1
X$6159 VDD synth_10330 synth_10163 synth_10165 VDD VNB|VSS VNB|VSS
+ sky130_fd_sc_hd__nand2_1
X$6160 VDD synth_3738 synth_3468 synth_3827 VDD VNB|VSS VNB|VSS
+ sky130_fd_sc_hd__nand2_1
X$6161 VDD synth_9910 synth_3616 synth_9838 VDD VNB|VSS VNB|VSS
+ sky130_fd_sc_hd__nand2_1
X$6162 VDD synth_813 synth_214 synth_610 VDD VNB|VSS VNB|VSS
+ sky130_fd_sc_hd__nand2_1
X$6163 VDD synth_207 synth_132 synth_374 VDD VNB|VSS VNB|VSS
+ sky130_fd_sc_hd__nand2_1
X$6164 VDD synth_8183 synth_8184 synth_8132 VDD VNB|VSS VNB|VSS
+ sky130_fd_sc_hd__nand2_1
X$6165 VDD synth_6597 synth_6673 synth_6548 VDD VNB|VSS VNB|VSS
+ sky130_fd_sc_hd__nand2_1
X$6166 VDD synth_7601 synth_8101 synth_7880 VDD VNB|VSS VNB|VSS
+ sky130_fd_sc_hd__nand2_1
X$6167 VDD synth_7743 synth_9250 synth_8954 VDD VNB|VSS VNB|VSS
+ sky130_fd_sc_hd__nand2_1
X$6168 VDD synth_3616 synth_9808 synth_10198 VDD VNB|VSS VNB|VSS
+ sky130_fd_sc_hd__nand2_1
X$6169 VDD synth_9273 synth_9271 synth_9247 VDD VNB|VSS VNB|VSS
+ sky130_fd_sc_hd__nand2_1
X$6170 VDD synth_2120 synth_2049 synth_2198 VDD VNB|VSS VNB|VSS
+ sky130_fd_sc_hd__nand2_1
X$6171 VDD synth_6443 synth_7186 synth_7095 VDD VNB|VSS VNB|VSS
+ sky130_fd_sc_hd__nand2_1
X$6172 VDD synth_6695 synth_7272 synth_7275 VDD VNB|VSS VNB|VSS
+ sky130_fd_sc_hd__nand2_1
X$6173 VDD synth_3831 synth_3940 synth_3967 VDD VNB|VSS VNB|VSS
+ sky130_fd_sc_hd__nand2_1
X$6174 VDD synth_8184 synth_8185 synth_8209 VDD VNB|VSS VNB|VSS
+ sky130_fd_sc_hd__nand2_1
X$6175 VDD synth_1109 synth_1428 synth_1473 VDD VNB|VSS VNB|VSS
+ sky130_fd_sc_hd__nand2_1
X$6176 VDD synth_8347 synth_8536 synth_8537 VDD VNB|VSS VNB|VSS
+ sky130_fd_sc_hd__nand2_1
X$6177 VDD synth_10164 synth_9808 synth_10163 VDD VNB|VSS VNB|VSS
+ sky130_fd_sc_hd__nand2_1
X$6178 VDD synth_9339 synth_9338 synth_9248 VDD VNB|VSS VNB|VSS
+ sky130_fd_sc_hd__nand2_1
X$6179 VDD synth_9453 synth_9072 synth_9338 VDD VNB|VSS VNB|VSS
+ sky130_fd_sc_hd__nand2_1
X$6180 VDD synth_8018 synth_8185 synth_8096 VDD VNB|VSS VNB|VSS
+ sky130_fd_sc_hd__nand2_1
X$6181 VDD synth_66 synth_2397 synth_2204 VDD VNB|VSS VNB|VSS
+ sky130_fd_sc_hd__nand2_1
X$6182 VDD synth_2483 synth_2204 synth_2484 VDD VNB|VSS VNB|VSS
+ sky130_fd_sc_hd__nand2_1
X$6183 VDD synth_11699 synth_3616 synth_11839 VDD VNB|VSS VNB|VSS
+ sky130_fd_sc_hd__nand2_1
X$6184 VDD synth_7196 synth_8181 synth_8014 VDD VNB|VSS VNB|VSS
+ sky130_fd_sc_hd__nand2_1
X$6185 VDD synth_5738 synth_11364 synth_11264 VDD VNB|VSS VNB|VSS
+ sky130_fd_sc_hd__nand2_1
X$6186 VDD synth_6760 synth_6909 synth_7134 VDD VNB|VSS VNB|VSS
+ sky130_fd_sc_hd__nand2_1
X$6187 VDD synth_9762 synth_11078 synth_11077 VDD VNB|VSS VNB|VSS
+ sky130_fd_sc_hd__nand2_1
X$6188 VDD synth_10976 synth_11077 synth_11202 VDD VNB|VSS VNB|VSS
+ sky130_fd_sc_hd__nand2_1
X$6189 VDD synth_7743 synth_11606 synth_11940 VDD VNB|VSS VNB|VSS
+ sky130_fd_sc_hd__nand2_1
X$6190 VDD synth_6399 synth_6461 synth_6557 VDD VNB|VSS VNB|VSS
+ sky130_fd_sc_hd__nand2_1
X$6191 VDD synth_2280 synth_364 synth_2129 VDD VNB|VSS VNB|VSS
+ sky130_fd_sc_hd__nand2_1
X$6192 VDD synth_9755 synth_9686 synth_9800 VDD VNB|VSS VNB|VSS
+ sky130_fd_sc_hd__nand2_1
X$6193 VDD synth_10993 synth_10920 synth_11187 VDD VNB|VSS VNB|VSS
+ sky130_fd_sc_hd__nand2_1
X$6194 VDD synth_965 synth_752 synth_821 VDD VNB|VSS VNB|VSS
+ sky130_fd_sc_hd__nand2_1
X$6195 VDD synth_5910 synth_657 synth_5850 VDD VNB|VSS VNB|VSS
+ sky130_fd_sc_hd__nand2_1
X$6196 VDD synth_9278 synth_9056 synth_9223 VDD VNB|VSS VNB|VSS
+ sky130_fd_sc_hd__nand2_1
X$6197 VDD synth_9132 synth_8958 synth_9025 VDD VNB|VSS VNB|VSS
+ sky130_fd_sc_hd__nand2_1
X$6198 VDD synth_9142 synth_9098 synth_9274 VDD VNB|VSS VNB|VSS
+ sky130_fd_sc_hd__nand2_1
X$6199 VDD synth_9311 synth_9309 synth_8904 VDD VNB|VSS VNB|VSS
+ sky130_fd_sc_hd__nand2_1
X$6200 VDD synth_151 synth_792 synth_752 VDD VNB|VSS VNB|VSS
+ sky130_fd_sc_hd__nand2_1
X$6201 VDD synth_11587 synth_5738 synth_11800 VDD VNB|VSS VNB|VSS
+ sky130_fd_sc_hd__nand2_1
X$6202 VDD synth_10963 synth_10920 synth_11038 VDD VNB|VSS VNB|VSS
+ sky130_fd_sc_hd__nand2_1
X$6203 VDD synth_9790 synth_9789 synth_9752 VDD VNB|VSS VNB|VSS
+ sky130_fd_sc_hd__nand2_1
X$6204 VDD synth_6432 synth_7016 synth_7220 VDD VNB|VSS VNB|VSS
+ sky130_fd_sc_hd__nand2_1
X$6205 VDD synth_6803 synth_6548 synth_6549 VDD VNB|VSS VNB|VSS
+ sky130_fd_sc_hd__nand2_1
X$6206 VDD synth_6573 synth_6264 synth_6314 VDD VNB|VSS VNB|VSS
+ sky130_fd_sc_hd__nand2_1
X$6207 VDD synth_9411 synth_9365 synth_9495 VDD VNB|VSS VNB|VSS
+ sky130_fd_sc_hd__nand2_1
X$6208 VDD synth_3240 synth_3239 synth_3314 VDD VNB|VSS VNB|VSS
+ sky130_fd_sc_hd__nand2_1
X$6209 VDD synth_10164 synth_10921 synth_10920 VDD VNB|VSS VNB|VSS
+ sky130_fd_sc_hd__nand2_1
X$6210 VDD synth_10164 synth_11587 synth_11841 VDD VNB|VSS VNB|VSS
+ sky130_fd_sc_hd__nand2_1
X$6211 VDD synth_749 synth_614 synth_670 VDD VNB|VSS VNB|VSS
+ sky130_fd_sc_hd__nand2_1
X$6212 VDD synth_10535 synth_10625 synth_10626 VDD VNB|VSS VNB|VSS
+ sky130_fd_sc_hd__nand2_1
X$6213 VDD synth_7798 synth_7111 synth_7958 VDD VNB|VSS VNB|VSS
+ sky130_fd_sc_hd__nand2_1
X$6214 VDD synth_3832 synth_3968 synth_4066 VDD VNB|VSS VNB|VSS
+ sky130_fd_sc_hd__nand2_1
X$6215 VDD synth_9409 synth_9405 synth_9455 VDD VNB|VSS VNB|VSS
+ sky130_fd_sc_hd__nand2_1
X$6216 VDD synth_11078 synth_5738 synth_11079 VDD VNB|VSS VNB|VSS
+ sky130_fd_sc_hd__nand2_1
X$6217 VDD synth_10121 synth_9987 synth_10224 VDD VNB|VSS VNB|VSS
+ sky130_fd_sc_hd__nand2_1
X$6218 VDD synth_636 synth_263 synth_465 VDD VNB|VSS VNB|VSS
+ sky130_fd_sc_hd__nand2_1
X$6219 VDD synth_4803 synth_1015 synth_5870 VDD VNB|VSS VNB|VSS
+ sky130_fd_sc_hd__nand2_1
X$6220 VDD synth_5814 synth_3632 synth_5898 VDD VNB|VSS VNB|VSS
+ sky130_fd_sc_hd__nand2_1
X$6221 VDD synth_12460 synth_5738 synth_12401 VDD VNB|VSS VNB|VSS
+ sky130_fd_sc_hd__nand2_1
X$6222 VDD synth_1063 synth_1062 synth_1129 VDD VNB|VSS VNB|VSS
+ sky130_fd_sc_hd__nand2_1
X$6223 VDD synth_2849 synth_2116 synth_3150 VDD VNB|VSS VNB|VSS
+ sky130_fd_sc_hd__nand2_1
X$6224 VDD synth_895 synth_1062 synth_1156 VDD VNB|VSS VNB|VSS
+ sky130_fd_sc_hd__nand2_1
X$6225 VDD synth_11086 synth_5738 synth_10765 VDD VNB|VSS VNB|VSS
+ sky130_fd_sc_hd__nand2_1
X$6226 VDD synth_167 synth_451 synth_234 VDD VNB|VSS VNB|VSS
+ sky130_fd_sc_hd__nand2_1
X$6227 VDD synth_5978 synth_5809 synth_6068 VDD VNB|VSS VNB|VSS
+ sky130_fd_sc_hd__nand2_1
X$6228 VDD synth_6199 synth_5809 synth_5893 VDD VNB|VSS VNB|VSS
+ sky130_fd_sc_hd__nand2_1
X$6229 VDD synth_1015 synth_4499 synth_5670 VDD VNB|VSS VNB|VSS
+ sky130_fd_sc_hd__nand2_1
X$6230 VDD synth_9423 synth_12087 synth_12296 VDD VNB|VSS VNB|VSS
+ sky130_fd_sc_hd__nand2_1
X$6231 VDD synth_3041 synth_657 synth_2874 VDD VNB|VSS VNB|VSS
+ sky130_fd_sc_hd__nand2_1
X$6232 VDD synth_9063 synth_9427 synth_9582 VDD VNB|VSS VNB|VSS
+ sky130_fd_sc_hd__nand2_1
X$6233 VDD synth_4325 synth_1015 synth_4925 VDD VNB|VSS VNB|VSS
+ sky130_fd_sc_hd__nand2_1
X$6234 VDD synth_5307 synth_5068 synth_5139 VDD VNB|VSS VNB|VSS
+ sky130_fd_sc_hd__nand2_1
X$6235 VDD synth_5415 synth_5252 synth_5543 VDD VNB|VSS VNB|VSS
+ sky130_fd_sc_hd__nand2_1
X$6236 VDD synth_2885 synth_364 synth_2596 VDD VNB|VSS VNB|VSS
+ sky130_fd_sc_hd__nand2_1
X$6237 VDD synth_9119 synth_8806 synth_9177 VDD VNB|VSS VNB|VSS
+ sky130_fd_sc_hd__nand2_1
X$6238 VDD synth_1338 synth_1313 synth_1062 VDD VNB|VSS VNB|VSS
+ sky130_fd_sc_hd__nand2_1
X$6239 VDD synth_9160 synth_9200 synth_9381 VDD VNB|VSS VNB|VSS
+ sky130_fd_sc_hd__nand2_1
X$6240 VDD synth_9432 synth_9436 synth_9520 VDD VNB|VSS VNB|VSS
+ sky130_fd_sc_hd__nand2_1
X$6241 VDD synth_6453 synth_6349 synth_6585 VDD VNB|VSS VNB|VSS
+ sky130_fd_sc_hd__nand2_1
X$6242 VDD synth_10586 synth_10585 synth_10453 VDD VNB|VSS VNB|VSS
+ sky130_fd_sc_hd__nand2_1
X$6243 VDD synth_12335 synth_12296 synth_12389 VDD VNB|VSS VNB|VSS
+ sky130_fd_sc_hd__nand2_1
X$6244 VDD synth_6049 synth_1015 synth_6420 VDD VNB|VSS VNB|VSS
+ sky130_fd_sc_hd__nand2_1
X$6245 VDD synth_12270 synth_12296 synth_12337 VDD VNB|VSS VNB|VSS
+ sky130_fd_sc_hd__nand2_1
X$6246 VDD synth_6053 synth_5747 synth_5961 VDD VNB|VSS VNB|VSS
+ sky130_fd_sc_hd__nand2_1
X$6247 VDD synth_3632 synth_5748 synth_5747 VDD VNB|VSS VNB|VSS
+ sky130_fd_sc_hd__nand2_1
X$6248 VDD synth_1720 synth_1721 synth_1637 VDD VNB|VSS VNB|VSS
+ sky130_fd_sc_hd__nand2_1
X$6249 VDD synth_3165 synth_3058 synth_3166 VDD VNB|VSS VNB|VSS
+ sky130_fd_sc_hd__nand2_1
X$6250 VDD synth_3198 synth_3161 synth_3162 VDD VNB|VSS VNB|VSS
+ sky130_fd_sc_hd__nand2_1
X$6251 VDD synth_4305 synth_4377 synth_4455 VDD VNB|VSS VNB|VSS
+ sky130_fd_sc_hd__nand2_1
X$6252 VDD synth_214 synth_336 synth_13 VDD VNB|VSS VNB|VSS
+ sky130_fd_sc_hd__nand2_1
X$6253 VDD synth_3632 synth_4796 synth_5014 VDD VNB|VSS VNB|VSS
+ sky130_fd_sc_hd__nand2_1
X$6254 VDD synth_1015 synth_4914 synth_4791 VDD VNB|VSS VNB|VSS
+ sky130_fd_sc_hd__nand2_1
X$6255 VDD synth_4916 synth_4915 synth_4965 VDD VNB|VSS VNB|VSS
+ sky130_fd_sc_hd__nand2_1
X$6256 VDD synth_3632 synth_4914 synth_4915 VDD VNB|VSS VNB|VSS
+ sky130_fd_sc_hd__nand2_1
X$6257 VDD synth_5210 synth_4915 synth_4966 VDD VNB|VSS VNB|VSS
+ sky130_fd_sc_hd__nand2_1
X$6258 VDD synth_3632 synth_4913 synth_4727 VDD VNB|VSS VNB|VSS
+ sky130_fd_sc_hd__nand2_1
X$6259 VDD synth_2931 synth_2948 synth_2930 VDD VNB|VSS VNB|VSS
+ sky130_fd_sc_hd__nand2_1
X$6260 VDD synth_6451 synth_6450 synth_6377 VDD VNB|VSS VNB|VSS
+ sky130_fd_sc_hd__nand2_1
X$6261 VDD synth_12634 synth_12515 synth_12460 VDD VNB|VSS VNB|VSS
+ sky130_fd_sc_hd__nand2_1
X$6262 VDD synth_214 synth_4800 synth_5069 VDD VNB|VSS VNB|VSS
+ sky130_fd_sc_hd__nand2_1
X$6263 VDD synth_5817 synth_5963 synth_5748 VDD VNB|VSS VNB|VSS
+ sky130_fd_sc_hd__nand2_1
X$6264 VDD synth_7743 synth_10760 synth_10449 VDD VNB|VSS VNB|VSS
+ sky130_fd_sc_hd__nand2_1
X$6265 VDD synth_135 synth_201 synth_202 VDD VNB|VSS VNB|VSS
+ sky130_fd_sc_hd__nand2_1
X$6266 VDD synth_66 synth_1112 synth_763 VDD VNB|VSS VNB|VSS
+ sky130_fd_sc_hd__nand2_1
X$6267 VDD synth_74 synth_201 synth_200 VDD VNB|VSS VNB|VSS
+ sky130_fd_sc_hd__nand2_1
X$6268 VDD synth_9042 synth_9433 synth_9476 VDD VNB|VSS VNB|VSS
+ sky130_fd_sc_hd__nand2_1
X$6269 VDD synth_430 synth_390 synth_429 VDD VNB|VSS VNB|VSS
+ sky130_fd_sc_hd__nand2_1
X$6270 VDD synth_9285 synth_9237 synth_9280 VDD VNB|VSS VNB|VSS
+ sky130_fd_sc_hd__nand2_1
X$6271 VDD synth_3632 synth_4803 synth_5982 VDD VNB|VSS VNB|VSS
+ sky130_fd_sc_hd__nand2_1
X$6272 VDD synth_6046 synth_5982 synth_6125 VDD VNB|VSS VNB|VSS
+ sky130_fd_sc_hd__nand2_1
X$6273 VDD synth_366 synth_194 synth_586 VDD VNB|VSS VNB|VSS
+ sky130_fd_sc_hd__nand2_1
X$6274 VDD synth_9233 synth_10097 synth_10045 VDD VNB|VSS VNB|VSS
+ sky130_fd_sc_hd__nand2_1
X$6275 VDD synth_1522 synth_1521 synth_1450 VDD VNB|VSS VNB|VSS
+ sky130_fd_sc_hd__nand2_1
X$6276 VDD synth_10011 synth_9932 synth_10105 VDD VNB|VSS VNB|VSS
+ sky130_fd_sc_hd__nand2_1
X$6277 VDD synth_2279 synth_2204 synth_2345 VDD VNB|VSS VNB|VSS
+ sky130_fd_sc_hd__nand2_1
X$6278 VDD synth_5136 synth_4887 synth_5107 VDD VNB|VSS VNB|VSS
+ sky130_fd_sc_hd__nand2_1
X$6279 VDD synth_5528 synth_5675 synth_5772 VDD VNB|VSS VNB|VSS
+ sky130_fd_sc_hd__nand2_1
X$6280 VDD synth_9119 synth_10443 synth_10445 VDD VNB|VSS VNB|VSS
+ sky130_fd_sc_hd__nand2_1
X$6281 VDD synth_5593 synth_3544 synth_5608 VDD VNB|VSS VNB|VSS
+ sky130_fd_sc_hd__nand2_1
X$6282 VDD synth_735 synth_802 synth_803 VDD VNB|VSS VNB|VSS
+ sky130_fd_sc_hd__nand2_1
X$6283 VDD synth_787 synth_737 synth_738 VDD VNB|VSS VNB|VSS
+ sky130_fd_sc_hd__nand2_1
X$6284 VDD synth_3626 synth_3604 synth_3726 VDD VNB|VSS VNB|VSS
+ sky130_fd_sc_hd__nand2_1
X$6285 VDD synth_194 synth_426 synth_102 VDD VNB|VSS VNB|VSS
+ sky130_fd_sc_hd__nand2_1
X$6286 VDD synth_8805 synth_10310 synth_10311 VDD VNB|VSS VNB|VSS
+ sky130_fd_sc_hd__nand2_1
X$6287 VDD synth_10605 synth_10584 synth_10677 VDD VNB|VSS VNB|VSS
+ sky130_fd_sc_hd__nand2_1
X$6288 VDD synth_10229 synth_5738 synth_9898 VDD VNB|VSS VNB|VSS
+ sky130_fd_sc_hd__nand2_1
X$6289 VDD synth_1831 synth_1744 synth_1897 VDD VNB|VSS VNB|VSS
+ sky130_fd_sc_hd__nand2_1
X$6290 VDD synth_8000 synth_7979 synth_7783 VDD VNB|VSS VNB|VSS
+ sky130_fd_sc_hd__nand2_1
X$6291 VDD synth_1338 synth_4188 synth_4345 VDD VNB|VSS VNB|VSS
+ sky130_fd_sc_hd__nand2_1
X$6292 VDD synth_10168 synth_9423 synth_10216 VDD VNB|VSS VNB|VSS
+ sky130_fd_sc_hd__nand2_1
X$6293 VDD synth_5262 synth_4993 synth_5383 VDD VNB|VSS VNB|VSS
+ sky130_fd_sc_hd__nand2_1
X$6294 VDD synth_2068 synth_2136 synth_2216 VDD VNB|VSS VNB|VSS
+ sky130_fd_sc_hd__nand2_1
X$6295 VDD synth_9559 synth_10142 synth_10899 VDD VNB|VSS VNB|VSS
+ sky130_fd_sc_hd__nand2_1
X$6296 VDD synth_10306 synth_10305 synth_10408 VDD VNB|VSS VNB|VSS
+ sky130_fd_sc_hd__nand2_1
X$6297 VDD synth_2215 synth_2136 synth_2137 VDD VNB|VSS VNB|VSS
+ sky130_fd_sc_hd__nand2_1
X$6298 VDD synth_3668 synth_3555 synth_3624 VDD VNB|VSS VNB|VSS
+ sky130_fd_sc_hd__nand2_1
X$6299 VDD synth_5260 synth_4709 synth_5259 VDD VNB|VSS VNB|VSS
+ sky130_fd_sc_hd__nand2_1
X$6300 VDD synth_1015 synth_3750 synth_3295 VDD VNB|VSS VNB|VSS
+ sky130_fd_sc_hd__nand2_1
X$6301 VDD synth_1015 synth_4188 synth_4089 VDD VNB|VSS VNB|VSS
+ sky130_fd_sc_hd__nand2_1
X$6302 VDD synth_9964 synth_9857 synth_10042 VDD VNB|VSS VNB|VSS
+ sky130_fd_sc_hd__nand2_1
X$6303 VDD synth_9762 synth_11922 synth_11850 VDD VNB|VSS VNB|VSS
+ sky130_fd_sc_hd__nand2_1
X$6304 VDD synth_1292 synth_1485 synth_1447 VDD VNB|VSS VNB|VSS
+ sky130_fd_sc_hd__nand2_1
X$6305 VDD synth_4287 synth_364 synth_4151 VDD VNB|VSS VNB|VSS
+ sky130_fd_sc_hd__nand2_1
X$6306 VDD synth_1353 synth_4287 synth_4369 VDD VNB|VSS VNB|VSS
+ sky130_fd_sc_hd__nand2_1
X$6307 VDD synth_6146 synth_6119 synth_6142 VDD VNB|VSS VNB|VSS
+ sky130_fd_sc_hd__nand2_1
X$6308 VDD synth_4372 synth_4371 synth_4287 VDD VNB|VSS VNB|VSS
+ sky130_fd_sc_hd__nand2_1
X$6309 VDD synth_5988 synth_1015 synth_6781 VDD VNB|VSS VNB|VSS
+ sky130_fd_sc_hd__nand2_1
X$6310 VDD synth_6368 synth_6143 synth_6369 VDD VNB|VSS VNB|VSS
+ sky130_fd_sc_hd__nand2_1
X$6311 VDD synth_2242 synth_2346 synth_2397 VDD VNB|VSS VNB|VSS
+ sky130_fd_sc_hd__nand2_1
X$6312 VDD synth_7111 synth_7545 synth_8325 VDD VNB|VSS VNB|VSS
+ sky130_fd_sc_hd__nand2_1
X$6313 VDD synth_8290 synth_8325 synth_8425 VDD VNB|VSS VNB|VSS
+ sky130_fd_sc_hd__nand2_1
X$6314 VDD synth_8378 synth_8325 synth_8424 VDD VNB|VSS VNB|VSS
+ sky130_fd_sc_hd__nand2_1
X$6315 VDD synth_2884 synth_364 synth_2442 VDD VNB|VSS VNB|VSS
+ sky130_fd_sc_hd__nand2_1
X$6316 VDD synth_5738 synth_5808 synth_5558 VDD VNB|VSS VNB|VSS
+ sky130_fd_sc_hd__nand2_1
X$6317 VDD synth_6140 synth_6226 synth_6141 VDD VNB|VSS VNB|VSS
+ sky130_fd_sc_hd__nand2_1
X$6318 VDD synth_2107 synth_6292 synth_6226 VDD VNB|VSS VNB|VSS
+ sky130_fd_sc_hd__nand2_1
X$6319 VDD synth_6444 synth_6411 synth_6364 VDD VNB|VSS VNB|VSS
+ sky130_fd_sc_hd__nand2_1
X$6320 VDD synth_11991 synth_11923 synth_11925 VDD VNB|VSS VNB|VSS
+ sky130_fd_sc_hd__nand2_1
X$6321 VDD synth_5944 synth_6066 synth_5803 VDD VNB|VSS VNB|VSS
+ sky130_fd_sc_hd__nand2_1
X$6322 VDD synth_5945 synth_5889 synth_5804 VDD VNB|VSS VNB|VSS
+ sky130_fd_sc_hd__nand2_1
X$6323 VDD synth_8321 synth_8172 synth_8390 VDD VNB|VSS VNB|VSS
+ sky130_fd_sc_hd__nand2_1
X$6324 VDD synth_5863 synth_5805 synth_5892 VDD VNB|VSS VNB|VSS
+ sky130_fd_sc_hd__nand2_1
X$6325 VDD synth_3544 synth_5776 synth_5805 VDD VNB|VSS VNB|VSS
+ sky130_fd_sc_hd__nand2_1
X$6326 VDD synth_8319 synth_8167 synth_8438 VDD VNB|VSS VNB|VSS
+ sky130_fd_sc_hd__nand2_1
X$6327 VDD synth_5738 synth_5776 synth_5455 VDD VNB|VSS VNB|VSS
+ sky130_fd_sc_hd__nand2_1
X$6328 VDD synth_2970 synth_2603 synth_2896 VDD VNB|VSS VNB|VSS
+ sky130_fd_sc_hd__nand2_1
X$6329 VDD synth_3544 synth_5808 synth_5492 VDD VNB|VSS VNB|VSS
+ sky130_fd_sc_hd__nand2_1
X$6330 VDD synth_7111 synth_7309 synth_8172 VDD VNB|VSS VNB|VSS
+ sky130_fd_sc_hd__nand2_1
X$6331 VDD synth_4041 synth_4140 synth_4115 VDD VNB|VSS VNB|VSS
+ sky130_fd_sc_hd__nand2_1
X$6332 VDD synth_3616 synth_7852 synth_7724 VDD VNB|VSS VNB|VSS
+ sky130_fd_sc_hd__nand2_1
X$6333 VDD synth_9762 synth_12375 synth_12506 VDD VNB|VSS VNB|VSS
+ sky130_fd_sc_hd__nand2_1
X$6334 VDD synth_1353 synth_1884 synth_1957 VDD VNB|VSS VNB|VSS
+ sky130_fd_sc_hd__nand2_1
X$6335 VDD synth_2025 synth_1957 synth_2046 VDD VNB|VSS VNB|VSS
+ sky130_fd_sc_hd__nand2_1
X$6336 VDD synth_1884 synth_214 synth_1804 VDD VNB|VSS VNB|VSS
+ sky130_fd_sc_hd__nand2_1
X$6337 VDD synth_5076 synth_657 synth_4739 VDD VNB|VSS VNB|VSS
+ sky130_fd_sc_hd__nand2_1
X$6338 VDD synth_7313 synth_7196 synth_8004 VDD VNB|VSS VNB|VSS
+ sky130_fd_sc_hd__nand2_1
X$6339 VDD synth_12372 synth_12506 synth_12545 VDD VNB|VSS VNB|VSS
+ sky130_fd_sc_hd__nand2_1
X$6340 VDD synth_12428 synth_12506 synth_12543 VDD VNB|VSS VNB|VSS
+ sky130_fd_sc_hd__nand2_1
X$6341 VDD synth_7615 synth_7572 synth_7699 VDD VNB|VSS VNB|VSS
+ sky130_fd_sc_hd__nand2_1
X$6342 VDD synth_7539 synth_7572 synth_7647 VDD VNB|VSS VNB|VSS
+ sky130_fd_sc_hd__nand2_1
X$6343 VDD synth_9160 synth_8986 synth_9111 VDD VNB|VSS VNB|VSS
+ sky130_fd_sc_hd__nand2_1
X$6344 VDD synth_5726 synth_1015 synth_6813 VDD VNB|VSS VNB|VSS
+ sky130_fd_sc_hd__nand2_1
X$6345 VDD synth_8281 synth_7916 synth_8046 VDD VNB|VSS VNB|VSS
+ sky130_fd_sc_hd__nand2_1
X$6346 VDD synth_7721 synth_7691 synth_7722 VDD VNB|VSS VNB|VSS
+ sky130_fd_sc_hd__nand2_1
X$6347 VDD synth_8910 synth_8738 synth_9008 VDD VNB|VSS VNB|VSS
+ sky130_fd_sc_hd__nand2_1
X$6348 VDD synth_3616 synth_7289 synth_7568 VDD VNB|VSS VNB|VSS
+ sky130_fd_sc_hd__nand2_1
X$6349 VDD synth_7183 synth_7289 synth_7691 VDD VNB|VSS VNB|VSS
+ sky130_fd_sc_hd__nand2_1
X$6350 VDD synth_8910 synth_8946 synth_9047 VDD VNB|VSS VNB|VSS
+ sky130_fd_sc_hd__nand2_1
X$6351 VDD synth_5318 synth_1015 synth_5316 VDD VNB|VSS VNB|VSS
+ sky130_fd_sc_hd__nand2_1
X$6352 VDD synth_7612 synth_7183 synth_7693 VDD VNB|VSS VNB|VSS
+ sky130_fd_sc_hd__nand2_1
X$6353 VDD synth_7256 synth_7187 synth_7367 VDD VNB|VSS VNB|VSS
+ sky130_fd_sc_hd__nand2_1
X$6354 VDD synth_3616 synth_7019 synth_7098 VDD VNB|VSS VNB|VSS
+ sky130_fd_sc_hd__nand2_1
X$6355 VDD synth_11658 synth_5738 synth_12508 VDD VNB|VSS VNB|VSS
+ sky130_fd_sc_hd__nand2_1
X$6356 VDD synth_7153 synth_7187 synth_7097 VDD VNB|VSS VNB|VSS
+ sky130_fd_sc_hd__nand2_1
X$6357 VDD synth_7295 synth_7572 synth_7697 VDD VNB|VSS VNB|VSS
+ sky130_fd_sc_hd__nand2_1
X$6358 VDD synth_9221 synth_9223 synth_9224 VDD VNB|VSS VNB|VSS
+ sky130_fd_sc_hd__nand2_1
X$6359 VDD synth_7164 synth_7196 synth_6651 VDD VNB|VSS VNB|VSS
+ sky130_fd_sc_hd__nand2_1
X$6360 VDD synth_7111 synth_7164 synth_6901 VDD VNB|VSS VNB|VSS
+ sky130_fd_sc_hd__nand2_1
X$6361 VDD synth_9762 synth_11768 synth_11984 VDD VNB|VSS VNB|VSS
+ sky130_fd_sc_hd__nand2_1
X$6362 VDD synth_7183 synth_8859 synth_8754 VDD VNB|VSS VNB|VSS
+ sky130_fd_sc_hd__nand2_1
X$6363 VDD synth_151 synth_1442 synth_1281 VDD VNB|VSS VNB|VSS
+ sky130_fd_sc_hd__nand2_1
X$6364 VDD synth_6248 synth_364 synth_6164 VDD VNB|VSS VNB|VSS
+ sky130_fd_sc_hd__nand2_1
X$6365 VDD synth_7171 synth_7196 synth_7258 VDD VNB|VSS VNB|VSS
+ sky130_fd_sc_hd__nand2_1
X$6366 VDD synth_8849 synth_8794 synth_8920 VDD VNB|VSS VNB|VSS
+ sky130_fd_sc_hd__nand2_1
X$6367 VDD synth_11768 synth_5738 synth_11801 VDD VNB|VSS VNB|VSS
+ sky130_fd_sc_hd__nand2_1
X$6368 VDD synth_8429 synth_8462 synth_8543 VDD VNB|VSS VNB|VSS
+ sky130_fd_sc_hd__nand2_1
X$6369 VDD synth_6637 synth_6685 synth_6687 VDD VNB|VSS VNB|VSS
+ sky130_fd_sc_hd__nand2_1
X$6370 VDD synth_4961 synth_4615 synth_5088 VDD VNB|VSS VNB|VSS
+ sky130_fd_sc_hd__nand2_1
X$6371 VDD synth_991 synth_364 synth_914 VDD VNB|VSS VNB|VSS
+ sky130_fd_sc_hd__nand2_1
X$6372 VDD synth_1353 synth_2175 synth_2271 VDD VNB|VSS VNB|VSS
+ sky130_fd_sc_hd__nand2_1
X$6373 VDD synth_8224 synth_8167 synth_8303 VDD VNB|VSS VNB|VSS
+ sky130_fd_sc_hd__nand2_1
X$6374 VDD synth_7111 synth_7313 synth_8167 VDD VNB|VSS VNB|VSS
+ sky130_fd_sc_hd__nand2_1
X$6375 VDD synth_4995 synth_4840 synth_4842 VDD VNB|VSS VNB|VSS
+ sky130_fd_sc_hd__nand2_1
X$6376 VDD synth_12375 synth_5738 synth_12484 VDD VNB|VSS VNB|VSS
+ sky130_fd_sc_hd__nand2_1
X$6377 VDD synth_1054 synth_912 synth_990 VDD VNB|VSS VNB|VSS
+ sky130_fd_sc_hd__nand2_1
X$6378 VDD synth_7579 synth_7578 synth_7635 VDD VNB|VSS VNB|VSS
+ sky130_fd_sc_hd__nand2_1
X$6379 VDD synth_6597 synth_7305 synth_7578 VDD VNB|VSS VNB|VSS
+ sky130_fd_sc_hd__nand2_1
X$6380 VDD synth_4074 synth_4100 synth_4250 VDD VNB|VSS VNB|VSS
+ sky130_fd_sc_hd__nand2_1
X$6381 VDD synth_3742 synth_4100 synth_4249 VDD VNB|VSS VNB|VSS
+ sky130_fd_sc_hd__nand2_1
X$6382 VDD synth_1694 synth_1957 synth_2045 VDD VNB|VSS VNB|VSS
+ sky130_fd_sc_hd__nand2_1
X$6383 VDD synth_2190 synth_3881 synth_4164 VDD VNB|VSS VNB|VSS
+ sky130_fd_sc_hd__nand2_1
X$6384 VDD synth_2270 synth_2271 synth_2340 VDD VNB|VSS VNB|VSS
+ sky130_fd_sc_hd__nand2_1
X$6385 VDD synth_5254 synth_5312 synth_4835 VDD VNB|VSS VNB|VSS
+ sky130_fd_sc_hd__nand2_1
X$6386 VDD synth_5738 synth_7897 synth_7620 VDD VNB|VSS VNB|VSS
+ sky130_fd_sc_hd__nand2_1
X$6387 VDD synth_5150 synth_2116 synth_5238 VDD VNB|VSS VNB|VSS
+ sky130_fd_sc_hd__nand2_1
X$6388 VDD synth_2584 synth_2271 synth_2708 VDD VNB|VSS VNB|VSS
+ sky130_fd_sc_hd__nand2_1
X$6389 VDD synth_12663 synth_12497 synth_12520 VDD VNB|VSS VNB|VSS
+ sky130_fd_sc_hd__nand2_1
X$6390 VDD synth_7195 synth_7574 synth_7707 VDD VNB|VSS VNB|VSS
+ sky130_fd_sc_hd__nand2_1
X$6391 VDD synth_7483 synth_7574 synth_7709 VDD VNB|VSS VNB|VSS
+ sky130_fd_sc_hd__nand2_1
X$6392 VDD synth_7102 synth_7100 synth_7104 VDD VNB|VSS VNB|VSS
+ sky130_fd_sc_hd__nand2_1
X$6393 VDD synth_9432 synth_9326 synth_9289 VDD VNB|VSS VNB|VSS
+ sky130_fd_sc_hd__nand2_1
X$6394 VDD synth_7399 synth_7324 synth_7543 VDD VNB|VSS VNB|VSS
+ sky130_fd_sc_hd__nand2_1
X$6395 VDD synth_12043 synth_5738 synth_12205 VDD VNB|VSS VNB|VSS
+ sky130_fd_sc_hd__nand2_1
X$6396 VDD synth_5748 synth_1015 synth_5671 VDD VNB|VSS VNB|VSS
+ sky130_fd_sc_hd__nand2_1
X$6397 VDD synth_12511 synth_9762 synth_12623 VDD VNB|VSS VNB|VSS
+ sky130_fd_sc_hd__nand2_1
X$6398 VDD synth_6597 synth_7019 synth_7187 VDD VNB|VSS VNB|VSS
+ sky130_fd_sc_hd__nand2_1
X$6399 VDD synth_7082 synth_7197 synth_7237 VDD VNB|VSS VNB|VSS
+ sky130_fd_sc_hd__nand2_1
X$6400 VDD synth_7106 synth_7197 synth_7198 VDD VNB|VSS VNB|VSS
+ sky130_fd_sc_hd__nand2_1
X$6401 VDD synth_214 synth_2946 synth_2727 VDD VNB|VSS VNB|VSS
+ sky130_fd_sc_hd__nand2_1
X$6402 VDD synth_458 synth_234 synth_406 VDD VNB|VSS VNB|VSS
+ sky130_fd_sc_hd__nand2_1
X$6403 VDD synth_4605 synth_364 synth_4450 VDD VNB|VSS VNB|VSS
+ sky130_fd_sc_hd__nand2_1
X$6404 VDD synth_6679 synth_6606 synth_6776 VDD VNB|VSS VNB|VSS
+ sky130_fd_sc_hd__nand2_1
X$6405 VDD synth_9063 synth_9580 synth_9581 VDD VNB|VSS VNB|VSS
+ sky130_fd_sc_hd__nand2_1
X$6406 VDD synth_214 synth_2646 synth_2719 VDD VNB|VSS VNB|VSS
+ sky130_fd_sc_hd__nand2_1
X$6407 VDD synth_2945 synth_2843 synth_2925 VDD VNB|VSS VNB|VSS
+ sky130_fd_sc_hd__nand2_1
X$6408 VDD synth_2457 synth_214 synth_2318 VDD VNB|VSS VNB|VSS
+ sky130_fd_sc_hd__nand2_1
X$6409 VDD synth_2524 synth_2271 synth_2525 VDD VNB|VSS VNB|VSS
+ sky130_fd_sc_hd__nand2_1
X$6410 VDD synth_7743 synth_10872 synth_11392 VDD VNB|VSS VNB|VSS
+ sky130_fd_sc_hd__nand2_1
X$6411 VDD synth_192 synth_392 synth_340 VDD VNB|VSS VNB|VSS
+ sky130_fd_sc_hd__nand2_1
X$6412 VDD synth_12435 synth_12512 synth_12625 VDD VNB|VSS VNB|VSS
+ sky130_fd_sc_hd__nand2_1
X$6413 VDD synth_2116 synth_2192 synth_1882 VDD VNB|VSS VNB|VSS
+ sky130_fd_sc_hd__nand2_1
X$6414 VDD synth_12485 synth_12572 synth_12739 VDD VNB|VSS VNB|VSS
+ sky130_fd_sc_hd__nand2_1
X$6415 VDD synth_8441 synth_8000 synth_8610 VDD VNB|VSS VNB|VSS
+ sky130_fd_sc_hd__nand2_1
X$6416 VDD synth_11681 synth_11682 synth_11683 VDD VNB|VSS VNB|VSS
+ sky130_fd_sc_hd__nand2_1
X$6417 VDD synth_1800 synth_1882 synth_1927 VDD VNB|VSS VNB|VSS
+ sky130_fd_sc_hd__nand2_1
X$6418 VDD synth_12103 synth_5738 synth_12295 VDD VNB|VSS VNB|VSS
+ sky130_fd_sc_hd__nand2_1
X$6419 VDD synth_12089 synth_5738 synth_12761 VDD VNB|VSS VNB|VSS
+ sky130_fd_sc_hd__nand2_1
X$6420 VDD synth_9044 synth_9047 synth_8989 VDD VNB|VSS VNB|VSS
+ sky130_fd_sc_hd__nand2_1
X$6421 VDD synth_9042 synth_8764 synth_8990 VDD VNB|VSS VNB|VSS
+ sky130_fd_sc_hd__nand2_1
X$6422 VDD synth_4847 synth_4602 synth_4876 VDD VNB|VSS VNB|VSS
+ sky130_fd_sc_hd__nand2_1
X$6423 VDD synth_167 synth_4605 synth_4602 VDD VNB|VSS VNB|VSS
+ sky130_fd_sc_hd__nand2_1
X$6424 VDD synth_151 synth_444 synth_347 VDD VNB|VSS VNB|VSS
+ sky130_fd_sc_hd__nand2_1
X$6425 VDD synth_10316 synth_10317 synth_10884 VDD VNB|VSS VNB|VSS
+ sky130_fd_sc_hd__nand2_1
X$6426 VDD synth_2924 synth_2590 synth_2659 VDD VNB|VSS VNB|VSS
+ sky130_fd_sc_hd__nand2_1
X$6427 VDD synth_8981 synth_9284 synth_9325 VDD VNB|VSS VNB|VSS
+ sky130_fd_sc_hd__nand2_1
X$6428 VDD synth_9292 synth_9293 synth_9566 VDD VNB|VSS VNB|VSS
+ sky130_fd_sc_hd__nand2_1
X$6429 VDD synth_5112 synth_4735 synth_4900 VDD VNB|VSS VNB|VSS
+ sky130_fd_sc_hd__nand2_1
X$6430 VDD synth_2702 synth_2537 synth_2577 VDD VNB|VSS VNB|VSS
+ sky130_fd_sc_hd__nand2_1
X$6431 VDD synth_7929 synth_8294 synth_8242 VDD VNB|VSS VNB|VSS
+ sky130_fd_sc_hd__nand2_1
X$6432 VDD synth_8000 synth_8242 synth_8077 VDD VNB|VSS VNB|VSS
+ sky130_fd_sc_hd__nand2_1
X$6433 VDD synth_7196 synth_8242 synth_7859 VDD VNB|VSS VNB|VSS
+ sky130_fd_sc_hd__nand2_1
X$6434 VDD synth_8078 synth_8077 synth_8001 VDD VNB|VSS VNB|VSS
+ sky130_fd_sc_hd__nand2_1
X$6435 VDD synth_9324 synth_8802 synth_9293 VDD VNB|VSS VNB|VSS
+ sky130_fd_sc_hd__nand2_1
X$6436 VDD synth_4835 synth_214 synth_5115 VDD VNB|VSS VNB|VSS
+ sky130_fd_sc_hd__nand2_1
X$6437 VDD synth_5612 synth_1015 synth_6605 VDD VNB|VSS VNB|VSS
+ sky130_fd_sc_hd__nand2_1
X$6438 VDD synth_6656 synth_6450 synth_6604 VDD VNB|VSS VNB|VSS
+ sky130_fd_sc_hd__nand2_1
X$6439 VDD synth_2864 synth_2843 synth_2797 VDD VNB|VSS VNB|VSS
+ sky130_fd_sc_hd__nand2_1
X$6440 VDD synth_6673 synth_7196 synth_6373 VDD VNB|VSS VNB|VSS
+ sky130_fd_sc_hd__nand2_1
X$6441 VDD synth_3317 synth_3419 synth_3493 VDD VNB|VSS VNB|VSS
+ sky130_fd_sc_hd__nand2_1
X$6442 VDD synth_3493 synth_364 synth_3182 VDD VNB|VSS VNB|VSS
+ sky130_fd_sc_hd__nand2_1
X$6443 VDD synth_659 synth_3018 synth_3124 VDD VNB|VSS VNB|VSS
+ sky130_fd_sc_hd__nand2_1
X$6444 VDD synth_8870 synth_10099 synth_11248 VDD VNB|VSS VNB|VSS
+ sky130_fd_sc_hd__nand2_1
X$6445 VDD synth_3616 synth_4399 synth_4297 VDD VNB|VSS VNB|VSS
+ sky130_fd_sc_hd__nand2_1
X$6446 VDD synth_3616 synth_3584 synth_3285 VDD VNB|VSS VNB|VSS
+ sky130_fd_sc_hd__nand2_1
X$6447 VDD synth_3849 synth_3951 synth_4045 VDD VNB|VSS VNB|VSS
+ sky130_fd_sc_hd__nand2_1
X$6448 VDD synth_3541 synth_3952 synth_3951 VDD VNB|VSS VNB|VSS
+ sky130_fd_sc_hd__nand2_1
X$6449 VDD synth_3710 synth_3951 synth_3977 VDD VNB|VSS VNB|VSS
+ sky130_fd_sc_hd__nand2_1
X$6450 VDD synth_3774 synth_3840 synth_3773 VDD VNB|VSS VNB|VSS
+ sky130_fd_sc_hd__nand2_1
X$6451 VDD synth_3449 synth_3360 synth_3361 VDD VNB|VSS VNB|VSS
+ sky130_fd_sc_hd__nand2_1
X$6452 VDD synth_2384 synth_2352 synth_2353 VDD VNB|VSS VNB|VSS
+ sky130_fd_sc_hd__nand2_1
X$6453 VDD synth_3616 synth_3618 synth_3055 VDD VNB|VSS VNB|VSS
+ sky130_fd_sc_hd__nand2_1
X$6454 VDD synth_10434 synth_10305 synth_10553 VDD VNB|VSS VNB|VSS
+ sky130_fd_sc_hd__nand2_1
X$6455 VDD synth_922 synth_1031 synth_1004 VDD VNB|VSS VNB|VSS
+ sky130_fd_sc_hd__nand2_1
X$6456 VDD synth_4131 synth_3887 synth_3983 VDD VNB|VSS VNB|VSS
+ sky130_fd_sc_hd__nand2_1
X$6457 VDD synth_3852 synth_3887 synth_3886 VDD VNB|VSS VNB|VSS
+ sky130_fd_sc_hd__nand2_1
X$6458 VDD synth_9762 synth_10632 synth_10431 VDD VNB|VSS VNB|VSS
+ sky130_fd_sc_hd__nand2_1
X$6459 VDD synth_10312 synth_11382 synth_12305 VDD VNB|VSS VNB|VSS
+ sky130_fd_sc_hd__nand2_1
X$6460 VDD synth_2343 synth_1353 synth_2517 VDD VNB|VSS VNB|VSS
+ sky130_fd_sc_hd__nand2_1
X$6461 VDD synth_1588 synth_1294 synth_2213 VDD VNB|VSS VNB|VSS
+ sky130_fd_sc_hd__nand2_1
X$6462 VDD synth_3422 synth_3161 synth_3286 VDD VNB|VSS VNB|VSS
+ sky130_fd_sc_hd__nand2_1
X$6463 VDD synth_3955 synth_4062 synth_4214 VDD VNB|VSS VNB|VSS
+ sky130_fd_sc_hd__nand2_1
X$6464 VDD synth_5026 synth_364 synth_5516 VDD VNB|VSS VNB|VSS
+ sky130_fd_sc_hd__nand2_1
X$6465 VDD synth_3477 synth_3476 synth_3583 VDD VNB|VSS VNB|VSS
+ sky130_fd_sc_hd__nand2_1
X$6466 VDD synth_11017 synth_10441 synth_12279 VDD VNB|VSS VNB|VSS
+ sky130_fd_sc_hd__nand2_1
X$6467 VDD synth_4465 synth_4378 synth_4466 VDD VNB|VSS VNB|VSS
+ sky130_fd_sc_hd__nand2_1
X$6468 VDD synth_4138 synth_3975 synth_3985 VDD VNB|VSS VNB|VSS
+ sky130_fd_sc_hd__nand2_1
X$6469 VDD synth_9232 synth_11090 synth_11137 VDD VNB|VSS VNB|VSS
+ sky130_fd_sc_hd__nand2_1
X$6470 VDD synth_10344 synth_9583 synth_11909 VDD VNB|VSS VNB|VSS
+ sky130_fd_sc_hd__nand2_1
X$6471 VDD synth_5631 synth_5479 synth_5523 VDD VNB|VSS VNB|VSS
+ sky130_fd_sc_hd__nand2_1
X$6472 VDD synth_3616 synth_5576 synth_5395 VDD VNB|VSS VNB|VSS
+ sky130_fd_sc_hd__nand2_1
X$6473 VDD synth_10578 synth_11164 synth_11581 VDD VNB|VSS VNB|VSS
+ sky130_fd_sc_hd__nand2_1
X$6474 VDD synth_3036 synth_3035 synth_3113 VDD VNB|VSS VNB|VSS
+ sky130_fd_sc_hd__nand2_1
X$6475 VDD synth_3616 synth_5240 synth_5029 VDD VNB|VSS VNB|VSS
+ sky130_fd_sc_hd__nand2_1
X$6476 VDD synth_3089 synth_3035 synth_3280 VDD VNB|VSS VNB|VSS
+ sky130_fd_sc_hd__nand2_1
X$6477 VDD synth_10911 synth_10997 synth_10979 VDD VNB|VSS VNB|VSS
+ sky130_fd_sc_hd__nand2_1
X$6478 VDD synth_9427 synth_8870 synth_10728 VDD VNB|VSS VNB|VSS
+ sky130_fd_sc_hd__nand2_1
X$6479 VDD synth_3648 synth_3647 synth_3649 VDD VNB|VSS VNB|VSS
+ sky130_fd_sc_hd__nand2_1
X$6480 VDD synth_10793 synth_10371 synth_12027 VDD VNB|VSS VNB|VSS
+ sky130_fd_sc_hd__nand2_1
X$6481 VDD synth_10150 synth_9998 synth_9920 VDD VNB|VSS VNB|VSS
+ sky130_fd_sc_hd__nand2_1
X$6482 VDD synth_167 synth_3493 synth_3243 VDD VNB|VSS VNB|VSS
+ sky130_fd_sc_hd__nand2_1
X$6483 VDD synth_1547 synth_1454 synth_1548 VDD VNB|VSS VNB|VSS
+ sky130_fd_sc_hd__nand2_1
X$6484 VDD synth_4579 synth_4471 synth_4648 VDD VNB|VSS VNB|VSS
+ sky130_fd_sc_hd__nand2_1
X$6485 VDD synth_3544 synth_4303 synth_4471 VDD VNB|VSS VNB|VSS
+ sky130_fd_sc_hd__nand2_1
X$6486 VDD synth_10981 synth_10999 synth_11001 VDD VNB|VSS VNB|VSS
+ sky130_fd_sc_hd__nand2_1
X$6487 VDD synth_10935 synth_10999 synth_11058 VDD VNB|VSS VNB|VSS
+ sky130_fd_sc_hd__nand2_1
X$6488 VDD synth_5430 synth_5352 synth_5274 VDD VNB|VSS VNB|VSS
+ sky130_fd_sc_hd__nand2_1
X$6489 VDD synth_3315 synth_3243 synth_3330 VDD VNB|VSS VNB|VSS
+ sky130_fd_sc_hd__nand2_1
X$6490 VDD synth_9112 synth_10003 synth_11912 VDD VNB|VSS VNB|VSS
+ sky130_fd_sc_hd__nand2_1
X$6491 VDD synth_9292 synth_12345 synth_12344 VDD VNB|VSS VNB|VSS
+ sky130_fd_sc_hd__nand2_1
X$6492 VDD synth_4428 synth_4471 synth_4548 VDD VNB|VSS VNB|VSS
+ sky130_fd_sc_hd__nand2_1
X$6493 VDD synth_9112 synth_12106 synth_12454 VDD VNB|VSS VNB|VSS
+ sky130_fd_sc_hd__nand2_1
X$6494 VDD synth_4856 synth_4645 synth_4687 VDD VNB|VSS VNB|VSS
+ sky130_fd_sc_hd__nand2_1
X$6495 VDD synth_2567 synth_2568 synth_2672 VDD VNB|VSS VNB|VSS
+ sky130_fd_sc_hd__nand2_1
X$6496 VDD synth_3616 synth_3952 synth_3914 VDD VNB|VSS VNB|VSS
+ sky130_fd_sc_hd__nand2_1
X$6497 VDD synth_9583 synth_10308 synth_11639 VDD VNB|VSS VNB|VSS
+ sky130_fd_sc_hd__nand2_1
X$6498 VDD synth_167 synth_1978 synth_2064 VDD VNB|VSS VNB|VSS
+ sky130_fd_sc_hd__nand2_1
X$6499 VDD synth_1980 synth_2064 synth_2076 VDD VNB|VSS VNB|VSS
+ sky130_fd_sc_hd__nand2_1
X$6500 VDD synth_2229 synth_2261 synth_2374 VDD VNB|VSS VNB|VSS
+ sky130_fd_sc_hd__nand2_1
X$6501 VDD synth_2078 synth_2261 synth_2372 VDD VNB|VSS VNB|VSS
+ sky130_fd_sc_hd__nand2_1
X$6502 VDD synth_11283 synth_10011 synth_11935 VDD VNB|VSS VNB|VSS
+ sky130_fd_sc_hd__nand2_1
X$6503 VDD synth_4613 synth_364 synth_4610 VDD VNB|VSS VNB|VSS
+ sky130_fd_sc_hd__nand2_1
X$6504 VDD synth_8806 synth_10232 synth_9470 VDD VNB|VSS VNB|VSS
+ sky130_fd_sc_hd__nand2_1
X$6505 VDD synth_10170 synth_9322 synth_11933 VDD VNB|VSS VNB|VSS
+ sky130_fd_sc_hd__nand2_1
X$6506 VDD synth_2469 synth_2447 synth_2507 VDD VNB|VSS VNB|VSS
+ sky130_fd_sc_hd__nand2_1
X$6507 VDD synth_3708 synth_3647 synth_3713 VDD VNB|VSS VNB|VSS
+ sky130_fd_sc_hd__nand2_1
X$6508 VDD synth_9062 synth_9042 synth_11815 VDD VNB|VSS VNB|VSS
+ sky130_fd_sc_hd__nand2_1
X$6509 VDD synth_214 synth_2641 synth_2450 VDD VNB|VSS VNB|VSS
+ sky130_fd_sc_hd__nand2_1
X$6510 VDD synth_4468 synth_4378 synth_4546 VDD VNB|VSS VNB|VSS
+ sky130_fd_sc_hd__nand2_1
X$6511 VDD synth_4042 synth_4118 synth_4133 VDD VNB|VSS VNB|VSS
+ sky130_fd_sc_hd__nand2_1
X$6512 VDD synth_927 synth_4129 synth_4378 VDD VNB|VSS VNB|VSS
+ sky130_fd_sc_hd__nand2_1
X$6513 VDD synth_1067 synth_2646 synth_2829 VDD VNB|VSS VNB|VSS
+ sky130_fd_sc_hd__nand2_1
X$6514 VDD synth_1015 synth_2301 synth_2378 VDD VNB|VSS VNB|VSS
+ sky130_fd_sc_hd__nand2_1
X$6515 VDD synth_927 synth_5171 synth_5276 VDD VNB|VSS VNB|VSS
+ sky130_fd_sc_hd__nand2_1
X$6516 VDD synth_10715 synth_10837 synth_10858 VDD VNB|VSS VNB|VSS
+ sky130_fd_sc_hd__nand2_1
X$6517 VDD synth_659 synth_2937 synth_2852 VDD VNB|VSS VNB|VSS
+ sky130_fd_sc_hd__nand2_1
X$6518 VDD synth_10978 synth_10711 synth_10906 VDD VNB|VSS VNB|VSS
+ sky130_fd_sc_hd__nand2_1
X$6519 VDD synth_2936 synth_2852 synth_2898 VDD VNB|VSS VNB|VSS
+ sky130_fd_sc_hd__nand2_1
X$6520 VDD synth_1015 synth_2937 synth_2822 VDD VNB|VSS VNB|VSS
+ sky130_fd_sc_hd__nand2_1
X$6521 VDD synth_9042 synth_12759 synth_12726 VDD VNB|VSS VNB|VSS
+ sky130_fd_sc_hd__nand2_1
X$6522 VDD synth_1338 synth_2301 synth_2261 VDD VNB|VSS VNB|VSS
+ sky130_fd_sc_hd__nand2_1
X$6523 VDD synth_9762 synth_10858 synth_10711 VDD VNB|VSS VNB|VSS
+ sky130_fd_sc_hd__nand2_1
X$6524 VDD synth_3066 synth_2829 synth_3138 VDD VNB|VSS VNB|VSS
+ sky130_fd_sc_hd__nand2_1
X$6525 VDD synth_10652 synth_10007 synth_12142 VDD VNB|VSS VNB|VSS
+ sky130_fd_sc_hd__nand2_1
X$6526 VDD synth_1770 synth_1712 synth_1914 VDD VNB|VSS VNB|VSS
+ sky130_fd_sc_hd__nand2_1
X$6527 VDD synth_1067 synth_1615 synth_1712 VDD VNB|VSS VNB|VSS
+ sky130_fd_sc_hd__nand2_1
X$6528 VDD synth_66 synth_1674 synth_1891 VDD VNB|VSS VNB|VSS
+ sky130_fd_sc_hd__nand2_1
X$6529 VDD synth_1015 synth_4261 synth_4147 VDD VNB|VSS VNB|VSS
+ sky130_fd_sc_hd__nand2_1
X$6530 VDD synth_10312 synth_12169 synth_12110 VDD VNB|VSS VNB|VSS
+ sky130_fd_sc_hd__nand2_1
X$6531 VDD synth_4722 synth_4580 synth_4864 VDD VNB|VSS VNB|VSS
+ sky130_fd_sc_hd__nand2_1
X$6532 VDD synth_9292 synth_9232 synth_11538 VDD VNB|VSS VNB|VSS
+ sky130_fd_sc_hd__nand2_1
X$6533 VDD synth_4400 synth_4580 synth_4693 VDD VNB|VSS VNB|VSS
+ sky130_fd_sc_hd__nand2_1
X$6534 VDD synth_3544 synth_4581 synth_4580 VDD VNB|VSS VNB|VSS
+ sky130_fd_sc_hd__nand2_1
X$6535 VDD synth_3426 synth_3476 synth_3585 VDD VNB|VSS VNB|VSS
+ sky130_fd_sc_hd__nand2_1
X$6536 VDD synth_4082 synth_3858 synth_4342 VDD VNB|VSS VNB|VSS
+ sky130_fd_sc_hd__nand2_1
X$6537 VDD synth_8950 synth_10901 synth_11631 VDD VNB|VSS VNB|VSS
+ sky130_fd_sc_hd__nand2_1
X$6538 VDD synth_5738 synth_9891 synth_10082 VDD VNB|VSS VNB|VSS
+ sky130_fd_sc_hd__nand2_1
X$6539 VDD synth_1895 synth_1828 synth_1910 VDD VNB|VSS VNB|VSS
+ sky130_fd_sc_hd__nand2_1
X$6540 VDD synth_3616 synth_3814 synth_3658 VDD VNB|VSS VNB|VSS
+ sky130_fd_sc_hd__nand2_1
X$6541 VDD synth_10003 synth_9550 synth_11900 VDD VNB|VSS VNB|VSS
+ sky130_fd_sc_hd__nand2_1
X$6542 VDD synth_3689 synth_3544 synth_3856 VDD VNB|VSS VNB|VSS
+ sky130_fd_sc_hd__nand2_1
X$6543 VDD synth_9931 synth_12054 synth_12139 VDD VNB|VSS VNB|VSS
+ sky130_fd_sc_hd__nand2_1
X$6544 VDD synth_2109 synth_2236 synth_2188 VDD VNB|VSS VNB|VSS
+ sky130_fd_sc_hd__nand2_1
X$6545 VDD synth_3367 synth_3291 synth_3290 VDD VNB|VSS VNB|VSS
+ sky130_fd_sc_hd__nand2_1
X$6546 VDD synth_9112 synth_11900 synth_12137 VDD VNB|VSS VNB|VSS
+ sky130_fd_sc_hd__nand2_1
X$6547 VDD synth_4458 synth_4392 synth_4863 VDD VNB|VSS VNB|VSS
+ sky130_fd_sc_hd__nand2_1
X$6548 VDD synth_3294 synth_3332 synth_3293 VDD VNB|VSS VNB|VSS
+ sky130_fd_sc_hd__nand2_1
X$6549 VDD synth_1015 synth_3293 synth_3061 VDD VNB|VSS VNB|VSS
+ sky130_fd_sc_hd__nand2_1
X$6550 VDD synth_3167 synth_1338 synth_3427 VDD VNB|VSS VNB|VSS
+ sky130_fd_sc_hd__nand2_1
X$6551 VDD synth_1704 synth_1630 synth_1629 VDD VNB|VSS VNB|VSS
+ sky130_fd_sc_hd__nand2_1
X$6552 VDD synth_3550 synth_3552 synth_3620 VDD VNB|VSS VNB|VSS
+ sky130_fd_sc_hd__nand2_1
X$6553 VDD synth_5947 synth_3468 synth_6114 VDD VNB|VSS VNB|VSS
+ sky130_fd_sc_hd__nand2_1
X$6554 VDD synth_66 synth_1817 synth_1738 VDD VNB|VSS VNB|VSS
+ sky130_fd_sc_hd__nand2_1
X$6555 VDD synth_3698 synth_3632 synth_3743 VDD VNB|VSS VNB|VSS
+ sky130_fd_sc_hd__nand2_1
X$6556 VDD synth_659 synth_1207 synth_1092 VDD VNB|VSS VNB|VSS
+ sky130_fd_sc_hd__nand2_1
X$6557 VDD synth_10171 synth_10011 synth_10772 VDD VNB|VSS VNB|VSS
+ sky130_fd_sc_hd__nand2_1
X$6558 VDD synth_11006 synth_9423 synth_11062 VDD VNB|VSS VNB|VSS
+ sky130_fd_sc_hd__nand2_1
X$6559 VDD synth_3277 synth_3461 synth_3612 VDD VNB|VSS VNB|VSS
+ sky130_fd_sc_hd__nand2_1
X$6560 VDD synth_3522 synth_3461 synth_3613 VDD VNB|VSS VNB|VSS
+ sky130_fd_sc_hd__nand2_1
X$6561 VDD synth_9629 synth_9850 synth_11322 VDD VNB|VSS VNB|VSS
+ sky130_fd_sc_hd__nand2_1
X$6562 VDD synth_9983 synth_10170 synth_9743 VDD VNB|VSS VNB|VSS
+ sky130_fd_sc_hd__nand2_1
X$6563 VDD synth_3468 synth_5856 synth_6379 VDD VNB|VSS VNB|VSS
+ sky130_fd_sc_hd__nand2_1
X$6564 VDD synth_3220 synth_3379 synth_3378 VDD VNB|VSS VNB|VSS
+ sky130_fd_sc_hd__nand2_1
X$6565 VDD synth_3610 synth_3381 synth_3560 VDD VNB|VSS VNB|VSS
+ sky130_fd_sc_hd__nand2_1
X$6566 VDD synth_1015 synth_3018 synth_2894 VDD VNB|VSS VNB|VSS
+ sky130_fd_sc_hd__nand2_1
X$6567 VDD synth_6334 synth_6379 synth_6414 VDD VNB|VSS VNB|VSS
+ sky130_fd_sc_hd__nand2_1
X$6568 VDD synth_5094 synth_4823 synth_5003 VDD VNB|VSS VNB|VSS
+ sky130_fd_sc_hd__nand2_1
X$6569 VDD synth_10022 synth_10023 synth_10392 VDD VNB|VSS VNB|VSS
+ sky130_fd_sc_hd__nand2_1
X$6570 VDD synth_4903 synth_5050 synth_5090 VDD VNB|VSS VNB|VSS
+ sky130_fd_sc_hd__nand2_1
X$6571 VDD synth_659 synth_1501 synth_1421 VDD VNB|VSS VNB|VSS
+ sky130_fd_sc_hd__nand2_1
X$6572 VDD synth_10712 synth_10711 synth_10757 VDD VNB|VSS VNB|VSS
+ sky130_fd_sc_hd__nand2_1
X$6573 VDD synth_5856 synth_1015 synth_5909 VDD VNB|VSS VNB|VSS
+ sky130_fd_sc_hd__nand2_1
X$6574 VDD synth_10860 synth_11059 synth_11086 VDD VNB|VSS VNB|VSS
+ sky130_fd_sc_hd__nand2_1
X$6575 VDD synth_1015 synth_1170 synth_635 VDD VNB|VSS VNB|VSS
+ sky130_fd_sc_hd__nand2_1
X$6576 VDD synth_8764 synth_9434 synth_10006 VDD VNB|VSS VNB|VSS
+ sky130_fd_sc_hd__nand2_1
X$6577 VDD synth_9036 synth_10007 synth_10172 VDD VNB|VSS VNB|VSS
+ sky130_fd_sc_hd__nand2_1
X$6578 VDD synth_5570 synth_364 synth_6090 VDD VNB|VSS VNB|VSS
+ sky130_fd_sc_hd__nand2_1
X$6579 VDD synth_1608 synth_1738 synth_1784 VDD VNB|VSS VNB|VSS
+ sky130_fd_sc_hd__nand2_1
X$6580 VDD synth_10022 synth_10028 synth_10024 VDD VNB|VSS VNB|VSS
+ sky130_fd_sc_hd__nand2_1
X$6581 VDD synth_10171 synth_11093 synth_11283 VDD VNB|VSS VNB|VSS
+ sky130_fd_sc_hd__nand2_1
X$6582 VDD synth_3627 synth_3604 synth_3727 VDD VNB|VSS VNB|VSS
+ sky130_fd_sc_hd__nand2_1
X$6583 VDD synth_3731 synth_3793 synth_3819 VDD VNB|VSS VNB|VSS
+ sky130_fd_sc_hd__nand2_1
X$6584 VDD synth_1067 synth_2625 synth_3604 VDD VNB|VSS VNB|VSS
+ sky130_fd_sc_hd__nand2_1
X$6585 VDD synth_10652 synth_10849 synth_11219 VDD VNB|VSS VNB|VSS
+ sky130_fd_sc_hd__nand2_1
X$6586 VDD synth_10171 synth_9559 synth_11096 VDD VNB|VSS VNB|VSS
+ sky130_fd_sc_hd__nand2_1
X$6587 VDD synth_659 synth_603 synth_495 VDD VNB|VSS VNB|VSS
+ sky130_fd_sc_hd__nand2_1
X$6588 VDD synth_3441 synth_3228 synth_3356 VDD VNB|VSS VNB|VSS
+ sky130_fd_sc_hd__nand2_1
X$6589 VDD synth_4022 synth_3822 synth_4189 VDD VNB|VSS VNB|VSS
+ sky130_fd_sc_hd__nand2_1
X$6590 VDD synth_9112 synth_10489 synth_10142 VDD VNB|VSS VNB|VSS
+ sky130_fd_sc_hd__nand2_1
X$6591 VDD synth_4190 synth_4093 synth_3945 VDD VNB|VSS VNB|VSS
+ sky130_fd_sc_hd__nand2_1
X$6592 VDD synth_4357 synth_3946 synth_4522 VDD VNB|VSS VNB|VSS
+ sky130_fd_sc_hd__nand2_1
X$6593 VDD synth_9233 synth_11322 synth_11510 VDD VNB|VSS VNB|VSS
+ sky130_fd_sc_hd__nand2_1
X$6594 VDD synth_1817 synth_364 synth_1681 VDD VNB|VSS VNB|VSS
+ sky130_fd_sc_hd__nand2_1
X$6595 VDD synth_4658 synth_4524 synth_4644 VDD VNB|VSS VNB|VSS
+ sky130_fd_sc_hd__nand2_1
X$6596 VDD synth_4593 synth_4524 synth_4573 VDD VNB|VSS VNB|VSS
+ sky130_fd_sc_hd__nand2_1
X$6597 VDD synth_1027 synth_1086 synth_1143 VDD VNB|VSS VNB|VSS
+ sky130_fd_sc_hd__nand2_1
X$6598 VDD synth_11664 synth_11667 synth_12025 VDD VNB|VSS VNB|VSS
+ sky130_fd_sc_hd__nand2_1
X$6599 VDD synth_5343 synth_5342 synth_5529 VDD VNB|VSS VNB|VSS
+ sky130_fd_sc_hd__nand2_1
X$6600 VDD synth_1015 synth_603 synth_386 VDD VNB|VSS VNB|VSS
+ sky130_fd_sc_hd__nand2_1
X$6601 VDD synth_10652 synth_9483 synth_10486 VDD VNB|VSS VNB|VSS
+ sky130_fd_sc_hd__nand2_1
X$6602 VDD synth_1057 synth_1092 synth_1146 VDD VNB|VSS VNB|VSS
+ sky130_fd_sc_hd__nand2_1
X$6603 VDD synth_4190 synth_3946 synth_4656 VDD VNB|VSS VNB|VSS
+ sky130_fd_sc_hd__nand2_1
X$6604 VDD synth_9899 synth_9921 synth_9976 VDD VNB|VSS VNB|VSS
+ sky130_fd_sc_hd__nand2_1
X$6605 VDD synth_4353 synth_4414 synth_4091 VDD VNB|VSS VNB|VSS
+ sky130_fd_sc_hd__nand2_1
X$6606 VDD synth_11377 synth_11668 synth_11667 VDD VNB|VSS VNB|VSS
+ sky130_fd_sc_hd__nand2_1
X$6607 VDD synth_1497 synth_1496 synth_1498 VDD VNB|VSS VNB|VSS
+ sky130_fd_sc_hd__nand2_1
X$6608 VDD synth_4276 synth_4522 synth_4804 VDD VNB|VSS VNB|VSS
+ sky130_fd_sc_hd__nand2_1
X$6609 VDD synth_9387 synth_10863 synth_11287 VDD VNB|VSS VNB|VSS
+ sky130_fd_sc_hd__nand2_1
X$6610 VDD synth_659 synth_2029 synth_1902 VDD VNB|VSS VNB|VSS
+ sky130_fd_sc_hd__nand2_1
X$6611 VDD synth_4929 synth_4735 synth_4901 VDD VNB|VSS VNB|VSS
+ sky130_fd_sc_hd__nand2_1
X$6612 VDD synth_2116 synth_4931 synth_4735 VDD VNB|VSS VNB|VSS
+ sky130_fd_sc_hd__nand2_1
X$6613 VDD synth_6017 synth_6217 synth_6257 VDD VNB|VSS VNB|VSS
+ sky130_fd_sc_hd__nand2_1
X$6614 VDD synth_6131 synth_6217 synth_6219 VDD VNB|VSS VNB|VSS
+ sky130_fd_sc_hd__nand2_1
X$6615 VDD synth_11158 synth_11242 synth_11356 VDD VNB|VSS VNB|VSS
+ sky130_fd_sc_hd__nand2_1
X$6616 VDD synth_3541 synth_6317 synth_6217 VDD VNB|VSS VNB|VSS
+ sky130_fd_sc_hd__nand2_1
X$6617 VDD synth_3616 synth_6317 synth_6174 VDD VNB|VSS VNB|VSS
+ sky130_fd_sc_hd__nand2_1
X$6618 VDD synth_11244 synth_11243 synth_11286 VDD VNB|VSS VNB|VSS
+ sky130_fd_sc_hd__nand2_1
X$6619 VDD synth_2177 synth_1902 synth_2178 VDD VNB|VSS VNB|VSS
+ sky130_fd_sc_hd__nand2_1
X$6620 VDD synth_5791 synth_5928 synth_5879 VDD VNB|VSS VNB|VSS
+ sky130_fd_sc_hd__nand2_1
X$6621 VDD synth_6389 synth_6214 synth_6351 VDD VNB|VSS VNB|VSS
+ sky130_fd_sc_hd__nand2_1
X$6622 VDD synth_11215 synth_5738 synth_10937 VDD VNB|VSS VNB|VSS
+ sky130_fd_sc_hd__nand2_1
X$6623 VDD synth_10578 synth_10344 synth_11676 VDD VNB|VSS VNB|VSS
+ sky130_fd_sc_hd__nand2_1
X$6624 VDD synth_3541 synth_6130 synth_6214 VDD VNB|VSS VNB|VSS
+ sky130_fd_sc_hd__nand2_1
X$6625 VDD synth_3073 synth_2876 synth_2964 VDD VNB|VSS VNB|VSS
+ sky130_fd_sc_hd__nand2_1
X$6626 VDD synth_3541 synth_5879 synth_5691 VDD VNB|VSS VNB|VSS
+ sky130_fd_sc_hd__nand2_1
X$6627 VDD synth_2966 synth_2876 synth_2997 VDD VNB|VSS VNB|VSS
+ sky130_fd_sc_hd__nand2_1
X$6628 VDD synth_5692 synth_5691 synth_5919 VDD VNB|VSS VNB|VSS
+ sky130_fd_sc_hd__nand2_1
X$6629 VDD synth_10793 synth_11164 synth_11220 VDD VNB|VSS VNB|VSS
+ sky130_fd_sc_hd__nand2_1
X$6630 VDD synth_66 synth_2545 synth_2352 VDD VNB|VSS VNB|VSS
+ sky130_fd_sc_hd__nand2_1
X$6631 VDD synth_3616 synth_5879 synth_5833 VDD VNB|VSS VNB|VSS
+ sky130_fd_sc_hd__nand2_1
X$6632 VDD synth_659 synth_2669 synth_2437 VDD VNB|VSS VNB|VSS
+ sky130_fd_sc_hd__nand2_1
X$6633 VDD synth_5657 synth_5691 synth_5693 VDD VNB|VSS VNB|VSS
+ sky130_fd_sc_hd__nand2_1
X$6634 VDD synth_3918 synth_364 synth_3650 VDD VNB|VSS VNB|VSS
+ sky130_fd_sc_hd__nand2_1
X$6635 VDD synth_9042 synth_11863 synth_11814 VDD VNB|VSS VNB|VSS
+ sky130_fd_sc_hd__nand2_1
X$6636 VDD synth_3616 synth_6130 synth_6254 VDD VNB|VSS VNB|VSS
+ sky130_fd_sc_hd__nand2_1
X$6637 VDD synth_4961 synth_5026 synth_5760 VDD VNB|VSS VNB|VSS
+ sky130_fd_sc_hd__nand2_1
X$6638 VDD synth_10576 synth_8918 synth_9553 VDD VNB|VSS VNB|VSS
+ sky130_fd_sc_hd__nand2_1
X$6639 VDD synth_6437 synth_6435 synth_6438 VDD VNB|VSS VNB|VSS
+ sky130_fd_sc_hd__nand2_1
X$6640 VDD synth_6542 synth_6435 synth_6359 VDD VNB|VSS VNB|VSS
+ sky130_fd_sc_hd__nand2_1
X$6641 VDD synth_5585 synth_1015 synth_5990 VDD VNB|VSS VNB|VSS
+ sky130_fd_sc_hd__nand2_1
X$6642 VDD synth_9615 synth_10095 synth_10777 VDD VNB|VSS VNB|VSS
+ sky130_fd_sc_hd__nand2_1
X$6643 VDD synth_3544 synth_5737 synth_5606 VDD VNB|VSS VNB|VSS
+ sky130_fd_sc_hd__nand2_1
X$6644 VDD synth_3063 synth_2752 synth_2881 VDD VNB|VSS VNB|VSS
+ sky130_fd_sc_hd__nand2_1
X$6645 VDD synth_3468 synth_5585 synth_6108 VDD VNB|VSS VNB|VSS
+ sky130_fd_sc_hd__nand2_1
X$6646 VDD synth_10840 synth_10939 synth_11070 VDD VNB|VSS VNB|VSS
+ sky130_fd_sc_hd__nand2_1
X$6647 VDD synth_5402 synth_5243 synth_5323 VDD VNB|VSS VNB|VSS
+ sky130_fd_sc_hd__nand2_1
X$6648 VDD synth_1761 synth_1794 synth_1867 VDD VNB|VSS VNB|VSS
+ sky130_fd_sc_hd__nand2_1
X$6649 VDD synth_9434 synth_11248 synth_11293 VDD VNB|VSS VNB|VSS
+ sky130_fd_sc_hd__nand2_1
X$6650 VDD synth_5202 synth_5060 synth_5038 VDD VNB|VSS VNB|VSS
+ sky130_fd_sc_hd__nand2_1
X$6651 VDD synth_3616 synth_5485 synth_5245 VDD VNB|VSS VNB|VSS
+ sky130_fd_sc_hd__nand2_1
X$6652 VDD synth_2828 synth_2679 synth_2754 VDD VNB|VSS VNB|VSS
+ sky130_fd_sc_hd__nand2_1
X$6653 VDD synth_5006 synth_3541 synth_5191 VDD VNB|VSS VNB|VSS
+ sky130_fd_sc_hd__nand2_1
X$6654 VDD synth_9423 synth_11086 synth_10999 VDD VNB|VSS VNB|VSS
+ sky130_fd_sc_hd__nand2_1
X$6655 VDD synth_9983 synth_9927 synth_11066 VDD VNB|VSS VNB|VSS
+ sky130_fd_sc_hd__nand2_1
X$6656 VDD synth_5859 synth_5606 synth_5662 VDD VNB|VSS VNB|VSS
+ sky130_fd_sc_hd__nand2_1
X$6657 VDD synth_11083 synth_11082 synth_11080 VDD VNB|VSS VNB|VSS
+ sky130_fd_sc_hd__nand2_1
X$6658 VDD synth_11310 synth_11430 synth_11378 VDD VNB|VSS VNB|VSS
+ sky130_fd_sc_hd__nand2_1
X$6659 VDD synth_66 synth_2280 synth_2209 VDD VNB|VSS VNB|VSS
+ sky130_fd_sc_hd__nand2_1
X$6660 VDD synth_1374 synth_1375 synth_1376 VDD VNB|VSS VNB|VSS
+ sky130_fd_sc_hd__nand2_1
X$6661 VDD synth_2912 synth_2878 synth_2962 VDD VNB|VSS VNB|VSS
+ sky130_fd_sc_hd__nand2_1
X$6662 VDD synth_5199 synth_5132 synth_5197 VDD VNB|VSS VNB|VSS
+ sky130_fd_sc_hd__nand2_1
X$6663 VDD synth_10578 synth_9927 synth_11093 VDD VNB|VSS VNB|VSS
+ sky130_fd_sc_hd__nand2_1
X$6664 VDD synth_9042 synth_11386 synth_11516 VDD VNB|VSS VNB|VSS
+ sky130_fd_sc_hd__nand2_1
X$6665 VDD synth_5551 synth_5371 synth_5605 VDD VNB|VSS VNB|VSS
+ sky130_fd_sc_hd__nand2_1
X$6666 VDD synth_9762 synth_11567 synth_11707 VDD VNB|VSS VNB|VSS
+ sky130_fd_sc_hd__nand2_1
X$6667 VDD synth_6983 synth_6920 synth_7043 VDD VNB|VSS VNB|VSS
+ sky130_fd_sc_hd__nand2_1
X$6668 VDD synth_2943 synth_2793 synth_2794 VDD VNB|VSS VNB|VSS
+ sky130_fd_sc_hd__nand2_1
X$6669 VDD synth_8110 synth_7949 synth_8063 VDD VNB|VSS VNB|VSS
+ sky130_fd_sc_hd__nand2_1
X$6670 VDD synth_8448 synth_8385 synth_8551 VDD VNB|VSS VNB|VSS
+ sky130_fd_sc_hd__nand2_1
X$6671 VDD synth_10164 synth_11829 synth_12456 VDD VNB|VSS VNB|VSS
+ sky130_fd_sc_hd__nand2_1
X$6672 VDD synth_7743 synth_8481 synth_8496 VDD VNB|VSS VNB|VSS
+ sky130_fd_sc_hd__nand2_1
X$6673 VDD synth_3616 synth_7981 synth_7769 VDD VNB|VSS VNB|VSS
+ sky130_fd_sc_hd__nand2_1
X$6674 VDD synth_11726 synth_9423 synth_11674 VDD VNB|VSS VNB|VSS
+ sky130_fd_sc_hd__nand2_1
X$6675 VDD synth_812 synth_666 synth_872 VDD VNB|VSS VNB|VSS
+ sky130_fd_sc_hd__nand2_1
X$6676 VDD synth_214 synth_1951 synth_1685 VDD VNB|VSS VNB|VSS
+ sky130_fd_sc_hd__nand2_1
X$6677 VDD synth_7520 synth_7251 synth_7477 VDD VNB|VSS VNB|VSS
+ sky130_fd_sc_hd__nand2_1
X$6678 VDD synth_2700 synth_2632 synth_2576 VDD VNB|VSS VNB|VSS
+ sky130_fd_sc_hd__nand2_1
X$6679 VDD synth_3468 synth_3469 synth_3035 VDD VNB|VSS VNB|VSS
+ sky130_fd_sc_hd__nand2_1
X$6680 VDD synth_483 synth_351 synth_412 VDD VNB|VSS VNB|VSS
+ sky130_fd_sc_hd__nand2_1
X$6681 VDD synth_3469 synth_657 synth_3091 VDD VNB|VSS VNB|VSS
+ sky130_fd_sc_hd__nand2_1
X$6682 VDD synth_1067 synth_1951 synth_1633 VDD VNB|VSS VNB|VSS
+ sky130_fd_sc_hd__nand2_1
X$6683 VDD synth_12275 synth_12403 synth_12499 VDD VNB|VSS VNB|VSS
+ sky130_fd_sc_hd__nand2_1
X$6684 VDD synth_864 synth_682 synth_704 VDD VNB|VSS VNB|VSS
+ sky130_fd_sc_hd__nand2_1
X$6685 VDD synth_865 synth_682 synth_783 VDD VNB|VSS VNB|VSS
+ sky130_fd_sc_hd__nand2_1
X$6686 VDD synth_7598 synth_7436 synth_7431 VDD VNB|VSS VNB|VSS
+ sky130_fd_sc_hd__nand2_1
X$6687 VDD synth_7671 synth_7472 synth_7638 VDD VNB|VSS VNB|VSS
+ sky130_fd_sc_hd__nand2_1
X$6688 VDD synth_7743 synth_10888 synth_12310 VDD VNB|VSS VNB|VSS
+ sky130_fd_sc_hd__nand2_1
X$6689 VDD synth_2695 synth_214 synth_2769 VDD VNB|VSS VNB|VSS
+ sky130_fd_sc_hd__nand2_1
X$6690 VDD synth_12413 synth_12362 synth_12600 VDD VNB|VSS VNB|VSS
+ sky130_fd_sc_hd__nand2_1
X$6691 VDD synth_12048 synth_11973 synth_12146 VDD VNB|VSS VNB|VSS
+ sky130_fd_sc_hd__nand2_1
X$6692 VDD synth_242 synth_29 synth_168 VDD VNB|VSS VNB|VSS
+ sky130_fd_sc_hd__nand2_1
X$6693 VDD synth_6695 synth_6694 synth_6705 VDD VNB|VSS VNB|VSS
+ sky130_fd_sc_hd__nand2_1
X$6694 VDD synth_11574 synth_5738 synth_11927 VDD VNB|VSS VNB|VSS
+ sky130_fd_sc_hd__nand2_1
X$6695 VDD synth_12030 synth_11973 synth_12032 VDD VNB|VSS VNB|VSS
+ sky130_fd_sc_hd__nand2_1
X$6696 VDD synth_8011 synth_8176 synth_8135 VDD VNB|VSS VNB|VSS
+ sky130_fd_sc_hd__nand2_1
X$6697 VDD synth_3616 synth_8859 synth_8999 VDD VNB|VSS VNB|VSS
+ sky130_fd_sc_hd__nand2_1
X$6698 VDD synth_6487 synth_6539 synth_6658 VDD VNB|VSS VNB|VSS
+ sky130_fd_sc_hd__nand2_1
X$6699 VDD synth_4512 synth_4359 synth_4529 VDD VNB|VSS VNB|VSS
+ sky130_fd_sc_hd__nand2_1
X$6700 VDD synth_4961 synth_5093 synth_5621 VDD VNB|VSS VNB|VSS
+ sky130_fd_sc_hd__nand2_1
X$6701 VDD synth_12476 synth_12456 synth_12608 VDD VNB|VSS VNB|VSS
+ sky130_fd_sc_hd__nand2_1
X$6702 VDD synth_3463 synth_214 synth_3351 VDD VNB|VSS VNB|VSS
+ sky130_fd_sc_hd__nand2_1
X$6703 VDD synth_8192 synth_7949 synth_7948 VDD VNB|VSS VNB|VSS
+ sky130_fd_sc_hd__nand2_1
X$6704 VDD synth_414 synth_149 synth_325 VDD VNB|VSS VNB|VSS
+ sky130_fd_sc_hd__nand2_1
X$6705 VDD synth_6663 synth_6631 synth_7070 VDD VNB|VSS VNB|VSS
+ sky130_fd_sc_hd__nand2_1
X$6706 VDD synth_219 synth_149 synth_150 VDD VNB|VSS VNB|VSS
+ sky130_fd_sc_hd__nand2_1
X$6707 VDD synth_8314 synth_8311 synth_8795 VDD VNB|VSS VNB|VSS
+ sky130_fd_sc_hd__nand2_1
X$6708 VDD synth_7759 synth_7196 synth_7963 VDD VNB|VSS VNB|VSS
+ sky130_fd_sc_hd__nand2_1
X$6709 VDD synth_7111 synth_7759 synth_8176 VDD VNB|VSS VNB|VSS
+ sky130_fd_sc_hd__nand2_1
X$6710 VDD synth_8381 synth_8466 synth_8608 VDD VNB|VSS VNB|VSS
+ sky130_fd_sc_hd__nand2_1
X$6711 VDD synth_8361 synth_8440 synth_8316 VDD VNB|VSS VNB|VSS
+ sky130_fd_sc_hd__nand2_1
X$6712 VDD synth_8247 synth_8176 synth_8283 VDD VNB|VSS VNB|VSS
+ sky130_fd_sc_hd__nand2_1
X$6713 VDD synth_1353 synth_2276 synth_2273 VDD VNB|VSS VNB|VSS
+ sky130_fd_sc_hd__nand2_1
X$6714 VDD synth_12533 synth_12417 synth_12767 VDD VNB|VSS VNB|VSS
+ sky130_fd_sc_hd__nand2_1
X$6715 VDD synth_4005 synth_3899 synth_4026 VDD VNB|VSS VNB|VSS
+ sky130_fd_sc_hd__nand2_1
X$6716 VDD synth_6597 synth_6860 synth_6435 VDD VNB|VSS VNB|VSS
+ sky130_fd_sc_hd__nand2_1
X$6717 VDD synth_8000 synth_9572 synth_9421 VDD VNB|VSS VNB|VSS
+ sky130_fd_sc_hd__nand2_1
X$6718 VDD synth_7087 synth_7009 synth_7129 VDD VNB|VSS VNB|VSS
+ sky130_fd_sc_hd__nand2_1
X$6719 VDD synth_11567 synth_5738 synth_11662 VDD VNB|VSS VNB|VSS
+ sky130_fd_sc_hd__nand2_1
X$6720 VDD synth_2514 synth_2803 synth_2764 VDD VNB|VSS VNB|VSS
+ sky130_fd_sc_hd__nand2_1
X$6721 VDD synth_11988 synth_11891 synth_11965 VDD VNB|VSS VNB|VSS
+ sky130_fd_sc_hd__nand2_1
X$6722 VDD synth_8548 synth_8468 synth_8526 VDD VNB|VSS VNB|VSS
+ sky130_fd_sc_hd__nand2_1
X$6723 VDD synth_9422 synth_9421 synth_9562 VDD VNB|VSS VNB|VSS
+ sky130_fd_sc_hd__nand2_1
X$6724 VDD synth_9213 synth_9421 synth_9560 VDD VNB|VSS VNB|VSS
+ sky130_fd_sc_hd__nand2_1
X$6725 VDD synth_11350 synth_11529 synth_11660 VDD VNB|VSS VNB|VSS
+ sky130_fd_sc_hd__nand2_1
X$6726 VDD synth_9423 synth_8939 synth_9228 VDD VNB|VSS VNB|VSS
+ sky130_fd_sc_hd__nand2_1
X$6727 VDD synth_8939 synth_5738 synth_9478 VDD VNB|VSS VNB|VSS
+ sky130_fd_sc_hd__nand2_1
X$6728 VDD synth_6972 synth_4740 synth_7114 VDD VNB|VSS VNB|VSS
+ sky130_fd_sc_hd__nand2_1
X$6729 VDD synth_2723 synth_214 synth_2839 VDD VNB|VSS VNB|VSS
+ sky130_fd_sc_hd__nand2_1
X$6730 VDD synth_1520 synth_1519 synth_1603 VDD VNB|VSS VNB|VSS
+ sky130_fd_sc_hd__nand2_1
X$6731 VDD synth_11237 synth_8237 synth_11564 VDD VNB|VSS VNB|VSS
+ sky130_fd_sc_hd__nand2_1
X$6732 VDD synth_1564 synth_1519 synth_1604 VDD VNB|VSS VNB|VSS
+ sky130_fd_sc_hd__nand2_1
X$6733 VDD synth_7414 synth_7196 synth_7413 VDD VNB|VSS VNB|VSS
+ sky130_fd_sc_hd__nand2_1
X$6734 VDD synth_6695 synth_6700 synth_6701 VDD VNB|VSS VNB|VSS
+ sky130_fd_sc_hd__nand2_1
X$6735 VDD synth_7362 synth_7491 synth_7411 VDD VNB|VSS VNB|VSS
+ sky130_fd_sc_hd__nand2_1
X$6736 VDD synth_194 synth_712 synth_745 VDD VNB|VSS VNB|VSS
+ sky130_fd_sc_hd__nand2_1
X$6737 VDD synth_7080 synth_7163 synth_7244 VDD VNB|VSS VNB|VSS
+ sky130_fd_sc_hd__nand2_1
X$6738 VDD synth_3116 synth_1353 synth_3140 VDD VNB|VSS VNB|VSS
+ sky130_fd_sc_hd__nand2_1
X$6739 VDD synth_878 synth_745 synth_818 VDD VNB|VSS VNB|VSS
+ sky130_fd_sc_hd__nand2_1
X$6740 VDD synth_4615 synth_364 synth_4942 VDD VNB|VSS VNB|VSS
+ sky130_fd_sc_hd__nand2_1
X$6741 VDD synth_11955 synth_9762 synth_12134 VDD VNB|VSS VNB|VSS
+ sky130_fd_sc_hd__nand2_1
X$6742 VDD synth_9319 synth_9228 synth_9229 VDD VNB|VSS VNB|VSS
+ sky130_fd_sc_hd__nand2_1
X$6743 VDD synth_3616 synth_7250 synth_7139 VDD VNB|VSS VNB|VSS
+ sky130_fd_sc_hd__nand2_1
X$6744 VDD synth_12392 synth_12403 synth_12500 VDD VNB|VSS VNB|VSS
+ sky130_fd_sc_hd__nand2_1
X$6745 VDD synth_4194 synth_214 synth_4166 VDD VNB|VSS VNB|VSS
+ sky130_fd_sc_hd__nand2_1
X$6746 VDD synth_7743 synth_10949 synth_12314 VDD VNB|VSS VNB|VSS
+ sky130_fd_sc_hd__nand2_1
X$6747 VDD synth_8867 synth_8709 synth_8782 VDD VNB|VSS VNB|VSS
+ sky130_fd_sc_hd__nand2_1
X$6748 VDD synth_2940 synth_2938 synth_2909 VDD VNB|VSS VNB|VSS
+ sky130_fd_sc_hd__nand2_1
X$6749 VDD synth_3042 synth_3115 synth_3041 VDD VNB|VSS VNB|VSS
+ sky130_fd_sc_hd__nand2_1
X$6750 VDD synth_8800 synth_8709 synth_8840 VDD VNB|VSS VNB|VSS
+ sky130_fd_sc_hd__nand2_1
X$6751 VDD synth_7876 synth_7436 synth_7475 VDD VNB|VSS VNB|VSS
+ sky130_fd_sc_hd__nand2_1
X$6752 VDD synth_1445 synth_364 synth_1491 VDD VNB|VSS VNB|VSS
+ sky130_fd_sc_hd__nand2_1
X$6753 VDD synth_9232 synth_9904 synth_9849 VDD VNB|VSS VNB|VSS
+ sky130_fd_sc_hd__nand2_1
X$6754 VDD synth_2116 synth_4194 synth_4100 VDD VNB|VSS VNB|VSS
+ sky130_fd_sc_hd__nand2_1
X$6755 VDD synth_1067 synth_2695 synth_2994 VDD VNB|VSS VNB|VSS
+ sky130_fd_sc_hd__nand2_1
X$6756 VDD synth_7010 synth_7009 synth_7050 VDD VNB|VSS VNB|VSS
+ sky130_fd_sc_hd__nand2_1
X$6757 VDD synth_7111 synth_6998 synth_7035 VDD VNB|VSS VNB|VSS
+ sky130_fd_sc_hd__nand2_1
X$6758 VDD synth_7234 synth_7035 synth_7154 VDD VNB|VSS VNB|VSS
+ sky130_fd_sc_hd__nand2_1
X$6759 VDD synth_9474 synth_10104 synth_11812 VDD VNB|VSS VNB|VSS
+ sky130_fd_sc_hd__nand2_1
X$6760 VDD synth_1214 synth_1519 synth_1602 VDD VNB|VSS VNB|VSS
+ sky130_fd_sc_hd__nand2_1
X$6761 VDD synth_1067 synth_2723 synth_2793 VDD VNB|VSS VNB|VSS
+ sky130_fd_sc_hd__nand2_1
X$6762 VDD synth_1353 synth_3041 synth_2803 VDD VNB|VSS VNB|VSS
+ sky130_fd_sc_hd__nand2_1
X$6763 VDD synth_9434 synth_11811 synth_11906 VDD VNB|VSS VNB|VSS
+ sky130_fd_sc_hd__nand2_1
X$6764 VDD synth_7089 synth_7317 synth_7472 VDD VNB|VSS VNB|VSS
+ sky130_fd_sc_hd__nand2_1
X$6765 VDD synth_9483 synth_9234 synth_11907 VDD VNB|VSS VNB|VSS
+ sky130_fd_sc_hd__nand2_1
X$6766 VDD synth_2116 synth_3386 synth_3175 VDD VNB|VSS VNB|VSS
+ sky130_fd_sc_hd__nand2_1
X$6767 VDD synth_5738 synth_9572 synth_9573 VDD VNB|VSS VNB|VSS
+ sky130_fd_sc_hd__nand2_1
X$6768 VDD synth_7157 synth_7035 synth_7077 VDD VNB|VSS VNB|VSS
+ sky130_fd_sc_hd__nand2_1
X$6769 VDD synth_1622 synth_1718 synth_1686 VDD VNB|VSS VNB|VSS
+ sky130_fd_sc_hd__nand2_1
X$6770 VDD synth_3873 synth_3824 synth_3872 VDD VNB|VSS VNB|VSS
+ sky130_fd_sc_hd__nand2_1
X$6771 VDD synth_7089 synth_8156 synth_7956 VDD VNB|VSS VNB|VSS
+ sky130_fd_sc_hd__nand2_1
X$6772 VDD synth_7245 synth_6901 synth_7028 VDD VNB|VSS VNB|VSS
+ sky130_fd_sc_hd__nand2_1
X$6773 VDD synth_5165 synth_5085 synth_5018 VDD VNB|VSS VNB|VSS
+ sky130_fd_sc_hd__nand2_1
X$6774 VDD synth_1925 synth_2040 synth_1955 VDD VNB|VSS VNB|VSS
+ sky130_fd_sc_hd__nand2_1
X$6775 VDD synth_7252 synth_7251 synth_7351 VDD VNB|VSS VNB|VSS
+ sky130_fd_sc_hd__nand2_1
X$6776 VDD synth_8068 synth_7956 synth_7911 VDD VNB|VSS VNB|VSS
+ sky130_fd_sc_hd__nand2_1
X$6777 VDD synth_3616 synth_7094 synth_7253 VDD VNB|VSS VNB|VSS
+ sky130_fd_sc_hd__nand2_1
X$6778 VDD synth_5738 synth_9500 synth_9225 VDD VNB|VSS VNB|VSS
+ sky130_fd_sc_hd__nand2_1
X$6779 VDD synth_9866 synth_9721 synth_9958 VDD VNB|VSS VNB|VSS
+ sky130_fd_sc_hd__nand2_1
X$6780 VDD synth_9423 synth_11807 synth_11740 VDD VNB|VSS VNB|VSS
+ sky130_fd_sc_hd__nand2_1
X$6781 VDD synth_2163 synth_2332 synth_2471 VDD VNB|VSS VNB|VSS
+ sky130_fd_sc_hd__nand2_1
X$6782 VDD synth_7563 synth_6597 synth_7683 VDD VNB|VSS VNB|VSS
+ sky130_fd_sc_hd__nand2_1
X$6783 VDD synth_12274 synth_5738 synth_12448 VDD VNB|VSS VNB|VSS
+ sky130_fd_sc_hd__nand2_1
X$6784 VDD synth_679 synth_678 synth_600 VDD VNB|VSS VNB|VSS
+ sky130_fd_sc_hd__nand2_1
X$6785 VDD synth_7983 synth_7985 synth_8065 VDD VNB|VSS VNB|VSS
+ sky130_fd_sc_hd__nand2_1
X$6786 VDD synth_2420 synth_214 synth_2473 VDD VNB|VSS VNB|VSS
+ sky130_fd_sc_hd__nand2_1
X$6787 VDD synth_7089 synth_7146 synth_7773 VDD VNB|VSS VNB|VSS
+ sky130_fd_sc_hd__nand2_1
X$6788 VDD synth_5018 synth_657 synth_4970 VDD VNB|VSS VNB|VSS
+ sky130_fd_sc_hd__nand2_1
X$6789 VDD synth_6627 synth_6435 synth_6856 VDD VNB|VSS VNB|VSS
+ sky130_fd_sc_hd__nand2_1
X$6790 VDD synth_12340 synth_12590 synth_12648 VDD VNB|VSS VNB|VSS
+ sky130_fd_sc_hd__nand2_1
X$6791 VDD synth_4234 synth_3704 synth_3798 VDD VNB|VSS VNB|VSS
+ sky130_fd_sc_hd__nand2_1
X$6792 VDD synth_6597 synth_7094 synth_7251 VDD VNB|VSS VNB|VSS
+ sky130_fd_sc_hd__nand2_1
X$6793 VDD synth_12370 synth_12504 synth_12565 VDD VNB|VSS VNB|VSS
+ sky130_fd_sc_hd__nand2_1
X$6794 VDD synth_4985 synth_4678 synth_4706 VDD VNB|VSS VNB|VSS
+ sky130_fd_sc_hd__nand2_1
X$6795 VDD synth_9968 synth_9844 synth_9969 VDD VNB|VSS VNB|VSS
+ sky130_fd_sc_hd__nand2_1
X$6796 VDD synth_8152 synth_8122 synth_8154 VDD VNB|VSS VNB|VSS
+ sky130_fd_sc_hd__nand2_1
X$6797 VDD synth_4747 synth_5018 synth_5083 VDD VNB|VSS VNB|VSS
+ sky130_fd_sc_hd__nand2_1
X$6798 VDD synth_7846 synth_7773 synth_7954 VDD VNB|VSS VNB|VSS
+ sky130_fd_sc_hd__nand2_1
X$6799 VDD synth_7609 synth_7359 synth_7567 VDD VNB|VSS VNB|VSS
+ sky130_fd_sc_hd__nand2_1
X$6800 VDD synth_1353 synth_2951 synth_2590 VDD VNB|VSS VNB|VSS
+ sky130_fd_sc_hd__nand2_1
X$6801 VDD synth_6575 synth_6690 synth_6613 VDD VNB|VSS VNB|VSS
+ sky130_fd_sc_hd__nand2_1
X$6802 VDD synth_3962 synth_3824 synth_4240 VDD VNB|VSS VNB|VSS
+ sky130_fd_sc_hd__nand2_1
X$6803 VDD synth_9670 synth_9762 synth_9736 VDD VNB|VSS VNB|VSS
+ sky130_fd_sc_hd__nand2_1
X$6804 VDD synth_3942 synth_657 synth_3764 VDD VNB|VSS VNB|VSS
+ sky130_fd_sc_hd__nand2_1
X$6805 VDD synth_11808 synth_11740 synth_11810 VDD VNB|VSS VNB|VSS
+ sky130_fd_sc_hd__nand2_1
X$6806 VDD synth_5204 synth_5083 synth_5084 VDD VNB|VSS VNB|VSS
+ sky130_fd_sc_hd__nand2_1
X$6807 VDD synth_11830 synth_5738 synth_12615 VDD VNB|VSS VNB|VSS
+ sky130_fd_sc_hd__nand2_1
X$6808 VDD synth_7719 synth_7773 synth_7816 VDD VNB|VSS VNB|VSS
+ sky130_fd_sc_hd__nand2_1
X$6809 VDD synth_8000 synth_9757 synth_9844 VDD VNB|VSS VNB|VSS
+ sky130_fd_sc_hd__nand2_1
X$6810 VDD synth_6446 synth_6232 synth_6545 VDD VNB|VSS VNB|VSS
+ sky130_fd_sc_hd__nand2_1
X$6811 VDD synth_3642 synth_4409 synth_4198 VDD VNB|VSS VNB|VSS
+ sky130_fd_sc_hd__nand2_1
X$6812 VDD synth_10164 synth_11830 synth_12504 VDD VNB|VSS VNB|VSS
+ sky130_fd_sc_hd__nand2_1
X$6813 VDD synth_9867 synth_9942 synth_9956 VDD VNB|VSS VNB|VSS
+ sky130_fd_sc_hd__nand2_1
X$6814 VDD synth_6819 synth_5900 synth_7170 VDD VNB|VSS VNB|VSS
+ sky130_fd_sc_hd__nand2_1
X$6815 VDD synth_2951 synth_657 synth_2592 VDD VNB|VSS VNB|VSS
+ sky130_fd_sc_hd__nand2_1
X$6816 VDD synth_6708 synth_6659 synth_6594 VDD VNB|VSS VNB|VSS
+ sky130_fd_sc_hd__nand2_1
X$6817 VDD synth_7991 synth_7848 synth_8069 VDD VNB|VSS VNB|VSS
+ sky130_fd_sc_hd__nand2_1
X$9826 VDD synth_4762 synth_4645 synth_4687 VDD synth_4686 VNB|VSS VNB|VSS
+ sky130_fd_sc_hd__o21ai_0
X$9827 VDD synth_10652 synth_11515 synth_11597 VDD synth_11638 VNB|VSS VNB|VSS
+ sky130_fd_sc_hd__o21ai_0
X$9828 VDD synth_3693 synth_3604 synth_3727 VDD synth_3939 VNB|VSS VNB|VSS
+ sky130_fd_sc_hd__o21ai_0
X$9829 VDD synth_9260 synth_8884 synth_8961 VDD synth_8812 VNB|VSS VNB|VSS
+ sky130_fd_sc_hd__o21ai_0
X$9830 VDD synth_5742 synth_3632 synth_5743 VDD synth_5874 VNB|VSS VNB|VSS
+ sky130_fd_sc_hd__o21ai_0
X$9831 VDD synth_5042 synth_4840 synth_4842 VDD synth_4998 VNB|VSS VNB|VSS
+ sky130_fd_sc_hd__o21ai_0
X$9832 VDD synth_10358 synth_8000 synth_10359 VDD synth_10473 VNB|VSS VNB|VSS
+ sky130_fd_sc_hd__o21ai_0
X$9833 VDD synth_10656 synth_10680 synth_10657 VDD synth_10948 VNB|VSS VNB|VSS
+ sky130_fd_sc_hd__o21ai_0
X$9834 VDD synth_10726 synth_10644 synth_9172 VDD synth_8984 VNB|VSS VNB|VSS
+ sky130_fd_sc_hd__o21ai_0
X$9835 VDD synth_7627 synth_7491 synth_7492 VDD synth_7455 VNB|VSS VNB|VSS
+ sky130_fd_sc_hd__o21ai_0
X$9836 VDD synth_7355 synth_7182 synth_7356 VDD synth_7442 VNB|VSS VNB|VSS
+ sky130_fd_sc_hd__o21ai_0
X$9837 VDD synth_9677 synth_10369 synth_10490 VDD synth_10368 VNB|VSS VNB|VSS
+ sky130_fd_sc_hd__o21ai_0
X$9838 VDD synth_801 synth_1059 synth_1095 VDD synth_1171 VNB|VSS VNB|VSS
+ sky130_fd_sc_hd__o21ai_0
X$9839 VDD synth_11335 synth_11405 synth_11334 VDD synth_11255 VNB|VSS VNB|VSS
+ sky130_fd_sc_hd__o21ai_0
X$9840 VDD synth_3678 synth_3604 synth_3726 VDD synth_3791 VNB|VSS VNB|VSS
+ sky130_fd_sc_hd__o21ai_0
X$9841 VDD synth_9474 synth_10169 synth_9292 VDD synth_10437 VNB|VSS VNB|VSS
+ sky130_fd_sc_hd__o21ai_0
X$9842 VDD synth_4895 synth_5014 synth_5045 VDD synth_4834 VNB|VSS VNB|VSS
+ sky130_fd_sc_hd__o21ai_0
X$9843 VDD synth_6533 synth_3541 synth_6534 VDD synth_6619 VNB|VSS VNB|VSS
+ sky130_fd_sc_hd__o21ai_0
X$9844 VDD synth_4057 synth_3927 synth_4112 VDD synth_3926 VNB|VSS VNB|VSS
+ sky130_fd_sc_hd__o21ai_0
X$9845 VDD synth_3921 synth_3887 synth_3983 VDD synth_4132 VNB|VSS VNB|VSS
+ sky130_fd_sc_hd__o21ai_0
X$9846 VDD synth_8752 synth_8750 synth_8702 VDD synth_8749 VNB|VSS VNB|VSS
+ sky130_fd_sc_hd__o21ai_0
X$9847 VDD synth_2299 synth_1338 synth_2327 VDD synth_2325 VNB|VSS VNB|VSS
+ sky130_fd_sc_hd__o21ai_0
X$9848 VDD synth_9387 synth_8945 synth_11864 VDD synth_11911 VNB|VSS VNB|VSS
+ sky130_fd_sc_hd__o21ai_0
X$9849 VDD synth_9154 synth_9170 synth_9226 VDD synth_9151 VNB|VSS VNB|VSS
+ sky130_fd_sc_hd__o21ai_0
X$9850 VDD synth_2437 synth_2529 synth_2566 VDD synth_2367 VNB|VSS VNB|VSS
+ sky130_fd_sc_hd__o21ai_0
X$9851 VDD synth_2194 synth_2272 synth_2253 VDD synth_2254 VNB|VSS VNB|VSS
+ sky130_fd_sc_hd__o21ai_0
X$9852 VDD synth_1568 synth_1435 synth_1514 VDD synth_1492 VNB|VSS VNB|VSS
+ sky130_fd_sc_hd__o21ai_0
X$9853 VDD synth_2543 synth_2588 synth_2589 VDD synth_2481 VNB|VSS VNB|VSS
+ sky130_fd_sc_hd__o21ai_0
X$9854 VDD synth_3883 synth_3951 synth_3977 VDD synth_3913 VNB|VSS VNB|VSS
+ sky130_fd_sc_hd__o21ai_0
X$9855 VDD synth_1700 synth_659 synth_1702 VDD synth_1763 VNB|VSS VNB|VSS
+ sky130_fd_sc_hd__o21ai_0
X$9856 VDD synth_12071 synth_10164 synth_12128 VDD synth_12191 VNB|VSS VNB|VSS
+ sky130_fd_sc_hd__o21ai_0
X$9857 VDD synth_9519 synth_9381 synth_9520 VDD synth_9465 VNB|VSS VNB|VSS
+ sky130_fd_sc_hd__o21ai_0
X$9858 VDD synth_5428 synth_5461 synth_5525 VDD synth_5713 VNB|VSS VNB|VSS
+ sky130_fd_sc_hd__o21ai_0
X$9859 VDD synth_476 synth_194 synth_434 VDD synth_433 VNB|VSS VNB|VSS
+ sky130_fd_sc_hd__o21ai_0
X$9860 VDD synth_11031 synth_11144 synth_11183 VDD synth_11230 VNB|VSS VNB|VSS
+ sky130_fd_sc_hd__o21ai_0
X$9861 VDD synth_6689 synth_4747 synth_6630 VDD synth_6765 VNB|VSS VNB|VSS
+ sky130_fd_sc_hd__o21ai_0
X$9862 VDD synth_10052 synth_9921 synth_9976 VDD synth_9975 VNB|VSS VNB|VSS
+ sky130_fd_sc_hd__o21ai_0
X$9863 VDD synth_7513 synth_7089 synth_7639 VDD synth_7673 VNB|VSS VNB|VSS
+ sky130_fd_sc_hd__o21ai_0
X$9864 VDD synth_8821 synth_8530 synth_8774 VDD synth_8722 VNB|VSS VNB|VSS
+ sky130_fd_sc_hd__o21ai_0
X$9865 VDD synth_12257 synth_9762 synth_12325 VDD synth_12324 VNB|VSS VNB|VSS
+ sky130_fd_sc_hd__o21ai_0
X$9866 VDD synth_7392 synth_7450 synth_7480 VDD synth_7482 VNB|VSS VNB|VSS
+ sky130_fd_sc_hd__o21ai_0
X$9867 VDD synth_907 synth_906 synth_1161 VDD synth_1121 VNB|VSS VNB|VSS
+ sky130_fd_sc_hd__o21ai_0
X$9868 VDD synth_11455 synth_11669 synth_11671 VDD synth_12045 VNB|VSS VNB|VSS
+ sky130_fd_sc_hd__o21ai_0
X$9869 VDD synth_10537 synth_10164 synth_10931 VDD synth_11119 VNB|VSS VNB|VSS
+ sky130_fd_sc_hd__o21ai_0
X$9870 VDD synth_10130 synth_10164 synth_10332 VDD synth_10227 VNB|VSS VNB|VSS
+ sky130_fd_sc_hd__o21ai_0
X$9871 VDD synth_5021 synth_5083 synth_5022 VDD synth_4971 VNB|VSS VNB|VSS
+ sky130_fd_sc_hd__o21ai_0
X$9872 VDD synth_2321 synth_2437 synth_2411 VDD synth_2410 VNB|VSS VNB|VSS
+ sky130_fd_sc_hd__o21ai_0
X$9873 VDD synth_595 synth_194 synth_597 VDD synth_650 VNB|VSS VNB|VSS
+ sky130_fd_sc_hd__o21ai_0
X$9874 VDD synth_10863 synth_9675 synth_9119 VDD synth_9584 VNB|VSS VNB|VSS
+ sky130_fd_sc_hd__o21ai_0
X$9875 VDD synth_4088 synth_4149 synth_4433 VDD synth_4485 VNB|VSS VNB|VSS
+ sky130_fd_sc_hd__o21ai_0
X$9876 VDD synth_2972 synth_927 synth_2974 VDD synth_2975 VNB|VSS VNB|VSS
+ sky130_fd_sc_hd__o21ai_0
X$9877 VDD synth_4819 synth_4840 synth_4841 VDD synth_4820 VNB|VSS VNB|VSS
+ sky130_fd_sc_hd__o21ai_0
X$9878 VDD synth_9101 synth_9894 synth_9520 VDD synth_9631 VNB|VSS VNB|VSS
+ sky130_fd_sc_hd__o21ai_0
X$9879 VDD synth_9773 synth_9431 synth_9629 VDD synth_10402 VNB|VSS VNB|VSS
+ sky130_fd_sc_hd__o21ai_0
X$9880 VDD synth_2114 synth_2310 synth_2166 VDD synth_2189 VNB|VSS VNB|VSS
+ sky130_fd_sc_hd__o21ai_0
X$9881 VDD synth_711 synth_745 synth_669 VDD synth_796 VNB|VSS VNB|VSS
+ sky130_fd_sc_hd__o21ai_0
X$9882 VDD synth_8896 synth_7089 synth_9051 VDD synth_9092 VNB|VSS VNB|VSS
+ sky130_fd_sc_hd__o21ai_0
X$9883 VDD synth_8831 synth_9377 synth_9062 VDD synth_9467 VNB|VSS VNB|VSS
+ sky130_fd_sc_hd__o21ai_0
X$9884 VDD synth_11181 synth_11141 synth_11182 VDD synth_11257 VNB|VSS VNB|VSS
+ sky130_fd_sc_hd__o21ai_0
X$9885 VDD synth_6052 synth_3632 synth_6072 VDD synth_6213 VNB|VSS VNB|VSS
+ sky130_fd_sc_hd__o21ai_0
X$9886 VDD synth_6201 synth_6232 synth_6234 VDD synth_6278 VNB|VSS VNB|VSS
+ sky130_fd_sc_hd__o21ai_0
X$9887 VDD synth_2788 synth_1067 synth_2786 VDD synth_2914 VNB|VSS VNB|VSS
+ sky130_fd_sc_hd__o21ai_0
X$9888 VDD synth_5665 synth_5739 synth_5782 VDD synth_5706 VNB|VSS VNB|VSS
+ sky130_fd_sc_hd__o21ai_0
X$9889 VDD synth_3097 synth_3124 synth_3195 VDD synth_3194 VNB|VSS VNB|VSS
+ sky130_fd_sc_hd__o21ai_0
X$9890 VDD synth_12118 synth_12119 synth_12120 VDD synth_12187 VNB|VSS VNB|VSS
+ sky130_fd_sc_hd__o21ai_0
X$9891 VDD synth_3444 synth_3381 synth_3380 VDD synth_3529 VNB|VSS VNB|VSS
+ sky130_fd_sc_hd__o21ai_0
X$9892 VDD synth_11593 synth_11594 synth_8803 VDD synth_11678 VNB|VSS VNB|VSS
+ sky130_fd_sc_hd__o21ai_0
X$9893 VDD synth_1216 synth_1281 synth_1365 VDD synth_1189 VNB|VSS VNB|VSS
+ sky130_fd_sc_hd__o21ai_0
X$9894 VDD synth_10084 synth_9762 synth_10151 VDD synth_10089 VNB|VSS VNB|VSS
+ sky130_fd_sc_hd__o21ai_0
X$9895 VDD synth_12100 synth_10164 synth_12123 VDD synth_12099 VNB|VSS VNB|VSS
+ sky130_fd_sc_hd__o21ai_0
X$9896 VDD synth_2605 synth_2548 synth_2673 VDD synth_2444 VNB|VSS VNB|VSS
+ sky130_fd_sc_hd__o21ai_0
X$9897 VDD synth_11371 synth_11588 synth_11300 VDD synth_11705 VNB|VSS VNB|VSS
+ sky130_fd_sc_hd__o21ai_0
X$9898 VDD synth_12090 synth_11973 synth_12032 VDD synth_11974 VNB|VSS VNB|VSS
+ sky130_fd_sc_hd__o21ai_0
X$9899 VDD synth_3838 synth_3927 synth_3903 VDD synth_3837 VNB|VSS VNB|VSS
+ sky130_fd_sc_hd__o21ai_0
X$9900 VDD synth_8626 synth_8756 synth_8627 VDD synth_8757 VNB|VSS VNB|VSS
+ sky130_fd_sc_hd__o21ai_0
X$9901 VDD synth_8013 synth_8210 synth_8178 VDD synth_8092 VNB|VSS VNB|VSS
+ sky130_fd_sc_hd__o21ai_0
X$9902 VDD synth_6120 synth_6349 synth_6585 VDD synth_6810 VNB|VSS VNB|VSS
+ sky130_fd_sc_hd__o21ai_0
X$9903 VDD synth_10212 synth_10312 synth_8806 VDD synth_10653 VNB|VSS VNB|VSS
+ sky130_fd_sc_hd__o21ai_0
X$9904 VDD synth_9947 synth_9948 synth_10123 VDD synth_9130 VNB|VSS VNB|VSS
+ sky130_fd_sc_hd__o21ai_0
X$9905 VDD synth_5938 synth_4747 synth_5937 VDD synth_6085 VNB|VSS VNB|VSS
+ sky130_fd_sc_hd__o21ai_0
X$9906 VDD synth_11479 synth_11480 synth_11478 VDD synth_11692 VNB|VSS VNB|VSS
+ sky130_fd_sc_hd__o21ai_0
X$9907 VDD synth_1586 synth_1435 synth_1515 VDD synth_1569 VNB|VSS VNB|VSS
+ sky130_fd_sc_hd__o21ai_0
X$9908 VDD synth_3023 synth_3058 synth_3130 VDD synth_3059 VNB|VSS VNB|VSS
+ sky130_fd_sc_hd__o21ai_0
X$9909 VDD synth_12268 synth_9423 synth_12580 VDD synth_12748 VNB|VSS VNB|VSS
+ sky130_fd_sc_hd__o21ai_0
X$9910 VDD synth_5299 synth_5088 synth_5271 VDD synth_5168 VNB|VSS VNB|VSS
+ sky130_fd_sc_hd__o21ai_0
X$9911 VDD synth_2683 synth_2642 synth_2827 VDD synth_2761 VNB|VSS VNB|VSS
+ sky130_fd_sc_hd__o21ai_0
X$9912 VDD synth_2992 synth_167 synth_2989 VDD synth_2991 VNB|VSS VNB|VSS
+ sky130_fd_sc_hd__o21ai_0
X$9913 VDD synth_5645 synth_5383 synth_5564 VDD synth_6047 VNB|VSS VNB|VSS
+ sky130_fd_sc_hd__o21ai_0
X$9914 VDD synth_3459 synth_1067 synth_3435 VDD synth_3516 VNB|VSS VNB|VSS
+ sky130_fd_sc_hd__o21ai_0
X$9915 VDD synth_3510 synth_1353 synth_3721 VDD synth_3769 VNB|VSS VNB|VSS
+ sky130_fd_sc_hd__o21ai_0
X$9916 VDD synth_6516 synth_6379 synth_6380 VDD synth_6455 VNB|VSS VNB|VSS
+ sky130_fd_sc_hd__o21ai_0
X$9917 VDD synth_225 synth_351 synth_287 VDD synth_250 VNB|VSS VNB|VSS
+ sky130_fd_sc_hd__o21ai_0
X$9918 VDD synth_10387 synth_10453 synth_10260 VDD synth_10182 VNB|VSS VNB|VSS
+ sky130_fd_sc_hd__o21ai_0
X$9919 VDD synth_3202 synth_3368 synth_3292 VDD synth_3265 VNB|VSS VNB|VSS
+ sky130_fd_sc_hd__o21ai_0
X$9920 VDD synth_5494 synth_5492 synth_5493 VDD synth_5495 VNB|VSS VNB|VSS
+ sky130_fd_sc_hd__o21ai_0
X$9921 VDD synth_9177 synth_11568 synth_11503 VDD synth_11628 VNB|VSS VNB|VSS
+ sky130_fd_sc_hd__o21ai_0
X$9922 VDD synth_132 synth_208 synth_272 VDD synth_544 VNB|VSS VNB|VSS
+ sky130_fd_sc_hd__o21ai_0
X$9923 VDD synth_9677 synth_10365 synth_10366 VDD synth_10414 VNB|VSS VNB|VSS
+ sky130_fd_sc_hd__o21ai_0
X$9924 VDD synth_6348 synth_5982 synth_6282 VDD synth_6235 VNB|VSS VNB|VSS
+ sky130_fd_sc_hd__o21ai_0
X$9925 VDD synth_10508 synth_9423 synth_10843 VDD synth_10618 VNB|VSS VNB|VSS
+ sky130_fd_sc_hd__o21ai_0
X$9926 VDD synth_3375 synth_3514 synth_3433 VDD synth_3457 VNB|VSS VNB|VSS
+ sky130_fd_sc_hd__o21ai_0
X$9927 VDD synth_4007 synth_3541 synth_4008 VDD synth_4127 VNB|VSS VNB|VSS
+ sky130_fd_sc_hd__o21ai_0
X$9928 VDD synth_3464 synth_3686 synth_3561 VDD synth_3687 VNB|VSS VNB|VSS
+ sky130_fd_sc_hd__o21ai_0
X$9929 VDD synth_9677 synth_10232 synth_8803 VDD synth_10219 VNB|VSS VNB|VSS
+ sky130_fd_sc_hd__o21ai_0
X$9930 VDD synth_4850 synth_4753 synth_4947 VDD synth_4955 VNB|VSS VNB|VSS
+ sky130_fd_sc_hd__o21ai_0
X$9931 VDD synth_7240 synth_6771 synth_7265 VDD synth_7584 VNB|VSS VNB|VSS
+ sky130_fd_sc_hd__o21ai_0
X$9932 VDD synth_10578 synth_10697 synth_10372 VDD synth_11167 VNB|VSS VNB|VSS
+ sky130_fd_sc_hd__o21ai_0
X$9933 VDD synth_3498 synth_3243 synth_3408 VDD synth_3497 VNB|VSS VNB|VSS
+ sky130_fd_sc_hd__o21ai_0
X$9934 VDD synth_1250 synth_1428 synth_1471 VDD synth_1554 VNB|VSS VNB|VSS
+ sky130_fd_sc_hd__o21ai_0
X$9935 VDD synth_1466 synth_1297 synth_1308 VDD synth_1307 VNB|VSS VNB|VSS
+ sky130_fd_sc_hd__o21ai_0
X$9936 VDD synth_1600 synth_1421 synth_1422 VDD synth_1464 VNB|VSS VNB|VSS
+ sky130_fd_sc_hd__o21ai_0
X$9937 VDD synth_724 synth_752 synth_673 VDD synth_798 VNB|VSS VNB|VSS
+ sky130_fd_sc_hd__o21ai_0
X$9938 VDD synth_6339 synth_3468 synth_6554 VDD synth_6641 VNB|VSS VNB|VSS
+ sky130_fd_sc_hd__o21ai_0
X$9939 VDD synth_8548 synth_8442 synth_8524 VDD synth_8609 VNB|VSS VNB|VSS
+ sky130_fd_sc_hd__o21ai_0
X$9940 VDD synth_4041 synth_4140 synth_3854 VDD synth_4052 VNB|VSS VNB|VSS
+ sky130_fd_sc_hd__o21ai_0
X$9941 VDD synth_1401 synth_1259 synth_1261 VDD synth_1555 VNB|VSS VNB|VSS
+ sky130_fd_sc_hd__o21ai_0
X$9942 VDD synth_85 synth_278 synth_383 VDD synth_47 VNB|VSS VNB|VSS
+ sky130_fd_sc_hd__o21ai_0
X$9943 VDD synth_10793 synth_10099 synth_10728 VDD synth_10794 VNB|VSS VNB|VSS
+ sky130_fd_sc_hd__o21ai_0
X$9944 VDD synth_10795 synth_12757 synth_10793 VDD synth_12642 VNB|VSS VNB|VSS
+ sky130_fd_sc_hd__o21ai_0
X$9945 VDD synth_3249 synth_3248 synth_3250 VDD synth_3187 VNB|VSS VNB|VSS
+ sky130_fd_sc_hd__o21ai_0
X$9946 VDD synth_2876 synth_2965 synth_2997 VDD synth_3069 VNB|VSS VNB|VSS
+ sky130_fd_sc_hd__o21ai_0
X$9947 VDD synth_65 synth_97 synth_111 VDD synth_31 VNB|VSS VNB|VSS
+ sky130_fd_sc_hd__o21ai_0
X$9948 VDD synth_4677 synth_4678 synth_4802 VDD synth_4626 VNB|VSS VNB|VSS
+ sky130_fd_sc_hd__o21ai_0
X$9949 VDD synth_9036 synth_10371 synth_9387 VDD synth_10370 VNB|VSS VNB|VSS
+ sky130_fd_sc_hd__o21ai_0
X$9950 VDD synth_5665 synth_5666 synth_5784 VDD synth_5741 VNB|VSS VNB|VSS
+ sky130_fd_sc_hd__o21ai_0
X$9951 VDD synth_8621 synth_8658 synth_8578 VDD synth_8622 VNB|VSS VNB|VSS
+ sky130_fd_sc_hd__o21ai_0
X$9952 VDD synth_4832 synth_4915 synth_4966 VDD synth_4790 VNB|VSS VNB|VSS
+ sky130_fd_sc_hd__o21ai_0
X$9953 VDD synth_5496 synth_3632 synth_5497 VDD synth_5410 VNB|VSS VNB|VSS
+ sky130_fd_sc_hd__o21ai_0
X$9954 VDD synth_2072 synth_1902 synth_2028 VDD synth_2073 VNB|VSS VNB|VSS
+ sky130_fd_sc_hd__o21ai_0
X$9955 VDD synth_5248 synth_3632 synth_5213 VDD synth_5062 VNB|VSS VNB|VSS
+ sky130_fd_sc_hd__o21ai_0
X$9956 VDD synth_2788 synth_2722 synth_2765 VDD synth_2787 VNB|VSS VNB|VSS
+ sky130_fd_sc_hd__o21ai_0
X$9957 VDD synth_9341 synth_9342 synth_9188 VDD synth_9351 VNB|VSS VNB|VSS
+ sky130_fd_sc_hd__o21ai_0
X$9958 VDD synth_6313 synth_6214 synth_6215 VDD synth_6216 VNB|VSS VNB|VSS
+ sky130_fd_sc_hd__o21ai_0
X$9959 VDD synth_6087 synth_5999 synth_6100 VDD synth_6169 VNB|VSS VNB|VSS
+ sky130_fd_sc_hd__o21ai_0
X$9960 VDD synth_4831 synth_4915 synth_4965 VDD synth_4888 VNB|VSS VNB|VSS
+ sky130_fd_sc_hd__o21ai_0
X$9961 VDD synth_10376 synth_8981 synth_10370 VDD synth_10369 VNB|VSS VNB|VSS
+ sky130_fd_sc_hd__o21ai_0
X$9962 VDD synth_10418 synth_9555 synth_9234 VDD synth_10364 VNB|VSS VNB|VSS
+ sky130_fd_sc_hd__o21ai_0
X$9963 VDD synth_3253 synth_3248 synth_3188 VDD synth_3259 VNB|VSS VNB|VSS
+ sky130_fd_sc_hd__o21ai_0
X$9964 VDD synth_8538 synth_8536 synth_8537 VDD synth_8729 VNB|VSS VNB|VSS
+ sky130_fd_sc_hd__o21ai_0
X$9965 VDD synth_2862 synth_2793 synth_2794 VDD synth_2795 VNB|VSS VNB|VSS
+ sky130_fd_sc_hd__o21ai_0
X$9966 VDD synth_3870 synth_3824 synth_3872 VDD synth_3803 VNB|VSS VNB|VSS
+ sky130_fd_sc_hd__o21ai_0
X$9967 VDD synth_1168 synth_1092 synth_1146 VDD synth_1091 VNB|VSS VNB|VSS
+ sky130_fd_sc_hd__o21ai_0
X$9968 VDD synth_9474 synth_10367 synth_9677 VDD synth_10366 VNB|VSS VNB|VSS
+ sky130_fd_sc_hd__o21ai_0
X$9969 VDD synth_9292 synth_10440 synth_11651 VDD synth_11650 VNB|VSS VNB|VSS
+ sky130_fd_sc_hd__o21ai_0
X$9970 VDD synth_8860 synth_9043 synth_8913 VDD synth_8983 VNB|VSS VNB|VSS
+ sky130_fd_sc_hd__o21ai_0
X$9971 VDD synth_9474 synth_11589 synth_9730 VDD synth_11728 VNB|VSS VNB|VSS
+ sky130_fd_sc_hd__o21ai_0
X$9972 VDD synth_4557 synth_4678 synth_4706 VDD synth_4498 VNB|VSS VNB|VSS
+ sky130_fd_sc_hd__o21ai_0
X$9973 VDD synth_567 synth_678 synth_600 VDD synth_601 VNB|VSS VNB|VSS
+ sky130_fd_sc_hd__o21ai_0
X$9974 VDD synth_1132 synth_1338 synth_1243 VDD synth_1242 VNB|VSS VNB|VSS
+ sky130_fd_sc_hd__o21ai_0
X$9975 VDD synth_6880 synth_6349 synth_6653 VDD synth_6726 VNB|VSS VNB|VSS
+ sky130_fd_sc_hd__o21ai_0
X$9976 VDD synth_9119 synth_9974 synth_9929 VDD synth_10152 VNB|VSS VNB|VSS
+ sky130_fd_sc_hd__o21ai_0
X$9977 VDD synth_10003 synth_10982 synth_10980 VDD synth_10059 VNB|VSS VNB|VSS
+ sky130_fd_sc_hd__o21ai_0
X$9978 VDD synth_11158 synth_11242 synth_11245 VDD synth_11376 VNB|VSS VNB|VSS
+ sky130_fd_sc_hd__o21ai_0
X$9979 VDD synth_5640 synth_5511 synth_5618 VDD synth_5639 VNB|VSS VNB|VSS
+ sky130_fd_sc_hd__o21ai_0
X$9980 VDD synth_3262 synth_3547 synth_3590 VDD synth_3589 VNB|VSS VNB|VSS
+ sky130_fd_sc_hd__o21ai_0
X$9981 VDD synth_330 synth_102 synth_262 VDD synth_26 VNB|VSS VNB|VSS
+ sky130_fd_sc_hd__o21ai_0
X$9982 VDD synth_12672 synth_12600 synth_12601 VDD synth_12751 VNB|VSS VNB|VSS
+ sky130_fd_sc_hd__o21ai_0
X$9983 VDD synth_10819 synth_10895 synth_10852 VDD synth_10929 VNB|VSS VNB|VSS
+ sky130_fd_sc_hd__o21ai_0
X$9984 VDD synth_10247 synth_10067 synth_10124 VDD synth_10195 VNB|VSS VNB|VSS
+ sky130_fd_sc_hd__o21ai_0
X$9985 VDD synth_6043 synth_5809 synth_5893 VDD synth_6042 VNB|VSS VNB|VSS
+ sky130_fd_sc_hd__o21ai_0
X$9986 VDD synth_12449 synth_12590 synth_12647 VDD synth_12447 VNB|VSS VNB|VSS
+ sky130_fd_sc_hd__o21ai_0
X$9987 VDD synth_5070 synth_5121 synth_5332 VDD synth_5228 VNB|VSS VNB|VSS
+ sky130_fd_sc_hd__o21ai_0
X$9988 VDD synth_7879 synth_7985 synth_7909 VDD synth_7877 VNB|VSS VNB|VSS
+ sky130_fd_sc_hd__o21ai_0
X$9989 VDD synth_9997 synth_9844 synth_10085 VDD synth_9916 VNB|VSS VNB|VSS
+ sky130_fd_sc_hd__o21ai_0
X$9990 VDD synth_1853 synth_1738 synth_1784 VDD synth_1684 VNB|VSS VNB|VSS
+ sky130_fd_sc_hd__o21ai_0
X$9991 VDD synth_8803 synth_9615 synth_10099 VDD synth_12549 VNB|VSS VNB|VSS
+ sky130_fd_sc_hd__o21ai_0
X$9992 VDD synth_5260 synth_4709 synth_5156 VDD synth_5079 VNB|VSS VNB|VSS
+ sky130_fd_sc_hd__o21ai_0
X$9993 VDD synth_8806 synth_9036 synth_9063 VDD synth_9103 VNB|VSS VNB|VSS
+ sky130_fd_sc_hd__o21ai_0
X$9994 VDD synth_5147 synth_5146 synth_5235 VDD synth_5251 VNB|VSS VNB|VSS
+ sky130_fd_sc_hd__o21ai_0
X$9995 VDD synth_5001 synth_5050 synth_5181 VDD synth_5091 VNB|VSS VNB|VSS
+ sky130_fd_sc_hd__o21ai_0
X$9996 VDD synth_9474 synth_12235 synth_9396 VDD synth_12347 VNB|VSS VNB|VSS
+ sky130_fd_sc_hd__o21ai_0
X$9997 VDD synth_589 synth_194 synth_558 VDD synth_591 VNB|VSS VNB|VSS
+ sky130_fd_sc_hd__o21ai_0
X$9998 VDD synth_10795 synth_12235 synth_10793 VDD synth_12283 VNB|VSS VNB|VSS
+ sky130_fd_sc_hd__o21ai_0
X$9999 VDD synth_5907 synth_3468 synth_5954 VDD synth_6050 VNB|VSS VNB|VSS
+ sky130_fd_sc_hd__o21ai_0
X$10000 VDD synth_12102 synth_9762 synth_12133 VDD synth_12193 VNB|VSS VNB|VSS
+ sky130_fd_sc_hd__o21ai_0
X$10001 VDD synth_4624 synth_4369 synth_4556 VDD synth_4532 VNB|VSS VNB|VSS
+ sky130_fd_sc_hd__o21ai_0
X$10002 VDD synth_1656 synth_1595 synth_1593 VDD synth_1655 VNB|VSS VNB|VSS
+ sky130_fd_sc_hd__o21ai_0
X$10003 VDD synth_11482 synth_11443 synth_11445 VDD synth_11407 VNB|VSS VNB|VSS
+ sky130_fd_sc_hd__o21ai_0
X$10004 VDD synth_6648 synth_6901 synth_6941 VDD synth_6650 VNB|VSS VNB|VSS
+ sky130_fd_sc_hd__o21ai_0
X$10005 VDD synth_3828 synth_3944 synth_4072 VDD synth_3868 VNB|VSS VNB|VSS
+ sky130_fd_sc_hd__o21ai_0
X$10006 VDD synth_12009 synth_11841 synth_11842 VDD synth_11918 VNB|VSS VNB|VSS
+ sky130_fd_sc_hd__o21ai_0
X$10007 VDD synth_2598 synth_2665 synth_2666 VDD synth_2600 VNB|VSS VNB|VSS
+ sky130_fd_sc_hd__o21ai_0
X$10008 VDD synth_5897 synth_6209 synth_6128 VDD synth_6071 VNB|VSS VNB|VSS
+ sky130_fd_sc_hd__o21ai_0
X$10009 VDD synth_3160 synth_3124 synth_3096 VDD synth_3192 VNB|VSS VNB|VSS
+ sky130_fd_sc_hd__o21ai_0
X$10010 VDD synth_3027 synth_1067 synth_3104 VDD synth_3168 VNB|VSS VNB|VSS
+ sky130_fd_sc_hd__o21ai_0
X$10011 VDD synth_3625 synth_1338 synth_3692 VDD synth_3751 VNB|VSS VNB|VSS
+ sky130_fd_sc_hd__o21ai_0
X$10012 VDD synth_4825 synth_4823 synth_4905 VDD synth_4690 VNB|VSS VNB|VSS
+ sky130_fd_sc_hd__o21ai_0
X$10013 VDD synth_9552 synth_9501 synth_9503 VDD synth_9472 VNB|VSS VNB|VSS
+ sky130_fd_sc_hd__o21ai_0
X$10014 VDD synth_5481 synth_5479 synth_5480 VDD synth_5574 VNB|VSS VNB|VSS
+ sky130_fd_sc_hd__o21ai_0
X$10015 VDD synth_5351 synth_4961 synth_5293 VDD synth_5353 VNB|VSS VNB|VSS
+ sky130_fd_sc_hd__o21ai_0
X$10016 VDD synth_6586 synth_6450 synth_6377 VDD synth_6655 VNB|VSS VNB|VSS
+ sky130_fd_sc_hd__o21ai_0
X$10017 VDD synth_10986 synth_11004 synth_11005 VDD synth_11003 VNB|VSS VNB|VSS
+ sky130_fd_sc_hd__o21ai_0
X$10018 VDD synth_3267 synth_1338 synth_3369 VDD synth_3502 VNB|VSS VNB|VSS
+ sky130_fd_sc_hd__o21ai_0
X$10019 VDD synth_6624 synth_6659 synth_6848 VDD synth_6623 VNB|VSS VNB|VSS
+ sky130_fd_sc_hd__o21ai_0
X$10020 VDD synth_9753 synth_10067 synth_10068 VDD synth_10066 VNB|VSS VNB|VSS
+ sky130_fd_sc_hd__o21ai_0
X$10021 VDD synth_6912 synth_6698 synth_6695 VDD synth_6986 VNB|VSS VNB|VSS
+ sky130_fd_sc_hd__o21ai_0
X$10022 VDD synth_789 synth_678 synth_680 VDD synth_719 VNB|VSS VNB|VSS
+ sky130_fd_sc_hd__o21ai_0
X$10023 VDD synth_10789 synth_10713 synth_10838 VDD synth_10836 VNB|VSS VNB|VSS
+ sky130_fd_sc_hd__o21ai_0
X$10024 VDD synth_5309 synth_5121 synth_5229 VDD synth_5310 VNB|VSS VNB|VSS
+ sky130_fd_sc_hd__o21ai_0
X$10025 VDD synth_11010 synth_10006 synth_11749 VDD synth_11748 VNB|VSS VNB|VSS
+ sky130_fd_sc_hd__o21ai_0
X$10026 VDD synth_1879 synth_1067 synth_2014 VDD synth_2013 VNB|VSS VNB|VSS
+ sky130_fd_sc_hd__o21ai_0
X$10027 VDD synth_10278 synth_10431 synth_10405 VDD synth_10276 VNB|VSS VNB|VSS
+ sky130_fd_sc_hd__o21ai_0
X$10028 VDD synth_5479 synth_5522 synth_5523 VDD synth_5436 VNB|VSS VNB|VSS
+ sky130_fd_sc_hd__o21ai_0
X$10029 VDD synth_10636 synth_10720 synth_10637 VDD synth_10721 VNB|VSS VNB|VSS
+ sky130_fd_sc_hd__o21ai_0
X$10030 VDD synth_1601 synth_1519 synth_1604 VDD synth_1679 VNB|VSS VNB|VSS
+ sky130_fd_sc_hd__o21ai_0
X$10031 VDD synth_8470 synth_8385 synth_8449 VDD synth_8523 VNB|VSS VNB|VSS
+ sky130_fd_sc_hd__o21ai_0
X$10032 VDD synth_9063 synth_10099 synth_8802 VDD synth_9977 VNB|VSS VNB|VSS
+ sky130_fd_sc_hd__o21ai_0
X$10033 VDD synth_6779 synth_6450 synth_6604 VDD synth_6654 VNB|VSS VNB|VSS
+ sky130_fd_sc_hd__o21ai_0
X$10034 VDD synth_11381 synth_11312 synth_11456 VDD synth_11577 VNB|VSS VNB|VSS
+ sky130_fd_sc_hd__o21ai_0
X$10035 VDD synth_5550 synth_5479 synth_5599 VDD synth_5600 VNB|VSS VNB|VSS
+ sky130_fd_sc_hd__o21ai_0
X$10036 VDD synth_11286 synth_11082 synth_11081 VDD synth_11152 VNB|VSS VNB|VSS
+ sky130_fd_sc_hd__o21ai_0
X$10037 VDD synth_12709 synth_12590 synth_12648 VDD synth_12782 VNB|VSS VNB|VSS
+ sky130_fd_sc_hd__o21ai_0
X$10038 VDD synth_11848 synth_11954 synth_11847 VDD synth_11802 VNB|VSS VNB|VSS
+ sky130_fd_sc_hd__o21ai_0
X$10039 VDD synth_9731 synth_8000 synth_9732 VDD synth_9822 VNB|VSS VNB|VSS
+ sky130_fd_sc_hd__o21ai_0
X$10040 VDD synth_3763 synth_3468 synth_4071 VDD synth_3943 VNB|VSS VNB|VSS
+ sky130_fd_sc_hd__o21ai_0
X$10041 VDD synth_4525 synth_4524 synth_4644 VDD synth_4443 VNB|VSS VNB|VSS
+ sky130_fd_sc_hd__o21ai_0
X$10042 VDD synth_1103 synth_1086 synth_1087 VDD synth_1102 VNB|VSS VNB|VSS
+ sky130_fd_sc_hd__o21ai_0
X$10043 VDD synth_113 synth_97 synth_315 VDD synth_173 VNB|VSS VNB|VSS
+ sky130_fd_sc_hd__o21ai_0
X$10044 VDD synth_3461 synth_3683 synth_3558 VDD synth_3684 VNB|VSS VNB|VSS
+ sky130_fd_sc_hd__o21ai_0
X$10045 VDD synth_1737 synth_1736 synth_1735 VDD synth_1691 VNB|VSS VNB|VSS
+ sky130_fd_sc_hd__o21ai_0
X$10046 VDD synth_8831 synth_9061 synth_9047 VDD synth_9064 VNB|VSS VNB|VSS
+ sky130_fd_sc_hd__o21ai_0
X$10047 VDD synth_4685 synth_927 synth_4854 VDD synth_4853 VNB|VSS VNB|VSS
+ sky130_fd_sc_hd__o21ai_0
X$10048 VDD synth_8830 synth_9029 synth_8900 VDD synth_8791 VNB|VSS VNB|VSS
+ sky130_fd_sc_hd__o21ai_0
X$10049 VDD synth_7155 synth_7111 synth_7207 VDD synth_7294 VNB|VSS VNB|VSS
+ sky130_fd_sc_hd__o21ai_0
X$10050 VDD synth_12050 synth_12300 synth_9427 VDD synth_12349 VNB|VSS VNB|VSS
+ sky130_fd_sc_hd__o21ai_0
X$10051 VDD synth_10919 synth_8746 synth_10958 VDD synth_10959 VNB|VSS VNB|VSS
+ sky130_fd_sc_hd__o21ai_0
X$10052 VDD synth_12672 synth_12603 synth_12602 VDD synth_12695 VNB|VSS VNB|VSS
+ sky130_fd_sc_hd__o21ai_0
X$10053 VDD synth_12093 synth_11973 synth_12146 VDD synth_12092 VNB|VSS VNB|VSS
+ sky130_fd_sc_hd__o21ai_0
X$10054 VDD synth_1652 synth_1828 synth_1591 VDD synth_1829 VNB|VSS VNB|VSS
+ sky130_fd_sc_hd__o21ai_0
X$10055 VDD synth_8549 synth_8759 synth_8550 VDD synth_8687 VNB|VSS VNB|VSS
+ sky130_fd_sc_hd__o21ai_0
X$10056 VDD synth_5362 synth_5396 synth_5365 VDD synth_5366 VNB|VSS VNB|VSS
+ sky130_fd_sc_hd__o21ai_0
X$10057 VDD synth_5024 synth_5088 synth_5033 VDD synth_4963 VNB|VSS VNB|VSS
+ sky130_fd_sc_hd__o21ai_0
X$10058 VDD synth_9507 synth_9386 synth_9736 VDD synth_9694 VNB|VSS VNB|VSS
+ sky130_fd_sc_hd__o21ai_0
X$10059 VDD synth_11504 synth_11600 synth_8806 VDD synth_11716 VNB|VSS VNB|VSS
+ sky130_fd_sc_hd__o21ai_0
X$10060 VDD synth_6236 synth_6597 synth_7109 VDD synth_7025 VNB|VSS VNB|VSS
+ sky130_fd_sc_hd__o21ai_0
X$10061 VDD synth_8690 synth_8709 synth_8840 VDD synth_8691 VNB|VSS VNB|VSS
+ sky130_fd_sc_hd__o21ai_0
X$10062 VDD synth_7820 synth_7691 synth_7776 VDD synth_7889 VNB|VSS VNB|VSS
+ sky130_fd_sc_hd__o21ai_0
X$10063 VDD synth_6436 synth_6435 synth_6359 VDD synth_6357 VNB|VSS VNB|VSS
+ sky130_fd_sc_hd__o21ai_0
X$10064 VDD synth_9119 synth_9923 synth_9696 VDD synth_10103 VNB|VSS VNB|VSS
+ sky130_fd_sc_hd__o21ai_0
X$10065 VDD synth_293 synth_29 synth_168 VDD synth_170 VNB|VSS VNB|VSS
+ sky130_fd_sc_hd__o21ai_0
X$10066 VDD synth_6287 synth_6597 synth_7027 VDD synth_7176 VNB|VSS VNB|VSS
+ sky130_fd_sc_hd__o21ai_0
X$10067 VDD synth_7321 synth_7529 synth_7387 VDD synth_7288 VNB|VSS VNB|VSS
+ sky130_fd_sc_hd__o21ai_0
X$10068 VDD synth_169 synth_304 synth_361 VDD synth_332 VNB|VSS VNB|VSS
+ sky130_fd_sc_hd__o21ai_0
X$10069 VDD synth_7899 synth_8050 synth_8051 VDD synth_8008 VNB|VSS VNB|VSS
+ sky130_fd_sc_hd__o21ai_0
X$10070 VDD synth_3796 synth_3793 synth_3892 VDD synth_4001 VNB|VSS VNB|VSS
+ sky130_fd_sc_hd__o21ai_0
X$10071 VDD synth_8820 synth_8746 synth_8963 VDD synth_8962 VNB|VSS VNB|VSS
+ sky130_fd_sc_hd__o21ai_0
X$10072 VDD synth_7067 synth_7038 synth_7120 VDD synth_6980 VNB|VSS VNB|VSS
+ sky130_fd_sc_hd__o21ai_0
X$10073 VDD synth_55 synth_123 synth_247 VDD synth_186 VNB|VSS VNB|VSS
+ sky130_fd_sc_hd__o21ai_0
X$10074 VDD synth_7904 synth_7783 synth_7784 VDD synth_7766 VNB|VSS VNB|VSS
+ sky130_fd_sc_hd__o21ai_0
X$10075 VDD synth_2462 synth_2437 synth_2549 VDD synth_2493 VNB|VSS VNB|VSS
+ sky130_fd_sc_hd__o21ai_0
X$10076 VDD synth_1287 synth_1281 synth_1321 VDD synth_1364 VNB|VSS VNB|VSS
+ sky130_fd_sc_hd__o21ai_0
X$10077 VDD synth_6264 synth_6249 synth_6314 VDD synth_6179 VNB|VSS VNB|VSS
+ sky130_fd_sc_hd__o21ai_0
X$10078 VDD synth_6063 synth_3544 synth_6184 VDD synth_6183 VNB|VSS VNB|VSS
+ sky130_fd_sc_hd__o21ai_0
X$10079 VDD synth_3747 synth_3544 synth_3784 VDD synth_3688 VNB|VSS VNB|VSS
+ sky130_fd_sc_hd__o21ai_0
X$10080 VDD synth_2952 synth_2953 synth_2954 VDD synth_3039 VNB|VSS VNB|VSS
+ sky130_fd_sc_hd__o21ai_0
X$10081 VDD synth_8679 synth_8462 synth_8543 VDD synth_8545 VNB|VSS VNB|VSS
+ sky130_fd_sc_hd__o21ai_0
X$10082 VDD synth_10652 synth_12016 synth_11935 VDD synth_12091 VNB|VSS VNB|VSS
+ sky130_fd_sc_hd__o21ai_0
X$10083 VDD synth_5878 synth_5691 synth_5919 VDD synth_6010 VNB|VSS VNB|VSS
+ sky130_fd_sc_hd__o21ai_0
X$10084 VDD synth_10578 synth_12096 synth_9514 VDD synth_12216 VNB|VSS VNB|VSS
+ sky130_fd_sc_hd__o21ai_0
X$10085 VDD synth_11295 synth_10164 synth_11341 VDD synth_11409 VNB|VSS VNB|VSS
+ sky130_fd_sc_hd__o21ai_0
X$10086 VDD synth_773 synth_937 synth_857 VDD synth_854 VNB|VSS VNB|VSS
+ sky130_fd_sc_hd__o21ai_0
X$10087 VDD synth_8381 synth_8466 synth_8382 VDD synth_8359 VNB|VSS VNB|VSS
+ sky130_fd_sc_hd__o21ai_0
X$10088 VDD synth_12351 synth_10164 synth_12566 VDD synth_12657 VNB|VSS VNB|VSS
+ sky130_fd_sc_hd__o21ai_0
X$10089 VDD synth_8682 synth_8510 synth_8546 VDD synth_8601 VNB|VSS VNB|VSS
+ sky130_fd_sc_hd__o21ai_0
X$10090 VDD synth_8710 synth_11457 synth_11458 VDD synth_11466 VNB|VSS VNB|VSS
+ sky130_fd_sc_hd__o21ai_0
X$10091 VDD synth_10212 synth_10440 synth_10652 VDD synth_10651 VNB|VSS VNB|VSS
+ sky130_fd_sc_hd__o21ai_0
X$10092 VDD synth_388 synth_194 synth_428 VDD synth_427 VNB|VSS VNB|VSS
+ sky130_fd_sc_hd__o21ai_0
X$10093 VDD synth_1220 synth_1279 synth_1278 VDD synth_1221 VNB|VSS VNB|VSS
+ sky130_fd_sc_hd__o21ai_0
X$10094 VDD synth_2717 synth_2852 synth_2898 VDD synth_2821 VNB|VSS VNB|VSS
+ sky130_fd_sc_hd__o21ai_0
X$10095 VDD synth_8231 synth_7089 synth_8264 VDD synth_8339 VNB|VSS VNB|VSS
+ sky130_fd_sc_hd__o21ai_0
X$10096 VDD synth_9210 synth_8000 synth_9735 VDD synth_9734 VNB|VSS VNB|VSS
+ sky130_fd_sc_hd__o21ai_0
X$10097 VDD synth_2328 synth_1338 synth_2329 VDD synth_2383 VNB|VSS VNB|VSS
+ sky130_fd_sc_hd__o21ai_0
X$10098 VDD synth_6811 synth_6606 synth_6776 VDD synth_6883 VNB|VSS VNB|VSS
+ sky130_fd_sc_hd__o21ai_0
X$10099 VDD synth_11843 synth_11841 synth_11844 VDD synth_11883 VNB|VSS VNB|VSS
+ sky130_fd_sc_hd__o21ai_0
X$10100 VDD synth_8195 synth_8106 synth_8107 VDD synth_8115 VNB|VSS VNB|VSS
+ sky130_fd_sc_hd__o21ai_0
X$10101 VDD synth_773 synth_695 synth_696 VDD synth_663 VNB|VSS VNB|VSS
+ sky130_fd_sc_hd__o21ai_0
X$10102 VDD synth_12017 synth_11984 synth_11986 VDD synth_12129 VNB|VSS VNB|VSS
+ sky130_fd_sc_hd__o21ai_0
X$10103 VDD synth_2959 synth_3120 synth_3001 VDD synth_3131 VNB|VSS VNB|VSS
+ sky130_fd_sc_hd__o21ai_0
X$10104 VDD synth_8873 synth_11785 synth_11752 VDD synth_11784 VNB|VSS VNB|VSS
+ sky130_fd_sc_hd__o21ai_0
X$10105 VDD synth_3508 synth_3239 synth_3403 VDD synth_3334 VNB|VSS VNB|VSS
+ sky130_fd_sc_hd__o21ai_0
X$10106 VDD synth_10312 synth_11636 synth_11634 VDD synth_11508 VNB|VSS VNB|VSS
+ sky130_fd_sc_hd__o21ai_0
X$10107 VDD synth_180 synth_151 synth_441 VDD synth_491 VNB|VSS VNB|VSS
+ sky130_fd_sc_hd__o21ai_0
X$10108 VDD synth_11017 synth_12096 synth_10578 VDD synth_11868 VNB|VSS VNB|VSS
+ sky130_fd_sc_hd__o21ai_0
X$10109 VDD synth_11088 synth_10986 synth_11062 VDD synth_11134 VNB|VSS VNB|VSS
+ sky130_fd_sc_hd__o21ai_0
X$10110 VDD synth_5901 synth_6052 synth_6123 VDD synth_6073 VNB|VSS VNB|VSS
+ sky130_fd_sc_hd__o21ai_0
X$10111 VDD synth_4411 synth_1338 synth_4413 VDD synth_4435 VNB|VSS VNB|VSS
+ sky130_fd_sc_hd__o21ai_0
X$10112 VDD synth_3505 synth_3555 synth_3597 VDD synth_3507 VNB|VSS VNB|VSS
+ sky130_fd_sc_hd__o21ai_0
X$10113 VDD synth_9701 synth_10849 synth_10312 VDD synth_12759 VNB|VSS VNB|VSS
+ sky130_fd_sc_hd__o21ai_0
X$10114 VDD synth_8869 synth_8000 synth_8868 VDD synth_8926 VNB|VSS VNB|VSS
+ sky130_fd_sc_hd__o21ai_0
X$10115 VDD synth_790 synth_666 synth_707 VDD synth_706 VNB|VSS VNB|VSS
+ sky130_fd_sc_hd__o21ai_0
X$10116 VDD synth_11368 synth_11622 synth_11586 VDD synth_11492 VNB|VSS VNB|VSS
+ sky130_fd_sc_hd__o21ai_0
X$10117 VDD synth_2682 synth_66 synth_2831 VDD synth_2760 VNB|VSS VNB|VSS
+ sky130_fd_sc_hd__o21ai_0
X$10118 VDD synth_3831 synth_3940 synth_3830 VDD synth_4032 VNB|VSS VNB|VSS
+ sky130_fd_sc_hd__o21ai_0
X$10119 VDD synth_9900 synth_9047 synth_10698 VDD synth_10699 VNB|VSS VNB|VSS
+ sky130_fd_sc_hd__o21ai_0
X$10120 VDD synth_3767 synth_3834 synth_3902 VDD synth_3932 VNB|VSS VNB|VSS
+ sky130_fd_sc_hd__o21ai_0
X$10121 VDD synth_2286 synth_2352 synth_2554 VDD synth_2593 VNB|VSS VNB|VSS
+ sky130_fd_sc_hd__o21ai_0
X$10122 VDD synth_7261 synth_6597 synth_7333 VDD synth_7464 VNB|VSS VNB|VSS
+ sky130_fd_sc_hd__o21ai_0
X$10123 VDD synth_8763 synth_8709 synth_8782 VDD synth_8611 VNB|VSS VNB|VSS
+ sky130_fd_sc_hd__o21ai_0
X$10124 VDD synth_4193 synth_4246 synth_4243 VDD synth_4281 VNB|VSS VNB|VSS
+ sky130_fd_sc_hd__o21ai_0
X$10125 VDD synth_12684 synth_12456 synth_12608 VDD synth_12680 VNB|VSS VNB|VSS
+ sky130_fd_sc_hd__o21ai_0
X$10126 VDD synth_614 synth_820 synth_902 VDD synth_887 VNB|VSS VNB|VSS
+ sky130_fd_sc_hd__o21ai_0
X$10127 VDD synth_10312 synth_12452 synth_8806 VDD synth_12668 VNB|VSS VNB|VSS
+ sky130_fd_sc_hd__o21ai_0
X$10128 VDD synth_3550 synth_3552 synth_3554 VDD synth_3666 VNB|VSS VNB|VSS
+ sky130_fd_sc_hd__o21ai_0
X$10129 VDD synth_267 synth_204 synth_367 VDD synth_413 VNB|VSS VNB|VSS
+ sky130_fd_sc_hd__o21ai_0
X$10130 VDD synth_3674 synth_3767 synth_3705 VDD synth_3677 VNB|VSS VNB|VSS
+ sky130_fd_sc_hd__o21ai_0
X$10131 VDD synth_2477 synth_2016 synth_2536 VDD synth_2629 VNB|VSS VNB|VSS
+ sky130_fd_sc_hd__o21ai_0
X$10132 VDD synth_2486 synth_2547 synth_2546 VDD synth_2611 VNB|VSS VNB|VSS
+ sky130_fd_sc_hd__o21ai_0
X$10133 VDD synth_11017 synth_9773 synth_10652 VDD synth_12214 VNB|VSS VNB|VSS
+ sky130_fd_sc_hd__o21ai_0
X$10134 VDD synth_190 synth_132 synth_374 VDD synth_480 VNB|VSS VNB|VSS
+ sky130_fd_sc_hd__o21ai_0
X$10135 VDD synth_3297 synth_3555 synth_3556 VDD synth_3296 VNB|VSS VNB|VSS
+ sky130_fd_sc_hd__o21ai_0
X$10136 VDD synth_5147 synth_3632 synth_5148 VDD synth_5250 VNB|VSS VNB|VSS
+ sky130_fd_sc_hd__o21ai_0
X$10137 VDD synth_5632 synth_5732 synth_5733 VDD synth_5697 VNB|VSS VNB|VSS
+ sky130_fd_sc_hd__o21ai_0
X$10138 VDD synth_8946 synth_11463 synth_9112 VDD synth_12237 VNB|VSS VNB|VSS
+ sky130_fd_sc_hd__o21ai_0
X$10139 VDD synth_4328 synth_4100 synth_4249 VDD synth_4506 VNB|VSS VNB|VSS
+ sky130_fd_sc_hd__o21ai_0
X$10140 VDD synth_8870 synth_10795 synth_10793 VDD synth_12467 VNB|VSS VNB|VSS
+ sky130_fd_sc_hd__o21ai_0
X$10141 VDD synth_5170 synth_5514 synth_5372 VDD synth_5443 VNB|VSS VNB|VSS
+ sky130_fd_sc_hd__o21ai_0
X$10142 VDD synth_437 synth_151 synth_438 VDD synth_393 VNB|VSS VNB|VSS
+ sky130_fd_sc_hd__o21ai_0
X$10143 VDD synth_10652 synth_11171 synth_10402 VDD synth_11278 VNB|VSS VNB|VSS
+ sky130_fd_sc_hd__o21ai_0
X$10144 VDD synth_322 synth_347 synth_380 VDD synth_35 VNB|VSS VNB|VSS
+ sky130_fd_sc_hd__o21ai_0
X$10145 VDD synth_9883 synth_9686 synth_9800 VDD synth_9884 VNB|VSS VNB|VSS
+ sky130_fd_sc_hd__o21ai_0
X$10146 VDD synth_922 synth_1031 synth_1003 VDD synth_1085 VNB|VSS VNB|VSS
+ sky130_fd_sc_hd__o21ai_0
X$10147 VDD synth_64 synth_347 synth_349 VDD synth_117 VNB|VSS VNB|VSS
+ sky130_fd_sc_hd__o21ai_0
X$10148 VDD synth_3123 synth_167 synth_3326 VDD synth_3327 VNB|VSS VNB|VSS
+ sky130_fd_sc_hd__o21ai_0
X$10149 VDD synth_7432 synth_7436 synth_7431 VDD synth_7218 VNB|VSS VNB|VSS
+ sky130_fd_sc_hd__o21ai_0
X$10150 VDD synth_1835 synth_1744 synth_1746 VDD synth_1834 VNB|VSS VNB|VSS
+ sky130_fd_sc_hd__o21ai_0
X$10151 VDD synth_6076 synth_6077 synth_6114 VDD synth_6113 VNB|VSS VNB|VSS
+ sky130_fd_sc_hd__o21ai_0
X$10152 VDD synth_7642 synth_6597 synth_7751 VDD synth_7643 VNB|VSS VNB|VSS
+ sky130_fd_sc_hd__o21ai_0
X$10153 VDD synth_11546 synth_11683 synth_11684 VDD synth_11827 VNB|VSS VNB|VSS
+ sky130_fd_sc_hd__o21ai_0
X$10154 VDD synth_8471 synth_8630 synth_8631 VDD synth_8686 VNB|VSS VNB|VSS
+ sky130_fd_sc_hd__o21ai_0
X$10155 VDD synth_3542 synth_3541 synth_3712 VDD synth_3580 VNB|VSS VNB|VSS
+ sky130_fd_sc_hd__o21ai_0
X$10156 VDD synth_5867 synth_5747 synth_5749 VDD synth_5716 VNB|VSS VNB|VSS
+ sky130_fd_sc_hd__o21ai_0
X$10157 VDD synth_6205 synth_5982 synth_6125 VDD synth_6207 VNB|VSS VNB|VSS
+ sky130_fd_sc_hd__o21ai_0
X$10158 VDD synth_8831 synth_9930 synth_9235 VDD synth_9929 VNB|VSS VNB|VSS
+ sky130_fd_sc_hd__o21ai_0
X$10159 VDD synth_6785 synth_6597 synth_6782 VDD synth_6875 VNB|VSS VNB|VSS
+ sky130_fd_sc_hd__o21ai_0
X$10160 VDD synth_5775 synth_5750 synth_5777 VDD synth_5723 VNB|VSS VNB|VSS
+ sky130_fd_sc_hd__o21ai_0
X$10161 VDD synth_3432 synth_3471 synth_3519 VDD synth_3592 VNB|VSS VNB|VSS
+ sky130_fd_sc_hd__o21ai_0
X$10162 VDD synth_12213 synth_12277 synth_12230 VDD synth_12232 VNB|VSS VNB|VSS
+ sky130_fd_sc_hd__o21ai_0
X$10163 VDD synth_8981 synth_9565 synth_9566 VDD synth_9681 VNB|VSS VNB|VSS
+ sky130_fd_sc_hd__o21ai_0
X$10164 VDD synth_2103 synth_659 synth_2222 VDD synth_2183 VNB|VSS VNB|VSS
+ sky130_fd_sc_hd__o21ai_0
X$10165 VDD synth_7901 synth_7926 synth_7978 VDD synth_7927 VNB|VSS VNB|VSS
+ sky130_fd_sc_hd__o21ai_0
X$10166 VDD synth_8245 synth_8167 synth_8303 VDD synth_8304 VNB|VSS VNB|VSS
+ sky130_fd_sc_hd__o21ai_0
X$10167 VDD synth_802 synth_805 synth_806 VDD synth_862 VNB|VSS VNB|VSS
+ sky130_fd_sc_hd__o21ai_0
X$10168 VDD synth_9499 synth_6634 synth_9497 VDD synth_9756 VNB|VSS VNB|VSS
+ sky130_fd_sc_hd__o21ai_0
X$10169 VDD synth_4977 synth_5160 synth_5209 VDD synth_4938 VNB|VSS VNB|VSS
+ sky130_fd_sc_hd__o21ai_0
X$10170 VDD synth_7865 synth_7111 synth_7942 VDD synth_7943 VNB|VSS VNB|VSS
+ sky130_fd_sc_hd__o21ai_0
X$10171 VDD synth_10615 synth_11169 synth_10898 VDD synth_11279 VNB|VSS VNB|VSS
+ sky130_fd_sc_hd__o21ai_0
X$10172 VDD synth_10900 synth_9762 synth_11051 VDD synth_11123 VNB|VSS VNB|VSS
+ sky130_fd_sc_hd__o21ai_0
X$10173 VDD synth_1182 synth_1137 synth_1138 VDD synth_1139 VNB|VSS VNB|VSS
+ sky130_fd_sc_hd__o21ai_0
X$10174 VDD synth_6308 synth_6461 synth_6489 VDD synth_6396 VNB|VSS VNB|VSS
+ sky130_fd_sc_hd__o21ai_0
X$10175 VDD synth_4909 synth_5132 synth_5131 VDD synth_4959 VNB|VSS VNB|VSS
+ sky130_fd_sc_hd__o21ai_0
X$10176 VDD synth_6232 synth_6517 synth_6545 VDD synth_6649 VNB|VSS VNB|VSS
+ sky130_fd_sc_hd__o21ai_0
X$10177 VDD synth_8376 synth_8172 synth_8221 VDD synth_8377 VNB|VSS VNB|VSS
+ sky130_fd_sc_hd__o21ai_0
X$10178 VDD synth_10285 synth_10840 synth_12385 VDD synth_12446 VNB|VSS VNB|VSS
+ sky130_fd_sc_hd__o21ai_0
X$10179 VDD synth_1449 synth_1375 synth_1310 VDD synth_1526 VNB|VSS VNB|VSS
+ sky130_fd_sc_hd__o21ai_0
X$10180 VDD synth_12266 synth_9762 synth_12355 VDD synth_12353 VNB|VSS VNB|VSS
+ sky130_fd_sc_hd__o21ai_0
X$10181 VDD synth_1415 synth_1272 synth_1273 VDD synth_1123 VNB|VSS VNB|VSS
+ sky130_fd_sc_hd__o21ai_0
X$10182 VDD synth_9677 synth_10371 synth_8870 VDD synth_11461 VNB|VSS VNB|VSS
+ sky130_fd_sc_hd__o21ai_0
X$10183 VDD synth_7193 synth_7324 synth_7543 VDD synth_7298 VNB|VSS VNB|VSS
+ sky130_fd_sc_hd__o21ai_0
X$10184 VDD synth_1212 synth_1290 synth_1194 VDD synth_1369 VNB|VSS VNB|VSS
+ sky130_fd_sc_hd__o21ai_0
X$10185 VDD synth_3547 synth_3544 synth_3546 VDD synth_3545 VNB|VSS VNB|VSS
+ sky130_fd_sc_hd__o21ai_0
X$10186 VDD synth_3218 synth_3175 synth_3217 VDD synth_3174 VNB|VSS VNB|VSS
+ sky130_fd_sc_hd__o21ai_0
X$10187 VDD synth_12736 synth_12504 synth_12564 VDD synth_12685 VNB|VSS VNB|VSS
+ sky130_fd_sc_hd__o21ai_0
X$10188 VDD synth_12576 synth_12512 synth_12625 VDD synth_12626 VNB|VSS VNB|VSS
+ sky130_fd_sc_hd__o21ai_0
X$10189 VDD synth_6076 synth_6081 synth_6082 VDD synth_6156 VNB|VSS VNB|VSS
+ sky130_fd_sc_hd__o21ai_0
X$10190 VDD synth_4514 synth_3544 synth_4516 VDD synth_4515 VNB|VSS VNB|VSS
+ sky130_fd_sc_hd__o21ai_0
X$10191 VDD synth_9310 synth_9208 synth_9413 VDD synth_9728 VNB|VSS VNB|VSS
+ sky130_fd_sc_hd__o21ai_0
X$10192 VDD synth_1588 synth_1294 synth_1589 VDD synth_1651 VNB|VSS VNB|VSS
+ sky130_fd_sc_hd__o21ai_0
X$10193 VDD synth_2259 synth_659 synth_2184 VDD synth_2224 VNB|VSS VNB|VSS
+ sky130_fd_sc_hd__o21ai_0
X$10194 VDD synth_1175 synth_1067 synth_1134 VDD synth_1218 VNB|VSS VNB|VSS
+ sky130_fd_sc_hd__o21ai_0
X$10195 VDD synth_7035 synth_7205 synth_7206 VDD synth_7268 VNB|VSS VNB|VSS
+ sky130_fd_sc_hd__o21ai_0
X$10196 VDD synth_12302 synth_12238 synth_10312 VDD synth_12280 VNB|VSS VNB|VSS
+ sky130_fd_sc_hd__o21ai_0
X$10197 VDD synth_2801 synth_2948 synth_2930 VDD synth_2929 VNB|VSS VNB|VSS
+ sky130_fd_sc_hd__o21ai_0
X$10198 VDD synth_5177 synth_927 synth_5178 VDD synth_5176 VNB|VSS VNB|VSS
+ sky130_fd_sc_hd__o21ai_0
X$10199 VDD synth_4503 synth_4524 synth_4573 VDD synth_4502 VNB|VSS VNB|VSS
+ sky130_fd_sc_hd__o21ai_0
X$10200 VDD synth_9901 synth_9765 synth_8738 VDD synth_9847 VNB|VSS VNB|VSS
+ sky130_fd_sc_hd__o21ai_0
X$10201 VDD synth_11237 synth_8237 synth_11235 VDD synth_11448 VNB|VSS VNB|VSS
+ sky130_fd_sc_hd__o21ai_0
X$10202 VDD synth_10652 synth_11017 synth_10697 VDD synth_12528 VNB|VSS VNB|VSS
+ sky130_fd_sc_hd__o21ai_0
X$10203 VDD synth_3228 synth_3108 synth_3278 VDD synth_3171 VNB|VSS VNB|VSS
+ sky130_fd_sc_hd__o21ai_0
X$10204 VDD synth_5779 synth_5805 synth_5948 VDD synth_6193 VNB|VSS VNB|VSS
+ sky130_fd_sc_hd__o21ai_0
X$10205 VDD synth_8226 synth_8471 synth_8610 VDD synth_8472 VNB|VSS VNB|VSS
+ sky130_fd_sc_hd__o21ai_0
X$10206 VDD synth_8198 synth_8307 synth_8234 VDD synth_8150 VNB|VSS VNB|VSS
+ sky130_fd_sc_hd__o21ai_0
X$10207 VDD synth_10212 synth_12241 synth_12387 VDD synth_11903 VNB|VSS VNB|VSS
+ sky130_fd_sc_hd__o21ai_0
X$10208 VDD synth_263 synth_363 synth_264 VDD synth_112 VNB|VSS VNB|VSS
+ sky130_fd_sc_hd__o21ai_0
X$10209 VDD synth_8226 synth_8000 synth_8387 VDD synth_8515 VNB|VSS VNB|VSS
+ sky130_fd_sc_hd__o21ai_0
X$10210 VDD synth_2755 synth_2679 synth_2754 VDD synth_2678 VNB|VSS VNB|VSS
+ sky130_fd_sc_hd__o21ai_0
X$10211 VDD synth_6881 synth_6606 synth_6646 VDD synth_6812 VNB|VSS VNB|VSS
+ sky130_fd_sc_hd__o21ai_0
X$10212 VDD synth_4185 synth_4650 synth_6962 VDD synth_6963 VNB|VSS VNB|VSS
+ sky130_fd_sc_hd__o21ai_0
X$10213 VDD synth_4276 synth_4522 synth_4275 VDD synth_4523 VNB|VSS VNB|VSS
+ sky130_fd_sc_hd__o21ai_0
X$10214 VDD synth_5389 synth_3468 synth_5535 VDD synth_5563 VNB|VSS VNB|VSS
+ sky130_fd_sc_hd__o21ai_0
X$10215 VDD synth_12445 synth_9423 synth_12753 VDD synth_12704 VNB|VSS VNB|VSS
+ sky130_fd_sc_hd__o21ai_0
X$10216 VDD synth_5747 synth_5902 synth_5961 VDD synth_6055 VNB|VSS VNB|VSS
+ sky130_fd_sc_hd__o21ai_0
X$10217 VDD synth_8233 synth_7089 synth_8266 VDD synth_8340 VNB|VSS VNB|VSS
+ sky130_fd_sc_hd__o21ai_0
X$10218 VDD synth_11856 synth_11858 synth_11857 VDD synth_11836 VNB|VSS VNB|VSS
+ sky130_fd_sc_hd__o21ai_0
X$10219 VDD synth_9112 synth_9061 synth_9060 VDD synth_9158 VNB|VSS VNB|VSS
+ sky130_fd_sc_hd__o21ai_0
X$10220 VDD synth_10652 synth_11994 synth_11935 VDD synth_12054 VNB|VSS VNB|VSS
+ sky130_fd_sc_hd__o21ai_0
X$10221 VDD synth_5602 synth_3541 synth_5603 VDD synth_5633 VNB|VSS VNB|VSS
+ sky130_fd_sc_hd__o21ai_0
X$10222 VDD synth_2324 synth_2261 synth_2374 VDD synth_2531 VNB|VSS VNB|VSS
+ sky130_fd_sc_hd__o21ai_0
X$10223 VDD synth_4983 synth_5068 synth_5015 VDD synth_4982 VNB|VSS VNB|VSS
+ sky130_fd_sc_hd__o21ai_0
X$10224 VDD synth_1766 synth_66 synth_1911 VDD synth_1825 VNB|VSS VNB|VSS
+ sky130_fd_sc_hd__o21ai_0
X$10225 VDD synth_11924 synth_9762 synth_11989 VDD synth_12085 VNB|VSS VNB|VSS
+ sky130_fd_sc_hd__o21ai_0
X$10226 VDD synth_4206 synth_927 synth_4208 VDD synth_4207 VNB|VSS VNB|VSS
+ sky130_fd_sc_hd__o21ai_0
X$10227 VDD synth_12063 synth_11915 synth_12004 VDD synth_12064 VNB|VSS VNB|VSS
+ sky130_fd_sc_hd__o21ai_0
X$10228 VDD synth_2544 synth_2588 synth_2657 VDD synth_2846 VNB|VSS VNB|VSS
+ sky130_fd_sc_hd__o21ai_0
X$10229 VDD synth_9235 synth_9626 synth_9119 VDD synth_9744 VNB|VSS VNB|VSS
+ sky130_fd_sc_hd__o21ai_0
X$10230 VDD synth_7088 synth_7089 synth_7013 VDD synth_7135 VNB|VSS VNB|VSS
+ sky130_fd_sc_hd__o21ai_0
X$10231 VDD synth_2949 synth_2948 synth_3008 VDD synth_3007 VNB|VSS VNB|VSS
+ sky130_fd_sc_hd__o21ai_0
X$10232 VDD synth_9329 synth_8915 synth_9330 VDD synth_9115 VNB|VSS VNB|VSS
+ sky130_fd_sc_hd__o21ai_0
X$10233 VDD synth_11486 synth_11472 synth_11474 VDD synth_11616 VNB|VSS VNB|VSS
+ sky130_fd_sc_hd__o21ai_0
X$10234 VDD synth_9112 synth_11228 synth_11227 VDD synth_11229 VNB|VSS VNB|VSS
+ sky130_fd_sc_hd__o21ai_0
X$10235 VDD synth_9699 synth_10371 synth_9292 VDD synth_10989 VNB|VSS VNB|VSS
+ sky130_fd_sc_hd__o21ai_0
X$10236 VDD synth_5752 synth_5750 synth_5751 VDD synth_5722 VNB|VSS VNB|VSS
+ sky130_fd_sc_hd__o21ai_0
X$10237 VDD synth_8738 synth_9902 synth_9847 VDD synth_9903 VNB|VSS VNB|VSS
+ sky130_fd_sc_hd__o21ai_0
X$10238 VDD synth_9302 synth_9539 synth_9303 VDD synth_9217 VNB|VSS VNB|VSS
+ sky130_fd_sc_hd__o21ai_0
X$10239 VDD synth_9294 synth_8746 synth_9295 VDD synth_9446 VNB|VSS VNB|VSS
+ sky130_fd_sc_hd__o21ai_0
X$10240 VDD synth_10705 synth_10625 synth_10681 VDD synth_10753 VNB|VSS VNB|VSS
+ sky130_fd_sc_hd__o21ai_0
X$10241 VDD synth_1739 synth_66 synth_1682 VDD synth_1848 VNB|VSS VNB|VSS
+ sky130_fd_sc_hd__o21ai_0
X$10242 VDD synth_8368 synth_8077 synth_8244 VDD synth_8369 VNB|VSS VNB|VSS
+ sky130_fd_sc_hd__o21ai_0
X$10243 VDD synth_2582 synth_2116 synth_2561 VDD synth_2637 VNB|VSS VNB|VSS
+ sky130_fd_sc_hd__o21ai_0
X$10244 VDD synth_2305 synth_1067 synth_2454 VDD synth_2421 VNB|VSS VNB|VSS
+ sky130_fd_sc_hd__o21ai_0
X$10245 VDD synth_10462 synth_8746 synth_10561 VDD synth_10527 VNB|VSS VNB|VSS
+ sky130_fd_sc_hd__o21ai_0
X$10246 VDD synth_7651 synth_7574 synth_7707 VDD synth_7622 VNB|VSS VNB|VSS
+ sky130_fd_sc_hd__o21ai_0
X$10247 VDD synth_3087 synth_2116 synth_3393 VDD synth_3390 VNB|VSS VNB|VSS
+ sky130_fd_sc_hd__o21ai_0
X$10248 VDD synth_12583 synth_12703 synth_12640 VDD synth_12752 VNB|VSS VNB|VSS
+ sky130_fd_sc_hd__o21ai_0
X$10249 VDD synth_5055 synth_3541 synth_5130 VDD synth_5285 VNB|VSS VNB|VSS
+ sky130_fd_sc_hd__o21ai_0
X$10250 VDD synth_903 synth_904 synth_981 VDD synth_982 VNB|VSS VNB|VSS
+ sky130_fd_sc_hd__o21ai_0
X$10251 VDD synth_1841 synth_1712 synth_1713 VDD synth_1842 VNB|VSS VNB|VSS
+ sky130_fd_sc_hd__o21ai_0
X$10252 VDD synth_10793 synth_9738 synth_11220 VDD synth_11291 VNB|VSS VNB|VSS
+ sky130_fd_sc_hd__o21ai_0
X$10253 VDD synth_7621 synth_7648 synth_7727 VDD synth_7573 VNB|VSS VNB|VSS
+ sky130_fd_sc_hd__o21ai_0
X$10254 VDD synth_3243 synth_3328 synth_3244 VDD synth_3200 VNB|VSS VNB|VSS
+ sky130_fd_sc_hd__o21ai_0
X$10255 VDD synth_7581 synth_7658 synth_7659 VDD synth_7657 VNB|VSS VNB|VSS
+ sky130_fd_sc_hd__o21ai_0
X$10256 VDD synth_4370 synth_4369 synth_4368 VDD synth_4495 VNB|VSS VNB|VSS
+ sky130_fd_sc_hd__o21ai_0
X$10257 VDD synth_7762 synth_7648 synth_7726 VDD synth_7619 VNB|VSS VNB|VSS
+ sky130_fd_sc_hd__o21ai_0
X$10258 VDD synth_1714 synth_1633 synth_1618 VDD synth_1716 VNB|VSS VNB|VSS
+ sky130_fd_sc_hd__o21ai_0
X$10259 VDD synth_9142 synth_9098 synth_9166 VDD synth_9307 VNB|VSS VNB|VSS
+ sky130_fd_sc_hd__o21ai_0
X$10260 VDD synth_9675 synth_9555 synth_9112 VDD synth_9627 VNB|VSS VNB|VSS
+ sky130_fd_sc_hd__o21ai_0
X$10261 VDD synth_6457 synth_6825 synth_6754 VDD synth_6864 VNB|VSS VNB|VSS
+ sky130_fd_sc_hd__o21ai_0
X$10262 VDD synth_8965 synth_8883 synth_8810 VDD synth_8964 VNB|VSS VNB|VSS
+ sky130_fd_sc_hd__o21ai_0
X$10263 VDD synth_6011 synth_5760 synth_5832 VDD synth_6012 VNB|VSS VNB|VSS
+ sky130_fd_sc_hd__o21ai_0
X$10264 VDD synth_554 synth_194 synth_555 VDD synth_532 VNB|VSS VNB|VSS
+ sky130_fd_sc_hd__o21ai_0
X$10265 VDD synth_59 synth_60 synth_93 VDD synth_195 VNB|VSS VNB|VSS
+ sky130_fd_sc_hd__o21ai_0
X$10266 VDD synth_2482 synth_1353 synth_2344 VDD synth_2428 VNB|VSS VNB|VSS
+ sky130_fd_sc_hd__o21ai_0
X$10267 VDD synth_4298 synth_4378 synth_4466 VDD synth_4300 VNB|VSS VNB|VSS
+ sky130_fd_sc_hd__o21ai_0
X$10268 VDD synth_10726 synth_12410 synth_9387 VDD synth_12553 VNB|VSS VNB|VSS
+ sky130_fd_sc_hd__o21ai_0
X$10269 VDD synth_7372 synth_7324 synth_7325 VDD synth_7462 VNB|VSS VNB|VSS
+ sky130_fd_sc_hd__o21ai_0
X$10270 VDD synth_7384 synth_7251 synth_7351 VDD synth_7439 VNB|VSS VNB|VSS
+ sky130_fd_sc_hd__o21ai_0
X$10271 VDD synth_1645 synth_1605 synth_1846 VDD synth_1974 VNB|VSS VNB|VSS
+ sky130_fd_sc_hd__o21ai_0
X$10272 VDD synth_4236 synth_4362 synth_4412 VDD synth_4507 VNB|VSS VNB|VSS
+ sky130_fd_sc_hd__o21ai_0
X$10273 VDD synth_10285 synth_11164 synth_9931 VDD synth_12527 VNB|VSS VNB|VSS
+ sky130_fd_sc_hd__o21ai_0
X$10274 VDD synth_11740 synth_11742 synth_11743 VDD synth_11720 VNB|VSS VNB|VSS
+ sky130_fd_sc_hd__o21ai_0
X$10275 VDD synth_12466 synth_12523 synth_12464 VDD synth_12465 VNB|VSS VNB|VSS
+ sky130_fd_sc_hd__o21ai_0
X$10276 VDD synth_1875 synth_2032 synth_1999 VDD synth_2230 VNB|VSS VNB|VSS
+ sky130_fd_sc_hd__o21ai_0
X$10277 VDD synth_4362 synth_3468 synth_4364 VDD synth_4508 VNB|VSS VNB|VSS
+ sky130_fd_sc_hd__o21ai_0
X$10278 VDD synth_3949 synth_3899 synth_3900 VDD synth_3901 VNB|VSS VNB|VSS
+ sky130_fd_sc_hd__o21ai_0
X$10279 VDD synth_5521 synth_5621 synth_5702 VDD synth_5446 VNB|VSS VNB|VSS
+ sky130_fd_sc_hd__o21ai_0
X$10280 VDD synth_8053 synth_8164 synth_8240 VDD synth_8518 VNB|VSS VNB|VSS
+ sky130_fd_sc_hd__o21ai_0
X$10281 VDD synth_104 synth_67 synth_306 VDD synth_27 VNB|VSS VNB|VSS
+ sky130_fd_sc_hd__o21ai_0
X$10282 VDD synth_2331 synth_2332 synth_2389 VDD synth_2623 VNB|VSS VNB|VSS
+ sky130_fd_sc_hd__o21ai_0
X$10283 VDD synth_2652 synth_2116 synth_2653 VDD synth_2775 VNB|VSS VNB|VSS
+ sky130_fd_sc_hd__o21ai_0
X$10284 VDD synth_4829 synth_4873 synth_4828 VDD synth_4778 VNB|VSS VNB|VSS
+ sky130_fd_sc_hd__o21ai_0
X$10285 VDD synth_10011 synth_12239 synth_9042 VDD synth_12644 VNB|VSS VNB|VSS
+ sky130_fd_sc_hd__o21ai_0
X$10286 VDD synth_7020 synth_6597 synth_7021 VDD synth_7165 VNB|VSS VNB|VSS
+ sky130_fd_sc_hd__o21ai_0
X$10287 VDD synth_9629 synth_12598 synth_12553 VDD synth_12643 VNB|VSS VNB|VSS
+ sky130_fd_sc_hd__o21ai_0
X$10288 VDD synth_10376 synth_9850 synth_10170 VDD synth_11098 VNB|VSS VNB|VSS
+ sky130_fd_sc_hd__o21ai_0
X$10289 VDD synth_9036 synth_9430 synth_9240 VDD synth_9327 VNB|VSS VNB|VSS
+ sky130_fd_sc_hd__o21ai_0
X$10290 VDD synth_5416 synth_5252 synth_5543 VDD synth_5610 VNB|VSS VNB|VSS
+ sky130_fd_sc_hd__o21ai_0
X$10291 VDD synth_5900 synth_6823 synth_6752 VDD synth_6999 VNB|VSS VNB|VSS
+ sky130_fd_sc_hd__o21ai_0
X$10292 VDD synth_945 synth_802 synth_804 VDD synth_861 VNB|VSS VNB|VSS
+ sky130_fd_sc_hd__o21ai_0
X$10293 VDD synth_2809 synth_167 synth_2810 VDD synth_2900 VNB|VSS VNB|VSS
+ sky130_fd_sc_hd__o21ai_0
X$10294 VDD synth_10578 synth_9926 synth_10212 VDD synth_12346 VNB|VSS VNB|VSS
+ sky130_fd_sc_hd__o21ai_0
X$10295 VDD synth_9738 synth_9907 synth_9232 VDD synth_9834 VNB|VSS VNB|VSS
+ sky130_fd_sc_hd__o21ai_0
X$10296 VDD synth_10500 synth_10164 synth_10501 VDD synth_10601 VNB|VSS VNB|VSS
+ sky130_fd_sc_hd__o21ai_0
X$10297 VDD synth_10578 synth_9700 synth_10728 VDD synth_10942 VNB|VSS VNB|VSS
+ sky130_fd_sc_hd__o21ai_0
X$10298 VDD synth_1975 synth_1891 synth_1994 VDD synth_2151 VNB|VSS VNB|VSS
+ sky130_fd_sc_hd__o21ai_0
X$10299 VDD synth_421 synth_495 synth_423 VDD synth_385 VNB|VSS VNB|VSS
+ sky130_fd_sc_hd__o21ai_0
X$10300 VDD synth_319 synth_351 synth_412 VDD synth_115 VNB|VSS VNB|VSS
+ sky130_fd_sc_hd__o21ai_0
X$10301 VDD synth_4420 synth_4656 synth_4354 VDD synth_4801 VNB|VSS VNB|VSS
+ sky130_fd_sc_hd__o21ai_0
X$10302 VDD synth_1582 synth_1712 synth_1914 VDD synth_2085 VNB|VSS VNB|VSS
+ sky130_fd_sc_hd__o21ai_0
X$10303 VDD synth_8760 synth_8759 synth_8743 VDD synth_8629 VNB|VSS VNB|VSS
+ sky130_fd_sc_hd__o21ai_0
X$10304 VDD synth_94 synth_278 synth_277 VDD synth_255 VNB|VSS VNB|VSS
+ sky130_fd_sc_hd__o21ai_0
X$10305 VDD synth_7011 synth_7216 synth_6886 VDD synth_7136 VNB|VSS VNB|VSS
+ sky130_fd_sc_hd__o21ai_0
X$10306 VDD synth_9747 synth_9836 synth_9748 VDD synth_9876 VNB|VSS VNB|VSS
+ sky130_fd_sc_hd__o21ai_0
X$10307 VDD synth_769 synth_686 synth_687 VDD synth_630 VNB|VSS VNB|VSS
+ sky130_fd_sc_hd__o21ai_0
X$10308 VDD synth_7664 synth_7586 synth_7663 VDD synth_7665 VNB|VSS VNB|VSS
+ sky130_fd_sc_hd__o21ai_0
X$10309 VDD synth_7174 synth_7183 synth_7375 VDD synth_7470 VNB|VSS VNB|VSS
+ sky130_fd_sc_hd__o21ai_0
X$10310 VDD synth_11947 synth_11980 synth_11978 VDD synth_11945 VNB|VSS VNB|VSS
+ sky130_fd_sc_hd__o21ai_0
X$10311 VDD synth_7926 synth_8000 synth_8059 VDD synth_7925 VNB|VSS VNB|VSS
+ sky130_fd_sc_hd__o21ai_0
X$10312 VDD synth_4589 synth_4519 synth_4520 VDD synth_4590 VNB|VSS VNB|VSS
+ sky130_fd_sc_hd__o21ai_0
X$10313 VDD synth_8579 synth_8530 synth_8531 VDD synth_8534 VNB|VSS VNB|VSS
+ sky130_fd_sc_hd__o21ai_0
X$10314 VDD synth_6508 synth_6411 synth_6364 VDD synth_6412 VNB|VSS VNB|VSS
+ sky130_fd_sc_hd__o21ai_0
X$10315 VDD synth_9004 synth_8000 synth_9106 VDD synth_9157 VNB|VSS VNB|VSS
+ sky130_fd_sc_hd__o21ai_0
X$10316 VDD synth_9918 synth_9972 synth_9919 VDD synth_9973 VNB|VSS VNB|VSS
+ sky130_fd_sc_hd__o21ai_0
X$10317 VDD synth_1560 synth_1352 synth_1483 VDD synth_1558 VNB|VSS VNB|VSS
+ sky130_fd_sc_hd__o21ai_0
X$10318 VDD synth_6756 synth_4961 synth_6762 VDD synth_6827 VNB|VSS VNB|VSS
+ sky130_fd_sc_hd__o21ai_0
X$10319 VDD synth_5117 synth_2116 synth_5237 VDD synth_5313 VNB|VSS VNB|VSS
+ sky130_fd_sc_hd__o21ai_0
X$10320 VDD synth_12718 synth_12512 synth_12486 VDD synth_12696 VNB|VSS VNB|VSS
+ sky130_fd_sc_hd__o21ai_0
X$10321 VDD synth_9484 synth_9486 synth_9485 VDD synth_9598 VNB|VSS VNB|VSS
+ sky130_fd_sc_hd__o21ai_0
X$10322 VDD synth_1309 synth_1454 synth_1548 VDD synth_1394 VNB|VSS VNB|VSS
+ sky130_fd_sc_hd__o21ai_0
X$10323 VDD synth_10990 synth_11141 synth_11140 VDD synth_11108 VNB|VSS VNB|VSS
+ sky130_fd_sc_hd__o21ai_0
X$10324 VDD synth_10840 synth_9901 synth_9292 VDD synth_11092 VNB|VSS VNB|VSS
+ sky130_fd_sc_hd__o21ai_0
X$10325 VDD synth_7975 synth_7183 synth_7923 VDD synth_7996 VNB|VSS VNB|VSS
+ sky130_fd_sc_hd__o21ai_0
X$10326 VDD synth_3887 synth_4010 synth_3922 VDD synth_4134 VNB|VSS VNB|VSS
+ sky130_fd_sc_hd__o21ai_0
X$10327 VDD synth_7922 synth_7924 synth_7833 VDD synth_7997 VNB|VSS VNB|VSS
+ sky130_fd_sc_hd__o21ai_0
X$10328 VDD synth_6329 synth_6108 synth_6244 VDD synth_6328 VNB|VSS VNB|VSS
+ sky130_fd_sc_hd__o21ai_0
X$10329 VDD synth_16 synth_149 synth_150 VDD synth_41 VNB|VSS VNB|VSS
+ sky130_fd_sc_hd__o21ai_0
X$10330 VDD synth_6696 synth_6693 synth_6471 VDD synth_6833 VNB|VSS VNB|VSS
+ sky130_fd_sc_hd__o21ai_0
X$10331 VDD synth_9112 synth_11900 synth_10728 VDD synth_11871 VNB|VSS VNB|VSS
+ sky130_fd_sc_hd__o21ai_0
X$10332 VDD synth_9699 synth_11091 synth_9292 VDD synth_11007 VNB|VSS VNB|VSS
+ sky130_fd_sc_hd__o21ai_0
X$10333 VDD synth_2633 synth_2271 synth_2525 VDD synth_2634 VNB|VSS VNB|VSS
+ sky130_fd_sc_hd__o21ai_0
X$10334 VDD synth_8870 synth_10159 synth_11139 VDD synth_11009 VNB|VSS VNB|VSS
+ sky130_fd_sc_hd__o21ai_0
X$10335 VDD synth_11153 synth_11077 synth_11154 VDD synth_11280 VNB|VSS VNB|VSS
+ sky130_fd_sc_hd__o21ai_0
X$10336 VDD synth_8764 synth_10169 synth_10093 VDD synth_9902 VNB|VSS VNB|VSS
+ sky130_fd_sc_hd__o21ai_0
X$10337 VDD synth_2050 synth_2049 synth_2051 VDD synth_2256 VNB|VSS VNB|VSS
+ sky130_fd_sc_hd__o21ai_0
X$10338 VDD synth_5552 synth_5634 synth_5636 VDD synth_5604 VNB|VSS VNB|VSS
+ sky130_fd_sc_hd__o21ai_0
X$10339 VDD synth_12211 synth_9423 synth_12298 VDD synth_12341 VNB|VSS VNB|VSS
+ sky130_fd_sc_hd__o21ai_0
X$10340 VDD synth_11155 synth_11077 synth_11202 VDD synth_11203 VNB|VSS VNB|VSS
+ sky130_fd_sc_hd__o21ai_0
X$10341 VDD synth_3574 synth_3476 synth_3583 VDD synth_3573 VNB|VSS VNB|VSS
+ sky130_fd_sc_hd__o21ai_0
X$10342 VDD synth_4871 synth_5083 synth_5096 VDD synth_4969 VNB|VSS VNB|VSS
+ sky130_fd_sc_hd__o21ai_0
X$10343 VDD synth_5944 synth_6066 synth_6109 VDD synth_5942 VNB|VSS VNB|VSS
+ sky130_fd_sc_hd__o21ai_0
X$10344 VDD synth_3324 synth_3161 synth_3223 VDD synth_3056 VNB|VSS VNB|VSS
+ sky130_fd_sc_hd__o21ai_0
X$10345 VDD synth_9085 synth_8931 synth_9084 VDD synth_9138 VNB|VSS VNB|VSS
+ sky130_fd_sc_hd__o21ai_0
X$10346 VDD synth_6431 synth_6433 synth_6592 VDD synth_6593 VNB|VSS VNB|VSS
+ sky130_fd_sc_hd__o21ai_0
X$10347 VDD synth_91 synth_132 synth_56 VDD synth_189 VNB|VSS VNB|VSS
+ sky130_fd_sc_hd__o21ai_0
X$10348 VDD synth_10985 synth_10999 synth_11000 VDD synth_10983 VNB|VSS VNB|VSS
+ sky130_fd_sc_hd__o21ai_0
X$10349 VDD synth_5573 synth_5623 synth_5625 VDD synth_5694 VNB|VSS VNB|VSS
+ sky130_fd_sc_hd__o21ai_0
X$10350 VDD synth_2908 synth_2829 synth_2985 VDD synth_3064 VNB|VSS VNB|VSS
+ sky130_fd_sc_hd__o21ai_0
X$10351 VDD synth_827 synth_869 synth_828 VDD synth_960 VNB|VSS VNB|VSS
+ sky130_fd_sc_hd__o21ai_0
X$10352 VDD synth_1645 synth_1739 synth_1778 VDD synth_1819 VNB|VSS VNB|VSS
+ sky130_fd_sc_hd__o21ai_0
X$10353 VDD synth_3399 synth_3274 synth_3400 VDD synth_3398 VNB|VSS VNB|VSS
+ sky130_fd_sc_hd__o21ai_0
X$10354 VDD synth_10007 synth_9923 synth_9063 VDD synth_10213 VNB|VSS VNB|VSS
+ sky130_fd_sc_hd__o21ai_0
X$10355 VDD synth_1722 synth_1723 synth_1724 VDD synth_1726 VNB|VSS VNB|VSS
+ sky130_fd_sc_hd__o21ai_0
X$10356 VDD synth_7036 synth_7035 synth_7154 VDD synth_7075 VNB|VSS VNB|VSS
+ sky130_fd_sc_hd__o21ai_0
X$10357 VDD synth_3161 synth_3224 synth_3286 VDD synth_3163 VNB|VSS VNB|VSS
+ sky130_fd_sc_hd__o21ai_0
X$10358 VDD synth_12692 synth_12506 synth_12545 VDD synth_12768 VNB|VSS VNB|VSS
+ sky130_fd_sc_hd__o21ai_0
X$10359 VDD synth_8414 synth_8557 synth_8558 VDD synth_8593 VNB|VSS VNB|VSS
+ sky130_fd_sc_hd__o21ai_0
X$10360 VDD synth_7118 synth_7035 synth_7077 VDD synth_6997 VNB|VSS VNB|VSS
+ sky130_fd_sc_hd__o21ai_0
X$10361 VDD synth_12388 synth_12360 synth_9112 VDD synth_12387 VNB|VSS VNB|VSS
+ sky130_fd_sc_hd__o21ai_0
X$10362 VDD synth_4773 synth_4580 synth_4693 VDD synth_4774 VNB|VSS VNB|VSS
+ sky130_fd_sc_hd__o21ai_0
X$10363 VDD synth_9171 synth_9423 synth_9763 VDD synth_9846 VNB|VSS VNB|VSS
+ sky130_fd_sc_hd__o21ai_0
X$10364 VDD synth_684 synth_765 synth_859 VDD synth_860 VNB|VSS VNB|VSS
+ sky130_fd_sc_hd__o21ai_0
X$10365 VDD synth_12402 synth_12296 synth_12389 VDD synth_12442 VNB|VSS VNB|VSS
+ sky130_fd_sc_hd__o21ai_0
X$10366 VDD synth_8485 synth_8403 synth_8189 VDD synth_8190 VNB|VSS VNB|VSS
+ sky130_fd_sc_hd__o21ai_0
X$10367 VDD synth_9220 synth_9308 synth_9375 VDD synth_9468 VNB|VSS VNB|VSS
+ sky130_fd_sc_hd__o21ai_0
X$10368 VDD synth_8910 synth_9512 synth_10061 VDD synth_9511 VNB|VSS VNB|VSS
+ sky130_fd_sc_hd__o21ai_0
X$10369 VDD synth_8053 synth_8218 synth_8164 VDD synth_8075 VNB|VSS VNB|VSS
+ sky130_fd_sc_hd__o21ai_0
X$10370 VDD synth_6989 synth_7009 synth_7050 VDD synth_7130 VNB|VSS VNB|VSS
+ sky130_fd_sc_hd__o21ai_0
X$10371 VDD synth_10113 synth_10119 synth_10115 VDD synth_8769 VNB|VSS VNB|VSS
+ sky130_fd_sc_hd__o21ai_0
X$10372 VDD synth_8764 synth_9924 synth_9925 VDD synth_9835 VNB|VSS VNB|VSS
+ sky130_fd_sc_hd__o21ai_0
X$10373 VDD synth_12143 synth_9423 synth_12585 VDD synth_12664 VNB|VSS VNB|VSS
+ sky130_fd_sc_hd__o21ai_0
X$10374 VDD synth_1200 synth_1297 synth_1298 VDD synth_1202 VNB|VSS VNB|VSS
+ sky130_fd_sc_hd__o21ai_0
X$10375 VDD synth_6220 synth_6097 synth_6483 VDD synth_6262 VNB|VSS VNB|VSS
+ sky130_fd_sc_hd__o21ai_0
X$10376 VDD synth_6398 synth_6217 synth_6257 VDD synth_6218 VNB|VSS VNB|VSS
+ sky130_fd_sc_hd__o21ai_0
X$10377 VDD synth_1796 synth_1633 synth_1715 VDD synth_1776 VNB|VSS VNB|VSS
+ sky130_fd_sc_hd__o21ai_0
X$10378 VDD synth_7086 synth_7009 synth_7129 VDD synth_7051 VNB|VSS VNB|VSS
+ sky130_fd_sc_hd__o21ai_0
X$10379 VDD synth_4290 synth_4374 synth_4398 VDD synth_4606 VNB|VSS VNB|VSS
+ sky130_fd_sc_hd__o21ai_0
X$10380 VDD synth_7369 synth_7183 synth_7919 VDD synth_8215 VNB|VSS VNB|VSS
+ sky130_fd_sc_hd__o21ai_0
X$10381 VDD synth_10064 synth_10223 synth_10114 VDD synth_10065 VNB|VSS VNB|VSS
+ sky130_fd_sc_hd__o21ai_0
X$10382 VDD synth_8328 synth_8422 synth_8421 VDD synth_8395 VNB|VSS VNB|VSS
+ sky130_fd_sc_hd__o21ai_0
X$10383 VDD synth_11085 synth_11129 synth_11160 VDD synth_11161 VNB|VSS VNB|VSS
+ sky130_fd_sc_hd__o21ai_0
X$10384 VDD synth_7667 synth_7801 synth_7752 VDD synth_7887 VNB|VSS VNB|VSS
+ sky130_fd_sc_hd__o21ai_0
X$10385 VDD synth_2429 synth_2731 synth_2658 VDD synth_2770 VNB|VSS VNB|VSS
+ sky130_fd_sc_hd__o21ai_0
X$10386 VDD synth_9913 synth_9914 synth_9991 VDD synth_9959 VNB|VSS VNB|VSS
+ sky130_fd_sc_hd__o21ai_0
X$10387 VDD synth_8049 synth_7916 synth_7917 VDD synth_7824 VNB|VSS VNB|VSS
+ sky130_fd_sc_hd__o21ai_0
X$10388 VDD synth_5830 synth_5760 synth_5763 VDD synth_6171 VNB|VSS VNB|VSS
+ sky130_fd_sc_hd__o21ai_0
X$10389 VDD synth_8910 synth_9926 synth_9292 VDD synth_9925 VNB|VSS VNB|VSS
+ sky130_fd_sc_hd__o21ai_0
X$10390 VDD synth_3894 synth_3822 synth_3757 VDD synth_3893 VNB|VSS VNB|VSS
+ sky130_fd_sc_hd__o21ai_0
X$10391 VDD synth_3065 synth_2829 synth_3138 VDD synth_2984 VNB|VSS VNB|VSS
+ sky130_fd_sc_hd__o21ai_0
X$10392 VDD synth_12492 synth_12296 synth_12337 VDD synth_12554 VNB|VSS VNB|VSS
+ sky130_fd_sc_hd__o21ai_0
X$10393 VDD synth_12715 synth_12506 synth_12543 VDD synth_12713 VNB|VSS VNB|VSS
+ sky130_fd_sc_hd__o21ai_0
X$10394 VDD synth_12226 synth_12224 synth_12273 VDD synth_12204 VNB|VSS VNB|VSS
+ sky130_fd_sc_hd__o21ai_0
X$10395 VDD synth_2120 synth_2049 synth_2048 VDD synth_2119 VNB|VSS VNB|VSS
+ sky130_fd_sc_hd__o21ai_0
X$10396 VDD synth_8987 synth_9105 synth_8870 VDD synth_8832 VNB|VSS VNB|VSS
+ sky130_fd_sc_hd__o21ai_0
X$10397 VDD synth_7698 synth_7572 synth_7699 VDD synth_7725 VNB|VSS VNB|VSS
+ sky130_fd_sc_hd__o21ai_0
X$10398 VDD synth_5406 synth_5704 synth_5607 VDD synth_5456 VNB|VSS VNB|VSS
+ sky130_fd_sc_hd__o21ai_0
X$10399 VDD synth_4536 synth_4602 synth_4553 VDD synth_4451 VNB|VSS VNB|VSS
+ sky130_fd_sc_hd__o21ai_0
X$10400 VDD synth_8072 synth_7183 synth_8073 VDD synth_8133 VNB|VSS VNB|VSS
+ sky130_fd_sc_hd__o21ai_0
X$10401 VDD synth_11772 synth_11707 synth_11738 VDD synth_11709 VNB|VSS VNB|VSS
+ sky130_fd_sc_hd__o21ai_0
X$10402 VDD synth_1418 synth_1496 synth_1596 VDD synth_1536 VNB|VSS VNB|VSS
+ sky130_fd_sc_hd__o21ai_0
X$10403 VDD synth_486 synth_151 synth_569 VDD synth_648 VNB|VSS VNB|VSS
+ sky130_fd_sc_hd__o21ai_0
X$10404 VDD synth_5164 synth_4747 synth_5198 VDD synth_5306 VNB|VSS VNB|VSS
+ sky130_fd_sc_hd__o21ai_0
X$10405 VDD synth_7572 synth_7778 synth_7647 VDD synth_7646 VNB|VSS VNB|VSS
+ sky130_fd_sc_hd__o21ai_0
X$10406 VDD synth_4164 synth_2089 synth_2059 VDD synth_4713 VNB|VSS VNB|VSS
+ sky130_fd_sc_hd__o21ai_0
X$10407 VDD synth_9914 synth_10074 synth_10075 VDD synth_10204 VNB|VSS VNB|VSS
+ sky130_fd_sc_hd__o21ai_0
X$10408 VDD synth_3359 synth_3360 synth_3361 VDD synth_3486 VNB|VSS VNB|VSS
+ sky130_fd_sc_hd__o21ai_0
X$10409 VDD synth_6341 synth_6143 synth_6229 VDD synth_6342 VNB|VSS VNB|VSS
+ sky130_fd_sc_hd__o21ai_0
X$10410 VDD synth_2835 synth_2994 synth_3103 VDD synth_3212 VNB|VSS VNB|VSS
+ sky130_fd_sc_hd__o21ai_0
X$10411 VDD synth_7187 synth_7322 synth_7367 VDD synth_7453 VNB|VSS VNB|VSS
+ sky130_fd_sc_hd__o21ai_0
X$10412 VDD synth_12473 synth_12419 synth_12368 VDD synth_12481 VNB|VSS VNB|VSS
+ sky130_fd_sc_hd__o21ai_0
X$10413 VDD synth_12440 synth_12459 synth_12458 VDD synth_12438 VNB|VSS VNB|VSS
+ sky130_fd_sc_hd__o21ai_0
X$10414 VDD synth_9050 synth_8958 synth_9079 VDD synth_9131 VNB|VSS VNB|VSS
+ sky130_fd_sc_hd__o21ai_0
X$10415 VDD synth_4245 synth_4020 synth_4356 VDD synth_4440 VNB|VSS VNB|VSS
+ sky130_fd_sc_hd__o21ai_0
X$10416 VDD synth_2608 synth_2679 synth_2880 VDD synth_2609 VNB|VSS VNB|VSS
+ sky130_fd_sc_hd__o21ai_0
X$10417 VDD synth_4075 synth_4157 synth_4241 VDD synth_3959 VNB|VSS VNB|VSS
+ sky130_fd_sc_hd__o21ai_0
X$10418 VDD synth_9878 synth_8746 synth_9749 VDD synth_9880 VNB|VSS VNB|VSS
+ sky130_fd_sc_hd__o21ai_0
X$10419 VDD synth_2210 synth_2209 synth_2238 VDD synth_2130 VNB|VSS VNB|VSS
+ sky130_fd_sc_hd__o21ai_0
X$10420 VDD synth_3450 synth_3360 synth_3540 VDD synth_3487 VNB|VSS VNB|VSS
+ sky130_fd_sc_hd__o21ai_0
X$10421 VDD synth_7854 synth_7572 synth_7697 VDD synth_7695 VNB|VSS VNB|VSS
+ sky130_fd_sc_hd__o21ai_0
X$10422 VDD synth_6153 synth_6238 synth_6239 VDD synth_6298 VNB|VSS VNB|VSS
+ sky130_fd_sc_hd__o21ai_0
X$10423 VDD synth_6385 synth_4961 synth_6394 VDD synth_6477 VNB|VSS VNB|VSS
+ sky130_fd_sc_hd__o21ai_0
X$10424 VDD synth_10795 synth_10778 synth_10170 VDD synth_9007 VNB|VSS VNB|VSS
+ sky130_fd_sc_hd__o21ai_0
X$10425 VDD synth_10578 synth_9239 synth_9559 VDD synth_11677 VNB|VSS VNB|VSS
+ sky130_fd_sc_hd__o21ai_0
X$10426 VDD synth_73 synth_263 synth_464 VDD synth_32 VNB|VSS VNB|VSS
+ sky130_fd_sc_hd__o21ai_0
X$10427 VDD synth_7227 synth_7187 synth_7097 VDD synth_7156 VNB|VSS VNB|VSS
+ sky130_fd_sc_hd__o21ai_0
X$10428 VDD synth_11928 synth_12526 synth_10003 VDD synth_12711 VNB|VSS VNB|VSS
+ sky130_fd_sc_hd__o21ai_0
X$10429 VDD synth_252 synth_194 synth_273 VDD synth_92 VNB|VSS VNB|VSS
+ sky130_fd_sc_hd__o21ai_0
X$10430 VDD synth_10773 synth_12468 synth_10578 VDD synth_12406 VNB|VSS VNB|VSS
+ sky130_fd_sc_hd__o21ai_0
X$10431 VDD synth_10056 synth_9921 synth_10053 VDD synth_10054 VNB|VSS VNB|VSS
+ sky130_fd_sc_hd__o21ai_0
X$10432 VDD synth_10466 synth_10462 synth_10496 VDD synth_10746 VNB|VSS VNB|VSS
+ sky130_fd_sc_hd__o21ai_0
X$10433 VDD synth_3015 synth_3468 synth_3396 VDD synth_3344 VNB|VSS VNB|VSS
+ sky130_fd_sc_hd__o21ai_0
X$10434 VDD synth_3241 synth_3239 synth_3314 VDD synth_3268 VNB|VSS VNB|VSS
+ sky130_fd_sc_hd__o21ai_0
X$10435 VDD synth_3074 synth_2876 synth_2963 VDD synth_3179 VNB|VSS VNB|VSS
+ sky130_fd_sc_hd__o21ai_0
X$10436 VDD synth_9434 synth_10290 synth_10361 VDD synth_10363 VNB|VSS VNB|VSS
+ sky130_fd_sc_hd__o21ai_0
X$10437 VDD synth_6696 synth_7047 synth_6471 VDD synth_7125 VNB|VSS VNB|VSS
+ sky130_fd_sc_hd__o21ai_0
X$10438 VDD synth_5135 synth_3632 synth_5137 VDD synth_5297 VNB|VSS VNB|VSS
+ sky130_fd_sc_hd__o21ai_0
X$10439 VDD synth_9387 synth_10797 synth_9322 VDD synth_11386 VNB|VSS VNB|VSS
+ sky130_fd_sc_hd__o21ai_0
X$10440 VDD synth_9119 synth_9850 synth_9233 VDD synth_10237 VNB|VSS VNB|VSS
+ sky130_fd_sc_hd__o21ai_0
X$10441 VDD synth_131 synth_60 synth_323 VDD synth_49 VNB|VSS VNB|VSS
+ sky130_fd_sc_hd__o21ai_0
X$10442 VDD synth_10039 synth_9914 synth_10136 VDD synth_9888 VNB|VSS VNB|VSS
+ sky130_fd_sc_hd__o21ai_0
X$10443 VDD synth_951 synth_737 synth_810 VDD synth_952 VNB|VSS VNB|VSS
+ sky130_fd_sc_hd__o21ai_0
X$10444 VDD synth_9421 synth_9561 synth_9560 VDD synth_9508 VNB|VSS VNB|VSS
+ sky130_fd_sc_hd__o21ai_0
X$10445 VDD synth_5580 synth_5511 synth_5512 VDD synth_5513 VNB|VSS VNB|VSS
+ sky130_fd_sc_hd__o21ai_0
X$10446 VDD synth_3853 synth_3887 synth_3886 VDD synth_3984 VNB|VSS VNB|VSS
+ sky130_fd_sc_hd__o21ai_0
X$10447 VDD synth_2203 synth_2204 synth_2248 VDD synth_2160 VNB|VSS VNB|VSS
+ sky130_fd_sc_hd__o21ai_0
X$10448 VDD synth_8738 synth_9510 synth_9511 VDD synth_9618 VNB|VSS VNB|VSS
+ sky130_fd_sc_hd__o21ai_0
X$10449 VDD synth_9387 synth_11912 synth_12142 VDD synth_12240 VNB|VSS VNB|VSS
+ sky130_fd_sc_hd__o21ai_0
X$10450 VDD synth_3205 synth_3058 synth_3101 VDD synth_3060 VNB|VSS VNB|VSS
+ sky130_fd_sc_hd__o21ai_0
X$10451 VDD synth_8853 synth_8931 synth_9027 VDD synth_8897 VNB|VSS VNB|VSS
+ sky130_fd_sc_hd__o21ai_0
X$10452 VDD synth_9426 synth_9228 synth_9320 VDD synth_9388 VNB|VSS VNB|VSS
+ sky130_fd_sc_hd__o21ai_0
X$10453 VDD synth_11969 synth_11850 synth_11853 VDD synth_11803 VNB|VSS VNB|VSS
+ sky130_fd_sc_hd__o21ai_0
X$10454 VDD synth_12659 synth_12572 synth_12571 VDD synth_12789 VNB|VSS VNB|VSS
+ sky130_fd_sc_hd__o21ai_0
X$10455 VDD synth_10175 synth_12384 synth_10003 VDD synth_12269 VNB|VSS VNB|VSS
+ sky130_fd_sc_hd__o21ai_0
X$10456 VDD synth_2416 synth_2261 synth_2372 VDD synth_2500 VNB|VSS VNB|VSS
+ sky130_fd_sc_hd__o21ai_0
X$10457 VDD synth_10863 synth_10233 synth_11516 VDD synth_11640 VNB|VSS VNB|VSS
+ sky130_fd_sc_hd__o21ai_0
X$10458 VDD synth_5211 synth_5268 synth_5346 VDD synth_5466 VNB|VSS VNB|VSS
+ sky130_fd_sc_hd__o21ai_0
X$10459 VDD synth_9569 synth_9486 synth_9642 VDD synth_9640 VNB|VSS VNB|VSS
+ sky130_fd_sc_hd__o21ai_0
X$10460 VDD synth_2957 synth_2617 synth_3140 VDD synth_3141 VNB|VSS VNB|VSS
+ sky130_fd_sc_hd__o21ai_0
X$10461 VDD synth_9396 synth_12306 synth_9387 VDD synth_12343 VNB|VSS VNB|VSS
+ sky130_fd_sc_hd__o21ai_0
X$10462 VDD synth_7912 synth_7956 synth_8207 VDD synth_8275 VNB|VSS VNB|VSS
+ sky130_fd_sc_hd__o21ai_0
X$10463 VDD synth_10652 synth_9240 synth_12142 VDD synth_10217 VNB|VSS VNB|VSS
+ sky130_fd_sc_hd__o21ai_0
X$10464 VDD synth_1254 synth_1344 synth_1397 VDD synth_1399 VNB|VSS VNB|VSS
+ sky130_fd_sc_hd__o21ai_0
X$10465 VDD synth_2942 synth_2793 synth_2923 VDD synth_2861 VNB|VSS VNB|VSS
+ sky130_fd_sc_hd__o21ai_0
X$10466 VDD synth_1704 synth_1630 synth_1705 VDD synth_1544 VNB|VSS VNB|VSS
+ sky130_fd_sc_hd__o21ai_0
X$10467 VDD synth_2265 synth_2266 synth_2392 VDD synth_2692 VNB|VSS VNB|VSS
+ sky130_fd_sc_hd__o21ai_0
X$10468 VDD synth_3760 synth_3899 synth_4026 VDD synth_3808 VNB|VSS VNB|VSS
+ sky130_fd_sc_hd__o21ai_0
X$10469 VDD synth_12265 synth_12209 synth_9931 VDD synth_12244 VNB|VSS VNB|VSS
+ sky130_fd_sc_hd__o21ai_0
X$10470 VDD synth_917 synth_957 synth_1039 VDD synth_998 VNB|VSS VNB|VSS
+ sky130_fd_sc_hd__o21ai_0
X$10471 VDD synth_4545 synth_4378 synth_4546 VDD synth_4464 VNB|VSS VNB|VSS
+ sky130_fd_sc_hd__o21ai_0
X$10472 VDD synth_9443 synth_9444 synth_9441 VDD synth_9343 VNB|VSS VNB|VSS
+ sky130_fd_sc_hd__o21ai_0
X$10473 VDD synth_3272 synth_3274 synth_3273 VDD synth_3311 VNB|VSS VNB|VSS
+ sky130_fd_sc_hd__o21ai_0
X$10474 VDD synth_1647 synth_1519 synth_1603 VDD synth_1998 VNB|VSS VNB|VSS
+ sky130_fd_sc_hd__o21ai_0
X$10475 VDD synth_10793 synth_12395 synth_12594 VDD synth_12556 VNB|VSS VNB|VSS
+ sky130_fd_sc_hd__o21ai_0
X$10476 VDD synth_7454 synth_7491 synth_7411 VDD synth_7412 VNB|VSS VNB|VSS
+ sky130_fd_sc_hd__o21ai_0
X$10477 VDD synth_4756 synth_4753 synth_4754 VDD synth_4860 VNB|VSS VNB|VSS
+ sky130_fd_sc_hd__o21ai_0
X$10478 VDD synth_12018 synth_9762 synth_12136 VDD synth_12081 VNB|VSS VNB|VSS
+ sky130_fd_sc_hd__o21ai_0
X$10479 VDD synth_4392 synth_4680 synth_4538 VDD synth_4866 VNB|VSS VNB|VSS
+ sky130_fd_sc_hd__o21ai_0
X$10480 VDD synth_9292 synth_9555 synth_10793 VDD synth_11975 VNB|VSS VNB|VSS
+ sky130_fd_sc_hd__o21ai_0
X$10481 VDD synth_2532 synth_2642 synth_2783 VDD synth_2784 VNB|VSS VNB|VSS
+ sky130_fd_sc_hd__o21ai_0
X$10482 VDD synth_1343 synth_1428 synth_1473 VDD synth_1472 VNB|VSS VNB|VSS
+ sky130_fd_sc_hd__o21ai_0
X$10483 VDD synth_4278 synth_2116 synth_4358 VDD synth_4504 VNB|VSS VNB|VSS
+ sky130_fd_sc_hd__o21ai_0
X$10484 VDD synth_7905 synth_7949 synth_7948 VDD synth_7873 VNB|VSS VNB|VSS
+ sky130_fd_sc_hd__o21ai_0
X$10485 VDD synth_9042 synth_11913 synth_11814 VDD synth_11837 VNB|VSS VNB|VSS
+ sky130_fd_sc_hd__o21ai_0
X$10486 VDD synth_905 synth_906 synth_1043 VDD synth_967 VNB|VSS VNB|VSS
+ sky130_fd_sc_hd__o21ai_0
X$10487 VDD synth_11745 synth_11673 synth_11674 VDD synth_11789 VNB|VSS VNB|VSS
+ sky130_fd_sc_hd__o21ai_0
X$10488 VDD synth_9387 synth_10344 synth_9322 VDD synth_12276 VNB|VSS VNB|VSS
+ sky130_fd_sc_hd__o21ai_0
X$10489 VDD synth_11513 synth_11539 synth_8950 VDD synth_11730 VNB|VSS VNB|VSS
+ sky130_fd_sc_hd__o21ai_0
X$10490 VDD synth_6972 synth_4740 synth_7033 VDD synth_7201 VNB|VSS VNB|VSS
+ sky130_fd_sc_hd__o21ai_0
X$10491 VDD synth_2933 synth_659 synth_2934 VDD synth_2978 VNB|VSS VNB|VSS
+ sky130_fd_sc_hd__o21ai_0
X$10492 VDD synth_11722 synth_11740 synth_11905 VDD synth_11838 VNB|VSS VNB|VSS
+ sky130_fd_sc_hd__o21ai_0
X$10493 VDD synth_3282 synth_2116 synth_3448 VDD synth_3384 VNB|VSS VNB|VSS
+ sky130_fd_sc_hd__o21ai_0
X$10494 VDD synth_8697 synth_7089 synth_8698 VDD synth_8720 VNB|VSS VNB|VSS
+ sky130_fd_sc_hd__o21ai_0
X$10495 VDD synth_7281 synth_7251 synth_7477 VDD synth_7279 VNB|VSS VNB|VSS
+ sky130_fd_sc_hd__o21ai_0
X$10496 VDD synth_3850 synth_3951 synth_4046 VDD synth_4006 VNB|VSS VNB|VSS
+ sky130_fd_sc_hd__o21ai_0
X$10497 VDD synth_7472 synth_7559 synth_7638 VDD synth_7596 VNB|VSS VNB|VSS
+ sky130_fd_sc_hd__o21ai_0
X$10498 VDD synth_5682 synth_5621 synth_5766 VDD synth_5635 VNB|VSS VNB|VSS
+ sky130_fd_sc_hd__o21ai_0
X$10499 VDD synth_7952 synth_7773 synth_7816 VDD synth_7953 VNB|VSS VNB|VSS
+ sky130_fd_sc_hd__o21ai_0
X$10500 VDD synth_9292 synth_11592 synth_11520 VDD synth_11732 VNB|VSS VNB|VSS
+ sky130_fd_sc_hd__o21ai_0
X$10501 VDD synth_9941 synth_9958 synth_9957 VDD synth_9944 VNB|VSS VNB|VSS
+ sky130_fd_sc_hd__o21ai_0
X$10502 VDD synth_240 synth_67 synth_238 VDD synth_160 VNB|VSS VNB|VSS
+ sky130_fd_sc_hd__o21ai_0
X$10503 VDD synth_9629 synth_12410 synth_11465 VDD synth_11731 VNB|VSS VNB|VSS
+ sky130_fd_sc_hd__o21ai_0
X$10504 VDD synth_8037 synth_7956 synth_7911 VDD synth_8208 VNB|VSS VNB|VSS
+ sky130_fd_sc_hd__o21ai_0
X$10505 VDD synth_8145 synth_8077 synth_8446 VDD synth_8366 VNB|VSS VNB|VSS
+ sky130_fd_sc_hd__o21ai_0
X$10506 VDD synth_466 synth_167 synth_577 VDD synth_536 VNB|VSS VNB|VSS
+ sky130_fd_sc_hd__o21ai_0
X$10507 VDD synth_9101 synth_12172 synth_12139 VDD synth_12201 VNB|VSS VNB|VSS
+ sky130_fd_sc_hd__o21ai_0
X$10508 VDD synth_1622 synth_1718 synth_1635 VDD synth_1634 VNB|VSS VNB|VSS
+ sky130_fd_sc_hd__o21ai_0
X$10509 VDD synth_5573 synth_5630 synth_5629 VDD synth_5572 VNB|VSS VNB|VSS
+ sky130_fd_sc_hd__o21ai_0
X$10510 VDD synth_2287 synth_66 synth_2380 VDD synth_2379 VNB|VSS VNB|VSS
+ sky130_fd_sc_hd__o21ai_0
X$10511 VDD synth_1349 synth_1259 synth_1481 VDD synth_1477 VNB|VSS VNB|VSS
+ sky130_fd_sc_hd__o21ai_0
X$10512 VDD synth_6326 synth_6597 synth_7065 VDD synth_6960 VNB|VSS VNB|VSS
+ sky130_fd_sc_hd__o21ai_0
X$10513 VDD synth_7320 synth_7524 synth_7522 VDD synth_7282 VNB|VSS VNB|VSS
+ sky130_fd_sc_hd__o21ai_0
X$10514 VDD synth_9321 synth_9228 synth_9229 VDD synth_9389 VNB|VSS VNB|VSS
+ sky130_fd_sc_hd__o21ai_0
X$10515 VDD synth_2803 synth_2958 synth_2919 VDD synth_3084 VNB|VSS VNB|VSS
+ sky130_fd_sc_hd__o21ai_0
X$10516 VDD synth_10652 synth_11933 synth_8948 VDD synth_11993 VNB|VSS VNB|VSS
+ sky130_fd_sc_hd__o21ai_0
X$10517 VDD synth_7947 synth_7949 synth_8063 VDD synth_8026 VNB|VSS VNB|VSS
+ sky130_fd_sc_hd__o21ai_0
X$10518 VDD synth_8616 synth_8450 synth_8692 VDD synth_8716 VNB|VSS VNB|VSS
+ sky130_fd_sc_hd__o21ai_0
X$10519 VDD synth_8548 synth_8468 synth_8442 VDD synth_8527 VNB|VSS VNB|VSS
+ sky130_fd_sc_hd__o21ai_0
X$10520 VDD synth_11653 synth_10164 synth_11764 VDD synth_11694 VNB|VSS VNB|VSS
+ sky130_fd_sc_hd__o21ai_0
X$10521 VDD synth_3137 synth_3267 synth_3427 VDD synth_3371 VNB|VSS VNB|VSS
+ sky130_fd_sc_hd__o21ai_0
X$10522 VDD synth_12286 synth_10164 synth_12321 VDD synth_12287 VNB|VSS VNB|VSS
+ sky130_fd_sc_hd__o21ai_0
X$10523 VDD synth_12723 synth_12403 synth_12500 VDD synth_12562 VNB|VSS VNB|VSS
+ sky130_fd_sc_hd__o21ai_0
X$10524 VDD synth_9335 synth_9247 synth_9367 VDD synth_9087 VNB|VSS VNB|VSS
+ sky130_fd_sc_hd__o21ai_0
X$10525 VDD synth_7847 synth_7773 synth_7954 VDD synth_7884 VNB|VSS VNB|VSS
+ sky130_fd_sc_hd__o21ai_0
X$10526 VDD synth_3070 synth_2994 synth_3142 VDD synth_3072 VNB|VSS VNB|VSS
+ sky130_fd_sc_hd__o21ai_0
X$10527 VDD synth_77 synth_123 synth_316 VDD synth_249 VNB|VSS VNB|VSS
+ sky130_fd_sc_hd__o21ai_0
X$10528 VDD synth_8414 synth_8332 synth_8333 VDD synth_8358 VNB|VSS VNB|VSS
+ sky130_fd_sc_hd__o21ai_0
X$10529 VDD synth_11661 synth_11707 synth_11771 VDD synth_11708 VNB|VSS VNB|VSS
+ sky130_fd_sc_hd__o21ai_0
X$10530 VDD synth_397 synth_151 synth_566 VDD synth_546 VNB|VSS VNB|VSS
+ sky130_fd_sc_hd__o21ai_0
X$10531 VDD synth_7989 synth_8153 synth_8236 VDD synth_8273 VNB|VSS VNB|VSS
+ sky130_fd_sc_hd__o21ai_0
X$10532 VDD synth_3815 synth_3747 synth_3856 VDD synth_3783 VNB|VSS VNB|VSS
+ sky130_fd_sc_hd__o21ai_0
X$10533 VDD synth_3774 synth_3840 synth_3841 VDD synth_3780 VNB|VSS VNB|VSS
+ sky130_fd_sc_hd__o21ai_0
X$10534 VDD synth_8569 synth_8450 synth_8652 VDD synth_8489 VNB|VSS VNB|VSS
+ sky130_fd_sc_hd__o21ai_0
X$10535 VDD synth_11809 synth_11740 synth_11810 VDD synth_11904 VNB|VSS VNB|VSS
+ sky130_fd_sc_hd__o21ai_0
X$10536 VDD synth_11314 synth_11460 synth_9042 VDD synth_11517 VNB|VSS VNB|VSS
+ sky130_fd_sc_hd__o21ai_0
X$10537 VDD synth_5196 synth_6658 synth_6433 VDD synth_6657 VNB|VSS VNB|VSS
+ sky130_fd_sc_hd__o21ai_0
X$10538 VDD synth_11443 synth_11799 synth_11610 VDD synth_11763 VNB|VSS VNB|VSS
+ sky130_fd_sc_hd__o21ai_0
X$10539 VDD synth_11350 synth_11529 synth_11372 VDD synth_11531 VNB|VSS VNB|VSS
+ sky130_fd_sc_hd__o21ai_0
X$10540 VDD synth_11673 synth_9423 synth_11792 VDD synth_11790 VNB|VSS VNB|VSS
+ sky130_fd_sc_hd__o21ai_0
X$10541 VDD synth_4388 synth_4471 synth_4648 VDD synth_4578 VNB|VSS VNB|VSS
+ sky130_fd_sc_hd__o21ai_0
X$10542 VDD synth_2305 synth_2265 synth_2395 VDD synth_2394 VNB|VSS VNB|VSS
+ sky130_fd_sc_hd__o21ai_0
X$10543 VDD synth_2955 synth_2803 synth_2922 VDD synth_2875 VNB|VSS VNB|VSS
+ sky130_fd_sc_hd__o21ai_0
X$10544 VDD synth_6435 synth_6852 synth_6856 VDD synth_6926 VNB|VSS VNB|VSS
+ sky130_fd_sc_hd__o21ai_0
X$10545 VDD synth_7080 synth_7163 synth_7117 VDD synth_7303 VNB|VSS VNB|VSS
+ sky130_fd_sc_hd__o21ai_0
X$10546 VDD synth_11872 synth_11893 synth_8805 VDD synth_11818 VNB|VSS VNB|VSS
+ sky130_fd_sc_hd__o21ai_0
X$10547 VDD synth_7140 synth_7436 synth_7475 VDD synth_7138 VNB|VSS VNB|VSS
+ sky130_fd_sc_hd__o21ai_0
X$10548 VDD synth_1813 synth_1886 synth_1866 VDD synth_1790 VNB|VSS VNB|VSS
+ sky130_fd_sc_hd__o21ai_0
X$10549 VDD synth_7315 synth_7472 synth_7509 VDD synth_7273 VNB|VSS VNB|VSS
+ sky130_fd_sc_hd__o21ai_0
X$10550 VDD synth_9398 synth_8746 synth_9534 VDD synth_9399 VNB|VSS VNB|VSS
+ sky130_fd_sc_hd__o21ai_0
X$10551 VDD synth_10143 synth_10208 synth_10271 VDD synth_9994 VNB|VSS VNB|VSS
+ sky130_fd_sc_hd__o21ai_0
X$10552 VDD synth_12613 synth_12504 synth_12539 VDD synth_12614 VNB|VSS VNB|VSS
+ sky130_fd_sc_hd__o21ai_0
X$10553 VDD synth_2341 synth_2273 synth_2275 VDD synth_2461 VNB|VSS VNB|VSS
+ sky130_fd_sc_hd__o21ai_0
X$10554 VDD synth_8993 synth_8958 synth_9025 VDD synth_8960 VNB|VSS VNB|VSS
+ sky130_fd_sc_hd__o21ai_0
X$10555 VDD synth_11598 synth_10489 synth_9629 VDD synth_11634 VNB|VSS VNB|VSS
+ sky130_fd_sc_hd__o21ai_0
X$10556 VDD synth_7380 synth_7472 synth_7508 VDD synth_7427 VNB|VSS VNB|VSS
+ sky130_fd_sc_hd__o21ai_0
X$10557 VDD synth_9101 synth_10771 synth_12244 VDD synth_12259 VNB|VSS VNB|VSS
+ sky130_fd_sc_hd__o21ai_0
X$10558 VDD synth_5275 synth_5276 synth_5356 VDD synth_5363 VNB|VSS VNB|VSS
+ sky130_fd_sc_hd__o21ai_0
X$10559 VDD synth_10312 synth_12405 synth_12406 VDD synth_12453 VNB|VSS VNB|VSS
+ sky130_fd_sc_hd__o21ai_0
X$10560 VDD synth_7562 synth_7641 synth_7516 VDD synth_7600 VNB|VSS VNB|VSS
+ sky130_fd_sc_hd__o21ai_0
X$10561 VDD synth_11241 synth_11306 synth_11353 VDD synth_11209 VNB|VSS VNB|VSS
+ sky130_fd_sc_hd__o21ai_0
X$10562 VDD synth_4719 synth_4645 synth_4761 VDD synth_4858 VNB|VSS VNB|VSS
+ sky130_fd_sc_hd__o21ai_0
X$10563 VDD synth_12504 synth_12612 synth_12565 VDD synth_12686 VNB|VSS VNB|VSS
+ sky130_fd_sc_hd__o21ai_0
X$10564 VDD synth_10078 synth_8000 synth_9965 VDD synth_10046 VNB|VSS VNB|VSS
+ sky130_fd_sc_hd__o21ai_0
X$10565 VDD synth_4837 synth_2116 synth_4734 VDD synth_4809 VNB|VSS VNB|VSS
+ sky130_fd_sc_hd__o21ai_0
X$10566 VDD synth_9126 synth_9139 synth_9075 VDD synth_9016 VNB|VSS VNB|VSS
+ sky130_fd_sc_hd__o21ai_0
X$10567 VDD synth_8361 synth_8440 synth_8437 VDD synth_8363 VNB|VSS VNB|VSS
+ sky130_fd_sc_hd__o21ai_0
X$10568 VDD synth_7320 synth_7642 synth_7683 VDD synth_7682 VNB|VSS VNB|VSS
+ sky130_fd_sc_hd__o21ai_0
X$10569 VDD synth_6666 synth_6665 synth_6667 VDD synth_6866 VNB|VSS VNB|VSS
+ sky130_fd_sc_hd__o21ai_0
X$10570 VDD synth_7915 synth_8155 synth_8130 VDD synth_8157 VNB|VSS VNB|VSS
+ sky130_fd_sc_hd__o21ai_0
X$10571 VDD synth_9629 synth_11050 synth_9062 VDD synth_10869 VNB|VSS VNB|VSS
+ sky130_fd_sc_hd__o21ai_0
X$10572 VDD synth_2718 synth_2785 synth_2832 VDD synth_2763 VNB|VSS VNB|VSS
+ sky130_fd_sc_hd__o21ai_0
X$10573 VDD synth_2067 synth_2064 synth_2065 VDD synth_1983 VNB|VSS VNB|VSS
+ sky130_fd_sc_hd__o21ai_0
X$10574 VDD synth_639 synth_763 synth_833 VDD synth_574 VNB|VSS VNB|VSS
+ sky130_fd_sc_hd__o21ai_0
X$10575 VDD synth_9712 synth_9683 synth_9791 VDD synth_9710 VNB|VSS VNB|VSS
+ sky130_fd_sc_hd__o21ai_0
X$10576 VDD synth_10432 synth_10431 synth_10475 VDD synth_10345 VNB|VSS VNB|VSS
+ sky130_fd_sc_hd__o21ai_0
X$10577 VDD synth_10312 synth_11966 synth_11868 VDD synth_10582 VNB|VSS VNB|VSS
+ sky130_fd_sc_hd__o21ai_0
X$10578 VDD synth_143 synth_217 synth_327 VDD synth_122 VNB|VSS VNB|VSS
+ sky130_fd_sc_hd__o21ai_0
X$10579 VDD synth_6260 synth_4961 synth_6400 VDD synth_6251 VNB|VSS VNB|VSS
+ sky130_fd_sc_hd__o21ai_0
X$10580 VDD synth_2496 synth_2568 synth_2639 VDD synth_2610 VNB|VSS VNB|VSS
+ sky130_fd_sc_hd__o21ai_0
X$10581 VDD synth_11210 synth_11306 synth_11422 VDD synth_11208 VNB|VSS VNB|VSS
+ sky130_fd_sc_hd__o21ai_0
X$10582 VDD synth_9996 synth_9844 synth_9969 VDD synth_10144 VNB|VSS VNB|VSS
+ sky130_fd_sc_hd__o21ai_0
X$10583 VDD synth_7017 synth_6597 synth_7018 VDD synth_6959 VNB|VSS VNB|VSS
+ sky130_fd_sc_hd__o21ai_0
X$10584 VDD synth_11524 synth_11487 synth_11585 VDD synth_11617 VNB|VSS VNB|VSS
+ sky130_fd_sc_hd__o21ai_0
X$10585 VDD synth_618 synth_151 synth_676 VDD synth_726 VNB|VSS VNB|VSS
+ sky130_fd_sc_hd__o21ai_0
X$10586 VDD synth_3006 synth_2803 synth_2764 VDD synth_3088 VNB|VSS VNB|VSS
+ sky130_fd_sc_hd__o21ai_0
X$10587 VDD synth_3382 synth_3381 synth_3560 VDD synth_3609 VNB|VSS VNB|VSS
+ sky130_fd_sc_hd__o21ai_0
X$10588 VDD synth_3411 synth_3243 synth_3330 VDD synth_3657 VNB|VSS VNB|VSS
+ sky130_fd_sc_hd__o21ai_0
X$10589 VDD synth_7881 synth_7089 synth_8344 VDD synth_8151 VNB|VSS VNB|VSS
+ sky130_fd_sc_hd__o21ai_0
X$10590 VDD synth_9824 synth_11928 synth_10212 VDD synth_12412 VNB|VSS VNB|VSS
+ sky130_fd_sc_hd__o21ai_0
X$10591 VDD synth_9117 synth_12622 synth_10238 VDD synth_12010 VNB|VSS VNB|VSS
+ sky130_fd_sc_hd__o21ai_0
X$10592 VDD synth_7774 synth_7183 synth_7775 VDD synth_7754 VNB|VSS VNB|VSS
+ sky130_fd_sc_hd__o21ai_0
X$10593 VDD synth_10083 synth_10268 synth_10341 VDD synth_10141 VNB|VSS VNB|VSS
+ sky130_fd_sc_hd__o21ai_0
X$10594 VDD synth_7761 synth_7111 synth_7838 VDD synth_7760 VNB|VSS VNB|VSS
+ sky130_fd_sc_hd__o21ai_0
X$10595 VDD synth_8806 synth_12411 synth_12412 VDD synth_11893 VNB|VSS VNB|VSS
+ sky130_fd_sc_hd__o21ai_0
X$10596 VDD synth_12501 synth_12456 synth_12537 VDD synth_12785 VNB|VSS VNB|VSS
+ sky130_fd_sc_hd__o21ai_0
X$10597 VDD synth_3305 synth_3175 synth_3281 VDD synth_3349 VNB|VSS VNB|VSS
+ sky130_fd_sc_hd__o21ai_0
X$10598 VDD synth_1071 synth_194 synth_1072 VDD synth_1113 VNB|VSS VNB|VSS
+ sky130_fd_sc_hd__o21ai_0
X$10599 VDD synth_9042 synth_9615 synth_11907 VDD synth_11811 VNB|VSS VNB|VSS
+ sky130_fd_sc_hd__o21ai_0
X$10600 VDD synth_1224 synth_1067 synth_1255 VDD synth_1176 VNB|VSS VNB|VSS
+ sky130_fd_sc_hd__o21ai_0
X$10601 VDD synth_8811 synth_8894 synth_8575 VDD synth_8813 VNB|VSS VNB|VSS
+ sky130_fd_sc_hd__o21ai_0
X$10602 VDD synth_10116 synth_8746 synth_10162 VDD synth_10192 VNB|VSS VNB|VSS
+ sky130_fd_sc_hd__o21ai_0
X$10603 VDD synth_2990 synth_1067 synth_3102 VDD synth_3068 VNB|VSS VNB|VSS
+ sky130_fd_sc_hd__o21ai_0
X$10604 VDD synth_5083 synth_5163 synth_5084 VDD synth_5203 VNB|VSS VNB|VSS
+ sky130_fd_sc_hd__o21ai_0
X$10605 VDD synth_11921 synth_12041 synth_12264 VDD synth_12083 VNB|VSS VNB|VSS
+ sky130_fd_sc_hd__o21ai_0
X$10606 VDD synth_9387 synth_12108 synth_12148 VDD synth_12170 VNB|VSS VNB|VSS
+ sky130_fd_sc_hd__o21ai_0
X$10607 VDD synth_746 synth_745 synth_818 VDD synth_880 VNB|VSS VNB|VSS
+ sky130_fd_sc_hd__o21ai_0
X$10608 VDD synth_8806 synth_12639 synth_12725 VDD synth_12758 VNB|VSS VNB|VSS
+ sky130_fd_sc_hd__o21ai_0
X$10609 VDD synth_3367 synth_3291 synth_3366 VDD synth_3288 VNB|VSS VNB|VSS
+ sky130_fd_sc_hd__o21ai_0
X$10610 VDD synth_4391 synth_4471 synth_4548 VDD synth_4689 VNB|VSS VNB|VSS
+ sky130_fd_sc_hd__o21ai_0
X$10611 VDD synth_6722 synth_6597 synth_6672 VDD synth_6723 VNB|VSS VNB|VSS
+ sky130_fd_sc_hd__o21ai_0
X$10612 VDD synth_2240 synth_2091 synth_2335 VDD synth_2574 VNB|VSS VNB|VSS
+ sky130_fd_sc_hd__o21ai_0
X$10613 VDD synth_7770 synth_7089 synth_7771 VDD synth_7716 VNB|VSS VNB|VSS
+ sky130_fd_sc_hd__o21ai_0
X$10614 VDD synth_6543 synth_6665 synth_6718 VDD synth_6511 VNB|VSS VNB|VSS
+ sky130_fd_sc_hd__o21ai_0
X$10615 VDD synth_839 synth_1006 synth_935 VDD synth_925 VNB|VSS VNB|VSS
+ sky130_fd_sc_hd__o21ai_0
X$10616 VDD synth_579 synth_167 synth_460 VDD synth_520 VNB|VSS VNB|VSS
+ sky130_fd_sc_hd__o21ai_0
X$10617 VDD synth_9165 synth_9299 synth_9357 VDD synth_9261 VNB|VSS VNB|VSS
+ sky130_fd_sc_hd__o21ai_0
X$10618 VDD synth_10787 synth_10711 synth_10906 VDD synth_10907 VNB|VSS VNB|VSS
+ sky130_fd_sc_hd__o21ai_0
X$10619 VDD synth_12473 synth_12767 synth_12479 VDD synth_12732 VNB|VSS VNB|VSS
+ sky130_fd_sc_hd__o21ai_0
X$10620 VDD synth_4478 synth_4393 synth_4213 VDD synth_4477 VNB|VSS VNB|VSS
+ sky130_fd_sc_hd__o21ai_0
X$10621 VDD synth_12646 synth_12403 synth_12499 VDD synth_12561 VNB|VSS VNB|VSS
+ sky130_fd_sc_hd__o21ai_0
X$10622 VDD synth_1992 synth_1891 synth_1917 VDD synth_2150 VNB|VSS VNB|VSS
+ sky130_fd_sc_hd__o21ai_0
X$10623 VDD synth_9216 synth_9299 synth_9359 VDD synth_9263 VNB|VSS VNB|VSS
+ sky130_fd_sc_hd__o21ai_0
X$10624 VDD synth_6697 synth_6698 synth_6695 VDD synth_6703 VNB|VSS VNB|VSS
+ sky130_fd_sc_hd__o21ai_0
X$10625 VDD synth_11523 synth_11443 synth_11611 VDD synth_11555 VNB|VSS VNB|VSS
+ sky130_fd_sc_hd__o21ai_0
X$10626 VDD synth_522 synth_686 synth_688 VDD synth_524 VNB|VSS VNB|VSS
+ sky130_fd_sc_hd__o21ai_0
X$10627 VDD synth_10376 synth_9233 synth_12242 VDD synth_12212 VNB|VSS VNB|VSS
+ sky130_fd_sc_hd__o21ai_0
X$10628 VDD synth_717 synth_151 synth_681 VDD synth_715 VNB|VSS VNB|VSS
+ sky130_fd_sc_hd__o21ai_0
X$10629 VDD synth_10212 synth_12239 synth_11463 VDD synth_12173 VNB|VSS VNB|VSS
+ sky130_fd_sc_hd__o21ai_0
X$10630 VDD synth_4385 synth_3541 synth_4544 VDD synth_4463 VNB|VSS VNB|VSS
+ sky130_fd_sc_hd__o21ai_0
X$10631 VDD synth_11916 synth_11915 synth_11977 VDD synth_11943 VNB|VSS VNB|VSS
+ sky130_fd_sc_hd__o21ai_0
X$10632 VDD synth_12050 synth_12491 synth_8803 VDD synth_12630 VNB|VSS VNB|VSS
+ sky130_fd_sc_hd__o21ai_0
X$10633 VDD synth_6819 synth_5900 synth_6903 VDD synth_6974 VNB|VSS VNB|VSS
+ sky130_fd_sc_hd__o21ai_0
X$10634 VDD synth_8445 synth_8385 synth_8551 VDD synth_8522 VNB|VSS VNB|VSS
+ sky130_fd_sc_hd__o21ai_0
X$10635 VDD synth_4721 synth_4823 synth_4859 VDD synth_4767 VNB|VSS VNB|VSS
+ sky130_fd_sc_hd__o21ai_0
X$10636 VDD synth_906 synth_1044 synth_1045 VDD synth_886 VNB|VSS VNB|VSS
+ sky130_fd_sc_hd__o21ai_0
X$10637 VDD synth_2509 synth_2618 synth_2645 VDD synth_2508 VNB|VSS VNB|VSS
+ sky130_fd_sc_hd__o21ai_0
X$10638 VDD synth_7849 synth_7089 synth_7914 VDD synth_7959 VNB|VSS VNB|VSS
+ sky130_fd_sc_hd__o21ai_0
X$10639 VDD synth_5357 synth_5276 synth_5361 VDD synth_5278 VNB|VSS VNB|VSS
+ sky130_fd_sc_hd__o21ai_0
X$10640 VDD synth_9646 synth_9258 synth_9344 VDD synth_8811 VNB|VSS VNB|VSS
+ sky130_fd_sc_hd__o21ai_0
X$10641 VDD synth_2780 synth_2753 synth_2779 VDD synth_2781 VNB|VSS VNB|VSS
+ sky130_fd_sc_hd__o21ai_0
X$10642 VDD synth_10427 synth_10268 synth_10503 VDD synth_10545 VNB|VSS VNB|VSS
+ sky130_fd_sc_hd__o21ai_0
X$10643 VDD synth_2285 synth_2352 synth_2353 VDD synth_2234 VNB|VSS VNB|VSS
+ sky130_fd_sc_hd__o21ai_0
X$10644 VDD synth_9673 synth_9421 synth_9562 VDD synth_9574 VNB|VSS VNB|VSS
+ sky130_fd_sc_hd__o21ai_0
X$10645 VDD synth_4292 synth_4392 synth_4203 VDD synth_4540 VNB|VSS VNB|VSS
+ sky130_fd_sc_hd__o21ai_0
X$10646 VDD synth_2429 synth_2482 synth_2517 VDD synth_2518 VNB|VSS VNB|VSS
+ sky130_fd_sc_hd__o21ai_0
X$10647 VDD synth_1546 synth_1632 synth_1675 VDD synth_1676 VNB|VSS VNB|VSS
+ sky130_fd_sc_hd__o21ai_0
X$10648 VDD synth_10903 synth_10711 synth_10905 VDD synth_10904 VNB|VSS VNB|VSS
+ sky130_fd_sc_hd__o21ai_0
X$10649 VDD synth_6707 synth_6659 synth_6594 VDD synth_6488 VNB|VSS VNB|VSS
+ sky130_fd_sc_hd__o21ai_0
X$10650 VDD synth_9623 synth_9421 synth_9671 VDD synth_9612 VNB|VSS VNB|VSS
+ sky130_fd_sc_hd__o21ai_0
X$10651 VDD synth_832 synth_763 synth_863 VDD synth_778 VNB|VSS VNB|VSS
+ sky130_fd_sc_hd__o21ai_0
X$10652 VDD synth_193 synth_212 synth_324 VDD synth_140 VNB|VSS VNB|VSS
+ sky130_fd_sc_hd__o21ai_0
X$10653 VDD synth_10999 synth_10936 synth_11001 VDD synth_10841 VNB|VSS VNB|VSS
+ sky130_fd_sc_hd__o21ai_0
X$10654 VDD synth_7986 synth_7985 synth_8065 VDD synth_8118 VNB|VSS VNB|VSS
+ sky130_fd_sc_hd__o21ai_0
X$10655 VDD synth_8239 synth_8284 synth_8434 VDD synth_8433 VNB|VSS VNB|VSS
+ sky130_fd_sc_hd__o21ai_0
X$10656 VDD synth_3331 synth_167 synth_3406 VDD synth_3424 VNB|VSS VNB|VSS
+ sky130_fd_sc_hd__o21ai_0
X$10657 VDD synth_6267 synth_6264 synth_6384 VDD synth_6181 VNB|VSS VNB|VSS
+ sky130_fd_sc_hd__o21ai_0
X$10658 VDD synth_2854 synth_659 synth_2824 VDD synth_2856 VNB|VSS VNB|VSS
+ sky130_fd_sc_hd__o21ai_0
X$10659 VDD synth_2313 synth_2273 synth_2409 VDD synth_2316 VNB|VSS VNB|VSS
+ sky130_fd_sc_hd__o21ai_0
X$10660 VDD synth_7254 synth_7182 synth_7354 VDD synth_7221 VNB|VSS VNB|VSS
+ sky130_fd_sc_hd__o21ai_0
X$10661 VDD synth_4736 synth_4735 synth_4900 VDD synth_4838 VNB|VSS VNB|VSS
+ sky130_fd_sc_hd__o21ai_0
X$10662 VDD synth_6663 synth_6631 synth_6633 VDD synth_7147 VNB|VSS VNB|VSS
+ sky130_fd_sc_hd__o21ai_0
X$10663 VDD synth_8946 synth_12020 synth_9112 VDD synth_12144 VNB|VSS VNB|VSS
+ sky130_fd_sc_hd__o21ai_0
X$10664 VDD synth_815 synth_666 synth_872 VDD synth_1110 VNB|VSS VNB|VSS
+ sky130_fd_sc_hd__o21ai_0
X$10665 VDD synth_3955 synth_4062 synth_4011 VDD synth_4171 VNB|VSS VNB|VSS
+ sky130_fd_sc_hd__o21ai_0
X$10666 VDD synth_666 synth_814 synth_743 VDD synth_642 VNB|VSS VNB|VSS
+ sky130_fd_sc_hd__o21ai_0
X$10667 VDD synth_4714 synth_4735 synth_4901 VDD synth_4810 VNB|VSS VNB|VSS
+ sky130_fd_sc_hd__o21ai_0
X$10668 VDD synth_4337 synth_3544 synth_4395 VDD synth_4340 VNB|VSS VNB|VSS
+ sky130_fd_sc_hd__o21ai_0
X$10669 VDD synth_9837 synth_9836 synth_9952 VDD synth_9951 VNB|VSS VNB|VSS
+ sky130_fd_sc_hd__o21ai_0
X$10670 VDD synth_2901 synth_2852 synth_2980 VDD synth_2853 VNB|VSS VNB|VSS
+ sky130_fd_sc_hd__o21ai_0
X$10671 VDD synth_2225 synth_2064 synth_2076 VDD synth_2134 VNB|VSS VNB|VSS
+ sky130_fd_sc_hd__o21ai_0
X$10672 VDD synth_6432 synth_7016 synth_6538 VDD synth_7091 VNB|VSS VNB|VSS
+ sky130_fd_sc_hd__o21ai_0
X$10673 VDD synth_2722 synth_2790 synth_2789 VDD synth_2720 VNB|VSS VNB|VSS
+ sky130_fd_sc_hd__o21ai_0
X$10674 VDD synth_2063 synth_2209 synth_2239 VDD synth_2153 VNB|VSS VNB|VSS
+ sky130_fd_sc_hd__o21ai_0
X$10675 VDD synth_1163 synth_1137 synth_1332 VDD synth_1119 VNB|VSS VNB|VSS
+ sky130_fd_sc_hd__o21ai_0
X$10676 VDD synth_2648 synth_2537 synth_2577 VDD synth_2478 VNB|VSS VNB|VSS
+ sky130_fd_sc_hd__o21ai_0
X$10677 VDD synth_3030 synth_3147 synth_3106 VDD synth_3077 VNB|VSS VNB|VSS
+ sky130_fd_sc_hd__o21ai_0
X$10678 VDD synth_1064 synth_1062 synth_1129 VDD synth_1106 VNB|VSS VNB|VSS
+ sky130_fd_sc_hd__o21ai_0
X$10679 VDD synth_7586 synth_7741 synth_7795 VDD synth_7832 VNB|VSS VNB|VSS
+ sky130_fd_sc_hd__o21ai_0
X$10680 VDD synth_8077 synth_8079 synth_8001 VDD synth_7782 VNB|VSS VNB|VSS
+ sky130_fd_sc_hd__o21ai_0
X$10681 VDD synth_4330 synth_4004 synth_4190 VDD synth_4076 VNB|VSS VNB|VSS
+ sky130_fd_sc_hd__o21ai_0
X$10682 VDD synth_6238 synth_3632 synth_6152 VDD synth_6204 VNB|VSS VNB|VSS
+ sky130_fd_sc_hd__o21ai_0
X$10683 VDD synth_5074 synth_5117 synth_5238 VDD synth_5236 VNB|VSS VNB|VSS
+ sky130_fd_sc_hd__o21ai_0
X$10684 VDD synth_1384 synth_1496 synth_1498 VDD synth_1460 VNB|VSS VNB|VSS
+ sky130_fd_sc_hd__o21ai_0
X$10685 VDD synth_6143 synth_6144 synth_6145 VDD synth_6274 VNB|VSS VNB|VSS
+ sky130_fd_sc_hd__o21ai_0
X$10686 VDD synth_3630 synth_3461 synth_3613 VDD synth_3740 VNB|VSS VNB|VSS
+ sky130_fd_sc_hd__o21ai_0
X$10687 VDD synth_3737 synth_3461 synth_3612 VDD synth_3739 VNB|VSS VNB|VSS
+ sky130_fd_sc_hd__o21ai_0
X$10688 VDD synth_6908 synth_6832 synth_6695 VDD synth_6844 VNB|VSS VNB|VSS
+ sky130_fd_sc_hd__o21ai_0
X$10689 VDD synth_9630 synth_9661 synth_9062 VDD synth_9585 VNB|VSS VNB|VSS
+ sky130_fd_sc_hd__o21ai_0
X$10690 VDD synth_11310 synth_11430 synth_11309 VDD synth_11509 VNB|VSS VNB|VSS
+ sky130_fd_sc_hd__o21ai_0
X$10691 VDD synth_5058 synth_5132 synth_5197 VDD synth_4958 VNB|VSS VNB|VSS
+ sky130_fd_sc_hd__o21ai_0
X$10692 VDD synth_5417 synth_5336 synth_5474 VDD synth_5539 VNB|VSS VNB|VSS
+ sky130_fd_sc_hd__o21ai_0
X$10693 VDD synth_1374 synth_1375 synth_1296 VDD synth_1395 VNB|VSS VNB|VSS
+ sky130_fd_sc_hd__o21ai_0
X$10694 VDD synth_2796 synth_2843 synth_2797 VDD synth_2724 VNB|VSS VNB|VSS
+ sky130_fd_sc_hd__o21ai_0
X$10695 VDD synth_6895 synth_6597 synth_6896 VDD synth_6869 VNB|VSS VNB|VSS
+ sky130_fd_sc_hd__o21ai_0
X$10696 VDD synth_11546 synth_11547 synth_11394 VDD synth_11561 VNB|VSS VNB|VSS
+ sky130_fd_sc_hd__o21ai_0
X$10697 VDD synth_9494 synth_9686 synth_9801 VDD synth_9802 VNB|VSS VNB|VSS
+ sky130_fd_sc_hd__o21ai_0
X$10698 VDD synth_11399 synth_11332 synth_11400 VDD synth_11401 VNB|VSS VNB|VSS
+ sky130_fd_sc_hd__o21ai_0
X$10699 VDD synth_8764 synth_8981 synth_9048 VDD synth_9006 VNB|VSS VNB|VSS
+ sky130_fd_sc_hd__o21ai_0
X$10700 VDD synth_448 synth_66 synth_576 VDD synth_399 VNB|VSS VNB|VSS
+ sky130_fd_sc_hd__o21ai_0
X$10701 VDD synth_2323 synth_2371 synth_2498 VDD synth_2297 VNB|VSS VNB|VSS
+ sky130_fd_sc_hd__o21ai_0
X$10702 VDD synth_4622 synth_167 synth_4849 VDD synth_4869 VNB|VSS VNB|VSS
+ sky130_fd_sc_hd__o21ai_0
X$10703 VDD synth_12118 synth_12116 synth_12183 VDD synth_12184 VNB|VSS VNB|VSS
+ sky130_fd_sc_hd__o21ai_0
X$10704 VDD synth_8918 synth_11463 synth_8803 VDD synth_11385 VNB|VSS VNB|VSS
+ sky130_fd_sc_hd__o21ai_0
X$10705 VDD synth_674 synth_752 synth_821 VDD synth_891 VNB|VSS VNB|VSS
+ sky130_fd_sc_hd__o21ai_0
X$10706 VDD synth_1165 synth_1353 synth_1510 VDD synth_1565 VNB|VSS VNB|VSS
+ sky130_fd_sc_hd__o21ai_0
X$10707 VDD synth_4874 synth_4602 synth_4876 VDD synth_4875 VNB|VSS VNB|VSS
+ sky130_fd_sc_hd__o21ai_0
X$10708 VDD synth_3867 synth_3767 synth_3835 VDD synth_3790 VNB|VSS VNB|VSS
+ sky130_fd_sc_hd__o21ai_0
X$10709 VDD synth_11130 synth_10999 synth_11058 VDD synth_11213 VNB|VSS VNB|VSS
+ sky130_fd_sc_hd__o21ai_0
X$10710 VDD synth_842 synth_1013 synth_1012 VDD synth_1010 VNB|VSS VNB|VSS
+ sky130_fd_sc_hd__o21ai_0
X$10711 VDD synth_7548 synth_7574 synth_7709 VDD synth_7708 VNB|VSS VNB|VSS
+ sky130_fd_sc_hd__o21ai_0
X$10712 VDD synth_5553 synth_5606 synth_5641 VDD synth_5292 VNB|VSS VNB|VSS
+ sky130_fd_sc_hd__o21ai_0
X$10713 VDD synth_6729 synth_6603 synth_6731 VDD synth_6780 VNB|VSS VNB|VSS
+ sky130_fd_sc_hd__o21ai_0
X$10714 VDD synth_11017 synth_10007 synth_8870 VDD synth_11384 VNB|VSS VNB|VSS
+ sky130_fd_sc_hd__o21ai_0
X$10715 VDD synth_5325 synth_5606 synth_5662 VDD synth_5701 VNB|VSS VNB|VSS
+ sky130_fd_sc_hd__o21ai_0
X$10716 VDD synth_5201 synth_3544 synth_5376 VDD synth_5291 VNB|VSS VNB|VSS
+ sky130_fd_sc_hd__o21ai_0
X$10717 VDD synth_1749 synth_927 synth_1751 VDD synth_1752 VNB|VSS VNB|VSS
+ sky130_fd_sc_hd__o21ai_0
X$10718 VDD synth_12574 synth_12717 synth_12743 VDD synth_12742 VNB|VSS VNB|VSS
+ sky130_fd_sc_hd__o21ai_0
X$10719 VDD synth_10478 synth_10451 synth_10399 VDD synth_10477 VNB|VSS VNB|VSS
+ sky130_fd_sc_hd__o21ai_0
X$10720 VDD synth_4602 synth_4780 synth_4554 VDD synth_4604 VNB|VSS VNB|VSS
+ sky130_fd_sc_hd__o21ai_0
X$10721 VDD synth_12260 synth_12574 synth_12623 VDD synth_12510 VNB|VSS VNB|VSS
+ sky130_fd_sc_hd__o21ai_0
X$10722 VDD synth_6676 synth_6603 synth_6587 VDD synth_6877 VNB|VSS VNB|VSS
+ sky130_fd_sc_hd__o21ai_0
X$10723 VDD synth_10940 synth_9555 synth_10578 VDD synth_11290 VNB|VSS VNB|VSS
+ sky130_fd_sc_hd__o21ai_0
X$10724 VDD synth_5121 synth_5232 synth_5391 VDD synth_5311 VNB|VSS VNB|VSS
+ sky130_fd_sc_hd__o21ai_0
X$10725 VDD synth_9483 synth_9738 synth_9063 VDD synth_10776 VNB|VSS VNB|VSS
+ sky130_fd_sc_hd__o21ai_0
X$10726 VDD synth_3438 synth_3633 synth_3743 VDD synth_3871 VNB|VSS VNB|VSS
+ sky130_fd_sc_hd__o21ai_0
X$10727 VDD synth_1519 synth_1648 synth_1602 VDD synth_1775 VNB|VSS VNB|VSS
+ sky130_fd_sc_hd__o21ai_0
X$10728 VDD synth_3438 synth_3632 synth_3682 VDD synth_3700 VNB|VSS VNB|VSS
+ sky130_fd_sc_hd__o21ai_0
X$10729 VDD synth_9629 synth_10775 synth_10772 VDD synth_10774 VNB|VSS VNB|VSS
+ sky130_fd_sc_hd__o21ai_0
X$10730 VDD synth_893 synth_1092 synth_1126 VDD synth_1204 VNB|VSS VNB|VSS
+ sky130_fd_sc_hd__o21ai_0
X$10731 VDD synth_10014 synth_9856 synth_9160 VDD synth_9858 VNB|VSS VNB|VSS
+ sky130_fd_sc_hd__o21ai_0
X$10732 VDD synth_9856 synth_9933 synth_9160 VDD synth_9857 VNB|VSS VNB|VSS
+ sky130_fd_sc_hd__o21ai_0
X$10733 VDD synth_9062 synth_9565 synth_9659 VDD synth_9826 VNB|VSS VNB|VSS
+ sky130_fd_sc_hd__o21ai_0
X$10734 VDD synth_5252 synth_5253 synth_5544 VDD synth_5118 VNB|VSS VNB|VSS
+ sky130_fd_sc_hd__o21ai_0
X$10735 VDD synth_9062 synth_10311 synth_10346 VDD synth_9967 VNB|VSS VNB|VSS
+ sky130_fd_sc_hd__o21ai_0
X$10736 VDD synth_10815 synth_10164 synth_10971 VDD synth_10891 VNB|VSS VNB|VSS
+ sky130_fd_sc_hd__o21ai_0
X$10737 VDD synth_6038 synth_3468 synth_5991 VDD synth_6035 VNB|VSS VNB|VSS
+ sky130_fd_sc_hd__o21ai_0
X$10738 VDD synth_2585 synth_2271 synth_2708 VDD synth_2773 VNB|VSS VNB|VSS
+ sky130_fd_sc_hd__o21ai_0
X$10739 VDD synth_2736 synth_2665 synth_2813 VDD synth_2597 VNB|VSS VNB|VSS
+ sky130_fd_sc_hd__o21ai_0
X$10740 VDD synth_9677 synth_9676 synth_9583 VDD synth_9290 VNB|VSS VNB|VSS
+ sky130_fd_sc_hd__o21ai_0
X$10741 VDD synth_9923 synth_10865 synth_10212 VDD synth_10902 VNB|VSS VNB|VSS
+ sky130_fd_sc_hd__o21ai_0
X$10742 VDD synth_11042 synth_10920 synth_11187 VDD synth_11115 VNB|VSS VNB|VSS
+ sky130_fd_sc_hd__o21ai_0
X$10743 VDD synth_1902 synth_2219 synth_2178 VDD synth_2143 VNB|VSS VNB|VSS
+ sky130_fd_sc_hd__o21ai_0
X$10744 VDD synth_1801 synth_1882 synth_1927 VDD synth_1728 VNB|VSS VNB|VSS
+ sky130_fd_sc_hd__o21ai_0
X$10745 VDD synth_1802 synth_1882 synth_1928 VDD synth_1850 VNB|VSS VNB|VSS
+ sky130_fd_sc_hd__o21ai_0
X$10746 VDD synth_10212 synth_11463 synth_9112 VDD synth_11388 VNB|VSS VNB|VSS
+ sky130_fd_sc_hd__o21ai_0
X$10747 VDD synth_11192 synth_11483 synth_11340 VDD synth_11190 VNB|VSS VNB|VSS
+ sky130_fd_sc_hd__o21ai_0
X$10748 VDD synth_7850 synth_7916 synth_8046 VDD synth_7891 VNB|VSS VNB|VSS
+ sky130_fd_sc_hd__o21ai_0
X$10749 VDD synth_5945 synth_5889 synth_6065 VDD synth_5971 VNB|VSS VNB|VSS
+ sky130_fd_sc_hd__o21ai_0
X$10750 VDD synth_10615 synth_11169 synth_10652 VDD synth_11212 VNB|VSS VNB|VSS
+ sky130_fd_sc_hd__o21ai_0
X$10751 VDD synth_5790 synth_5598 synth_5927 VDD synth_5880 VNB|VSS VNB|VSS
+ sky130_fd_sc_hd__o21ai_0
X$10752 VDD synth_7692 synth_7691 synth_7722 VDD synth_7755 VNB|VSS VNB|VSS
+ sky130_fd_sc_hd__o21ai_0
X$10753 VDD synth_3667 synth_3476 synth_3585 VDD synth_3720 VNB|VSS VNB|VSS
+ sky130_fd_sc_hd__o21ai_0
X$10754 VDD synth_9923 synth_9901 synth_9677 VDD synth_11582 VNB|VSS VNB|VSS
+ sky130_fd_sc_hd__o21ai_0
X$10755 VDD synth_9272 synth_9654 synth_9542 VDD synth_9268 VNB|VSS VNB|VSS
+ sky130_fd_sc_hd__o21ai_0
X$10756 VDD synth_5348 synth_5160 synth_5380 VDD synth_5208 VNB|VSS VNB|VSS
+ sky130_fd_sc_hd__o21ai_0
X$10757 VDD synth_7533 synth_7183 synth_7569 VDD synth_7614 VNB|VSS VNB|VSS
+ sky130_fd_sc_hd__o21ai_0
X$10758 VDD synth_6365 synth_6411 synth_6582 VDD synth_6509 VNB|VSS VNB|VSS
+ sky130_fd_sc_hd__o21ai_0
X$10759 VDD synth_6140 synth_6226 synth_6225 VDD synth_6294 VNB|VSS VNB|VSS
+ sky130_fd_sc_hd__o21ai_0
X$10760 VDD synth_946 synth_1067 synth_1247 VDD synth_1245 VNB|VSS VNB|VSS
+ sky130_fd_sc_hd__o21ai_0
X$10761 VDD synth_10707 synth_10568 synth_10686 VDD synth_10830 VNB|VSS VNB|VSS
+ sky130_fd_sc_hd__o21ai_0
X$10762 VDD synth_525 synth_495 synth_496 VDD synth_631 VNB|VSS VNB|VSS
+ sky130_fd_sc_hd__o21ai_0
X$10763 VDD synth_4022 synth_3822 synth_4023 VDD synth_4096 VNB|VSS VNB|VSS
+ sky130_fd_sc_hd__o21ai_0
X$10764 VDD synth_2126 synth_66 synth_2127 VDD synth_2159 VNB|VSS VNB|VSS
+ sky130_fd_sc_hd__o21ai_0
X$10765 VDD synth_4186 synth_4157 synth_4239 VDD synth_4155 VNB|VSS VNB|VSS
+ sky130_fd_sc_hd__o21ai_0
X$10766 VDD synth_10166 synth_10163 synth_10165 VDD synth_10197 VNB|VSS VNB|VSS
+ sky130_fd_sc_hd__o21ai_0
X$10767 VDD synth_6462 synth_6461 synth_6557 VDD synth_6486 VNB|VSS VNB|VSS
+ sky130_fd_sc_hd__o21ai_0
X$10768 VDD synth_5256 synth_3468 synth_5257 VDD synth_5319 VNB|VSS VNB|VSS
+ sky130_fd_sc_hd__o21ai_0
X$10769 VDD synth_7974 synth_8219 synth_8239 VDD synth_8216 VNB|VSS VNB|VSS
+ sky130_fd_sc_hd__o21ai_0
X$10770 VDD synth_6176 synth_6217 synth_6219 VDD synth_6175 VNB|VSS VNB|VSS
+ sky130_fd_sc_hd__o21ai_0
X$10771 VDD synth_9474 synth_10773 synth_8870 VDD synth_10698 VNB|VSS VNB|VSS
+ sky130_fd_sc_hd__o21ai_0
X$10772 VDD synth_9677 synth_9895 synth_9239 VDD synth_10411 VNB|VSS VNB|VSS
+ sky130_fd_sc_hd__o21ai_0
X$10773 VDD synth_11899 synth_11850 synth_12022 VDD synth_12021 VNB|VSS VNB|VSS
+ sky130_fd_sc_hd__o21ai_0
X$10774 VDD synth_5806 synth_5805 synth_5892 VDD synth_5864 VNB|VSS VNB|VSS
+ sky130_fd_sc_hd__o21ai_0
X$10775 VDD synth_1528 synth_1454 synth_1545 VDD synth_1392 VNB|VSS VNB|VSS
+ sky130_fd_sc_hd__o21ai_0
X$10776 VDD synth_8322 synth_8172 synth_8390 VDD synth_8605 VNB|VSS VNB|VSS
+ sky130_fd_sc_hd__o21ai_0
X$10777 VDD synth_8318 synth_8167 synth_8438 VDD synth_8439 VNB|VSS VNB|VSS
+ sky130_fd_sc_hd__o21ai_0
X$10778 VDD synth_10001 synth_10094 synth_8738 VDD synth_9984 VNB|VSS VNB|VSS
+ sky130_fd_sc_hd__o21ai_0
X$10779 VDD synth_9540 synth_7089 synth_9406 VDD synth_9490 VNB|VSS VNB|VSS
+ sky130_fd_sc_hd__o21ai_0
X$10780 VDD synth_6443 synth_7186 synth_6740 VDD synth_7225 VNB|VSS VNB|VSS
+ sky130_fd_sc_hd__o21ai_0
X$10781 VDD synth_5851 synth_5939 synth_5824 VDD synth_5849 VNB|VSS VNB|VSS
+ sky130_fd_sc_hd__o21ai_0
X$10782 VDD synth_12738 synth_12572 synth_12739 VDD synth_12770 VNB|VSS VNB|VSS
+ sky130_fd_sc_hd__o21ai_0
X$10783 VDD synth_10521 synth_10669 synth_10398 VDD synth_10463 VNB|VSS VNB|VSS
+ sky130_fd_sc_hd__o21ai_0
X$10784 VDD synth_6796 synth_6597 synth_6893 VDD synth_6798 VNB|VSS VNB|VSS
+ sky130_fd_sc_hd__o21ai_0
X$10785 VDD synth_7392 synth_7533 synth_7693 VDD synth_7570 VNB|VSS VNB|VSS
+ sky130_fd_sc_hd__o21ai_0
X$10786 VDD synth_5975 synth_3544 synth_6118 VDD synth_6034 VNB|VSS VNB|VSS
+ sky130_fd_sc_hd__o21ai_0
X$10787 VDD synth_7215 synth_6696 synth_6471 VDD synth_7271 VNB|VSS VNB|VSS
+ sky130_fd_sc_hd__o21ai_0
X$10788 VDD synth_3092 synth_3035 synth_3113 VDD synth_3090 VNB|VSS VNB|VSS
+ sky130_fd_sc_hd__o21ai_0
X$10789 VDD synth_10316 synth_10317 synth_10259 VDD synth_10333 VNB|VSS VNB|VSS
+ sky130_fd_sc_hd__o21ai_0
X$10790 VDD synth_6230 synth_6143 synth_6369 VDD synth_6512 VNB|VSS VNB|VSS
+ sky130_fd_sc_hd__o21ai_0
X$10791 VDD synth_11072 synth_11074 synth_11150 VDD synth_10995 VNB|VSS VNB|VSS
+ sky130_fd_sc_hd__o21ai_0
X$10792 VDD synth_9824 synth_10511 synth_9112 VDD synth_11168 VNB|VSS VNB|VSS
+ sky130_fd_sc_hd__o21ai_0
X$10793 VDD synth_3930 synth_1353 synth_4059 VDD synth_3861 VNB|VSS VNB|VSS
+ sky130_fd_sc_hd__o21ai_0
X$10794 VDD synth_8396 synth_8176 synth_8135 VDD synth_8419 VNB|VSS VNB|VSS
+ sky130_fd_sc_hd__o21ai_0
X$10795 VDD synth_5344 synth_4818 synth_5422 VDD synth_5674 VNB|VSS VNB|VSS
+ sky130_fd_sc_hd__o21ai_0
X$10796 VDD synth_4446 synth_4359 synth_4529 VDD synth_4567 VNB|VSS VNB|VSS
+ sky130_fd_sc_hd__o21ai_0
X$10797 VDD synth_1099 synth_1086 synth_1143 VDD synth_1148 VNB|VSS VNB|VSS
+ sky130_fd_sc_hd__o21ai_0
X$10798 VDD synth_8918 synth_8804 synth_8872 VDD synth_8917 VNB|VSS VNB|VSS
+ sky130_fd_sc_hd__o21ai_0
X$10799 VDD synth_1391 synth_1067 synth_1503 VDD synth_1550 VNB|VSS VNB|VSS
+ sky130_fd_sc_hd__o21ai_0
X$10800 VDD synth_6403 synth_5196 synth_6434 VDD synth_6917 VNB|VSS VNB|VSS
+ sky130_fd_sc_hd__o21ai_0
X$10801 VDD synth_4457 synth_4943 synth_4456 VDD synth_5092 VNB|VSS VNB|VSS
+ sky130_fd_sc_hd__o21ai_0
X$10802 VDD synth_1504 synth_1469 synth_1616 VDD synth_1551 VNB|VSS VNB|VSS
+ sky130_fd_sc_hd__o21ai_0
X$10803 VDD synth_7865 synth_7794 synth_7958 VDD synth_7957 VNB|VSS VNB|VSS
+ sky130_fd_sc_hd__o21ai_0
X$10804 VDD synth_3481 synth_3663 synth_3716 VDD synth_3645 VNB|VSS VNB|VSS
+ sky130_fd_sc_hd__o21ai_0
X$10805 VDD synth_7189 synth_7187 synth_7257 VDD synth_7228 VNB|VSS VNB|VSS
+ sky130_fd_sc_hd__o21ai_0
X$10806 VDD synth_4592 synth_4656 synth_4655 VDD synth_4638 VNB|VSS VNB|VSS
+ sky130_fd_sc_hd__o21ai_0
X$10807 VDD synth_10821 synth_10625 synth_10626 VDD synth_10603 VNB|VSS VNB|VSS
+ sky130_fd_sc_hd__o21ai_0
X$10808 VDD synth_9364 synth_7089 synth_9492 VDD synth_9456 VNB|VSS VNB|VSS
+ sky130_fd_sc_hd__o21ai_0
X$10809 VDD synth_1052 synth_1272 synth_1186 VDD synth_1051 VNB|VSS VNB|VSS
+ sky130_fd_sc_hd__o21ai_0
X$10810 VDD synth_7393 synth_6597 synth_7396 VDD synth_7535 VNB|VSS VNB|VSS
+ sky130_fd_sc_hd__o21ai_0
X$10811 VDD synth_7685 synth_7586 synth_7962 VDD synth_7618 VNB|VSS VNB|VSS
+ sky130_fd_sc_hd__o21ai_0
X$10812 VDD synth_1882 synth_2096 synth_2169 VDD synth_2170 VNB|VSS VNB|VSS
+ sky130_fd_sc_hd__o21ai_0
X$10813 VDD synth_162 synth_234 synth_303 VDD synth_101 VNB|VSS VNB|VSS
+ sky130_fd_sc_hd__o21ai_0
X$10814 VDD synth_68 synth_234 synth_406 VDD synth_24 VNB|VSS VNB|VSS
+ sky130_fd_sc_hd__o21ai_0
X$10815 VDD synth_2366 synth_927 synth_2491 VDD synth_2490 VNB|VSS VNB|VSS
+ sky130_fd_sc_hd__o21ai_0
X$10816 VDD synth_3100 synth_3161 synth_3162 VDD synth_3199 VNB|VSS VNB|VSS
+ sky130_fd_sc_hd__o21ai_0
X$10817 VDD synth_5813 synth_3632 synth_5960 VDD synth_5872 VNB|VSS VNB|VSS
+ sky130_fd_sc_hd__o21ai_0
X$10818 VDD synth_7496 synth_7418 synth_7525 VDD synth_7526 VNB|VSS VNB|VSS
+ sky130_fd_sc_hd__o21ai_0
X$10819 VDD synth_8870 synth_10577 synth_8764 VDD synth_10620 VNB|VSS VNB|VSS
+ sky130_fd_sc_hd__o21ai_0
X$10820 VDD synth_9119 synth_9518 synth_9435 VDD synth_9436 VNB|VSS VNB|VSS
+ sky130_fd_sc_hd__o21ai_0
X$10821 VDD synth_3155 synth_2116 synth_3231 VDD synth_3173 VNB|VSS VNB|VSS
+ sky130_fd_sc_hd__o21ai_0
X$10822 VDD synth_800 synth_659 synth_846 VDD synth_771 VNB|VSS VNB|VSS
+ sky130_fd_sc_hd__o21ai_0
X$10823 VDD synth_5000 synth_3541 synth_5031 VDD synth_4952 VNB|VSS VNB|VSS
+ sky130_fd_sc_hd__o21ai_0
X$10824 VDD synth_10701 synth_10700 synth_10744 VDD synth_10803 VNB|VSS VNB|VSS
+ sky130_fd_sc_hd__o21ai_0
X$10825 VDD synth_9434 synth_10485 synth_10439 VDD synth_10484 VNB|VSS VNB|VSS
+ sky130_fd_sc_hd__o21ai_0
X$10826 VDD synth_158 synth_227 synth_244 VDD synth_154 VNB|VSS VNB|VSS
+ sky130_fd_sc_hd__o21ai_0
X$10827 VDD synth_6978 synth_7038 synth_7071 VDD synth_7073 VNB|VSS VNB|VSS
+ sky130_fd_sc_hd__o21ai_0
X$10828 VDD synth_12459 synth_12513 synth_12632 VDD synth_12551 VNB|VSS VNB|VSS
+ sky130_fd_sc_hd__o21ai_0
X$10829 VDD synth_1351 synth_1352 synth_1430 VDD synth_1482 VNB|VSS VNB|VSS
+ sky130_fd_sc_hd__o21ai_0
X$10830 VDD synth_10578 synth_10987 synth_10414 VDD synth_10828 VNB|VSS VNB|VSS
+ sky130_fd_sc_hd__o21ai_0
X$10831 VDD synth_1720 synth_1721 synth_1619 VDD synth_1690 VNB|VSS VNB|VSS
+ sky130_fd_sc_hd__o21ai_0
X$10832 VDD synth_7419 synth_7418 synth_7497 VDD synth_7443 VNB|VSS VNB|VSS
+ sky130_fd_sc_hd__o21ai_0
X$10833 VDD synth_2870 synth_3032 synth_3150 VDD synth_3034 VNB|VSS VNB|VSS
+ sky130_fd_sc_hd__o21ai_0
X$10834 VDD synth_5718 synth_5747 synth_5964 VDD synth_5672 VNB|VSS VNB|VSS
+ sky130_fd_sc_hd__o21ai_0
X$10835 VDD synth_3032 synth_2116 synth_3151 VDD synth_3085 VNB|VSS VNB|VSS
+ sky130_fd_sc_hd__o21ai_0
X$10836 VDD synth_1434 synth_1180 synth_1330 VDD synth_1329 VNB|VSS VNB|VSS
+ sky130_fd_sc_hd__o21ai_0
X$10837 VDD synth_3058 synth_3226 synth_3166 VDD synth_3207 VNB|VSS VNB|VSS
+ sky130_fd_sc_hd__o21ai_0
X$10838 VDD synth_5196 synth_6220 synth_6061 VDD synth_6132 VNB|VSS VNB|VSS
+ sky130_fd_sc_hd__o21ai_0
X$10839 VDD synth_6133 synth_5196 synth_5966 VDD synth_6177 VNB|VSS VNB|VSS
+ sky130_fd_sc_hd__o21ai_0
X$10840 VDD synth_4063 synth_1338 synth_4178 VDD synth_4085 VNB|VSS VNB|VSS
+ sky130_fd_sc_hd__o21ai_0
X$10841 VDD synth_1180 synth_194 synth_1267 VDD synth_1326 VNB|VSS VNB|VSS
+ sky130_fd_sc_hd__o21ai_0
X$10842 VDD synth_2806 synth_2983 synth_2968 VDD synth_2988 VNB|VSS VNB|VSS
+ sky130_fd_sc_hd__o21ai_0
X$10843 VDD synth_5037 synth_4747 synth_4748 VDD synth_4978 VNB|VSS VNB|VSS
+ sky130_fd_sc_hd__o21ai_0
X$10844 VDD synth_10713 synth_9762 synth_10716 VDD synth_10714 VNB|VSS VNB|VSS
+ sky130_fd_sc_hd__o21ai_0
X$10845 VDD synth_4823 synth_4904 synth_5003 VDD synth_4769 VNB|VSS VNB|VSS
+ sky130_fd_sc_hd__o21ai_0
X$10846 VDD synth_4432 synth_4407 synth_4784 VDD synth_4783 VNB|VSS VNB|VSS
+ sky130_fd_sc_hd__o21ai_0
X$10847 VDD synth_1198 synth_1201 synth_1305 VDD synth_1301 VNB|VSS VNB|VSS
+ sky130_fd_sc_hd__o21ai_0
X$10848 VDD synth_175 synth_201 synth_200 VDD synth_310 VNB|VSS VNB|VSS
+ sky130_fd_sc_hd__o21ai_0
X$10849 VDD synth_203 synth_201 synth_202 VDD synth_468 VNB|VSS VNB|VSS
+ sky130_fd_sc_hd__o21ai_0
X$10850 VDD synth_12102 synth_11848 synth_12134 VDD synth_12194 VNB|VSS VNB|VSS
+ sky130_fd_sc_hd__o21ai_0
X$10851 VDD synth_10613 synth_9762 synth_10762 VDD synth_10761 VNB|VSS VNB|VSS
+ sky130_fd_sc_hd__o21ai_0
X$10852 VDD synth_179 synth_505 synth_586 VDD synth_504 VNB|VSS VNB|VSS
+ sky130_fd_sc_hd__o21ai_0
X$10853 VDD synth_10791 synth_9423 synth_10914 VDD synth_10764 VNB|VSS VNB|VSS
+ sky130_fd_sc_hd__o21ai_0
X$10854 VDD synth_12443 synth_9423 synth_12720 VDD synth_12749 VNB|VSS VNB|VSS
+ sky130_fd_sc_hd__o21ai_0
X$10855 VDD synth_6521 synth_6548 synth_6549 VDD synth_6547 VNB|VSS VNB|VSS
+ sky130_fd_sc_hd__o21ai_0
X$10856 VDD synth_3564 synth_3471 synth_3472 VDD synth_3436 VNB|VSS VNB|VSS
+ sky130_fd_sc_hd__o21ai_0
X$10857 VDD synth_11193 synth_11346 synth_11296 VDD synth_11233 VNB|VSS VNB|VSS
+ sky130_fd_sc_hd__o21ai_0
X$10858 VDD synth_6000 synth_5999 synth_6099 VDD synth_6258 VNB|VSS VNB|VSS
+ sky130_fd_sc_hd__o21ai_0
X$10859 VDD synth_8870 synth_10007 synth_9907 VDD synth_10222 VNB|VSS VNB|VSS
+ sky130_fd_sc_hd__o21ai_0
X$10860 VDD synth_1434 synth_1562 synth_1508 VDD synth_1563 VNB|VSS VNB|VSS
+ sky130_fd_sc_hd__o21ai_0
X$10861 VDD synth_1334 synth_1353 synth_1885 VDD synth_1861 VNB|VSS VNB|VSS
+ sky130_fd_sc_hd__o21ai_0
X$10862 VDD synth_1014 synth_659 synth_1237 VDD synth_1169 VNB|VSS VNB|VSS
+ sky130_fd_sc_hd__o21ai_0
X$10863 VDD synth_6077 synth_3468 synth_6115 VDD synth_6045 VNB|VSS VNB|VSS
+ sky130_fd_sc_hd__o21ai_0
X$10864 VDD synth_12631 synth_12459 synth_12577 VDD synth_12790 VNB|VSS VNB|VSS
+ sky130_fd_sc_hd__o21ai_0
X$10865 VDD synth_6439 synth_6435 synth_6438 VDD synth_6494 VNB|VSS VNB|VSS
+ sky130_fd_sc_hd__o21ai_0
X$10866 VDD synth_8600 synth_8325 synth_8425 VDD synth_8681 VNB|VSS VNB|VSS
+ sky130_fd_sc_hd__o21ai_0
X$10867 VDD synth_8475 synth_8325 synth_8424 VDD synth_8602 VNB|VSS VNB|VSS
+ sky130_fd_sc_hd__o21ai_0
X$10868 VDD synth_4922 synth_4920 synth_4897 VDD synth_4981 VNB|VSS VNB|VSS
+ sky130_fd_sc_hd__o21ai_0
X$10869 VDD synth_1543 synth_1421 synth_1540 VDD synth_1541 VNB|VSS VNB|VSS
+ sky130_fd_sc_hd__o21ai_0
X$10870 VDD synth_389 synth_263 synth_465 VDD synth_239 VNB|VSS VNB|VSS
+ sky130_fd_sc_hd__o21ai_0
X$10871 VDD synth_4827 synth_4580 synth_4864 VDD synth_4956 VNB|VSS VNB|VSS
+ sky130_fd_sc_hd__o21ai_0
X$10872 VDD synth_179 synth_312 synth_313 VDD synth_136 VNB|VSS VNB|VSS
+ sky130_fd_sc_hd__o21ai_0
X$10873 VDD synth_75 synth_204 synth_314 VDD synth_40 VNB|VSS VNB|VSS
+ sky130_fd_sc_hd__o21ai_0
X$10874 VDD synth_4918 synth_5014 synth_5046 VDD synth_4729 VNB|VSS VNB|VSS
+ sky130_fd_sc_hd__o21ai_0
X$10875 VDD synth_6302 synth_6379 synth_6414 VDD synth_6336 VNB|VSS VNB|VSS
+ sky130_fd_sc_hd__o21ai_0
X$10876 VDD synth_9239 synth_9240 synth_9385 VDD synth_9238 VNB|VSS VNB|VSS
+ sky130_fd_sc_hd__o21ai_0
X$10877 VDD synth_8454 synth_8536 synth_8584 VDD synth_8310 VNB|VSS VNB|VSS
+ sky130_fd_sc_hd__o21ai_0
X$10878 VDD synth_1416 synth_151 synth_1441 VDD synth_1362 VNB|VSS VNB|VSS
+ sky130_fd_sc_hd__o21ai_0
X$10879 VDD synth_10711 synth_10710 synth_10757 VDD synth_10758 VNB|VSS VNB|VSS
+ sky130_fd_sc_hd__o21ai_0
X$10880 VDD synth_11088 synth_9423 synth_11089 VDD synth_11133 VNB|VSS VNB|VSS
+ sky130_fd_sc_hd__o21ai_0
X$10881 VDD synth_5897 synth_5813 synth_5898 VDD synth_5871 VNB|VSS VNB|VSS
+ sky130_fd_sc_hd__o21ai_0
X$10882 VDD synth_5065 synth_3632 synth_5221 VDD synth_5116 VNB|VSS VNB|VSS
+ sky130_fd_sc_hd__o21ai_0
X$10883 VDD synth_7401 synth_7553 synth_7469 VDD synth_7630 VNB|VSS VNB|VSS
+ sky130_fd_sc_hd__o21ai_0
X$10884 VDD synth_1574 synth_659 synth_1698 VDD synth_1667 VNB|VSS VNB|VSS
+ sky130_fd_sc_hd__o21ai_0
X$10885 VDD synth_9119 synth_8806 synth_8831 VDD synth_9740 VNB|VSS VNB|VSS
+ sky130_fd_sc_hd__o21ai_0
X$10886 VDD synth_903 synth_194 synth_980 VDD synth_1037 VNB|VSS VNB|VSS
+ sky130_fd_sc_hd__o21ai_0
X$10887 VDD synth_5562 synth_5336 synth_5393 VDD synth_5592 VNB|VSS VNB|VSS
+ sky130_fd_sc_hd__o21ai_0
X$10888 VDD synth_7401 synth_7174 synth_7552 VDD synth_7402 VNB|VSS VNB|VSS
+ sky130_fd_sc_hd__o21ai_0
X$10889 VDD synth_9329 synth_9236 synth_9330 VDD synth_9237 VNB|VSS VNB|VSS
+ sky130_fd_sc_hd__o21ai_0
X$10890 VDD synth_7107 synth_7197 synth_7198 VDD synth_7178 VNB|VSS VNB|VSS
+ sky130_fd_sc_hd__o21ai_0
X$10891 VDD synth_9947 synth_10024 synth_10187 VDD synth_9018 VNB|VSS VNB|VSS
+ sky130_fd_sc_hd__o21ai_0
X$10892 VDD synth_9928 synth_9977 synth_8805 VDD synth_9853 VNB|VSS VNB|VSS
+ sky130_fd_sc_hd__o21ai_0
X$10893 VDD synth_7378 synth_7183 synth_7487 VDD synth_7466 VNB|VSS VNB|VSS
+ sky130_fd_sc_hd__o21ai_0
X$10894 VDD synth_7400 synth_7379 synth_7377 VDD synth_7549 VNB|VSS VNB|VSS
+ sky130_fd_sc_hd__o21ai_0
X$10895 VDD synth_10466 synth_10564 synth_10672 VDD synth_10562 VNB|VSS VNB|VSS
+ sky130_fd_sc_hd__o21ai_0
X$10896 VDD synth_3377 synth_3228 synth_3356 VDD synth_3279 VNB|VSS VNB|VSS
+ sky130_fd_sc_hd__o21ai_0
X$10897 VDD synth_5324 synth_5243 synth_5368 VDD synth_5244 VNB|VSS VNB|VSS
+ sky130_fd_sc_hd__o21ai_0
X$10898 VDD synth_7238 synth_7197 synth_7237 VDD synth_7177 VNB|VSS VNB|VSS
+ sky130_fd_sc_hd__o21ai_0
X$10899 VDD synth_3639 synth_3685 synth_3636 VDD synth_3702 VNB|VSS VNB|VSS
+ sky130_fd_sc_hd__o21ai_0
X$10900 VDD synth_5560 synth_5252 synth_5594 VDD synth_5561 VNB|VSS VNB|VSS
+ sky130_fd_sc_hd__o21ai_0
X$10901 VDD synth_9041 synth_8804 synth_9387 VDD synth_9328 VNB|VSS VNB|VSS
+ sky130_fd_sc_hd__o21ai_0
X$10902 VDD synth_12390 synth_12224 synth_12272 VDD synth_12338 VNB|VSS VNB|VSS
+ sky130_fd_sc_hd__o21ai_0
X$10903 VDD synth_6307 synth_6108 synth_6330 VDD synth_6324 VNB|VSS VNB|VSS
+ sky130_fd_sc_hd__o21ai_0
X$10904 VDD synth_9119 synth_9203 synth_9435 VDD synth_9547 VNB|VSS VNB|VSS
+ sky130_fd_sc_hd__o21ai_0
X$10905 VDD synth_1060 synth_1059 synth_1096 VDD synth_1152 VNB|VSS VNB|VSS
+ sky130_fd_sc_hd__o21ai_0
X$10906 VDD synth_11432 synth_11312 synth_11361 VDD synth_11433 VNB|VSS VNB|VSS
+ sky130_fd_sc_hd__o21ai_0
X$10907 VDD synth_9901 synth_9985 synth_9824 VDD synth_9908 VNB|VSS VNB|VSS
+ sky130_fd_sc_hd__o21ai_0
X$10908 VDD synth_7081 synth_7101 synth_7192 VDD synth_7078 VNB|VSS VNB|VSS
+ sky130_fd_sc_hd__o21ai_0
X$10909 VDD synth_4770 synth_5055 synth_5191 VDD synth_5192 VNB|VSS VNB|VSS
+ sky130_fd_sc_hd__o21ai_0
X$10910 VDD synth_10615 synth_11218 synth_9474 VDD synth_11360 VNB|VSS VNB|VSS
+ sky130_fd_sc_hd__o21ai_0
X$10911 VDD synth_8946 synth_9379 synth_9063 VDD synth_9376 VNB|VSS VNB|VSS
+ sky130_fd_sc_hd__o21ai_0
X$10912 VDD synth_6153 synth_6299 synth_6421 VDD synth_6378 VNB|VSS VNB|VSS
+ sky130_fd_sc_hd__o21ai_0
X$10913 VDD synth_9695 synth_10006 synth_9978 VDD synth_10161 VNB|VSS VNB|VSS
+ sky130_fd_sc_hd__o21ai_0
X$10914 VDD synth_9387 synth_10354 synth_10173 VDD synth_10353 VNB|VSS VNB|VSS
+ sky130_fd_sc_hd__o21ai_0
X$10915 VDD synth_5224 synth_5068 synth_5139 VDD synth_5120 VNB|VSS VNB|VSS
+ sky130_fd_sc_hd__o21ai_0
X$10916 VDD synth_8764 synth_9390 synth_9514 VDD synth_9482 VNB|VSS VNB|VSS
+ sky130_fd_sc_hd__o21ai_0
X$10917 VDD synth_7224 synth_4961 synth_7210 VDD synth_7123 VNB|VSS VNB|VSS
+ sky130_fd_sc_hd__o21ai_0
X$10918 VDD synth_2338 synth_2537 synth_2563 VDD synth_2458 VNB|VSS VNB|VSS
+ sky130_fd_sc_hd__o21ai_0
X$10919 VDD synth_5957 synth_5809 synth_6068 VDD synth_5810 VNB|VSS VNB|VSS
+ sky130_fd_sc_hd__o21ai_0
X$10920 VDD synth_6906 synth_6920 synth_7043 VDD synth_6921 VNB|VSS VNB|VSS
+ sky130_fd_sc_hd__o21ai_0
X$10921 VDD synth_6295 synth_6232 synth_6416 VDD synth_6296 VNB|VSS VNB|VSS
+ sky130_fd_sc_hd__o21ai_0
X$10922 VDD synth_2245 synth_2204 synth_2345 VDD synth_2306 VNB|VSS VNB|VSS
+ sky130_fd_sc_hd__o21ai_0
X$10923 VDD synth_9288 synth_9111 synth_9289 VDD synth_9149 VNB|VSS VNB|VSS
+ sky130_fd_sc_hd__o21ai_0
X$10924 VDD synth_9235 synth_9559 synth_9905 VDD synth_9614 VNB|VSS VNB|VSS
+ sky130_fd_sc_hd__o21ai_0
X$10925 VDD synth_5623 synth_4961 synth_5689 VDD synth_5696 VNB|VSS VNB|VSS
+ sky130_fd_sc_hd__o21ai_0
X$10926 VDD synth_6419 synth_6548 synth_6447 VDD synth_6372 VNB|VSS VNB|VSS
+ sky130_fd_sc_hd__o21ai_0
X$10927 VDD synth_11698 synth_11487 synth_11618 VDD synth_11700 VNB|VSS VNB|VSS
+ sky130_fd_sc_hd__o21ai_0
X$10928 VDD synth_10741 synth_10700 synth_10743 VDD synth_10876 VNB|VSS VNB|VSS
+ sky130_fd_sc_hd__o21ai_0
X$10929 VDD synth_1816 synth_1738 synth_1926 VDD synth_1889 VNB|VSS VNB|VSS
+ sky130_fd_sc_hd__o21ai_0
X$10930 VDD synth_12260 synth_9762 synth_12573 VDD synth_12509 VNB|VSS VNB|VSS
+ sky130_fd_sc_hd__o21ai_0
X$10931 VDD synth_9292 synth_11010 synth_9583 VDD synth_10938 VNB|VSS VNB|VSS
+ sky130_fd_sc_hd__o21ai_0
X$10932 VDD synth_1061 synth_1062 synth_1156 VDD synth_1155 VNB|VSS VNB|VSS
+ sky130_fd_sc_hd__o21ai_0
X$10933 VDD synth_2767 synth_2590 synth_2660 VDD synth_2766 VNB|VSS VNB|VSS
+ sky130_fd_sc_hd__o21ai_0
X$10934 VDD synth_9852 synth_9177 synth_9853 VDD synth_9587 VNB|VSS VNB|VSS
+ sky130_fd_sc_hd__o21ai_0
X$10935 VDD synth_6405 synth_6457 synth_6578 VDD synth_6320 VNB|VSS VNB|VSS
+ sky130_fd_sc_hd__o21ai_0
X$10936 VDD synth_11191 synth_11147 synth_11193 VDD synth_11702 VNB|VSS VNB|VSS
+ sky130_fd_sc_hd__o21ai_0
X$10937 VDD synth_683 synth_682 synth_704 VDD synth_705 VNB|VSS VNB|VSS
+ sky130_fd_sc_hd__o21ai_0
X$10938 VDD synth_7044 synth_6920 synth_6984 VDD synth_7141 VNB|VSS VNB|VSS
+ sky130_fd_sc_hd__o21ai_0
X$10939 VDD synth_5289 synth_5243 synth_5323 VDD synth_5288 VNB|VSS VNB|VSS
+ sky130_fd_sc_hd__o21ai_0
X$10940 VDD synth_646 synth_682 synth_783 VDD synth_572 VNB|VSS VNB|VSS
+ sky130_fd_sc_hd__o21ai_0
X$10941 VDD synth_1761 synth_1794 synth_1870 VDD synth_1793 VNB|VSS VNB|VSS
+ sky130_fd_sc_hd__o21ai_0
X$10942 VDD synth_5995 synth_5851 synth_6084 VDD synth_6106 VNB|VSS VNB|VSS
+ sky130_fd_sc_hd__o21ai_0
X$10943 VDD synth_5800 synth_5801 synth_5883 VDD synth_5852 VNB|VSS VNB|VSS
+ sky130_fd_sc_hd__o21ai_0
X$10944 VDD synth_7155 synth_7208 synth_7352 VDD synth_7353 VNB|VSS VNB|VSS
+ sky130_fd_sc_hd__o21ai_0
X$10945 VDD synth_2586 synth_2628 synth_2655 VDD synth_2711 VNB|VSS VNB|VSS
+ sky130_fd_sc_hd__o21ai_0
X$10946 VDD synth_2725 synth_2843 synth_2925 VDD synth_2650 VNB|VSS VNB|VSS
+ sky130_fd_sc_hd__o21ai_0
X$10947 VDD synth_6456 synth_6457 synth_6580 VDD synth_6500 VNB|VSS VNB|VSS
+ sky130_fd_sc_hd__o21ai_0
X$10948 VDD synth_1002 synth_66 synth_1033 VDD synth_955 VNB|VSS VNB|VSS
+ sky130_fd_sc_hd__o21ai_0
X$10949 VDD synth_2870 synth_3154 synth_3012 VDD synth_3031 VNB|VSS VNB|VSS
+ sky130_fd_sc_hd__o21ai_0
X$10950 VDD synth_2359 synth_167 synth_2488 VDD synth_2487 VNB|VSS VNB|VSS
+ sky130_fd_sc_hd__o21ai_0
X$10951 VDD synth_5885 synth_5801 synth_5884 VDD synth_5854 VNB|VSS VNB|VSS
+ sky130_fd_sc_hd__o21ai_0
X$10952 VDD synth_2877 synth_2876 synth_2964 VDD synth_2960 VNB|VSS VNB|VSS
+ sky130_fd_sc_hd__o21ai_0
X$10953 VDD synth_11532 synth_9762 synth_11569 VDD synth_11711 VNB|VSS VNB|VSS
+ sky130_fd_sc_hd__o21ai_0
X$10954 VDD synth_9239 synth_10510 synth_10445 VDD synth_10374 VNB|VSS VNB|VSS
+ sky130_fd_sc_hd__o21ai_0
X$10955 VDD synth_4149 synth_4230 synth_4229 VDD synth_4152 VNB|VSS VNB|VSS
+ sky130_fd_sc_hd__o21ai_0
X$10956 VDD synth_6165 synth_6264 synth_6383 VDD synth_6318 VNB|VSS VNB|VSS
+ sky130_fd_sc_hd__o21ai_0
X$10957 VDD synth_7505 synth_7506 synth_7128 VDD synth_7429 VNB|VSS VNB|VSS
+ sky130_fd_sc_hd__o21ai_0
X$10958 VDD synth_3754 synth_3793 synth_3819 VDD synth_3869 VNB|VSS VNB|VSS
+ sky130_fd_sc_hd__o21ai_0
X$10959 VDD synth_1936 synth_1353 synth_1808 VDD synth_1856 VNB|VSS VNB|VSS
+ sky130_fd_sc_hd__o21ai_0
X$10960 VDD synth_2819 synth_659 synth_2932 VDD synth_2891 VNB|VSS VNB|VSS
+ sky130_fd_sc_hd__o21ai_0
X$10961 VDD synth_9988 synth_10200 synth_10199 VDD synth_10300 VNB|VSS VNB|VSS
+ sky130_fd_sc_hd__o21ai_0
X$10962 VDD synth_4738 synth_2116 synth_4839 VDD synth_4667 VNB|VSS VNB|VSS
+ sky130_fd_sc_hd__o21ai_0
X$10963 VDD synth_7556 synth_7370 synth_7557 VDD synth_7468 VNB|VSS VNB|VSS
+ sky130_fd_sc_hd__o21ai_0
X$10964 VDD synth_7405 synth_7370 synth_7489 VDD synth_7404 VNB|VSS VNB|VSS
+ sky130_fd_sc_hd__o21ai_0
X$10965 VDD synth_3136 synth_3044 synth_3081 VDD synth_3139 VNB|VSS VNB|VSS
+ sky130_fd_sc_hd__o21ai_0
X$10966 VDD synth_9429 synth_10175 synth_10212 VDD synth_10176 VNB|VSS VNB|VSS
+ sky130_fd_sc_hd__o21ai_0
X$10967 VDD synth_12053 synth_12152 synth_9175 VDD synth_11976 VNB|VSS VNB|VSS
+ sky130_fd_sc_hd__o21ai_0
X$10968 VDD synth_8702 synth_9033 synth_8997 VDD synth_8978 VNB|VSS VNB|VSS
+ sky130_fd_sc_hd__o21ai_0
X$10969 VDD synth_9922 synth_9423 synth_10091 VDD synth_10000 VNB|VSS VNB|VSS
+ sky130_fd_sc_hd__o21ai_0
X$10970 VDD synth_10251 synth_10295 synth_10297 VDD synth_10225 VNB|VSS VNB|VSS
+ sky130_fd_sc_hd__o21ai_0
X$10971 VDD synth_5567 synth_4747 synth_5584 VDD synth_5583 VNB|VSS VNB|VSS
+ sky130_fd_sc_hd__o21ai_0
X$10972 VDD synth_5051 synth_5050 synth_5090 VDD synth_5122 VNB|VSS VNB|VSS
+ sky130_fd_sc_hd__o21ai_0
X$10973 VDD synth_6006 synth_6253 synth_6255 VDD synth_6172 VNB|VSS VNB|VSS
+ sky130_fd_sc_hd__o21ai_0
X$10974 VDD synth_671 synth_614 synth_720 VDD synth_799 VNB|VSS VNB|VSS
+ sky130_fd_sc_hd__o21ai_0
X$10975 VDD synth_252 synth_210 synth_254 VDD synth_133 VNB|VSS VNB|VSS
+ sky130_fd_sc_hd__o21ai_0
X$10976 VDD synth_10312 synth_9061 synth_11467 VDD synth_11387 VNB|VSS VNB|VSS
+ sky130_fd_sc_hd__o21ai_0
X$10977 VDD synth_8594 synth_7183 synth_8908 VDD synth_8909 VNB|VSS VNB|VSS
+ sky130_fd_sc_hd__o21ai_0
X$10978 VDD synth_8907 synth_8754 synth_8792 VDD synth_8911 VNB|VSS VNB|VSS
+ sky130_fd_sc_hd__o21ai_0
X$10979 VDD synth_10060 synth_10169 synth_9387 VDD synth_11467 VNB|VSS VNB|VSS
+ sky130_fd_sc_hd__o21ai_0
X$10980 VDD synth_5396 synth_3541 synth_5399 VDD synth_5397 VNB|VSS VNB|VSS
+ sky130_fd_sc_hd__o21ai_0
X$10981 VDD synth_3776 synth_3647 synth_3713 VDD synth_3779 VNB|VSS VNB|VSS
+ sky130_fd_sc_hd__o21ai_0
X$10982 VDD synth_9629 synth_9233 synth_9850 VDD synth_10443 VNB|VSS VNB|VSS
+ sky130_fd_sc_hd__o21ai_0
X$10983 VDD synth_760 synth_912 synth_963 VDD synth_1053 VNB|VSS VNB|VSS
+ sky130_fd_sc_hd__o21ai_0
X$10984 VDD synth_5559 synth_5492 synth_5597 VDD synth_5609 VNB|VSS VNB|VSS
+ sky130_fd_sc_hd__o21ai_0
X$10985 VDD synth_2101 synth_1902 synth_2142 VDD synth_2291 VNB|VSS VNB|VSS
+ sky130_fd_sc_hd__o21ai_0
X$10986 VDD synth_5666 synth_3544 synth_5667 VDD synth_5785 VNB|VSS VNB|VSS
+ sky130_fd_sc_hd__o21ai_0
X$10987 VDD synth_9112 synth_10844 synth_12155 VDD synth_12154 VNB|VSS VNB|VSS
+ sky130_fd_sc_hd__o21ai_0
X$10988 VDD synth_3414 synth_927 synth_3577 VDD synth_3483 VNB|VSS VNB|VSS
+ sky130_fd_sc_hd__o21ai_0
X$10989 VDD synth_6288 synth_6214 synth_6351 VDD synth_6392 VNB|VSS VNB|VSS
+ sky130_fd_sc_hd__o21ai_0
X$10990 VDD synth_6162 synth_5851 synth_6187 VDD synth_6322 VNB|VSS VNB|VSS
+ sky130_fd_sc_hd__o21ai_0
X$10991 VDD synth_9434 synth_9324 synth_9615 VDD synth_10915 VNB|VSS VNB|VSS
+ sky130_fd_sc_hd__o21ai_0
X$10992 VDD synth_8084 synth_7111 synth_8055 VDD synth_8056 VNB|VSS VNB|VSS
+ sky130_fd_sc_hd__o21ai_0
X$10993 VDD synth_10263 synth_10164 synth_10403 VDD synth_10339 VNB|VSS VNB|VSS
+ sky130_fd_sc_hd__o21ai_0
X$10994 VDD synth_7931 synth_8000 synth_8081 VDD synth_8060 VNB|VSS VNB|VSS
+ sky130_fd_sc_hd__o21ai_0
X$10995 VDD synth_505 synth_194 synth_503 VDD synth_538 VNB|VSS VNB|VSS
+ sky130_fd_sc_hd__o21ai_0
X$10996 VDD synth_11532 synth_11452 synth_11533 VDD synth_11633 VNB|VSS VNB|VSS
+ sky130_fd_sc_hd__o21ai_0
X$10997 VDD synth_1050 synth_912 synth_990 VDD synth_913 VNB|VSS VNB|VSS
+ sky130_fd_sc_hd__o21ai_0
X$10998 VDD synth_5691 synth_5836 synth_5693 VDD synth_5835 VNB|VSS VNB|VSS
+ sky130_fd_sc_hd__o21ai_0
X$10999 VDD synth_165 synth_102 synth_196 VDD synth_105 VNB|VSS VNB|VSS
+ sky130_fd_sc_hd__o21ai_0
X$11000 VDD synth_10489 synth_10615 synth_9119 VDD synth_10487 VNB|VSS VNB|VSS
+ sky130_fd_sc_hd__o21ai_0
X$11001 VDD synth_4811 synth_4818 synth_5504 VDD synth_5653 VNB|VSS VNB|VSS
+ sky130_fd_sc_hd__o21ai_0
X$11002 VDD synth_613 synth_614 synth_670 VDD synth_654 VNB|VSS VNB|VSS
+ sky130_fd_sc_hd__o21ai_0
X$11003 VDD synth_2194 synth_1353 synth_2195 VDD synth_2171 VNB|VSS VNB|VSS
+ sky130_fd_sc_hd__o21ai_0
X$11004 VDD synth_10652 synth_11096 synth_9849 VDD synth_11222 VNB|VSS VNB|VSS
+ sky130_fd_sc_hd__o21ai_0
X$11005 VDD synth_664 synth_802 synth_803 VDD synth_784 VNB|VSS VNB|VSS
+ sky130_fd_sc_hd__o21ai_0
X$11006 VDD synth_10574 synth_10619 synth_9292 VDD synth_10575 VNB|VSS VNB|VSS
+ sky130_fd_sc_hd__o21ai_0
X$11007 VDD synth_8510 synth_7183 synth_8599 VDD synth_8513 VNB|VSS VNB|VSS
+ sky130_fd_sc_hd__o21ai_0
X$11008 VDD synth_8682 synth_8785 synth_8916 VDD synth_8985 VNB|VSS VNB|VSS
+ sky130_fd_sc_hd__o21ai_0
X$11009 VDD synth_5788 synth_5691 synth_5831 VDD synth_5876 VNB|VSS VNB|VSS
+ sky130_fd_sc_hd__o21ai_0
X$11010 VDD synth_11452 synth_11635 synth_11535 VDD synth_11534 VNB|VSS VNB|VSS
+ sky130_fd_sc_hd__o21ai_0
X$11011 VDD synth_2271 synth_2408 synth_2340 VDD synth_2319 VNB|VSS VNB|VSS
+ sky130_fd_sc_hd__o21ai_0
X$11012 VDD synth_1284 synth_151 synth_1443 VDD synth_1406 VNB|VSS VNB|VSS
+ sky130_fd_sc_hd__o21ai_0
X$11013 VDD synth_2348 synth_66 synth_2351 VDD synth_2388 VNB|VSS VNB|VSS
+ sky130_fd_sc_hd__o21ai_0
X$11014 VDD synth_9383 synth_9170 synth_9382 VDD synth_9287 VNB|VSS VNB|VSS
+ sky130_fd_sc_hd__o21ai_0
X$11015 VDD synth_2617 synth_1353 synth_3117 VDD synth_3211 VNB|VSS VNB|VSS
+ sky130_fd_sc_hd__o21ai_0
X$11016 VDD synth_2472 synth_2332 synth_2471 VDD synth_2510 VNB|VSS VNB|VSS
+ sky130_fd_sc_hd__o21ai_0
X$11017 VDD synth_4182 synth_4345 synth_4571 VDD synth_4434 VNB|VSS VNB|VSS
+ sky130_fd_sc_hd__o21ai_0
X$11018 VDD synth_9922 synth_10214 synth_10216 VDD synth_10215 VNB|VSS VNB|VSS
+ sky130_fd_sc_hd__o21ai_0
X$11019 VDD synth_2640 synth_2568 synth_2672 VDD synth_2612 VNB|VSS VNB|VSS
+ sky130_fd_sc_hd__o21ai_0
X$11020 VDD synth_3555 synth_3690 synth_3624 VDD synth_3934 VNB|VSS VNB|VSS
+ sky130_fd_sc_hd__o21ai_0
X$11021 VDD synth_9112 synth_10558 synth_8805 VDD synth_10492 VNB|VSS VNB|VSS
+ sky130_fd_sc_hd__o21ai_0
X$11022 VDD synth_8536 synth_8590 synth_8586 VDD synth_8500 VNB|VSS VNB|VSS
+ sky130_fd_sc_hd__o21ai_0
X$11023 VDD synth_8260 synth_8191 synth_7872 VDD synth_8259 VNB|VSS VNB|VSS
+ sky130_fd_sc_hd__o21ai_0
X$11024 VDD synth_8455 synth_7089 synth_8539 VDD synth_8501 VNB|VSS VNB|VSS
+ sky130_fd_sc_hd__o21ai_0
X$11025 VDD synth_9386 synth_9762 synth_9669 VDD synth_9761 VNB|VSS VNB|VSS
+ sky130_fd_sc_hd__o21ai_0
X$11026 VDD synth_10298 synth_10295 synth_10328 VDD synth_10327 VNB|VSS VNB|VSS
+ sky130_fd_sc_hd__o21ai_0
X$11027 VDD synth_3709 synth_3647 synth_3649 VDD synth_3651 VNB|VSS VNB|VSS
+ sky130_fd_sc_hd__o21ai_0
X$11028 VDD synth_3176 synth_3035 synth_3280 VDD synth_3215 VNB|VSS VNB|VSS
+ sky130_fd_sc_hd__o21ai_0
X$11029 VDD synth_684 synth_859 synth_1208 VDD synth_1293 VNB|VSS VNB|VSS
+ sky130_fd_sc_hd__o21ai_0
X$11030 VDD synth_4359 synth_4416 synth_4360 VDD synth_4237 VNB|VSS VNB|VSS
+ sky130_fd_sc_hd__o21ai_0
X$11031 VDD synth_4726 synth_4727 synth_4882 VDD synth_4883 VNB|VSS VNB|VSS
+ sky130_fd_sc_hd__o21ai_0
X$11032 VDD synth_10962 synth_10920 synth_11038 VDD synth_11188 VNB|VSS VNB|VSS
+ sky130_fd_sc_hd__o21ai_0
X$11033 VDD synth_4788 synth_4727 synth_4884 VDD synth_4786 VNB|VSS VNB|VSS
+ sky130_fd_sc_hd__o21ai_0
X$11034 VDD synth_4445 synth_4359 synth_4569 VDD synth_4568 VNB|VSS VNB|VSS
+ sky130_fd_sc_hd__o21ai_0
X$11035 VDD synth_2138 synth_2136 synth_2216 VDD synth_2218 VNB|VSS VNB|VSS
+ sky130_fd_sc_hd__o21ai_0
X$11036 VDD synth_10911 synth_10997 synth_11056 VDD synth_10934 VNB|VSS VNB|VSS
+ sky130_fd_sc_hd__o21ai_0
X$11037 VDD synth_8430 synth_8462 synth_8542 VDD synth_8354 VNB|VSS VNB|VSS
+ sky130_fd_sc_hd__o21ai_0
X$11038 VDD synth_3951 synth_4048 synth_4045 VDD synth_4125 VNB|VSS VNB|VSS
+ sky130_fd_sc_hd__o21ai_0
X$11039 VDD synth_4408 synth_4407 synth_4561 VDD synth_4518 VNB|VSS VNB|VSS
+ sky130_fd_sc_hd__o21ai_0
X$11040 VDD synth_6640 synth_6716 synth_6715 VDD synth_6599 VNB|VSS VNB|VSS
+ sky130_fd_sc_hd__o21ai_0
X$11041 VDD synth_9063 synth_9983 synth_10510 VDD synth_10494 VNB|VSS VNB|VSS
+ sky130_fd_sc_hd__o21ai_0
X$11042 VDD synth_8793 synth_8754 synth_8843 VDD synth_8846 VNB|VSS VNB|VSS
+ sky130_fd_sc_hd__o21ai_0
X$11043 VDD synth_169 synth_388 synth_462 VDD synth_461 VNB|VSS VNB|VSS
+ sky130_fd_sc_hd__o21ai_0
X$11044 VDD synth_9292 synth_11164 synth_8981 VDD synth_11090 VNB|VSS VNB|VSS
+ sky130_fd_sc_hd__o21ai_0
X$11045 VDD synth_4150 synth_4149 synth_4228 VDD synth_3999 VNB|VSS VNB|VSS
+ sky130_fd_sc_hd__o21ai_0
X$11046 VDD synth_10214 synth_10351 synth_10282 VDD synth_10409 VNB|VSS VNB|VSS
+ sky130_fd_sc_hd__o21ai_0
X$11047 VDD synth_12074 synth_11984 synth_12014 VDD synth_11919 VNB|VSS VNB|VSS
+ sky130_fd_sc_hd__o21ai_0
X$11048 VDD synth_10555 synth_10305 synth_10553 VDD synth_10693 VNB|VSS VNB|VSS
+ sky130_fd_sc_hd__o21ai_0
X$11049 VDD synth_7083 synth_6901 synth_7028 VDD synth_6882 VNB|VSS VNB|VSS
+ sky130_fd_sc_hd__o21ai_0
X$11050 VDD synth_5914 synth_4961 synth_5997 VDD synth_5996 VNB|VSS VNB|VSS
+ sky130_fd_sc_hd__o21ai_0
X$11051 VDD synth_12282 synth_12234 synth_9474 VDD synth_12215 VNB|VSS VNB|VSS
+ sky130_fd_sc_hd__o21ai_0
X$11052 VDD synth_7199 synth_7111 synth_7247 VDD synth_7263 VNB|VSS VNB|VSS
+ sky130_fd_sc_hd__o21ai_0
X$11053 VDD synth_9380 synth_9501 synth_9551 VDD synth_9378 VNB|VSS VNB|VSS
+ sky130_fd_sc_hd__o21ai_0
X$11054 VDD synth_3045 synth_3044 synth_3080 VDD synth_3134 VNB|VSS VNB|VSS
+ sky130_fd_sc_hd__o21ai_0
X$11055 VDD synth_11664 synth_11667 synth_11666 VDD synth_11806 VNB|VSS VNB|VSS
+ sky130_fd_sc_hd__o21ai_0
X$11056 VDD synth_5264 synth_5266 synth_5263 VDD synth_5261 VNB|VSS VNB|VSS
+ sky130_fd_sc_hd__o21ai_0
X$11057 VDD synth_2217 synth_2136 synth_2137 VDD synth_2140 VNB|VSS VNB|VSS
+ sky130_fd_sc_hd__o21ai_0
X$11058 VDD synth_9221 synth_9223 synth_9169 VDD synth_9222 VNB|VSS VNB|VSS
+ sky130_fd_sc_hd__o21ai_0
X$11059 VDD synth_12451 synth_9423 synth_12783 VDD synth_12794 VNB|VSS VNB|VSS
+ sky130_fd_sc_hd__o21ai_0
X$11060 VDD synth_8804 synth_10862 synth_9926 VDD synth_11797 VNB|VSS VNB|VSS
+ sky130_fd_sc_hd__o21ai_0
X$11061 VDD synth_3915 synth_927 synth_3976 VDD synth_3911 VNB|VSS VNB|VSS
+ sky130_fd_sc_hd__o21ai_0
X$11062 VDD synth_4288 synth_4406 synth_4373 VDD synth_4449 VNB|VSS VNB|VSS
+ sky130_fd_sc_hd__o21ai_0
X$11063 VDD synth_298 synth_405 synth_454 VDD synth_453 VNB|VSS VNB|VSS
+ sky130_fd_sc_hd__o21ai_0
X$11064 VDD synth_10435 synth_10305 synth_10408 VDD synth_10479 VNB|VSS VNB|VSS
+ sky130_fd_sc_hd__o21ai_0
X$11065 VDD synth_8946 synth_8945 synth_11463 VDD synth_10912 VNB|VSS VNB|VSS
+ sky130_fd_sc_hd__o21ai_0
X$11066 VDD synth_4266 synth_4345 synth_4346 VDD synth_4318 VNB|VSS VNB|VSS
+ sky130_fd_sc_hd__o21ai_0
X$11067 VDD synth_2918 synth_66 synth_3046 VDD synth_3078 VNB|VSS VNB|VSS
+ sky130_fd_sc_hd__o21ai_0
X$11068 VDD synth_695 synth_659 synth_661 VDD synth_605 VNB|VSS VNB|VSS
+ sky130_fd_sc_hd__o21ai_0
X$11069 VDD synth_3956 synth_1338 synth_3936 VDD synth_3994 VNB|VSS VNB|VSS
+ sky130_fd_sc_hd__o21ai_0
X$11070 VDD synth_2591 synth_2590 synth_2659 VDD synth_2619 VNB|VSS VNB|VSS
+ sky130_fd_sc_hd__o21ai_0
X$11071 VDD synth_7728 synth_7783 synth_7841 VDD synth_7765 VNB|VSS VNB|VSS
+ sky130_fd_sc_hd__o21ai_0
X$11072 VDD synth_3828 synth_3763 synth_3827 VDD synth_3829 VNB|VSS VNB|VSS
+ sky130_fd_sc_hd__o21ai_0
X$11073 VDD synth_5598 synth_3541 synth_5839 VDD synth_5789 VNB|VSS VNB|VSS
+ sky130_fd_sc_hd__o21ai_0
X$11074 VDD synth_2664 synth_2746 synth_2811 VDD synth_2735 VNB|VSS VNB|VSS
+ sky130_fd_sc_hd__o21ai_0
X$11075 VDD synth_4114 synth_167 synth_4053 VDD synth_3988 VNB|VSS VNB|VSS
+ sky130_fd_sc_hd__o21ai_0
X$11076 VDD synth_7554 synth_7578 synth_7635 VDD synth_7409 VNB|VSS VNB|VSS
+ sky130_fd_sc_hd__o21ai_0
X$11077 VDD synth_2551 synth_2548 synth_2674 VDD synth_2497 VNB|VSS VNB|VSS
+ sky130_fd_sc_hd__o21ai_0
X$11078 VDD synth_1757 synth_1744 synth_1897 VDD synth_1903 VNB|VSS VNB|VSS
+ sky130_fd_sc_hd__o21ai_0
X$11079 VDD synth_3358 synth_3228 synth_3615 VDD synth_3525 VNB|VSS VNB|VSS
+ sky130_fd_sc_hd__o21ai_0
X$11080 VDD synth_6173 synth_3541 synth_6535 VDD synth_6478 VNB|VSS VNB|VSS
+ sky130_fd_sc_hd__o21ai_0
X$11081 VDD synth_10652 synth_10728 synth_9550 VDD synth_10867 VNB|VSS VNB|VSS
+ sky130_fd_sc_hd__o21ai_0
X$11082 VDD synth_10299 synth_10163 synth_10329 VDD synth_10255 VNB|VSS VNB|VSS
+ sky130_fd_sc_hd__o21ai_0
X$11083 VDD synth_5825 synth_5938 synth_6104 VDD synth_6086 VNB|VSS VNB|VSS
+ sky130_fd_sc_hd__o21ai_0
X$11084 VDD synth_2204 synth_2399 synth_2484 VDD synth_2456 VNB|VSS VNB|VSS
+ sky130_fd_sc_hd__o21ai_0
X$11085 VDD synth_6684 synth_6685 synth_6686 VDD synth_6513 VNB|VSS VNB|VSS
+ sky130_fd_sc_hd__o21ai_0
X$11086 VDD synth_5010 synth_5206 synth_5134 VDD synth_5296 VNB|VSS VNB|VSS
+ sky130_fd_sc_hd__o21ai_0
X$11087 VDD synth_5406 synth_5555 synth_5608 VDD synth_5556 VNB|VSS VNB|VSS
+ sky130_fd_sc_hd__o21ai_0
X$11088 VDD synth_4099 synth_4100 synth_4250 VDD synth_4165 VNB|VSS VNB|VSS
+ sky130_fd_sc_hd__o21ai_0
X$11089 VDD synth_809 synth_737 synth_738 VDD synth_739 VNB|VSS VNB|VSS
+ sky130_fd_sc_hd__o21ai_0
X$11090 VDD synth_8017 synth_8096 synth_8128 VDD synth_8035 VNB|VSS VNB|VSS
+ sky130_fd_sc_hd__o21ai_0
X$11091 VDD synth_7704 synth_7578 synth_7705 VDD synth_7636 VNB|VSS VNB|VSS
+ sky130_fd_sc_hd__o21ai_0
X$11092 VDD synth_5555 synth_3544 synth_5644 VDD synth_5591 VNB|VSS VNB|VSS
+ sky130_fd_sc_hd__o21ai_0
X$11093 VDD synth_5381 synth_3544 synth_5451 VDD synth_5404 VNB|VSS VNB|VSS
+ sky130_fd_sc_hd__o21ai_0
X$11094 VDD synth_5793 synth_5794 synth_5795 VDD synth_5792 VNB|VSS VNB|VSS
+ sky130_fd_sc_hd__o21ai_0
X$11095 VDD synth_5266 synth_5268 synth_5264 VDD synth_5314 VNB|VSS VNB|VSS
+ sky130_fd_sc_hd__o21ai_0
X$11096 VDD synth_2024 synth_1957 synth_2045 VDD synth_2023 VNB|VSS VNB|VSS
+ sky130_fd_sc_hd__o21ai_0
X$11097 VDD synth_8248 synth_8176 synth_8283 VDD synth_8371 VNB|VSS VNB|VSS
+ sky130_fd_sc_hd__o21ai_0
X$11098 VDD synth_9101 synth_10010 synth_9606 VDD synth_10012 VNB|VSS VNB|VSS
+ sky130_fd_sc_hd__o21ai_0
X$11099 VDD synth_10652 synth_10171 synth_11219 VDD synth_11216 VNB|VSS VNB|VSS
+ sky130_fd_sc_hd__o21ai_0
X$11100 VDD synth_10840 synth_8804 synth_9387 VDD synth_11642 VNB|VSS VNB|VSS
+ sky130_fd_sc_hd__o21ai_0
X$11101 VDD synth_10706 synth_10568 synth_10684 VDD synth_10829 VNB|VSS VNB|VSS
+ sky130_fd_sc_hd__o21ai_0
X$11102 VDD synth_1449 synth_1480 synth_1521 VDD synth_1444 VNB|VSS VNB|VSS
+ sky130_fd_sc_hd__o21ai_0
X$11103 VDD synth_1959 synth_1957 synth_2046 VDD synth_2097 VNB|VSS VNB|VSS
+ sky130_fd_sc_hd__o21ai_0
X$11104 VDD synth_3826 synth_3824 synth_4240 VDD synth_4159 VNB|VSS VNB|VSS
+ sky130_fd_sc_hd__o21ai_0
X$11105 VDD synth_3881 synth_4020 synth_4245 VDD synth_4092 VNB|VSS VNB|VSS
+ sky130_fd_sc_hd__o21ai_0
X$11106 VDD synth_9387 synth_10104 synth_8806 VDD synth_11128 VNB|VSS VNB|VSS
+ sky130_fd_sc_hd__o21ai_0
X$11107 VDD synth_5642 synth_4747 synth_5769 VDD synth_5936 VNB|VSS VNB|VSS
+ sky130_fd_sc_hd__o21ai_0
X$11108 VDD synth_11214 synth_10510 synth_11168 VDD synth_11122 VNB|VSS VNB|VSS
+ sky130_fd_sc_hd__o21ai_0
X$11109 VDD synth_9997 VDD VNB|VSS synth_10146 VNB|VSS sky130_fd_sc_hd__inv_1
X$11110 VDD synth_10555 VDD VNB|VSS synth_10556 VNB|VSS sky130_fd_sc_hd__inv_1
X$11111 VDD synth_10087 VDD VNB|VSS synth_10150 VNB|VSS sky130_fd_sc_hd__inv_1
X$11112 VDD synth_2086 VDD VNB|VSS synth_2157 VNB|VSS sky130_fd_sc_hd__inv_1
X$11113 VDD synth_11722 VDD VNB|VSS synth_11721 VNB|VSS sky130_fd_sc_hd__inv_1
X$11114 VDD synth_5826 VDD VNB|VSS synth_5757 VNB|VSS sky130_fd_sc_hd__inv_1
X$11115 VDD synth_10056 VDD VNB|VSS synth_10153 VNB|VSS sky130_fd_sc_hd__inv_1
X$11116 VDD synth_2961 VDD VNB|VSS synth_3000 VNB|VSS sky130_fd_sc_hd__inv_1
X$11117 VDD synth_10083 VDD VNB|VSS synth_10471 VNB|VSS sky130_fd_sc_hd__inv_1
X$11118 VDD synth_1740 VDD VNB|VSS synth_1772 VNB|VSS sky130_fd_sc_hd__inv_1
X$11119 VDD synth_2063 VDD VNB|VSS synth_2281 VNB|VSS sky130_fd_sc_hd__inv_1
X$11120 VDD synth_11310 VDD VNB|VSS synth_11429 VNB|VSS sky130_fd_sc_hd__inv_1
X$11121 VDD synth_11887 VDD VNB|VSS synth_12078 VNB|VSS sky130_fd_sc_hd__inv_1
X$11122 VDD synth_12104 VDD VNB|VSS synth_12231 VNB|VSS sky130_fd_sc_hd__inv_1
X$11123 VDD synth_10638 VDD VNB|VSS synth_10722 VNB|VSS sky130_fd_sc_hd__inv_1
X$11124 VDD synth_6087 VDD VNB|VSS synth_6088 VNB|VSS sky130_fd_sc_hd__inv_1
X$11125 VDD synth_12356 VDD VNB|VSS synth_12400 VNB|VSS sky130_fd_sc_hd__inv_1
X$11126 VDD synth_11843 VDD VNB|VSS synth_12072 VNB|VSS sky130_fd_sc_hd__inv_1
X$11127 VDD synth_6621 VDD VNB|VSS synth_6464 VNB|VSS sky130_fd_sc_hd__inv_1
X$11128 VDD synth_5580 VDD VNB|VSS synth_5681 VNB|VSS sky130_fd_sc_hd__inv_1
X$11129 VDD synth_11983 VDD VNB|VSS synth_11982 VNB|VSS sky130_fd_sc_hd__inv_1
X$11130 VDD synth_11455 VDD VNB|VSS synth_11572 VNB|VSS sky130_fd_sc_hd__inv_1
X$11131 VDD synth_10985 VDD VNB|VSS synth_11131 VNB|VSS sky130_fd_sc_hd__inv_1
X$11132 VDD synth_12760 VDD VNB|VSS synth_12773 VNB|VSS sky130_fd_sc_hd__inv_1
X$11133 VDD synth_4757 VDD VNB|VSS synth_5027 VNB|VSS sky130_fd_sc_hd__inv_1
X$11134 VDD synth_4538 VDD VNB|VSS synth_4691 VNB|VSS sky130_fd_sc_hd__inv_1
X$11135 VDD synth_6308 VDD VNB|VSS synth_6480 VNB|VSS sky130_fd_sc_hd__inv_1
X$11136 VDD synth_1586 VDD VNB|VSS synth_1692 VNB|VSS sky130_fd_sc_hd__inv_1
X$11137 VDD synth_12708 VDD VNB|VSS synth_12589 VNB|VSS sky130_fd_sc_hd__inv_1
X$11138 VDD synth_11158 VDD VNB|VSS synth_11426 VNB|VSS sky130_fd_sc_hd__inv_1
X$11139 VDD synth_46 VDD VNB|VSS synth_125 VNB|VSS sky130_fd_sc_hd__inv_1
X$11140 VDD synth_12093 VDD VNB|VSS synth_12147 VNB|VSS sky130_fd_sc_hd__inv_1
X$11141 VDD synth_11987 VDD VNB|VSS synth_11988 VNB|VSS sky130_fd_sc_hd__inv_1
X$11142 VDD synth_68 VDD VNB|VSS synth_299 VNB|VSS sky130_fd_sc_hd__inv_1
X$11143 VDD synth_10086 VDD VNB|VSS synth_10148 VNB|VSS sky130_fd_sc_hd__inv_1
X$11144 VDD synth_11526 VDD VNB|VSS synth_11620 VNB|VSS sky130_fd_sc_hd__inv_1
X$11145 VDD synth_11524 VDD VNB|VSS synth_11619 VNB|VSS sky130_fd_sc_hd__inv_1
X$11146 VDD synth_12402 VDD VNB|VSS synth_12494 VNB|VSS sky130_fd_sc_hd__inv_1
X$11147 VDD synth_11087 VDD VNB|VSS synth_11060 VNB|VSS sky130_fd_sc_hd__inv_1
X$11148 VDD synth_16 VDD VNB|VSS synth_283 VNB|VSS sky130_fd_sc_hd__inv_1
X$11149 VDD synth_1601 VDD VNB|VSS synth_1774 VNB|VSS sky130_fd_sc_hd__inv_1
X$11150 VDD synth_3045 VDD VNB|VSS synth_3119 VNB|VSS sky130_fd_sc_hd__inv_1
X$11151 VDD synth_2848 VDD VNB|VSS synth_3010 VNB|VSS sky130_fd_sc_hd__inv_1
X$11152 VDD synth_2519 VDD VNB|VSS synth_2558 VNB|VSS sky130_fd_sc_hd__inv_1
X$11153 VDD synth_11805 VDD VNB|VSS synth_11970 VNB|VSS sky130_fd_sc_hd__inv_1
X$11154 VDD synth_6009 VDD VNB|VSS synth_5918 VNB|VSS sky130_fd_sc_hd__inv_1
X$11155 VDD synth_11210 VDD VNB|VSS synth_11355 VNB|VSS sky130_fd_sc_hd__inv_1
X$11156 VDD synth_11211 VDD VNB|VSS synth_11354 VNB|VSS sky130_fd_sc_hd__inv_1
X$11157 VDD synth_12658 VDD VNB|VSS synth_12690 VNB|VSS sky130_fd_sc_hd__inv_1
X$11158 VDD synth_12391 VDD VNB|VSS synth_12496 VNB|VSS sky130_fd_sc_hd__inv_1
X$11159 VDD synth_11372 VDD VNB|VSS synth_11565 VNB|VSS sky130_fd_sc_hd__inv_1
X$11160 VDD synth_9915 VDD VNB|VSS synth_10079 VNB|VSS sky130_fd_sc_hd__inv_1
X$11161 VDD synth_12462 VDD VNB|VSS synth_12493 VNB|VSS sky130_fd_sc_hd__inv_1
X$11162 VDD synth_12592 VDD VNB|VSS synth_12593 VNB|VSS sky130_fd_sc_hd__inv_1
X$11163 VDD synth_6089 VDD VNB|VSS synth_6002 VNB|VSS sky130_fd_sc_hd__inv_1
X$11164 VDD synth_11435 VDD VNB|VSS synth_11362 VNB|VSS sky130_fd_sc_hd__inv_1
X$11165 VDD synth_2801 VDD VNB|VSS synth_3009 VNB|VSS sky130_fd_sc_hd__inv_1
X$11166 VDD synth_12769 VDD VNB|VSS synth_12693 VNB|VSS sky130_fd_sc_hd__inv_1
X$11167 VDD synth_11661 VDD VNB|VSS synth_11834 VNB|VSS sky130_fd_sc_hd__inv_1
X$11168 VDD synth_11641 VDD VNB|VSS synth_11862 VNB|VSS sky130_fd_sc_hd__inv_1
X$11169 VDD synth_10278 VDD VNB|VSS synth_10433 VNB|VSS sky130_fd_sc_hd__inv_1
X$11170 VDD synth_10634 VDD VNB|VSS synth_10505 VNB|VSS sky130_fd_sc_hd__inv_1
X$11171 VDD synth_12226 VDD VNB|VSS synth_12444 VNB|VSS sky130_fd_sc_hd__inv_1
X$11172 VDD synth_5865 VDD VNB|VSS synth_5949 VNB|VSS sky130_fd_sc_hd__inv_1
X$11173 VDD synth_8538 VDD VNB|VSS synth_8591 VNB|VSS sky130_fd_sc_hd__inv_1
X$11174 VDD synth_3826 VDD VNB|VSS synth_3825 VNB|VSS sky130_fd_sc_hd__inv_1
X$11175 VDD synth_12678 VDD VNB|VSS synth_12679 VNB|VSS sky130_fd_sc_hd__inv_1
X$11176 VDD synth_9634 VDD VNB|VSS synth_9649 VNB|VSS sky130_fd_sc_hd__inv_1
X$11177 VDD synth_7498 VDD VNB|VSS synth_7527 VNB|VSS sky130_fd_sc_hd__inv_1
X$11178 VDD synth_8417 VDD VNB|VSS synth_8589 VNB|VSS sky130_fd_sc_hd__inv_1
X$11179 VDD synth_55 VDD VNB|VSS synth_43 VNB|VSS sky130_fd_sc_hd__inv_1
X$11180 VDD synth_5501 VDD VNB|VSS synth_5475 VNB|VSS sky130_fd_sc_hd__inv_1
X$11181 VDD synth_8996 VDD VNB|VSS synth_8974 VNB|VSS sky130_fd_sc_hd__inv_1
X$11182 VDD synth_6615 VDD VNB|VSS synth_6863 VNB|VSS sky130_fd_sc_hd__inv_1
X$11183 VDD synth_621 VDD VNB|VSS synth_718 VNB|VSS sky130_fd_sc_hd__inv_1
X$11184 VDD synth_5545 VDD VNB|VSS synth_5648 VNB|VSS sky130_fd_sc_hd__inv_1
X$11185 VDD synth_128 VDD VNB|VSS synth_78 VNB|VSS sky130_fd_sc_hd__inv_1
X$11186 VDD synth_2441 VDD VNB|VSS synth_2552 VNB|VSS sky130_fd_sc_hd__inv_1
X$11187 VDD synth_1244 VDD VNB|VSS synth_1172 VNB|VSS sky130_fd_sc_hd__inv_1
X$11188 VDD synth_907 VDD VNB|VSS synth_985 VNB|VSS sky130_fd_sc_hd__inv_1
X$11189 VDD synth_7723 VDD VNB|VSS synth_7821 VNB|VSS sky130_fd_sc_hd__inv_1
X$11190 VDD synth_8318 VDD VNB|VSS synth_8511 VNB|VSS sky130_fd_sc_hd__inv_1
X$11191 VDD synth_8457 VDD VNB|VSS synth_8666 VNB|VSS sky130_fd_sc_hd__inv_1
X$11192 VDD synth_4871 VDD VNB|VSS synth_5036 VNB|VSS sky130_fd_sc_hd__inv_1
X$11193 VDD synth_8520 VDD VNB|VSS synth_8521 VNB|VSS sky130_fd_sc_hd__inv_1
X$11194 VDD synth_7158 VDD VNB|VSS synth_7229 VNB|VSS sky130_fd_sc_hd__inv_1
X$11195 VDD synth_6543 VDD VNB|VSS synth_6643 VNB|VSS sky130_fd_sc_hd__inv_1
X$11196 VDD synth_69 VDD VNB|VSS synth_70 VNB|VSS sky130_fd_sc_hd__inv_1
X$11197 VDD synth_5719 VDD VNB|VSS synth_5781 VNB|VSS sky130_fd_sc_hd__inv_1
X$11198 VDD synth_664 VDD VNB|VSS synth_947 VNB|VSS sky130_fd_sc_hd__inv_1
X$11199 VDD synth_5503 VDD VNB|VSS synth_5419 VNB|VSS sky130_fd_sc_hd__inv_1
X$11200 VDD synth_1687 VDD VNB|VSS synth_2015 VNB|VSS sky130_fd_sc_hd__inv_1
X$11201 VDD synth_1026 VDD VNB|VSS synth_1246 VNB|VSS sky130_fd_sc_hd__inv_1
X$11202 VDD synth_7912 VDD VNB|VSS synth_8039 VNB|VSS sky130_fd_sc_hd__inv_1
X$11203 VDD synth_4663 VDD VNB|VSS synth_4660 VNB|VSS sky130_fd_sc_hd__inv_1
X$11204 VDD synth_567 VDD VNB|VSS synth_716 VNB|VSS sky130_fd_sc_hd__inv_1
X$11205 VDD synth_8901 VDD VNB|VSS synth_8967 VNB|VSS sky130_fd_sc_hd__inv_1
X$11206 VDD synth_8943 VDD VNB|VSS synth_8835 VNB|VSS sky130_fd_sc_hd__inv_1
X$11207 VDD synth_8248 VDD VNB|VSS synth_8370 VNB|VSS sky130_fd_sc_hd__inv_1
X$11208 VDD synth_7847 VDD VNB|VSS synth_8123 VNB|VSS sky130_fd_sc_hd__inv_1
X$11209 VDD synth_7987 VDD VNB|VSS synth_8067 VNB|VSS sky130_fd_sc_hd__inv_1
X$11210 VDD synth_622 VDD VNB|VSS synth_758 VNB|VSS sky130_fd_sc_hd__inv_1
X$11211 VDD synth_4509 VDD VNB|VSS synth_4563 VNB|VSS sky130_fd_sc_hd__inv_1
X$11212 VDD synth_337 VDD VNB|VSS synth_268 VNB|VSS sky130_fd_sc_hd__inv_1
X$11213 VDD synth_12425 VDD VNB|VSS synth_12538 VNB|VSS sky130_fd_sc_hd__inv_1
X$11214 VDD synth_4370 VDD VNB|VSS synth_4492 VNB|VSS sky130_fd_sc_hd__inv_1
X$11215 VDD synth_9592 VDD VNB|VSS synth_9651 VNB|VSS sky130_fd_sc_hd__inv_1
X$11216 VDD synth_8323 VDD VNB|VSS synth_8296 VNB|VSS sky130_fd_sc_hd__inv_1
X$11217 VDD synth_4022 VDD VNB|VSS synth_4329 VNB|VSS sky130_fd_sc_hd__inv_1
X$11218 VDD synth_4439 VDD VNB|VSS synth_4521 VNB|VSS sky130_fd_sc_hd__inv_1
X$11219 VDD synth_1163 VDD VNB|VSS synth_1270 VNB|VSS sky130_fd_sc_hd__inv_1
X$11220 VDD synth_4242 VDD VNB|VSS synth_4418 VNB|VSS sky130_fd_sc_hd__inv_1
X$11221 VDD synth_3348 VDD VNB|VSS synth_3467 VNB|VSS sky130_fd_sc_hd__inv_1
X$11222 VDD synth_4075 VDD VNB|VSS synth_4322 VNB|VSS sky130_fd_sc_hd__inv_1
X$11223 VDD synth_2141 VDD VNB|VSS synth_2363 VNB|VSS sky130_fd_sc_hd__inv_1
X$11224 VDD synth_6859 VDD VNB|VSS synth_6992 VNB|VSS sky130_fd_sc_hd__inv_1
X$11225 VDD synth_8085 VDD VNB|VSS synth_8171 VNB|VSS sky130_fd_sc_hd__inv_1
X$11226 VDD synth_3697 VDD VNB|VSS synth_3696 VNB|VSS sky130_fd_sc_hd__inv_1
X$11227 VDD synth_667 VDD VNB|VSS synth_709 VNB|VSS sky130_fd_sc_hd__inv_1
X$11228 VDD synth_1750 VDD VNB|VSS synth_1661 VNB|VSS sky130_fd_sc_hd__inv_1
X$11229 VDD synth_1099 VDD VNB|VSS synth_1100 VNB|VSS sky130_fd_sc_hd__inv_1
X$11230 VDD synth_1832 VDD VNB|VSS synth_1748 VNB|VSS sky130_fd_sc_hd__inv_1
X$11231 VDD synth_3358 VDD VNB|VSS synth_3442 VNB|VSS sky130_fd_sc_hd__inv_1
X$11232 VDD synth_936 VDD VNB|VSS synth_1098 VNB|VSS sky130_fd_sc_hd__inv_1
X$11233 VDD synth_5796 VDD VNB|VSS synth_6020 VNB|VSS sky130_fd_sc_hd__inv_1
X$11234 VDD synth_1238 VDD VNB|VSS synth_1093 VNB|VSS sky130_fd_sc_hd__inv_1
X$11235 VDD synth_7386 VDD VNB|VSS synth_7357 VNB|VSS sky130_fd_sc_hd__inv_1
X$11236 VDD synth_3921 VDD VNB|VSS synth_3813 VNB|VSS sky130_fd_sc_hd__inv_1
X$11237 VDD synth_6303 VDD VNB|VSS synth_6409 VNB|VSS sky130_fd_sc_hd__inv_1
X$11238 VDD synth_3346 VDD VNB|VSS synth_3460 VNB|VSS sky130_fd_sc_hd__inv_1
X$11239 VDD synth_4831 VDD VNB|VSS synth_4917 VNB|VSS sky130_fd_sc_hd__inv_1
X$11240 VDD synth_8388 VDD VNB|VSS synth_8320 VNB|VSS sky130_fd_sc_hd__inv_1
X$11241 VDD synth_8775 VDD VNB|VSS synth_8930 VNB|VSS sky130_fd_sc_hd__inv_1
X$11242 VDD synth_4997 VDD VNB|VSS synth_5077 VNB|VSS sky130_fd_sc_hd__inv_1
X$11243 VDD synth_190 VDD VNB|VSS synth_377 VNB|VSS sky130_fd_sc_hd__inv_1
X$11244 VDD synth_4432 VDD VNB|VSS synth_4263 VNB|VSS sky130_fd_sc_hd__inv_1
X$11245 VDD synth_4344 VDD VNB|VSS synth_4180 VNB|VSS sky130_fd_sc_hd__inv_1
X$11246 VDD synth_421 VDD VNB|VSS synth_497 VNB|VSS sky130_fd_sc_hd__inv_1
X$11247 VDD synth_5321 VDD VNB|VSS synth_5220 VNB|VSS sky130_fd_sc_hd__inv_1
X$11248 VDD synth_3352 VDD VNB|VSS synth_3465 VNB|VSS sky130_fd_sc_hd__inv_1
X$11249 VDD synth_10520 VDD VNB|VSS synth_11259 VNB|VSS sky130_fd_sc_hd__inv_1
X$11250 VDD synth_5260 VDD VNB|VSS synth_5477 VNB|VSS sky130_fd_sc_hd__inv_1
X$11251 VDD synth_3297 VDD VNB|VSS synth_3599 VNB|VSS sky130_fd_sc_hd__inv_1
X$11252 VDD synth_9707 VDD VNB|VSS synth_9641 VNB|VSS sky130_fd_sc_hd__inv_1
X$11253 VDD synth_3753 VDD VNB|VSS synth_3606 VNB|VSS sky130_fd_sc_hd__inv_1
X$11254 VDD synth_3693 VDD VNB|VSS synth_3679 VNB|VSS sky130_fd_sc_hd__inv_1
X$11255 VDD synth_9165 VDD VNB|VSS synth_9360 VNB|VSS sky130_fd_sc_hd__inv_1
X$11256 VDD synth_3788 VDD VNB|VSS synth_3572 VNB|VSS sky130_fd_sc_hd__inv_1
X$11257 VDD synth_9494 VDD VNB|VSS synth_9886 VNB|VSS sky130_fd_sc_hd__inv_1
X$11258 VDD synth_9496 VDD VNB|VSS synth_9804 VNB|VSS sky130_fd_sc_hd__inv_1
X$11259 VDD synth_7685 VDD VNB|VSS synth_7830 VNB|VSS sky130_fd_sc_hd__inv_1
X$11260 VDD synth_4275 VDD VNB|VSS synth_4643 VNB|VSS sky130_fd_sc_hd__inv_1
X$11261 VDD synth_8074 VDD VNB|VSS synth_7894 VNB|VSS sky130_fd_sc_hd__inv_1
X$11262 VDD synth_2651 VDD VNB|VSS synth_2774 VNB|VSS sky130_fd_sc_hd__inv_1
X$11263 VDD synth_7002 VDD VNB|VSS synth_7102 VNB|VSS sky130_fd_sc_hd__inv_1
X$11264 VDD synth_950 VDD VNB|VSS synth_918 VNB|VSS sky130_fd_sc_hd__inv_1
X$11265 VDD synth_2460 VDD VNB|VSS synth_2538 VNB|VSS sky130_fd_sc_hd__inv_1
X$11266 VDD synth_7874 VDD VNB|VSS synth_7982 VNB|VSS sky130_fd_sc_hd__inv_1
X$11267 VDD synth_75 VDD VNB|VSS synth_181 VNB|VSS sky130_fd_sc_hd__inv_1
X$11268 VDD synth_4895 VDD VNB|VSS synth_4979 VNB|VSS sky130_fd_sc_hd__inv_1
X$11269 VDD synth_265 VDD VNB|VSS synth_311 VNB|VSS sky130_fd_sc_hd__inv_1
X$11270 VDD synth_4036 VDD VNB|VSS synth_4154 VNB|VSS sky130_fd_sc_hd__inv_1
X$11271 VDD synth_3796 VDD VNB|VSS synth_3797 VNB|VSS sky130_fd_sc_hd__inv_1
X$11272 VDD synth_9793 VDD VNB|VSS synth_9790 VNB|VSS sky130_fd_sc_hd__inv_1
X$11273 VDD synth_4533 VDD VNB|VSS synth_4534 VNB|VSS sky130_fd_sc_hd__inv_1
X$11274 VDD synth_4222 VDD VNB|VSS synth_4448 VNB|VSS sky130_fd_sc_hd__inv_1
X$11275 VDD synth_360 VDD VNB|VSS synth_161 VNB|VSS sky130_fd_sc_hd__inv_1
X$11276 VDD synth_10379 VDD VNB|VSS synth_10382 VNB|VSS sky130_fd_sc_hd__inv_1
X$11277 VDD synth_5471 VDD VNB|VSS synth_5500 VNB|VSS sky130_fd_sc_hd__inv_1
X$11278 VDD synth_6205 VDD VNB|VSS synth_6284 VNB|VSS sky130_fd_sc_hd__inv_1
X$11279 VDD synth_677 VDD VNB|VSS synth_754 VNB|VSS sky130_fd_sc_hd__inv_1
X$11280 VDD synth_3830 VDD VNB|VSS synth_4107 VNB|VSS sky130_fd_sc_hd__inv_1
X$11281 VDD synth_1233 VDD VNB|VSS synth_1262 VNB|VSS sky130_fd_sc_hd__inv_1
X$11282 VDD synth_73 VDD VNB|VSS synth_411 VNB|VSS sky130_fd_sc_hd__inv_1
X$11283 VDD synth_5745 VDD VNB|VSS synth_5812 VNB|VSS sky130_fd_sc_hd__inv_1
X$11284 VDD synth_8648 VDD VNB|VSS synth_8562 VNB|VSS sky130_fd_sc_hd__inv_1
X$11285 VDD synth_447 VDD VNB|VSS synth_354 VNB|VSS sky130_fd_sc_hd__inv_1
X$11286 VDD synth_6876 VDD VNB|VSS synth_6675 VNB|VSS sky130_fd_sc_hd__inv_1
X$11287 VDD synth_2796 VDD VNB|VSS synth_2928 VNB|VSS sky130_fd_sc_hd__inv_1
X$11288 VDD synth_11760 VDD VNB|VSS synth_11690 VNB|VSS sky130_fd_sc_hd__inv_1
X$11289 VDD synth_44 VDD VNB|VSS synth_187 VNB|VSS sky130_fd_sc_hd__inv_1
X$11290 VDD synth_7276 VDD VNB|VSS synth_7349 VNB|VSS sky130_fd_sc_hd__inv_1
X$11291 VDD synth_6914 VDD VNB|VSS synth_7014 VNB|VSS sky130_fd_sc_hd__inv_1
X$11292 VDD synth_1583 VDD VNB|VSS synth_1771 VNB|VSS sky130_fd_sc_hd__inv_1
X$11293 VDD synth_435 VDD VNB|VSS synth_338 VNB|VSS sky130_fd_sc_hd__inv_1
X$11294 VDD synth_8644 VDD VNB|VSS synth_8592 VNB|VSS sky130_fd_sc_hd__inv_1
X$11295 VDD synth_3232 VDD VNB|VSS synth_3283 VNB|VSS sky130_fd_sc_hd__inv_1
X$11296 VDD synth_225 VDD VNB|VSS synth_318 VNB|VSS sky130_fd_sc_hd__inv_1
X$11297 VDD synth_563 VDD VNB|VSS synth_611 VNB|VSS sky130_fd_sc_hd__inv_1
X$11298 VDD synth_72 VDD VNB|VSS synth_166 VNB|VSS sky130_fd_sc_hd__inv_1
X$11299 VDD synth_6989 VDD VNB|VSS synth_7132 VNB|VSS sky130_fd_sc_hd__inv_1
X$11300 VDD synth_573 VDD VNB|VSS synth_643 VNB|VSS sky130_fd_sc_hd__inv_1
X$11301 VDD synth_3160 VDD VNB|VSS synth_3158 VNB|VSS sky130_fd_sc_hd__inv_1
X$11302 VDD synth_293 VDD VNB|VSS synth_294 VNB|VSS sky130_fd_sc_hd__inv_1
X$11303 VDD synth_3539 VDD VNB|VSS synth_3389 VNB|VSS sky130_fd_sc_hd__inv_1
X$11304 VDD synth_94 VDD VNB|VSS synth_124 VNB|VSS sky130_fd_sc_hd__inv_1
X$11305 VDD synth_8651 VDD VNB|VSS synth_8567 VNB|VSS sky130_fd_sc_hd__inv_1
X$11306 VDD synth_7108 VDD VNB|VSS synth_7308 VNB|VSS sky130_fd_sc_hd__inv_1
X$11307 VDD synth_8491 VDD VNB|VSS synth_8529 VNB|VSS sky130_fd_sc_hd__inv_1
X$11308 VDD synth_10385 VDD VNB|VSS synth_10386 VNB|VSS sky130_fd_sc_hd__inv_1
X$11309 VDD synth_4980 VDD VNB|VSS synth_5067 VNB|VSS sky130_fd_sc_hd__inv_1
X$11310 VDD synth_5049 VDD VNB|VSS synth_5226 VNB|VSS sky130_fd_sc_hd__inv_1
X$11311 VDD synth_1427 VDD VNB|VSS synth_1505 VNB|VSS sky130_fd_sc_hd__inv_1
X$11312 VDD synth_9530 VDD VNB|VSS synth_9529 VNB|VSS sky130_fd_sc_hd__inv_1
X$11313 VDD synth_9094 VDD VNB|VSS synth_9028 VNB|VSS sky130_fd_sc_hd__inv_1
X$11314 VDD synth_809 VDD VNB|VSS synth_897 VNB|VSS sky130_fd_sc_hd__inv_1
X$11315 VDD synth_10387 VDD VNB|VSS synth_10517 VNB|VSS sky130_fd_sc_hd__inv_1
X$11316 VDD synth_898 VDD VNB|VSS synth_811 VNB|VSS sky130_fd_sc_hd__inv_1
X$11317 VDD synth_307 VDD VNB|VSS synth_362 VNB|VSS sky130_fd_sc_hd__inv_1
X$11318 VDD synth_9298 VDD VNB|VSS synth_9215 VNB|VSS sky130_fd_sc_hd__inv_1
X$11319 VDD synth_5072 VDD VNB|VSS synth_5230 VNB|VSS sky130_fd_sc_hd__inv_1
X$11320 VDD synth_1061 VDD VNB|VSS synth_1157 VNB|VSS sky130_fd_sc_hd__inv_1
X$11321 VDD synth_6120 VDD VNB|VSS synth_6652 VNB|VSS sky130_fd_sc_hd__inv_1
X$11322 VDD synth_9535 VDD VNB|VSS synth_9400 VNB|VSS sky130_fd_sc_hd__inv_1
X$11323 VDD synth_7189 VDD VNB|VSS synth_7230 VNB|VSS sky130_fd_sc_hd__inv_1
X$11324 VDD synth_6365 VDD VNB|VSS synth_6413 VNB|VSS sky130_fd_sc_hd__inv_1
X$11325 VDD synth_6337 VDD VNB|VSS synth_6366 VNB|VSS sky130_fd_sc_hd__inv_1
X$11326 VDD synth_6230 VDD VNB|VSS synth_6275 VNB|VSS sky130_fd_sc_hd__inv_1
X$11327 VDD synth_6231 VDD VNB|VSS synth_6276 VNB|VSS sky130_fd_sc_hd__inv_1
X$11328 VDD synth_5070 VDD VNB|VSS synth_5142 VNB|VSS sky130_fd_sc_hd__inv_1
X$11329 VDD synth_4557 VDD VNB|VSS synth_4746 VNB|VSS sky130_fd_sc_hd__inv_1
X$11330 VDD synth_6419 VDD VNB|VSS synth_6525 VNB|VSS sky130_fd_sc_hd__inv_1
X$11331 VDD synth_6600 VDD VNB|VSS synth_6602 VNB|VSS sky130_fd_sc_hd__inv_1
X$11332 VDD synth_7316 VDD VNB|VSS synth_7597 VNB|VSS sky130_fd_sc_hd__inv_1
X$11333 VDD synth_64 VDD VNB|VSS synth_286 VNB|VSS sky130_fd_sc_hd__inv_1
X$11334 VDD synth_6885 VDD VNB|VSS synth_7053 VNB|VSS sky130_fd_sc_hd__inv_1
X$11335 VDD synth_240 VDD VNB|VSS synth_103 VNB|VSS sky130_fd_sc_hd__inv_1
X$11336 VDD synth_7315 VDD VNB|VSS synth_7510 VNB|VSS sky130_fd_sc_hd__inv_1
X$11337 VDD synth_5427 VDD VNB|VSS synth_5510 VNB|VSS sky130_fd_sc_hd__inv_1
X$11338 VDD synth_1164 VDD VNB|VSS synth_976 VNB|VSS sky130_fd_sc_hd__inv_1
X$11339 VDD synth_8616 VDD VNB|VSS synth_8615 VNB|VSS sky130_fd_sc_hd__inv_1
X$11340 VDD synth_6346 VDD VNB|VSS synth_6280 VNB|VSS sky130_fd_sc_hd__inv_1
X$11341 VDD synth_8574 VDD VNB|VSS synth_8617 VNB|VSS sky130_fd_sc_hd__inv_1
X$11342 VDD synth_6201 VDD VNB|VSS synth_6417 VNB|VSS sky130_fd_sc_hd__inv_1
X$11343 VDD synth_6519 VDD VNB|VSS synth_6546 VNB|VSS sky130_fd_sc_hd__inv_1
X$11344 VDD synth_9862 VDD VNB|VSS synth_9724 VNB|VSS sky130_fd_sc_hd__inv_1
X$11345 VDD synth_2446 VDD VNB|VSS synth_2264 VNB|VSS sky130_fd_sc_hd__inv_1
X$11346 VDD synth_2598 VDD VNB|VSS synth_2737 VNB|VSS sky130_fd_sc_hd__inv_1
X$11347 VDD synth_442 VDD VNB|VSS synth_222 VNB|VSS sky130_fd_sc_hd__inv_1
X$11348 VDD synth_5957 VDD VNB|VSS synth_5895 VNB|VSS sky130_fd_sc_hd__inv_1
X$11349 VDD synth_7913 VDD VNB|VSS synth_7991 VNB|VSS sky130_fd_sc_hd__inv_1
X$11350 VDD synth_2338 VDD VNB|VSS synth_2580 VNB|VSS sky130_fd_sc_hd__inv_1
X$11351 VDD synth_1088 VDD VNB|VSS synth_1147 VNB|VSS sky130_fd_sc_hd__inv_1
X$11352 VDD synth_4647 VDD VNB|VSS synth_4720 VNB|VSS sky130_fd_sc_hd__inv_1
X$11353 VDD synth_9753 VDD VNB|VSS synth_10196 VNB|VSS sky130_fd_sc_hd__inv_1
X$11354 VDD synth_1465 VDD VNB|VSS synth_1578 VNB|VSS sky130_fd_sc_hd__inv_1
X$11355 VDD synth_7608 VDD VNB|VSS synth_7882 VNB|VSS sky130_fd_sc_hd__inv_1
X$11356 VDD synth_3159 VDD VNB|VSS synth_3020 VNB|VSS sky130_fd_sc_hd__inv_1
X$11357 VDD synth_4336 VDD VNB|VSS synth_4386 VNB|VSS sky130_fd_sc_hd__inv_1
X$11358 VDD synth_10814 VDD VNB|VSS synth_10925 VNB|VSS sky130_fd_sc_hd__inv_1
X$11359 VDD synth_6154 VDD VNB|VSS synth_6778 VNB|VSS sky130_fd_sc_hd__inv_1
X$11360 VDD synth_8936 VDD VNB|VSS synth_8861 VNB|VSS sky130_fd_sc_hd__inv_1
X$11361 VDD synth_6648 VDD VNB|VSS synth_7006 VNB|VSS sky130_fd_sc_hd__inv_1
X$11362 VDD synth_3400 VDD VNB|VSS synth_3402 VNB|VSS sky130_fd_sc_hd__inv_1
X$11363 VDD synth_7601 VDD VNB|VSS synth_7807 VNB|VSS sky130_fd_sc_hd__inv_1
X$11364 VDD synth_2935 VDD VNB|VSS synth_3021 VNB|VSS sky130_fd_sc_hd__inv_1
X$11365 VDD synth_4099 VDD VNB|VSS synth_4247 VNB|VSS sky130_fd_sc_hd__inv_1
X$11366 VDD synth_9317 VDD VNB|VSS synth_9418 VNB|VSS sky130_fd_sc_hd__inv_1
X$11367 VDD synth_9154 VDD VNB|VSS synth_9314 VNB|VSS sky130_fd_sc_hd__inv_1
X$11368 VDD synth_10706 VDD VNB|VSS synth_10708 VNB|VSS sky130_fd_sc_hd__inv_1
X$11369 VDD synth_10786 VDD VNB|VSS synth_10832 VNB|VSS sky130_fd_sc_hd__inv_1
X$11370 VDD synth_6884 VDD VNB|VSS synth_6971 VNB|VSS sky130_fd_sc_hd__inv_1
X$11371 VDD synth_2369 VDD VNB|VSS synth_2892 VNB|VSS sky130_fd_sc_hd__inv_1
X$11372 VDD synth_797 VDD VNB|VSS synth_747 VNB|VSS sky130_fd_sc_hd__inv_1
X$11373 VDD synth_9380 VDD VNB|VSS synth_9504 VNB|VSS sky130_fd_sc_hd__inv_1
X$11374 VDD synth_10340 VDD VNB|VSS synth_10356 VNB|VSS sky130_fd_sc_hd__inv_1
X$11375 VDD synth_10133 VDD VNB|VSS synth_10073 VNB|VSS sky130_fd_sc_hd__inv_1
X$11376 VDD synth_4209 VDD VNB|VSS synth_4295 VNB|VSS sky130_fd_sc_hd__inv_1
X$11377 VDD synth_12688 VDD VNB|VSS synth_12762 VNB|VSS sky130_fd_sc_hd__inv_1
X$11378 VDD synth_2067 VDD VNB|VSS synth_2289 VNB|VSS sky130_fd_sc_hd__inv_1
X$11379 VDD synth_5128 VDD VNB|VSS synth_5053 VNB|VSS sky130_fd_sc_hd__inv_1
X$11380 VDD synth_4203 VDD VNB|VSS synth_4616 VNB|VSS sky130_fd_sc_hd__inv_1
X$11381 VDD synth_6748 VDD VNB|VSS synth_6746 VNB|VSS sky130_fd_sc_hd__inv_1
X$11382 VDD synth_3910 VDD VNB|VSS synth_3907 VNB|VSS sky130_fd_sc_hd__inv_1
X$11383 VDD synth_2214 VDD VNB|VSS synth_2223 VNB|VSS sky130_fd_sc_hd__inv_1
X$11384 VDD synth_10624 VDD VNB|VSS synth_10566 VNB|VSS sky130_fd_sc_hd__inv_1
X$11385 VDD synth_2039 VDD VNB|VSS synth_1953 VNB|VSS sky130_fd_sc_hd__inv_1
X$11386 VDD synth_6822 VDD VNB|VSS synth_6770 VNB|VSS sky130_fd_sc_hd__inv_1
X$11387 VDD synth_3904 VDD VNB|VSS synth_3973 VNB|VSS sky130_fd_sc_hd__inv_1
X$11388 VDD synth_3765 VDD VNB|VSS synth_3802 VNB|VSS sky130_fd_sc_hd__inv_1
X$11389 VDD synth_7200 VDD VNB|VSS synth_7030 VNB|VSS sky130_fd_sc_hd__inv_1
X$11390 VDD synth_9221 VDD VNB|VSS synth_9469 VNB|VSS sky130_fd_sc_hd__inv_1
X$11391 VDD synth_5001 VDD VNB|VSS synth_5124 VNB|VSS sky130_fd_sc_hd__inv_1
X$11392 VDD synth_6390 VDD VNB|VSS synth_6835 VNB|VSS sky130_fd_sc_hd__inv_1
X$11393 VDD synth_2944 VDD VNB|VSS synth_2999 VNB|VSS sky130_fd_sc_hd__inv_1
X$11394 VDD synth_684 VDD VNB|VSS synth_1206 VNB|VSS sky130_fd_sc_hd__inv_1
X$11395 VDD synth_5024 VDD VNB|VSS synth_5295 VNB|VSS sky130_fd_sc_hd__inv_1
X$11396 VDD synth_674 VDD VNB|VSS synth_731 VNB|VSS sky130_fd_sc_hd__inv_1
X$11397 VDD synth_1374 VDD VNB|VSS synth_1552 VNB|VSS sky130_fd_sc_hd__inv_1
X$11398 VDD synth_3955 VDD VNB|VSS synth_4142 VNB|VSS sky130_fd_sc_hd__inv_1
X$11399 VDD synth_3664 VDD VNB|VSS synth_3582 VNB|VSS sky130_fd_sc_hd__inv_1
X$11400 VDD synth_2862 VDD VNB|VSS synth_2998 VNB|VSS sky130_fd_sc_hd__inv_1
X$11401 VDD synth_1703 VDD VNB|VSS synth_1627 VNB|VSS sky130_fd_sc_hd__inv_1
X$11402 VDD synth_4957 VDD VNB|VSS synth_4906 VNB|VSS sky130_fd_sc_hd__inv_1
X$11403 VDD synth_4827 VDD VNB|VSS synth_4868 VNB|VSS sky130_fd_sc_hd__inv_1
X$11404 VDD synth_4721 VDD VNB|VSS synth_4862 VNB|VSS sky130_fd_sc_hd__inv_1
X$11405 VDD synth_10705 VDD VNB|VSS synth_10783 VNB|VSS sky130_fd_sc_hd__inv_1
X$11406 VDD synth_4619 VDD VNB|VSS synth_4861 VNB|VSS sky130_fd_sc_hd__inv_1
X$11407 VDD synth_9751 VDD VNB|VSS synth_10248 VNB|VSS sky130_fd_sc_hd__inv_1
X$11408 VDD synth_3148 VDD VNB|VSS synth_3105 VNB|VSS sky130_fd_sc_hd__inv_1
X$11409 VDD synth_9505 VDD VNB|VSS synth_9554 VNB|VSS sky130_fd_sc_hd__inv_1
X$11410 VDD synth_3923 VDD VNB|VSS synth_3855 VNB|VSS sky130_fd_sc_hd__inv_1
X$11411 VDD synth_1894 VDD VNB|VSS synth_1822 VNB|VSS sky130_fd_sc_hd__inv_1
X$11412 VDD synth_2284 VDD VNB|VSS synth_2282 VNB|VSS sky130_fd_sc_hd__inv_1
X$11413 VDD synth_6814 VDD VNB|VSS synth_6681 VNB|VSS sky130_fd_sc_hd__inv_1
X$11414 VDD synth_1543 VDD VNB|VSS synth_1577 VNB|VSS sky130_fd_sc_hd__inv_1
X$11415 VDD synth_2212 VDD VNB|VSS synth_2381 VNB|VSS sky130_fd_sc_hd__inv_1
X$11416 VDD synth_3492 VDD VNB|VSS synth_3421 VNB|VSS sky130_fd_sc_hd__inv_1
X$11417 VDD synth_3411 VDD VNB|VSS synth_3409 VNB|VSS sky130_fd_sc_hd__inv_1
X$11418 VDD synth_10683 VDD VNB|VSS synth_10784 VNB|VSS sky130_fd_sc_hd__inv_1
X$11419 VDD synth_10422 VDD VNB|VSS synth_10498 VNB|VSS sky130_fd_sc_hd__inv_1
X$11420 VDD synth_6609 VDD VNB|VSS synth_6644 VNB|VSS sky130_fd_sc_hd__inv_1
X$11421 VDD synth_6906 VDD VNB|VSS synth_6918 VNB|VSS sky130_fd_sc_hd__inv_1
X$11422 VDD synth_3655 VDD VNB|VSS synth_3451 VNB|VSS sky130_fd_sc_hd__inv_1
X$11423 VDD synth_9693 VDD VNB|VSS synth_9419 VNB|VSS sky130_fd_sc_hd__inv_1
X$11424 VDD synth_2835 VDD VNB|VSS synth_2996 VNB|VSS sky130_fd_sc_hd__inv_1
X$11425 VDD synth_10016 VDD VNB|VSS synth_9936 VNB|VSS sky130_fd_sc_hd__inv_1
X$11426 VDD synth_6831 VDD VNB|VSS synth_6826 VNB|VSS sky130_fd_sc_hd__inv_1
X$11427 VDD synth_7544 VDD VNB|VSS synth_7546 VNB|VSS sky130_fd_sc_hd__inv_1
X$11428 VDD synth_9940 VDD VNB|VSS synth_10020 VNB|VSS sky130_fd_sc_hd__inv_1
X$11429 VDD synth_3883 VDD VNB|VSS synth_3812 VNB|VSS sky130_fd_sc_hd__inv_1
X$11430 VDD synth_11153 VDD VNB|VSS synth_11156 VNB|VSS sky130_fd_sc_hd__inv_1
X$11431 VDD synth_3884 VDD VNB|VSS synth_3917 VNB|VSS sky130_fd_sc_hd__inv_1
X$11432 VDD synth_3362 VDD VNB|VSS synth_3363 VNB|VSS sky130_fd_sc_hd__inv_1
X$11433 VDD synth_3407 VDD VNB|VSS synth_3404 VNB|VSS sky130_fd_sc_hd__inv_1
X$11434 VDD synth_4387 VDD VNB|VSS synth_4542 VNB|VSS sky130_fd_sc_hd__inv_1
X$11435 VDD synth_2825 VDD VNB|VSS synth_2823 VNB|VSS sky130_fd_sc_hd__inv_1
X$11436 VDD synth_1419 VDD VNB|VSS synth_1420 VNB|VSS sky130_fd_sc_hd__inv_1
X$11437 VDD synth_7026 VDD VNB|VSS synth_6809 VNB|VSS sky130_fd_sc_hd__inv_1
X$11438 VDD synth_8066 VDD VNB|VSS synth_8120 VNB|VSS sky130_fd_sc_hd__inv_1
X$11439 VDD synth_3218 VDD VNB|VSS synth_3347 VNB|VSS sky130_fd_sc_hd__inv_1
X$11440 VDD synth_8099 VDD VNB|VSS synth_8268 VNB|VSS sky130_fd_sc_hd__inv_1
X$11441 VDD synth_8862 VDD VNB|VSS synth_8787 VNB|VSS sky130_fd_sc_hd__inv_1
X$11442 VDD synth_2778 VDD VNB|VSS synth_2857 VNB|VSS sky130_fd_sc_hd__inv_1
X$11443 VDD synth_2101 VDD VNB|VSS synth_2075 VNB|VSS sky130_fd_sc_hd__inv_1
X$11444 VDD synth_8626 VDD VNB|VSS synth_8755 VNB|VSS sky130_fd_sc_hd__inv_1
X$11445 VDD synth_10023 VDD VNB|VSS synth_10028 VNB|VSS sky130_fd_sc_hd__inv_1
X$11446 VDD synth_10076 VDD VNB|VSS synth_10139 VNB|VSS sky130_fd_sc_hd__inv_1
X$11447 VDD synth_8232 VDD VNB|VSS synth_7907 VNB|VSS sky130_fd_sc_hd__inv_1
X$11448 VDD synth_4633 VDD VNB|VSS synth_4665 VNB|VSS sky130_fd_sc_hd__inv_1
X$11449 VDD synth_10702 VDD VNB|VSS synth_10668 VNB|VSS sky130_fd_sc_hd__inv_1
X$11450 VDD synth_2532 VDD VNB|VSS synth_2557 VNB|VSS sky130_fd_sc_hd__inv_1
X$11451 VDD synth_10110 VDD VNB|VSS synth_10189 VNB|VSS sky130_fd_sc_hd__inv_1
X$11452 VDD synth_6245 VDD VNB|VSS synth_6382 VNB|VSS sky130_fd_sc_hd__inv_1
X$11453 VDD synth_7172 VDD VNB|VSS synth_6732 VNB|VSS sky130_fd_sc_hd__inv_1
X$11454 VDD synth_6928 VDD VNB|VSS synth_7074 VNB|VSS sky130_fd_sc_hd__inv_1
X$11455 VDD synth_424 VDD VNB|VSS synth_425 VNB|VSS sky130_fd_sc_hd__inv_1
X$11456 VDD synth_660 VDD VNB|VSS synth_553 VNB|VSS sky130_fd_sc_hd__inv_1
X$11457 VDD synth_6978 VDD VNB|VSS synth_7062 VNB|VSS sky130_fd_sc_hd__inv_1
X$11458 VDD synth_4684 VDD VNB|VSS synth_4948 VNB|VSS sky130_fd_sc_hd__inv_1
X$11459 VDD synth_7792 VDD VNB|VSS synth_7662 VNB|VSS sky130_fd_sc_hd__inv_1
X$11460 VDD synth_6185 VDD VNB|VSS synth_5888 VNB|VSS sky130_fd_sc_hd__inv_1
X$11461 VDD synth_7850 VDD VNB|VSS synth_7918 VNB|VSS sky130_fd_sc_hd__inv_1
X$11462 VDD synth_4528 VDD VNB|VSS synth_4733 VNB|VSS sky130_fd_sc_hd__inv_1
X$11463 VDD synth_2356 VDD VNB|VSS synth_2434 VNB|VSS sky130_fd_sc_hd__inv_1
X$11464 VDD synth_6439 VDD VNB|VSS synth_6628 VNB|VSS sky130_fd_sc_hd__inv_1
X$11465 VDD synth_6498 VDD VNB|VSS synth_6581 VNB|VSS sky130_fd_sc_hd__inv_1
X$11466 VDD synth_8381 VDD VNB|VSS synth_8519 VNB|VSS sky130_fd_sc_hd__inv_1
X$11467 VDD synth_1289 VDD VNB|VSS synth_1285 VNB|VSS sky130_fd_sc_hd__inv_1
X$11468 VDD synth_3241 VDD VNB|VSS synth_3475 VNB|VSS sky130_fd_sc_hd__inv_1
X$11469 VDD synth_6982 VDD VNB|VSS synth_7041 VNB|VSS sky130_fd_sc_hd__inv_1
X$11470 VDD synth_7728 VDD VNB|VSS synth_7786 VNB|VSS sky130_fd_sc_hd__inv_1
X$11471 VDD synth_8549 VDD VNB|VSS synth_8761 VNB|VSS sky130_fd_sc_hd__inv_1
X$11472 VDD synth_7788 VDD VNB|VSS synth_7785 VNB|VSS sky130_fd_sc_hd__inv_1
X$11473 VDD synth_1507 VDD VNB|VSS synth_1484 VNB|VSS sky130_fd_sc_hd__inv_1
X$11474 VDD synth_3382 VDD VNB|VSS synth_3446 VNB|VSS sky130_fd_sc_hd__inv_1
X$11475 VDD synth_1287 VDD VNB|VSS synth_1288 VNB|VSS sky130_fd_sc_hd__inv_1
X$11476 VDD synth_8223 VDD VNB|VSS synth_8297 VNB|VSS sky130_fd_sc_hd__inv_1
X$11477 VDD synth_1309 VDD VNB|VSS synth_1542 VNB|VSS sky130_fd_sc_hd__inv_1
X$11478 VDD synth_2663 VDD VNB|VSS synth_2675 VNB|VSS sky130_fd_sc_hd__inv_1
X$11479 VDD synth_8689 VDD VNB|VSS synth_8688 VNB|VSS sky130_fd_sc_hd__inv_1
X$11480 VDD synth_6315 VDD VNB|VSS synth_6401 VNB|VSS sky130_fd_sc_hd__inv_1
X$11481 VDD synth_1200 VDD VNB|VSS synth_1387 VNB|VSS sky130_fd_sc_hd__inv_1
X$11482 VDD synth_9624 VDD VNB|VSS synth_9674 VNB|VSS sky130_fd_sc_hd__inv_1
X$11483 VDD synth_2166 VDD VNB|VSS synth_2626 VNB|VSS sky130_fd_sc_hd__inv_1
X$11484 VDD synth_9623 VDD VNB|VSS synth_9741 VNB|VSS sky130_fd_sc_hd__inv_1
X$11485 VDD synth_6743 VDD VNB|VSS synth_6745 VNB|VSS sky130_fd_sc_hd__inv_1
X$11486 VDD synth_1455 VDD VNB|VSS synth_1529 VNB|VSS sky130_fd_sc_hd__inv_1
X$11487 VDD synth_3246 VDD VNB|VSS synth_3325 VNB|VSS sky130_fd_sc_hd__inv_1
X$11488 VDD synth_1575 VDD VNB|VSS synth_1626 VNB|VSS sky130_fd_sc_hd__inv_1
X$11489 VDD synth_6729 VDD VNB|VSS synth_6677 VNB|VSS sky130_fd_sc_hd__inv_1
X$11490 VDD synth_5878 VDD VNB|VSS synth_5923 VNB|VSS sky130_fd_sc_hd__inv_1
X$11491 VDD synth_1384 VDD VNB|VSS synth_1538 VNB|VSS sky130_fd_sc_hd__inv_1
X$11492 VDD synth_5877 VDD VNB|VSS synth_5922 VNB|VSS sky130_fd_sc_hd__inv_1
X$11493 VDD synth_6427 VDD VNB|VSS synth_6428 VNB|VSS sky130_fd_sc_hd__inv_1
X$11494 VDD synth_5325 VDD VNB|VSS synth_5490 VNB|VSS sky130_fd_sc_hd__inv_1
X$11495 VDD synth_2105 VDD VNB|VSS synth_2293 VNB|VSS sky130_fd_sc_hd__inv_1
X$11496 VDD synth_8614 VDD VNB|VSS synth_8781 VNB|VSS sky130_fd_sc_hd__inv_1
X$11497 VDD synth_5521 VDD VNB|VSS synth_5684 VNB|VSS sky130_fd_sc_hd__inv_1
X$11498 VDD synth_2757 VDD VNB|VSS synth_2662 VNB|VSS sky130_fd_sc_hd__inv_1
X$11499 VDD synth_4909 VDD VNB|VSS synth_5059 VNB|VSS sky130_fd_sc_hd__inv_1
X$11500 VDD synth_4872 VDD VNB|VSS synth_5099 VNB|VSS sky130_fd_sc_hd__inv_1
X$11501 VDD synth_10990 VDD VNB|VSS synth_11145 VNB|VSS sky130_fd_sc_hd__inv_1
X$11502 VDD synth_1192 VDD VNB|VSS synth_1318 VNB|VSS sky130_fd_sc_hd__inv_1
X$11503 VDD synth_7329 VDD VNB|VSS synth_7331 VNB|VSS sky130_fd_sc_hd__inv_1
X$11504 VDD synth_4878 VDD VNB|VSS synth_5202 VNB|VSS sky130_fd_sc_hd__inv_1
X$11505 VDD synth_1809 VDD VNB|VSS synth_1805 VNB|VSS sky130_fd_sc_hd__inv_1
X$11506 VDD synth_5188 VDD VNB|VSS synth_5444 VNB|VSS sky130_fd_sc_hd__inv_1
X$11507 VDD synth_3253 VDD VNB|VSS synth_3255 VNB|VSS sky130_fd_sc_hd__inv_1
X$11508 VDD synth_8690 VDD VNB|VSS synth_8838 VNB|VSS sky130_fd_sc_hd__inv_1
X$11509 VDD synth_1299 VDD VNB|VSS synth_1379 VNB|VSS sky130_fd_sc_hd__inv_1
X$11510 VDD synth_9058 VDD VNB|VSS synth_8784 VNB|VSS sky130_fd_sc_hd__inv_1
X$11511 VDD synth_7548 VDD VNB|VSS synth_7710 VNB|VSS sky130_fd_sc_hd__inv_1
X$11512 VDD synth_6784 VDD VNB|VSS synth_6720 VNB|VSS sky130_fd_sc_hd__inv_1
X$11513 VDD synth_683 VDD VNB|VSS synth_702 VNB|VSS sky130_fd_sc_hd__inv_1
X$11514 VDD synth_12791 VDD VNB|VSS synth_12518 VNB|VSS sky130_fd_sc_hd__inv_1
X$11515 VDD synth_12738 VDD VNB|VSS synth_12741 VNB|VSS sky130_fd_sc_hd__inv_1
X$11516 VDD synth_7107 VDD VNB|VSS synth_7239 VNB|VSS sky130_fd_sc_hd__inv_1
X$11517 VDD synth_7193 VDD VNB|VSS synth_7374 VNB|VSS sky130_fd_sc_hd__inv_1
X$11518 VDD synth_7858 VDD VNB|VSS synth_7998 VNB|VSS sky130_fd_sc_hd__inv_1
X$11519 VDD synth_7194 VDD VNB|VSS synth_7463 VNB|VSS sky130_fd_sc_hd__inv_1
X$11520 VDD synth_7621 VDD VNB|VSS synth_7836 VNB|VSS sky130_fd_sc_hd__inv_1
X$11521 VDD synth_2585 VDD VNB|VSS synth_2710 VNB|VSS sky130_fd_sc_hd__inv_1
X$11522 VDD synth_11099 VDD VNB|VSS synth_11196 VNB|VSS sky130_fd_sc_hd__inv_1
X$11523 VDD synth_11773 VDD VNB|VSS synth_11892 VNB|VSS sky130_fd_sc_hd__inv_1
X$11524 VDD synth_7547 VDD VNB|VSS synth_7834 VNB|VSS sky130_fd_sc_hd__inv_1
X$11525 VDD synth_7692 VDD VNB|VSS synth_7822 VNB|VSS sky130_fd_sc_hd__inv_1
X$11526 VDD synth_623 VDD VNB|VSS synth_350 VNB|VSS sky130_fd_sc_hd__inv_1
X$11527 VDD synth_1785 VDD VNB|VSS synth_1931 VNB|VSS sky130_fd_sc_hd__inv_1
X$11528 VDD synth_1802 VDD VNB|VSS synth_1930 VNB|VSS sky130_fd_sc_hd__inv_1
X$11529 VDD synth_1959 VDD VNB|VSS synth_1958 VNB|VSS sky130_fd_sc_hd__inv_1
X$11530 VDD synth_7698 VDD VNB|VSS synth_7831 VNB|VSS sky130_fd_sc_hd__inv_1
X$11531 VDD synth_5283 VDD VNB|VSS synth_5184 VNB|VSS sky130_fd_sc_hd__inv_1
X$11532 VDD synth_7408 VDD VNB|VSS synth_7312 VNB|VSS sky130_fd_sc_hd__inv_1
X$11533 VDD synth_159 VDD VNB|VSS synth_292 VNB|VSS sky130_fd_sc_hd__inv_1
X$11534 VDD synth_4714 VDD VNB|VSS synth_4737 VNB|VSS sky130_fd_sc_hd__inv_1
X$11535 VDD synth_4819 VDD VNB|VSS synth_5078 VNB|VSS sky130_fd_sc_hd__inv_1
X$11536 VDD synth_65 VDD VNB|VSS synth_228 VNB|VSS sky130_fd_sc_hd__inv_1
X$11537 VDD synth_7696 VDD VNB|VSS synth_7851 VNB|VSS sky130_fd_sc_hd__inv_1
X$11538 VDD synth_7454 VDD VNB|VSS synth_7583 VNB|VSS sky130_fd_sc_hd__inv_1
X$11539 VDD synth_7405 VDD VNB|VSS synth_7332 VNB|VSS sky130_fd_sc_hd__inv_1
X$11540 VDD synth_7580 VDD VNB|VSS synth_7702 VNB|VSS sky130_fd_sc_hd__inv_1
X$11541 VDD synth_4280 VDD VNB|VSS synth_4326 VNB|VSS sky130_fd_sc_hd__inv_1
X$11542 VDD synth_8706 VDD VNB|VSS synth_8680 VNB|VSS sky130_fd_sc_hd__inv_1
X$11543 VDD synth_7825 VDD VNB|VSS synth_7893 VNB|VSS sky130_fd_sc_hd__inv_1
X$11544 VDD synth_8430 VDD VNB|VSS synth_8683 VNB|VSS sky130_fd_sc_hd__inv_1
X$11545 VDD synth_7779 VDD VNB|VSS synth_7972 VNB|VSS sky130_fd_sc_hd__inv_1
X$11546 VDD synth_760 VDD VNB|VSS synth_1049 VNB|VSS sky130_fd_sc_hd__inv_1
X$11547 VDD synth_3987 VDD VNB|VSS synth_3989 VNB|VSS sky130_fd_sc_hd__inv_1
X$11548 VDD synth_7554 VDD VNB|VSS synth_7703 VNB|VSS sky130_fd_sc_hd__inv_1
X$11549 VDD synth_7395 VDD VNB|VSS synth_7394 VNB|VSS sky130_fd_sc_hd__inv_1
X$11550 VDD synth_8146 VDD VNB|VSS synth_7930 VNB|VSS sky130_fd_sc_hd__inv_1
X$11551 VDD synth_2098 VDD VNB|VSS synth_1960 VNB|VSS sky130_fd_sc_hd__inv_1
X$11552 VDD synth_761 VDD VNB|VSS synth_1048 VNB|VSS sky130_fd_sc_hd__inv_1
X$11553 VDD synth_7896 VDD VNB|VSS synth_7853 VNB|VSS sky130_fd_sc_hd__inv_1
X$11554 VDD synth_7485 VDD VNB|VSS synth_7575 VNB|VSS sky130_fd_sc_hd__inv_1
X$11555 VDD synth_81 VDD VNB|VSS synth_116 VNB|VSS sky130_fd_sc_hd__inv_1
X$11556 VDD synth_8145 VDD VNB|VSS synth_8295 VNB|VSS sky130_fd_sc_hd__inv_1
X$11557 VDD synth_5035 VDD VNB|VSS synth_5375 VNB|VSS sky130_fd_sc_hd__inv_1
X$11558 VDD synth_7484 VDD VNB|VSS synth_7711 VNB|VSS sky130_fd_sc_hd__inv_1
X$11559 VDD synth_12584 VDD VNB|VSS synth_12663 VNB|VSS sky130_fd_sc_hd__inv_1
X$11560 VDD synth_4779 VDD VNB|VSS synth_4967 VNB|VSS sky130_fd_sc_hd__inv_1
X$11561 VDD synth_4750 VDD VNB|VSS synth_4964 VNB|VSS sky130_fd_sc_hd__inv_1
X$11562 VDD synth_4536 VDD VNB|VSS synth_4870 VNB|VSS sky130_fd_sc_hd__inv_1
X$11563 VDD synth_12308 VDD VNB|VSS synth_12332 VNB|VSS sky130_fd_sc_hd__inv_1
X$11564 VDD synth_82 VDD VNB|VSS synth_253 VNB|VSS sky130_fd_sc_hd__inv_1
X$11565 VDD synth_2474 VDD VNB|VSS synth_2452 VNB|VSS sky130_fd_sc_hd__inv_1
X$11566 VDD synth_9759 VDD VNB|VSS synth_9690 VNB|VSS sky130_fd_sc_hd__inv_1
X$11567 VDD synth_6663 VDD VNB|VSS synth_6862 VNB|VSS sky130_fd_sc_hd__inv_1
X$11568 VDD synth_6367 VDD VNB|VSS synth_6865 VNB|VSS sky130_fd_sc_hd__inv_1
X$11569 VDD synth_2472 VDD VNB|VSS synth_2453 VNB|VSS sky130_fd_sc_hd__inv_1
X$11570 VDD synth_7397 VDD VNB|VSS synth_7456 VNB|VSS sky130_fd_sc_hd__inv_1
X$11571 VDD synth_12327 VDD VNB|VSS synth_12293 VNB|VSS sky130_fd_sc_hd__inv_1
X$11572 VDD synth_4716 VDD VNB|VSS synth_4715 VNB|VSS sky130_fd_sc_hd__inv_1
X$11573 VDD synth_1777 VDD VNB|VSS synth_1921 VNB|VSS sky130_fd_sc_hd__inv_1
X$11574 VDD synth_6586 VDD VNB|VSS synth_6879 VNB|VSS sky130_fd_sc_hd__inv_1
X$11575 VDD synth_8793 VDD VNB|VSS synth_8845 VNB|VSS sky130_fd_sc_hd__inv_1
X$11576 VDD synth_5562 VDD VNB|VSS synth_5476 VNB|VSS sky130_fd_sc_hd__inv_1
X$11577 VDD synth_12017 VDD VNB|VSS synth_12132 VNB|VSS sky130_fd_sc_hd__inv_1
X$11578 VDD synth_12721 VDD VNB|VSS synth_12522 VNB|VSS sky130_fd_sc_hd__inv_1
X$11579 VDD synth_8858 VDD VNB|VSS synth_8856 VNB|VSS sky130_fd_sc_hd__inv_1
X$11580 VDD synth_8445 VDD VNB|VSS synth_8612 VNB|VSS sky130_fd_sc_hd__inv_1
X$11581 VDD synth_12715 VDD VNB|VSS synth_12714 VNB|VSS sky130_fd_sc_hd__inv_1
X$11582 VDD synth_4941 VDD VNB|VSS synth_5034 VNB|VSS sky130_fd_sc_hd__inv_1
X$11583 VDD synth_5373 VDD VNB|VSS synth_5370 VNB|VSS sky130_fd_sc_hd__inv_1
X$11584 VDD synth_2877 VDD VNB|VSS synth_3127 VNB|VSS sky130_fd_sc_hd__inv_1
X$11585 VDD synth_2260 VDD VNB|VSS synth_2295 VNB|VSS sky130_fd_sc_hd__inv_1
X$11586 VDD synth_1941 VDD VNB|VSS synth_2074 VNB|VSS sky130_fd_sc_hd__inv_1
X$11587 VDD synth_3395 VDD VNB|VSS synth_3308 VNB|VSS sky130_fd_sc_hd__inv_1
X$11588 VDD synth_10191 VDD VNB|VSS synth_10190 VNB|VSS sky130_fd_sc_hd__inv_1
X$11589 VDD synth_3574 VDD VNB|VSS synth_3665 VNB|VSS sky130_fd_sc_hd__inv_1
X$11590 VDD synth_3048 VDD VNB|VSS synth_3128 VNB|VSS sky130_fd_sc_hd__inv_1
X$11591 VDD synth_3484 VDD VNB|VSS synth_3258 VNB|VSS sky130_fd_sc_hd__inv_1
X$11592 VDD synth_5977 VDD VNB|VSS synth_6039 VNB|VSS sky130_fd_sc_hd__inv_1
X$11593 VDD synth_6313 VDD VNB|VSS synth_6352 VNB|VSS sky130_fd_sc_hd__inv_1
X$11594 VDD synth_6289 VDD VNB|VSS synth_6353 VNB|VSS sky130_fd_sc_hd__inv_1
X$11595 VDD synth_3709 VDD VNB|VSS synth_3842 VNB|VSS sky130_fd_sc_hd__inv_1
X$11596 VDD synth_5550 VDD VNB|VSS synth_5577 VNB|VSS sky130_fd_sc_hd__inv_1
X$11597 VDD synth_5549 VDD VNB|VSS synth_5578 VNB|VSS sky130_fd_sc_hd__inv_1
X$11598 VDD synth_10767 VDD VNB|VSS synth_10766 VNB|VSS sky130_fd_sc_hd__inv_1
X$11599 VDD synth_5002 VDD VNB|VSS synth_5123 VNB|VSS sky130_fd_sc_hd__inv_1
X$11600 VDD synth_2464 VDD VNB|VSS synth_2677 VNB|VSS sky130_fd_sc_hd__inv_1
X$11601 VDD synth_3778 VDD VNB|VSS synth_3845 VNB|VSS sky130_fd_sc_hd__inv_1
X$11602 VDD synth_2496 VDD VNB|VSS synth_2676 VNB|VSS sky130_fd_sc_hd__inv_1
X$11603 VDD synth_6176 VDD VNB|VSS synth_6355 VNB|VSS sky130_fd_sc_hd__inv_1
X$11604 VDD synth_11040 VDD VNB|VSS synth_10951 VNB|VSS sky130_fd_sc_hd__inv_1
X$11605 VDD synth_3799 VDD VNB|VSS synth_3733 VNB|VSS sky130_fd_sc_hd__inv_1
X$11606 VDD synth_3674 VDD VNB|VSS synth_3865 VNB|VSS sky130_fd_sc_hd__inv_1
X$11607 VDD synth_801 VDD VNB|VSS synth_1154 VNB|VSS sky130_fd_sc_hd__inv_1
X$11608 VDD synth_3230 VDD VNB|VSS synth_3443 VNB|VSS sky130_fd_sc_hd__inv_1
X$11609 VDD synth_6302 VDD VNB|VSS synth_6410 VNB|VSS sky130_fd_sc_hd__inv_1
X$11610 VDD synth_6386 VDD VNB|VSS synth_6463 VNB|VSS sky130_fd_sc_hd__inv_1
X$11611 VDD synth_893 VDD VNB|VSS synth_1236 VNB|VSS sky130_fd_sc_hd__inv_1
X$11612 VDD synth_5800 VDD VNB|VSS synth_5940 VNB|VSS sky130_fd_sc_hd__inv_1
X$11613 VDD synth_5289 VDD VNB|VSS synth_5442 VNB|VSS sky130_fd_sc_hd__inv_1
X$11614 VDD synth_5998 VDD VNB|VSS synth_5828 VNB|VSS sky130_fd_sc_hd__inv_1
X$11615 VDD synth_5994 VDD VNB|VSS synth_5992 VNB|VSS sky130_fd_sc_hd__inv_1
X$11616 VDD synth_3428 VDD VNB|VSS synth_3586 VNB|VSS sky130_fd_sc_hd__inv_1
X$11617 VDD synth_5771 VDD VNB|VSS synth_5941 VNB|VSS sky130_fd_sc_hd__inv_1
X$11618 VDD synth_1644 VDD VNB|VSS synth_1783 VNB|VSS sky130_fd_sc_hd__inv_1
X$11619 VDD synth_6434 VDD VNB|VSS synth_6404 VNB|VSS sky130_fd_sc_hd__inv_1
X$11620 VDD synth_5632 VDD VNB|VSS synth_6096 VNB|VSS sky130_fd_sc_hd__inv_1
X$11621 VDD synth_2608 VDD VNB|VSS synth_2751 VNB|VSS sky130_fd_sc_hd__inv_1
X$11622 VDD synth_5526 VDD VNB|VSS synth_5551 VNB|VSS sky130_fd_sc_hd__inv_1
X$11623 VDD synth_6307 VDD VNB|VSS synth_6305 VNB|VSS sky130_fd_sc_hd__inv_1
X$11624 VDD synth_2883 VDD VNB|VSS synth_3063 VNB|VSS sky130_fd_sc_hd__inv_1
X$11625 VDD synth_3100 VDD VNB|VSS synth_3287 VNB|VSS sky130_fd_sc_hd__inv_1
X$11626 VDD synth_3129 VDD VNB|VSS synth_3423 VNB|VSS sky130_fd_sc_hd__inv_1
X$11627 VDD synth_3202 VDD VNB|VSS synth_3496 VNB|VSS sky130_fd_sc_hd__inv_1
X$11628 VDD synth_3554 VDD VNB|VSS synth_3622 VNB|VSS sky130_fd_sc_hd__inv_1
X$11629 VDD synth_11052 VDD VNB|VSS synth_11126 VNB|VSS sky130_fd_sc_hd__inv_1
X$11630 VDD synth_3453 VDD VNB|VSS synth_3863 VNB|VSS sky130_fd_sc_hd__inv_1
X$11631 VDD synth_1947 VDD VNB|VSS synth_2003 VNB|VSS sky130_fd_sc_hd__inv_1
X$11632 VDD synth_2448 VDD VNB|VSS synth_2469 VNB|VSS sky130_fd_sc_hd__inv_1
X$11633 VDD synth_2501 VDD VNB|VSS synth_2467 VNB|VSS sky130_fd_sc_hd__inv_1
X$11634 VDD synth_3838 VDD VNB|VSS synth_4038 VNB|VSS sky130_fd_sc_hd__inv_1
X$11635 VDD synth_2416 VDD VNB|VSS synth_2417 VNB|VSS sky130_fd_sc_hd__inv_1
X$11636 VDD synth_10303 VDD VNB|VSS synth_10429 VNB|VSS sky130_fd_sc_hd__inv_1
X$11637 VDD synth_4298 VDD VNB|VSS synth_4459 VNB|VSS sky130_fd_sc_hd__inv_1
X$11638 VDD synth_3024 VDD VNB|VSS synth_3132 VNB|VSS sky130_fd_sc_hd__inv_1
X$11639 VDD synth_2570 VDD VNB|VSS synth_2644 VNB|VSS sky130_fd_sc_hd__inv_1
X$11640 VDD synth_2717 VDD VNB|VSS synth_2904 VNB|VSS sky130_fd_sc_hd__inv_1
X$11641 VDD synth_10835 VDD VNB|VSS synth_10909 VNB|VSS sky130_fd_sc_hd__inv_1
X$11642 VDD synth_1761 VDD VNB|VSS synth_1943 VNB|VSS sky130_fd_sc_hd__inv_1
X$11643 VDD synth_1704 VDD VNB|VSS synth_1993 VNB|VSS sky130_fd_sc_hd__inv_1
X$11644 VDD synth_10787 VDD VNB|VSS synth_10908 VNB|VSS sky130_fd_sc_hd__inv_1
X$11645 VDD synth_10304 VDD VNB|VSS synth_10472 VNB|VSS sky130_fd_sc_hd__inv_1
X$11646 VDD synth_3916 VDD VNB|VSS synth_4128 VNB|VSS sky130_fd_sc_hd__inv_1
X$11647 VDD synth_4719 VDD VNB|VSS synth_4765 VNB|VSS sky130_fd_sc_hd__inv_1
X$11648 VDD synth_2131 VDD VNB|VSS synth_2237 VNB|VSS sky130_fd_sc_hd__inv_1
X$11649 VDD synth_5169 VDD VNB|VSS synth_5430 VNB|VSS sky130_fd_sc_hd__inv_1
X$11650 VDD synth_4389 VDD VNB|VSS synth_4390 VNB|VSS sky130_fd_sc_hd__inv_1
X$11651 VDD synth_4338 VDD VNB|VSS synth_4430 VNB|VSS sky130_fd_sc_hd__inv_1
X$11652 VDD synth_4391 VDD VNB|VSS synth_4472 VNB|VSS sky130_fd_sc_hd__inv_1
X$11653 VDD synth_1977 VDD VNB|VSS synth_1987 VNB|VSS sky130_fd_sc_hd__inv_1
X$11654 VDD synth_764 VDD VNB|VSS synth_777 VNB|VSS sky130_fd_sc_hd__inv_1
X$11655 VDD synth_1975 VDD VNB|VSS synth_1976 VNB|VSS sky130_fd_sc_hd__inv_1
X$11656 VDD synth_2315 VDD VNB|VSS synth_2521 VNB|VSS sky130_fd_sc_hd__inv_1
X$11657 VDD synth_2712 VDD VNB|VSS synth_2851 VNB|VSS sky130_fd_sc_hd__inv_1
X$11658 VDD synth_2438 VDD VNB|VSS synth_2495 VNB|VSS sky130_fd_sc_hd__inv_1
X$11659 VDD synth_2462 VDD VNB|VSS synth_2494 VNB|VSS sky130_fd_sc_hd__inv_1
X$11660 VDD synth_2286 VDD VNB|VSS synth_2382 VNB|VSS sky130_fd_sc_hd__inv_1
X$11661 VDD synth_3774 VDD VNB|VSS synth_4050 VNB|VSS sky130_fd_sc_hd__inv_1
X$11662 VDD synth_3450 VDD VNB|VSS synth_3490 VNB|VSS sky130_fd_sc_hd__inv_1
X$11663 VDD synth_4555 VDD VNB|VSS synth_4584 VNB|VSS sky130_fd_sc_hd__inv_1
X$11664 VDD synth_10347 VDD VNB|VSS synth_10551 VNB|VSS sky130_fd_sc_hd__inv_1
X$11665 VDD synth_1582 VDD VNB|VSS synth_1768 VNB|VSS sky130_fd_sc_hd__inv_1
X$11666 VDD synth_10212 VDD VNB|VSS synth_11793 VNB|VSS sky130_fd_sc_hd__inv_1
X$11667 VDD synth_639 VDD VNB|VSS synth_834 VNB|VSS sky130_fd_sc_hd__inv_1
X$11668 VDD synth_5655 VDD VNB|VSS synth_5906 VNB|VSS sky130_fd_sc_hd__inv_1
X$11669 VDD synth_5752 VDD VNB|VSS synth_5774 VNB|VSS sky130_fd_sc_hd__inv_1
X$11670 VDD synth_2499 VDD VNB|VSS synth_2288 VNB|VSS sky130_fd_sc_hd__inv_1
X$11671 VDD synth_333 VDD VNB|VSS synth_534 VNB|VSS sky130_fd_sc_hd__inv_1
X$11672 VDD synth_4749 VDD VNB|VSS synth_4846 VNB|VSS sky130_fd_sc_hd__inv_1
X$11673 VDD synth_5987 VDD VNB|VSS synth_5986 VNB|VSS sky130_fd_sc_hd__inv_1
X$11674 VDD synth_2492 VDD VNB|VSS synth_2362 VNB|VSS sky130_fd_sc_hd__inv_1
X$11675 VDD synth_1065 VDD VNB|VSS synth_1130 VNB|VSS sky130_fd_sc_hd__inv_1
X$11676 VDD synth_2138 VDD VNB|VSS synth_2364 VNB|VSS sky130_fd_sc_hd__inv_1
X$11677 VDD synth_894 VDD VNB|VSS synth_1235 VNB|VSS sky130_fd_sc_hd__inv_1
X$11678 VDD synth_12440 VDD VNB|VSS synth_12490 VNB|VSS sky130_fd_sc_hd__inv_1
X$11679 VDD synth_5981 VDD VNB|VSS synth_5979 VNB|VSS sky130_fd_sc_hd__inv_1
X$11680 VDD synth_2890 VDD VNB|VSS synth_2815 VNB|VSS sky130_fd_sc_hd__inv_1
X$11681 VDD synth_5413 VDD VNB|VSS synth_5331 VNB|VSS sky130_fd_sc_hd__inv_1
X$11682 VDD synth_4983 VDD VNB|VSS synth_5140 VNB|VSS sky130_fd_sc_hd__inv_1
X$11683 VDD synth_10205 VDD VNB|VSS synth_10335 VNB|VSS sky130_fd_sc_hd__inv_1
X$11684 VDD synth_1194 VDD VNB|VSS synth_1370 VNB|VSS sky130_fd_sc_hd__inv_1
X$11685 VDD synth_2667 VDD VNB|VSS synth_2817 VNB|VSS sky130_fd_sc_hd__inv_1
X$11686 VDD synth_896 VDD VNB|VSS synth_1025 VNB|VSS sky130_fd_sc_hd__inv_1
X$11687 VDD synth_2671 VDD VNB|VSS synth_2970 VNB|VSS sky130_fd_sc_hd__inv_1
X$11688 VDD synth_5275 VDD VNB|VSS synth_5358 VNB|VSS sky130_fd_sc_hd__inv_1
X$11689 VDD synth_5416 VDD VNB|VSS synth_5542 VNB|VSS sky130_fd_sc_hd__inv_1
X$11690 VDD synth_12718 VDD VNB|VSS synth_12699 VNB|VSS sky130_fd_sc_hd__inv_1
X$11691 VDD synth_2908 VDD VNB|VSS synth_3067 VNB|VSS sky130_fd_sc_hd__inv_1
X$11692 VDD synth_2729 VDD VNB|VSS synth_2776 VNB|VSS sky130_fd_sc_hd__inv_1
X$11693 VDD synth_11200 VDD VNB|VSS synth_11268 VNB|VSS sky130_fd_sc_hd__inv_1
X$11694 VDD synth_5718 VDD VNB|VSS synth_5866 VNB|VSS sky130_fd_sc_hd__inv_1
X$11695 VDD synth_1350 VDD VNB|VSS synth_1264 VNB|VSS sky130_fd_sc_hd__inv_1
X$11696 VDD synth_2591 VDD VNB|VSS synth_2690 VNB|VSS sky130_fd_sc_hd__inv_1
X$11697 VDD synth_2526 VDD VNB|VSS synth_2709 VNB|VSS sky130_fd_sc_hd__inv_1
X$11698 VDD synth_2689 VDD VNB|VSS synth_2841 VNB|VSS sky130_fd_sc_hd__inv_1
X$11699 VDD synth_8475 VDD VNB|VSS synth_8598 VNB|VSS sky130_fd_sc_hd__inv_1
X$11700 VDD synth_3023 VDD VNB|VSS synth_3206 VNB|VSS sky130_fd_sc_hd__inv_1
X$11701 VDD synth_675 VDD VNB|VSS synth_729 VNB|VSS sky130_fd_sc_hd__inv_1
X$11702 VDD synth_5174 VDD VNB|VSS synth_5182 VNB|VSS sky130_fd_sc_hd__inv_1
X$11703 VDD synth_4794 VDD VNB|VSS synth_4919 VNB|VSS sky130_fd_sc_hd__inv_1
X$11704 VDD synth_203 VDD VNB|VSS synth_176 VNB|VSS sky130_fd_sc_hd__inv_1
X$11705 VDD synth_12514 VDD VNB|VSS synth_12633 VNB|VSS sky130_fd_sc_hd__inv_1
X$11706 VDD synth_12579 VDD VNB|VSS synth_12747 VNB|VSS sky130_fd_sc_hd__inv_1
X$11707 VDD synth_6148 VDD VNB|VSS synth_6283 VNB|VSS sky130_fd_sc_hd__inv_1
X$11708 VDD synth_8554 VDD VNB|VSS synth_8597 VNB|VSS sky130_fd_sc_hd__inv_1
X$11709 VDD synth_9979 VDD VNB|VSS synth_10154 VNB|VSS sky130_fd_sc_hd__inv_1
X$11710 VDD synth_4728 VDD VNB|VSS synth_4891 VNB|VSS sky130_fd_sc_hd__inv_1
X$11711 VDD synth_4182 VDD VNB|VSS synth_4348 VNB|VSS sky130_fd_sc_hd__inv_1
X$11712 VDD synth_4271 VDD VNB|VSS synth_4270 VNB|VSS sky130_fd_sc_hd__inv_1
X$11713 VDD synth_4181 VDD VNB|VSS synth_4349 VNB|VSS sky130_fd_sc_hd__inv_1
X$11714 VDD synth_3836 VDD VNB|VSS synth_3992 VNB|VSS sky130_fd_sc_hd__inv_1
X$11715 VDD synth_4788 VDD VNB|VSS synth_4885 VNB|VSS sky130_fd_sc_hd__inv_1
X$11716 VDD synth_4789 VDD VNB|VSS synth_4886 VNB|VSS sky130_fd_sc_hd__inv_1
X$11717 VDD synth_2544 VDD VNB|VSS synth_2622 VNB|VSS sky130_fd_sc_hd__inv_1
X$11718 VDD synth_5779 VDD VNB|VSS synth_5950 VNB|VSS sky130_fd_sc_hd__inv_1
X$11719 VDD synth_3957 VDD VNB|VSS synth_3995 VNB|VSS sky130_fd_sc_hd__inv_1
X$11720 VDD synth_3602 VDD VNB|VSS synth_3789 VNB|VSS sky130_fd_sc_hd__inv_1
X$11721 VDD synth_3430 VDD VNB|VSS synth_3603 VNB|VSS sky130_fd_sc_hd__inv_1
X$11722 VDD synth_10436 VDD VNB|VSS synth_10557 VNB|VSS sky130_fd_sc_hd__inv_1
X$11723 VDD synth_11034 VDD VNB|VSS synth_11176 VNB|VSS sky130_fd_sc_hd__inv_1
X$11724 VDD synth_3724 VDD VNB|VSS synth_3864 VNB|VSS sky130_fd_sc_hd__inv_1
X$11725 VDD synth_1757 VDD VNB|VSS synth_1747 VNB|VSS sky130_fd_sc_hd__inv_1
X$11726 VDD synth_11664 VDD VNB|VSS synth_11715 VNB|VSS sky130_fd_sc_hd__inv_1
X$11727 VDD synth_3630 VDD VNB|VSS synth_3741 VNB|VSS sky130_fd_sc_hd__inv_1
X$11728 VDD synth_1816 VDD VNB|VSS synth_1852 VNB|VSS sky130_fd_sc_hd__inv_1
X$11729 VDD synth_3996 VDD VNB|VSS synth_4068 VNB|VSS sky130_fd_sc_hd__inv_1
X$11730 VDD synth_8322 VDD VNB|VSS synth_8379 VNB|VSS sky130_fd_sc_hd__inv_1
X$11731 VDD synth_11899 VDD VNB|VSS synth_12023 VNB|VSS sky130_fd_sc_hd__inv_1
X$11732 VDD synth_5945 VDD VNB|VSS synth_6269 VNB|VSS sky130_fd_sc_hd__inv_1
X$11733 VDD synth_5830 VDD VNB|VSS synth_5916 VNB|VSS sky130_fd_sc_hd__inv_1
X$11734 VDD synth_5973 VDD VNB|VSS synth_6507 VNB|VSS sky130_fd_sc_hd__inv_1
X$11735 VDD synth_11854 VDD VNB|VSS synth_11991 VNB|VSS sky130_fd_sc_hd__inv_1
X$11736 VDD synth_11026 VDD VNB|VSS synth_10953 VNB|VSS sky130_fd_sc_hd__inv_1
X$11737 VDD synth_2060 VDD VNB|VSS synth_2246 VNB|VSS sky130_fd_sc_hd__inv_1
X$11738 VDD synth_2245 VDD VNB|VSS synth_2244 VNB|VSS sky130_fd_sc_hd__inv_1
X$11739 VDD synth_8330 VDD VNB|VSS synth_8418 VNB|VSS sky130_fd_sc_hd__inv_1
X$11740 VDD synth_11028 VDD VNB|VSS synth_10956 VNB|VSS sky130_fd_sc_hd__inv_1
X$11741 VDD synth_5452 VDD VNB|VSS synth_5405 VNB|VSS sky130_fd_sc_hd__inv_1
X$11742 VDD synth_5326 VDD VNB|VSS synth_5588 VNB|VSS sky130_fd_sc_hd__inv_1
X$11743 VDD synth_5011 VDD VNB|VSS synth_5136 VNB|VSS sky130_fd_sc_hd__inv_1
X$11744 VDD synth_5559 VDD VNB|VSS synth_5647 VNB|VSS sky130_fd_sc_hd__inv_1
X$11745 VDD synth_5214 VDD VNB|VSS synth_5013 VNB|VSS sky130_fd_sc_hd__inv_1
X$11746 VDD synth_11258 VDD VNB|VSS synth_11252 VNB|VSS sky130_fd_sc_hd__inv_1
X$11747 VDD synth_165 VDD VNB|VSS synth_301 VNB|VSS sky130_fd_sc_hd__inv_1
X$11748 VDD synth_71 VDD VNB|VSS synth_300 VNB|VSS sky130_fd_sc_hd__inv_1
X$11749 VDD synth_4087 VDD VNB|VSS synth_4086 VNB|VSS sky130_fd_sc_hd__inv_1
X$11750 VDD synth_4088 VDD VNB|VSS synth_4069 VNB|VSS sky130_fd_sc_hd__inv_1
X$11751 VDD synth_2551 VDD VNB|VSS synth_2604 VNB|VSS sky130_fd_sc_hd__inv_1
X$11752 VDD synth_10251 VDD VNB|VSS synth_10499 VNB|VSS sky130_fd_sc_hd__inv_1
X$11753 VDD synth_908 VDD VNB|VSS synth_1046 VNB|VSS sky130_fd_sc_hd__inv_1
X$11754 VDD synth_11238 VDD VNB|VSS synth_11239 VNB|VSS sky130_fd_sc_hd__inv_1
X$11755 VDD synth_8127 VDD VNB|VSS synth_8269 VNB|VSS sky130_fd_sc_hd__inv_1
X$11756 VDD synth_10930 VDD VNB|VSS synth_11276 VNB|VSS sky130_fd_sc_hd__inv_1
X$11757 VDD synth_7988 VDD VNB|VSS synth_8152 VNB|VSS sky130_fd_sc_hd__inv_1
X$11758 VDD synth_815 VDD VNB|VSS synth_791 VNB|VSS sky130_fd_sc_hd__inv_1
X$11759 VDD synth_6710 VDD VNB|VSS synth_6931 VNB|VSS sky130_fd_sc_hd__inv_1
X$11760 VDD synth_11397 VDD VNB|VSS synth_11343 VNB|VSS sky130_fd_sc_hd__inv_1
X$11761 VDD synth_6620 VDD VNB|VSS synth_6426 VNB|VSS sky130_fd_sc_hd__inv_1
X$11762 VDD synth_6166 VDD VNB|VSS synth_6265 VNB|VSS sky130_fd_sc_hd__inv_1
X$11763 VDD synth_11523 VDD VNB|VSS synth_11615 VNB|VSS sky130_fd_sc_hd__inv_1
X$11764 VDD synth_10071 VDD VNB|VSS synth_10331 VNB|VSS sky130_fd_sc_hd__inv_1
X$11765 VDD synth_4445 VDD VNB|VSS synth_4510 VNB|VSS sky130_fd_sc_hd__inv_1
X$11766 VDD synth_7063 VDD VNB|VSS synth_6789 VNB|VSS sky130_fd_sc_hd__inv_1
X$11767 VDD synth_7419 VDD VNB|VSS synth_7528 VNB|VSS sky130_fd_sc_hd__inv_1
X$11768 VDD synth_3178 VDD VNB|VSS synth_3177 VNB|VSS sky130_fd_sc_hd__inv_1
X$11769 VDD synth_1940 VDD VNB|VSS synth_1731 VNB|VSS sky130_fd_sc_hd__inv_1
X$11770 VDD synth_3383 VDD VNB|VSS synth_3445 VNB|VSS sky130_fd_sc_hd__inv_1
X$11771 VDD synth_559 VDD VNB|VSS synth_246 VNB|VSS sky130_fd_sc_hd__inv_1
X$11772 VDD synth_11484 VDD VNB|VSS synth_11614 VNB|VSS sky130_fd_sc_hd__inv_1
X$11773 VDD synth_11584 VDD VNB|VSS synth_11695 VNB|VSS sky130_fd_sc_hd__inv_1
X$11774 VDD synth_8458 VDD VNB|VSS synth_8502 VNB|VSS sky130_fd_sc_hd__inv_1
X$11775 VDD synth_2955 VDD VNB|VSS synth_3005 VNB|VSS sky130_fd_sc_hd__inv_1
X$11776 VDD synth_1349 VDD VNB|VSS synth_1263 VNB|VSS sky130_fd_sc_hd__inv_1
X$11777 VDD synth_12449 VDD VNB|VSS synth_12793 VNB|VSS sky130_fd_sc_hd__inv_1
X$11778 VDD synth_522 VDD VNB|VSS synth_689 VNB|VSS sky130_fd_sc_hd__inv_1
X$11779 VDD synth_7684 VDD VNB|VSS synth_7829 VNB|VSS sky130_fd_sc_hd__inv_1
X$11780 VDD synth_12733 VDD VNB|VSS synth_12681 VNB|VSS sky130_fd_sc_hd__inv_1
X$11781 VDD synth_11381 VDD VNB|VSS synth_11578 VNB|VSS sky130_fd_sc_hd__inv_1
X$11782 VDD synth_8498 VDD VNB|VSS synth_8580 VNB|VSS sky130_fd_sc_hd__inv_1
X$11783 VDD synth_629 VDD VNB|VSS synth_690 VNB|VSS sky130_fd_sc_hd__inv_1
X$11784 VDD synth_723 VDD VNB|VSS synth_615 VNB|VSS sky130_fd_sc_hd__inv_1
X$11785 VDD synth_8412 VDD VNB|VSS synth_8656 VNB|VSS sky130_fd_sc_hd__inv_1
X$11786 VDD synth_11042 VDD VNB|VSS synth_10966 VNB|VSS sky130_fd_sc_hd__inv_1
X$11787 VDD synth_11071 VDD VNB|VSS synth_10924 VNB|VSS sky130_fd_sc_hd__inv_1
X$11788 VDD synth_1513 VDD VNB|VSS synth_1356 VNB|VSS sky130_fd_sc_hd__inv_1
X$11789 VDD synth_12471 VDD VNB|VSS synth_12541 VNB|VSS sky130_fd_sc_hd__inv_1
X$11790 VDD synth_613 VDD VNB|VSS synth_722 VNB|VSS sky130_fd_sc_hd__inv_1
X$11791 VDD synth_1714 VDD VNB|VSS synth_1920 VNB|VSS sky130_fd_sc_hd__inv_1
X$11792 VDD synth_6985 VDD VNB|VSS synth_6851 VNB|VSS sky130_fd_sc_hd__inv_1
X$11793 VDD synth_12542 VDD VNB|VSS synth_12775 VNB|VSS sky130_fd_sc_hd__inv_1
X$11794 VDD synth_7281 VDD VNB|VSS synth_7478 VNB|VSS sky130_fd_sc_hd__inv_1
X$11795 VDD synth_7385 VDD VNB|VSS synth_7521 VNB|VSS sky130_fd_sc_hd__inv_1
X$11796 VDD synth_100 VDD VNB|VSS synth_302 VNB|VSS sky130_fd_sc_hd__inv_1
X$11797 VDD synth_4599 VDD VNB|VSS synth_4704 VNB|VSS sky130_fd_sc_hd__inv_1
X$11798 VDD synth_12786 VDD VNB|VSS synth_12788 VNB|VSS sky130_fd_sc_hd__inv_1
X$11799 VDD synth_8673 VDD VNB|VSS synth_8670 VNB|VSS sky130_fd_sc_hd__inv_1
X$11800 VDD synth_12066 VDD VNB|VSS synth_12122 VNB|VSS sky130_fd_sc_hd__inv_1
X$11801 VDD synth_7036 VDD VNB|VSS synth_7152 VNB|VSS sky130_fd_sc_hd__inv_1
X$11802 VDD synth_1735 VDD VNB|VSS synth_1860 VNB|VSS sky130_fd_sc_hd__inv_1
X$11803 VDD synth_8892 VDD VNB|VSS synth_9163 VNB|VSS sky130_fd_sc_hd__inv_1
X$11804 VDD synth_9142 VDD VNB|VSS synth_9053 VNB|VSS sky130_fd_sc_hd__inv_1
X$11805 VDD synth_9125 VDD VNB|VSS synth_9013 VNB|VSS sky130_fd_sc_hd__inv_1
X$11806 VDD synth_9499 VDD VNB|VSS synth_9498 VNB|VSS sky130_fd_sc_hd__inv_1
X$11807 VDD synth_2341 VDD VNB|VSS synth_2405 VNB|VSS sky130_fd_sc_hd__inv_1
X$11808 VDD synth_6624 VDD VNB|VSS synth_6661 VNB|VSS sky130_fd_sc_hd__inv_1
X$11809 VDD synth_12613 VDD VNB|VSS synth_12787 VNB|VSS sky130_fd_sc_hd__inv_1
X$11810 VDD synth_10166 VDD VNB|VSS synth_10257 VNB|VSS sky130_fd_sc_hd__inv_1
X$11811 VDD synth_5995 VDD VNB|VSS synth_6105 VNB|VSS sky130_fd_sc_hd__inv_1
X$11812 VDD synth_6247 VDD VNB|VSS synth_6321 VNB|VSS sky130_fd_sc_hd__inv_1
X$11813 VDD synth_6668 VDD VNB|VSS synth_6669 VNB|VSS sky130_fd_sc_hd__inv_1
X$11814 VDD synth_9911 VDD VNB|VSS synth_9953 VNB|VSS sky130_fd_sc_hd__inv_1
X$11815 VDD synth_3092 VDD VNB|VSS synth_3235 VNB|VSS sky130_fd_sc_hd__inv_1
X$11816 VDD synth_9050 VDD VNB|VSS synth_9162 VNB|VSS sky130_fd_sc_hd__inv_1
X$11817 VDD synth_5205 VDD VNB|VSS synth_5378 VNB|VSS sky130_fd_sc_hd__inv_1
X$11818 VDD synth_519 VDD VNB|VSS synth_231 VNB|VSS sky130_fd_sc_hd__inv_1
X$11819 VDD synth_7254 VDD VNB|VSS synth_7358 VNB|VSS sky130_fd_sc_hd__inv_1
X$11820 VDD synth_1177 VDD VNB|VSS synth_1178 VNB|VSS sky130_fd_sc_hd__inv_1
X$11821 VDD synth_4756 VDD VNB|VSS synth_4949 VNB|VSS sky130_fd_sc_hd__inv_1
X$11822 VDD synth_6165 VDD VNB|VSS synth_6266 VNB|VSS sky130_fd_sc_hd__inv_1
X$11823 VDD synth_10701 VDD VNB|VSS synth_10745 VNB|VSS sky130_fd_sc_hd__inv_1
X$11824 VDD synth_9787 VDD VNB|VSS synth_9785 VNB|VSS sky130_fd_sc_hd__inv_1
X$11825 VDD synth_9602 VDD VNB|VSS synth_9603 VNB|VSS sky130_fd_sc_hd__inv_1
X$11826 VDD synth_9747 VDD VNB|VSS synth_9954 VNB|VSS sky130_fd_sc_hd__inv_1
X$11827 VDD synth_7124 VDD VNB|VSS synth_7039 VNB|VSS sky130_fd_sc_hd__inv_1
X$11828 VDD synth_11563 VDD VNB|VSS synth_11542 VNB|VSS sky130_fd_sc_hd__inv_1
X$11829 VDD synth_9015 VDD VNB|VSS synth_9082 VNB|VSS sky130_fd_sc_hd__inv_1
X$11830 VDD synth_12475 VDD VNB|VSS synth_12535 VNB|VSS sky130_fd_sc_hd__inv_1
X$11831 VDD synth_12031 VDD VNB|VSS synth_12150 VNB|VSS sky130_fd_sc_hd__inv_1
X$11832 VDD synth_9569 VDD VNB|VSS synth_9639 VNB|VSS sky130_fd_sc_hd__inv_1
X$11833 VDD synth_8724 VDD VNB|VSS synth_8663 VNB|VSS sky130_fd_sc_hd__inv_1
X$11834 VDD synth_6579 VDD VNB|VSS synth_6660 VNB|VSS sky130_fd_sc_hd__inv_1
X$11835 VDD synth_7677 VDD VNB|VSS synth_7818 VNB|VSS sky130_fd_sc_hd__inv_1
X$11836 VDD synth_7383 VDD VNB|VSS synth_7715 VNB|VSS sky130_fd_sc_hd__inv_1
X$11837 VDD synth_11266 VDD VNB|VSS synth_11365 VNB|VSS sky130_fd_sc_hd__inv_1
X$11838 VDD synth_6811 VDD VNB|VSS synth_6749 VNB|VSS sky130_fd_sc_hd__inv_1
X$11839 VDD synth_1720 VDD VNB|VSS synth_1847 VNB|VSS sky130_fd_sc_hd__inv_1
X$11840 VDD synth_1722 synth_1724 synth_1720 synth_1619 synth_2041 VDD VNB|VSS
+ VNB|VSS sky130_fd_sc_hd__or4_1
X$11841 VDD synth_6405 VDD VNB|VSS synth_6574 VNB|VSS sky130_fd_sc_hd__inv_1
X$11842 VDD synth_12723 VDD VNB|VSS synth_12707 VNB|VSS sky130_fd_sc_hd__inv_1
X$11843 VDD synth_12684 VDD VNB|VSS synth_12610 VNB|VSS sky130_fd_sc_hd__inv_1
X$11844 VDD synth_9447 VDD VNB|VSS synth_9525 VNB|VSS sky130_fd_sc_hd__inv_1
X$11845 VDD synth_7738 VDD VNB|VSS synth_6374 VNB|VSS sky130_fd_sc_hd__inv_1
X$11846 VDD synth_5575 VDD VNB|VSS synth_5683 VNB|VSS sky130_fd_sc_hd__inv_1
X$11847 VDD synth_6167 VDD VNB|VSS synth_6261 VNB|VSS sky130_fd_sc_hd__inv_1
X$11848 VDD synth_7879 VDD VNB|VSS synth_8119 VNB|VSS sky130_fd_sc_hd__inv_1
X$11849 VDD synth_9265 VDD VNB|VSS synth_9361 VNB|VSS sky130_fd_sc_hd__inv_1
X$11850 VDD synth_394 VDD VNB|VSS synth_142 VNB|VSS sky130_fd_sc_hd__inv_1
X$11851 VDD synth_2791 VDD VNB|VSS synth_2995 VNB|VSS sky130_fd_sc_hd__inv_1
X$11852 VDD synth_12060 VDD VNB|VSS synth_12062 VNB|VSS sky130_fd_sc_hd__inv_1
X$11853 VDD synth_4977 VDD VNB|VSS synth_5379 VNB|VSS sky130_fd_sc_hd__inv_1
X$11854 VDD synth_3961 VDD VNB|VSS synth_4029 VNB|VSS sky130_fd_sc_hd__inv_1
X$11855 VDD synth_8910 VDD VNB|VSS synth_9232 VNB|VSS sky130_fd_sc_hd__inv_1
X$11856 VDD synth_6520 VDD VNB|VSS synth_6647 VNB|VSS sky130_fd_sc_hd__inv_1
X$11857 VDD synth_7947 VDD VNB|VSS synth_8030 VNB|VSS sky130_fd_sc_hd__inv_1
X$11858 VDD synth_11413 VDD VNB|VSS synth_11411 VNB|VSS sky130_fd_sc_hd__inv_1
X$11859 VDD synth_11916 VDD VNB|VSS synth_12121 VNB|VSS sky130_fd_sc_hd__inv_1
X$11860 VDD synth_8579 VDD VNB|VSS synth_8789 VNB|VSS sky130_fd_sc_hd__inv_1
X$11861 VDD synth_8699 VDD VNB|VSS synth_8788 VNB|VSS sky130_fd_sc_hd__inv_1
X$11862 VDD synth_209 VDD VNB|VSS synth_320 VNB|VSS sky130_fd_sc_hd__inv_1
X$11863 VDD synth_8995 VDD VNB|VSS synth_9090 VNB|VSS sky130_fd_sc_hd__inv_1
X$11864 VDD synth_7080 VDD VNB|VSS synth_7160 VNB|VSS sky130_fd_sc_hd__inv_1
X$11865 VDD synth_9410 VDD VNB|VSS synth_9411 VNB|VSS sky130_fd_sc_hd__inv_1
X$11866 VDD synth_8853 VDD VNB|VSS synth_9088 VNB|VSS sky130_fd_sc_hd__inv_1
X$11867 VDD synth_59 VDD VNB|VSS synth_129 VNB|VSS sky130_fd_sc_hd__inv_1
X$11868 VDD synth_3272 VDD VNB|VSS synth_3593 VNB|VSS sky130_fd_sc_hd__inv_1
X$11869 VDD synth_4597 VDD VNB|VSS synth_7242 VNB|VSS sky130_fd_sc_hd__inv_1
X$11870 VDD synth_10882 VDD VNB|VSS synth_10960 VNB|VSS sky130_fd_sc_hd__inv_1
X$11871 VDD synth_1493 VDD VNB|VSS synth_1733 VNB|VSS sky130_fd_sc_hd__inv_1
X$11872 VDD synth_5637 VDD VNB|VSS synth_5767 VNB|VSS sky130_fd_sc_hd__inv_1
X$11873 VDD synth_1052 VDD VNB|VSS synth_1275 VNB|VSS sky130_fd_sc_hd__inv_1
X$11874 VDD synth_12591 VDD VNB|VSS synth_12665 VNB|VSS sky130_fd_sc_hd__inv_1
X$11875 VDD synth_1160 VDD VNB|VSS synth_1327 VNB|VSS sky130_fd_sc_hd__inv_1
X$11876 VDD synth_10992 VDD VNB|VSS synth_11184 VNB|VSS sky130_fd_sc_hd__inv_1
X$11877 VDD synth_1363 VDD VNB|VSS synth_1360 VNB|VSS sky130_fd_sc_hd__inv_1
X$11878 VDD synth_4503 VDD VNB|VSS synth_4661 VNB|VSS sky130_fd_sc_hd__inv_1
X$11879 VDD synth_12683 VDD VNB|VSS synth_12609 VNB|VSS sky130_fd_sc_hd__inv_1
X$11880 VDD synth_1351 VDD VNB|VSS synth_1431 VNB|VSS sky130_fd_sc_hd__inv_1
X$11881 VDD synth_12033 VDD VNB|VSS synth_12035 VNB|VSS sky130_fd_sc_hd__inv_1
X$11882 VDD synth_2120 VDD VNB|VSS synth_2168 VNB|VSS sky130_fd_sc_hd__inv_1
X$11883 VDD synth_9913 VDD VNB|VSS synth_10040 VNB|VSS sky130_fd_sc_hd__inv_1
X$11884 VDD synth_9814 VDD VNB|VSS synth_9960 VNB|VSS sky130_fd_sc_hd__inv_1
X$11885 VDD synth_4424 VDD VNB|VSS synth_4027 VNB|VSS sky130_fd_sc_hd__inv_1
X$11886 VDD synth_7530 VDD VNB|VSS synth_7609 VNB|VSS sky130_fd_sc_hd__inv_1
X$11887 VDD synth_3079 VDD VNB|VSS synth_3133 VNB|VSS sky130_fd_sc_hd__inv_1
X$11888 VDD synth_9146 VDD VNB|VSS synth_9122 VNB|VSS sky130_fd_sc_hd__inv_1
X$11889 VDD synth_7266 VDD VNB|VSS synth_7302 VNB|VSS sky130_fd_sc_hd__inv_1
X$11890 VDD synth_746 VDD VNB|VSS synth_714 VNB|VSS sky130_fd_sc_hd__inv_1
X$11891 VDD synth_7140 VDD VNB|VSS synth_7433 VNB|VSS sky130_fd_sc_hd__inv_1
X$11892 VDD synth_3760 VDD VNB|VSS synth_3880 VNB|VSS sky130_fd_sc_hd__inv_1
X$11893 VDD synth_1251 VDD VNB|VSS synth_1476 VNB|VSS sky130_fd_sc_hd__inv_1
X$11894 VDD synth_440 VDD VNB|VSS synth_185 VNB|VSS sky130_fd_sc_hd__inv_1
X$11895 VDD synth_1183 VDD VNB|VSS synth_1333 VNB|VSS sky130_fd_sc_hd__inv_1
X$11896 VDD synth_1250 VDD VNB|VSS synth_1475 VNB|VSS sky130_fd_sc_hd__inv_1
X$11897 VDD synth_87 VDD VNB|VSS synth_130 VNB|VSS sky130_fd_sc_hd__inv_1
X$11898 VDD synth_10120 VDD VNB|VSS synth_10121 VNB|VSS sky130_fd_sc_hd__inv_1
X$11899 VDD synth_12505 VDD VNB|VSS synth_12540 VNB|VSS sky130_fd_sc_hd__inv_1
X$11900 VDD synth_12290 VDD VNB|VSS synth_12350 VNB|VSS sky130_fd_sc_hd__inv_1
X$11901 VDD synth_2479 VDD VNB|VSS synth_2649 VNB|VSS sky130_fd_sc_hd__inv_1
X$11902 VDD synth_6458 VDD VNB|VSS synth_6576 VNB|VSS sky130_fd_sc_hd__inv_1
X$11903 VDD synth_7990 VDD VNB|VSS synth_8129 VNB|VSS sky130_fd_sc_hd__inv_1
X$11904 VDD synth_8571 VDD VNB|VSS synth_8564 VNB|VSS sky130_fd_sc_hd__inv_1
X$11905 VDD synth_8738 VDD VNB|VSS synth_9481 VNB|VSS sky130_fd_sc_hd__inv_1
X$11906 VDD synth_8270 VDD VNB|VSS synth_8341 VNB|VSS sky130_fd_sc_hd__inv_1
X$11907 VDD synth_9304 VDD VNB|VSS synth_9409 VNB|VSS sky130_fd_sc_hd__inv_1
X$11908 VDD synth_9764 VDD VNB|VSS synth_9563 VNB|VSS sky130_fd_sc_hd__inv_1
X$11909 VDD synth_2830 VDD VNB|VSS synth_2986 VNB|VSS sky130_fd_sc_hd__inv_1
X$11910 VDD synth_2858 VDD VNB|VSS synth_2940 VNB|VSS sky130_fd_sc_hd__inv_1
X$11911 VDD synth_10933 VDD VNB|VSS synth_10785 VNB|VSS sky130_fd_sc_hd__inv_1
X$11912 VDD synth_7348 VDD VNB|VSS synth_7511 VNB|VSS sky130_fd_sc_hd__inv_1
X$11913 VDD synth_9479 VDD VNB|VSS synth_9564 VNB|VSS sky130_fd_sc_hd__inv_1
X$11914 VDD synth_9426 VDD VNB|VSS synth_9424 VNB|VSS sky130_fd_sc_hd__inv_1
X$11915 VDD synth_8890 VDD VNB|VSS synth_8814 VNB|VSS sky130_fd_sc_hd__inv_1
X$11916 VDD synth_2956 VDD VNB|VSS synth_3086 VNB|VSS sky130_fd_sc_hd__inv_1
X$11917 VDD synth_3186 VDD VNB|VSS synth_3252 VNB|VSS sky130_fd_sc_hd__inv_1
X$11918 VDD synth_12629 VDD VNB|VSS synth_12662 VNB|VSS sky130_fd_sc_hd__inv_1
X$11919 VDD synth_12161 VDD VNB|VSS synth_12039 VNB|VSS sky130_fd_sc_hd__inv_1
X$11920 VNB|VSS synth_9595 synth_10025 VDD VDD VNB|VSS
+ sky130_fd_sc_hd__clkbuf_16
X$11921 VNB|VSS synth_701 synth_2208 VDD VDD VNB|VSS sky130_fd_sc_hd__clkbuf_16
X$11922 VNB|VSS synth_7145 synth_6890 VDD VDD VNB|VSS sky130_fd_sc_hd__clkbuf_16
X$11923 VNB|VSS synth_3336 synth_5753 VDD VDD VNB|VSS sky130_fd_sc_hd__clkbuf_16
X$11924 VNB|VSS synth_7460 synth_6897 VDD VDD VNB|VSS sky130_fd_sc_hd__clkbuf_16
X$11925 VNB|VSS synth_535 synth_5400 VDD VDD VNB|VSS sky130_fd_sc_hd__clkbuf_16
X$11926 VNB|VSS synth_7145 synth_9754 VDD VDD VNB|VSS sky130_fd_sc_hd__clkbuf_16
X$11927 VNB|VSS synth_7145 synth_10538 VDD VDD VNB|VSS
+ sky130_fd_sc_hd__clkbuf_16
X$11928 VNB|VSS synth_564 synth_2268 VDD VDD VNB|VSS sky130_fd_sc_hd__clkbuf_16
X$11929 VNB|VSS synth_3885 synth_4826 VDD VDD VNB|VSS sky130_fd_sc_hd__clkbuf_16
X$11930 VNB|VSS synth_7076 synth_8864 VDD VDD VNB|VSS sky130_fd_sc_hd__clkbuf_16
X$11931 VNB|VSS synth_3336 synth_3703 VDD VDD VNB|VSS sky130_fd_sc_hd__clkbuf_16
X$11932 VNB|VSS synth_9595 synth_9256 VDD VDD VNB|VSS sky130_fd_sc_hd__clkbuf_16
X$11933 VNB|VSS synth_7424 synth_6388 VDD VDD VNB|VSS sky130_fd_sc_hd__clkbuf_16
X$11934 VNB|VSS synth_3333 synth_3576 VDD VDD VNB|VSS sky130_fd_sc_hd__clkbuf_16
X$11935 VNB|VSS synth_564 synth_63 VDD VDD VNB|VSS sky130_fd_sc_hd__clkbuf_16
X$11936 VNB|VSS synth_38 synth_2205 VDD VDD VNB|VSS sky130_fd_sc_hd__clkbuf_16
X$11937 VNB|VSS synth_3336 synth_3043 VDD VDD VNB|VSS sky130_fd_sc_hd__clkbuf_16
X$11938 VNB|VSS synth_7076 synth_11849 VDD VDD VNB|VSS
+ sky130_fd_sc_hd__clkbuf_16
X$11939 VNB|VSS synth_7145 synth_11961 VDD VDD VNB|VSS
+ sky130_fd_sc_hd__clkbuf_16
X$11940 VNB|VSS synth_616 synth_2193 VDD VDD VNB|VSS sky130_fd_sc_hd__clkbuf_16
X$11941 VNB|VSS synth_5333 synth_5016 VDD VDD VNB|VSS sky130_fd_sc_hd__clkbuf_16
X$11942 VNB|VSS synth_6828 synth_12839 VDD VDD VNB|VSS
+ sky130_fd_sc_hd__clkbuf_16
X$11943 VNB|VSS synth_4935 synth_5166 VDD VDD VNB|VSS sky130_fd_sc_hd__clkbuf_16
X$11944 VNB|VSS synth_7460 synth_6801 VDD VDD VNB|VSS sky130_fd_sc_hd__clkbuf_16
X$11945 VNB|VSS synth_4935 synth_5082 VDD VDD VNB|VSS sky130_fd_sc_hd__clkbuf_16
X$11946 VNB|VSS synth_7076 synth_7190 VDD VDD VNB|VSS sky130_fd_sc_hd__clkbuf_16
X$11947 VNB|VSS synth_701 synth_1142 VDD VDD VNB|VSS sky130_fd_sc_hd__clkbuf_16
X$11948 VNB|VSS synth_7145 synth_6541 VDD VDD VNB|VSS sky130_fd_sc_hd__clkbuf_16
X$11949 VNB|VSS synth_2267 synth_21 VDD VDD VNB|VSS sky130_fd_sc_hd__clkbuf_16
X$11950 VNB|VSS synth_2267 synth_6981 VDD VDD VNB|VSS sky130_fd_sc_hd__clkbuf_16
X$11951 VNB|VSS synth_506 synth_470 VDD VDD VNB|VSS sky130_fd_sc_hd__clkbuf_16
X$11952 VNB|VSS synth_2267 synth_10180 VDD VDD VNB|VSS
+ sky130_fd_sc_hd__clkbuf_16
X$11953 VNB|VSS synth_3885 synth_3263 VDD VDD VNB|VSS sky130_fd_sc_hd__clkbuf_16
X$11954 VNB|VSS synth_7145 synth_9912 VDD VDD VNB|VSS sky130_fd_sc_hd__clkbuf_16
X$11955 VNB|VSS synth_3885 synth_5089 VDD VDD VNB|VSS sky130_fd_sc_hd__clkbuf_16
X$11956 VNB|VSS synth_7460 synth_7023 VDD VDD VNB|VSS sky130_fd_sc_hd__clkbuf_16
X$11957 VNB|VSS synth_7076 synth_7022 VDD VDD VNB|VSS sky130_fd_sc_hd__clkbuf_16
X$11958 VNB|VSS synth_616 synth_443 VDD VDD VNB|VSS sky130_fd_sc_hd__clkbuf_16
X$11959 VDD synth_346 synth_761 synth_760 synth_826 VNB|VSS synth_870 VDD
+ VNB|VSS sky130_fd_sc_hd__nor4_1
X$11960 VNB|VSS synth_871 synth_760 synth_761 synth_826 synth_827 synth_151 VDD
+ VDD VNB|VSS sky130_fd_sc_hd__o311a_1
X$11961 VNB|VSS synth_535 synth_12840 VDD VDD VNB|VSS sky130_fd_sc_hd__clkbuf_16
X$11962 VNB|VSS synth_7076 synth_12202 VDD VDD VNB|VSS
+ sky130_fd_sc_hd__clkbuf_16
X$11963 VNB|VSS synth_10180 synth_12311 VDD VDD VNB|VSS
+ sky130_fd_sc_hd__clkbuf_16
X$11964 VNB|VSS synth_2267 synth_3885 VDD VDD VNB|VSS sky130_fd_sc_hd__clkbuf_16
X$11965 VNB|VSS synth_7460 synth_7826 VDD VDD VNB|VSS sky130_fd_sc_hd__clkbuf_16
X$11966 VNB|VSS synth_7145 synth_12036 VDD VDD VNB|VSS
+ sky130_fd_sc_hd__clkbuf_16
X$11967 VNB|VSS synth_3333 synth_3122 VDD VDD VNB|VSS sky130_fd_sc_hd__clkbuf_16
X$11968 VNB|VSS synth_701 synth_578 VDD VDD VNB|VSS sky130_fd_sc_hd__clkbuf_16
X$11969 VNB|VSS synth_3885 synth_3318 VDD VDD VNB|VSS sky130_fd_sc_hd__clkbuf_16
X$11970 VNB|VSS synth_9595 synth_9702 VDD VDD VNB|VSS sky130_fd_sc_hd__clkbuf_16
X$11971 VNB|VSS synth_10180 synth_12315 VDD VDD VNB|VSS
+ sky130_fd_sc_hd__clkbuf_16
X$11972 VNB|VSS synth_9990 synth_11495 VDD VDD VNB|VSS
+ sky130_fd_sc_hd__clkbuf_16
X$11973 VNB|VSS synth_4935 synth_6459 VDD VDD VNB|VSS sky130_fd_sc_hd__clkbuf_16
X$11974 VNB|VSS synth_6730 synth_2267 VDD VDD VNB|VSS sky130_fd_sc_hd__clkbuf_16
X$11975 VNB|VSS synth_6449 synth_2541 VDD VDD VNB|VSS sky130_fd_sc_hd__clkbuf_16
X$11976 VNB|VSS synth_10049 synth_11719 VDD VDD VNB|VSS
+ sky130_fd_sc_hd__clkbuf_16
X$11977 VNB|VSS synth_9595 synth_10802 VDD VDD VNB|VSS
+ sky130_fd_sc_hd__clkbuf_16
X$11978 VNB|VSS synth_7145 synth_8928 VDD VDD VNB|VSS sky130_fd_sc_hd__clkbuf_16
X$11979 VNB|VSS synth_535 synth_4999 VDD VDD VNB|VSS sky130_fd_sc_hd__clkbuf_16
X$11980 VNB|VSS synth_616 synth_1265 VDD VDD VNB|VSS sky130_fd_sc_hd__clkbuf_16
X$11981 VNB|VSS synth_2541 synth_701 VDD VDD VNB|VSS sky130_fd_sc_hd__clkbuf_16
X$11982 VNB|VSS synth_7145 synth_8228 VDD VDD VNB|VSS sky130_fd_sc_hd__clkbuf_16
X$11983 VNB|VSS synth_535 synth_2320 VDD VDD VNB|VSS sky130_fd_sc_hd__clkbuf_16
X$11984 VNB|VSS synth_3885 synth_3543 VDD VDD VNB|VSS sky130_fd_sc_hd__clkbuf_16
X$11985 VNB|VSS synth_2267 synth_3336 VDD VDD VNB|VSS sky130_fd_sc_hd__clkbuf_16
X$11986 VNB|VSS synth_4090 synth_6347 VDD VDD VNB|VSS sky130_fd_sc_hd__clkbuf_16
X$11987 VNB|VSS synth_506 synth_89 VDD VDD VNB|VSS sky130_fd_sc_hd__clkbuf_16
X$11988 VNB|VSS synth_506 synth_19 VDD VDD VNB|VSS sky130_fd_sc_hd__clkbuf_16
X$11989 VNB|VSS synth_7460 synth_9045 VDD VDD VNB|VSS sky130_fd_sc_hd__clkbuf_16
X$11990 VNB|VSS synth_564 synth_2533 VDD VDD VNB|VSS sky130_fd_sc_hd__clkbuf_16
X$11991 VNB|VSS synth_616 synth_3557 VDD VDD VNB|VSS sky130_fd_sc_hd__clkbuf_16
X$11992 VNB|VSS synth_2541 synth_7076 VDD VDD VNB|VSS sky130_fd_sc_hd__clkbuf_16
X$11993 VNB|VSS synth_6981 synth_6929 VDD VDD VNB|VSS sky130_fd_sc_hd__clkbuf_16
X$11994 VNB|VSS synth_3333 synth_12841 VDD VDD VNB|VSS
+ sky130_fd_sc_hd__clkbuf_16
X$11995 VNB|VSS synth_2267 synth_10049 VDD VDD VNB|VSS
+ sky130_fd_sc_hd__clkbuf_16
X$11996 VNB|VSS synth_6981 synth_6927 VDD VDD VNB|VSS sky130_fd_sc_hd__clkbuf_16
X$11997 VNB|VSS synth_4935 synth_7335 VDD VDD VNB|VSS sky130_fd_sc_hd__clkbuf_16
X$11998 VNB|VSS synth_9990 synth_11527 VDD VDD VNB|VSS
+ sky130_fd_sc_hd__clkbuf_16
X$11999 VNB|VSS synth_665 synth_5217 VDD VDD VNB|VSS sky130_fd_sc_hd__clkbuf_16
X$12000 VNB|VSS synth_6970 synth_6454 VDD VDD VNB|VSS sky130_fd_sc_hd__clkbuf_16
X$12001 VNB|VSS synth_2267 synth_3333 VDD VDD VNB|VSS sky130_fd_sc_hd__clkbuf_16
X$12002 VNB|VSS synth_6970 synth_7334 VDD VDD VNB|VSS sky130_fd_sc_hd__clkbuf_16
X$12003 VNB|VSS synth_506 synth_1149 VDD VDD VNB|VSS sky130_fd_sc_hd__clkbuf_16
X$12004 VNB|VSS synth_5333 synth_7933 VDD VDD VNB|VSS sky130_fd_sc_hd__clkbuf_16
X$12005 VNB|VSS synth_9990 synth_11917 VDD VDD VNB|VSS
+ sky130_fd_sc_hd__clkbuf_16
X$12006 VNB|VSS synth_10049 synth_11851 VDD VDD VNB|VSS
+ sky130_fd_sc_hd__clkbuf_16
X$12007 VNB|VSS synth_9990 synth_11489 VDD VDD VNB|VSS
+ sky130_fd_sc_hd__clkbuf_16
X$12008 VNB|VSS synth_2541 synth_7145 VDD VDD VNB|VSS sky130_fd_sc_hd__clkbuf_16
X$12009 VNB|VSS synth_535 synth_1576 VDD VDD VNB|VSS sky130_fd_sc_hd__clkbuf_16
X$12010 VNB|VSS synth_506 synth_2330 VDD VDD VNB|VSS sky130_fd_sc_hd__clkbuf_16
X$12011 VNB|VSS synth_21 synth_571 VDD VDD VNB|VSS sky130_fd_sc_hd__clkbuf_16
X$12012 VNB|VSS synth_616 synth_3284 VDD VDD VNB|VSS sky130_fd_sc_hd__clkbuf_16
X$12013 VNB|VSS synth_6970 synth_8778 VDD VDD VNB|VSS sky130_fd_sc_hd__clkbuf_16
X$12014 VNB|VSS synth_8765 synth_9160 synth_8873 VDD VDD VNB|VSS
+ sky130_fd_sc_hd__nor2_4
X$12015 VNB|VSS synth_2541 synth_4935 VDD VDD VNB|VSS sky130_fd_sc_hd__clkbuf_16
X$12016 VNB|VSS synth_701 synth_517 VDD VDD VNB|VSS sky130_fd_sc_hd__clkbuf_16
X$12017 VNB|VSS synth_3885 synth_6059 VDD VDD VNB|VSS sky130_fd_sc_hd__clkbuf_16
X$12018 VNB|VSS synth_25 synth_12842 VDD VDD VNB|VSS sky130_fd_sc_hd__clkbuf_16
X$12019 VNB|VSS synth_5333 synth_4657 VDD VDD VNB|VSS sky130_fd_sc_hd__clkbuf_16
X$12020 VNB|VSS synth_10180 synth_11939 VDD VDD VNB|VSS
+ sky130_fd_sc_hd__clkbuf_16
X$12021 VNB|VSS synth_3333 synth_3478 VDD VDD VNB|VSS sky130_fd_sc_hd__clkbuf_16
X$12022 VNB|VSS synth_6970 synth_8082 VDD VDD VNB|VSS sky130_fd_sc_hd__clkbuf_16
X$12023 VNB|VSS synth_535 synth_3950 VDD VDD VNB|VSS sky130_fd_sc_hd__clkbuf_16
X$12024 VNB|VSS synth_7460 synth_6961 VDD VDD VNB|VSS sky130_fd_sc_hd__clkbuf_16
X$12025 VNB|VSS synth_665 synth_54 VDD VDD VNB|VSS sky130_fd_sc_hd__clkbuf_16
X$12026 VNB|VSS synth_7460 synth_8315 VDD VDD VNB|VSS sky130_fd_sc_hd__clkbuf_16
X$12027 VNB|VSS synth_3333 synth_4487 VDD VDD VNB|VSS sky130_fd_sc_hd__clkbuf_16
X$12028 VNB|VSS synth_7747 synth_7748 VDD VDD VNB|VSS sky130_fd_sc_hd__clkbuf_16
X$12029 VNB|VSS synth_7066 synth_8488 VDD VDD VNB|VSS sky130_fd_sc_hd__clkbuf_16
X$12030 VNB|VSS synth_2267 synth_7066 VDD VDD VNB|VSS sky130_fd_sc_hd__clkbuf_16
X$12031 VNB|VSS synth_2267 synth_9595 VDD VDD VNB|VSS sky130_fd_sc_hd__clkbuf_16
X$12032 VNB|VSS synth_506 synth_2179 VDD VDD VNB|VSS sky130_fd_sc_hd__clkbuf_16
X$12033 VNB|VSS synth_3885 synth_5658 VDD VDD VNB|VSS sky130_fd_sc_hd__clkbuf_16
X$12034 VNB|VSS synth_2730 synth_12843 VDD VDD VNB|VSS
+ sky130_fd_sc_hd__clkbuf_16
X$12035 VNB|VSS synth_10049 synth_10910 VDD VDD VNB|VSS
+ sky130_fd_sc_hd__clkbuf_16
X$12036 VNB|VSS synth_535 synth_1011 VDD VDD VNB|VSS sky130_fd_sc_hd__clkbuf_16
X$12037 VNB|VSS synth_7145 synth_11840 VDD VDD VNB|VSS
+ sky130_fd_sc_hd__clkbuf_16
X$12038 VNB|VSS synth_4090 synth_5303 VDD VDD VNB|VSS sky130_fd_sc_hd__clkbuf_16
X$12039 VNB|VSS synth_616 synth_3806 VDD VDD VNB|VSS sky130_fd_sc_hd__clkbuf_16
X$12040 VNB|VSS synth_616 synth_2800 VDD VDD VNB|VSS sky130_fd_sc_hd__clkbuf_16
X$12041 VNB|VSS synth_701 synth_3794 VDD VDD VNB|VSS sky130_fd_sc_hd__clkbuf_16
X$12042 VNB|VSS synth_6970 synth_8553 VDD VDD VNB|VSS sky130_fd_sc_hd__clkbuf_16
X$12043 VNB|VSS synth_10180 synth_10808 VDD VDD VNB|VSS
+ sky130_fd_sc_hd__clkbuf_16
X$12044 VNB|VSS synth_701 synth_2145 VDD VDD VNB|VSS sky130_fd_sc_hd__clkbuf_16
X$12045 VNB|VSS synth_6981 synth_8650 VDD VDD VNB|VSS sky130_fd_sc_hd__clkbuf_16
X$12046 VNB|VSS synth_7066 synth_7144 VDD VDD VNB|VSS sky130_fd_sc_hd__clkbuf_16
X$12047 VNB|VSS synth_665 synth_3335 VDD VDD VNB|VSS sky130_fd_sc_hd__clkbuf_16
X$12048 VNB|VSS synth_3333 synth_3413 VDD VDD VNB|VSS sky130_fd_sc_hd__clkbuf_16
X$12049 VNB|VSS synth_616 synth_1437 VDD VDD VNB|VSS sky130_fd_sc_hd__clkbuf_16
X$12050 VNB|VSS synth_38 synth_1810 VDD VDD VNB|VSS sky130_fd_sc_hd__clkbuf_16
X$12051 VNB|VSS synth_6981 synth_7809 VDD VDD VNB|VSS sky130_fd_sc_hd__clkbuf_16
X$12052 VNB|VSS synth_665 synth_4264 VDD VDD VNB|VSS sky130_fd_sc_hd__clkbuf_16
X$12053 VNB|VSS synth_10049 synth_10616 VDD VDD VNB|VSS
+ sky130_fd_sc_hd__clkbuf_16
X$12054 VNB|VSS synth_9595 synth_11470 VDD VDD VNB|VSS
+ sky130_fd_sc_hd__clkbuf_16
X$12055 VNB|VSS synth_10180 synth_11549 VDD VDD VNB|VSS
+ sky130_fd_sc_hd__clkbuf_16
X$12056 VNB|VSS synth_10049 synth_10081 VDD VDD VNB|VSS
+ sky130_fd_sc_hd__clkbuf_16
X$12057 VNB|VSS synth_4090 synth_3374 VDD VDD VNB|VSS sky130_fd_sc_hd__clkbuf_16
X$12058 VNB|VSS synth_4090 synth_3820 VDD VDD VNB|VSS sky130_fd_sc_hd__clkbuf_16
X$12059 VNB|VSS synth_3333 synth_5715 VDD VDD VNB|VSS sky130_fd_sc_hd__clkbuf_16
X$12060 VNB|VSS synth_616 synth_282 VDD VDD VNB|VSS sky130_fd_sc_hd__clkbuf_16
X$12061 VNB|VSS synth_38 synth_756 VDD VDD VNB|VSS sky130_fd_sc_hd__clkbuf_16
X$12062 VNB|VSS synth_7066 synth_7814 VDD VDD VNB|VSS sky130_fd_sc_hd__clkbuf_16
X$12063 VNB|VSS synth_7066 synth_7645 VDD VDD VNB|VSS sky130_fd_sc_hd__clkbuf_16
X$12064 VNB|VSS synth_9595 synth_10806 VDD VDD VNB|VSS
+ sky130_fd_sc_hd__clkbuf_16
X$12065 VNB|VSS synth_6981 synth_8413 VDD VDD VNB|VSS sky130_fd_sc_hd__clkbuf_16
X$12066 VNB|VSS synth_7144 synth_12844 VDD VDD VNB|VSS
+ sky130_fd_sc_hd__clkbuf_16
X$12067 VNB|VSS synth_7076 synth_11379 VDD VDD VNB|VSS
+ sky130_fd_sc_hd__clkbuf_16
X$12068 VNB|VSS synth_7145 synth_7644 VDD VDD VNB|VSS sky130_fd_sc_hd__clkbuf_16
X$12069 VNB|VSS synth_4090 synth_4575 VDD VDD VNB|VSS sky130_fd_sc_hd__clkbuf_16
X$12070 VNB|VSS synth_21 synth_640 VDD VDD VNB|VSS sky130_fd_sc_hd__clkbuf_16
X$12071 VNB|VSS synth_535 synth_2077 VDD VDD VNB|VSS sky130_fd_sc_hd__clkbuf_16
X$12072 VNB|VSS synth_6981 synth_6828 VDD VDD VNB|VSS sky130_fd_sc_hd__clkbuf_16
X$12073 VNB|VSS synth_506 synth_1872 VDD VDD VNB|VSS sky130_fd_sc_hd__clkbuf_16
X$12074 VNB|VSS synth_10180 synth_11117 VDD VDD VNB|VSS
+ sky130_fd_sc_hd__clkbuf_16
X$12075 VNB|VSS synth_2541 synth_665 VDD VDD VNB|VSS sky130_fd_sc_hd__clkbuf_16
X$12076 VNB|VSS synth_7076 synth_11536 VDD VDD VNB|VSS
+ sky130_fd_sc_hd__clkbuf_16
X$12077 VNB|VSS synth_3333 synth_5515 VDD VDD VNB|VSS sky130_fd_sc_hd__clkbuf_16
X$12078 VNB|VSS synth_535 synth_699 VDD VDD VNB|VSS sky130_fd_sc_hd__clkbuf_16
X$12079 VNB|VSS synth_506 synth_1795 VDD VDD VNB|VSS sky130_fd_sc_hd__clkbuf_16
X$12080 VNB|VSS synth_2267 synth_506 VDD VDD VNB|VSS sky130_fd_sc_hd__clkbuf_16
X$12081 VNB|VSS synth_7145 synth_9717 VDD VDD VNB|VSS sky130_fd_sc_hd__clkbuf_16
X$12082 VNB|VSS synth_2267 synth_564 VDD VDD VNB|VSS sky130_fd_sc_hd__clkbuf_16
X$12083 VNB|VSS synth_7145 synth_10467 VDD VDD VNB|VSS
+ sky130_fd_sc_hd__clkbuf_16
X$12084 VNB|VSS synth_564 synth_1345 VDD VDD VNB|VSS sky130_fd_sc_hd__clkbuf_16
X$12085 VNB|VSS synth_3333 synth_3569 VDD VDD VNB|VSS sky130_fd_sc_hd__clkbuf_16
X$12086 VNB|VSS synth_506 synth_30 VDD VDD VNB|VSS sky130_fd_sc_hd__clkbuf_16
X$12087 VNB|VSS synth_535 synth_6531 VDD VDD VNB|VSS sky130_fd_sc_hd__clkbuf_16
X$12088 VNB|VSS synth_1970 synth_12845 VDD VDD VNB|VSS
+ sky130_fd_sc_hd__clkbuf_16
X$12089 VNB|VSS synth_7076 synth_10549 VDD VDD VNB|VSS
+ sky130_fd_sc_hd__clkbuf_16
X$12090 VNB|VSS synth_38 synth_2730 VDD VDD VNB|VSS sky130_fd_sc_hd__clkbuf_16
X$12091 VNB|VSS synth_9990 synth_10804 VDD VDD VNB|VSS
+ sky130_fd_sc_hd__clkbuf_16
X$12092 VNB|VSS synth_7748 synth_7424 VDD VDD VNB|VSS sky130_fd_sc_hd__clkbuf_16
X$12093 VNB|VSS synth_9595 synth_10021 VDD VDD VNB|VSS
+ sky130_fd_sc_hd__clkbuf_16
X$12094 VNB|VSS synth_11719 synth_12846 VDD VDD VNB|VSS
+ sky130_fd_sc_hd__clkbuf_16
X$12095 VNB|VSS synth_616 synth_439 VDD VDD VNB|VSS sky130_fd_sc_hd__clkbuf_16
X$12096 VNB|VSS synth_616 synth_2845 VDD VDD VNB|VSS sky130_fd_sc_hd__clkbuf_16
X$12097 VNB|VSS synth_665 synth_6069 VDD VDD VNB|VSS sky130_fd_sc_hd__clkbuf_16
X$12098 VNB|VSS synth_3336 synth_5478 VDD VDD VNB|VSS sky130_fd_sc_hd__clkbuf_16
X$12099 VNB|VSS synth_21 synth_1453 VDD VDD VNB|VSS sky130_fd_sc_hd__clkbuf_16
X$12100 VNB|VSS synth_21 synth_1898 VDD VDD VNB|VSS sky130_fd_sc_hd__clkbuf_16
X$12101 VNB|VSS synth_21 synth_2602 VDD VDD VNB|VSS sky130_fd_sc_hd__clkbuf_16
X$12102 VNB|VSS synth_564 synth_270 VDD VDD VNB|VSS sky130_fd_sc_hd__clkbuf_16
X$12103 VNB|VSS synth_9990 synth_10628 VDD VDD VNB|VSS
+ sky130_fd_sc_hd__clkbuf_16
X$12104 VNB|VSS synth_3885 synth_4461 VDD VDD VNB|VSS sky130_fd_sc_hd__clkbuf_16
X$12105 VNB|VSS synth_9990 synth_9986 VDD VDD VNB|VSS sky130_fd_sc_hd__clkbuf_16
X$12106 VNB|VSS synth_7066 synth_9402 VDD VDD VNB|VSS sky130_fd_sc_hd__clkbuf_16
X$12107 VNB|VSS synth_7076 synth_7534 VDD VDD VNB|VSS sky130_fd_sc_hd__clkbuf_16
X$12108 VNB|VSS synth_4935 synth_4541 VDD VDD VNB|VSS sky130_fd_sc_hd__clkbuf_16
X$12109 VNB|VSS synth_3703 synth_12847 VDD VDD VNB|VSS
+ sky130_fd_sc_hd__clkbuf_16
X$12110 VNB|VSS synth_21 synth_1906 VDD VDD VNB|VSS sky130_fd_sc_hd__clkbuf_16
X$12111 VNB|VSS synth_616 synth_276 VDD VDD VNB|VSS sky130_fd_sc_hd__clkbuf_16
X$12112 VNB|VSS synth_7460 synth_8863 VDD VDD VNB|VSS sky130_fd_sc_hd__clkbuf_16
X$12113 VNB|VSS synth_38 synth_1518 VDD VDD VNB|VSS sky130_fd_sc_hd__clkbuf_16
X$12114 VNB|VSS synth_665 synth_1136 VDD VDD VNB|VSS sky130_fd_sc_hd__clkbuf_16
X$12115 VNB|VSS synth_3336 synth_3397 VDD VDD VNB|VSS sky130_fd_sc_hd__clkbuf_16
X$12116 VNB|VSS synth_5333 synth_5249 VDD VDD VNB|VSS sky130_fd_sc_hd__clkbuf_16
X$12117 VNB|VSS synth_9990 synth_11846 VDD VDD VNB|VSS
+ sky130_fd_sc_hd__clkbuf_16
X$12118 VNB|VSS synth_4090 synth_5227 VDD VDD VNB|VSS sky130_fd_sc_hd__clkbuf_16
X$12119 VNB|VSS synth_665 synth_5008 VDD VDD VNB|VSS sky130_fd_sc_hd__clkbuf_16
X$12120 VNB|VSS synth_4090 synth_3462 VDD VDD VNB|VSS sky130_fd_sc_hd__clkbuf_16
X$12121 VNB|VSS synth_6981 synth_8595 VDD VDD VNB|VSS sky130_fd_sc_hd__clkbuf_16
X$12122 VNB|VSS synth_4935 synth_5439 VDD VDD VNB|VSS sky130_fd_sc_hd__clkbuf_16
X$12123 VNB|VSS synth_7424 synth_7588 VDD VDD VNB|VSS sky130_fd_sc_hd__clkbuf_16
X$12124 VNB|VSS synth_3333 synth_5087 VDD VDD VNB|VSS sky130_fd_sc_hd__clkbuf_16
X$12125 VNB|VSS synth_10049 synth_10090 VDD VDD VNB|VSS
+ sky130_fd_sc_hd__clkbuf_16
X$12126 VNB|VSS synth_506 synth_1833 VDD VDD VNB|VSS sky130_fd_sc_hd__clkbuf_16
X$12127 VNB|VSS synth_6970 synth_6939 VDD VDD VNB|VSS sky130_fd_sc_hd__clkbuf_16
X$12128 VNB|VSS synth_3336 synth_4505 VDD VDD VNB|VSS sky130_fd_sc_hd__clkbuf_16
X$12129 VNB|VSS synth_3333 synth_4293 VDD VDD VNB|VSS sky130_fd_sc_hd__clkbuf_16
X$12130 VNB|VSS synth_7145 synth_11294 VDD VDD VNB|VSS
+ sky130_fd_sc_hd__clkbuf_16
X$12131 VNB|VSS synth_5333 synth_4836 VDD VDD VNB|VSS sky130_fd_sc_hd__clkbuf_16
X$12132 VNB|VSS synth_616 synth_3169 VDD VDD VNB|VSS sky130_fd_sc_hd__clkbuf_16
X$12133 VNB|VSS synth_4935 synth_3937 VDD VDD VNB|VSS sky130_fd_sc_hd__clkbuf_16
X$12134 VNB|VSS synth_665 synth_557 VDD VDD VNB|VSS sky130_fd_sc_hd__clkbuf_16
X$12135 VNB|VSS synth_665 synth_4651 VDD VDD VNB|VSS sky130_fd_sc_hd__clkbuf_16
X$12136 VNB|VSS synth_535 synth_3221 VDD VDD VNB|VSS sky130_fd_sc_hd__clkbuf_16
X$12137 VNB|VSS synth_7460 synth_9291 VDD VDD VNB|VSS sky130_fd_sc_hd__clkbuf_16
X$12138 VNB|VSS synth_9595 synth_10106 VDD VDD VNB|VSS
+ sky130_fd_sc_hd__clkbuf_16
X$12139 VNB|VSS synth_21 synth_2080 VDD VDD VNB|VSS sky130_fd_sc_hd__clkbuf_16
X$12140 VNB|VSS synth_3336 synth_3385 VDD VDD VNB|VSS sky130_fd_sc_hd__clkbuf_16
X$12141 VNB|VSS synth_535 synth_2468 VDD VDD VNB|VSS sky130_fd_sc_hd__clkbuf_16
X$12142 VNB|VSS synth_9990 synth_12848 VDD VDD VNB|VSS
+ sky130_fd_sc_hd__clkbuf_16
X$12143 VNB|VSS synth_665 synth_48 VDD VDD VNB|VSS sky130_fd_sc_hd__clkbuf_16
X$12144 VNB|VSS synth_7066 synth_6733 VDD VDD VNB|VSS sky130_fd_sc_hd__clkbuf_16
X$12145 VNB|VSS synth_2267 synth_7460 VDD VDD VNB|VSS sky130_fd_sc_hd__clkbuf_16
X$12146 VNB|VSS synth_3885 synth_3818 VDD VDD VNB|VSS sky130_fd_sc_hd__clkbuf_16
X$12147 VNB|VSS synth_12299 synth_12849 VDD VDD VNB|VSS
+ sky130_fd_sc_hd__clkbuf_16
X$12148 VNB|VSS synth_616 synth_1280 VDD VDD VNB|VSS sky130_fd_sc_hd__clkbuf_16
X$12149 VNB|VSS synth_6981 synth_8479 VDD VDD VNB|VSS sky130_fd_sc_hd__clkbuf_16
X$12150 VNB|VSS synth_7066 synth_9270 VDD VDD VNB|VSS sky130_fd_sc_hd__clkbuf_16
X$12151 VNB|VSS synth_21 synth_521 VDD VDD VNB|VSS sky130_fd_sc_hd__clkbuf_16
X$12152 VNB|VSS synth_3336 synth_5159 VDD VDD VNB|VSS sky130_fd_sc_hd__clkbuf_16
X$12153 VNB|VSS synth_564 synth_61 VDD VDD VNB|VSS sky130_fd_sc_hd__clkbuf_16
X$12154 VNB|VSS synth_10180 synth_11626 VDD VDD VNB|VSS
+ sky130_fd_sc_hd__clkbuf_16
X$12155 VNB|VSS synth_7145 synth_8659 VDD VDD VNB|VSS sky130_fd_sc_hd__clkbuf_16
X$12156 VNB|VSS synth_5333 synth_6583 VDD VDD VNB|VSS sky130_fd_sc_hd__clkbuf_16
X$12157 VNB|VSS synth_7145 synth_7637 VDD VDD VNB|VSS sky130_fd_sc_hd__clkbuf_16
X$12158 VNB|VSS synth_6970 synth_8391 VDD VDD VNB|VSS sky130_fd_sc_hd__clkbuf_16
X$12159 VNB|VSS synth_3333 synth_5447 VDD VDD VNB|VSS sky130_fd_sc_hd__clkbuf_16
X$12160 VNB|VSS synth_38 synth_1970 VDD VDD VNB|VSS sky130_fd_sc_hd__clkbuf_16
X$12161 VNB|VSS synth_2267 synth_38 VDD VDD VNB|VSS sky130_fd_sc_hd__clkbuf_16
X$12162 VNB|VSS synth_3885 synth_5450 VDD VDD VNB|VSS sky130_fd_sc_hd__clkbuf_16
X$12163 VNB|VSS synth_7814 synth_12850 VDD VDD VNB|VSS
+ sky130_fd_sc_hd__clkbuf_16
X$12164 VNB|VSS synth_4935 synth_6611 VDD VDD VNB|VSS sky130_fd_sc_hd__clkbuf_16
X$12165 VNB|VSS synth_564 synth_51 VDD VDD VNB|VSS sky130_fd_sc_hd__clkbuf_16
X$12166 VNB|VSS synth_2267 synth_4090 VDD VDD VNB|VSS sky130_fd_sc_hd__clkbuf_16
X$12167 VNB|VSS synth_10049 synth_12024 VDD VDD VNB|VSS
+ sky130_fd_sc_hd__clkbuf_16
X$12168 VNB|VSS synth_7076 synth_6794 VDD VDD VNB|VSS sky130_fd_sc_hd__clkbuf_16
X$12169 VNB|VSS synth_616 synth_2044 VDD VDD VNB|VSS sky130_fd_sc_hd__clkbuf_16
X$12170 VNB|VSS synth_2267 synth_6970 VDD VDD VNB|VSS sky130_fd_sc_hd__clkbuf_16
X$12171 VNB|VSS synth_9990 synth_10226 VDD VDD VNB|VSS
+ sky130_fd_sc_hd__clkbuf_16
X$12172 VNB|VSS synth_5333 synth_7576 VDD VDD VNB|VSS sky130_fd_sc_hd__clkbuf_16
X$12173 VNB|VSS synth_535 synth_235 VDD VDD VNB|VSS sky130_fd_sc_hd__clkbuf_16
X$12174 VNB|VSS synth_7066 synth_8380 VDD VDD VNB|VSS sky130_fd_sc_hd__clkbuf_16
X$12175 VNB|VSS synth_4935 synth_4600 VDD VDD VNB|VSS sky130_fd_sc_hd__clkbuf_16
X$12176 VNB|VSS synth_564 synth_1727 VDD VDD VNB|VSS sky130_fd_sc_hd__clkbuf_16
X$12177 VNB|VSS synth_7066 synth_8533 VDD VDD VNB|VSS sky130_fd_sc_hd__clkbuf_16
X$12178 VNB|VSS synth_6970 synth_6950 VDD VDD VNB|VSS sky130_fd_sc_hd__clkbuf_16
X$12179 VNB|VSS synth_7076 synth_10047 VDD VDD VNB|VSS
+ sky130_fd_sc_hd__clkbuf_16
X$12180 VNB|VSS synth_21 synth_450 VDD VDD VNB|VSS sky130_fd_sc_hd__clkbuf_16
X$12181 VNB|VSS synth_9990 synth_12163 VDD VDD VNB|VSS
+ sky130_fd_sc_hd__clkbuf_16
X$12182 VNB|VSS synth_21 synth_25 VDD VDD VNB|VSS sky130_fd_sc_hd__clkbuf_16
X$12183 VNB|VSS synth_2267 synth_9990 VDD VDD VNB|VSS sky130_fd_sc_hd__clkbuf_16
X$12184 VNB|VSS synth_5333 synth_6241 VDD VDD VNB|VSS sky130_fd_sc_hd__clkbuf_16
X$12185 VNB|VSS synth_535 synth_53 VDD VDD VNB|VSS sky130_fd_sc_hd__clkbuf_16
X$12186 VNB|VSS synth_564 synth_2339 VDD VDD VNB|VSS sky130_fd_sc_hd__clkbuf_16
X$12187 VNB|VSS synth_7460 synth_8367 VDD VDD VNB|VSS sky130_fd_sc_hd__clkbuf_16
X$12188 VNB|VSS synth_701 synth_3242 VDD VDD VNB|VSS sky130_fd_sc_hd__clkbuf_16
X$12189 VNB|VSS synth_4090 synth_4019 VDD VDD VNB|VSS sky130_fd_sc_hd__clkbuf_16
X$12190 VNB|VSS synth_21 synth_33 VDD VDD VNB|VSS sky130_fd_sc_hd__clkbuf_16
X$12191 VDD synth_22 synth_29 synth_28 VDD synth_11 VNB|VSS VNB|VSS
+ sky130_fd_sc_hd__o21ai_0
X$12192 VNB|VSS synth_6550 synth_6375 VDD VDD VNB|VSS sky130_fd_sc_hd__clkbuf_16
X$12193 VNB|VSS synth_5333 synth_7490 VDD VDD VNB|VSS sky130_fd_sc_hd__clkbuf_16
X$12194 VNB|VSS synth_535 synth_4299 VDD VDD VNB|VSS sky130_fd_sc_hd__clkbuf_16
X$12195 VNB|VSS synth_6970 synth_7115 VDD VDD VNB|VSS sky130_fd_sc_hd__clkbuf_16
X$12196 VNB|VSS synth_7076 synth_8165 VDD VDD VNB|VSS sky130_fd_sc_hd__clkbuf_16
X$12197 VNB|VSS synth_4935 synth_6824 VDD VDD VNB|VSS sky130_fd_sc_hd__clkbuf_16
X$12198 VNB|VSS synth_3336 synth_4934 VDD VDD VNB|VSS sky130_fd_sc_hd__clkbuf_16
X$12199 VNB|VSS synth_506 synth_2465 VDD VDD VNB|VSS sky130_fd_sc_hd__clkbuf_16
X$12200 VNB|VSS synth_3336 synth_4422 VDD VDD VNB|VSS sky130_fd_sc_hd__clkbuf_16
X$12201 VNB|VSS synth_6981 synth_7868 VDD VDD VNB|VSS sky130_fd_sc_hd__clkbuf_16
X$12202 VNB|VSS synth_506 synth_1423 VDD VDD VNB|VSS sky130_fd_sc_hd__clkbuf_16
X$12203 VNB|VSS synth_7076 synth_9102 VDD VDD VNB|VSS sky130_fd_sc_hd__clkbuf_16
X$12204 VNB|VSS synth_38 synth_568 VDD VDD VNB|VSS sky130_fd_sc_hd__clkbuf_16
X$12205 VNB|VSS synth_535 synth_5531 VDD VDD VNB|VSS sky130_fd_sc_hd__clkbuf_16
X$12206 VNB|VSS synth_3885 synth_5057 VDD VDD VNB|VSS sky130_fd_sc_hd__clkbuf_16
X$12207 VNB|VSS synth_564 synth_1432 VDD VDD VNB|VSS sky130_fd_sc_hd__clkbuf_16
X$12208 VNB|VSS synth_701 synth_2432 VDD VDD VNB|VSS sky130_fd_sc_hd__clkbuf_16
X$12209 VNB|VSS synth_10180 synth_10269 VDD VDD VNB|VSS
+ sky130_fd_sc_hd__clkbuf_16
X$12210 VNB|VSS synth_4090 synth_4833 VDD VDD VNB|VSS sky130_fd_sc_hd__clkbuf_16
X$12211 VNB|VSS synth_7424 synth_7213 VDD VDD VNB|VSS sky130_fd_sc_hd__clkbuf_16
X$12212 VNB|VSS synth_7602 synth_7512 synth_6759 synth_7134 VDD VDD VNB|VSS
+ sky130_fd_sc_hd__mux2_2
X$12213 VNB|VSS synth_701 synth_3247 VDD VDD VNB|VSS sky130_fd_sc_hd__clkbuf_16
X$12214 VNB|VSS synth_564 synth_1717 VDD VDD VNB|VSS sky130_fd_sc_hd__clkbuf_16
X$12215 VNB|VSS synth_701 synth_1657 VDD VDD VNB|VSS sky130_fd_sc_hd__clkbuf_16
X$12216 VNB|VSS synth_6970 synth_6815 VDD VDD VNB|VSS sky130_fd_sc_hd__clkbuf_16
X$12217 VNB|VSS synth_701 synth_840 VDD VDD VNB|VSS sky130_fd_sc_hd__clkbuf_16
X$12218 VNB|VSS synth_10049 synth_9760 VDD VDD VNB|VSS
+ sky130_fd_sc_hd__clkbuf_16
X$12219 VNB|VSS synth_5333 synth_6237 VDD VDD VNB|VSS sky130_fd_sc_hd__clkbuf_16
X$12220 VNB|VSS synth_10049 synth_12299 VDD VDD VNB|VSS
+ sky130_fd_sc_hd__clkbuf_16
X$12221 VNB|VSS synth_616 synth_484 VDD VDD VNB|VSS sky130_fd_sc_hd__clkbuf_16
X$12222 VNB|VSS synth_3333 synth_5172 VDD VDD VNB|VSS sky130_fd_sc_hd__clkbuf_16
X$12223 VNB|VSS synth_38 synth_1276 VDD VDD VNB|VSS sky130_fd_sc_hd__clkbuf_16
X$12224 VNB|VSS synth_4090 synth_5327 VDD VDD VNB|VSS sky130_fd_sc_hd__clkbuf_16
X$12225 VNB|VSS synth_616 synth_2201 VDD VDD VNB|VSS sky130_fd_sc_hd__clkbuf_16
X$12226 VNB|VSS synth_9990 synth_9811 VDD VDD VNB|VSS sky130_fd_sc_hd__clkbuf_16
X$12227 VNB|VSS synth_6452 synth_6550 VDD VDD VNB|VSS sky130_fd_sc_hd__clkbuf_16
X$12228 VNB|VSS synth_9595 synth_9370 VDD VDD VNB|VSS sky130_fd_sc_hd__clkbuf_16
X$12229 VNB|VSS synth_7076 synth_9896 VDD VDD VNB|VSS sky130_fd_sc_hd__clkbuf_16
X$12230 VNB|VSS synth_7424 synth_7808 VDD VDD VNB|VSS sky130_fd_sc_hd__clkbuf_16
X$12231 VNB|VSS synth_9595 synth_9127 VDD VDD VNB|VSS sky130_fd_sc_hd__clkbuf_16
X$12232 VNB|VSS synth_4090 synth_5953 VDD VDD VNB|VSS sky130_fd_sc_hd__clkbuf_16
X$12233 VNB|VSS synth_2541 synth_535 VDD VDD VNB|VSS sky130_fd_sc_hd__clkbuf_16
X$12234 VNB|VSS synth_665 synth_3025 VDD VDD VNB|VSS sky130_fd_sc_hd__clkbuf_16
X$12235 VNB|VSS synth_9990 synth_10030 VDD VDD VNB|VSS
+ sky130_fd_sc_hd__clkbuf_16
X$12236 VNB|VSS synth_7076 synth_10355 VDD VDD VNB|VSS
+ sky130_fd_sc_hd__clkbuf_16
X$12237 VNB|VSS synth_2541 synth_5333 VDD VDD VNB|VSS sky130_fd_sc_hd__clkbuf_16
X$12238 VNB|VSS synth_665 synth_5407 VDD VDD VNB|VSS sky130_fd_sc_hd__clkbuf_16
X$12239 VNB|VSS synth_7066 synth_6853 VDD VDD VNB|VSS sky130_fd_sc_hd__clkbuf_16
X$12240 VNB|VSS synth_701 synth_2804 VDD VDD VNB|VSS sky130_fd_sc_hd__clkbuf_16
X$12241 VNB|VSS synth_701 synth_446 VDD VDD VNB|VSS sky130_fd_sc_hd__clkbuf_16
X$12242 VNB|VSS synth_7145 synth_12851 VDD VDD VNB|VSS
+ sky130_fd_sc_hd__clkbuf_16
X$12243 VNB|VSS synth_535 synth_3781 VDD VDD VNB|VSS sky130_fd_sc_hd__clkbuf_16
X$12244 VNB|VSS synth_2541 synth_616 VDD VDD VNB|VSS sky130_fd_sc_hd__clkbuf_16
X$12245 VNB|VSS synth_6981 synth_8103 VDD VDD VNB|VSS sky130_fd_sc_hd__clkbuf_16
X$12246 VNB|VSS synth_701 synth_2750 VDD VDD VNB|VSS sky130_fd_sc_hd__clkbuf_16
X$12247 VNB|VSS synth_6550 synth_6728 VDD VDD VNB|VSS sky130_fd_sc_hd__clkbuf_16
X$12248 VNB|VSS synth_7066 synth_6734 VDD VDD VNB|VSS sky130_fd_sc_hd__clkbuf_16
X$12249 VNB|VSS synth_506 synth_2643 VDD VDD VNB|VSS sky130_fd_sc_hd__clkbuf_16
X$12250 VNB|VSS synth_38 synth_36 VDD VDD VNB|VSS sky130_fd_sc_hd__clkbuf_16
X$12251 VDD synth_12011 synth_11843 synth_11983 VDD VNB|VSS synth_12073 VNB|VSS
+ sky130_fd_sc_hd__o21bai_1
X$12252 VDD synth_6526 synth_6419 synth_6600 VDD VNB|VSS synth_6448 VNB|VSS
+ sky130_fd_sc_hd__o21bai_1
X$12253 VDD synth_6354 synth_6315 synth_6176 VDD VNB|VSS synth_6430 VNB|VSS
+ sky130_fd_sc_hd__o21bai_1
X$12254 VDD synth_9315 synth_9317 synth_9154 VDD VNB|VSS synth_9316 VNB|VSS
+ sky130_fd_sc_hd__o21bai_1
X$12255 VDD synth_6747 synth_6748 synth_6586 VDD VNB|VSS synth_7007 VNB|VSS
+ sky130_fd_sc_hd__o21bai_1
X$12256 VDD synth_868 synth_809 synth_898 VDD VNB|VSS synth_867 VNB|VSS
+ sky130_fd_sc_hd__o21bai_1
X$12257 VDD synth_7969 synth_7825 synth_7850 VDD VNB|VSS synth_8136 VNB|VSS
+ sky130_fd_sc_hd__o21bai_1
X$12258 VDD synth_9166 synth_9310 synth_9546 VDD VNB|VSS synth_9095 VNB|VSS
+ sky130_fd_sc_hd__o21bai_1
X$12259 VDD synth_12461 synth_12462 synth_12402 VDD VNB|VSS synth_12555 VNB|VSS
+ sky130_fd_sc_hd__o21bai_1
X$12260 VDD synth_3401 synth_3402 synth_3399 VDD VNB|VSS synth_3524 VNB|VSS
+ sky130_fd_sc_hd__o21bai_1
X$12261 VDD synth_4594 synth_4528 synth_4503 VDD VNB|VSS synth_4572 VNB|VSS
+ sky130_fd_sc_hd__o21bai_1
X$12262 VDD synth_2365 synth_2141 synth_2138 VDD VNB|VSS synth_2436 VNB|VSS
+ sky130_fd_sc_hd__o21bai_1
X$12263 VDD synth_2211 synth_2063 synth_2131 VDD VNB|VSS synth_2390 VNB|VSS
+ sky130_fd_sc_hd__o21bai_1
X$12264 VDD synth_9070 synth_9028 synth_9068 VDD VNB|VSS synth_9069 VNB|VSS
+ sky130_fd_sc_hd__o21bai_1
X$12265 VDD synth_10822 synth_10705 synth_10683 VDD VNB|VSS synth_10825 VNB|VSS
+ sky130_fd_sc_hd__o21bai_1
X$12266 VDD synth_8783 synth_8689 synth_8549 VDD VNB|VSS synth_8762 VNB|VSS
+ sky130_fd_sc_hd__o21bai_1
X$12267 VDD synth_8780 synth_8614 synth_8690 VDD VNB|VSS synth_8836 VNB|VSS
+ sky130_fd_sc_hd__o21bai_1
X$12268 VDD synth_9091 synth_9013 synth_9071 VDD VNB|VSS synth_9089 VNB|VSS
+ sky130_fd_sc_hd__o21bai_1
X$12269 VDD synth_6830 synth_6985 synth_6906 VDD VNB|VSS synth_6907 VNB|VSS
+ sky130_fd_sc_hd__o21bai_1
X$12270 VDD synth_561 synth_746 synth_797 VDD VNB|VSS synth_612 VNB|VSS
+ sky130_fd_sc_hd__o21bai_1
X$12271 VDD synth_45 synth_46 synth_94 VDD VNB|VSS synth_259 VNB|VSS
+ sky130_fd_sc_hd__o21bai_1
X$12272 VDD synth_7117 synth_7240 synth_7204 VDD VNB|VSS synth_7241 VNB|VSS
+ sky130_fd_sc_hd__o21bai_1
X$12273 VDD synth_5054 synth_5002 synth_5001 VDD VNB|VSS synth_5052 VNB|VSS
+ sky130_fd_sc_hd__o21bai_1
X$12274 VDD synth_5993 synth_6307 synth_6245 VDD VNB|VSS synth_6306 VNB|VSS
+ sky130_fd_sc_hd__o21bai_1
X$12275 VDD synth_4013 synth_4344 synth_4432 VDD VNB|VSS synth_4313 VNB|VSS
+ sky130_fd_sc_hd__o21bai_1
X$12276 VDD synth_8528 synth_8491 synth_8616 VDD VNB|VSS synth_8573 VNB|VSS
+ sky130_fd_sc_hd__o21bai_1
X$12277 VDD synth_6993 synth_6982 synth_6978 VDD VNB|VSS synth_7042 VNB|VSS
+ sky130_fd_sc_hd__o21bai_1
X$12278 VDD synth_8710 synth_10171 synth_10098 VDD VNB|VSS synth_9329 VNB|VSS
+ sky130_fd_sc_hd__o21bai_1
X$12279 VDD synth_4427 synth_4719 synth_4647 VDD VNB|VSS synth_4646 VNB|VSS
+ sky130_fd_sc_hd__o21bai_1
X$12280 VDD synth_456 synth_421 synth_424 VDD VNB|VSS synth_457 VNB|VSS
+ sky130_fd_sc_hd__o21bai_1
X$12281 VNB|VSS synth_19 VDD VDD VNB|VSS sky130_fd_sc_hd__clkbuf_8
X$12282 VDD synth_4890 synth_4728 synth_4831 VDD VNB|VSS synth_5111 VNB|VSS
+ sky130_fd_sc_hd__o21bai_1
X$12283 VDD synth_4705 synth_4599 synth_4557 VDD VNB|VSS synth_4679 VNB|VSS
+ sky130_fd_sc_hd__o21bai_1
X$12284 VDD synth_2668 synth_2598 synth_2667 VDD VNB|VSS synth_2739 VNB|VSS
+ sky130_fd_sc_hd__o21bai_1
X$12285 VDD synth_1131 synth_1061 synth_1065 VDD VNB|VSS synth_1210 VNB|VSS
+ sky130_fd_sc_hd__o21bai_1
X$12286 VDD synth_3518 synth_3799 synth_3796 VDD VNB|VSS synth_3734 VNB|VSS
+ sky130_fd_sc_hd__o21bai_1
X$12287 VDD synth_4268 synth_4182 synth_4181 VDD VNB|VSS synth_4319 VNB|VSS
+ sky130_fd_sc_hd__o21bai_1
X$12288 VDD synth_6465 synth_6386 synth_6308 VDD VNB|VSS synth_6481 VNB|VSS
+ sky130_fd_sc_hd__o21bai_1
X$12289 VDD synth_10381 synth_10382 synth_10447 VDD VNB|VSS synth_10179 VNB|VSS
+ sky130_fd_sc_hd__o21bai_1
X$12290 VDD synth_617 synth_675 synth_674 VDD VNB|VSS synth_795 VNB|VSS
+ sky130_fd_sc_hd__o21bai_1
X$12291 VDD synth_2895 synth_3160 synth_3159 VDD VNB|VSS synth_3098 VNB|VSS
+ sky130_fd_sc_hd__o21bai_1
X$12292 VDD synth_9863 synth_9724 synth_9726 VDD VNB|VSS synth_9885 VNB|VSS
+ sky130_fd_sc_hd__o21bai_1
X$12293 VDD synth_3392 synth_3348 synth_3218 VDD VNB|VSS synth_3388 VNB|VSS
+ sky130_fd_sc_hd__o21bai_1
X$12294 VDD synth_10425 synth_10786 synth_10706 VDD VNB|VSS synth_10834 VNB|VSS
+ sky130_fd_sc_hd__o21bai_1
X$12295 VDD synth_5339 synth_5501 synth_5562 VDD VNB|VSS synth_5538 VNB|VSS
+ sky130_fd_sc_hd__o21bai_1
X$12296 VDD synth_6737 synth_6579 synth_6624 VDD VNB|VSS synth_6767 VNB|VSS
+ sky130_fd_sc_hd__o21bai_1
X$12297 VDD synth_620 synth_567 synth_621 VDD VNB|VSS synth_653 VNB|VSS
+ sky130_fd_sc_hd__o21bai_1
X$12298 VDD synth_8168 synth_8318 synth_8388 VDD VNB|VSS synth_8374 VNB|VSS
+ sky130_fd_sc_hd__o21bai_1
X$12299 VDD synth_4813 synth_4716 synth_4714 VDD VNB|VSS synth_4814 VNB|VSS
+ sky130_fd_sc_hd__o21bai_1
X$12300 VDD synth_1539 synth_1419 synth_1384 VDD VNB|VSS synth_1666 VNB|VSS
+ sky130_fd_sc_hd__o21bai_1
X$12301 VDD synth_1823 synth_1975 synth_1977 VDD VNB|VSS synth_1989 VNB|VSS
+ sky130_fd_sc_hd__o21bai_1
X$12302 VDD synth_10384 synth_10386 synth_10262 VDD VNB|VSS synth_10733 VNB|VSS
+ sky130_fd_sc_hd__o21bai_1
X$12303 VDD synth_10017 synth_9936 synth_9938 VDD VNB|VSS synth_10018 VNB|VSS
+ sky130_fd_sc_hd__o21bai_1
X$12304 VDD synth_6744 synth_6743 synth_6729 VDD VNB|VSS synth_6808 VNB|VSS
+ sky130_fd_sc_hd__o21bai_1
X$12305 VDD synth_1579 synth_1543 synth_1465 VDD VNB|VSS synth_1669 VNB|VSS
+ sky130_fd_sc_hd__o21bai_1
X$12306 VDD synth_5382 synth_5326 synth_5325 VDD VNB|VSS synth_5643 VNB|VSS
+ sky130_fd_sc_hd__o21bai_1
X$12307 VDD synth_11669 synth_11671 synth_11780 VDD VNB|VSS synth_11454 VNB|VSS
+ sky130_fd_sc_hd__o21bai_1
X$12308 VDD synth_9066 synth_9122 synth_9124 VDD VNB|VSS synth_9067 VNB|VSS
+ sky130_fd_sc_hd__o21bai_1
X$12309 VDD synth_11253 synth_11252 synth_11185 VDD VNB|VSS synth_11338 VNB|VSS
+ sky130_fd_sc_hd__o21bai_1
X$12310 VDD synth_296 synth_240 synth_69 VDD VNB|VSS synth_295 VNB|VSS
+ sky130_fd_sc_hd__o21bai_1
X$12311 VDD synth_79 synth_128 synth_55 VDD VNB|VSS synth_372 VNB|VSS
+ sky130_fd_sc_hd__o21bai_1
X$12312 VDD synth_6540 synth_6577 synth_6787 VDD VNB|VSS synth_6764 VNB|VSS
+ sky130_fd_sc_hd__o21bai_1
X$12313 VDD synth_9939 synth_10020 synth_10036 VDD VNB|VSS synth_9798 VNB|VSS
+ sky130_fd_sc_hd__o21bai_1
X$12314 VDD synth_7260 synth_7329 synth_7405 VDD VNB|VSS synth_7371 VNB|VSS
+ sky130_fd_sc_hd__o21bai_1
X$12315 VDD synth_12289 synth_12683 synth_12684 VDD VNB|VSS synth_12656 VNB|VSS
+ sky130_fd_sc_hd__o21bai_1
X$12316 VDD synth_7787 synth_7788 synth_7728 VDD VNB|VSS synth_7903 VNB|VSS
+ sky130_fd_sc_hd__o21bai_1
X$12317 VDD synth_1754 synth_1757 synth_1832 VDD VNB|VSS synth_1900 VNB|VSS
+ sky130_fd_sc_hd__o21bai_1
X$12318 VDD synth_5744 synth_5981 synth_5957 VDD VNB|VSS synth_5980 VNB|VSS
+ sky130_fd_sc_hd__o21bai_1
X$12319 VDD synth_3491 synth_3450 synth_3362 VDD VNB|VSS synth_3489 VNB|VSS
+ sky130_fd_sc_hd__o21bai_1
X$12320 VDD synth_7626 synth_7544 synth_7454 VDD VNB|VSS synth_7625 VNB|VSS
+ sky130_fd_sc_hd__o21bai_1
X$12321 VDD synth_6642 synth_6814 synth_6811 VDD VNB|VSS synth_6878 VNB|VSS
+ sky130_fd_sc_hd__o21bai_1
X$12322 VDD synth_5858 synth_5655 synth_5752 VDD VNB|VSS synth_5955 VNB|VSS
+ sky130_fd_sc_hd__o21bai_1
X$12323 VDD synth_9610 synth_9380 synth_9505 VDD VNB|VSS synth_9733 VNB|VSS
+ sky130_fd_sc_hd__o21bai_1
X$12324 VDD synth_4582 synth_4957 synth_4827 VDD VNB|VSS synth_4776 VNB|VSS
+ sky130_fd_sc_hd__o21bai_1
X$12325 VDD synth_6670 synth_6543 synth_6668 VDD VNB|VSS synth_6671 VNB|VSS
+ sky130_fd_sc_hd__o21bai_1
X$12326 VDD synth_11371 synth_11300 synth_11528 VDD VNB|VSS synth_11530 VNB|VSS
+ sky130_fd_sc_hd__o21bai_1
X$12327 VDD synth_9425 synth_9479 synth_9426 VDD VNB|VSS synth_9616 VNB|VSS
+ sky130_fd_sc_hd__o21bai_1
X$12328 VDD synth_5225 synth_5049 synth_4983 VDD VNB|VSS synth_5141 VNB|VSS
+ sky130_fd_sc_hd__o21bai_1
X$12329 VDD synth_1128 synth_894 synth_893 VDD VNB|VSS synth_1017 VNB|VSS
+ sky130_fd_sc_hd__o21bai_1
X$12330 VDD synth_5680 synth_5637 synth_5580 VDD VNB|VSS synth_5843 VNB|VSS
+ sky130_fd_sc_hd__o21bai_1
X$12331 VDD synth_835 synth_764 synth_639 VDD VNB|VSS synth_953 VNB|VSS
+ sky130_fd_sc_hd__o21bai_1
X$12332 VDD synth_269 synth_75 synth_337 VDD VNB|VSS synth_206 VNB|VSS
+ sky130_fd_sc_hd__o21bai_1
X$12333 VDD synth_1286 synth_1192 synth_1287 VDD VNB|VSS synth_1191 VNB|VSS
+ sky130_fd_sc_hd__o21bai_1
X$12334 VDD synth_3974 synth_3904 synth_3838 VDD VNB|VSS synth_4143 VNB|VSS
+ sky130_fd_sc_hd__o21bai_1
X$12335 VDD synth_2296 synth_2214 synth_2067 VDD VNB|VSS synth_2443 VNB|VSS
+ sky130_fd_sc_hd__o21bai_1
X$12336 VDD synth_10532 synth_10422 synth_10251 VDD VNB|VSS synth_10469 VNB|VSS
+ sky130_fd_sc_hd__o21bai_1
X$12337 VDD synth_11157 synth_11153 synth_11238 VDD VNB|VSS synth_11204 VNB|VSS
+ sky130_fd_sc_hd__o21bai_1
X$12338 VDD synth_5733 synth_5793 synth_6021 VDD VNB|VSS synth_6060 VNB|VSS
+ sky130_fd_sc_hd__o21bai_1
X$12339 VDD synth_1730 synth_1493 synth_1586 VDD VNB|VSS synth_1693 VNB|VSS
+ sky130_fd_sc_hd__o21bai_1
X$12340 VDD synth_243 synth_65 synth_159 VDD VNB|VSS synth_291 VNB|VSS
+ sky130_fd_sc_hd__o21bai_1
X$12341 VDD synth_8873 synth_11816 synth_11889 VDD VNB|VSS synth_11873 VNB|VSS
+ sky130_fd_sc_hd__o21bai_1
X$12342 VDD synth_2581 synth_2479 synth_2338 VDD VNB|VSS synth_2562 VNB|VSS
+ sky130_fd_sc_hd__o21bai_1
X$12343 VDD synth_1807 synth_2098 synth_1959 VDD VNB|VSS synth_2020 VNB|VSS
+ sky130_fd_sc_hd__o21bai_1
X$12344 VDD synth_5155 synth_4819 synth_4997 VDD VNB|VSS synth_5223 VNB|VSS
+ sky130_fd_sc_hd__o21bai_1
X$12345 VDD synth_1878 synth_1714 synth_1777 VDD VNB|VSS synth_1844 VNB|VSS
+ sky130_fd_sc_hd__o21bai_1
X$12346 VDD synth_12437 synth_12629 synth_12718 VDD VNB|VSS synth_12550 VNB|VSS
+ sky130_fd_sc_hd__o21bai_1
X$12347 VDD synth_6395 synth_6289 synth_6313 VDD VNB|VSS synth_6475 VNB|VSS
+ sky130_fd_sc_hd__o21bai_1
X$12348 VDD synth_309 synth_293 synth_72 VDD VNB|VSS synth_232 VNB|VSS
+ sky130_fd_sc_hd__o21bai_1
X$12349 VDD synth_3237 synth_3178 synth_3092 VDD VNB|VSS synth_3343 VNB|VSS
+ sky130_fd_sc_hd__o21bai_1
X$12350 VDD synth_5504 synth_5421 synth_5530 VDD VNB|VSS synth_5614 VNB|VSS
+ sky130_fd_sc_hd__o21bai_1
X$12351 VDD synth_8064 synth_7947 synth_7874 VDD VNB|VSS synth_8031 VNB|VSS
+ sky130_fd_sc_hd__o21bai_1
X$12352 VDD synth_11253 synth_11252 synth_11256 VDD VNB|VSS synth_11337 VNB|VSS
+ sky130_fd_sc_hd__o21bai_1
X$12353 VDD synth_9549 synth_8517 synth_9281 VDD VNB|VSS synth_9609 VNB|VSS
+ sky130_fd_sc_hd__o21bai_1
X$12354 VDD synth_12326 synth_12769 synth_12715 VDD VNB|VSS synth_12570 VNB|VSS
+ sky130_fd_sc_hd__o21bai_1
X$12355 VDD synth_2726 synth_2796 synth_2651 VDD VNB|VSS synth_2798 VNB|VSS
+ sky130_fd_sc_hd__o21bai_1
X$12356 VDD synth_4211 synth_4387 synth_4298 VDD VNB|VSS synth_4543 VNB|VSS
+ sky130_fd_sc_hd__o21bai_1
X$12357 VDD synth_12587 synth_12723 synth_12708 VDD VNB|VSS synth_12722 VNB|VSS
+ sky130_fd_sc_hd__o21bai_1
X$12358 VDD synth_1348 synth_1350 synth_1349 VDD VNB|VSS synth_1347 VNB|VSS
+ sky130_fd_sc_hd__o21bai_1
X$12359 VDD synth_9548 synth_9220 synth_9374 VDD VNB|VSS synth_9464 VNB|VSS
+ sky130_fd_sc_hd__o21bai_1
X$12360 VDD synth_284 synth_16 synth_82 VDD VNB|VSS synth_223 VNB|VSS
+ sky130_fd_sc_hd__o21bai_1
X$12361 VDD synth_2263 synth_2501 synth_2416 VDD VNB|VSS synth_2615 VNB|VSS
+ sky130_fd_sc_hd__o21bai_1
X$12362 VDD synth_3254 synth_3186 synth_3253 VDD VNB|VSS synth_3257 VNB|VSS
+ sky130_fd_sc_hd__o21bai_1
X$12363 VDD synth_4758 synth_4757 synth_4756 VDD VNB|VSS synth_4954 VNB|VSS
+ sky130_fd_sc_hd__o21bai_1
X$12364 VDD synth_224 synth_64 synth_81 VDD VNB|VSS synth_378 VNB|VSS
+ sky130_fd_sc_hd__o21bai_1
X$12365 VDD synth_1271 synth_1183 synth_1163 VDD VNB|VSS synth_1412 VNB|VSS
+ sky130_fd_sc_hd__o21bai_1
X$12366 VDD synth_10887 synth_11042 synth_11071 VDD VNB|VSS synth_10922 VNB|VSS
+ sky130_fd_sc_hd__o21bai_1
X$12367 VDD synth_5183 synth_5275 synth_5174 VDD VNB|VSS synth_5282 VNB|VSS
+ sky130_fd_sc_hd__o21bai_1
X$12368 VDD synth_5969 synth_5771 synth_5800 VDD VNB|VSS synth_5857 VNB|VSS
+ sky130_fd_sc_hd__o21bai_1
X$12369 VDD synth_10206 synth_10335 synth_10383 VDD VNB|VSS synth_10336 VNB|VSS
+ sky130_fd_sc_hd__o21bai_1
X$12370 VDD synth_5685 synth_5521 synth_5575 VDD VNB|VSS synth_5765 VNB|VSS
+ sky130_fd_sc_hd__o21bai_1
X$12371 VDD synth_7031 synth_6884 synth_6648 VDD VNB|VSS synth_7004 VNB|VSS
+ sky130_fd_sc_hd__o21bai_1
X$12372 VDD synth_3843 synth_3778 synth_3709 VDD VNB|VSS synth_3777 VNB|VSS
+ sky130_fd_sc_hd__o21bai_1
X$12373 VDD synth_4257 synth_4219 synth_3925 VDD VNB|VSS synth_4405 VNB|VSS
+ sky130_fd_sc_hd__o21bai_1
X$12374 VDD synth_1274 synth_1052 synth_1160 VDD VNB|VSS synth_1417 VNB|VSS
+ sky130_fd_sc_hd__o21bai_1
X$12375 VDD synth_9489 synth_9530 synth_9569 VDD VNB|VSS synth_9644 VNB|VSS
+ sky130_fd_sc_hd__o21bai_1
X$12376 VDD synth_3587 synth_3428 synth_3241 VDD VNB|VSS synth_3588 VNB|VSS
+ sky130_fd_sc_hd__o21bai_1
X$12377 VDD synth_4077 synth_3760 synth_3961 VDD VNB|VSS synth_4167 VNB|VSS
+ sky130_fd_sc_hd__o21bai_1
X$12378 VDD synth_10507 synth_10347 synth_10278 VDD VNB|VSS synth_10476 VNB|VSS
+ sky130_fd_sc_hd__o21bai_1
X$12379 VDD synth_11505 synth_10911 synth_11427 VDD VNB|VSS synth_11506 VNB|VSS
+ sky130_fd_sc_hd__o21bai_1
X$12380 VDD synth_9133 synth_8892 synth_9050 VDD VNB|VSS synth_9134 VNB|VSS
+ sky130_fd_sc_hd__o21bai_1
X$12381 VDD synth_6696 synth_7507 synth_6837 VNB|VSS VDD VNB|VSS
+ sky130_fd_sc_hd__nor2_1
X$12382 VDD synth_9019 synth_10126 synth_9716 VNB|VSS VDD VNB|VSS
+ sky130_fd_sc_hd__nor2_1
X$12383 VDD synth_2114 synth_2113 synth_2040 VNB|VSS VDD VNB|VSS
+ sky130_fd_sc_hd__nor2_1
X$12384 VDD synth_8567 synth_8109 synth_8715 VNB|VSS VDD VNB|VSS
+ sky130_fd_sc_hd__nor2_1
X$12385 VDD synth_9873 synth_10667 synth_10742 VNB|VSS VDD VNB|VSS
+ sky130_fd_sc_hd__nor2_1
X$12386 VDD synth_6140 synth_6225 synth_6504 VNB|VSS VDD VNB|VSS
+ sky130_fd_sc_hd__nor2_1
X$12387 VDD synth_6211 synth_7937 synth_7935 VNB|VSS VDD VNB|VSS
+ sky130_fd_sc_hd__nor2_1
X$12388 VDD synth_9427 synth_10797 synth_10644 VNB|VSS VDD VNB|VSS
+ sky130_fd_sc_hd__nor2_1
X$12389 VDD synth_570 synth_580 synth_526 VNB|VSS VDD VNB|VSS
+ sky130_fd_sc_hd__nor2_1
X$12390 VDD synth_11022 synth_11612 synth_11697 VNB|VSS VDD VNB|VSS
+ sky130_fd_sc_hd__nor2_1
X$12391 VDD synth_8248 synth_8330 synth_8249 VNB|VSS VDD VNB|VSS
+ sky130_fd_sc_hd__nor2_1
X$12392 VDD synth_4649 synth_2152 synth_4256 VNB|VSS VDD VNB|VSS
+ sky130_fd_sc_hd__nor2_1
X$12393 VDD synth_1456 synth_5138 synth_7718 VNB|VSS VDD VNB|VSS
+ sky130_fd_sc_hd__nor2_1
X$12394 VDD synth_99 synth_297 synth_359 VNB|VSS VDD VNB|VSS
+ sky130_fd_sc_hd__nor2_1
X$12395 VDD synth_9589 synth_9943 synth_10035 VNB|VSS VDD VNB|VSS
+ sky130_fd_sc_hd__nor2_1
X$12396 VDD synth_6393 synth_6761 synth_6846 VNB|VSS VDD VNB|VSS
+ sky130_fd_sc_hd__nor2_1
X$12397 VDD synth_11726 synth_11745 synth_11744 VNB|VSS VDD VNB|VSS
+ sky130_fd_sc_hd__nor2_1
X$12398 VDD synth_9292 synth_10416 synth_9767 VNB|VSS VDD VNB|VSS
+ sky130_fd_sc_hd__nor2_1
X$12399 VDD synth_513 synth_5129 synth_5401 VNB|VSS VDD VNB|VSS
+ sky130_fd_sc_hd__nor2_1
X$12400 VDD synth_3798 synth_3641 synth_3523 VNB|VSS VDD VNB|VSS
+ sky130_fd_sc_hd__nor2_1
X$12401 VDD synth_10952 synth_11186 synth_11103 VNB|VSS VDD VNB|VSS
+ sky130_fd_sc_hd__nor2_1
X$12402 VDD synth_513 synth_4936 synth_5508 VNB|VSS VDD VNB|VSS
+ sky130_fd_sc_hd__nor2_1
X$12403 VDD synth_1711 synth_2713 synth_4460 VNB|VSS VDD VNB|VSS
+ sky130_fd_sc_hd__nor2_1
X$12404 VDD synth_1525 synth_1375 synth_1650 VNB|VSS VDD VNB|VSS
+ sky130_fd_sc_hd__nor2_1
X$12405 VDD synth_1125 synth_7777 synth_9989 VNB|VSS VDD VNB|VSS
+ sky130_fd_sc_hd__nor2_1
X$12406 VDD synth_3957 synth_4018 synth_4016 VNB|VSS VDD VNB|VSS
+ sky130_fd_sc_hd__nor2_1
X$12407 VDD synth_995 synth_5138 synth_6845 VNB|VSS VDD VNB|VSS
+ sky130_fd_sc_hd__nor2_1
X$12408 VDD synth_5006 synth_4770 synth_5056 VNB|VSS VDD VNB|VSS
+ sky130_fd_sc_hd__nor2_1
X$12409 VDD synth_9427 synth_10513 synth_10446 VNB|VSS VDD VNB|VSS
+ sky130_fd_sc_hd__nor2_1
X$12410 VDD synth_545 synth_7819 synth_12291 VNB|VSS VDD VNB|VSS
+ sky130_fd_sc_hd__nor2_1
X$12411 VDD synth_12314 synth_12433 synth_12434 VNB|VSS VDD VNB|VSS
+ sky130_fd_sc_hd__nor2_1
X$12412 VDD synth_10552 synth_10831 synth_10313 VNB|VSS VDD VNB|VSS
+ sky130_fd_sc_hd__nor2_1
X$12413 VDD synth_9629 synth_10232 synth_10689 VNB|VSS VDD VNB|VSS
+ sky130_fd_sc_hd__nor2_1
X$12414 VDD synth_10956 synth_10952 synth_10875 VNB|VSS VDD VNB|VSS
+ sky130_fd_sc_hd__nor2_1
X$12415 VDD synth_10952 synth_11179 synth_11254 VNB|VSS VDD VNB|VSS
+ sky130_fd_sc_hd__nor2_1
X$12416 VDD synth_5977 synth_6067 synth_6119 VNB|VSS VDD VNB|VSS
+ sky130_fd_sc_hd__nor2_1
X$12417 VDD synth_647 synth_509 synth_1108 VNB|VSS VDD VNB|VSS
+ sky130_fd_sc_hd__nor2_1
X$12418 VDD synth_408 synth_855 synth_772 VNB|VSS VDD VNB|VSS
+ sky130_fd_sc_hd__nor2_1
X$12419 VDD synth_9774 synth_10235 synth_10275 VNB|VSS VDD VNB|VSS
+ sky130_fd_sc_hd__nor2_1
X$12420 VDD synth_2807 synth_545 synth_3646 VNB|VSS VDD VNB|VSS
+ sky130_fd_sc_hd__nor2_1
X$12421 VDD synth_510 synth_7819 synth_12162 VNB|VSS VDD VNB|VSS
+ sky130_fd_sc_hd__nor2_1
X$12422 VDD synth_560 synth_6636 synth_6505 VNB|VSS VDD VNB|VSS
+ sky130_fd_sc_hd__nor2_1
X$12423 VDD synth_1026 synth_807 synth_1174 VNB|VSS VDD VNB|VSS
+ sky130_fd_sc_hd__nor2_1
X$12424 VDD synth_1456 synth_2431 synth_2926 VNB|VSS VDD VNB|VSS
+ sky130_fd_sc_hd__nor2_1
X$12425 VDD synth_939 synth_4936 synth_6158 VNB|VSS VDD VNB|VSS
+ sky130_fd_sc_hd__nor2_1
X$12426 VDD synth_9695 synth_11382 synth_10001 VNB|VSS VDD VNB|VSS
+ sky130_fd_sc_hd__nor2_1
X$12427 VDD synth_513 synth_5138 synth_5408 VNB|VSS VDD VNB|VSS
+ sky130_fd_sc_hd__nor2_1
X$12428 VDD synth_5730 synth_5790 synth_5928 VNB|VSS VDD VNB|VSS
+ sky130_fd_sc_hd__nor2_1
X$12429 VDD synth_1456 synth_5129 synth_8032 VNB|VSS VDD VNB|VSS
+ sky130_fd_sc_hd__nor2_1
X$12430 VDD synth_11080 synth_10997 synth_10996 VNB|VSS VDD VNB|VSS
+ sky130_fd_sc_hd__nor2_1
X$12431 VDD synth_11310 synth_11309 synth_11359 VNB|VSS VDD VNB|VSS
+ sky130_fd_sc_hd__nor2_1
X$12432 VDD synth_10495 synth_10621 synth_10671 VNB|VSS VDD VNB|VSS
+ sky130_fd_sc_hd__nor2_1
X$12433 VDD synth_9589 synth_9937 synth_9864 VNB|VSS VDD VNB|VSS
+ sky130_fd_sc_hd__nor2_1
X$12434 VDD synth_10449 synth_10400 synth_10481 VNB|VSS VDD VNB|VSS
+ sky130_fd_sc_hd__nor2_1
X$12435 VDD synth_12452 synth_9824 synth_12649 VNB|VSS VDD VNB|VSS
+ sky130_fd_sc_hd__nor2_1
X$12436 VDD synth_1827 synth_7780 synth_12228 VNB|VSS VDD VNB|VSS
+ sky130_fd_sc_hd__nor2_1
X$12437 VDD synth_1533 synth_1656 synth_1830 VNB|VSS VDD VNB|VSS
+ sky130_fd_sc_hd__nor2_1
X$12438 VDD synth_10189 synth_9873 synth_10027 VNB|VSS VDD VNB|VSS
+ sky130_fd_sc_hd__nor2_1
X$12439 VDD synth_939 synth_509 synth_748 VNB|VSS VDD VNB|VSS
+ sky130_fd_sc_hd__nor2_1
X$12440 VDD synth_1094 synth_550 synth_734 VNB|VSS VDD VNB|VSS
+ sky130_fd_sc_hd__nor2_1
X$12441 VDD synth_1292 synth_1195 synth_1400 VNB|VSS VDD VNB|VSS
+ sky130_fd_sc_hd__nor2_1
X$12442 VDD synth_877 synth_550 synth_1981 VNB|VSS VDD VNB|VSS
+ sky130_fd_sc_hd__nor2_1
X$12443 VDD synth_9292 synth_8870 synth_12235 VNB|VSS VDD VNB|VSS
+ sky130_fd_sc_hd__nor2_1
X$12444 VDD synth_4649 synth_2035 synth_2108 VNB|VSS VDD VNB|VSS
+ sky130_fd_sc_hd__nor2_1
X$12445 VDD synth_10285 synth_8948 synth_12302 VNB|VSS VDD VNB|VSS
+ sky130_fd_sc_hd__nor2_1
X$12446 VDD synth_1094 synth_2431 synth_2128 VNB|VSS VDD VNB|VSS
+ sky130_fd_sc_hd__nor2_1
X$12447 VDD synth_1587 synth_1780 synth_1605 VNB|VSS VDD VNB|VSS
+ sky130_fd_sc_hd__nor2_1
X$12448 VDD synth_4675 synth_4742 synth_4744 VNB|VSS VDD VNB|VSS
+ sky130_fd_sc_hd__nor2_1
X$12449 VDD synth_10449 synth_10655 synth_10609 VNB|VSS VDD VNB|VSS
+ sky130_fd_sc_hd__nor2_1
X$12450 VDD synth_4598 synth_4531 synth_7440 VNB|VSS VDD VNB|VSS
+ sky130_fd_sc_hd__nor2_1
X$12451 VDD synth_510 synth_550 synth_12 VNB|VSS VDD VNB|VSS
+ sky130_fd_sc_hd__nor2_1
X$12452 VNB|VSS synth_53 VDD VDD VNB|VSS sky130_fd_sc_hd__bufinv_16
X$12453 VDD synth_7345 synth_7339 synth_7212 VNB|VSS VDD VNB|VSS
+ sky130_fd_sc_hd__nor2_1
X$12454 VDD synth_1299 synth_1200 synth_1302 VNB|VSS VDD VNB|VSS
+ sky130_fd_sc_hd__nor2_1
X$12455 VDD synth_7000 synth_1094 synth_8842 VNB|VSS VDD VNB|VSS
+ sky130_fd_sc_hd__nor2_1
X$12456 VDD synth_1588 synth_1589 synth_1522 VNB|VSS VDD VNB|VSS
+ sky130_fd_sc_hd__nor2_1
X$12457 VDD synth_1521 synth_1588 synth_1294 synth_1589 VDD VNB|VSS synth_1375
+ VNB|VSS sky130_fd_sc_hd__or4b_1
X$12458 VDD synth_1652 synth_1590 synth_1599 VNB|VSS VDD VNB|VSS
+ sky130_fd_sc_hd__nor2_1
X$12459 VDD synth_9019 synth_10125 synth_9879 VNB|VSS VDD VNB|VSS
+ sky130_fd_sc_hd__nor2_1
X$12460 VDD synth_1652 synth_1591 synth_1521 VNB|VSS VDD VNB|VSS
+ sky130_fd_sc_hd__nor2_1
X$12461 VDD synth_4084 synth_4308 synth_4258 VNB|VSS VDD VNB|VSS
+ sky130_fd_sc_hd__nor2_1
X$12462 VDD synth_8954 synth_8879 synth_9026 VNB|VSS VDD VNB|VSS
+ sky130_fd_sc_hd__nor2_1
X$12463 VDD synth_581 synth_4371 synth_4200 VNB|VSS VDD VNB|VSS
+ sky130_fd_sc_hd__nor2_1
X$12464 VDD synth_9119 synth_9233 synth_9893 VNB|VSS VDD VNB|VSS
+ sky130_fd_sc_hd__nor2_1
X$12465 VDD synth_12310 synth_12469 synth_12547 VNB|VSS VDD VNB|VSS
+ sky130_fd_sc_hd__nor2_1
X$12466 VDD synth_358 synth_359 synth_405 VNB|VSS VDD VNB|VSS
+ sky130_fd_sc_hd__nor2_1
X$12467 VDD synth_8250 synth_8398 synth_8503 VNB|VSS VDD VNB|VSS
+ sky130_fd_sc_hd__nor2_1
X$12468 VDD synth_2120 synth_2048 synth_2258 VNB|VSS VDD VNB|VSS
+ sky130_fd_sc_hd__nor2_1
X$12469 VDD synth_10793 synth_9322 synth_11928 VNB|VSS VDD VNB|VSS
+ sky130_fd_sc_hd__nor2_1
X$12470 VDD synth_513 synth_7777 synth_7886 VNB|VSS VDD VNB|VSS
+ sky130_fd_sc_hd__nor2_1
X$12471 VDD synth_10099 synth_10778 synth_12468 VNB|VSS VDD VNB|VSS
+ sky130_fd_sc_hd__nor2_1
X$12472 VDD synth_647 synth_5129 synth_6424 VNB|VSS VDD VNB|VSS
+ sky130_fd_sc_hd__nor2_1
X$12473 VDD synth_1081 synth_1561 synth_1490 VNB|VSS VDD VNB|VSS
+ sky130_fd_sc_hd__nor2_1
X$12474 VDD synth_939 synth_2807 synth_2742 VNB|VSS VDD VNB|VSS
+ sky130_fd_sc_hd__nor2_1
X$12475 VDD synth_6696 synth_6698 synth_7049 VNB|VSS VDD VNB|VSS
+ sky130_fd_sc_hd__nor2_1
X$12476 VDD synth_1467 synth_550 synth_949 VNB|VSS VDD VNB|VSS
+ sky130_fd_sc_hd__nor2_1
X$12477 VDD synth_580 synth_5129 synth_6952 VNB|VSS VDD VNB|VSS
+ sky130_fd_sc_hd__nor2_1
X$12478 VDD synth_5830 synth_6009 synth_5690 VNB|VSS VDD VNB|VSS
+ sky130_fd_sc_hd__nor2_1
X$12479 VDD synth_6698 synth_7133 synth_7047 VNB|VSS VDD VNB|VSS
+ sky130_fd_sc_hd__nor2_1
X$12480 VDD synth_6390 synth_6702 synth_6561 VNB|VSS VDD VNB|VSS
+ sky130_fd_sc_hd__nor2_1
X$12481 VDD synth_581 synth_1535 synth_1461 VNB|VSS VDD VNB|VSS
+ sky130_fd_sc_hd__nor2_1
X$12482 VDD synth_9589 synth_10034 synth_10033 VNB|VSS VDD VNB|VSS
+ sky130_fd_sc_hd__nor2_1
X$12483 VDD synth_2807 synth_1827 synth_5686 VNB|VSS VDD VNB|VSS
+ sky130_fd_sc_hd__nor2_1
X$12484 VDD synth_474 synth_901 synth_958 VNB|VSS VDD VNB|VSS
+ sky130_fd_sc_hd__nor2_1
X$12485 VDD synth_6469 synth_8891 synth_8771 VNB|VSS VDD VNB|VSS
+ sky130_fd_sc_hd__nor2_1
X$12486 VDD synth_545 synth_3107 synth_5073 VNB|VSS VDD VNB|VSS
+ sky130_fd_sc_hd__nor2_1
X$12487 VDD synth_9701 synth_9483 synth_9658 VNB|VSS VDD VNB|VSS
+ sky130_fd_sc_hd__nor2_1
X$12488 VDD synth_10190 synth_9873 synth_10242 VNB|VSS VDD VNB|VSS
+ sky130_fd_sc_hd__nor2_1
X$12489 VDD synth_995 synth_3107 synth_5414 VNB|VSS VDD VNB|VSS
+ sky130_fd_sc_hd__nor2_1
X$12490 VDD synth_6391 synth_6704 synth_6559 VNB|VSS VDD VNB|VSS
+ sky130_fd_sc_hd__nor2_1
X$12491 VDD synth_2713 synth_877 synth_3196 VNB|VSS VDD VNB|VSS
+ sky130_fd_sc_hd__nor2_1
X$12492 VDD synth_1456 synth_7780 synth_12086 VNB|VSS VDD VNB|VSS
+ sky130_fd_sc_hd__nor2_1
X$12493 VDD synth_6469 synth_7504 synth_7603 VNB|VSS VDD VNB|VSS
+ sky130_fd_sc_hd__nor2_1
X$12494 VDD synth_5071 synth_5146 synth_5143 VNB|VSS VDD VNB|VSS
+ sky130_fd_sc_hd__nor2_1
X$12495 VDD synth_7590 synth_6759 synth_7512 VNB|VSS VDD VNB|VSS
+ sky130_fd_sc_hd__nor2_1
X$12496 VDD synth_10399 synth_10515 synth_10539 VNB|VSS VDD VNB|VSS
+ sky130_fd_sc_hd__nor2_1
X$12497 VDD synth_7882 synth_7422 synth_8033 VNB|VSS VDD VNB|VSS
+ sky130_fd_sc_hd__nor2_1
X$12498 VDD synth_877 synth_5129 synth_4950 VNB|VSS VDD VNB|VSS
+ sky130_fd_sc_hd__nor2_1
X$12499 VDD synth_5196 synth_5195 synth_6221 VNB|VSS VDD VNB|VSS
+ sky130_fd_sc_hd__nor2_1
X$12500 VDD synth_8250 synth_8416 synth_8282 VNB|VSS VDD VNB|VSS
+ sky130_fd_sc_hd__nor2_1
X$12501 VDD synth_6835 synth_6697 synth_6760 VNB|VSS VDD VNB|VSS
+ sky130_fd_sc_hd__nor2_1
X$12502 VDD synth_7674 synth_6727 synth_7946 VNB|VSS VDD VNB|VSS
+ sky130_fd_sc_hd__nor2_1
X$12503 VDD synth_1070 synth_3107 synth_3879 VNB|VSS VDD VNB|VSS
+ sky130_fd_sc_hd__nor2_1
X$12504 VDD synth_1467 synth_5129 synth_8992 VNB|VSS VDD VNB|VSS
+ sky130_fd_sc_hd__nor2_1
X$12505 VDD synth_8109 synth_8111 synth_8025 VNB|VSS VDD VNB|VSS
+ sky130_fd_sc_hd__nor2_1
X$12506 VDD synth_7345 synth_7517 synth_7287 VNB|VSS VDD VNB|VSS
+ sky130_fd_sc_hd__nor2_1
X$12507 VDD synth_11435 synth_11381 synth_11163 VNB|VSS VDD VNB|VSS
+ sky130_fd_sc_hd__nor2_1
X$12508 VDD synth_1094 synth_7780 synth_11717 VNB|VSS VDD VNB|VSS
+ sky130_fd_sc_hd__nor2_1
X$12509 VDD synth_11006 synth_11135 synth_11004 VNB|VSS VDD VNB|VSS
+ sky130_fd_sc_hd__nor2_1
X$12510 VDD synth_7345 synth_7669 synth_7606 VNB|VSS VDD VNB|VSS
+ sky130_fd_sc_hd__nor2_1
X$12511 VDD synth_8803 synth_8804 synth_10367 VNB|VSS VDD VNB|VSS
+ sky130_fd_sc_hd__nor2_1
X$12512 VDD synth_8250 synth_9032 synth_8828 VNB|VSS VDD VNB|VSS
+ sky130_fd_sc_hd__nor2_1
X$12513 VDD synth_1303 synth_1302 synth_1306 VNB|VSS VDD VNB|VSS
+ sky130_fd_sc_hd__nor2_1
X$12514 VDD synth_6007 synth_6092 synth_6253 VNB|VSS VDD VNB|VSS
+ sky130_fd_sc_hd__nor2_1
X$12515 VDD synth_5947 synth_6272 synth_6081 VNB|VSS VDD VNB|VSS
+ sky130_fd_sc_hd__nor2_1
X$12516 VDD synth_8812 synth_8769 synth_8484 VNB|VSS VDD VNB|VSS
+ sky130_fd_sc_hd__nor2_1
X$12517 VDD synth_10697 synth_9559 synth_11648 VNB|VSS VDD VNB|VSS
+ sky130_fd_sc_hd__nor2_1
X$12518 VDD synth_995 synth_7819 synth_11761 VNB|VSS VDD VNB|VSS
+ sky130_fd_sc_hd__nor2_1
X$12519 VDD synth_1816 synth_1644 synth_1818 VNB|VSS VDD VNB|VSS
+ sky130_fd_sc_hd__nor2_1
X$12520 VDD synth_6089 synth_6087 synth_6091 VNB|VSS VDD VNB|VSS
+ sky130_fd_sc_hd__nor2_1
X$12521 VDD synth_8768 synth_8822 synth_8772 VNB|VSS VDD VNB|VSS
+ sky130_fd_sc_hd__nor2_1
X$12522 VDD synth_6469 synth_7950 synth_8126 VNB|VSS VDD VNB|VSS
+ sky130_fd_sc_hd__nor2_1
X$12523 VDD synth_3698 synth_3633 synth_3701 VNB|VSS VDD VNB|VSS
+ sky130_fd_sc_hd__nor2_1
X$12524 VDD synth_8250 synth_8766 synth_8825 VNB|VSS VDD VNB|VSS
+ sky130_fd_sc_hd__nor2_1
X$12525 VDD synth_10319 synth_10389 synth_10391 VNB|VSS VDD VNB|VSS
+ sky130_fd_sc_hd__nor2_1
X$12526 VDD synth_6540 synth_6577 synth_6622 VNB|VSS VDD VNB|VSS
+ sky130_fd_sc_hd__nor2_1
X$12527 VDD synth_7805 synth_8100 synth_8267 VNB|VSS VDD VNB|VSS
+ sky130_fd_sc_hd__nor2_1
X$12528 VDD synth_10726 synth_10559 synth_11065 VNB|VSS VDD VNB|VSS
+ sky130_fd_sc_hd__nor2_1
X$12529 VDD synth_10520 synth_10107 synth_10961 VNB|VSS VDD VNB|VSS
+ sky130_fd_sc_hd__nor2_1
X$12530 VDD synth_11455 synth_11669 synth_11377 VNB|VSS VDD VNB|VSS
+ sky130_fd_sc_hd__nor2_1
X$12531 VDD synth_6469 synth_6617 synth_6387 VNB|VSS VDD VNB|VSS
+ sky130_fd_sc_hd__nor2_1
X$12532 VDD synth_6432 synth_6538 synth_6592 VNB|VSS VDD VNB|VSS
+ sky130_fd_sc_hd__nor2_1
X$12533 VDD synth_4936 synth_877 synth_5853 VNB|VSS VDD VNB|VSS
+ sky130_fd_sc_hd__nor2_1
X$12534 VDD synth_1622 synth_1880 synth_2016 VNB|VSS VDD VNB|VSS
+ sky130_fd_sc_hd__nor2_1
X$12535 VDD synth_545 synth_5138 synth_6323 VNB|VSS VDD VNB|VSS
+ sky130_fd_sc_hd__nor2_1
X$12536 VDD synth_1722 synth_1724 synth_2018 VNB|VSS VDD VNB|VSS
+ sky130_fd_sc_hd__nor2_1
X$12537 VDD synth_7344 synth_7425 synth_7675 VNB|VSS VDD VNB|VSS
+ sky130_fd_sc_hd__nor2_1
X$12538 VDD synth_510 synth_5129 synth_5433 VNB|VSS VDD VNB|VSS
+ sky130_fd_sc_hd__nor2_1
X$12539 VDD synth_570 synth_939 synth_774 VNB|VSS VDD VNB|VSS
+ sky130_fd_sc_hd__nor2_1
X$12540 VDD synth_5242 synth_5362 synth_5482 VNB|VSS VDD VNB|VSS
+ sky130_fd_sc_hd__nor2_1
X$12541 VDD synth_9186 synth_9185 synth_9259 VNB|VSS VDD VNB|VSS
+ sky130_fd_sc_hd__nor2_1
X$12542 VDD synth_1711 synth_5129 synth_8816 VNB|VSS VDD VNB|VSS
+ sky130_fd_sc_hd__nor2_1
X$12543 VDD synth_9947 synth_10022 synth_10252 VNB|VSS VDD VNB|VSS
+ sky130_fd_sc_hd__nor2_1
X$12544 VDD synth_342 synth_193 synth_275 VNB|VSS VDD VNB|VSS
+ sky130_fd_sc_hd__nor2_1
X$12545 VDD synth_1827 synth_5138 synth_7277 VNB|VSS VDD VNB|VSS
+ sky130_fd_sc_hd__nor2_1
X$12546 VDD synth_9629 synth_9934 synth_9963 VNB|VSS VDD VNB|VSS
+ sky130_fd_sc_hd__nor2_1
X$12547 VDD synth_6469 synth_8654 synth_8718 VNB|VSS VDD VNB|VSS
+ sky130_fd_sc_hd__nor2_1
X$12548 VDD synth_9895 synth_10438 synth_10485 VNB|VSS VDD VNB|VSS
+ sky130_fd_sc_hd__nor2_1
X$12549 VDD synth_877 synth_7780 synth_10857 VNB|VSS VDD VNB|VSS
+ sky130_fd_sc_hd__nor2_1
X$12550 VDD synth_9186 synth_9191 synth_9445 VNB|VSS VDD VNB|VSS
+ sky130_fd_sc_hd__nor2_1
X$12551 VDD synth_2807 synth_580 synth_2733 VNB|VSS VDD VNB|VSS
+ sky130_fd_sc_hd__nor2_1
X$12552 VDD synth_6469 synth_7813 synth_7875 VNB|VSS VDD VNB|VSS
+ sky130_fd_sc_hd__nor2_1
X$12553 VDD synth_7345 synth_7343 synth_7285 VNB|VSS VDD VNB|VSS
+ sky130_fd_sc_hd__nor2_1
X$12554 VDD synth_9947 synth_10256 synth_10754 VNB|VSS VDD VNB|VSS
+ sky130_fd_sc_hd__nor2_1
X$12555 VDD synth_8870 synth_10371 synth_10418 VNB|VSS VDD VNB|VSS
+ sky130_fd_sc_hd__nor2_1
X$12556 VDD synth_7589 synth_7806 synth_7878 VNB|VSS VDD VNB|VSS
+ sky130_fd_sc_hd__nor2_1
X$12557 VDD synth_9019 synth_10664 synth_10587 VNB|VSS VDD VNB|VSS
+ sky130_fd_sc_hd__nor2_1
X$12558 VDD synth_1309 synth_1455 synth_1531 VNB|VSS VDD VNB|VSS
+ sky130_fd_sc_hd__nor2_1
X$12559 VDD synth_8956 synth_8259 synth_8575 VNB|VSS VDD VNB|VSS
+ sky130_fd_sc_hd__nor2_1
X$12560 VDD synth_2431 synth_877 synth_3313 VNB|VSS VDD VNB|VSS
+ sky130_fd_sc_hd__nor2_1
X$12561 VDD synth_10233 synth_10649 synth_10648 VNB|VSS VDD VNB|VSS
+ sky130_fd_sc_hd__nor2_1
X$12562 VDD synth_10648 synth_10491 synth_10782 VNB|VSS VDD VNB|VSS
+ sky130_fd_sc_hd__nor2_1
X$12563 VDD synth_9019 synth_10752 synth_10751 VNB|VSS VDD VNB|VSS
+ sky130_fd_sc_hd__nor2_1
X$12564 VDD synth_939 synth_2713 synth_2599 VNB|VSS VDD VNB|VSS
+ sky130_fd_sc_hd__nor2_1
X$12565 VDD synth_6003 synth_6091 synth_6092 VNB|VSS VDD VNB|VSS
+ sky130_fd_sc_hd__nor2_1
X$12566 VDD synth_1559 synth_1649 synth_1561 VNB|VSS VDD VNB|VSS
+ sky130_fd_sc_hd__nor2_1
X$12567 VDD synth_6469 synth_7046 synth_7137 VNB|VSS VDD VNB|VSS
+ sky130_fd_sc_hd__nor2_1
X$12568 VDD synth_10285 synth_10644 synth_10646 VNB|VSS VDD VNB|VSS
+ sky130_fd_sc_hd__nor2_1
X$12569 VDD synth_10520 synth_10186 synth_9714 VNB|VSS VDD VNB|VSS
+ sky130_fd_sc_hd__nor2_1
X$12570 VDD synth_9119 synth_9324 synth_10175 VNB|VSS VDD VNB|VSS
+ sky130_fd_sc_hd__nor2_1
X$12571 VDD synth_995 synth_7777 synth_10424 VNB|VSS VDD VNB|VSS
+ sky130_fd_sc_hd__nor2_1
X$12572 VDD synth_11940 synth_12057 synth_11951 VNB|VSS VDD VNB|VSS
+ sky130_fd_sc_hd__nor2_1
X$12573 VDD synth_581 synth_6008 synth_5915 VNB|VSS VDD VNB|VSS
+ sky130_fd_sc_hd__nor2_1
X$12574 VDD synth_8870 synth_11017 synth_11315 VNB|VSS VDD VNB|VSS
+ sky130_fd_sc_hd__nor2_1
X$12575 VDD synth_10793 synth_9427 synth_12409 VNB|VSS VDD VNB|VSS
+ sky130_fd_sc_hd__nor2_1
X$12576 VDD synth_1711 synth_7000 synth_8166 VNB|VSS VDD VNB|VSS
+ sky130_fd_sc_hd__nor2_1
X$12577 VDD synth_8946 synth_11017 synth_9061 VNB|VSS VDD VNB|VSS
+ sky130_fd_sc_hd__nor2_1
X$12578 VDD synth_8093 synth_8209 synth_8254 VNB|VSS VDD VNB|VSS
+ sky130_fd_sc_hd__nor2_1
X$12579 VDD synth_570 synth_1094 synth_767 VNB|VSS VDD VNB|VSS
+ sky130_fd_sc_hd__nor2_1
X$12580 VDD synth_58 synth_210 synth_392 VNB|VSS VDD VNB|VSS
+ sky130_fd_sc_hd__nor2_1
X$12581 VDD synth_7974 synth_8239 synth_8240 VNB|VSS VDD VNB|VSS
+ sky130_fd_sc_hd__nor2_1
X$12582 VDD synth_570 synth_1125 synth_2135 VNB|VSS VDD VNB|VSS
+ sky130_fd_sc_hd__nor2_1
X$12583 VDD synth_8768 synth_8955 synth_8823 VNB|VSS VDD VNB|VSS
+ sky130_fd_sc_hd__nor2_1
X$12584 VDD synth_2272 synth_2174 synth_2197 VNB|VSS VDD VNB|VSS
+ sky130_fd_sc_hd__nor2_1
X$12585 VDD synth_3693 synth_3753 synth_3456 VNB|VSS VDD VNB|VSS
+ sky130_fd_sc_hd__nor2_1
X$12586 VDD synth_5925 synth_5915 synth_6013 VNB|VSS VDD VNB|VSS
+ sky130_fd_sc_hd__nor2_1
X$12587 VDD synth_3602 synth_3672 synth_3691 VNB|VSS VDD VNB|VSS
+ sky130_fd_sc_hd__nor2_1
X$12588 VDD synth_647 synth_3107 synth_4486 VNB|VSS VDD VNB|VSS
+ sky130_fd_sc_hd__nor2_1
X$12589 VDD synth_10232 synth_9431 synth_10289 VNB|VSS VDD VNB|VSS
+ sky130_fd_sc_hd__nor2_1
X$12590 VDD synth_12310 synth_12674 synth_12691 VNB|VSS VDD VNB|VSS
+ sky130_fd_sc_hd__nor2_1
X$12591 VDD synth_7316 synth_7318 synth_7381 VNB|VSS VDD VNB|VSS
+ sky130_fd_sc_hd__nor2_1
X$12592 VDD synth_12314 synth_12367 synth_12316 VNB|VSS VDD VNB|VSS
+ sky130_fd_sc_hd__nor2_1
X$12593 VDD synth_11237 synth_11235 synth_11351 VNB|VSS VDD VNB|VSS
+ sky130_fd_sc_hd__nor2_1
X$12594 VDD synth_684 synth_859 synth_1209 VNB|VSS VDD VNB|VSS
+ sky130_fd_sc_hd__nor2_1
X$12595 VDD synth_922 synth_1003 synth_1208 VNB|VSS VDD VNB|VSS
+ sky130_fd_sc_hd__nor2_1
X$12596 VDD synth_1220 synth_1278 synth_1862 VNB|VSS VDD VNB|VSS
+ sky130_fd_sc_hd__nor2_1
X$12597 VDD synth_9901 synth_11468 synth_11568 VNB|VSS VDD VNB|VSS
+ sky130_fd_sc_hd__nor2_1
X$12598 VDD synth_5624 synth_5688 synth_5630 VNB|VSS VDD VNB|VSS
+ sky130_fd_sc_hd__nor2_1
X$12599 VDD synth_5422 synth_5344 synth_5262 VNB|VSS VDD VNB|VSS
+ sky130_fd_sc_hd__nor2_1
X$12600 VDD synth_8109 synth_8114 synth_8194 VNB|VSS VDD VNB|VSS
+ sky130_fd_sc_hd__nor2_1
X$12601 VDD synth_7000 synth_1125 synth_9227 VNB|VSS VDD VNB|VSS
+ sky130_fd_sc_hd__nor2_1
X$12602 VDD synth_4185 synth_4184 synth_4235 VNB|VSS VDD VNB|VSS
+ sky130_fd_sc_hd__nor2_1
X$12603 VDD synth_10952 synth_11607 synth_11551 VNB|VSS VDD VNB|VSS
+ sky130_fd_sc_hd__nor2_1
X$12604 VDD synth_513 synth_550 synth_236 VNB|VSS VDD VNB|VSS
+ sky130_fd_sc_hd__nor2_1
X$12605 VDD synth_8562 synth_8015 synth_8655 VNB|VSS VDD VNB|VSS
+ sky130_fd_sc_hd__nor2_1
X$12606 VDD synth_10212 synth_8804 synth_11468 VNB|VSS VDD VNB|VSS
+ sky130_fd_sc_hd__nor2_1
X$12607 VDD synth_5632 synth_5733 synth_5933 VNB|VSS VDD VNB|VSS
+ sky130_fd_sc_hd__nor2_1
X$12608 VDD synth_1094 synth_7777 synth_10423 VNB|VSS VDD VNB|VSS
+ sky130_fd_sc_hd__nor2_1
X$12609 VDD synth_9629 synth_9239 synth_11169 VNB|VSS VDD VNB|VSS
+ sky130_fd_sc_hd__nor2_1
X$12610 VDD synth_9650 synth_8015 synth_9591 VNB|VSS VDD VNB|VSS
+ sky130_fd_sc_hd__nor2_1
X$12611 VDD synth_346 synth_968 synth_984 VNB|VSS VDD VNB|VSS
+ sky130_fd_sc_hd__nor2_1
X$12612 VDD synth_5260 synth_5156 synth_5341 VNB|VSS VDD VNB|VSS
+ sky130_fd_sc_hd__nor2_1
X$12613 VDD synth_510 synth_2713 synth_2439 VNB|VSS VDD VNB|VSS
+ sky130_fd_sc_hd__nor2_1
X$12614 VDD synth_3916 synth_3978 synth_4009 VNB|VSS VDD VNB|VSS
+ sky130_fd_sc_hd__nor2_1
X$12615 VDD synth_838 synth_839 synth_855 VNB|VSS VDD VNB|VSS
+ sky130_fd_sc_hd__nor2_1
X$12616 VDD synth_4356 synth_4577 synth_4419 VNB|VSS VDD VNB|VSS
+ sky130_fd_sc_hd__nor2_1
X$12617 VDD synth_5966 synth_6061 synth_5881 VNB|VSS VDD VNB|VSS
+ sky130_fd_sc_hd__nor2_1
X$12618 VDD synth_87 synth_59 synth_20 VNB|VSS VDD VNB|VSS
+ sky130_fd_sc_hd__nor2_1
X$12619 VDD synth_4274 synth_4330 synth_4095 VNB|VSS VDD VNB|VSS
+ sky130_fd_sc_hd__nor2_1
X$12620 VDD synth_8258 synth_8097 synth_8349 VNB|VSS VDD VNB|VSS
+ sky130_fd_sc_hd__nor2_1
X$12621 VDD synth_647 synth_550 synth_892 VNB|VSS VDD VNB|VSS
+ sky130_fd_sc_hd__nor2_1
X$12622 VDD synth_8127 synth_8099 synth_8185 VNB|VSS VDD VNB|VSS
+ sky130_fd_sc_hd__nor2_1
X$12623 VDD synth_513 synth_7819 synth_10420 VNB|VSS VDD VNB|VSS
+ sky130_fd_sc_hd__nor2_1
X$12624 VDD synth_10483 synth_11382 synth_11514 VNB|VSS VDD VNB|VSS
+ sky130_fd_sc_hd__nor2_1
X$12625 VDD synth_1456 synth_7777 synth_10070 VNB|VSS VDD VNB|VSS
+ sky130_fd_sc_hd__nor2_1
X$12626 VDD synth_1607 synth_1818 synth_1780 VNB|VSS VDD VNB|VSS
+ sky130_fd_sc_hd__nor2_1
X$12627 VDD synth_9434 synth_10344 synth_11314 VNB|VSS VDD VNB|VSS
+ sky130_fd_sc_hd__nor2_1
X$12628 VDD synth_560 synth_3107 synth_3515 VNB|VSS VDD VNB|VSS
+ sky130_fd_sc_hd__nor2_1
X$12629 VDD synth_9434 synth_11292 synth_11225 VNB|VSS VDD VNB|VSS
+ sky130_fd_sc_hd__nor2_1
X$12630 VDD synth_100 synth_68 synth_297 VNB|VSS VDD VNB|VSS
+ sky130_fd_sc_hd__nor2_1
X$12631 VDD synth_836 synth_772 synth_942 VNB|VSS VDD VNB|VSS
+ sky130_fd_sc_hd__nor2_1
X$12632 VDD synth_10578 synth_9695 synth_10796 VNB|VSS VDD VNB|VSS
+ sky130_fd_sc_hd__nor2_1
X$12633 VDD synth_1467 synth_3107 synth_4732 VNB|VSS VDD VNB|VSS
+ sky130_fd_sc_hd__nor2_1
X$12634 VDD synth_647 synth_2431 synth_3762 VNB|VSS VDD VNB|VSS
+ sky130_fd_sc_hd__nor2_1
X$12635 VDD synth_514 synth_545 synth_147 VNB|VSS VDD VNB|VSS
+ sky130_fd_sc_hd__nor2_1
X$12636 VDD synth_9555 synth_11508 synth_11324 VNB|VSS VDD VNB|VSS
+ sky130_fd_sc_hd__nor2_1
X$12637 VDD synth_580 synth_2713 synth_3017 VNB|VSS VDD VNB|VSS
+ sky130_fd_sc_hd__nor2_1
X$12638 VDD synth_5422 synth_5615 synth_5565 VNB|VSS VDD VNB|VSS
+ sky130_fd_sc_hd__nor2_1
X$12639 VDD synth_5645 synth_5529 synth_5566 VNB|VSS VDD VNB|VSS
+ sky130_fd_sc_hd__nor2_1
X$12640 VDD synth_12314 synth_12771 synth_12616 VNB|VSS VDD VNB|VSS
+ sky130_fd_sc_hd__nor2_1
X$12641 VDD synth_4276 synth_4275 synth_4441 VNB|VSS VDD VNB|VSS
+ sky130_fd_sc_hd__nor2_1
X$12642 VDD synth_560 synth_550 synth_494 VNB|VSS VDD VNB|VSS
+ sky130_fd_sc_hd__nor2_1
X$12643 VDD synth_3881 synth_4020 synth_3946 VNB|VSS VDD VNB|VSS
+ sky130_fd_sc_hd__nor2_1
X$12644 VDD synth_8738 synth_9239 synth_9626 VNB|VSS VDD VNB|VSS
+ sky130_fd_sc_hd__nor2_1
X$12645 VDD synth_7326 synth_7180 synth_7471 VNB|VSS VDD VNB|VSS
+ sky130_fd_sc_hd__nor2_1
X$12646 VDD synth_509 synth_1125 synth_962 VNB|VSS VDD VNB|VSS
+ sky130_fd_sc_hd__nor2_1
X$12647 VDD synth_10652 synth_9696 synth_10865 VNB|VSS VDD VNB|VSS
+ sky130_fd_sc_hd__nor2_1
X$12648 VDD synth_7000 synth_1827 synth_6802 VNB|VSS VDD VNB|VSS
+ sky130_fd_sc_hd__nor2_1
X$12649 VDD synth_510 synth_7000 synth_6343 VNB|VSS VDD VNB|VSS
+ sky130_fd_sc_hd__nor2_1
X$12650 VDD synth_3859 synth_3717 synth_3925 VNB|VSS VDD VNB|VSS
+ sky130_fd_sc_hd__nor2_1
X$12651 VDD synth_3877 synth_4101 synth_4162 VNB|VSS VDD VNB|VSS
+ sky130_fd_sc_hd__nor2_1
X$12652 VDD synth_8007 synth_7935 synth_7934 VNB|VSS VDD VNB|VSS
+ sky130_fd_sc_hd__nor2_1
X$12653 VDD synth_560 synth_509 synth_182 VNB|VSS VDD VNB|VSS
+ sky130_fd_sc_hd__nor2_1
X$12654 VDD synth_6211 synth_8327 synth_8173 VNB|VSS VDD VNB|VSS
+ sky130_fd_sc_hd__nor2_1
X$12655 VDD synth_580 synth_7777 synth_8747 VNB|VSS VDD VNB|VSS
+ sky130_fd_sc_hd__nor2_1
X$12656 VDD synth_6903 synth_6904 synth_6902 VNB|VSS VDD VNB|VSS
+ sky130_fd_sc_hd__nor2_1
X$12657 VDD synth_570 synth_560 synth_479 VNB|VSS VDD VNB|VSS
+ sky130_fd_sc_hd__nor2_1
X$12658 VDD synth_510 synth_2431 synth_2162 VNB|VSS VDD VNB|VSS
+ sky130_fd_sc_hd__nor2_1
X$12659 VDD synth_647 synth_6636 synth_7577 VNB|VSS VDD VNB|VSS
+ sky130_fd_sc_hd__nor2_1
X$12660 VDD synth_647 synth_7000 synth_7105 VNB|VSS VDD VNB|VSS
+ sky130_fd_sc_hd__nor2_1
X$12661 VDD synth_11046 synth_8015 synth_11045 VNB|VSS VDD VNB|VSS
+ sky130_fd_sc_hd__nor2_1
X$12662 VDD synth_10449 synth_11199 synth_11267 VNB|VSS VDD VNB|VSS
+ sky130_fd_sc_hd__nor2_1
X$12663 VDD synth_11099 synth_11045 synth_11197 VNB|VSS VDD VNB|VSS
+ sky130_fd_sc_hd__nor2_1
X$12664 VDD synth_6211 synth_7867 synth_7800 VNB|VSS VDD VNB|VSS
+ sky130_fd_sc_hd__nor2_1
X$12665 VDD synth_7666 synth_7667 synth_7867 VNB|VSS VDD VNB|VSS
+ sky130_fd_sc_hd__nor2_1
X$12666 VDD synth_518 synth_1120 synth_481 VNB|VSS VDD VNB|VSS
+ sky130_fd_sc_hd__nor2_1
X$12667 VDD synth_9589 synth_9632 synth_9722 VNB|VSS VDD VNB|VSS
+ sky130_fd_sc_hd__nor2_1
X$12668 VDD synth_7446 synth_7800 synth_7890 VNB|VSS VDD VNB|VSS
+ sky130_fd_sc_hd__nor2_1
X$12669 VDD synth_12760 synth_12738 synth_12661 VNB|VSS VDD VNB|VSS
+ sky130_fd_sc_hd__nor2_1
X$12670 VDD synth_1711 synth_2807 synth_5187 VNB|VSS VDD VNB|VSS
+ sky130_fd_sc_hd__nor2_1
X$12671 VDD synth_8657 synth_8015 synth_8561 VNB|VSS VDD VNB|VSS
+ sky130_fd_sc_hd__nor2_1
X$12672 VDD synth_5150 synth_5074 synth_5312 VNB|VSS VDD VNB|VSS
+ sky130_fd_sc_hd__nor2_1
X$12673 VDD synth_1467 synth_2431 synth_4227 VNB|VSS VDD VNB|VSS
+ sky130_fd_sc_hd__nor2_1
X$12674 VDD synth_7209 synth_7208 synth_7232 VNB|VSS VDD VNB|VSS
+ sky130_fd_sc_hd__nor2_1
X$12675 VDD synth_1070 synth_6636 synth_7458 VNB|VSS VDD VNB|VSS
+ sky130_fd_sc_hd__nor2_1
X$12676 VDD synth_509 synth_877 synth_511 VNB|VSS VDD VNB|VSS
+ sky130_fd_sc_hd__nor2_1
X$12677 VDD synth_10793 synth_9474 synth_12452 VNB|VSS VDD VNB|VSS
+ sky130_fd_sc_hd__nor2_1
X$12678 VDD synth_10652 synth_11831 synth_11783 VNB|VSS VDD VNB|VSS
+ sky130_fd_sc_hd__nor2_1
X$12679 VDD synth_9042 synth_8764 synth_9231 VNB|VSS VDD VNB|VSS
+ sky130_fd_sc_hd__nor2_1
X$12680 VDD synth_9175 synth_9172 synth_9174 VNB|VSS VDD VNB|VSS
+ sky130_fd_sc_hd__nor2_1
X$12681 VDD synth_8097 synth_8272 synth_8019 VNB|VSS VDD VNB|VSS
+ sky130_fd_sc_hd__nor2_1
X$12682 VDD synth_8803 synth_9233 synth_9675 VNB|VSS VDD VNB|VSS
+ sky130_fd_sc_hd__nor2_1
X$12683 VDD synth_995 synth_2431 synth_2620 VNB|VSS VDD VNB|VSS
+ sky130_fd_sc_hd__nor2_1
X$12684 VDD synth_408 synth_1830 synth_1984 VNB|VSS VDD VNB|VSS
+ sky130_fd_sc_hd__nor2_1
X$12685 VDD synth_8097 synth_8647 synth_8582 VNB|VSS VDD VNB|VSS
+ sky130_fd_sc_hd__nor2_1
X$12686 VDD synth_1009 synth_1090 synth_1007 VNB|VSS VDD VNB|VSS
+ sky130_fd_sc_hd__nor2_1
X$12687 VDD synth_570 synth_647 synth_445 VNB|VSS VDD VNB|VSS
+ sky130_fd_sc_hd__nor2_1
X$12688 VDD synth_11584 synth_11654 synth_11696 VNB|VSS VDD VNB|VSS
+ sky130_fd_sc_hd__nor2_1
X$12689 VDD synth_11330 synth_8015 synth_11395 VNB|VSS VDD VNB|VSS
+ sky130_fd_sc_hd__nor2_1
X$12690 VDD synth_5818 synth_5901 synth_5963 VNB|VSS VDD VNB|VSS
+ sky130_fd_sc_hd__nor2_1
X$12691 VDD synth_8954 synth_9083 synth_9141 VNB|VSS VDD VNB|VSS
+ sky130_fd_sc_hd__nor2_1
X$12692 VDD synth_1125 synth_7780 synth_12227 VNB|VSS VDD VNB|VSS
+ sky130_fd_sc_hd__nor2_1
X$12693 VDD synth_3273 synth_3272 synth_3568 VNB|VSS VDD VNB|VSS
+ sky130_fd_sc_hd__nor2_1
X$12694 VDD synth_4103 synth_4282 synth_4244 VNB|VSS VDD VNB|VSS
+ sky130_fd_sc_hd__nor2_1
X$12695 VDD synth_1711 synth_4936 synth_5820 VNB|VSS VDD VNB|VSS
+ sky130_fd_sc_hd__nor2_1
X$12696 VDD synth_8087 synth_8086 synth_8141 VNB|VSS VDD VNB|VSS
+ sky130_fd_sc_hd__nor2_1
X$12697 VDD synth_7601 synth_6374 synth_8020 VNB|VSS VDD VNB|VSS
+ sky130_fd_sc_hd__nor2_1
X$12698 VDD synth_1761 synth_1870 synth_2079 VNB|VSS VDD VNB|VSS
+ sky130_fd_sc_hd__nor2_1
X$12699 VDD synth_7000 synth_995 synth_6968 VNB|VSS VDD VNB|VSS
+ sky130_fd_sc_hd__nor2_1
X$12700 VDD synth_831 synth_916 synth_957 VNB|VSS VDD VNB|VSS
+ sky130_fd_sc_hd__nor2_1
X$12701 VDD synth_580 synth_3107 synth_2868 VNB|VSS VDD VNB|VSS
+ sky130_fd_sc_hd__nor2_1
X$12702 VDD synth_8954 synth_9452 synth_9450 VNB|VSS VDD VNB|VSS
+ sky130_fd_sc_hd__nor2_1
X$12703 VDD synth_8098 synth_8094 synth_8018 VNB|VSS VDD VNB|VSS
+ sky130_fd_sc_hd__nor2_1
X$12704 VDD synth_10652 synth_9983 synth_12050 VNB|VSS VDD VNB|VSS
+ sky130_fd_sc_hd__nor2_1
X$12705 VDD synth_545 synth_5129 synth_7560 VNB|VSS VDD VNB|VSS
+ sky130_fd_sc_hd__nor2_1
X$12706 VDD synth_11940 synth_12125 synth_12195 VNB|VSS VDD VNB|VSS
+ sky130_fd_sc_hd__nor2_1
X$12707 VDD synth_1467 synth_7777 synth_9995 VNB|VSS VDD VNB|VSS
+ sky130_fd_sc_hd__nor2_1
X$12708 VDD synth_8954 synth_9179 synth_9276 VNB|VSS VDD VNB|VSS
+ sky130_fd_sc_hd__nor2_1
X$12709 VDD synth_570 synth_995 synth_781 VNB|VSS VDD VNB|VSS
+ sky130_fd_sc_hd__nor2_1
X$12710 VDD synth_8870 synth_8871 synth_8915 VNB|VSS VDD VNB|VSS
+ sky130_fd_sc_hd__nor2_1
X$12711 VDD synth_1711 synth_550 synth_1248 VNB|VSS VDD VNB|VSS
+ sky130_fd_sc_hd__nor2_1
X$12712 VDD synth_560 synth_2431 synth_2515 VNB|VSS VDD VNB|VSS
+ sky130_fd_sc_hd__nor2_1
X$12713 VDD synth_11940 synth_11876 synth_11948 VNB|VSS VDD VNB|VSS
+ sky130_fd_sc_hd__nor2_1
X$12714 VDD synth_7939 synth_8013 synth_8012 VNB|VSS VDD VNB|VSS
+ sky130_fd_sc_hd__nor2_1
X$12715 VDD synth_647 synth_7777 synth_9685 VNB|VSS VDD VNB|VSS
+ sky130_fd_sc_hd__nor2_1
X$12716 VDD synth_1456 synth_6636 synth_7895 VNB|VSS VDD VNB|VSS
+ sky130_fd_sc_hd__nor2_1
X$12717 VDD synth_6211 synth_8012 synth_7965 VNB|VSS VDD VNB|VSS
+ sky130_fd_sc_hd__nor2_1
X$12718 VDD synth_7000 synth_1070 synth_7999 VNB|VSS VDD VNB|VSS
+ sky130_fd_sc_hd__nor2_1
X$12719 VDD synth_939 synth_7000 synth_7293 VNB|VSS VDD VNB|VSS
+ sky130_fd_sc_hd__nor2_1
X$12720 VDD synth_1467 synth_7000 synth_9147 VNB|VSS VDD VNB|VSS
+ sky130_fd_sc_hd__nor2_1
X$12721 VDD synth_12310 synth_12378 synth_12377 VNB|VSS VDD VNB|VSS
+ sky130_fd_sc_hd__nor2_1
X$12722 VDD synth_1907 synth_1984 synth_1840 VNB|VSS VDD VNB|VSS
+ sky130_fd_sc_hd__nor2_1
X$12723 VDD synth_939 synth_550 synth_606 VNB|VSS VDD VNB|VSS
+ sky130_fd_sc_hd__nor2_1
X$12724 VDD synth_581 synth_931 synth_1090 VNB|VSS VDD VNB|VSS
+ sky130_fd_sc_hd__nor2_1
X$12725 VDD synth_1094 synth_5138 synth_7151 VNB|VSS VDD VNB|VSS
+ sky130_fd_sc_hd__nor2_1
X$12726 VDD synth_1711 synth_5138 synth_6795 VNB|VSS VDD VNB|VSS
+ sky130_fd_sc_hd__nor2_1
X$12727 VDD synth_11392 synth_11770 synth_11826 VNB|VSS VDD VNB|VSS
+ sky130_fd_sc_hd__nor2_1
X$12728 VDD synth_6740 synth_6793 synth_6773 VNB|VSS VDD VNB|VSS
+ sky130_fd_sc_hd__nor2_1
X$12729 VDD synth_11392 synth_11602 synth_11710 VNB|VSS VDD VNB|VSS
+ sky130_fd_sc_hd__nor2_1
X$12730 VDD synth_11392 synth_11753 synth_11828 VNB|VSS VDD VNB|VSS
+ sky130_fd_sc_hd__nor2_1
X$12731 VDD synth_8097 synth_8587 synth_8660 VNB|VSS VDD VNB|VSS
+ sky130_fd_sc_hd__nor2_1
X$12732 VDD synth_10285 synth_8806 synth_12755 VNB|VSS VDD VNB|VSS
+ sky130_fd_sc_hd__nor2_1
X$12733 VDD synth_930 synth_842 synth_931 VNB|VSS VDD VNB|VSS
+ sky130_fd_sc_hd__nor2_1
X$12734 VDD synth_3365 synth_3262 synth_3548 VNB|VSS VDD VNB|VSS
+ sky130_fd_sc_hd__nor2_1
X$12735 VDD synth_7798 synth_7794 synth_7866 VNB|VSS VDD VNB|VSS
+ sky130_fd_sc_hd__nor2_1
X$12736 VDD synth_12310 synth_12673 synth_12694 VNB|VSS VDD VNB|VSS
+ sky130_fd_sc_hd__nor2_1
X$12737 VDD synth_10449 synth_10401 synth_10266 VNB|VSS VDD VNB|VSS
+ sky130_fd_sc_hd__nor2_1
X$12738 VDD synth_7666 synth_7888 synth_7801 VNB|VSS VDD VNB|VSS
+ sky130_fd_sc_hd__nor2_1
X$12739 VDD synth_570 synth_1827 synth_1677 VNB|VSS VDD VNB|VSS
+ sky130_fd_sc_hd__nor2_1
X$12740 VDD synth_830 synth_829 synth_916 VNB|VSS VDD VNB|VSS
+ sky130_fd_sc_hd__nor2_1
X$12741 VDD synth_8109 synth_8409 synth_8336 VNB|VSS VDD VNB|VSS
+ sky130_fd_sc_hd__nor2_1
X$12742 VDD synth_510 synth_3107 synth_2863 VNB|VSS VDD VNB|VSS
+ sky130_fd_sc_hd__nor2_1
X$12743 VDD synth_1125 synth_5129 synth_9128 VNB|VSS VDD VNB|VSS
+ sky130_fd_sc_hd__nor2_1
X$12744 VDD synth_1125 synth_550 synth_1988 VNB|VSS VDD VNB|VSS
+ sky130_fd_sc_hd__nor2_1
X$12745 VDD synth_11017 synth_9379 synth_11966 VNB|VSS VDD VNB|VSS
+ sky130_fd_sc_hd__nor2_1
X$12746 VDD synth_1827 synth_7819 synth_12196 VNB|VSS VDD VNB|VSS
+ sky130_fd_sc_hd__nor2_1
X$12747 VDD synth_580 synth_7819 synth_10918 VNB|VSS VDD VNB|VSS
+ sky130_fd_sc_hd__nor2_1
X$12748 VDD synth_9112 synth_11750 synth_11751 VNB|VSS VDD VNB|VSS
+ sky130_fd_sc_hd__nor2_1
X$12749 VDD synth_9292 synth_8910 synth_9513 VNB|VSS VDD VNB|VSS
+ sky130_fd_sc_hd__nor2_1
X$12750 VDD synth_4457 synth_4539 synth_4609 VNB|VSS VDD VNB|VSS
+ sky130_fd_sc_hd__nor2_1
X$12751 VDD synth_7928 synth_7901 synth_8294 VNB|VSS VDD VNB|VSS
+ sky130_fd_sc_hd__nor2_1
X$12752 VDD synth_8237 synth_8279 synth_8461 VNB|VSS VDD VNB|VSS
+ sky130_fd_sc_hd__nor2_1
X$12753 VDD synth_8460 synth_8504 synth_8541 synth_6441 synth_6503 VDD
+ synth_4830 VNB|VSS VNB|VSS sky130_fd_sc_hd__o2111ai_1
X$12754 VDD synth_4936 synth_1094 synth_4989 VNB|VSS VDD VNB|VSS
+ sky130_fd_sc_hd__nor2_1
X$12755 VDD synth_570 synth_1070 synth_762 VNB|VSS VDD VNB|VSS
+ sky130_fd_sc_hd__nor2_1
X$12756 VDD synth_513 synth_570 synth_401 VNB|VSS VDD VNB|VSS
+ sky130_fd_sc_hd__nor2_1
X$12757 VDD synth_4164 synth_2089 synth_4741 VNB|VSS VDD VNB|VSS
+ sky130_fd_sc_hd__nor2_1
X$12758 VDD synth_4538 synth_4609 synth_4537 VNB|VSS VDD VNB|VSS
+ sky130_fd_sc_hd__nor2_1
X$12759 VDD synth_9221 synth_9169 synth_8998 VNB|VSS VDD VNB|VSS
+ sky130_fd_sc_hd__nor2_1
X$12760 VDD synth_7000 synth_877 synth_9155 VNB|VSS VDD VNB|VSS
+ sky130_fd_sc_hd__nor2_1
X$12761 VDD synth_8764 synth_8981 synth_9430 VNB|VSS VDD VNB|VSS
+ sky130_fd_sc_hd__nor2_1
X$12762 VDD synth_9063 synth_9629 synth_9930 VNB|VSS VDD VNB|VSS
+ sky130_fd_sc_hd__nor2_1
X$12763 VDD synth_545 synth_509 synth_1956 VNB|VSS VDD VNB|VSS
+ sky130_fd_sc_hd__nor2_1
X$12764 VDD synth_2807 synth_1094 synth_4752 VNB|VSS VDD VNB|VSS
+ sky130_fd_sc_hd__nor2_1
X$12765 VDD synth_9062 synth_9042 synth_9932 VNB|VSS VDD VNB|VSS
+ sky130_fd_sc_hd__nor2_1
X$12766 VDD synth_11392 synth_11327 synth_11275 VNB|VSS VDD VNB|VSS
+ sky130_fd_sc_hd__nor2_1
X$12767 VDD synth_8517 synth_8704 synth_8703 VNB|VSS VDD VNB|VSS
+ sky130_fd_sc_hd__nor2_1
X$12768 VDD synth_510 synth_509 synth_15 VNB|VSS VDD VNB|VSS
+ sky130_fd_sc_hd__nor2_1
X$12769 VDD synth_3774 synth_3841 synth_4135 VNB|VSS VDD VNB|VSS
+ sky130_fd_sc_hd__nor2_1
X$12770 VDD synth_513 synth_6636 synth_6626 VNB|VSS VDD VNB|VSS
+ sky130_fd_sc_hd__nor2_1
X$12771 VDD synth_1456 synth_7819 synth_12222 VNB|VSS VDD VNB|VSS
+ sky130_fd_sc_hd__nor2_1
X$12772 VDD synth_5945 synth_6065 synth_6136 VNB|VSS VDD VNB|VSS
+ sky130_fd_sc_hd__nor2_1
X$12773 VDD synth_8626 synth_8627 synth_8524 VNB|VSS VDD VNB|VSS
+ sky130_fd_sc_hd__nor2_1
X$12774 VDD synth_1546 synth_1675 synth_2000 VNB|VSS VDD VNB|VSS
+ sky130_fd_sc_hd__nor2_1
X$12775 VDD synth_10652 synth_10099 synth_12388 VNB|VSS VDD VNB|VSS
+ sky130_fd_sc_hd__nor2_1
X$12776 VDD synth_11017 synth_9036 synth_11937 VNB|VSS VDD VNB|VSS
+ sky130_fd_sc_hd__nor2_1
X$12777 VDD synth_2036 synth_2031 synth_2110 VNB|VSS VDD VNB|VSS
+ sky130_fd_sc_hd__nor2_1
X$12778 VDD synth_8910 synth_8870 synth_10004 VNB|VSS VDD VNB|VSS
+ sky130_fd_sc_hd__nor2_1
X$12779 VDD synth_8381 synth_8382 synth_8435 VNB|VSS VDD VNB|VSS
+ sky130_fd_sc_hd__nor2_1
X$12780 VDD synth_12319 synth_8015 synth_12474 VNB|VSS VDD VNB|VSS
+ sky130_fd_sc_hd__nor2_1
X$12781 VDD synth_8934 synth_8980 synth_8313 VNB|VSS VDD VNB|VSS
+ sky130_fd_sc_hd__nor2_1
X$12782 VDD synth_6167 synth_6102 synth_6250 VNB|VSS VDD VNB|VSS
+ sky130_fd_sc_hd__nor2_1
X$12783 VDD synth_647 synth_5138 synth_4910 VNB|VSS VDD VNB|VSS
+ sky130_fd_sc_hd__nor2_1
X$12784 VDD synth_9142 synth_9166 synth_9110 VNB|VSS VDD VNB|VSS
+ sky130_fd_sc_hd__nor2_1
X$12785 VDD synth_2240 synth_2335 synth_2564 VNB|VSS VDD VNB|VSS
+ sky130_fd_sc_hd__nor2_1
X$12786 VDD synth_1467 synth_7819 synth_11737 VNB|VSS VDD VNB|VSS
+ sky130_fd_sc_hd__nor2_1
X$12787 VDD synth_1711 synth_514 synth_2523 VNB|VSS VDD VNB|VSS
+ sky130_fd_sc_hd__nor2_1
X$12788 VDD synth_9427 synth_11793 synth_11598 VNB|VSS VDD VNB|VSS
+ sky130_fd_sc_hd__nor2_1
X$12789 VDD synth_1125 synth_7819 synth_12294 VNB|VSS VDD VNB|VSS
+ sky130_fd_sc_hd__nor2_1
X$12790 VDD synth_514 synth_939 synth_1074 VNB|VSS VDD VNB|VSS
+ sky130_fd_sc_hd__nor2_1
X$12791 VDD synth_3167 synth_3137 synth_3332 VNB|VSS VDD VNB|VSS
+ sky130_fd_sc_hd__nor2_1
X$12792 VDD synth_8517 synth_8795 synth_8285 VNB|VSS VDD VNB|VSS
+ sky130_fd_sc_hd__nor2_1
X$12793 VDD synth_8751 synth_8701 synth_8837 VNB|VSS VDD VNB|VSS
+ sky130_fd_sc_hd__nor2_1
X$12794 VDD synth_995 synth_7780 synth_11835 VNB|VSS VDD VNB|VSS
+ sky130_fd_sc_hd__nor2_1
X$12795 VDD synth_10578 synth_9427 synth_12404 VNB|VSS VDD VNB|VSS
+ sky130_fd_sc_hd__nor2_1
X$12796 VDD synth_7419 synth_7498 synth_7611 VNB|VSS VDD VNB|VSS
+ sky130_fd_sc_hd__nor2_1
X$12797 VDD synth_560 synth_7819 synth_11231 VNB|VSS VDD VNB|VSS
+ sky130_fd_sc_hd__nor2_1
X$12798 VDD synth_7582 synth_7763 synth_7658 VNB|VSS VDD VNB|VSS
+ sky130_fd_sc_hd__nor2_1
X$12799 VDD synth_1070 synth_7819 synth_10325 VNB|VSS VDD VNB|VSS
+ sky130_fd_sc_hd__nor2_1
X$12800 VDD synth_2591 synth_2689 synth_2873 VNB|VSS VDD VNB|VSS
+ sky130_fd_sc_hd__nor2_1
X$12801 VDD synth_178 synth_266 synth_335 VNB|VSS VDD VNB|VSS
+ sky130_fd_sc_hd__nor2_1
X$12802 VDD synth_1070 synth_7777 synth_9660 VNB|VSS VDD VNB|VSS
+ sky130_fd_sc_hd__nor2_1
X$12803 VDD synth_545 synth_550 synth_587 VNB|VSS VDD VNB|VSS
+ sky130_fd_sc_hd__nor2_1
X$12804 VDD synth_1467 synth_4936 synth_6297 VNB|VSS VDD VNB|VSS
+ sky130_fd_sc_hd__nor2_1
X$12805 VDD synth_4173 synth_4258 synth_4220 VNB|VSS VDD VNB|VSS
+ sky130_fd_sc_hd__nor2_1
X$12806 VDD synth_203 synth_265 synth_266 VNB|VSS VDD VNB|VSS
+ sky130_fd_sc_hd__nor2_1
X$12807 VDD synth_8901 synth_8880 synth_8881 VNB|VSS VDD VNB|VSS
+ sky130_fd_sc_hd__nor2_1
X$12808 VDD synth_570 synth_545 synth_1671 VNB|VSS VDD VNB|VSS
+ sky130_fd_sc_hd__nor2_1
X$12809 VDD synth_11940 synth_12536 synth_12423 VNB|VSS VDD VNB|VSS
+ sky130_fd_sc_hd__nor2_1
X$12810 VDD synth_9670 synth_9507 synth_9621 VNB|VSS VDD VNB|VSS
+ sky130_fd_sc_hd__nor2_1
X$12811 VDD synth_560 synth_7777 synth_8352 VNB|VSS VDD VNB|VSS
+ sky130_fd_sc_hd__nor2_1
X$12812 VDD synth_6636 synth_877 synth_6996 VNB|VSS VDD VNB|VSS
+ sky130_fd_sc_hd__nor2_1
X$12813 VDD synth_2037 synth_2154 synth_2081 VNB|VSS VDD VNB|VSS
+ sky130_fd_sc_hd__nor2_1
X$12814 VDD synth_9589 synth_9633 synth_9795 VNB|VSS VDD VNB|VSS
+ sky130_fd_sc_hd__nor2_1
X$12815 VDD synth_11017 synth_11590 synth_10062 VNB|VSS VDD VNB|VSS
+ sky130_fd_sc_hd__nor2_1
X$12816 VDD synth_10449 synth_10947 synth_11048 VNB|VSS VDD VNB|VSS
+ sky130_fd_sc_hd__nor2_1
X$12817 VDD synth_3040 synth_3094 synth_2953 VNB|VSS VDD VNB|VSS
+ sky130_fd_sc_hd__nor2_1
X$12818 VDD synth_366 synth_335 synth_312 VNB|VSS VDD VNB|VSS
+ sky130_fd_sc_hd__nor2_1
X$12819 VDD synth_8212 synth_8173 synth_8213 VNB|VSS VDD VNB|VSS
+ sky130_fd_sc_hd__nor2_1
X$12820 VDD synth_1711 synth_3107 synth_4272 VNB|VSS VDD VNB|VSS
+ sky130_fd_sc_hd__nor2_1
X$12821 VDD synth_7938 synth_7899 synth_7937 VNB|VSS VDD VNB|VSS
+ sky130_fd_sc_hd__nor2_1
X$12822 VDD synth_10718 synth_10789 synth_10837 VNB|VSS VDD VNB|VSS
+ sky130_fd_sc_hd__nor2_1
X$12823 VDD synth_10449 synth_10871 synth_10968 VNB|VSS VDD VNB|VSS
+ sky130_fd_sc_hd__nor2_1
X$12824 VDD synth_11940 synth_12003 synth_11941 VNB|VSS VDD VNB|VSS
+ sky130_fd_sc_hd__nor2_1
X$12825 VDD synth_11940 synth_12002 synth_12067 VNB|VSS VDD VNB|VSS
+ sky130_fd_sc_hd__nor2_1
X$12826 VDD synth_10578 synth_12233 synth_12282 VNB|VSS VDD VNB|VSS
+ sky130_fd_sc_hd__nor2_1
X$12827 VDD synth_560 synth_2713 synth_2505 VNB|VSS VDD VNB|VSS
+ sky130_fd_sc_hd__nor2_1
X$12828 VDD synth_10312 synth_11993 synth_11932 VNB|VSS VDD VNB|VSS
+ sky130_fd_sc_hd__nor2_1
X$12829 VDD synth_1467 synth_5138 synth_7565 VNB|VSS VDD VNB|VSS
+ sky130_fd_sc_hd__nor2_1
X$12830 VDD synth_10940 synth_10440 synth_11010 VNB|VSS VDD VNB|VSS
+ sky130_fd_sc_hd__nor2_1
X$12831 VDD synth_7345 synth_7676 synth_7607 VNB|VSS VDD VNB|VSS
+ sky130_fd_sc_hd__nor2_1
X$12832 VDD synth_877 synth_7777 synth_7993 VNB|VSS VDD VNB|VSS
+ sky130_fd_sc_hd__nor2_1
X$12833 VDD synth_1125 synth_5138 synth_7388 VNB|VSS VDD VNB|VSS
+ sky130_fd_sc_hd__nor2_1
X$12834 VDD synth_9525 synth_8768 synth_9715 VNB|VSS VDD VNB|VSS
+ sky130_fd_sc_hd__nor2_1
X$12835 VDD synth_7000 synth_560 synth_7617 VNB|VSS VDD VNB|VSS
+ sky130_fd_sc_hd__nor2_1
X$12836 VDD synth_1081 synth_3038 synth_3037 VNB|VSS VDD VNB|VSS
+ sky130_fd_sc_hd__nor2_1
X$12837 VDD synth_3014 synth_3037 synth_3093 VNB|VSS VDD VNB|VSS
+ sky130_fd_sc_hd__nor2_1
X$12838 VDD synth_2335 synth_2575 synth_2697 VNB|VSS VDD VNB|VSS
+ sky130_fd_sc_hd__nor2_1
X$12839 VDD synth_6007 synth_6006 synth_6008 VNB|VSS VDD VNB|VSS
+ sky130_fd_sc_hd__nor2_1
X$12840 VDD synth_877 synth_7819 synth_10748 VNB|VSS VDD VNB|VSS
+ sky130_fd_sc_hd__nor2_1
X$12841 VDD synth_510 synth_4936 synth_4987 VNB|VSS VDD VNB|VSS
+ sky130_fd_sc_hd__nor2_1
X$12842 VDD synth_9019 synth_9130 synth_9080 VNB|VSS VDD VNB|VSS
+ sky130_fd_sc_hd__nor2_1
X$12843 VDD synth_4936 synth_580 synth_4932 VNB|VSS VDD VNB|VSS
+ sky130_fd_sc_hd__nor2_1
X$12844 VDD synth_570 synth_510 synth_533 VNB|VSS VDD VNB|VSS
+ sky130_fd_sc_hd__nor2_1
X$12845 VDD synth_10186 synth_10107 synth_10185 VNB|VSS VDD VNB|VSS
+ sky130_fd_sc_hd__nor2_1
X$12846 VDD synth_7940 synth_7965 synth_7966 VNB|VSS VDD VNB|VSS
+ sky130_fd_sc_hd__nor2_1
X$12847 VDD synth_513 synth_3107 synth_3302 VNB|VSS VDD VNB|VSS
+ sky130_fd_sc_hd__nor2_1
X$12848 VDD synth_358 synth_298 synth_685 VNB|VSS VDD VNB|VSS
+ sky130_fd_sc_hd__nor2_1
X$12849 VDD synth_580 synth_2431 synth_2300 VNB|VSS VDD VNB|VSS
+ sky130_fd_sc_hd__nor2_1
X$12850 VDD synth_513 synth_7780 synth_12047 VNB|VSS VDD VNB|VSS
+ sky130_fd_sc_hd__nor2_1
X$12851 VDD synth_6302 synth_6303 synth_6157 VNB|VSS VDD VNB|VSS
+ sky130_fd_sc_hd__nor2_1
X$12852 VDD synth_3232 synth_3109 synth_3379 VNB|VSS VDD VNB|VSS
+ sky130_fd_sc_hd__nor2_1
X$12853 VDD synth_4936 synth_1125 synth_6196 VNB|VSS VDD VNB|VSS
+ sky130_fd_sc_hd__nor2_1
X$12854 VDD synth_1456 synth_570 synth_1205 VNB|VSS VDD VNB|VSS
+ sky130_fd_sc_hd__nor2_1
X$12855 VDD synth_514 synth_1467 synth_1184 VNB|VSS VDD VNB|VSS
+ sky130_fd_sc_hd__nor2_1
X$12856 VDD synth_1070 synth_5129 synth_6015 VNB|VSS VDD VNB|VSS
+ sky130_fd_sc_hd__nor2_1
X$12857 VDD synth_1070 synth_550 synth_1534 VNB|VSS VDD VNB|VSS
+ sky130_fd_sc_hd__nor2_1
X$12858 VDD synth_10951 synth_11022 synth_11043 VNB|VSS VDD VNB|VSS
+ sky130_fd_sc_hd__nor2_1
X$12859 VDD synth_11022 synth_11041 synth_11114 VNB|VSS VDD VNB|VSS
+ sky130_fd_sc_hd__nor2_1
X$12860 VDD synth_10911 synth_11056 synth_11243 VNB|VSS VDD VNB|VSS
+ sky130_fd_sc_hd__nor2_1
X$12861 VDD synth_9474 synth_9513 synth_12028 VNB|VSS VDD VNB|VSS
+ sky130_fd_sc_hd__nor2_1
X$12862 VDD synth_1704 synth_1705 synth_2149 VNB|VSS VDD VNB|VSS
+ sky130_fd_sc_hd__nor2_1
X$12863 VDD synth_831 synth_917 synth_1079 VNB|VSS VDD VNB|VSS
+ sky130_fd_sc_hd__nor2_1
X$12864 VDD synth_9049 synth_10635 synth_11511 VNB|VSS VDD VNB|VSS
+ sky130_fd_sc_hd__nor2_1
X$12865 VDD synth_9232 synth_9695 synth_11247 VNB|VSS VDD VNB|VSS
+ sky130_fd_sc_hd__nor2_1
X$12866 VDD synth_10767 synth_10842 synth_11059 VNB|VSS VDD VNB|VSS
+ sky130_fd_sc_hd__nor2_1
X$12867 VDD synth_3040 synth_2952 synth_3038 VNB|VSS VDD VNB|VSS
+ sky130_fd_sc_hd__nor2_1
X$12868 VDD synth_11158 synth_11245 synth_11244 VNB|VSS VDD VNB|VSS
+ sky130_fd_sc_hd__nor2_1
X$12869 VDD synth_3527 synth_4414 synth_4436 VNB|VSS VDD VNB|VSS
+ sky130_fd_sc_hd__nor2_1
X$12870 VDD synth_10319 synth_10318 synth_10183 VNB|VSS VDD VNB|VSS
+ sky130_fd_sc_hd__nor2_1
X$12871 VDD synth_1711 synth_6636 synth_7110 VNB|VSS VDD VNB|VSS
+ sky130_fd_sc_hd__nor2_1
X$12872 VDD synth_4439 synth_4589 synth_4414 VNB|VSS VDD VNB|VSS
+ sky130_fd_sc_hd__nor2_1
X$12873 VDD synth_11665 synth_11505 synth_11778 VNB|VSS VDD VNB|VSS
+ sky130_fd_sc_hd__nor2_1
X$12874 VDD synth_629 synth_522 synth_841 VNB|VSS VDD VNB|VSS
+ sky130_fd_sc_hd__nor2_1
X$12875 VDD synth_3836 synth_3931 synth_4060 VNB|VSS VDD VNB|VSS
+ sky130_fd_sc_hd__nor2_1
X$12876 VDD synth_4280 synth_4099 synth_4282 VNB|VSS VDD VNB|VSS
+ sky130_fd_sc_hd__nor2_1
X$12877 VDD synth_9603 synth_8768 synth_9537 VNB|VSS VDD VNB|VSS
+ sky130_fd_sc_hd__nor2_1
X$12878 VDD synth_4075 synth_4242 synth_4574 VNB|VSS VDD VNB|VSS
+ sky130_fd_sc_hd__nor2_1
X$12879 VDD synth_3639 synth_3636 synth_3947 VNB|VSS VDD VNB|VSS
+ sky130_fd_sc_hd__nor2_1
X$12880 VDD synth_560 synth_5129 synth_4953 VNB|VSS VDD VNB|VSS
+ sky130_fd_sc_hd__nor2_1
X$12881 VDD synth_510 synth_7780 synth_11380 VNB|VSS VDD VNB|VSS
+ sky130_fd_sc_hd__nor2_1
X$12882 VDD synth_11671 synth_11670 synth_11668 VNB|VSS VDD VNB|VSS
+ sky130_fd_sc_hd__nor2_1
X$12883 VDD synth_7601 synth_7590 synth_8021 VNB|VSS VDD VNB|VSS
+ sky130_fd_sc_hd__nor2_1
X$12884 VDD synth_8805 synth_9008 synth_9034 VNB|VSS VDD VNB|VSS
+ sky130_fd_sc_hd__nor2_1
X$12885 VDD synth_1081 synth_482 synth_1120 VNB|VSS VDD VNB|VSS
+ sky130_fd_sc_hd__nor2_1
X$12886 VDD synth_939 synth_7780 synth_10913 VNB|VSS VDD VNB|VSS
+ sky130_fd_sc_hd__nor2_1
X$12887 VDD synth_7939 synth_8177 synth_8210 VNB|VSS VDD VNB|VSS
+ sky130_fd_sc_hd__nor2_1
X$12888 VDD synth_1094 synth_3107 synth_3214 VNB|VSS VDD VNB|VSS
+ sky130_fd_sc_hd__nor2_1
X$12889 VDD synth_995 synth_550 synth_1385 VNB|VSS VDD VNB|VSS
+ sky130_fd_sc_hd__nor2_1
X$12890 VDD synth_2757 synth_2879 synth_2878 VNB|VSS VDD VNB|VSS
+ sky130_fd_sc_hd__nor2_1
X$12891 VDD synth_10324 synth_10244 synth_10326 VNB|VSS VDD VNB|VSS
+ sky130_fd_sc_hd__nor2_1
X$12892 VDD synth_1144 synth_1461 synth_1382 VNB|VSS VDD VNB|VSS
+ sky130_fd_sc_hd__nor2_1
X$12893 VDD synth_513 synth_2713 synth_2715 VNB|VSS VDD VNB|VSS
+ sky130_fd_sc_hd__nor2_1
X$12894 VDD synth_10952 synth_11556 synth_11554 VNB|VSS VDD VNB|VSS
+ sky130_fd_sc_hd__nor2_1
X$12895 VDD synth_9589 synth_9946 synth_10031 VNB|VSS VDD VNB|VSS
+ sky130_fd_sc_hd__nor2_1
X$12896 VDD synth_9589 synth_9781 synth_9803 VNB|VSS VDD VNB|VSS
+ sky130_fd_sc_hd__nor2_1
X$12897 VDD synth_6469 synth_8124 synth_8202 VNB|VSS VDD VNB|VSS
+ sky130_fd_sc_hd__nor2_1
X$12898 VDD synth_8954 synth_9438 synth_9541 VNB|VSS VDD VNB|VSS
+ sky130_fd_sc_hd__nor2_1
X$12899 VDD synth_8812 synth_8887 synth_8894 VNB|VSS VDD VNB|VSS
+ sky130_fd_sc_hd__nor2_1
X$12900 VDD synth_1945 synth_2034 synth_2001 VNB|VSS VDD VNB|VSS
+ sky130_fd_sc_hd__nor2_1
X$12901 VDD synth_8910 synth_8918 synth_9041 VNB|VSS VDD VNB|VSS
+ sky130_fd_sc_hd__nor2_1
X$12902 VDD synth_8091 synth_8249 synth_8177 VNB|VSS VDD VNB|VSS
+ sky130_fd_sc_hd__nor2_1
X$12903 VDD synth_6061 synth_6220 synth_5798 VNB|VSS VDD VNB|VSS
+ sky130_fd_sc_hd__nor2_1
X$12904 VDD synth_11815 synth_11865 synth_11816 VNB|VSS VDD VNB|VSS
+ sky130_fd_sc_hd__nor2_1
X$12905 VDD synth_1467 synth_7780 synth_12166 VNB|VSS VDD VNB|VSS
+ sky130_fd_sc_hd__nor2_1
X$12906 VDD synth_768 synth_841 synth_843 VNB|VSS VDD VNB|VSS
+ sky130_fd_sc_hd__nor2_1
X$12907 VDD synth_11236 synth_11303 synth_11073 VNB|VSS VDD VNB|VSS
+ sky130_fd_sc_hd__nor2_1
X$12908 VDD synth_1467 synth_6636 synth_7730 VNB|VSS VDD VNB|VSS
+ sky130_fd_sc_hd__nor2_1
X$12909 VDD synth_8644 synth_8643 synth_8726 VNB|VSS VDD VNB|VSS
+ sky130_fd_sc_hd__nor2_1
X$12910 VDD synth_560 synth_7780 synth_11421 VNB|VSS VDD VNB|VSS
+ sky130_fd_sc_hd__nor2_1
X$12911 VDD synth_7345 synth_7284 synth_7283 VNB|VSS VDD VNB|VSS
+ sky130_fd_sc_hd__nor2_1
X$12912 VDD synth_4104 synth_4244 synth_4246 VNB|VSS VDD VNB|VSS
+ sky130_fd_sc_hd__nor2_1
X$12913 VDD synth_4109 synth_4033 synth_4106 VNB|VSS VDD VNB|VSS
+ sky130_fd_sc_hd__nor2_1
X$12914 VDD synth_10578 synth_9700 synth_11091 VNB|VSS VDD VNB|VSS
+ sky130_fd_sc_hd__nor2_1
X$12915 VDD synth_11392 synth_11775 synth_11952 VNB|VSS VDD VNB|VSS
+ sky130_fd_sc_hd__nor2_1
X$12916 VDD synth_4104 synth_4193 synth_4195 VNB|VSS VDD VNB|VSS
+ sky130_fd_sc_hd__nor2_1
X$12917 VDD synth_513 synth_514 synth_751 VNB|VSS VDD VNB|VSS
+ sky130_fd_sc_hd__nor2_1
X$12918 VDD synth_8196 synth_8581 synth_8721 VNB|VSS VDD VNB|VSS
+ sky130_fd_sc_hd__nor2_1
X$12919 VDD synth_3964 synth_4195 synth_4101 VNB|VSS VDD VNB|VSS
+ sky130_fd_sc_hd__nor2_1
X$12920 VDD synth_647 synth_7780 synth_10273 VNB|VSS VDD VNB|VSS
+ sky130_fd_sc_hd__nor2_1
X$12921 VDD synth_346 synth_275 synth_487 VNB|VSS VDD VNB|VSS
+ sky130_fd_sc_hd__nor2_1
X$12922 VDD synth_1622 synth_1635 synth_1924 VNB|VSS VDD VNB|VSS
+ sky130_fd_sc_hd__nor2_1
X$12923 VDD synth_9641 synth_9186 synth_9597 VNB|VSS VDD VNB|VSS
+ sky130_fd_sc_hd__nor2_1
X$12924 VDD synth_4041 synth_4051 synth_4139 VNB|VSS VDD VNB|VSS
+ sky130_fd_sc_hd__nor2_1
X$12925 VDD synth_8811 synth_8887 synth_9023 VNB|VSS VDD VNB|VSS
+ sky130_fd_sc_hd__nor2_1
X$12926 VDD synth_560 synth_5138 synth_5290 VNB|VSS VDD VNB|VSS
+ sky130_fd_sc_hd__nor2_1
X$12927 VDD synth_10256 synth_10184 synth_9872 VNB|VSS VDD VNB|VSS
+ sky130_fd_sc_hd__nor2_1
X$12928 VDD synth_2807 synth_877 synth_4120 VNB|VSS VDD VNB|VSS
+ sky130_fd_sc_hd__nor2_1
X$12929 VDD synth_7582 synth_7581 synth_7764 VNB|VSS VDD VNB|VSS
+ sky130_fd_sc_hd__nor2_1
X$12930 VDD synth_514 synth_1125 synth_911 VNB|VSS VDD VNB|VSS
+ sky130_fd_sc_hd__nor2_1
X$12931 VDD synth_7580 synth_7554 synth_7700 VNB|VSS VDD VNB|VSS
+ sky130_fd_sc_hd__nor2_1
X$12932 VDD synth_1070 synth_2431 synth_4321 VNB|VSS VDD VNB|VSS
+ sky130_fd_sc_hd__nor2_1
X$12933 VDD synth_5796 synth_5731 synth_5931 VNB|VSS VDD VNB|VSS
+ sky130_fd_sc_hd__nor2_1
X$12934 VDD synth_1533 synth_1532 synth_1595 VNB|VSS VDD VNB|VSS
+ sky130_fd_sc_hd__nor2_1
X$12935 VDD synth_10022 synth_10028 synth_10186 VNB|VSS VDD VNB|VSS
+ sky130_fd_sc_hd__nor2_1
X$12936 VDD synth_6211 synth_7764 synth_7731 VNB|VSS VDD VNB|VSS
+ sky130_fd_sc_hd__nor2_1
X$12937 VDD synth_11350 synth_11372 synth_11370 VNB|VSS VDD VNB|VSS
+ sky130_fd_sc_hd__nor2_1
X$12938 VDD synth_5846 synth_5882 synth_6134 VNB|VSS VDD VNB|VSS
+ sky130_fd_sc_hd__nor2_1
X$12939 VDD synth_1530 synth_1531 synth_1532 VNB|VSS VDD VNB|VSS
+ sky130_fd_sc_hd__nor2_1
X$12940 VDD synth_9947 synth_10028 synth_10249 VNB|VSS VDD VNB|VSS
+ sky130_fd_sc_hd__nor2_1
X$12941 VDD synth_1070 synth_5138 synth_6022 VNB|VSS VDD VNB|VSS
+ sky130_fd_sc_hd__nor2_1
X$12942 VDD synth_1720 synth_1619 synth_1881 VNB|VSS VDD VNB|VSS
+ sky130_fd_sc_hd__nor2_1
X$12943 VDD synth_2840 synth_2873 synth_3094 VNB|VSS VDD VNB|VSS
+ sky130_fd_sc_hd__nor2_1
X$12944 VDD synth_510 synth_6636 synth_6460 VNB|VSS VDD VNB|VSS
+ sky130_fd_sc_hd__nor2_1
X$12945 VDD synth_6636 synth_1827 synth_8057 VNB|VSS VDD VNB|VSS
+ sky130_fd_sc_hd__nor2_1
X$12946 VDD synth_10028 synth_9019 synth_10194 VNB|VSS VDD VNB|VSS
+ sky130_fd_sc_hd__nor2_1
X$12947 VDD synth_939 synth_7777 synth_8346 VNB|VSS VDD VNB|VSS
+ sky130_fd_sc_hd__nor2_1
X$12948 VDD synth_11392 synth_11712 synth_11776 VNB|VSS VDD VNB|VSS
+ sky130_fd_sc_hd__nor2_1
X$12949 VDD synth_939 synth_5129 synth_5432 VNB|VSS VDD VNB|VSS
+ sky130_fd_sc_hd__nor2_1
X$12950 VDD synth_647 synth_2807 synth_3972 VNB|VSS VDD VNB|VSS
+ sky130_fd_sc_hd__nor2_1
X$12951 VDD synth_9785 synth_9186 synth_9786 VNB|VSS VDD VNB|VSS
+ sky130_fd_sc_hd__nor2_1
X$12952 VDD synth_9186 synth_9345 synth_9346 VNB|VSS VDD VNB|VSS
+ sky130_fd_sc_hd__nor2_1
X$12953 VDD synth_1711 synth_2431 synth_2616 VNB|VSS VDD VNB|VSS
+ sky130_fd_sc_hd__nor2_1
X$12954 VDD synth_8187 synth_8097 synth_8204 VNB|VSS VDD VNB|VSS
+ sky130_fd_sc_hd__nor2_1
X$12955 VDD synth_7655 synth_7700 synth_7763 VNB|VSS VDD VNB|VSS
+ sky130_fd_sc_hd__nor2_1
X$12956 VDD synth_9292 synth_10003 synth_9907 VNB|VSS VDD VNB|VSS
+ sky130_fd_sc_hd__nor2_1
X$12957 VDD synth_342 synth_86 synth_212 VNB|VSS VDD VNB|VSS
+ sky130_fd_sc_hd__nor2_1
X$12958 VDD synth_9292 synth_9474 synth_11590 VNB|VSS VDD VNB|VSS
+ sky130_fd_sc_hd__nor2_1
X$12959 VDD synth_9589 synth_9588 synth_9719 VNB|VSS VDD VNB|VSS
+ sky130_fd_sc_hd__nor2_1
X$12960 VDD synth_9019 synth_9018 synth_8342 VNB|VSS VDD VNB|VSS
+ sky130_fd_sc_hd__nor2_1
X$12961 VDD synth_2336 synth_2477 synth_2476 VNB|VSS VDD VNB|VSS
+ sky130_fd_sc_hd__nor2_1
X$12962 VDD synth_9873 synth_10456 synth_10457 VNB|VSS VDD VNB|VSS
+ sky130_fd_sc_hd__nor2_1
X$12963 VDD synth_5989 synth_6157 synth_6272 VNB|VSS VDD VNB|VSS
+ sky130_fd_sc_hd__nor2_1
X$12964 VDD synth_4750 synth_4620 synth_4777 VNB|VSS VDD VNB|VSS
+ sky130_fd_sc_hd__nor2_1
X$12965 VDD synth_9019 synth_9136 synth_9135 VNB|VSS VDD VNB|VSS
+ sky130_fd_sc_hd__nor2_1
X$12966 VDD synth_10022 synth_10023 synth_10455 VNB|VSS VDD VNB|VSS
+ sky130_fd_sc_hd__nor2_1
X$12967 VDD synth_6595 synth_6291 synth_6711 VNB|VSS VDD VNB|VSS
+ sky130_fd_sc_hd__nor2_1
X$12968 VDD synth_9947 synth_10023 synth_10184 VNB|VSS VDD VNB|VSS
+ sky130_fd_sc_hd__nor2_1
X$12969 VDD synth_4936 synth_560 synth_5454 VNB|VSS VDD VNB|VSS
+ sky130_fd_sc_hd__nor2_1
X$12970 VDD synth_6615 synth_6691 synth_6690 VNB|VSS VDD VNB|VSS
+ sky130_fd_sc_hd__nor2_1
X$12971 VDD synth_7745 synth_7611 synth_7888 VNB|VSS VDD VNB|VSS
+ sky130_fd_sc_hd__nor2_1
X$12972 VDD synth_8954 synth_9197 synth_9454 VNB|VSS VDD VNB|VSS
+ sky130_fd_sc_hd__nor2_1
X$12973 VDD synth_1711 synth_7819 synth_11885 VNB|VSS VDD VNB|VSS
+ sky130_fd_sc_hd__nor2_1
X$12974 VDD synth_9873 synth_10522 synth_10393 VNB|VSS VDD VNB|VSS
+ sky130_fd_sc_hd__nor2_1
X$12975 VDD synth_6683 synth_6872 synth_6816 VNB|VSS VDD VNB|VSS
+ sky130_fd_sc_hd__nor2_1
X$12976 VDD synth_9434 synth_8981 synth_10862 VNB|VSS VDD VNB|VSS
+ sky130_fd_sc_hd__nor2_1
X$12977 VDD synth_1711 synth_570 synth_2132 VNB|VSS VDD VNB|VSS
+ sky130_fd_sc_hd__nor2_1
X$12978 VDD synth_513 synth_2807 synth_2756 VNB|VSS VDD VNB|VSS
+ sky130_fd_sc_hd__nor2_1
X$12979 VDD synth_510 synth_7777 synth_8507 VNB|VSS VDD VNB|VSS
+ sky130_fd_sc_hd__nor2_1
X$12980 VDD synth_12310 synth_12206 synth_12331 VNB|VSS VDD VNB|VSS
+ sky130_fd_sc_hd__nor2_1
X$12981 VDD synth_11149 synth_11148 synth_11412 VNB|VSS VDD VNB|VSS
+ sky130_fd_sc_hd__nor2_1
X$12982 VDD synth_9186 synth_9596 synth_9788 VNB|VSS VDD VNB|VSS
+ sky130_fd_sc_hd__nor2_1
X$12983 VDD synth_9474 synth_8870 synth_10307 VNB|VSS VDD VNB|VSS
+ sky130_fd_sc_hd__nor2_1
X$12984 VDD synth_8803 synth_8946 synth_12096 VNB|VSS VDD VNB|VSS
+ sky130_fd_sc_hd__nor2_1
X$12985 VDD synth_514 synth_580 synth_381 VNB|VSS VDD VNB|VSS
+ sky130_fd_sc_hd__nor2_1
X$12986 VDD synth_2105 synth_2104 synth_2144 VNB|VSS VDD VNB|VSS
+ sky130_fd_sc_hd__nor2_1
X$12987 VDD synth_9220 synth_9375 synth_9278 VNB|VSS VDD VNB|VSS
+ sky130_fd_sc_hd__nor2_1
X$12988 VDD synth_10819 synth_10852 synth_11348 VNB|VSS VDD VNB|VSS
+ sky130_fd_sc_hd__nor2_1
X$12989 VDD synth_939 synth_2431 synth_2684 VNB|VSS VDD VNB|VSS
+ sky130_fd_sc_hd__nor2_1
X$12990 VDD synth_6636 synth_1125 synth_8006 VNB|VSS VDD VNB|VSS
+ sky130_fd_sc_hd__nor2_1
X$12991 VDD synth_7789 synth_7731 synth_7767 VNB|VSS VDD VNB|VSS
+ sky130_fd_sc_hd__nor2_1
X$12992 VDD synth_10256 synth_10252 synth_10673 VNB|VSS VDD VNB|VSS
+ sky130_fd_sc_hd__nor2_1
X$12993 VDD synth_10863 synth_10169 synth_10797 VNB|VSS VDD VNB|VSS
+ sky130_fd_sc_hd__nor2_1
X$12994 VDD synth_10023 synth_10520 synth_10676 VNB|VSS VDD VNB|VSS
+ sky130_fd_sc_hd__nor2_1
X$12995 VDD synth_9589 synth_9657 synth_9809 VNB|VSS VDD VNB|VSS
+ sky130_fd_sc_hd__nor2_1
X$12996 VDD synth_6469 synth_7346 synth_7430 VNB|VSS VDD VNB|VSS
+ sky130_fd_sc_hd__nor2_1
X$12997 VDD synth_11940 synth_12320 synth_12322 VNB|VSS VDD VNB|VSS
+ sky130_fd_sc_hd__nor2_1
X$12998 VDD synth_10930 synth_11191 synth_11296 VNB|VSS VDD VNB|VSS
+ sky130_fd_sc_hd__nor2_1
X$12999 VDD synth_12310 synth_12329 synth_12328 VNB|VSS VDD VNB|VSS
+ sky130_fd_sc_hd__nor2_1
X$13000 VDD synth_877 synth_5138 synth_5448 VNB|VSS VDD VNB|VSS
+ sky130_fd_sc_hd__nor2_1
X$13001 VDD synth_8768 synth_9196 synth_9137 VNB|VSS VDD VNB|VSS
+ sky130_fd_sc_hd__nor2_1
X$13002 VDD synth_7214 synth_7270 synth_7280 VNB|VSS VDD VNB|VSS
+ sky130_fd_sc_hd__nor2_1
X$13003 VDD synth_514 synth_647 synth_1639 VNB|VSS VDD VNB|VSS
+ sky130_fd_sc_hd__nor2_1
X$13004 VDD synth_1070 synth_7780 synth_10709 VNB|VSS VDD VNB|VSS
+ sky130_fd_sc_hd__nor2_1
X$13005 VDD synth_9629 synth_10212 synth_12306 VNB|VSS VDD VNB|VSS
+ sky130_fd_sc_hd__nor2_1
X$13006 VDD synth_7345 synth_7503 synth_7605 VNB|VSS VDD VNB|VSS
+ sky130_fd_sc_hd__nor2_1
X$13007 VDD synth_11068 synth_10941 synth_9770 VNB|VSS VDD VNB|VSS
+ sky130_fd_sc_hd__nor2_1
X$13008 VDD synth_11162 synth_11163 synth_11135 VNB|VSS VDD VNB|VSS
+ sky130_fd_sc_hd__nor2_1
X$13009 VDD synth_9589 synth_10019 synth_10134 VNB|VSS VDD VNB|VSS
+ sky130_fd_sc_hd__nor2_1
X$13010 VDD synth_995 synth_2713 synth_3782 VNB|VSS VDD VNB|VSS
+ sky130_fd_sc_hd__nor2_1
X$13011 VDD synth_2086 synth_2207 synth_2346 VNB|VSS VDD VNB|VSS
+ sky130_fd_sc_hd__nor2_1
X$13012 VDD synth_939 synth_5138 synth_5974 VNB|VSS VDD VNB|VSS
+ sky130_fd_sc_hd__nor2_1
X$13013 VDD synth_888 synth_904 synth_1116 VNB|VSS VDD VNB|VSS
+ sky130_fd_sc_hd__nor2_1
X$13014 VDD synth_939 synth_7819 synth_11880 VNB|VSS VDD VNB|VSS
+ sky130_fd_sc_hd__nor2_1
X$13015 VDD synth_9571 synth_9548 synth_9608 VNB|VSS VDD VNB|VSS
+ sky130_fd_sc_hd__nor2_1
X$13016 VDD synth_8475 synth_8554 synth_8393 VNB|VSS VDD VNB|VSS
+ sky130_fd_sc_hd__nor2_1
X$13017 VDD synth_4222 synth_4288 synth_4371 VNB|VSS VDD VNB|VSS
+ sky130_fd_sc_hd__nor2_1
X$13018 VDD synth_11940 synth_12248 synth_12250 VNB|VSS VDD VNB|VSS
+ sky130_fd_sc_hd__nor2_1
X$13019 VDD synth_9499 synth_9571 synth_9607 VNB|VSS VDD VNB|VSS
+ sky130_fd_sc_hd__nor2_1
X$13020 VDD synth_514 synth_877 synth_2269 VNB|VSS VDD VNB|VSS
+ sky130_fd_sc_hd__nor2_1
X$13021 VDD synth_1827 synth_2713 synth_4479 VNB|VSS VDD VNB|VSS
+ sky130_fd_sc_hd__nor2_1
X$13022 VDD synth_9101 synth_9817 synth_9816 VNB|VSS VDD VNB|VSS
+ sky130_fd_sc_hd__nor2_1
X$13023 VDD synth_34 synth_225 synth_155 VNB|VSS VDD VNB|VSS
+ sky130_fd_sc_hd__nor2_1
X$13024 VDD synth_10013 synth_10105 synth_10014 VNB|VSS VDD VNB|VSS
+ sky130_fd_sc_hd__nor2_1
X$13025 VDD synth_1456 synth_550 synth_940 VNB|VSS VDD VNB|VSS
+ sky130_fd_sc_hd__nor2_1
X$13026 VDD synth_9292 synth_8764 synth_9428 VNB|VSS VDD VNB|VSS
+ sky130_fd_sc_hd__nor2_1
X$13027 VDD synth_11022 synth_11548 synth_11557 VNB|VSS VDD VNB|VSS
+ sky130_fd_sc_hd__nor2_1
X$13028 VDD synth_1467 synth_509 synth_2913 VNB|VSS VDD VNB|VSS
+ sky130_fd_sc_hd__nor2_1
X$13029 VDD synth_4936 synth_1827 synth_6301 VNB|VSS VDD VNB|VSS
+ sky130_fd_sc_hd__nor2_1
X$13030 VDD synth_10259 synth_10316 synth_10470 VNB|VSS VDD VNB|VSS
+ sky130_fd_sc_hd__nor2_1
X$13031 VDD synth_10451 synth_10454 synth_10474 VNB|VSS VDD VNB|VSS
+ sky130_fd_sc_hd__nor2_1
X$13032 VDD synth_6696 synth_6694 synth_6704 VNB|VSS VDD VNB|VSS
+ sky130_fd_sc_hd__nor2_1
X$13033 VDD synth_10478 synth_10539 synth_10454 VNB|VSS VDD VNB|VSS
+ sky130_fd_sc_hd__nor2_1
X$13034 VDD synth_4936 synth_545 synth_4976 VNB|VSS VDD VNB|VSS
+ sky130_fd_sc_hd__nor2_1
X$13035 VDD synth_9773 synth_9854 synth_9974 VNB|VSS VDD VNB|VSS
+ sky130_fd_sc_hd__nor2_1
X$13036 VDD synth_514 synth_995 synth_1219 VNB|VSS VDD VNB|VSS
+ sky130_fd_sc_hd__nor2_1
X$13037 VDD synth_7938 synth_8141 synth_8050 VNB|VSS VDD VNB|VSS
+ sky130_fd_sc_hd__nor2_1
X$13038 VDD synth_995 synth_6636 synth_8045 VNB|VSS VDD VNB|VSS
+ sky130_fd_sc_hd__nor2_1
X$13039 VDD synth_647 synth_7819 synth_9874 VNB|VSS VDD VNB|VSS
+ sky130_fd_sc_hd__nor2_1
X$13040 VDD synth_10212 synth_9927 synth_12410 VNB|VSS VDD VNB|VSS
+ sky130_fd_sc_hd__nor2_1
X$13041 VDD synth_8287 synth_8394 synth_8422 VNB|VSS VDD VNB|VSS
+ sky130_fd_sc_hd__nor2_1
X$13042 VDD synth_11392 synth_11469 synth_11417 VNB|VSS VDD VNB|VSS
+ sky130_fd_sc_hd__nor2_1
X$13043 VDD synth_9019 synth_10530 synth_10736 VNB|VSS VDD VNB|VSS
+ sky130_fd_sc_hd__nor2_1
X$13044 VDD synth_12314 synth_12313 synth_12323 VNB|VSS VDD VNB|VSS
+ sky130_fd_sc_hd__nor2_1
X$13045 VDD synth_7327 synth_7471 synth_7553 VNB|VSS VDD VNB|VSS
+ sky130_fd_sc_hd__nor2_1
X$13046 VDD synth_1456 synth_509 synth_1584 VNB|VSS VDD VNB|VSS
+ sky130_fd_sc_hd__nor2_1
X$13047 VDD synth_7108 synth_7107 synth_7180 VNB|VSS VDD VNB|VSS
+ sky130_fd_sc_hd__nor2_1
X$13048 VDD synth_8806 synth_11504 synth_11636 VNB|VSS VDD VNB|VSS
+ sky130_fd_sc_hd__nor2_1
X$13049 VDD synth_647 synth_2713 synth_3416 VNB|VSS VDD VNB|VSS
+ sky130_fd_sc_hd__nor2_1
X$13050 VDD synth_8287 synth_8328 synth_8327 VNB|VSS VDD VNB|VSS
+ sky130_fd_sc_hd__nor2_1
X$13051 VDD synth_2807 synth_995 synth_3184 VNB|VSS VDD VNB|VSS
+ sky130_fd_sc_hd__nor2_1
X$13052 VDD synth_1467 synth_2807 synth_5620 VNB|VSS VDD VNB|VSS
+ sky130_fd_sc_hd__nor2_1
X$13053 VDD synth_9873 synth_10740 synth_10805 VNB|VSS VDD VNB|VSS
+ sky130_fd_sc_hd__nor2_1
X$13054 VDD synth_7266 synth_7267 synth_7360 VNB|VSS VDD VNB|VSS
+ sky130_fd_sc_hd__nor2_1
X$13055 VDD synth_6140 synth_6506 synth_6442 VNB|VSS VDD VNB|VSS
+ sky130_fd_sc_hd__nor2_1
X$13056 VDD synth_1094 synth_5129 synth_7714 VNB|VSS VDD VNB|VSS
+ sky130_fd_sc_hd__nor2_1
X$13057 VDD synth_8322 synth_8323 synth_8086 VNB|VSS VDD VNB|VSS
+ sky130_fd_sc_hd__nor2_1
X$13058 VDD synth_1456 synth_4936 synth_5255 VNB|VSS VDD VNB|VSS
+ sky130_fd_sc_hd__nor2_1
X$13059 VDD synth_514 synth_560 synth_1117 VNB|VSS VDD VNB|VSS
+ sky130_fd_sc_hd__nor2_1
X$13060 VDD synth_3830 synth_3831 synth_3968 VNB|VSS VDD VNB|VSS
+ sky130_fd_sc_hd__nor2_1
X$13061 VDD synth_5945 synth_5944 synth_6332 VNB|VSS VDD VNB|VSS
+ sky130_fd_sc_hd__nor2_1
X$13062 VDD synth_3519 synth_3432 synth_4153 VNB|VSS VDD VNB|VSS
+ sky130_fd_sc_hd__nor2_1
X$13063 VDD synth_8250 synth_8712 synth_8776 VNB|VSS VDD VNB|VSS
+ sky130_fd_sc_hd__nor2_1
X$13064 VDD synth_514 synth_1827 synth_1643 VNB|VSS VDD VNB|VSS
+ sky130_fd_sc_hd__nor2_1
X$13065 VDD synth_510 synth_2807 synth_3181 VNB|VSS VDD VNB|VSS
+ sky130_fd_sc_hd__nor2_1
X$13066 VDD synth_2807 synth_560 synth_3204 VNB|VSS VDD VNB|VSS
+ sky130_fd_sc_hd__nor2_1
X$13067 VDD synth_11392 synth_11396 synth_11493 VNB|VSS VDD VNB|VSS
+ sky130_fd_sc_hd__nor2_1
X$13068 VDD synth_6636 synth_580 synth_7034 VNB|VSS VDD VNB|VSS
+ sky130_fd_sc_hd__nor2_1
X$13069 VDD synth_8326 synth_8393 synth_8394 VNB|VSS VDD VNB|VSS
+ sky130_fd_sc_hd__nor2_1
X$13070 VDD synth_10316 synth_10317 synth_10390 VNB|VSS VDD VNB|VSS
+ sky130_fd_sc_hd__nor2_1
X$13071 VDD synth_11397 synth_11395 synth_11415 VNB|VSS VDD VNB|VSS
+ sky130_fd_sc_hd__nor2_1
X$13072 VDD synth_10449 synth_11174 synth_11118 VNB|VSS VDD VNB|VSS
+ sky130_fd_sc_hd__nor2_1
X$13073 VDD synth_838 synth_926 synth_1006 VNB|VSS VDD VNB|VSS
+ sky130_fd_sc_hd__nor2_1
X$13074 VDD synth_2001 synth_2232 synth_2233 VNB|VSS VDD VNB|VSS
+ sky130_fd_sc_hd__nor2_1
X$13075 VDD synth_4398 synth_4139 synth_4550 VNB|VSS VDD VNB|VSS
+ sky130_fd_sc_hd__nor2_1
X$13076 VDD synth_10097 synth_11812 synth_11908 VNB|VSS VDD VNB|VSS
+ sky130_fd_sc_hd__nor2_1
X$13077 VDD synth_570 synth_877 synth_1215 VNB|VSS VDD VNB|VSS
+ sky130_fd_sc_hd__nor2_1
X$13078 VDD synth_8564 synth_8109 synth_8572 VNB|VSS VDD VNB|VSS
+ sky130_fd_sc_hd__nor2_1
X$13079 VDD synth_4936 synth_995 synth_5815 VNB|VSS VDD VNB|VSS
+ sky130_fd_sc_hd__nor2_1
X$13080 VDD synth_1827 synth_2431 synth_2871 VNB|VSS VDD VNB|VSS
+ sky130_fd_sc_hd__nor2_1
X$13081 VDD synth_12733 synth_12607 synth_12735 VNB|VSS VDD VNB|VSS
+ sky130_fd_sc_hd__nor2_1
X$13082 VDD synth_157 synth_158 synth_482 VNB|VSS VDD VNB|VSS
+ sky130_fd_sc_hd__nor2_1
X$13083 VDD synth_10449 synth_10448 synth_10338 VNB|VSS VDD VNB|VSS
+ sky130_fd_sc_hd__nor2_1
X$13084 VDD synth_9073 synth_8015 synth_8880 VNB|VSS VDD VNB|VSS
+ sky130_fd_sc_hd__nor2_1
X$13085 VDD synth_2807 synth_1070 synth_4601 VNB|VSS VDD VNB|VSS
+ sky130_fd_sc_hd__nor2_1
X$13086 VDD synth_333 synth_172 synth_390 VNB|VSS VDD VNB|VSS
+ sky130_fd_sc_hd__nor2_1
X$13087 VDD synth_4936 synth_1070 synth_6150 VNB|VSS VDD VNB|VSS
+ sky130_fd_sc_hd__nor2_1
X$13088 VDD synth_8250 synth_8637 synth_8732 VNB|VSS VDD VNB|VSS
+ sky130_fd_sc_hd__nor2_1
X$13089 VDD synth_8710 synth_8805 synth_8807 VNB|VSS VDD VNB|VSS
+ sky130_fd_sc_hd__nor2_1
X$13090 VDD synth_8921 synth_8796 synth_8847 VNB|VSS VDD VNB|VSS
+ sky130_fd_sc_hd__nor2_1
X$13091 VDD synth_10793 synth_11538 synth_12094 VNB|VSS VDD VNB|VSS
+ sky130_fd_sc_hd__nor2_1
X$13092 VDD synth_8981 synth_9240 synth_9241 VNB|VSS VDD VNB|VSS
+ sky130_fd_sc_hd__nor2_1
X$13093 VDD synth_8921 synth_8797 synth_8848 VNB|VSS VDD VNB|VSS
+ sky130_fd_sc_hd__nor2_1
X$13094 VDD synth_2005 synth_1933 synth_2092 VNB|VSS VDD VNB|VSS
+ sky130_fd_sc_hd__nor2_1
X$13095 VDD synth_1199 synth_1306 synth_1201 VNB|VSS VDD VNB|VSS
+ sky130_fd_sc_hd__nor2_1
X$13096 VDD synth_8626 synth_8548 synth_8740 VNB|VSS VDD VNB|VSS
+ sky130_fd_sc_hd__nor2_1
X$13097 VDD synth_10652 synth_8948 synth_11934 VNB|VSS VDD VNB|VSS
+ sky130_fd_sc_hd__nor2_1
X$13098 VDD synth_8904 synth_9098 synth_9056 VNB|VSS VDD VNB|VSS
+ sky130_fd_sc_hd__nor2_1
X$13099 VDD synth_11022 synth_11613 synth_11476 VNB|VSS VDD VNB|VSS
+ sky130_fd_sc_hd__nor2_1
X$13100 VDD synth_647 synth_4936 synth_6151 VNB|VSS VDD VNB|VSS
+ sky130_fd_sc_hd__nor2_1
X$13101 VDD synth_939 synth_6636 synth_6858 VNB|VSS VDD VNB|VSS
+ sky130_fd_sc_hd__nor2_1
X$13102 VDD synth_1467 synth_2713 synth_4431 VNB|VSS VDD VNB|VSS
+ sky130_fd_sc_hd__nor2_1
X$13103 VDD synth_9109 synth_9054 synth_4908 VNB|VSS VDD VNB|VSS
+ sky130_fd_sc_hd__nor2_1
X$13104 VDD synth_1199 synth_1198 synth_1535 VNB|VSS VDD VNB|VSS
+ sky130_fd_sc_hd__nor2_1
X$13105 VDD synth_8196 synth_10888 synth_10800 VNB|VSS VDD VNB|VSS
+ sky130_fd_sc_hd__nor2_1
X$13106 VDD synth_3107 synth_1125 synth_5746 VNB|VSS VDD VNB|VSS
+ sky130_fd_sc_hd__nor2_1
X$13107 VDD synth_2807 synth_1125 synth_5571 VNB|VSS VDD VNB|VSS
+ sky130_fd_sc_hd__nor2_1
X$13108 VDD synth_8250 synth_8596 synth_8505 VNB|VSS VDD VNB|VSS
+ sky130_fd_sc_hd__nor2_1
X$13109 VDD synth_3116 synth_2957 synth_3115 VNB|VSS VDD VNB|VSS
+ sky130_fd_sc_hd__nor2_1
X$13110 VDD synth_3400 synth_3399 synth_3736 VNB|VSS VDD VNB|VSS
+ sky130_fd_sc_hd__nor2_1
X$13111 VDD synth_3472 synth_3564 synth_3704 VNB|VSS VDD VNB|VSS
+ sky130_fd_sc_hd__nor2_1
X$13112 VDD synth_10516 synth_10399 synth_10586 VNB|VSS VDD VNB|VSS
+ sky130_fd_sc_hd__nor2_1
X$13113 VDD synth_744 synth_644 synth_901 VNB|VSS VDD VNB|VSS
+ sky130_fd_sc_hd__nor2_1
X$13114 VDD synth_10478 synth_10451 synth_10585 VNB|VSS VDD VNB|VSS
+ sky130_fd_sc_hd__nor2_1
X$13115 VDD synth_8642 synth_8015 synth_8643 VNB|VSS VDD VNB|VSS
+ sky130_fd_sc_hd__nor2_1
X$13116 VDD synth_12579 synth_12635 synth_12515 VNB|VSS VDD VNB|VSS
+ sky130_fd_sc_hd__nor2_1
X$13117 VDD synth_1711 synth_7777 synth_9840 VNB|VSS VDD VNB|VSS
+ sky130_fd_sc_hd__nor2_1
X$13118 VDD synth_580 synth_509 synth_1114 VNB|VSS VDD VNB|VSS
+ sky130_fd_sc_hd__nor2_1
X$13119 VDD synth_545 synth_7780 synth_12165 VNB|VSS VDD VNB|VSS
+ sky130_fd_sc_hd__nor2_1
X$13120 VDD synth_3955 synth_4011 synth_4216 VNB|VSS VDD VNB|VSS
+ sky130_fd_sc_hd__nor2_1
X$13121 VDD synth_4290 synth_4398 synth_4394 VNB|VSS VDD VNB|VSS
+ sky130_fd_sc_hd__nor2_1
X$13122 VDD synth_513 synth_2431 synth_2520 VNB|VSS VDD VNB|VSS
+ sky130_fd_sc_hd__nor2_1
X$13123 VDD synth_8954 synth_9251 synth_9267 VNB|VSS VDD VNB|VSS
+ sky130_fd_sc_hd__nor2_1
X$13124 VDD synth_12314 synth_12682 synth_12764 VNB|VSS VDD VNB|VSS
+ sky130_fd_sc_hd__nor2_1
X$13125 VDD synth_4455 synth_4394 synth_4608 VNB|VSS VDD VNB|VSS
+ sky130_fd_sc_hd__nor2_1
X$13126 VDD synth_545 synth_2431 synth_3766 VNB|VSS VDD VNB|VSS
+ sky130_fd_sc_hd__nor2_1
X$13127 VDD synth_10212 synth_12243 synth_12265 VNB|VSS VDD VNB|VSS
+ sky130_fd_sc_hd__nor2_1
X$13128 VDD synth_1070 synth_2713 synth_3022 VNB|VSS VDD VNB|VSS
+ sky130_fd_sc_hd__nor2_1
X$13129 VDD synth_226 synth_155 synth_156 VNB|VSS VDD VNB|VSS
+ sky130_fd_sc_hd__nor2_1
X$13130 VDD synth_157 synth_156 synth_227 VNB|VSS VDD VNB|VSS
+ sky130_fd_sc_hd__nor2_1
X$13131 VDD synth_3107 synth_877 synth_5304 VNB|VSS VDD VNB|VSS
+ sky130_fd_sc_hd__nor2_1
X$13132 VDD synth_3107 synth_1827 synth_5669 VNB|VSS VDD VNB|VSS
+ sky130_fd_sc_hd__nor2_1
X$13133 VDD synth_10531 synth_10671 synth_10564 VNB|VSS VDD VNB|VSS
+ sky130_fd_sc_hd__nor2_1
X$13134 VDD synth_939 synth_3107 synth_3170 VNB|VSS VDD VNB|VSS
+ sky130_fd_sc_hd__nor2_1
X$13135 VDD synth_693 synth_627 synth_632 VNB|VSS VDD VNB|VSS
+ sky130_fd_sc_hd__nor2_1
X$13136 VDD synth_4455 synth_4453 synth_4552 VNB|VSS VDD VNB|VSS
+ sky130_fd_sc_hd__nor2_1
X$13137 VDD synth_1827 synth_7777 synth_9570 VNB|VSS VDD VNB|VSS
+ sky130_fd_sc_hd__nor2_1
X$13138 VDD synth_3553 synth_3453 synth_3718 VNB|VSS VDD VNB|VSS
+ sky130_fd_sc_hd__nor2_1
X$13139 VDD synth_3246 synth_3197 synth_3419 VNB|VSS VDD VNB|VSS
+ sky130_fd_sc_hd__nor2_1
X$13140 VDD synth_1213 synth_3299 synth_3372 VNB|VSS VDD VNB|VSS
+ sky130_fd_sc_hd__nor2_1
X$13141 VDD synth_3300 synth_3375 synth_3299 VNB|VSS VDD VNB|VSS
+ sky130_fd_sc_hd__nor2_1
X$13142 VDD synth_12425 synth_12474 synth_12611 VNB|VSS VDD VNB|VSS
+ sky130_fd_sc_hd__nor2_1
X$13143 VDD synth_3300 synth_3458 synth_3514 VNB|VSS VDD VNB|VSS
+ sky130_fd_sc_hd__nor2_1
X$13144 VDD synth_7127 synth_6837 synth_7594 VNB|VSS VDD VNB|VSS
+ sky130_fd_sc_hd__nor2_1
X$13145 VDD synth_3373 synth_3456 synth_3458 VNB|VSS VDD VNB|VSS
+ sky130_fd_sc_hd__nor2_1
X$13146 VDD synth_10449 synth_10735 synth_10660 VNB|VSS VDD VNB|VSS
+ sky130_fd_sc_hd__nor2_1
X$13147 VDD synth_9583 synth_8990 synth_11914 VNB|VSS VDD VNB|VSS
+ sky130_fd_sc_hd__nor2_1
X$13148 VDD synth_7000 synth_545 synth_7860 VNB|VSS VDD VNB|VSS
+ sky130_fd_sc_hd__nor2_1
X$13149 VDD synth_545 synth_2713 synth_3504 VNB|VSS VDD VNB|VSS
+ sky130_fd_sc_hd__nor2_1
X$13150 VDD synth_1711 synth_509 synth_2111 VNB|VSS VDD VNB|VSS
+ sky130_fd_sc_hd__nor2_1
X$13151 VDD synth_9232 synth_8738 synth_9105 VNB|VSS VDD VNB|VSS
+ sky130_fd_sc_hd__nor2_1
X$13152 VDD synth_581 synth_685 synth_627 VNB|VSS VDD VNB|VSS
+ sky130_fd_sc_hd__nor2_1
X$13153 VDD synth_1125 synth_2713 synth_4315 VNB|VSS VDD VNB|VSS
+ sky130_fd_sc_hd__nor2_1
X$13154 VDD synth_1094 synth_509 synth_2635 VNB|VSS VDD VNB|VSS
+ sky130_fd_sc_hd__nor2_1
X$13155 VDD synth_509 synth_1827 synth_3454 VNB|VSS VDD VNB|VSS
+ sky130_fd_sc_hd__nor2_1
X$13156 VDD synth_989 synth_885 synth_968 VNB|VSS VDD VNB|VSS
+ sky130_fd_sc_hd__nor2_1
X$13157 VDD synth_5035 synth_5086 synth_5085 VNB|VSS VDD VNB|VSS
+ sky130_fd_sc_hd__nor2_1
X$13158 VDD synth_580 synth_7780 synth_9897 VNB|VSS VDD VNB|VSS
+ sky130_fd_sc_hd__nor2_1
X$13159 VDD synth_12421 synth_8015 synth_12607 VNB|VSS VDD VNB|VSS
+ sky130_fd_sc_hd__nor2_1
X$13160 VDD synth_12542 synth_12675 synth_12744 VNB|VSS VDD VNB|VSS
+ sky130_fd_sc_hd__nor2_1
X$13161 VDD synth_7591 synth_6695 synth_7812 VNB|VSS VDD VNB|VSS
+ sky130_fd_sc_hd__nor2_1
X$13162 VDD synth_1094 synth_2713 synth_3846 VNB|VSS VDD VNB|VSS
+ sky130_fd_sc_hd__nor2_1
X$13163 VDD synth_1456 synth_2713 synth_4254 VNB|VSS VDD VNB|VSS
+ sky130_fd_sc_hd__nor2_1
X$13164 VDD synth_12310 synth_12728 synth_12701 VNB|VSS VDD VNB|VSS
+ sky130_fd_sc_hd__nor2_1
X$13165 VDD synth_995 synth_509 synth_2920 VNB|VSS VDD VNB|VSS
+ sky130_fd_sc_hd__nor2_1
X$13166 VDD synth_580 synth_550 synth_694 VNB|VSS VDD VNB|VSS
+ sky130_fd_sc_hd__nor2_1
X$13167 VDD synth_3367 synth_3366 synth_3591 VNB|VSS VDD VNB|VSS
+ sky130_fd_sc_hd__nor2_1
X$13168 VDD synth_2167 synth_2696 synth_2575 VNB|VSS VDD VNB|VSS
+ sky130_fd_sc_hd__nor2_1
X$13169 VDD synth_1456 synth_2807 synth_5270 VNB|VSS VDD VNB|VSS
+ sky130_fd_sc_hd__nor2_1
X$13170 VDD synth_7805 synth_6696 synth_8036 VNB|VSS VDD VNB|VSS
+ sky130_fd_sc_hd__nor2_1
X$13171 VDD synth_4245 synth_4356 synth_4357 VNB|VSS VDD VNB|VSS
+ sky130_fd_sc_hd__nor2_1
X$13172 VDD synth_6310 synth_6692 synth_6706 VNB|VSS VDD VNB|VSS
+ sky130_fd_sc_hd__nor2_1
X$13173 VDD synth_8954 synth_9145 synth_8973 VNB|VSS VDD VNB|VSS
+ sky130_fd_sc_hd__nor2_1
X$13174 VDD synth_4591 synth_4354 synth_4639 VNB|VSS VDD VNB|VSS
+ sky130_fd_sc_hd__nor2_1
X$13175 VDD synth_8196 synth_8480 synth_8499 VNB|VSS VDD VNB|VSS
+ sky130_fd_sc_hd__nor2_1
X$13176 VDD synth_9427 synth_9239 synth_10438 VNB|VSS VDD VNB|VSS
+ sky130_fd_sc_hd__nor2_1
X$13177 VDD synth_7807 synth_7590 synth_8188 VNB|VSS VDD VNB|VSS
+ sky130_fd_sc_hd__nor2_1
X$13178 VDD synth_12314 synth_12618 synth_12687 VNB|VSS VDD VNB|VSS
+ sky130_fd_sc_hd__nor2_1
X$13179 VDD synth_10701 synth_10702 synth_10621 VNB|VSS VDD VNB|VSS
+ sky130_fd_sc_hd__nor2_1
X$13180 VDD synth_7000 synth_580 synth_7162 VNB|VSS VDD VNB|VSS
+ sky130_fd_sc_hd__nor2_1
X$13181 VDD synth_8954 synth_9012 synth_8971 VNB|VSS VDD VNB|VSS
+ sky130_fd_sc_hd__nor2_1
X$13182 VDD synth_9592 synth_9591 synth_9652 VNB|VSS VDD VNB|VSS
+ sky130_fd_sc_hd__nor2_1
X$13183 VDD synth_1827 synth_550 synth_3208 VNB|VSS VDD VNB|VSS
+ sky130_fd_sc_hd__nor2_1
X$13184 VDD synth_8250 synth_8179 synth_8364 VNB|VSS VDD VNB|VSS
+ sky130_fd_sc_hd__nor2_1
X$13185 VDD synth_513 synth_7000 synth_6964 VNB|VSS VDD VNB|VSS
+ sky130_fd_sc_hd__nor2_1
X$13186 VDD synth_8381 synth_7974 synth_8434 VNB|VSS VDD VNB|VSS
+ sky130_fd_sc_hd__nor2_1
X$13187 VDD synth_7818 synth_7422 synth_7951 VNB|VSS VDD VNB|VSS
+ sky130_fd_sc_hd__nor2_1
X$13188 VDD synth_12310 synth_12727 synth_12781 VNB|VSS VDD VNB|VSS
+ sky130_fd_sc_hd__nor2_1
X$13189 VDD synth_10833 synth_11014 synth_10975 VNB|VSS VDD VNB|VSS
+ sky130_fd_sc_hd__nor2_1
X$13190 VDD synth_4022 synth_4023 synth_4160 VNB|VSS VDD VNB|VSS
+ sky130_fd_sc_hd__nor2_1
X$13191 VDD synth_12314 synth_12676 synth_12677 VNB|VSS VDD VNB|VSS
+ sky130_fd_sc_hd__nor2_1
X$13192 VDD synth_12314 synth_12731 synth_12774 VNB|VSS VDD VNB|VSS
+ sky130_fd_sc_hd__nor2_1
X$13193 VDD synth_3787 synth_3748 synth_3786 VNB|VSS VDD VNB|VSS
+ sky130_fd_sc_hd__nor2_1
X$13194 VDD synth_8588 synth_8257 synth_8585 VNB|VSS VDD VNB|VSS
+ sky130_fd_sc_hd__nor2_1
X$13195 VDD synth_8765 synth_10945 synth_10973 VNB|VSS VDD VNB|VSS
+ sky130_fd_sc_hd__nor2_1
X$13196 VDD synth_1711 synth_7780 synth_10279 VNB|VSS VDD VNB|VSS
+ sky130_fd_sc_hd__nor2_1
X$13197 VDD synth_570 synth_1467 synth_1658 VNB|VSS VDD VNB|VSS
+ sky130_fd_sc_hd__nor2_1
X$13198 VDD synth_11176 synth_11022 synth_11102 VNB|VSS VDD VNB|VSS
+ sky130_fd_sc_hd__nor2_1
X$13199 VDD synth_8768 synth_8882 synth_8773 VNB|VSS VDD VNB|VSS
+ sky130_fd_sc_hd__nor2_1
X$13200 VDD synth_8478 synth_8257 synth_8662 VNB|VSS VDD VNB|VSS
+ sky130_fd_sc_hd__nor2_1
X$13201 VDD synth_8910 synth_9615 synth_9429 VNB|VSS VDD VNB|VSS
+ sky130_fd_sc_hd__nor2_1
X$13202 VDD synth_1125 synth_2431 synth_3761 VNB|VSS VDD VNB|VSS
+ sky130_fd_sc_hd__nor2_1
X$13203 VDD synth_851 synth_1089 synth_926 VNB|VSS VDD VNB|VSS
+ sky130_fd_sc_hd__nor2_1
X$13204 VDD synth_513 synth_509 synth_419 VNB|VSS VDD VNB|VSS
+ sky130_fd_sc_hd__nor2_1
X$13205 VDD synth_1311 synth_1448 synth_1478 VNB|VSS VDD VNB|VSS
+ sky130_fd_sc_hd__nor2_1
X$13206 VDD synth_545 synth_7777 synth_10426 VNB|VSS VDD VNB|VSS
+ sky130_fd_sc_hd__nor2_1
X$13207 VDD synth_199 synth_198 synth_304 VNB|VSS VDD VNB|VSS
+ sky130_fd_sc_hd__nor2_1
X$13208 VDD synth_514 synth_1070 synth_1414 VNB|VSS VDD VNB|VSS
+ sky130_fd_sc_hd__nor2_1
X$13209 VDD synth_1094 synth_7819 synth_11442 VNB|VSS VDD VNB|VSS
+ sky130_fd_sc_hd__nor2_1
X$13210 VDD synth_9239 synth_9322 synth_9173 VNB|VSS VDD VNB|VSS
+ sky130_fd_sc_hd__nor2_1
X$13211 VDD synth_11928 synth_11936 synth_11894 VNB|VSS VDD VNB|VSS
+ sky130_fd_sc_hd__nor2_1
X$13212 VDD synth_995 synth_5129 synth_8148 VNB|VSS VDD VNB|VSS
+ sky130_fd_sc_hd__nor2_1
X$13213 VDD synth_1827 synth_5129 synth_8492 VNB|VSS VDD VNB|VSS
+ sky130_fd_sc_hd__nor2_1
X$13214 VDD synth_8954 synth_9014 synth_8970 VNB|VSS VDD VNB|VSS
+ sky130_fd_sc_hd__nor2_1
X$13215 VDD synth_8097 synth_8878 synth_8767 VNB|VSS VDD VNB|VSS
+ sky130_fd_sc_hd__nor2_1
X$13216 VDD synth_197 synth_134 synth_198 VNB|VSS VDD VNB|VSS
+ sky130_fd_sc_hd__nor2_1
X$13217 VDD synth_573 synth_683 synth_829 VNB|VSS VDD VNB|VSS
+ sky130_fd_sc_hd__nor2_1
X$13218 VDD synth_3512 synth_3372 synth_3339 VNB|VSS VDD VNB|VSS
+ sky130_fd_sc_hd__nor2_1
X$13219 VDD synth_12620 synth_12661 synth_12716 VNB|VSS VDD VNB|VSS
+ sky130_fd_sc_hd__nor2_1
X$13220 VDD synth_12511 synth_12716 synth_12717 VNB|VSS VDD VNB|VSS
+ sky130_fd_sc_hd__nor2_1
X$13221 VDD synth_3719 synth_3500 synth_3860 VNB|VSS VDD VNB|VSS
+ sky130_fd_sc_hd__nor2_1
X$13222 VDD synth_1456 synth_3107 synth_5114 VNB|VSS VDD VNB|VSS
+ sky130_fd_sc_hd__nor2_1
X$13223 VDD synth_1088 synth_1099 synth_1089 VNB|VSS VDD VNB|VSS
+ sky130_fd_sc_hd__nor2_1
X$13224 VDD synth_1456 synth_514 synth_488 VNB|VSS VDD VNB|VSS
+ sky130_fd_sc_hd__nor2_1
X$13225 VDD synth_1456 synth_7000 synth_8841 VNB|VSS VDD VNB|VSS
+ sky130_fd_sc_hd__nor2_1
X$13226 VDD synth_165 synth_71 synth_134 VNB|VSS VDD VNB|VSS
+ sky130_fd_sc_hd__nor2_1
X$13227 VDD synth_545 synth_6636 synth_7336 VNB|VSS VDD VNB|VSS
+ sky130_fd_sc_hd__nor2_1
X$13228 VDD synth_9310 synth_9413 synth_9144 VNB|VSS VDD VNB|VSS
+ sky130_fd_sc_hd__nor2_1
X$13229 VDD synth_10953 synth_10952 synth_11107 VNB|VSS VDD VNB|VSS
+ sky130_fd_sc_hd__nor2_1
X$13230 VDD synth_9019 synth_10602 synth_10883 VNB|VSS VDD VNB|VSS
+ sky130_fd_sc_hd__nor2_1
X$13231 VDD synth_10101 synth_12525 synth_12557 VNB|VSS VDD VNB|VSS
+ sky130_fd_sc_hd__nor2_1
X$13232 VDD synth_10258 synth_10320 synth_10319 VNB|VSS VDD VNB|VSS
+ sky130_fd_sc_hd__nor2_1
X$13233 VDD synth_4361 synth_4236 synth_4363 VNB|VSS VDD VNB|VSS
+ sky130_fd_sc_hd__nor2_1
X$13234 VDD synth_10449 synth_10732 synth_10769 VNB|VSS VDD VNB|VSS
+ sky130_fd_sc_hd__nor2_1
X$13235 VDD synth_5627 synth_5690 synth_5688 VNB|VSS VDD VNB|VSS
+ sky130_fd_sc_hd__nor2_1
X$13236 VDD synth_8109 synth_8261 synth_8027 VNB|VSS VDD VNB|VSS
+ sky130_fd_sc_hd__nor2_1
X$13237 VDD synth_8764 synth_9682 synth_9768 VNB|VSS VDD VNB|VSS
+ sky130_fd_sc_hd__nor2_1
X$13238 VDD synth_12531 synth_8015 synth_12675 VNB|VSS VDD VNB|VSS
+ sky130_fd_sc_hd__nor2_1
X$13239 VDD synth_10793 synth_9677 synth_10773 VNB|VSS VDD VNB|VSS
+ sky130_fd_sc_hd__nor2_1
X$13240 VDD synth_1070 synth_509 synth_741 VNB|VSS VDD VNB|VSS
+ sky130_fd_sc_hd__nor2_1
X$13241 VDD synth_1081 synth_1079 synth_1077 VNB|VSS VDD VNB|VSS
+ sky130_fd_sc_hd__nor2_1
X$13242 VDD synth_9292 synth_9580 synth_9625 VNB|VSS VDD VNB|VSS
+ sky130_fd_sc_hd__nor2_1
X$13243 VDD synth_1078 synth_1077 synth_1080 VNB|VSS VDD VNB|VSS
+ sky130_fd_sc_hd__nor2_1
X$13244 VDD synth_930 synth_843 synth_1013 VNB|VSS VDD VNB|VSS
+ sky130_fd_sc_hd__nor2_1
X$13245 VDD synth_514 synth_510 synth_395 VNB|VSS VDD VNB|VSS
+ sky130_fd_sc_hd__nor2_1
X$13246 VDD synth_510 synth_5138 synth_5590 VNB|VSS VDD VNB|VSS
+ sky130_fd_sc_hd__nor2_1
X$13247 VDD synth_514 synth_1094 synth_656 VNB|VSS VDD VNB|VSS
+ sky130_fd_sc_hd__nor2_1
X$13248 VDD synth_580 synth_5138 synth_5108 VNB|VSS VDD VNB|VSS
+ sky130_fd_sc_hd__nor2_1
X$13249 VDD synth_6636 synth_1094 synth_7585 VNB|VSS VDD VNB|VSS
+ sky130_fd_sc_hd__nor2_1
X$13250 VNB|VSS synth_7651 synth_7486 synth_7710 VDD synth_7711 VDD VNB|VSS
+ sky130_fd_sc_hd__ha_1
X$13251 VNB|VSS synth_1415 synth_1274 synth_1275 VDD synth_1327 VDD VNB|VSS
+ sky130_fd_sc_hd__ha_1
X$13252 VNB|VSS synth_4677 synth_4705 synth_4746 VDD synth_4704 VDD VNB|VSS
+ sky130_fd_sc_hd__ha_1
X$13253 VNB|VSS synth_11420 synth_11393 synth_11328 VDD synth_11172 VDD VNB|VSS
+ sky130_fd_sc_hd__ha_1
X$13254 VNB|VSS synth_5042 synth_5155 synth_5078 VDD synth_5077 VDD VNB|VSS
+ sky130_fd_sc_hd__ha_1
X$13255 VNB|VSS synth_4328 synth_4103 synth_4247 VDD synth_4326 VDD VNB|VSS
+ sky130_fd_sc_hd__ha_1
X$13256 VNB|VSS synth_2949 synth_3033 synth_3009 VDD synth_3010 VDD VNB|VSS
+ sky130_fd_sc_hd__ha_1
X$13257 VNB|VSS synth_12061 synth_12069 synth_12000 VDD synth_12007 VDD VNB|VSS
+ sky130_fd_sc_hd__ha_1
X$13258 VNB|VSS synth_322 synth_224 synth_286 VDD synth_116 VDD VNB|VSS
+ sky130_fd_sc_hd__ha_1
X$13259 VNB|VSS synth_6329 synth_5993 synth_6305 VDD synth_6382 VDD VNB|VSS
+ sky130_fd_sc_hd__ha_1
X$13260 VNB|VSS synth_12646 synth_12587 synth_12707 VDD synth_12589 VDD VNB|VSS
+ sky130_fd_sc_hd__ha_1
X$13261 VNB|VSS synth_9721 synth_9783 synth_9805 VDD synth_9275 VDD VNB|VSS
+ sky130_fd_sc_hd__ha_1
X$13262 VNB|VSS synth_9271 synth_9337 synth_9336 VDD synth_9275 VDD VNB|VSS
+ sky130_fd_sc_hd__ha_1
X$13263 VNB|VSS synth_1401 synth_1348 synth_1263 VDD synth_1264 VDD VNB|VSS
+ sky130_fd_sc_hd__ha_1
X$13264 VNB|VSS synth_2210 synth_2211 synth_2281 VDD synth_2237 VDD VNB|VSS
+ sky130_fd_sc_hd__ha_1
X$13265 VNB|VSS synth_9085 synth_9052 synth_9088 VDD synth_9090 VDD VNB|VSS
+ sky130_fd_sc_hd__ha_1
X$13266 VNB|VSS synth_267 synth_269 synth_181 VDD synth_268 VDD VNB|VSS
+ sky130_fd_sc_hd__ha_1
X$13267 VNB|VSS synth_951 synth_868 synth_897 VDD synth_811 VDD VNB|VSS
+ sky130_fd_sc_hd__ha_1
X$13268 VNB|VSS synth_5324 synth_5371 synth_5442 VDD synth_5370 VDD VNB|VSS
+ sky130_fd_sc_hd__ha_1
X$13269 VNB|VSS synth_11130 synth_10860 synth_11131 VDD synth_11060 VDD VNB|VSS
+ sky130_fd_sc_hd__ha_1
X$13270 VNB|VSS synth_3065 synth_2938 synth_3067 VDD synth_2986 VDD VNB|VSS
+ sky130_fd_sc_hd__ha_1
X$13271 VNB|VSS synth_6398 synth_6354 synth_6355 VDD synth_6401 VDD VNB|VSS
+ sky130_fd_sc_hd__ha_1
X$13272 VNB|VSS synth_9883 synth_9365 synth_9886 VDD synth_9804 VDD VNB|VSS
+ sky130_fd_sc_hd__ha_1
X$13273 VNB|VSS synth_8049 synth_7969 synth_7918 VDD synth_7893 VDD VNB|VSS
+ sky130_fd_sc_hd__ha_1
X$13274 VNB|VSS synth_4874 synth_4751 synth_4870 VDD synth_4967 VDD VNB|VSS
+ sky130_fd_sc_hd__ha_1
X$13275 VNB|VSS synth_7704 synth_7655 synth_7703 VDD synth_7702 VDD VNB|VSS
+ sky130_fd_sc_hd__ha_1
X$13276 VNB|VSS synth_91 synth_192 synth_377 VDD synth_320 VDD VNB|VSS
+ sky130_fd_sc_hd__ha_1
X$13277 VNB|VSS synth_9273 synth_9453 synth_9451 VDD synth_9522 VDD VNB|VSS
+ sky130_fd_sc_hd__ha_1
X$13278 VNB|VSS synth_4832 synth_4890 synth_4917 VDD synth_4891 VDD VNB|VSS
+ sky130_fd_sc_hd__ha_1
X$13279 VNB|VSS synth_4545 synth_4211 synth_4459 VDD synth_4542 VDD VNB|VSS
+ sky130_fd_sc_hd__ha_1
X$13280 VNB|VSS synth_2901 synth_2855 synth_2904 VDD synth_2823 VDD VNB|VSS
+ sky130_fd_sc_hd__ha_1
X$13281 VNB|VSS synth_11390 synth_11391 synth_11345 VDD synth_11273 VDD VNB|VSS
+ sky130_fd_sc_hd__ha_1
X$13282 VNB|VSS synth_12181 synth_12115 synth_12114 VDD synth_12113 VDD VNB|VSS
+ sky130_fd_sc_hd__ha_1
X$13283 VNB|VSS synth_7118 synth_7119 synth_7152 VDD synth_7074 VDD VNB|VSS
+ sky130_fd_sc_hd__ha_1
X$13284 VNB|VSS synth_5560 synth_5254 synth_5542 VDD synth_5500 VDD VNB|VSS
+ sky130_fd_sc_hd__ha_1
X$13285 VNB|VSS synth_8968 synth_9073 synth_9082 VDD synth_8967 VDD VNB|VSS
+ sky130_fd_sc_hd__ha_1
X$13286 VNB|VSS synth_5775 synth_5858 synth_5774 VDD synth_5906 VDD VNB|VSS
+ sky130_fd_sc_hd__ha_1
X$13287 VNB|VSS synth_4762 synth_4427 synth_4765 VDD synth_4720 VDD VNB|VSS
+ sky130_fd_sc_hd__ha_1
X$13288 VNB|VSS synth_6295 synth_6345 synth_6417 VDD synth_6280 VDD VNB|VSS
+ sky130_fd_sc_hd__ha_1
X$13289 VNB|VSS synth_2225 synth_2296 synth_2289 VDD synth_2223 VDD VNB|VSS
+ sky130_fd_sc_hd__ha_1
X$13290 VNB|VSS synth_3498 synth_3317 synth_3409 VDD synth_3421 VDD VNB|VSS
+ sky130_fd_sc_hd__ha_1
X$13291 VNB|VSS synth_22 synth_309 synth_294 VDD synth_166 VDD VNB|VSS
+ sky130_fd_sc_hd__ha_1
X$13292 VNB|VSS synth_12307 synth_12334 synth_12309 VDD synth_12262 VDD VNB|VSS
+ sky130_fd_sc_hd__ha_1
X$13293 VNB|VSS synth_12709 synth_12710 synth_12793 VDD synth_12665 VDD VNB|VSS
+ sky130_fd_sc_hd__ha_1
X$13294 VNB|VSS synth_6043 synth_5744 synth_5895 VDD synth_5979 VDD VNB|VSS
+ sky130_fd_sc_hd__ha_1
X$13295 VNB|VSS synth_10038 synth_10137 synth_9865 VDD synth_10138 VDD VNB|VSS
+ sky130_fd_sc_hd__ha_1
X$13296 VNB|VSS synth_7945 synth_7668 synth_7882 VDD synth_7818 VDD VNB|VSS
+ sky130_fd_sc_hd__ha_1
X$13297 VNB|VSS synth_9146 synth_9066 synth_9065 VDD synth_9199 VDD VNB|VSS
+ sky130_fd_sc_hd__ha_1
X$13298 VNB|VSS synth_1835 synth_1754 synth_1747 VDD synth_1748 VDD VNB|VSS
+ sky130_fd_sc_hd__ha_1
X$13299 VNB|VSS synth_6881 synth_6642 synth_6749 VDD synth_6681 VDD VNB|VSS
+ sky130_fd_sc_hd__ha_1
X$13300 VNB|VSS synth_9673 synth_9622 synth_9741 VDD synth_9674 VDD VNB|VSS
+ sky130_fd_sc_hd__ha_1
X$13301 VNB|VSS synth_10205 synth_10206 synth_10264 VDD synth_9198 VDD VNB|VSS
+ sky130_fd_sc_hd__ha_1
X$13302 VNB|VSS synth_104 synth_296 synth_103 VDD synth_70 VDD VNB|VSS
+ sky130_fd_sc_hd__ha_1
X$13303 VNB|VSS synth_10544 synth_10514 synth_10543 VDD synth_10041 VDD VNB|VSS
+ sky130_fd_sc_hd__ha_1
X$13304 VNB|VSS synth_9075 synth_8965 synth_8898 VDD synth_9076 VDD VNB|VSS
+ sky130_fd_sc_hd__ha_1
X$13305 VNB|VSS synth_1103 synth_851 synth_1100 VDD synth_1147 VDD VNB|VSS
+ sky130_fd_sc_hd__ha_1
X$13306 VNB|VSS synth_5867 synth_5817 synth_5866 VDD synth_5781 VDD VNB|VSS
+ sky130_fd_sc_hd__ha_1
X$13307 VNB|VSS synth_9725 synth_9860 synth_9656 VDD synth_9815 VDD VNB|VSS
+ sky130_fd_sc_hd__ha_1
X$13308 VNB|VSS synth_6521 synth_6526 synth_6525 VDD synth_6602 VDD VNB|VSS
+ sky130_fd_sc_hd__ha_1
X$13309 VNB|VSS synth_9125 synth_9091 synth_8969 VDD synth_9093 VDD VNB|VSS
+ sky130_fd_sc_hd__ha_1
X$13310 VNB|VSS synth_11398 synth_11399 synth_11251 VDD synth_10809 VDD VNB|VSS
+ sky130_fd_sc_hd__ha_1
X$13311 VNB|VSS synth_2324 synth_2263 synth_2417 VDD synth_2467 VDD VNB|VSS
+ sky130_fd_sc_hd__ha_1
X$13312 VNB|VSS synth_12009 synth_12011 synth_12072 VDD synth_11982 VDD VNB|VSS
+ sky130_fd_sc_hd__ha_1
X$13313 VNB|VSS synth_4825 synth_5007 synth_4862 VDD synth_4861 VDD VNB|VSS
+ sky130_fd_sc_hd__ha_1
X$13314 VNB|VSS synth_10588 synth_10521 synth_10464 VDD synth_10529 VDD VNB|VSS
+ sky130_fd_sc_hd__ha_1
X$13315 VNB|VSS synth_1418 synth_1539 synth_1538 VDD synth_1420 VDD VNB|VSS
+ sky130_fd_sc_hd__ha_1
X$13316 VNB|VSS synth_9484 synth_9489 synth_9639 VDD synth_9529 VDD VNB|VSS
+ sky130_fd_sc_hd__ha_1
X$13317 VNB|VSS synth_8760 synth_8783 synth_8761 VDD synth_8688 VDD VNB|VSS
+ sky130_fd_sc_hd__ha_1
X$13318 VNB|VSS synth_10247 synth_9789 synth_10196 VDD synth_10248 VDD VNB|VSS
+ sky130_fd_sc_hd__ha_1
X$13319 VNB|VSS synth_5299 synth_5352 synth_5295 VDD synth_5444 VDD VNB|VSS
+ sky130_fd_sc_hd__ha_1
X$13320 VNB|VSS synth_2755 synth_2752 synth_2751 VDD synth_2675 VDD VNB|VSS
+ sky130_fd_sc_hd__ha_1
X$13321 VNB|VSS synth_4388 synth_4341 synth_4472 VDD synth_4390 VDD VNB|VSS
+ sky130_fd_sc_hd__ha_1
X$13322 VNB|VSS synth_12745 synth_12531 synth_12762 VDD synth_12775 VDD VNB|VSS
+ sky130_fd_sc_hd__ha_1
X$13323 VNB|VSS synth_12199 synth_12200 synth_12312 VDD synth_12258 VDD VNB|VSS
+ sky130_fd_sc_hd__ha_1
X$13324 VNB|VSS synth_8368 synth_7929 synth_8295 VDD synth_8297 VDD VNB|VSS
+ sky130_fd_sc_hd__ha_1
X$13325 VNB|VSS synth_5021 synth_5165 synth_5036 VDD synth_5034 VDD VNB|VSS
+ sky130_fd_sc_hd__ha_1
X$13326 VNB|VSS synth_7952 synth_8122 synth_8123 VDD synth_8067 VDD VNB|VSS
+ sky130_fd_sc_hd__ha_1
X$13327 VNB|VSS synth_1600 synth_1579 synth_1577 VDD synth_1578 VDD VNB|VSS
+ sky130_fd_sc_hd__ha_1
X$13328 VNB|VSS synth_3667 synth_3480 synth_3665 VDD synth_3582 VDD VNB|VSS
+ sky130_fd_sc_hd__ha_1
X$13329 VNB|VSS synth_3737 synth_3631 synth_3741 VDD synth_3696 VDD VNB|VSS
+ sky130_fd_sc_hd__ha_1
X$13330 VNB|VSS synth_3070 synth_2768 synth_2996 VDD synth_2995 VDD VNB|VSS
+ sky130_fd_sc_hd__ha_1
X$13331 VNB|VSS synth_8657 synth_8648 synth_8580 VDD synth_8656 VDD VNB|VSS
+ sky130_fd_sc_hd__ha_1
X$13332 VNB|VSS synth_2331 synth_2422 synth_2453 VDD synth_2452 VDD VNB|VSS
+ sky130_fd_sc_hd__ha_1
X$13333 VNB|VSS synth_12852 synth_7421 synth_7882 VDD synth_7677 VDD VNB|VSS
+ sky130_fd_sc_hd__ha_1
X$13334 VNB|VSS synth_12576 synth_12437 synth_12699 VDD synth_12662 VDD VNB|VSS
+ sky130_fd_sc_hd__ha_1
X$13335 VNB|VSS synth_1841 synth_1425 synth_1768 VDD synth_1771 VDD VNB|VSS
+ sky130_fd_sc_hd__ha_1
X$13336 VNB|VSS synth_12737 synth_12421 synth_12679 VDD synth_12681 VDD VNB|VSS
+ sky130_fd_sc_hd__ha_1
X$13337 VNB|VSS synth_6011 synth_5627 synth_5916 VDD synth_5918 VDD VNB|VSS
+ sky130_fd_sc_hd__ha_1
X$13338 VNB|VSS synth_6341 synth_6146 synth_6275 VDD synth_6276 VDD VNB|VSS
+ sky130_fd_sc_hd__ha_1
X$13339 VNB|VSS synth_10821 synth_10822 synth_10783 VDD synth_10784 VDD VNB|VSS
+ sky130_fd_sc_hd__ha_1
X$13340 VNB|VSS synth_10039 synth_10043 synth_10040 VDD synth_9960 VDD VNB|VSS
+ sky130_fd_sc_hd__ha_1
X$13341 VNB|VSS synth_11432 synth_11162 synth_11578 VDD synth_11362 VDD VNB|VSS
+ sky130_fd_sc_hd__ha_1
X$13342 VNB|VSS synth_12470 synth_12532 synth_12472 VDD synth_12416 VDD VNB|VSS
+ sky130_fd_sc_hd__ha_1
X$13343 VNB|VSS synth_11809 synth_11724 synth_11721 VDD synth_11862 VDD VNB|VSS
+ sky130_fd_sc_hd__ha_1
X$13344 VNB|VSS synth_5224 synth_5225 synth_5140 VDD synth_5226 VDD VNB|VSS
+ sky130_fd_sc_hd__ha_1
X$13345 VNB|VSS synth_9441 synth_9341 synth_9340 VDD synth_9354 VDD VNB|VSS
+ sky130_fd_sc_hd__ha_1
X$13346 VNB|VSS synth_2072 synth_2102 synth_2075 VDD synth_2074 VDD VNB|VSS
+ sky130_fd_sc_hd__ha_1
X$13347 VNB|VSS synth_3359 synth_3491 synth_3490 VDD synth_3363 VDD VNB|VSS
+ sky130_fd_sc_hd__ha_1
X$13348 VNB|VSS synth_8975 synth_8953 synth_8877 VDD synth_9031 VDD VNB|VSS
+ sky130_fd_sc_hd__ha_1
X$13349 VNB|VSS synth_10741 synth_10495 synth_10745 VDD synth_10668 VDD VNB|VSS
+ sky130_fd_sc_hd__ha_1
X$13350 VNB|VSS synth_7750 synth_7215 synth_7591 VDD synth_7670 VDD VNB|VSS
+ sky130_fd_sc_hd__ha_1
X$13351 VNB|VSS synth_2605 synth_2603 synth_2604 VDD synth_2552 VDD VNB|VSS
+ sky130_fd_sc_hd__ha_1
X$13352 VNB|VSS synth_9148 synth_9030 synth_8808 VDD synth_9096 VDD VNB|VSS
+ sky130_fd_sc_hd__ha_1
X$13353 VNB|VSS synth_12363 synth_12365 synth_12415 VDD synth_12374 VDD VNB|VSS
+ sky130_fd_sc_hd__ha_1
X$13354 VNB|VSS synth_5309 synth_5144 synth_5142 VDD synth_5230 VDD VNB|VSS
+ sky130_fd_sc_hd__ha_1
X$13355 VNB|VSS synth_220 synth_284 synth_283 VDD synth_253 VDD VNB|VSS
+ sky130_fd_sc_hd__ha_1
X$13356 VNB|VSS synth_8258 synth_8183 synth_8268 VDD synth_8269 VDD VNB|VSS
+ sky130_fd_sc_hd__ha_1
X$13357 VNB|VSS synth_3006 synth_3042 synth_3005 VDD synth_3086 VDD VNB|VSS
+ sky130_fd_sc_hd__ha_1
X$13358 VNB|VSS synth_10606 synth_10584 synth_10661 VDD synth_9522 VDD VNB|VSS
+ sky130_fd_sc_hd__ha_1
X$13359 VNB|VSS synth_5885 synth_5969 synth_5940 VDD synth_5941 VDD VNB|VSS
+ sky130_fd_sc_hd__ha_1
X$13360 VNB|VSS synth_6779 synth_6747 synth_6879 VDD synth_6746 VDD VNB|VSS
+ sky130_fd_sc_hd__ha_1
X$13361 VNB|VSS synth_330 synth_197 synth_301 VDD synth_300 VDD VNB|VSS
+ sky130_fd_sc_hd__ha_1
X$13362 VNB|VSS synth_1560 synth_1266 synth_1431 VDD synth_1484 VDD VNB|VSS
+ sky130_fd_sc_hd__ha_1
X$13363 VNB|VSS synth_9371 synth_9462 synth_9333 VDD synth_9463 VDD VNB|VSS
+ sky130_fd_sc_hd__ha_1
X$13364 VNB|VSS synth_5481 synth_5398 synth_5577 VDD synth_5578 VDD VNB|VSS
+ sky130_fd_sc_hd__ha_1
X$13365 VNB|VSS synth_12207 synth_12175 synth_12111 VDD synth_12130 VDD VNB|VSS
+ sky130_fd_sc_hd__ha_1
X$13366 VNB|VSS synth_8907 synth_8857 synth_8845 VDD synth_8861 VDD VNB|VSS
+ sky130_fd_sc_hd__ha_1
X$13367 VNB|VSS synth_6436 synth_6790 synth_6628 VDD synth_6581 VDD VNB|VSS
+ sky130_fd_sc_hd__ha_1
X$13368 VNB|VSS synth_832 synth_835 synth_834 VDD synth_777 VDD VNB|VSS
+ sky130_fd_sc_hd__ha_1
X$13369 VNB|VSS synth_4150 synth_4017 synth_4069 VDD synth_4068 VDD VNB|VSS
+ sky130_fd_sc_hd__ha_1
X$13370 VNB|VSS synth_9552 synth_9610 synth_9504 VDD synth_9554 VDD VNB|VSS
+ sky130_fd_sc_hd__ha_1
X$13371 VNB|VSS synth_789 synth_620 synth_716 VDD synth_718 VDD VNB|VSS
+ sky130_fd_sc_hd__ha_1
X$13372 VNB|VSS synth_3444 synth_3353 synth_3446 VDD synth_3445 VDD VNB|VSS
+ sky130_fd_sc_hd__ha_1
X$13373 VNB|VSS synth_11400 synth_11486 synth_11473 VDD synth_11490 VDD VNB|VSS
+ sky130_fd_sc_hd__ha_1
X$13374 VNB|VSS synth_175 synth_178 synth_176 VDD synth_311 VDD VNB|VSS
+ sky130_fd_sc_hd__ha_1
X$13375 VNB|VSS synth_10962 synth_10887 synth_10966 VDD synth_10924 VDD VNB|VSS
+ sky130_fd_sc_hd__ha_1
X$13376 VNB|VSS synth_12178 synth_12177 synth_12330 VDD synth_11958 VDD VNB|VSS
+ sky130_fd_sc_hd__ha_1
X$13377 VNB|VSS synth_9709 synth_9705 synth_9706 VDD synth_9643 VDD VNB|VSS
+ sky130_fd_sc_hd__ha_1
X$13378 VNB|VSS synth_525 synth_456 synth_497 VDD synth_425 VDD VNB|VSS
+ sky130_fd_sc_hd__ha_1
X$13379 VNB|VSS synth_11155 synth_11157 synth_11156 VDD synth_11239 VDD VNB|VSS
+ sky130_fd_sc_hd__ha_1
X$13380 VNB|VSS synth_11698 synth_11342 synth_11619 VDD synth_11620 VDD VNB|VSS
+ sky130_fd_sc_hd__ha_1
X$13381 VNB|VSS synth_8664 synth_8642 synth_8663 VDD synth_8592 VDD VNB|VSS
+ sky130_fd_sc_hd__ha_1
X$13382 VNB|VSS synth_8376 synth_8087 synth_8379 VDD synth_8296 VDD VNB|VSS
+ sky130_fd_sc_hd__ha_1
X$13383 VNB|VSS synth_7227 synth_7292 synth_7230 VDD synth_7229 VDD VNB|VSS
+ sky130_fd_sc_hd__ha_1
X$13384 VNB|VSS synth_9544 synth_9437 synth_9369 VDD synth_9521 VDD VNB|VSS
+ sky130_fd_sc_hd__ha_1
X$13385 VNB|VSS synth_11767 synth_11755 synth_11758 VDD synth_11757 VDD VNB|VSS
+ sky130_fd_sc_hd__ha_1
X$13386 VNB|VSS synth_3136 synth_3076 synth_3119 VDD synth_3133 VDD VNB|VSS
+ sky130_fd_sc_hd__ha_1
X$13387 VNB|VSS synth_8679 synth_8603 synth_8683 VDD synth_8680 VDD VNB|VSS
+ sky130_fd_sc_hd__ha_1
X$13388 VNB|VSS synth_7086 synth_7090 synth_7132 VDD synth_7053 VDD VNB|VSS
+ sky130_fd_sc_hd__ha_1
X$13389 VNB|VSS synth_3205 synth_3294 synth_3206 VDD synth_3132 VDD VNB|VSS
+ sky130_fd_sc_hd__ha_1
X$13390 VNB|VSS synth_7556 synth_7260 synth_7332 VDD synth_7331 VDD VNB|VSS
+ sky130_fd_sc_hd__ha_1
X$13391 VNB|VSS synth_6508 synth_6797 synth_6413 VDD synth_6366 VDD VNB|VSS
+ sky130_fd_sc_hd__ha_1
X$13392 VNB|VSS synth_2543 synth_2430 synth_2622 VDD synth_2558 VDD VNB|VSS
+ sky130_fd_sc_hd__ha_1
X$13393 VNB|VSS synth_11962 synth_12079 synth_11938 VDD synth_12012 VDD VNB|VSS
+ sky130_fd_sc_hd__ha_1
X$13394 VNB|VSS synth_7496 synth_7745 synth_7528 VDD synth_7527 VDD VNB|VSS
+ sky130_fd_sc_hd__ha_1
X$13395 VNB|VSS synth_8569 synth_8528 synth_8615 VDD synth_8529 VDD VNB|VSS
+ sky130_fd_sc_hd__ha_1
X$13396 VNB|VSS synth_7904 synth_7787 synth_7786 VDD synth_7785 VDD VNB|VSS
+ sky130_fd_sc_hd__ha_1
X$13397 VNB|VSS synth_131 synth_62 synth_129 VDD synth_130 VDD VNB|VSS
+ sky130_fd_sc_hd__ha_1
X$13398 VNB|VSS synth_3249 synth_3254 synth_3255 VDD synth_3252 VDD VNB|VSS
+ sky130_fd_sc_hd__ha_1
X$13399 VNB|VSS synth_1853 synth_1607 synth_1852 VDD synth_1783 VDD VNB|VSS
+ sky130_fd_sc_hd__ha_1
X$13400 VNB|VSS synth_9635 synth_9637 synth_9636 VDD synth_9713 VDD VNB|VSS
+ sky130_fd_sc_hd__ha_1
X$13401 VNB|VSS synth_10826 synth_10827 synth_10824 VDD synth_10267 VDD VNB|VSS
+ sky130_fd_sc_hd__ha_1
X$13402 VNB|VSS synth_790 synth_816 synth_791 VDD synth_709 VDD VNB|VSS
+ sky130_fd_sc_hd__ha_1
X$13403 VNB|VSS synth_11101 synth_11100 synth_11023 VDD synth_11037 VDD VNB|VSS
+ sky130_fd_sc_hd__ha_1
X$13404 VNB|VSS synth_10298 synth_10532 synth_10499 VDD synth_10498 VDD VNB|VSS
+ sky130_fd_sc_hd__ha_1
X$13405 VNB|VSS synth_12080 synth_11996 synth_12077 VDD synth_11888 VDD VNB|VSS
+ sky130_fd_sc_hd__ha_1
X$13406 VNB|VSS synth_10379 synth_10381 synth_10380 VDD synth_9543 VDD VNB|VSS
+ sky130_fd_sc_hd__ha_1
X$13407 VNB|VSS synth_9533 synth_9523 synth_9448 VDD synth_9524 VDD VNB|VSS
+ sky130_fd_sc_hd__ha_1
X$13408 VNB|VSS synth_2942 synth_3026 synth_2998 VDD synth_2999 VDD VNB|VSS
+ sky130_fd_sc_hd__ha_1
X$13409 VNB|VSS synth_12631 synth_12634 synth_12490 VDD synth_12633 VDD VNB|VSS
+ sky130_fd_sc_hd__ha_1
X$13410 VNB|VSS synth_11550 synth_11479 synth_11403 VDD synth_11406 VDD VNB|VSS
+ sky130_fd_sc_hd__ha_1
X$13411 VNB|VSS synth_6348 synth_5899 synth_6284 VDD synth_6283 VDD VNB|VSS
+ sky130_fd_sc_hd__ha_1
X$13412 VNB|VSS synth_8993 synth_9133 synth_9162 VDD synth_9163 VDD VNB|VSS
+ sky130_fd_sc_hd__ha_1
X$13413 VNB|VSS synth_6516 synth_5989 synth_6410 VDD synth_6409 VDD VNB|VSS
+ sky130_fd_sc_hd__ha_1
X$13414 VNB|VSS synth_9181 synth_9255 synth_9184 VDD synth_9183 VDD VNB|VSS
+ sky130_fd_sc_hd__ha_1
X$13415 VNB|VSS synth_3097 synth_2895 synth_3158 VDD synth_3020 VDD VNB|VSS
+ sky130_fd_sc_hd__ha_1
X$13416 VNB|VSS synth_5051 synth_5054 synth_5124 VDD synth_5123 VDD VNB|VSS
+ sky130_fd_sc_hd__ha_1
X$13417 VNB|VSS synth_11111 synth_11110 synth_11025 VDD synth_10879 VDD VNB|VSS
+ sky130_fd_sc_hd__ha_1
X$13418 VNB|VSS synth_3678 synth_3373 synth_3679 VDD synth_3606 VDD VNB|VSS
+ sky130_fd_sc_hd__ha_1
X$13419 VNB|VSS synth_11258 synth_11253 synth_11104 VDD synth_11189 VDD VNB|VSS
+ sky130_fd_sc_hd__ha_1
X$13420 VNB|VSS synth_9383 synth_9315 synth_9314 VDD synth_9418 VDD VNB|VSS
+ sky130_fd_sc_hd__ha_1
X$13421 VNB|VSS synth_7432 synth_7434 synth_7433 VDD synth_7349 VDD VNB|VSS
+ sky130_fd_sc_hd__ha_1
X$13422 VNB|VSS synth_4624 synth_4372 synth_4492 VDD synth_4534 VDD VNB|VSS
+ sky130_fd_sc_hd__ha_1
X$13423 VNB|VSS synth_769 synth_768 synth_689 VDD synth_690 VDD VNB|VSS
+ sky130_fd_sc_hd__ha_1
X$13424 VNB|VSS synth_11414 synth_11330 synth_11411 VDD synth_11343 VDD VNB|VSS
+ sky130_fd_sc_hd__ha_1
X$13425 VNB|VSS synth_2633 synth_2196 synth_2710 VDD synth_2709 VDD VNB|VSS
+ sky130_fd_sc_hd__ha_1
X$13426 VNB|VSS synth_6880 synth_6240 synth_6652 VDD synth_6778 VDD VNB|VSS
+ sky130_fd_sc_hd__ha_1
X$13427 VNB|VSS synth_8470 synth_8516 synth_8612 VDD synth_8521 VDD VNB|VSS
+ sky130_fd_sc_hd__ha_1
X$13428 VNB|VSS synth_10739 synth_10738 synth_10461 VDD synth_10737 VDD VNB|VSS
+ sky130_fd_sc_hd__ha_1
X$13429 VNB|VSS synth_4446 synth_4365 synth_4510 VDD synth_4563 VDD VNB|VSS
+ sky130_fd_sc_hd__ha_1
X$13430 VNB|VSS synth_10016 synth_10017 synth_9887 VDD synth_9198 VDD VNB|VSS
+ sky130_fd_sc_hd__ha_1
X$13431 VNB|VSS synth_3074 synth_2912 synth_3127 VDD synth_3128 VDD VNB|VSS
+ sky130_fd_sc_hd__ha_1
X$13432 VNB|VSS synth_5553 synth_5382 synth_5490 VDD synth_5588 VDD VNB|VSS
+ sky130_fd_sc_hd__ha_1
X$13433 VNB|VSS synth_9216 synth_9405 synth_9360 VDD synth_9361 VDD VNB|VSS
+ sky130_fd_sc_hd__ha_1
X$13434 VNB|VSS synth_10299 synth_10072 synth_10257 VDD synth_10331 VDD VNB|VSS
+ sky130_fd_sc_hd__ha_1
X$13435 VNB|VSS synth_4186 synth_4353 synth_4322 VDD synth_4418 VDD VNB|VSS
+ sky130_fd_sc_hd__ha_1
X$13436 VNB|VSS synth_4726 synth_4887 synth_4885 VDD synth_4886 VDD VNB|VSS
+ sky130_fd_sc_hd__ha_1
X$13437 VNB|VSS synth_11820 synth_11875 synth_11874 VDD synth_11679 VDD VNB|VSS
+ sky130_fd_sc_hd__ha_1
X$13438 VNB|VSS synth_945 synth_1024 synth_947 VDD synth_1025 VDD VNB|VSS
+ sky130_fd_sc_hd__ha_1
X$13439 VNB|VSS synth_10435 synth_10554 synth_10556 VDD synth_10557 VDD VNB|VSS
+ sky130_fd_sc_hd__ha_1
X$13440 VNB|VSS synth_7762 synth_7835 synth_7836 VDD synth_7834 VDD VNB|VSS
+ sky130_fd_sc_hd__ha_1
X$13441 VNB|VSS synth_4850 synth_4758 synth_4949 VDD synth_5027 VDD VNB|VSS
+ sky130_fd_sc_hd__ha_1
X$13442 VNB|VSS synth_10398 synth_10324 synth_10323 VDD synth_10322 VDD VNB|VSS
+ sky130_fd_sc_hd__ha_1
X$13443 VNB|VSS synth_6456 synth_6575 synth_6574 VDD synth_6576 VDD VNB|VSS
+ sky130_fd_sc_hd__ha_1
X$13444 VNB|VSS synth_10385 synth_10384 synth_10450 VDD synth_9093 VDD VNB|VSS
+ sky130_fd_sc_hd__ha_1
X$13445 VNB|VSS synth_11969 synth_11923 synth_12023 VDD synth_11970 VDD VNB|VSS
+ sky130_fd_sc_hd__ha_1
X$13446 VNB|VSS synth_5357 synth_5183 synth_5358 VDD synth_5182 VDD VNB|VSS
+ sky130_fd_sc_hd__ha_1
X$13447 VNB|VSS synth_11178 synth_11177 synth_11105 VDD synth_10524 VDD VNB|VSS
+ sky130_fd_sc_hd__ha_1
X$13448 VNB|VSS synth_5494 synth_5668 synth_5647 VDD synth_5648 VDD VNB|VSS
+ sky130_fd_sc_hd__ha_1
X$13449 VNB|VSS synth_12659 synth_12620 synth_12741 VDD synth_12773 VDD VNB|VSS
+ sky130_fd_sc_hd__ha_1
X$13450 VNB|VSS synth_6462 synth_6465 synth_6480 VDD synth_6463 VDD VNB|VSS
+ sky130_fd_sc_hd__ha_1
X$13451 VNB|VSS synth_10892 synth_10870 synth_10893 VDD synth_10896 VDD VNB|VSS
+ sky130_fd_sc_hd__ha_1
X$13452 VNB|VSS synth_6000 synth_6003 synth_6088 VDD synth_6002 VDD VNB|VSS
+ sky130_fd_sc_hd__ha_1
X$13453 VNB|VSS synth_11040 synth_11035 synth_11024 VDD synth_11036 VDD VNB|VSS
+ sky130_fd_sc_hd__ha_1
X$13454 VNB|VSS synth_85 synth_45 synth_124 VDD synth_125 VDD VNB|VSS
+ sky130_fd_sc_hd__ha_1
X$13455 VNB|VSS synth_3754 synth_3518 synth_3797 VDD synth_3733 VDD VNB|VSS
+ sky130_fd_sc_hd__ha_1
X$13456 VNB|VSS synth_11250 synth_11329 synth_11344 VDD synth_11205 VDD VNB|VSS
+ sky130_fd_sc_hd__ha_1
X$13457 VNB|VSS synth_6162 synth_5911 synth_6105 VDD synth_6321 VDD VNB|VSS
+ sky130_fd_sc_hd__ha_1
X$13458 VNB|VSS synth_162 synth_99 synth_299 VDD synth_302 VDD VNB|VSS
+ sky130_fd_sc_hd__ha_1
X$13459 VNB|VSS synth_1182 synth_1271 synth_1270 VDD synth_1333 VDD VNB|VSS
+ sky130_fd_sc_hd__ha_1
X$13460 VNB|VSS synth_8600 synth_8326 synth_8598 VDD synth_8597 VDD VNB|VSS
+ sky130_fd_sc_hd__ha_1
X$13461 VNB|VSS synth_2767 synth_2840 synth_2690 VDD synth_2841 VDD VNB|VSS
+ sky130_fd_sc_hd__ha_1
X$13462 VNB|VSS synth_11408 synth_11402 synth_11477 VDD synth_11339 VDD VNB|VSS
+ sky130_fd_sc_hd__ha_1
X$13463 VNB|VSS synth_7044 synth_6830 synth_6918 VDD synth_6851 VDD VNB|VSS
+ sky130_fd_sc_hd__ha_1
X$13464 VNB|VSS synth_3508 synth_3587 synth_3475 VDD synth_3586 VDD VNB|VSS
+ sky130_fd_sc_hd__ha_1
X$13465 VNB|VSS synth_10052 synth_9999 synth_10153 VDD synth_10154 VDD VNB|VSS
+ sky130_fd_sc_hd__ha_1
X$13466 VNB|VSS synth_8952 synth_8951 synth_8876 VDD synth_9097 VDD VNB|VSS
+ sky130_fd_sc_hd__ha_1
X$13467 VNB|VSS synth_11026 synth_10955 synth_11030 VDD synth_10877 VDD VNB|VSS
+ sky130_fd_sc_hd__ha_1
X$13468 VNB|VSS synth_671 synth_721 synth_722 VDD synth_615 VDD VNB|VSS
+ sky130_fd_sc_hd__ha_1
X$13469 VNB|VSS synth_1168 synth_1128 synth_1236 VDD synth_1235 VDD VNB|VSS
+ sky130_fd_sc_hd__ha_1
X$13470 VNB|VSS synth_8634 synth_8635 synth_8639 VDD synth_8733 VDD VNB|VSS
+ sky130_fd_sc_hd__ha_1
X$13471 VNB|VSS synth_319 synth_226 synth_318 VDD synth_80 VDD VNB|VSS
+ sky130_fd_sc_hd__ha_1
X$13472 VNB|VSS synth_3505 synth_3601 synth_3599 VDD synth_3603 VDD VNB|VSS
+ sky130_fd_sc_hd__ha_1
X$13473 VNB|VSS synth_4918 synth_5048 synth_4979 VDD synth_4919 VDD VNB|VSS
+ sky130_fd_sc_hd__ha_1
X$13474 VNB|VSS synth_8189 synth_8195 synth_8116 VDD synth_8265 VDD VNB|VSS
+ sky130_fd_sc_hd__ha_1
X$13475 VNB|VSS synth_2725 synth_2726 synth_2928 VDD synth_2774 VDD VNB|VSS
+ sky130_fd_sc_hd__ha_1
X$13476 VNB|VSS synth_10395 synth_10396 synth_10241 VDD synth_10188 VDD VNB|VSS
+ sky130_fd_sc_hd__ha_1
X$13477 VNB|VSS synth_10460 synth_10523 synth_10394 VDD synth_10524 VDD VNB|VSS
+ sky130_fd_sc_hd__ha_1
X$13478 VNB|VSS synth_6676 synth_6744 synth_6677 VDD synth_6745 VDD VNB|VSS
+ sky130_fd_sc_hd__ha_1
X$13479 VNB|VSS synth_10679 synth_10659 synth_10607 VDD synth_9275 VDD VNB|VSS
+ sky130_fd_sc_hd__ha_1
X$13480 VNB|VSS synth_7372 synth_7100 synth_7374 VDD synth_7463 VDD VNB|VSS
+ sky130_fd_sc_hd__ha_1
X$13481 VNB|VSS synth_5806 synth_5557 synth_5950 VDD synth_5949 VDD VNB|VSS
+ sky130_fd_sc_hd__ha_1
X$13482 VNB|VSS synth_646 synth_830 synth_702 VDD synth_643 VDD VNB|VSS
+ sky130_fd_sc_hd__ha_1
X$13483 VNB|VSS synth_8396 synth_8091 synth_8370 VDD synth_8418 VDD VNB|VSS
+ sky130_fd_sc_hd__ha_1
X$13484 VNB|VSS synth_11027 synth_11106 synth_10874 VDD synth_10954 VDD VNB|VSS
+ sky130_fd_sc_hd__ha_1
X$13485 VNB|VSS synth_7067 synth_6993 synth_7062 VDD synth_7041 VDD VNB|VSS
+ sky130_fd_sc_hd__ha_1
X$13486 VNB|VSS synth_3377 synth_3220 synth_3442 VDD synth_3443 VDD VNB|VSS
+ sky130_fd_sc_hd__ha_1
X$13487 VNB|VSS synth_4266 synth_4268 synth_4348 VDD synth_4349 VDD VNB|VSS
+ sky130_fd_sc_hd__ha_1
X$13488 VNB|VSS synth_3176 synth_3237 synth_3235 VDD synth_3177 VDD VNB|VSS
+ sky130_fd_sc_hd__ha_1
X$13489 VNB|VSS synth_2203 synth_2242 synth_2244 VDD synth_2246 VDD VNB|VSS
+ sky130_fd_sc_hd__ha_1
X$13490 VNB|VSS synth_2736 synth_2668 synth_2737 VDD synth_2817 VDD VNB|VSS
+ sky130_fd_sc_hd__ha_1
X$13491 VNB|VSS synth_1064 synth_1131 synth_1157 VDD synth_1130 VDD VNB|VSS
+ sky130_fd_sc_hd__ha_1
X$13492 VNB|VSS synth_2217 synth_2365 synth_2364 VDD synth_2363 VDD VNB|VSS
+ sky130_fd_sc_hd__ha_1
X$13493 VNB|VSS synth_11201 synth_11046 synth_11268 VDD synth_11196 VDD VNB|VSS
+ sky130_fd_sc_hd__ha_1
X$13494 VNB|VSS synth_10595 synth_10666 synth_10592 VDD synth_10590 VDD VNB|VSS
+ sky130_fd_sc_hd__ha_1
X$13495 VNB|VSS synth_7238 synth_7326 synth_7239 VDD synth_7308 VDD VNB|VSS
+ sky130_fd_sc_hd__ha_1
X$13496 VNB|VSS synth_1466 synth_1303 synth_1387 VDD synth_1379 VDD VNB|VSS
+ sky130_fd_sc_hd__ha_1
X$13497 VNB|VSS synth_389 synth_430 synth_411 VDD synth_362 VDD VNB|VSS
+ sky130_fd_sc_hd__ha_1
X$13498 VNB|VSS synth_3853 synth_3746 synth_3813 VDD synth_3855 VDD VNB|VSS
+ sky130_fd_sc_hd__ha_1
X$13499 VNB|VSS synth_11998 synth_12058 synth_11999 VDD synth_12076 VDD VNB|VSS
+ sky130_fd_sc_hd__ha_1
X$13500 VNB|VSS synth_3324 synth_3619 synth_3287 VDD synth_3423 VDD VNB|VSS
+ sky130_fd_sc_hd__ha_1
X$13501 VNB|VSS synth_113 synth_243 synth_228 VDD synth_292 VDD VNB|VSS
+ sky130_fd_sc_hd__ha_1
X$13502 VNB|VSS synth_1060 synth_733 synth_1154 VDD synth_1098 VDD VNB|VSS
+ sky130_fd_sc_hd__ha_1
X$13503 VNB|VSS synth_1992 synth_1823 synth_1976 VDD synth_1987 VDD VNB|VSS
+ sky130_fd_sc_hd__ha_1
X$13504 VNB|VSS synth_8454 synth_8540 synth_8591 VDD synth_8589 VDD VNB|VSS
+ sky130_fd_sc_hd__ha_1
X$13505 VNB|VSS synth_11601 synth_11566 synth_11624 VDD synth_11779 VDD VNB|VSS
+ sky130_fd_sc_hd__ha_1
X$13506 VNB|VSS synth_1050 synth_992 synth_1049 VDD synth_1048 VDD VNB|VSS
+ sky130_fd_sc_hd__ha_1
X$13507 VNB|VSS synth_2285 synth_2354 synth_2382 VDD synth_2381 VDD VNB|VSS
+ sky130_fd_sc_hd__ha_1
X$13508 VNB|VSS synth_905 synth_988 synth_985 VDD synth_1046 VDD VNB|VSS
+ sky130_fd_sc_hd__ha_1
X$13509 VNB|VSS synth_8037 synth_7848 synth_8039 VDD synth_8129 VDD VNB|VSS
+ sky130_fd_sc_hd__ha_1
X$13510 VNB|VSS synth_8568 synth_8487 synth_8338 VDD synth_8565 VDD VNB|VSS
+ sky130_fd_sc_hd__ha_1
X$13511 VNB|VSS synth_11772 synth_11891 synth_11834 VDD synth_11892 VDD VNB|VSS
+ sky130_fd_sc_hd__ha_1
X$13512 VNB|VSS synth_11543 synth_11544 synth_11680 VDD synth_11541 VDD VNB|VSS
+ sky130_fd_sc_hd__ha_1
X$13513 VNB|VSS synth_1216 synth_1286 synth_1288 VDD synth_1318 VDD VNB|VSS
+ sky130_fd_sc_hd__ha_1
X$13514 VNB|VSS synth_7905 synth_8064 synth_8030 VDD synth_7982 VDD VNB|VSS
+ sky130_fd_sc_hd__ha_1
X$13515 VNB|VSS synth_12534 synth_12319 synth_12535 VDD synth_12538 VDD VNB|VSS
+ sky130_fd_sc_hd__ha_1
X$13516 VNB|VSS synth_7380 synth_7319 synth_7510 VDD synth_7511 VDD VNB|VSS
+ sky130_fd_sc_hd__ha_1
X$13517 VNB|VSS synth_10427 synth_10428 synth_10471 VDD synth_10472 VDD VNB|VSS
+ sky130_fd_sc_hd__ha_1
X$13518 VNB|VSS synth_9243 synth_9244 synth_9178 VDD synth_9373 VDD VNB|VSS
+ sky130_fd_sc_hd__ha_1
X$13519 VNB|VSS synth_8571 synth_8566 synth_8407 VDD synth_8570 VDD VNB|VSS
+ sky130_fd_sc_hd__ha_1
X$13520 VNB|VSS synth_2683 synth_2447 synth_2557 VDD synth_2644 VDD VNB|VSS
+ sky130_fd_sc_hd__ha_1
X$13521 VNB|VSS synth_9837 synth_9987 synth_9954 VDD synth_9953 VDD VNB|VSS
+ sky130_fd_sc_hd__ha_1
X$13522 VNB|VSS synth_11704 synth_11756 synth_11686 VDD synth_11044 VDD VNB|VSS
+ sky130_fd_sc_hd__ha_1
X$13523 VNB|VSS synth_1568 synth_1730 synth_1692 VDD synth_1733 VDD VNB|VSS
+ sky130_fd_sc_hd__ha_1
X$13524 VNB|VSS synth_10110 synth_10112 synth_10111 VDD synth_10109 VDD VNB|VSS
+ sky130_fd_sc_hd__ha_1
X$13525 VNB|VSS synth_9862 synth_9863 synth_9779 VDD synth_9543 VDD VNB|VSS
+ sky130_fd_sc_hd__ha_1
X$13526 VNB|VSS synth_5640 synth_5680 synth_5681 VDD synth_5767 VDD VNB|VSS
+ sky130_fd_sc_hd__ha_1
X$13527 VNB|VSS synth_12063 synth_12034 synth_12121 VDD synth_12122 VDD VNB|VSS
+ sky130_fd_sc_hd__ha_1
X$13528 VNB|VSS synth_1801 synth_1932 synth_1930 VDD synth_1931 VDD VNB|VSS
+ sky130_fd_sc_hd__ha_1
X$13529 VNB|VSS synth_3850 synth_3851 synth_3812 VDD synth_3917 VDD VNB|VSS
+ sky130_fd_sc_hd__ha_1
X$13530 VNB|VSS synth_7820 synth_7481 synth_7822 VDD synth_7821 VDD VNB|VSS
+ sky130_fd_sc_hd__ha_1
X$13531 VNB|VSS synth_6288 synth_6395 synth_6352 VDD synth_6353 VDD VNB|VSS
+ sky130_fd_sc_hd__ha_1
X$13532 VNB|VSS synth_9777 synth_10015 synth_9778 VDD synth_9727 VDD VNB|VSS
+ sky130_fd_sc_hd__ha_1
X$13533 VNB|VSS synth_711 synth_561 synth_714 VDD synth_747 VDD VNB|VSS
+ sky130_fd_sc_hd__ha_1
X$13534 VNB|VSS synth_12853 synth_7437 synth_7608 VDD synth_7677 VDD VNB|VSS
+ sky130_fd_sc_hd__ha_1
X$13535 VNB|VSS synth_2640 synth_2412 synth_2676 VDD synth_2677 VDD VNB|VSS
+ sky130_fd_sc_hd__ha_1
X$13536 VNB|VSS synth_8821 synth_8895 synth_8789 VDD synth_8788 VDD VNB|VSS
+ sky130_fd_sc_hd__ha_1
X$13537 VNB|VSS synth_6707 synth_6737 synth_6661 VDD synth_6660 VDD VNB|VSS
+ sky130_fd_sc_hd__ha_1
X$13538 VNB|VSS synth_8483 synth_8485 synth_8406 VDD synth_8717 VDD VNB|VSS
+ sky130_fd_sc_hd__ha_1
X$13539 VNB|VSS synth_10707 synth_10425 synth_10708 VDD synth_10832 VDD VNB|VSS
+ sky130_fd_sc_hd__ha_1
X$13540 VNB|VSS synth_9787 synth_9708 synth_9638 VDD synth_9949 VDD VNB|VSS
+ sky130_fd_sc_hd__ha_1
X$13541 VNB|VSS synth_12692 synth_12326 synth_12714 VDD synth_12693 VDD VNB|VSS
+ sky130_fd_sc_hd__ha_1
X$13542 VNB|VSS synth_7627 synth_7626 synth_7583 VDD synth_7546 VDD VNB|VSS
+ sky130_fd_sc_hd__ha_1
X$13543 VNB|VSS synth_7355 synth_7359 synth_7358 VDD synth_7357 VDD VNB|VSS
+ sky130_fd_sc_hd__ha_1
X$13544 VNB|VSS synth_4408 synth_4013 synth_4263 VDD synth_4180 VDD VNB|VSS
+ sky130_fd_sc_hd__ha_1
X$13545 VNB|VSS synth_2313 synth_2403 synth_2405 VDD synth_2521 VDD VNB|VSS
+ sky130_fd_sc_hd__ha_1
X$13546 VNB|VSS synth_8404 synth_8405 synth_8335 VDD synth_9183 VDD VNB|VSS
+ sky130_fd_sc_hd__ha_1
X$13547 VNB|VSS synth_11482 synth_11655 synth_11615 VDD synth_11614 VDD VNB|VSS
+ sky130_fd_sc_hd__ha_1
X$13548 VNB|VSS synth_5682 synth_5685 synth_5684 VDD synth_5683 VDD VNB|VSS
+ sky130_fd_sc_hd__ha_1
X$13549 VNB|VSS synth_1343 synth_1253 synth_1475 VDD synth_1476 VDD VNB|VSS
+ sky130_fd_sc_hd__ha_1
X$13550 VNB|VSS synth_3305 synth_3392 synth_3347 VDD synth_3467 VDD VNB|VSS
+ sky130_fd_sc_hd__ha_1
X$13551 VNB|VSS synth_6666 synth_6670 synth_6643 VDD synth_6669 VDD VNB|VSS
+ sky130_fd_sc_hd__ha_1
X$13552 VNB|VSS synth_4773 synth_4582 synth_4868 VDD synth_4906 VDD VNB|VSS
+ sky130_fd_sc_hd__ha_1
X$13553 VNB|VSS synth_8245 synth_8168 synth_8511 VDD synth_8320 VDD VNB|VSS
+ sky130_fd_sc_hd__ha_1
X$13554 VNB|VSS synth_143 synth_84 synth_144 VDD synth_187 VDD VNB|VSS
+ sky130_fd_sc_hd__ha_1
X$13555 VNB|VSS synth_12390 synth_12497 synth_12444 VDD synth_12496 VDD VNB|VSS
+ sky130_fd_sc_hd__ha_1
X$13556 VNB|VSS synth_5788 synth_5791 synth_5923 VDD synth_5922 VDD VNB|VSS
+ sky130_fd_sc_hd__ha_1
X$13557 VNB|VSS synth_4525 synth_4594 synth_4661 VDD synth_4733 VDD VNB|VSS
+ sky130_fd_sc_hd__ha_1
X$13558 VNB|VSS synth_4057 synth_3974 synth_4038 VDD synth_3973 VDD VNB|VSS
+ sky130_fd_sc_hd__ha_1
X$13559 VNB|VSS synth_11181 synth_10991 synth_11145 VDD synth_11184 VDD VNB|VSS
+ sky130_fd_sc_hd__ha_1
X$13560 VNB|VSS synth_8638 synth_8672 synth_8556 VDD synth_8731 VDD VNB|VSS
+ sky130_fd_sc_hd__ha_1
X$13561 VNB|VSS synth_7986 synth_8117 synth_8119 VDD synth_8120 VDD VNB|VSS
+ sky130_fd_sc_hd__ha_1
X$13562 VNB|VSS synth_5348 synth_5509 synth_5379 VDD synth_5378 VDD VNB|VSS
+ sky130_fd_sc_hd__ha_1
X$13563 VNB|VSS synth_9940 synth_9939 synth_9782 VDD synth_9093 VDD VNB|VSS
+ sky130_fd_sc_hd__ha_1
X$13564 VNB|VSS synth_12501 synth_12289 synth_12610 VDD synth_12609 VDD VNB|VSS
+ sky130_fd_sc_hd__ha_1
X$13565 VNB|VSS synth_3870 synth_3800 synth_3825 VDD synth_3802 VDD VNB|VSS
+ sky130_fd_sc_hd__ha_1
X$13566 VNB|VSS synth_7384 synth_7564 synth_7478 VDD synth_7521 VDD VNB|VSS
+ sky130_fd_sc_hd__ha_1
X$13567 VNB|VSS synth_9321 synth_9425 synth_9424 VDD synth_9564 VDD VNB|VSS
+ sky130_fd_sc_hd__ha_1
X$13568 VNB|VSS synth_12492 synth_12461 synth_12494 VDD synth_12493 VDD VNB|VSS
+ sky130_fd_sc_hd__ha_1
X$13569 VNB|VSS synth_11241 synth_11284 synth_11355 VDD synth_11354 VDD VNB|VSS
+ sky130_fd_sc_hd__ha_1
X$13570 VNB|VSS synth_3949 synth_4077 synth_3880 VDD synth_4029 VDD VNB|VSS
+ sky130_fd_sc_hd__ha_1
X$13571 VNB|VSS synth_2648 synth_2581 synth_2580 VDD synth_2649 VDD VNB|VSS
+ sky130_fd_sc_hd__ha_1
X$13572 VNB|VSS synth_8763 synth_8780 synth_8838 VDD synth_8781 VDD VNB|VSS
+ sky130_fd_sc_hd__ha_1
X$13573 VNB|VSS synth_12197 synth_12127 synth_12255 VDD synth_12180 VDD VNB|VSS
+ sky130_fd_sc_hd__ha_1
X$13574 VNB|VSS synth_9866 synth_9797 synth_9718 VDD synth_9522 VDD VNB|VSS
+ sky130_fd_sc_hd__ha_1
X$13575 VNB|VSS synth_1528 synth_1530 synth_1542 VDD synth_1529 VDD VNB|VSS
+ sky130_fd_sc_hd__ha_1
X$13576 VNB|VSS synth_10903 synth_10715 synth_10908 VDD synth_10909 VDD VNB|VSS
+ sky130_fd_sc_hd__ha_1
X$13577 VNB|VSS synth_4736 synth_4813 synth_4737 VDD synth_4715 VDD VNB|VSS
+ sky130_fd_sc_hd__ha_1
X$13578 VNB|VSS synth_9526 synth_9443 synth_9593 VDD synth_9648 VDD VNB|VSS
+ sky130_fd_sc_hd__ha_1
X$13579 VNB|VSS synth_7854 synth_7855 synth_7831 VDD synth_7972 VDD VNB|VSS
+ sky130_fd_sc_hd__ha_1
X$13580 VNB|VSS synth_1796 synth_1878 synth_1920 VDD synth_1921 VDD VNB|VSS
+ sky130_fd_sc_hd__ha_1
X$13581 VNB|VSS synth_9094 synth_9070 synth_9143 VDD synth_9198 VDD VNB|VSS
+ sky130_fd_sc_hd__ha_1
X$13582 VNB|VSS synth_5058 synth_5060 synth_5059 VDD synth_5099 VDD VNB|VSS
+ sky130_fd_sc_hd__ha_1
X$13583 VNB|VSS synth_12074 synth_11959 synth_12132 VDD synth_12078 VDD VNB|VSS
+ sky130_fd_sc_hd__ha_1
X$13584 VNB|VSS synth_7083 synth_7031 synth_7006 VDD synth_6971 VDD VNB|VSS
+ sky130_fd_sc_hd__ha_1
X$13585 VNB|VSS synth_12854 synth_7746 synth_7608 VDD synth_7818 VDD VNB|VSS
+ sky130_fd_sc_hd__ha_1
X$13586 VNB|VSS synth_2024 synth_1807 synth_1958 VDD synth_1960 VDD VNB|VSS
+ sky130_fd_sc_hd__ha_1
X$13587 VNB|VSS synth_9602 synth_9356 synth_9439 VDD synth_9358 VDD VNB|VSS
+ sky130_fd_sc_hd__ha_1
X$13588 VNB|VSS synth_10432 synth_10507 synth_10433 VDD synth_10551 VDD VNB|VSS
+ sky130_fd_sc_hd__ha_1
X$13589 VNB|VSS synth_12736 synth_12567 synth_12787 VDD synth_12788 VDD VNB|VSS
+ sky130_fd_sc_hd__ha_1
X$13590 VNB|VSS synth_7664 synth_7796 synth_7830 VDD synth_7829 VDD VNB|VSS
+ sky130_fd_sc_hd__ha_1
X$13591 VNB|VSS synth_6267 synth_6263 synth_6266 VDD synth_6265 VDD VNB|VSS
+ sky130_fd_sc_hd__ha_1
X$13592 VNB|VSS synth_9253 synth_9126 synth_9254 VDD synth_9358 VDD VNB|VSS
+ sky130_fd_sc_hd__ha_1
X$13593 VNB|VSS synth_9996 synth_9998 synth_10146 VDD synth_10148 VDD VNB|VSS
+ sky130_fd_sc_hd__ha_1
X$13594 VNB|VSS synth_12090 synth_12229 synth_12147 VDD synth_12150 VDD VNB|VSS
+ sky130_fd_sc_hd__ha_1
X$13595 VNB|VSS synth_724 synth_617 synth_731 VDD synth_729 VDD VNB|VSS
+ sky130_fd_sc_hd__ha_1
X$13596 VNB|VSS synth_3776 synth_3843 synth_3842 VDD synth_3845 VDD VNB|VSS
+ sky130_fd_sc_hd__ha_1
X$13597 VNB|VSS synth_9653 synth_9650 synth_9649 VDD synth_9651 VDD VNB|VSS
+ sky130_fd_sc_hd__ha_1
X$13598 VNB|VSS synth_5417 synth_5339 synth_5476 VDD synth_5475 VDD VNB|VSS
+ sky130_fd_sc_hd__ha_1
X$13599 VNB|VSS synth_3867 synth_3971 synth_3865 VDD synth_3864 VDD VNB|VSS
+ sky130_fd_sc_hd__ha_1
X$13600 VNB|VSS synth_2321 synth_2553 synth_2494 VDD synth_2495 VDD VNB|VSS
+ sky130_fd_sc_hd__ha_1
X$13601 VNB|VSS synth_1647 synth_1446 synth_1774 VDD synth_1772 VDD VNB|VSS
+ sky130_fd_sc_hd__ha_1
X$13602 VDD synth_4317 VDD synth_4265 VNB|VSS VNB|VSS
+ sky130_fd_sc_hd__dlygate4sd3_1
X$13603 VDD synth_4565 VDD synth_4316 VNB|VSS VNB|VSS
+ sky130_fd_sc_hd__dlygate4sd3_1
X$13604 VDD synth_6755 VDD synth_6485 VNB|VSS VNB|VSS
+ sky130_fd_sc_hd__dlygate4sd3_1
X$13605 VDD synth_4488 VDD synth_4570 VNB|VSS VNB|VSS
+ sky130_fd_sc_hd__dlygate4sd3_1
X$13606 VDD synth_7243 VDD synth_7245 VNB|VSS VNB|VSS
+ sky130_fd_sc_hd__dlygate4sd3_1
X$13607 VDD synth_6857 VDD synth_6983 VNB|VSS VNB|VSS
+ sky130_fd_sc_hd__dlygate4sd3_1
X$13608 VDD synth_5873 VDD synth_6046 VNB|VSS VNB|VSS
+ sky130_fd_sc_hd__dlygate4sd3_1
X$13609 VDD load_data[0] VDD synth_5917 VNB|VSS VNB|VSS
+ sky130_fd_sc_hd__dlygate4sd3_1
X$13610 VDD synth_2220 VDD synth_2215 VNB|VSS VNB|VSS
+ sky130_fd_sc_hd__dlygate4sd3_1
X$13611 VDD synth_6070 VDD synth_6208 VNB|VSS VNB|VSS
+ sky130_fd_sc_hd__dlygate4sd3_1
X$13612 VDD synth_11609 VDD synth_11522 VNB|VSS VNB|VSS
+ sky130_fd_sc_hd__dlygate4sd3_1
X$13613 VDD synth_5390 VDD synth_5498 VNB|VSS VNB|VSS
+ sky130_fd_sc_hd__dlygate4sd3_1
X$13614 VDD synth_5920 VDD synth_5787 VNB|VSS VNB|VSS
+ sky130_fd_sc_hd__dlygate4sd3_1
X$13615 VDD synth_1905 VDD synth_1831 VNB|VSS VNB|VSS
+ sky130_fd_sc_hd__dlygate4sd3_1
X$13616 VDD synth_7113 VDD synth_7169 VNB|VSS VNB|VSS
+ sky130_fd_sc_hd__dlygate4sd3_1
X$13617 VDD synth_4855 VDD synth_4856 VNB|VSS VNB|VSS
+ sky130_fd_sc_hd__dlygate4sd3_1
X$13618 VDD synth_3912 VDD synth_3710 VNB|VSS VNB|VSS
+ sky130_fd_sc_hd__dlygate4sd3_1
X$13619 VDD synth_9194 VDD synth_9190 VNB|VSS VNB|VSS
+ sky130_fd_sc_hd__dlygate4sd3_1
X$13620 VDD synth_7976 VDD synth_8224 VNB|VSS VNB|VSS
+ sky130_fd_sc_hd__dlygate4sd3_1
X$13621 VDD synth_12439 VDD synth_12552 VNB|VSS VNB|VSS
+ sky130_fd_sc_hd__dlygate4sd3_1
X$13622 VDD synth_2069 VDD synth_2068 VNB|VSS VNB|VSS
+ sky130_fd_sc_hd__dlygate4sd3_1
X$13623 VDD synth_3941 VDD synth_3891 VNB|VSS VNB|VSS
+ sky130_fd_sc_hd__dlygate4sd3_1
X$13624 VDD synth_3792 VDD synth_3731 VNB|VSS VNB|VSS
+ sky130_fd_sc_hd__dlygate4sd3_1
X$13625 VDD synth_4073 VDD synth_4156 VNB|VSS VNB|VSS
+ sky130_fd_sc_hd__dlygate4sd3_1
X$13626 VDD synth_2899 VDD synth_2902 VNB|VSS VNB|VSS
+ sky130_fd_sc_hd__dlygate4sd3_1
X$13627 VDD synth_6122 VDD synth_5978 VNB|VSS VNB|VSS
+ sky130_fd_sc_hd__dlygate4sd3_1
X$13628 VDD synth_2451 VDD synth_2384 VNB|VSS VNB|VSS
+ sky130_fd_sc_hd__dlygate4sd3_1
X$13629 VDD synth_3355 VDD synth_3441 VNB|VSS VNB|VSS
+ sky130_fd_sc_hd__dlygate4sd3_1
X$13630 VDD synth_1055 VDD synth_1054 VNB|VSS VNB|VSS
+ sky130_fd_sc_hd__dlygate4sd3_1
X$13631 VDD synth_5305 VDD synth_5119 VNB|VSS VNB|VSS
+ sky130_fd_sc_hd__dlygate4sd3_1
X$13632 VDD synth_6923 VDD synth_6847 VNB|VSS VNB|VSS
+ sky130_fd_sc_hd__dlygate4sd3_1
X$13633 VDD synth_7842 VDD synth_7633 VNB|VSS VNB|VSS
+ sky130_fd_sc_hd__dlygate4sd3_1
X$13634 VDD synth_6206 VDD synth_6203 VNB|VSS VNB|VSS
+ sky130_fd_sc_hd__dlygate4sd3_1
X$13635 VDD synth_6468 VDD synth_6389 VNB|VSS VNB|VSS
+ sky130_fd_sc_hd__dlygate4sd3_1
X$13636 VDD synth_7845 VDD synth_7768 VNB|VSS VNB|VSS
+ sky130_fd_sc_hd__dlygate4sd3_1
X$13637 VDD synth_10540 VDD synth_10569 VNB|VSS VNB|VSS
+ sky130_fd_sc_hd__dlygate4sd3_1
X$13638 VDD synth_5302 VDD synth_5219 VNB|VSS VNB|VSS
+ sky130_fd_sc_hd__dlygate4sd3_1
X$13639 VDD synth_8410 VDD synth_8577 VNB|VSS VNB|VSS
+ sky130_fd_sc_hd__dlygate4sd3_1
X$13640 VDD synth_2838 VDD synth_2921 VNB|VSS VNB|VSS
+ sky130_fd_sc_hd__dlygate4sd3_1
X$13641 VDD synth_5541 VDD synth_5334 VNB|VSS VNB|VSS
+ sky130_fd_sc_hd__dlygate4sd3_1
X$13642 VDD synth_10253 VDD synth_10254 VNB|VSS VNB|VSS
+ sky130_fd_sc_hd__dlygate4sd3_1
X$13643 VDD synth_3420 VDD synth_3422 VNB|VSS VNB|VSS
+ sky130_fd_sc_hd__dlygate4sd3_1
X$13644 VDD load_data[1] VDD synth_4381 VNB|VSS VNB|VSS
+ sky130_fd_sc_hd__dlygate4sd3_1
X$13645 VDD synth_4124 VDD synth_4078 VNB|VSS VNB|VSS
+ sky130_fd_sc_hd__dlygate4sd3_1
X$13646 VDD synth_6270 VDD synth_6304 VNB|VSS VNB|VSS
+ sky130_fd_sc_hd__dlygate4sd3_1
X$13647 VDD synth_12141 VDD synth_12225 VNB|VSS VNB|VSS
+ sky130_fd_sc_hd__dlygate4sd3_1
X$13648 VDD synth_3354 VDD synth_3357 VNB|VSS VNB|VSS
+ sky130_fd_sc_hd__dlygate4sd3_1
X$13649 VDD synth_5189 VDD synth_5190 VNB|VSS VNB|VSS
+ sky130_fd_sc_hd__dlygate4sd3_1
X$13650 VDD synth_3440 VDD synth_3526 VNB|VSS VNB|VSS
+ sky130_fd_sc_hd__dlygate4sd3_1
X$13651 VDD synth_6074 VDD synth_6058 VNB|VSS VNB|VSS
+ sky130_fd_sc_hd__dlygate4sd3_1
X$13652 VDD synth_7678 VDD synth_7679 VNB|VSS VNB|VSS
+ sky130_fd_sc_hd__dlygate4sd3_1
X$13653 VDD synth_1916 VDD synth_1991 VNB|VSS VNB|VSS
+ sky130_fd_sc_hd__dlygate4sd3_1
X$13654 VDD synth_2772 VDD synth_2656 VNB|VSS VNB|VSS
+ sky130_fd_sc_hd__dlygate4sd3_1
X$13655 VDD synth_6523 VDD synth_6679 VNB|VSS VNB|VSS
+ sky130_fd_sc_hd__dlygate4sd3_1
X$13656 VDD synth_5731 VDD synth_5930 VNB|VSS VNB|VSS
+ sky130_fd_sc_hd__dlygate4sd3_1
X$13657 VDD synth_5868 VDD synth_6054 VNB|VSS VNB|VSS
+ sky130_fd_sc_hd__dlygate4sd3_1
X$13658 VDD synth_4470 VDD synth_4579 VNB|VSS VNB|VSS
+ sky130_fd_sc_hd__dlygate4sd3_1
X$13659 VDD synth_5861 VDD synth_6029 VNB|VSS VNB|VSS
+ sky130_fd_sc_hd__dlygate4sd3_1
X$13660 VDD synth_3725 VDD synth_3675 VNB|VSS VNB|VSS
+ sky130_fd_sc_hd__dlygate4sd3_1
X$13661 VDD synth_2066 VDD synth_1980 VNB|VSS VNB|VSS
+ sky130_fd_sc_hd__dlygate4sd3_1
X$13662 VDD synth_7037 VDD synth_7148 VNB|VSS VNB|VSS
+ sky130_fd_sc_hd__dlygate4sd3_1
X$13663 VDD synth_5656 VDD synth_5860 VNB|VSS VNB|VSS
+ sky130_fd_sc_hd__dlygate4sd3_1
X$13664 VDD start VDD synth_8201 VNB|VSS VNB|VSS sky130_fd_sc_hd__dlygate4sd3_1
X$13665 VDD synth_7150 VDD synth_6994 VNB|VSS VNB|VSS
+ sky130_fd_sc_hd__dlygate4sd3_1
X$13666 VDD synth_8044 VDD synth_8212 VNB|VSS VNB|VSS
+ sky130_fd_sc_hd__dlygate4sd3_1
X$13667 VDD synth_7365 VDD synth_8217 VNB|VSS VNB|VSS
+ sky130_fd_sc_hd__dlygate4sd3_1
X$13668 VDD synth_8606 VDD synth_8632 VNB|VSS VNB|VSS
+ sky130_fd_sc_hd__dlygate4sd3_1
X$13669 VDD synth_6338 VDD synth_6368 VNB|VSS VNB|VSS
+ sky130_fd_sc_hd__dlygate4sd3_1
X$13670 VDD synth_8214 VDD synth_8378 VNB|VSS VNB|VSS
+ sky130_fd_sc_hd__dlygate4sd3_1
X$13671 VDD synth_8274 VDD synth_8353 VNB|VSS VNB|VSS
+ sky130_fd_sc_hd__dlygate4sd3_1
X$13672 VDD synth_10749 VDD synth_10963 VNB|VSS VNB|VSS
+ sky130_fd_sc_hd__dlygate4sd3_1
X$13673 VDD synth_6552 VDD synth_6656 VNB|VSS VNB|VSS
+ sky130_fd_sc_hd__dlygate4sd3_1
X$13674 VDD synth_1594 VDD synth_1665 VNB|VSS VNB|VSS
+ sky130_fd_sc_hd__dlygate4sd3_1
X$13675 VDD synth_2903 VDD synth_2808 VNB|VSS VNB|VSS
+ sky130_fd_sc_hd__dlygate4sd3_1
X$13676 VDD synth_5335 VDD synth_5234 VNB|VSS VNB|VSS
+ sky130_fd_sc_hd__dlygate4sd3_1
X$13677 VDD synth_5113 VDD synth_5112 VNB|VSS VNB|VSS
+ sky130_fd_sc_hd__dlygate4sd3_1
X$13678 VDD synth_6032 VDD synth_6195 VNB|VSS VNB|VSS
+ sky130_fd_sc_hd__dlygate4sd3_1
X$13679 VDD synth_4496 VDD synth_4447 VNB|VSS VNB|VSS
+ sky130_fd_sc_hd__dlygate4sd3_1
X$13680 VDD synth_8099 VDD synth_8187 VNB|VSS VNB|VSS
+ sky130_fd_sc_hd__dlygate4sd3_1
X$13681 VDD synth_3811 VDD synth_3810 VNB|VSS VNB|VSS
+ sky130_fd_sc_hd__dlygate4sd3_1
X$13682 VDD synth_6121 VDD synth_6453 VNB|VSS VNB|VSS
+ sky130_fd_sc_hd__dlygate4sd3_1
X$13683 VDD synth_2226 VDD synth_2227 VNB|VSS VNB|VSS
+ sky130_fd_sc_hd__dlygate4sd3_1
X$13684 VDD synth_6350 VDD synth_6376 VNB|VSS VNB|VSS
+ sky130_fd_sc_hd__dlygate4sd3_1
X$13685 VDD synth_6529 VDD synth_6551 VNB|VSS VNB|VSS
+ sky130_fd_sc_hd__dlygate4sd3_1
X$13686 VDD synth_1614 VDD synth_1678 VNB|VSS VNB|VSS
+ sky130_fd_sc_hd__dlygate4sd3_1
X$13687 VDD synth_7532 VDD synth_7613 VNB|VSS VNB|VSS
+ sky130_fd_sc_hd__dlygate4sd3_1
X$13688 VDD synth_5736 VDD synth_5859 VNB|VSS VNB|VSS
+ sky130_fd_sc_hd__dlygate4sd3_1
X$13689 VDD synth_12013 VDD synth_11845 VNB|VSS VNB|VSS
+ sky130_fd_sc_hd__dlygate4sd3_1
X$13690 VDD synth_5532 VDD synth_5246 VNB|VSS VNB|VSS
+ sky130_fd_sc_hd__dlygate4sd3_1
X$13691 VDD synth_2555 VDD synth_2594 VNB|VSS VNB|VSS
+ sky130_fd_sc_hd__dlygate4sd3_1
X$13692 VDD synth_1896 VDD synth_1547 VNB|VSS VNB|VSS
+ sky130_fd_sc_hd__dlygate4sd3_1
X$13693 VDD synth_5486 VDD synth_5199 VNB|VSS VNB|VSS
+ sky130_fd_sc_hd__dlygate4sd3_1
X$13694 VDD synth_7967 VDD synth_8089 VNB|VSS VNB|VSS
+ sky130_fd_sc_hd__dlygate4sd3_1
X$13695 VDD synth_2247 VDD synth_2206 VNB|VSS VNB|VSS
+ sky130_fd_sc_hd__dlygate4sd3_1
X$13696 VDD synth_4898 VDD synth_5044 VNB|VSS VNB|VSS
+ sky130_fd_sc_hd__dlygate4sd3_1
X$13697 VDD synth_3745 VDD synth_3758 VNB|VSS VNB|VSS
+ sky130_fd_sc_hd__dlygate4sd3_1
X$13698 VDD synth_7373 VDD synth_7398 VNB|VSS VNB|VSS
+ sky130_fd_sc_hd__dlygate4sd3_1
X$13699 VDD synth_6273 VDD synth_6078 VNB|VSS VNB|VSS
+ sky130_fd_sc_hd__dlygate4sd3_1
X$13700 VDD synth_5435 VDD synth_5360 VNB|VSS VNB|VSS
+ sky130_fd_sc_hd__dlygate4sd3_1
X$13701 VDD synth_1402 VDD synth_1520 VNB|VSS VNB|VSS
+ sky130_fd_sc_hd__dlygate4sd3_1
X$13702 VDD synth_2661 VDD synth_2916 VNB|VSS VNB|VSS
+ sky130_fd_sc_hd__dlygate4sd3_1
X$13703 VDD synth_6854 VDD synth_6763 VNB|VSS VNB|VSS
+ sky130_fd_sc_hd__dlygate4sd3_1
X$13704 VDD synth_8365 VDD synth_8243 VNB|VSS VNB|VSS
+ sky130_fd_sc_hd__dlygate4sd3_1
X$13705 VDD synth_866 VDD synth_864 VNB|VSS VNB|VSS
+ sky130_fd_sc_hd__dlygate4sd3_1
X$13706 VDD synth_4469 VDD synth_4468 VNB|VSS VNB|VSS
+ sky130_fd_sc_hd__dlygate4sd3_1
X$13707 VDD synth_5703 VDD synth_5863 VNB|VSS VNB|VSS
+ sky130_fd_sc_hd__dlygate4sd3_1
X$13708 VDD synth_8431 VDD synth_8509 VNB|VSS VNB|VSS
+ sky130_fd_sc_hd__dlygate4sd3_1
X$13709 VDD synth_5735 VDD synth_5768 VNB|VSS VNB|VSS
+ sky130_fd_sc_hd__dlygate4sd3_1
X$13710 VDD synth_7057 VDD synth_7056 VNB|VSS VNB|VSS
+ sky130_fd_sc_hd__dlygate4sd3_1
X$13711 VDD synth_5527 VDD synth_5463 VNB|VSS VNB|VSS
+ sky130_fd_sc_hd__dlygate4sd3_1
X$13712 VDD synth_2477 VDD synth_2700 VNB|VSS VNB|VSS
+ sky130_fd_sc_hd__dlygate4sd3_1
X$13713 VDD synth_417 VDD synth_375 VNB|VSS VNB|VSS
+ sky130_fd_sc_hd__dlygate4sd3_1
X$13714 VDD synth_83 VDD synth_57 VNB|VSS VNB|VSS sky130_fd_sc_hd__dlygate4sd3_1
X$13715 VDD synth_6493 VDD synth_6402 VNB|VSS VNB|VSS
+ sky130_fd_sc_hd__dlygate4sd3_1
X$13716 VDD load_data[2] VDD synth_2816 VNB|VSS VNB|VSS
+ sky130_fd_sc_hd__dlygate4sd3_1
X$13717 VDD synth_5524 VDD synth_5579 VNB|VSS VNB|VSS
+ sky130_fd_sc_hd__dlygate4sd3_1
X$13718 VDD synth_899 VDD synth_873 VNB|VSS VNB|VSS
+ sky130_fd_sc_hd__dlygate4sd3_1
X$13719 VDD synth_5097 VDD synth_5204 VNB|VSS VNB|VSS
+ sky130_fd_sc_hd__dlygate4sd3_1
X$13720 VDD synth_5652 VDD synth_5499 VNB|VSS VNB|VSS
+ sky130_fd_sc_hd__dlygate4sd3_1
X$13721 VDD synth_977 VDD synth_1109 VNB|VSS VNB|VSS
+ sky130_fd_sc_hd__dlygate4sd3_1
X$13722 VDD synth_4877 VDD synth_4973 VNB|VSS VNB|VSS
+ sky130_fd_sc_hd__dlygate4sd3_1
X$13723 VDD synth_6391 VDD synth_6563 VNB|VSS VNB|VSS
+ sky130_fd_sc_hd__dlygate4sd3_1
X$13724 VDD synth_1101 VDD synth_1063 VNB|VSS VNB|VSS
+ sky130_fd_sc_hd__dlygate4sd3_1
X$13725 VDD synth_7449 VDD synth_7234 VNB|VSS VNB|VSS
+ sky130_fd_sc_hd__dlygate4sd3_1
X$13726 VDD synth_5700 VDD synth_5622 VNB|VSS VNB|VSS
+ sky130_fd_sc_hd__dlygate4sd3_1
X$13727 VDD synth_6030 VDD synth_6083 VNB|VSS VNB|VSS
+ sky130_fd_sc_hd__dlygate4sd3_1
X$13728 VDD synth_4148 VDD synth_4145 VNB|VSS VNB|VSS
+ sky130_fd_sc_hd__dlygate4sd3_1
X$13729 VDD synth_7689 VDD synth_7686 VNB|VSS VNB|VSS
+ sky130_fd_sc_hd__dlygate4sd3_1
X$13730 VDD synth_2070 VDD synth_2026 VNB|VSS VNB|VSS
+ sky130_fd_sc_hd__dlygate4sd3_1
X$13731 VDD synth_2176 VDD synth_2177 VNB|VSS VNB|VSS
+ sky130_fd_sc_hd__dlygate4sd3_1
X$13732 VDD synth_979 VDD synth_1231 VNB|VSS VNB|VSS
+ sky130_fd_sc_hd__dlygate4sd3_1
X$13733 VDD synth_539 VDD synth_353 VNB|VSS VNB|VSS
+ sky130_fd_sc_hd__dlygate4sd3_1
X$13734 VDD synth_2993 VDD synth_3071 VNB|VSS VNB|VSS
+ sky130_fd_sc_hd__dlygate4sd3_1
X$13735 VDD synth_3270 VDD synth_3240 VNB|VSS VNB|VSS
+ sky130_fd_sc_hd__dlygate4sd3_1
X$13736 VDD synth_6632 VDD synth_6614 VNB|VSS VNB|VSS
+ sky130_fd_sc_hd__dlygate4sd3_1
X$13737 VDD synth_794 VDD synth_879 VNB|VSS VNB|VSS
+ sky130_fd_sc_hd__dlygate4sd3_1
X$13738 VDD synth_2071 VDD synth_2027 VNB|VSS VNB|VSS
+ sky130_fd_sc_hd__dlygate4sd3_1
X$13739 VDD synth_1034 VDD synth_956 VNB|VSS VNB|VSS
+ sky130_fd_sc_hd__dlygate4sd3_1
X$13740 VDD synth_5699 VDD synth_5837 VNB|VSS VNB|VSS
+ sky130_fd_sc_hd__dlygate4sd3_1
X$13741 VDD synth_452 VDD synth_357 VNB|VSS VNB|VSS
+ sky130_fd_sc_hd__dlygate4sd3_1
X$13742 VDD synth_6861 VDD synth_6573 VNB|VSS VNB|VSS
+ sky130_fd_sc_hd__dlygate4sd3_1
X$13743 VDD synth_4547 VDD synth_4465 VNB|VSS VNB|VSS
+ sky130_fd_sc_hd__dlygate4sd3_1
X$13744 VDD synth_703 VDD synth_812 VNB|VSS VNB|VSS
+ sky130_fd_sc_hd__dlygate4sd3_1
X$13745 VDD synth_5619 VDD synth_5638 VNB|VSS VNB|VSS
+ sky130_fd_sc_hd__dlygate4sd3_1
X$13746 VDD synth_5364 VDD synth_5355 VNB|VSS VNB|VSS
+ sky130_fd_sc_hd__dlygate4sd3_1
X$13747 VDD synth_5838 VDD synth_6001 VNB|VSS VNB|VSS
+ sky130_fd_sc_hd__dlygate4sd3_1
X$13748 VDD synth_5030 VDD synth_4946 VNB|VSS VNB|VSS
+ sky130_fd_sc_hd__dlygate4sd3_1
X$13749 VDD synth_786 VDD synth_787 VNB|VSS VNB|VSS
+ sky130_fd_sc_hd__dlygate4sd3_1
X$13750 VDD synth_6246 VDD synth_6188 VNB|VSS VNB|VSS
+ sky130_fd_sc_hd__dlygate4sd3_1
X$13751 VDD synth_3714 VDD synth_3708 VNB|VSS VNB|VSS
+ sky130_fd_sc_hd__dlygate4sd3_1
X$13752 VDD synth_1041 VDD synth_1118 VNB|VSS VNB|VSS
+ sky130_fd_sc_hd__dlygate4sd3_1
X$13753 VDD synth_1304 VDD synth_1335 VNB|VSS VNB|VSS
+ sky130_fd_sc_hd__dlygate4sd3_1
X$13754 VDD load_data[3] VDD synth_1458 VNB|VSS VNB|VSS
+ sky130_fd_sc_hd__dlygate4sd3_1
X$13755 VDD synth_7902 VDD synth_7861 VNB|VSS VNB|VSS
+ sky130_fd_sc_hd__dlygate4sd3_1
X$13756 VDD synth_780 VDD synth_779 VNB|VSS VNB|VSS
+ sky130_fd_sc_hd__dlygate4sd3_1
X$13757 VDD synth_5568 VDD synth_5710 VNB|VSS VNB|VSS
+ sky130_fd_sc_hd__dlygate4sd3_1
X$13758 VDD synth_1683 VDD synth_1773 VNB|VSS VNB|VSS
+ sky130_fd_sc_hd__dlygate4sd3_1
X$13759 VDD synth_5926 VDD synth_5925 VNB|VSS VNB|VSS
+ sky130_fd_sc_hd__dlygate4sd3_1
X$13760 VDD synth_4700 VDD synth_4535 VNB|VSS VNB|VSS
+ sky130_fd_sc_hd__dlygate4sd3_1
X$13761 VDD synth_1843 VDD synth_1876 VNB|VSS VNB|VSS
+ sky130_fd_sc_hd__dlygate4sd3_1
X$13762 VDD synth_2607 VDD synth_2567 VNB|VSS VNB|VSS
+ sky130_fd_sc_hd__dlygate4sd3_1
X$13763 VDD synth_6625 VDD synth_6490 VNB|VSS VNB|VSS
+ sky130_fd_sc_hd__dlygate4sd3_1
X$13764 VDD synth_849 VDD synth_845 VNB|VSS VNB|VSS
+ sky130_fd_sc_hd__dlygate4sd3_1
X$13765 VDD synth_2583 VDD synth_2584 VNB|VSS VNB|VSS
+ sky130_fd_sc_hd__dlygate4sd3_1
X$13766 VDD synth_11949 VDD synth_11950 VNB|VSS VNB|VSS
+ sky130_fd_sc_hd__dlygate4sd3_1
X$13767 VDD synth_10964 VDD synth_10993 VNB|VSS VNB|VSS
+ sky130_fd_sc_hd__dlygate4sd3_1
X$13768 VDD synth_5460 VDD synth_5458 VNB|VSS VNB|VSS
+ sky130_fd_sc_hd__dlygate4sd3_1
X$13769 VDD synth_6727 VDD synth_7806 VNB|VSS VNB|VSS
+ sky130_fd_sc_hd__dlygate4sd3_1
X$13770 VDD synth_5519 VDD synth_5517 VNB|VSS VNB|VSS
+ sky130_fd_sc_hd__dlygate4sd3_1
X$13771 VDD synth_5374 VDD synth_5298 VNB|VSS VNB|VSS
+ sky130_fd_sc_hd__dlygate4sd3_1
X$13772 VDD synth_4333 VDD synth_4253 VNB|VSS VNB|VSS
+ sky130_fd_sc_hd__dlygate4sd3_1
X$13773 VDD synth_2303 VDD synth_2302 VNB|VSS VNB|VSS
+ sky130_fd_sc_hd__dlygate4sd3_1
X$13774 VDD synth_5212 VDD synth_5210 VNB|VSS VNB|VSS
+ sky130_fd_sc_hd__dlygate4sd3_1
X$13775 VDD synth_6344 VDD synth_6233 VNB|VSS VNB|VSS
+ sky130_fd_sc_hd__dlygate4sd3_1
X$13776 VDD synth_5956 VDD synth_6199 VNB|VSS VNB|VSS
+ sky130_fd_sc_hd__dlygate4sd3_1
X$13777 VDD synth_174 VDD synth_135 VNB|VSS VNB|VSS
+ sky130_fd_sc_hd__dlygate4sd3_1
X$13778 VDD synth_5764 VDD synth_5929 VNB|VSS VNB|VSS
+ sky130_fd_sc_hd__dlygate4sd3_1
X$13779 VDD synth_8134 VDD synth_8247 VNB|VSS VNB|VSS
+ sky130_fd_sc_hd__dlygate4sd3_1
X$13780 VDD synth_2714 VDD synth_2638 VNB|VSS VNB|VSS
+ sky130_fd_sc_hd__dlygate4sd3_1
X$13781 VDD synth_638 VDD synth_365 VNB|VSS VNB|VSS
+ sky130_fd_sc_hd__dlygate4sd3_1
X$13782 VDD synth_8010 VDD synth_7968 VNB|VSS VNB|VSS
+ sky130_fd_sc_hd__dlygate4sd3_1
X$13783 VDD synth_7364 VDD synth_7362 VNB|VSS VNB|VSS
+ sky130_fd_sc_hd__dlygate4sd3_1
X$13784 VDD synth_6514 VDD synth_6446 VNB|VSS VNB|VSS
+ sky130_fd_sc_hd__dlygate4sd3_1
X$13785 VDD synth_6645 VDD synth_6370 VNB|VSS VNB|VSS
+ sky130_fd_sc_hd__dlygate4sd3_1
X$13786 VDD synth_7363 VDD synth_7361 VNB|VSS VNB|VSS
+ sky130_fd_sc_hd__dlygate4sd3_1
X$13787 VDD synth_847 VDD synth_770 VNB|VSS VNB|VSS
+ sky130_fd_sc_hd__dlygate4sd3_1
X$13788 VDD synth_5301 VDD synth_5328 VNB|VSS VNB|VSS
+ sky130_fd_sc_hd__dlygate4sd3_1
X$13789 VDD synth_2082 VDD synth_1892 VNB|VSS VNB|VSS
+ sky130_fd_sc_hd__dlygate4sd3_1
X$13790 VDD synth_369 VDD synth_370 VNB|VSS VNB|VSS
+ sky130_fd_sc_hd__dlygate4sd3_1
X$13791 VDD synth_184 VDD synth_138 VNB|VSS VNB|VSS
+ sky130_fd_sc_hd__dlygate4sd3_1
X$13792 VDD synth_3083 VDD synth_3082 VNB|VSS VNB|VSS
+ sky130_fd_sc_hd__dlygate4sd3_1
X$13793 VDD synth_1107 VDD synth_1104 VNB|VSS VNB|VSS
+ sky130_fd_sc_hd__dlygate4sd3_1
X$13794 VDD synth_742 VDD synth_874 VNB|VSS VNB|VSS
+ sky130_fd_sc_hd__dlygate4sd3_1
X$13795 VDD synth_7734 VDD synth_7844 VNB|VSS VNB|VSS
+ sky130_fd_sc_hd__dlygate4sd3_1
X$13796 VDD synth_7790 VDD synth_8291 VNB|VSS VNB|VSS
+ sky130_fd_sc_hd__dlygate4sd3_1
X$13797 VDD synth_6415 VDD synth_6518 VNB|VSS VNB|VSS
+ sky130_fd_sc_hd__dlygate4sd3_1
X$13798 VDD synth_7264 VDD synth_7837 VNB|VSS VNB|VSS
+ sky130_fd_sc_hd__dlygate4sd3_1
X$13799 VDD synth_7457 VDD synth_8139 VNB|VSS VNB|VSS
+ sky130_fd_sc_hd__dlygate4sd3_1
X$13800 VDD synth_5377 VDD synth_5020 VNB|VSS VNB|VSS
+ sky130_fd_sc_hd__dlygate4sd3_1
X$13801 VDD synth_10203 VDD synth_10202 VNB|VSS VNB|VSS
+ sky130_fd_sc_hd__dlygate4sd3_1
X$13802 VDD synth_4130 VDD synth_4131 VNB|VSS VNB|VSS
+ sky130_fd_sc_hd__dlygate4sd3_1
X$13803 VDD synth_3329 VDD synth_3410 VNB|VSS VNB|VSS
+ sky130_fd_sc_hd__dlygate4sd3_1
X$13804 VDD synth_8293 VDD synth_8290 VNB|VSS VNB|VSS
+ sky130_fd_sc_hd__dlygate4sd3_1
X$13805 VDD synth_5028 VDD synth_4766 VNB|VSS VNB|VSS
+ sky130_fd_sc_hd__dlygate4sd3_1
X$13806 VDD synth_4760 VDD synth_4718 VNB|VSS VNB|VSS
+ sky130_fd_sc_hd__dlygate4sd3_1
X$13807 VDD synth_6155 VDD synth_6334 VNB|VSS VNB|VSS
+ sky130_fd_sc_hd__dlygate4sd3_1
X$13808 VDD synth_10468 VDD synth_10421 VNB|VSS VNB|VSS
+ sky130_fd_sc_hd__dlygate4sd3_1
X$13809 VDD synth_8714 VDD synth_8886 VNB|VSS VNB|VSS
+ sky130_fd_sc_hd__dlygate4sd3_1
X$13810 VDD synth_6423 VDD synth_6451 VNB|VSS VNB|VSS
+ sky130_fd_sc_hd__dlygate4sd3_1
X$13811 VDD synth_8088 VDD synth_8011 VNB|VSS VNB|VSS
+ sky130_fd_sc_hd__dlygate4sd3_1
X$13812 VDD synth_11576 VDD synth_11575 VNB|VSS VNB|VSS
+ sky130_fd_sc_hd__dlygate4sd3_1
X$13813 VDD synth_3654 VDD synth_3648 VNB|VSS VNB|VSS
+ sky130_fd_sc_hd__dlygate4sd3_1
X$13814 VDD synth_700 VDD synth_735 VNB|VSS VNB|VSS
+ sky130_fd_sc_hd__dlygate4sd3_1
X$13815 VDD synth_1145 VDD synth_1167 VNB|VSS VNB|VSS
+ sky130_fd_sc_hd__dlygate4sd3_1
X$13816 VDD synth_11553 VDD synth_11444 VNB|VSS VNB|VSS
+ sky130_fd_sc_hd__dlygate4sd3_1
X$13817 VDD synth_3963 VDD synth_3962 VNB|VSS VNB|VSS
+ sky130_fd_sc_hd__dlygate4sd3_1
X$13818 VDD synth_11688 VDD synth_11687 VNB|VSS VNB|VSS
+ sky130_fd_sc_hd__dlygate4sd3_1
X$13819 VDD synth_3804 VDD synth_3873 VNB|VSS VNB|VSS
+ sky130_fd_sc_hd__dlygate4sd3_1
X$13820 VDD synth_3503 VDD synth_3477 VNB|VSS VNB|VSS
+ sky130_fd_sc_hd__dlygate4sd3_1
X$13821 VDD synth_11336 VDD synth_11180 VNB|VSS VNB|VSS
+ sky130_fd_sc_hd__dlygate4sd3_1
X$13822 VDD synth_2161 VDD synth_2391 VNB|VSS VNB|VSS
+ sky130_fd_sc_hd__dlygate4sd3_1
X$13823 VDD synth_2741 VDD synth_2740 VNB|VSS VNB|VSS
+ sky130_fd_sc_hd__dlygate4sd3_1
X$13824 VDD synth_5834 VDD synth_5921 VNB|VSS VNB|VSS
+ sky130_fd_sc_hd__dlygate4sd3_1
X$13825 VDD synth_11109 VDD synth_11142 VNB|VSS VNB|VSS
+ sky130_fd_sc_hd__dlygate4sd3_1
X$13826 VDD synth_11691 VDD synth_11693 VNB|VSS VNB|VSS
+ sky130_fd_sc_hd__dlygate4sd3_1
X$13827 VDD synth_1023 VDD synth_895 VNB|VSS VNB|VSS
+ sky130_fd_sc_hd__dlygate4sd3_1
X$13828 VDD synth_11968 VDD synth_12084 VNB|VSS VNB|VSS
+ sky130_fd_sc_hd__dlygate4sd3_1
X$13829 VDD synth_808 VDD synth_1028 VNB|VSS VNB|VSS
+ sky130_fd_sc_hd__dlygate4sd3_1
X$13830 VDD synth_943 VDD synth_944 VNB|VSS VNB|VSS
+ sky130_fd_sc_hd__dlygate4sd3_1
X$13831 VDD synth_6031 VDD synth_6194 VNB|VSS VNB|VSS
+ sky130_fd_sc_hd__dlygate4sd3_1
X$13832 VDD synth_8372 VDD synth_8319 VNB|VSS VNB|VSS
+ sky130_fd_sc_hd__dlygate4sd3_1
X$13833 VDD synth_3528 VDD synth_3610 VNB|VSS VNB|VSS
+ sky130_fd_sc_hd__dlygate4sd3_1
X$13834 VDD synth_8375 VDD synth_8321 VNB|VSS VNB|VSS
+ sky130_fd_sc_hd__dlygate4sd3_1
X$13835 VDD synth_5687 VDD synth_5829 VNB|VSS VNB|VSS
+ sky130_fd_sc_hd__dlygate4sd3_1
X$13836 VDD synth_1396 VDD synth_1342 VNB|VSS VNB|VSS
+ sky130_fd_sc_hd__dlygate4sd3_1
X$13837 VDD synth_6922 VDD synth_6708 VNB|VSS VNB|VSS
+ sky130_fd_sc_hd__dlygate4sd3_1
X$13838 VDD synth_5425 VDD synth_5457 VNB|VSS VNB|VSS
+ sky130_fd_sc_hd__dlygate4sd3_1
X$13839 VDD synth_5273 VDD synth_5350 VNB|VSS VNB|VSS
+ sky130_fd_sc_hd__dlygate4sd3_1
X$13840 VDD synth_5040 VDD synth_5101 VNB|VSS VNB|VSS
+ sky130_fd_sc_hd__dlygate4sd3_1
X$13841 VDD synth_8121 VDD synth_8029 VNB|VSS VNB|VSS
+ sky130_fd_sc_hd__dlygate4sd3_1
X$13842 VDD synth_5193 VDD synth_5167 VNB|VSS VNB|VSS
+ sky130_fd_sc_hd__dlygate4sd3_1
X$13843 VDD synth_8047 VDD synth_8426 VNB|VSS VNB|VSS
+ sky130_fd_sc_hd__dlygate4sd3_1
X$13844 VDD synth_884 VDD synth_788 VNB|VSS VNB|VSS
+ sky130_fd_sc_hd__dlygate4sd3_1
X$13845 VDD synth_3203 VDD synth_3426 VNB|VSS VNB|VSS
+ sky130_fd_sc_hd__dlygate4sd3_1
X$13846 VDD synth_4771 VDD synth_4722 VNB|VSS VNB|VSS
+ sky130_fd_sc_hd__dlygate4sd3_1
X$13847 VDD synth_3847 VDD synth_3849 VNB|VSS VNB|VSS
+ sky130_fd_sc_hd__dlygate4sd3_1
X$13848 VDD synth_4805 VDD synth_4658 VNB|VSS VNB|VSS
+ sky130_fd_sc_hd__dlygate4sd3_1
X$13849 VDD synth_551 VDD synth_422 VNB|VSS VNB|VSS
+ sky130_fd_sc_hd__dlygate4sd3_1
X$13850 VDD synth_6709 VDD synth_6542 VNB|VSS VNB|VSS
+ sky130_fd_sc_hd__dlygate4sd3_1
X$13851 VDD synth_3866 VDD synth_3768 VNB|VSS VNB|VSS
+ sky130_fd_sc_hd__dlygate4sd3_1
X$13852 VDD synth_9845 VDD synth_8875 VNB|VSS VNB|VSS
+ sky130_fd_sc_hd__dlygate4sd3_1
X$13853 VDD synth_4926 VDD synth_4988 VNB|VSS VNB|VSS
+ sky130_fd_sc_hd__dlygate4sd3_1
X$13854 VDD synth_8267 VDD synth_8200 VNB|VSS VNB|VSS
+ sky130_fd_sc_hd__dlygate4sd3_1
X$13855 VDD synth_5959 VDD synth_5862 VNB|VSS VNB|VSS
+ sky130_fd_sc_hd__dlygate4sd3_1
X$13856 VDD synth_1652 VDD synth_1895 VNB|VSS VNB|VSS
+ sky130_fd_sc_hd__dlygate4sd3_1
X$13857 VDD synth_7297 VDD synth_7296 VNB|VSS VNB|VSS
+ sky130_fd_sc_hd__dlygate4sd3_1
X$13858 VDD synth_4768 VDD synth_4683 VNB|VSS VNB|VSS
+ sky130_fd_sc_hd__dlygate4sd3_1
X$13859 VDD synth_7235 VDD synth_7157 VNB|VSS VNB|VSS
+ sky130_fd_sc_hd__dlygate4sd3_1
X$13860 VDD synth_2687 VDD synth_2837 VNB|VSS VNB|VSS
+ sky130_fd_sc_hd__dlygate4sd3_1
X$13861 VDD synth_5438 VDD synth_5431 VNB|VSS VNB|VSS
+ sky130_fd_sc_hd__dlygate4sd3_1
X$13862 VDD synth_3260 VDD synth_3316 VNB|VSS VNB|VSS
+ sky130_fd_sc_hd__dlygate4sd3_1
X$13863 VDD synth_1458 VDD synth_1234 VNB|VSS VNB|VSS
+ sky130_fd_sc_hd__dlygate4sd3_1
X$13864 VDD synth_6285 VDD synth_6584 VNB|VSS VNB|VSS
+ sky130_fd_sc_hd__dlygate4sd3_1
X$13865 VDD synth_3310 VDD synth_3338 VNB|VSS VNB|VSS
+ sky130_fd_sc_hd__dlygate4sd3_1
X$13866 VDD synth_858 VDD synth_1027 VNB|VSS VNB|VSS
+ sky130_fd_sc_hd__dlygate4sd3_1
X$13867 VDD synth_1789 VDD synth_1788 VNB|VSS VNB|VSS
+ sky130_fd_sc_hd__dlygate4sd3_1
X$13868 VDD synth_1042 VDD synth_865 VNB|VSS VNB|VSS
+ sky130_fd_sc_hd__dlygate4sd3_1
X$13869 VDD synth_2748 VDD synth_2747 VNB|VSS VNB|VSS
+ sky130_fd_sc_hd__dlygate4sd3_1
X$13870 VDD synth_5385 VDD synth_5307 VNB|VSS VNB|VSS
+ sky130_fd_sc_hd__dlygate4sd3_1
X$13871 VDD synth_7687 VDD synth_7739 VNB|VSS VNB|VSS
+ sky130_fd_sc_hd__dlygate4sd3_1
X$13872 VDD synth_2886 VDD synth_2893 VNB|VSS VNB|VSS
+ sky130_fd_sc_hd__dlygate4sd3_1
X$13873 VDD synth_6340 VDD synth_6553 VNB|VSS VNB|VSS
+ sky130_fd_sc_hd__dlygate4sd3_1
X$13874 VDD synth_5650 VDD synth_5651 VNB|VSS VNB|VSS
+ sky130_fd_sc_hd__dlygate4sd3_1
X$13875 VDD synth_1566 VDD synth_1564 VNB|VSS VNB|VSS
+ sky130_fd_sc_hd__dlygate4sd3_1
X$13876 VDD synth_5468 VDD synth_5467 VNB|VSS VNB|VSS
+ sky130_fd_sc_hd__dlygate4sd3_1
X$13877 VDD synth_585 VDD synth_528 VNB|VSS VNB|VSS
+ sky130_fd_sc_hd__dlygate4sd3_1
X$13878 VDD synth_7267 VDD synth_7415 VNB|VSS VNB|VSS
+ sky130_fd_sc_hd__dlygate4sd3_1
X$13879 VDD synth_1670 VDD synth_1653 VNB|VSS VNB|VSS
+ sky130_fd_sc_hd__dlygate4sd3_1
X$13880 VDD synth_3506 VDD synth_3598 VNB|VSS VNB|VSS
+ sky130_fd_sc_hd__dlygate4sd3_1
X$13881 VDD synth_3323 VDD synth_3322 VNB|VSS VNB|VSS
+ sky130_fd_sc_hd__dlygate4sd3_1
X$13882 VDD synth_7706 VDD synth_7579 VNB|VSS VNB|VSS
+ sky130_fd_sc_hd__dlygate4sd3_1
X$13883 VDD synth_8095 VDD synth_8128 VNB|VSS VNB|VSS
+ sky130_fd_sc_hd__dlygate4sd3_1
X$13884 VDD synth_5469 VDD synth_5676 VNB|VSS VNB|VSS
+ sky130_fd_sc_hd__dlygate4sd3_1
X$13885 VDD synth_3991 VDD synth_4056 VNB|VSS VNB|VSS
+ sky130_fd_sc_hd__dlygate4sd3_1
X$13886 VDD synth_7541 VDD synth_7399 VNB|VSS VNB|VSS
+ sky130_fd_sc_hd__dlygate4sd3_1
X$13887 VDD synth_2336 VDD synth_2401 VNB|VSS VNB|VSS
+ sky130_fd_sc_hd__dlygate4sd3_1
X$13888 VDD synth_6496 VDD synth_6495 VNB|VSS VNB|VSS
+ sky130_fd_sc_hd__dlygate4sd3_1
X$13889 VDD synth_2826 VDD synth_2782 VNB|VSS VNB|VSS
+ sky130_fd_sc_hd__dlygate4sd3_1
X$13890 VDD synth_634 VDD synth_458 VNB|VSS VNB|VSS
+ sky130_fd_sc_hd__dlygate4sd3_1
X$13891 VDD synth_4785 VDD synth_4847 VNB|VSS VNB|VSS
+ sky130_fd_sc_hd__dlygate4sd3_1
X$13892 VDD synth_6555 VDD synth_6714 VNB|VSS VNB|VSS
+ sky130_fd_sc_hd__dlygate4sd3_1
X$13893 VDD synth_4603 VDD synth_4621 VNB|VSS VNB|VSS
+ sky130_fd_sc_hd__dlygate4sd3_1
X$13894 VDD synth_5464 VDD synth_5162 VNB|VSS VNB|VSS
+ sky130_fd_sc_hd__dlygate4sd3_1
X$13895 VDD synth_2614 VDD synth_2966 VNB|VSS VNB|VSS
+ sky130_fd_sc_hd__dlygate4sd3_1
X$13896 VDD synth_6492 VDD synth_6399 VNB|VSS VNB|VSS
+ sky130_fd_sc_hd__dlygate4sd3_1
X$13897 VDD synth_1111 VDD synth_1229 VNB|VSS VNB|VSS
+ sky130_fd_sc_hd__dlygate4sd3_1
X$13898 VDD synth_7631 VDD synth_7632 VNB|VSS VNB|VSS
+ sky130_fd_sc_hd__dlygate4sd3_1
X$13899 VDD synth_6271 VDD synth_6189 VNB|VSS VNB|VSS
+ sky130_fd_sc_hd__dlygate4sd3_1
X$13900 VDD synth_3605 VDD synth_3626 VNB|VSS VNB|VSS
+ sky130_fd_sc_hd__dlygate4sd3_1
X$13901 VDD synth_6051 VDD synth_6053 VNB|VSS VNB|VSS
+ sky130_fd_sc_hd__dlygate4sd3_1
X$13902 VDD synth_1929 VDD synth_1888 VNB|VSS VNB|VSS
+ sky130_fd_sc_hd__dlygate4sd3_1
X$13903 VDD synth_3190 VDD synth_3157 VNB|VSS VNB|VSS
+ sky130_fd_sc_hd__dlygate4sd3_1
X$13904 VDD synth_3511 VDD synth_3474 VNB|VSS VNB|VSS
+ sky130_fd_sc_hd__dlygate4sd3_1
X$13905 VDD synth_7531 VDD synth_7417 VNB|VSS VNB|VSS
+ sky130_fd_sc_hd__dlygate4sd3_1
X$13906 VDD synth_3628 VDD synth_3627 VNB|VSS VNB|VSS
+ sky130_fd_sc_hd__dlygate4sd3_1
X$13907 VDD synth_4703 VDD synth_4632 VNB|VSS VNB|VSS
+ sky130_fd_sc_hd__dlygate4sd3_1
X$13908 VDD synth_4286 VDD synth_4310 VNB|VSS VNB|VSS
+ sky130_fd_sc_hd__dlygate4sd3_1
X$13909 VDD synth_2897 VDD synth_2936 VNB|VSS VNB|VSS
+ sky130_fd_sc_hd__dlygate4sd3_1
X$13910 VDD synth_5472 VDD synth_5473 VNB|VSS VNB|VSS
+ sky130_fd_sc_hd__dlygate4sd3_1
X$13911 VDD synth_641 VDD synth_110 VNB|VSS VNB|VSS
+ sky130_fd_sc_hd__dlygate4sd3_1
X$13912 VDD synth_237 VDD synth_52 VNB|VSS VNB|VSS
+ sky130_fd_sc_hd__dlygate4sd3_1
X$13913 VDD synth_5440 VDD synth_5441 VNB|VSS VNB|VSS
+ sky130_fd_sc_hd__dlygate4sd3_1
X$13914 VDD synth_5470 VDD synth_5415 VNB|VSS VNB|VSS
+ sky130_fd_sc_hd__dlygate4sd3_1
X$13915 VDD synth_7149 VDD synth_6977 VNB|VSS VNB|VSS
+ sky130_fd_sc_hd__dlygate4sd3_1
X$13916 VDD synth_4990 VDD synth_4929 VNB|VSS VNB|VSS
+ sky130_fd_sc_hd__dlygate4sd3_1
X$13917 VDD synth_7797 VDD synth_7740 VNB|VSS VNB|VSS
+ sky130_fd_sc_hd__dlygate4sd3_1
X$13918 VDD synth_5109 VDD synth_5110 VNB|VSS VNB|VSS
+ sky130_fd_sc_hd__dlygate4sd3_1
X$13919 VDD synth_1769 VDD synth_1770 VNB|VSS VNB|VSS
+ sky130_fd_sc_hd__dlygate4sd3_1
X$13920 VDD synth_649 VDD synth_878 VNB|VSS VNB|VSS
+ sky130_fd_sc_hd__dlygate4sd3_1
X$13921 VDD synth_4933 VDD synth_4995 VNB|VSS VNB|VSS
+ sky130_fd_sc_hd__dlygate4sd3_1
X$13922 VDD synth_2915 VDD synth_3073 VNB|VSS VNB|VSS
+ sky130_fd_sc_hd__dlygate4sd3_1
X$13923 VDD synth_2805 VDD synth_2828 VNB|VSS VNB|VSS
+ sky130_fd_sc_hd__dlygate4sd3_1
X$13924 VDD synth_8225 VDD synth_8222 VNB|VSS VNB|VSS
+ sky130_fd_sc_hd__dlygate4sd3_1
X$13925 VDD synth_2480 VDD synth_2524 VNB|VSS VNB|VSS
+ sky130_fd_sc_hd__dlygate4sd3_1
X$13926 VDD synth_5943 VDD synth_5823 VNB|VSS VNB|VSS
+ sky130_fd_sc_hd__dlygate4sd3_1
X$13927 VDD synth_7863 VDD synth_7789 VNB|VSS VNB|VSS
+ sky130_fd_sc_hd__dlygate4sd3_1
X$13928 VDD synth_3935 VDD synth_3933 VNB|VSS VNB|VSS
+ sky130_fd_sc_hd__dlygate4sd3_1
X$13929 VDD synth_4986 VDD synth_4985 VNB|VSS VNB|VSS
+ sky130_fd_sc_hd__dlygate4sd3_1
X$13930 VDD synth_5819 VDD synth_5816 VNB|VSS VNB|VSS
+ sky130_fd_sc_hd__dlygate4sd3_1
X$13931 VDD synth_1459 VDD synth_1337 VNB|VSS VNB|VSS
+ sky130_fd_sc_hd__dlygate4sd3_1
X$13932 VDD synth_5595 VDD synth_5546 VNB|VSS VNB|VSS
+ sky130_fd_sc_hd__dlygate4sd3_1
X$13933 VDD synth_8298 VDD synth_8220 VNB|VSS VNB|VSS
+ sky130_fd_sc_hd__dlygate4sd3_1
X$13934 VDD synth_5019 VDD synth_4745 VNB|VSS VNB|VSS
+ sky130_fd_sc_hd__dlygate4sd3_1
X$13935 VDD synth_2738 VDD synth_2850 VNB|VSS VNB|VSS
+ sky130_fd_sc_hd__dlygate4sd3_1
X$13936 VDD synth_9021 VDD synth_9020 VNB|VSS VNB|VSS
+ sky130_fd_sc_hd__dlygate4sd3_1
X$13937 VDD reset VDD synth_9845 VNB|VSS VNB|VSS sky130_fd_sc_hd__dlygate4sd3_1
X$13938 VDD synth_7314 VDD synth_7168 VNB|VSS VNB|VSS
+ sky130_fd_sc_hd__dlygate4sd3_1
X$13939 VDD synth_3401 VDD synth_3309 VNB|VSS VNB|VSS
+ sky130_fd_sc_hd__dlygate4sd3_1
X$13940 VDD synth_10037 VDD synth_10201 VNB|VSS VNB|VSS
+ sky130_fd_sc_hd__dlygate4sd3_1
X$13941 VDD synth_5762 VDD synth_5695 VNB|VSS VNB|VSS
+ sky130_fd_sc_hd__dlygate4sd3_1
X$13942 VDD synth_4559 VDD synth_4701 VNB|VSS VNB|VSS
+ sky130_fd_sc_hd__dlygate4sd3_1
X$13943 VDD synth_7839 VDD synth_7840 VNB|VSS VNB|VSS
+ sky130_fd_sc_hd__dlygate4sd3_1
X$13944 VDD synth_6333 VDD synth_6243 VNB|VSS VNB|VSS
+ sky130_fd_sc_hd__dlygate4sd3_1
X$13945 VDD synth_5218 VDD synth_5064 VNB|VSS VNB|VSS
+ sky130_fd_sc_hd__dlygate4sd3_1
X$13946 VDD synth_2907 VDD synth_2906 VNB|VSS VNB|VSS
+ sky130_fd_sc_hd__dlygate4sd3_1
X$13947 VDD synth_6358 VDD synth_6437 VNB|VSS VNB|VSS
+ sky130_fd_sc_hd__dlygate4sd3_1
X$13948 VDD synth_4483 VDD synth_4484 VNB|VSS VNB|VSS
+ sky130_fd_sc_hd__dlygate4sd3_1
X$13949 VDD synth_4912 VDD synth_4962 VNB|VSS VNB|VSS
+ sky130_fd_sc_hd__dlygate4sd3_1
X$13950 VDD synth_4587 VDD synth_4625 VNB|VSS VNB|VSS
+ sky130_fd_sc_hd__dlygate4sd3_1
X$13951 VDD synth_1995 VDD synth_2148 VNB|VSS VNB|VSS
+ sky130_fd_sc_hd__dlygate4sd3_1
X$13952 VDD load_valid VDD synth_7733 VNB|VSS VNB|VSS
+ sky130_fd_sc_hd__dlygate4sd3_1
X$13953 VDD synth_4879 VDD synth_4911 VNB|VSS VNB|VSS
+ sky130_fd_sc_hd__dlygate4sd3_1
X$13954 VDD synth_588 VDD synth_368 VNB|VSS VNB|VSS
+ sky130_fd_sc_hd__dlygate4sd3_1
X$13955 VDD synth_4116 VDD synth_4138 VNB|VSS VNB|VSS
+ sky130_fd_sc_hd__dlygate4sd3_1
X$13956 VDD synth_11877 VDD synth_11760 VNB|VSS VNB|VSS
+ sky130_fd_sc_hd__dlygate4sd3_1
X$13957 VDD synth_609 VDD synth_608 VNB|VSS VNB|VSS
+ sky130_fd_sc_hd__dlygate4sd3_1
X$13958 VDD synth_4708 VDD synth_4593 VNB|VSS VNB|VSS
+ sky130_fd_sc_hd__dlygate4sd3_1
X$13959 VDD synth_3193 VDD synth_3189 VNB|VSS VNB|VSS
+ sky130_fd_sc_hd__dlygate4sd3_1
X$13960 VDD synth_5429 VDD synth_5453 VNB|VSS VNB|VSS
+ sky130_fd_sc_hd__dlygate4sd3_1
X$13961 VDD synth_4049 VDD synth_4119 VNB|VSS VNB|VSS
+ sky130_fd_sc_hd__dlygate4sd3_1
X$13962 VDD synth_6635 VDD synth_6612 VNB|VSS VNB|VSS
+ sky130_fd_sc_hd__dlygate4sd3_1
X$13963 VDD synth_3271 VDD synth_3210 VNB|VSS VNB|VSS
+ sky130_fd_sc_hd__dlygate4sd3_1
X$13964 VDD synth_2084 VDD synth_1997 VNB|VSS VNB|VSS
+ sky130_fd_sc_hd__dlygate4sd3_1
X$13965 VDD synth_1413 VDD synth_1411 VNB|VSS VNB|VSS
+ sky130_fd_sc_hd__dlygate4sd3_1
X$13966 VDD synth_1203 VDD synth_1389 VNB|VSS VNB|VSS
+ sky130_fd_sc_hd__dlygate4sd3_1
X$13967 VDD synth_188 VDD synth_207 VNB|VSS VNB|VSS
+ sky130_fd_sc_hd__dlygate4sd3_1
X$13968 VDD synth_875 VDD synth_825 VNB|VSS VNB|VSS
+ sky130_fd_sc_hd__dlygate4sd3_1
X$13969 VDD synth_8147 VDD synth_8080 VNB|VSS VNB|VSS
+ sky130_fd_sc_hd__dlygate4sd3_1
X$13970 VNB|VSS synth_1351 synth_1432 synth_1482 synth_1404 VDD VDD VNB|VSS
+ sky130_fd_sc_hd__edfxtp_1
X$13971 VNB|VSS synth_5028 synth_4541 synth_966 synth_4752 VDD VDD VNB|VSS
+ sky130_fd_sc_hd__edfxtp_1
X$13972 VNB|VSS synth_10071 synth_10226 synth_10255 synth_10198 VDD VDD VNB|VSS
+ sky130_fd_sc_hd__edfxtp_1
X$13973 VNB|VSS synth_8330 synth_8391 synth_8419 synth_7963 VDD VDD VNB|VSS
+ sky130_fd_sc_hd__edfxtp_1
X$13974 VNB|VSS synth_3269 synth_2468 synth_1181 synth_3208 VDD VDD VNB|VSS
+ sky130_fd_sc_hd__edfxtp_1
X$13975 VNB|VSS synth_4895 synth_4833 synth_4834 synth_4793 VDD VDD VNB|VSS
+ sky130_fd_sc_hd__edfxtp_1
X$13976 VNB|VSS synth_437 synth_276 synth_183 synth_381 VDD VDD VNB|VSS
+ sky130_fd_sc_hd__edfxtp_1
X$13977 VNB|VSS synth_2555 synth_2432 synth_449 synth_2300 VDD VDD VNB|VSS
+ sky130_fd_sc_hd__edfxtp_1
X$13978 VNB|VSS synth_5532 synth_4651 synth_1181 synth_5290 VDD VDD VNB|VSS
+ sky130_fd_sc_hd__edfxtp_1
X$13979 VNB|VSS synth_12574 synth_12163 synth_12621 synth_12508 VDD VDD VNB|VSS
+ sky130_fd_sc_hd__edfxtp_1
X$13980 VNB|VSS synth_6985 synth_6828 synth_7141 synth_6850 VDD VDD VNB|VSS
+ sky130_fd_sc_hd__edfxtp_1
X$13981 VNB|VSS synth_2757 synth_2080 synth_2732 synth_2758 VDD VDD VNB|VSS
+ sky130_fd_sc_hd__edfxtp_1
X$13982 VNB|VSS synth_137 synth_89 synth_120 synth_13 VDD VDD VNB|VSS
+ sky130_fd_sc_hd__edfxtp_1
X$13983 VNB|VSS synth_245 synth_137 synth_181 synth_205 synth_246 synth_268 VDD
+ VDD VNB|VSS sky130_fd_sc_hd__a41o_1
X$13984 VNB|VSS synth_2911 synth_3335 synth_1459 synth_3208 VDD VDD VNB|VSS
+ sky130_fd_sc_hd__edfxtp_1
X$13985 VNB|VSS synth_3048 synth_3122 synth_3179 synth_2758 VDD VDD VNB|VSS
+ sky130_fd_sc_hd__edfxtp_1
X$13986 VNB|VSS synth_5065 synth_5217 synth_5329 synth_5114 VDD VDD VNB|VSS
+ sky130_fd_sc_hd__edfxtp_1
X$13987 VNB|VSS synth_5545 synth_5303 synth_5495 synth_5558 VDD VDD VNB|VSS
+ sky130_fd_sc_hd__edfxtp_1
X$13988 VNB|VSS synth_6302 synth_5753 synth_6336 synth_5909 VDD VDD VNB|VSS
+ sky130_fd_sc_hd__edfxtp_1
X$13989 VNB|VSS synth_5174 synth_5172 synth_5278 synth_5277 VDD VDD VNB|VSS
+ sky130_fd_sc_hd__edfxtp_1
X$13990 VNB|VSS synth_5977 synth_5953 synth_6037 synth_6033 VDD VDD VNB|VSS
+ sky130_fd_sc_hd__edfxtp_1
X$13991 VNB|VSS synth_5275 synth_5172 synth_5363 synth_5277 VDD VDD VNB|VSS
+ sky130_fd_sc_hd__edfxtp_1
X$13992 VNB|VSS synth_157 synth_36 synth_371 synth_96 VDD VDD VNB|VSS
+ sky130_fd_sc_hd__edfxtp_1
X$13993 VNB|VSS synth_5623 synth_5439 synth_4111 synth_5571 VDD VDD VNB|VSS
+ sky130_fd_sc_hd__edfxtp_1
X$13994 VNB|VSS synth_10933 synth_10628 synth_10974 synth_10604 VDD VDD VNB|VSS
+ sky130_fd_sc_hd__edfxtp_1
X$13995 VNB|VSS synth_6645 synth_6069 synth_382 synth_6343 VDD VDD VNB|VSS
+ sky130_fd_sc_hd__edfxtp_1
X$13996 VNB|VSS synth_6230 synth_5953 synth_6512 synth_6033 VDD VDD VNB|VSS
+ sky130_fd_sc_hd__edfxtp_1
X$13997 VNB|VSS synth_3672 synth_3818 synth_3934 synth_3295 VDD VDD VNB|VSS
+ sky130_fd_sc_hd__edfxtp_1
X$13998 VNB|VSS synth_665 VDD VDD VNB|VSS sky130_fd_sc_hd__clkinv_16
X$13999 VNB|VSS synth_10127 synth_9912 synth_6564 synth_10070 VDD VDD VNB|VSS
+ sky130_fd_sc_hd__edfxtp_1
X$14000 VNB|VSS synth_6247 synth_5715 synth_6322 synth_5850 VDD VDD VNB|VSS
+ sky130_fd_sc_hd__edfxtp_1
X$14001 VNB|VSS synth_12511 synth_12163 synth_12548 synth_12508 VDD VDD VNB|VSS
+ sky130_fd_sc_hd__edfxtp_1
X$14002 VNB|VSS synth_2689 synth_2205 synth_2766 synth_2592 VDD VDD VNB|VSS
+ sky130_fd_sc_hd__edfxtp_1
X$14003 VNB|VSS synth_4432 synth_3818 synth_4783 synth_4147 VDD VDD VNB|VSS
+ sky130_fd_sc_hd__edfxtp_1
X$14004 VNB|VSS synth_4879 synth_4651 synth_2860 synth_4910 VDD VDD VNB|VSS
+ sky130_fd_sc_hd__edfxtp_1
X$14005 VNB|VSS synth_3222 synth_3221 synth_2860 synth_3196 VDD VDD VNB|VSS
+ sky130_fd_sc_hd__edfxtp_1
X$14006 VNB|VSS synth_12383 synth_12163 synth_12624 synth_12295 VDD VDD VNB|VSS
+ sky130_fd_sc_hd__edfxtp_1
X$14007 VNB|VSS synth_10265 synth_10628 synth_10687 synth_10301 VDD VDD VNB|VSS
+ sky130_fd_sc_hd__edfxtp_1
X$14008 VNB|VSS synth_5104 synth_4651 synth_1459 synth_4910 VDD VDD VNB|VSS
+ sky130_fd_sc_hd__edfxtp_1
X$14009 VNB|VSS synth_5126 synth_5089 synth_5359 synth_5029 VDD VDD VNB|VSS
+ sky130_fd_sc_hd__edfxtp_1
X$14010 VNB|VSS synth_10263 synth_10355 synth_2777 synth_10424 VDD VDD VNB|VSS
+ sky130_fd_sc_hd__edfxtp_1
X$14011 VNB|VSS synth_10078 synth_9717 synth_2777 synth_9989 VDD VDD VNB|VSS
+ sky130_fd_sc_hd__edfxtp_1
X$14012 VNB|VSS synth_10203 synth_9717 synth_6564 synth_9989 VDD VDD VNB|VSS
+ sky130_fd_sc_hd__edfxtp_1
X$14013 VNB|VSS synth_5001 synth_5089 synth_5091 synth_5029 VDD VDD VNB|VSS
+ sky130_fd_sc_hd__edfxtp_1
X$14014 VNB|VSS synth_1350 synth_1345 synth_1555 synth_1232 VDD VDD VNB|VSS
+ sky130_fd_sc_hd__edfxtp_1
X$14015 VNB|VSS synth_12579 synth_11851 synth_12776 synth_12401 VDD VDD VNB|VSS
+ sky130_fd_sc_hd__edfxtp_1
X$14016 VNB|VSS synth_3160 synth_3318 synth_3192 synth_2894 VDD VDD VNB|VSS
+ sky130_fd_sc_hd__edfxtp_1
X$14017 VNB|VSS synth_6648 synth_6454 synth_6650 synth_6651 VDD VDD VNB|VSS
+ sky130_fd_sc_hd__edfxtp_1
X$14018 VNB|VSS synth_1694 synth_1265 synth_382 synth_1639 VDD VDD VNB|VSS
+ sky130_fd_sc_hd__edfxtp_1
X$14019 VNB|VSS synth_1513 synth_1432 synth_1511 synth_1073 VDD VDD VNB|VSS
+ sky130_fd_sc_hd__edfxtp_1
X$14020 VNB|VSS synth_6161 synth_5753 synth_6408 synth_5990 VDD VDD VNB|VSS
+ sky130_fd_sc_hd__edfxtp_1
X$14021 VNB|VSS synth_2260 synth_1833 synth_2294 synth_2185 VDD VDD VNB|VSS
+ sky130_fd_sc_hd__edfxtp_1
X$14022 VNB|VSS synth_10166 synth_9811 synth_10197 synth_10198 VDD VDD VNB|VSS
+ sky130_fd_sc_hd__edfxtp_1
X$14023 VNB|VSS synth_2862 synth_2268 synth_2795 synth_2839 VDD VDD VNB|VSS
+ sky130_fd_sc_hd__edfxtp_1
X$14024 VNB|VSS synth_3030 synth_2268 synth_3077 synth_2839 VDD VDD VNB|VSS
+ sky130_fd_sc_hd__edfxtp_1
X$14025 VNB|VSS synth_4087 synth_3818 synth_4146 synth_4147 VDD VDD VNB|VSS
+ sky130_fd_sc_hd__edfxtp_1
X$14026 VNB|VSS synth_10536 synth_9912 synth_6564 synth_10423 VDD VDD VNB|VSS
+ sky130_fd_sc_hd__edfxtp_1
X$14027 VNB|VSS synth_1683 synth_1136 synth_88 synth_1584 VDD VDD VNB|VSS
+ sky130_fd_sc_hd__edfxtp_1
X$14028 VNB|VSS synth_10678 synth_9912 synth_6699 synth_10423 VDD VDD VNB|VSS
+ sky130_fd_sc_hd__edfxtp_1
X$14029 VNB|VSS synth_6524 synth_6241 synth_4588 synth_6301 VDD VDD VNB|VSS
+ sky130_fd_sc_hd__edfxtp_1
X$14030 VNB|VSS synth_4878 synth_4826 synth_5102 synth_4723 VDD VDD VNB|VSS
+ sky130_fd_sc_hd__edfxtp_1
X$14031 VNB|VSS synth_2259 synth_1576 synth_387 synth_2439 VDD VDD VNB|VSS
+ sky130_fd_sc_hd__edfxtp_1
X$14032 VNB|VSS synth_12435 synth_11961 synth_6987 synth_12196 VDD VDD VNB|VSS
+ sky130_fd_sc_hd__edfxtp_1
X$14033 VNB|VSS synth_6458 synth_5715 synth_6500 synth_6319 VDD VDD VNB|VSS
+ sky130_fd_sc_hd__edfxtp_1
X$14034 VNB|VSS synth_5631 synth_4999 synth_1695 synth_5433 VDD VDD VNB|VSS
+ sky130_fd_sc_hd__edfxtp_1
X$14035 VNB|VSS synth_6340 synth_6241 synth_3656 synth_6301 VDD VDD VNB|VSS
+ sky130_fd_sc_hd__edfxtp_1
X$14036 VNB|VSS synth_10565 synth_10030 synth_10675 synth_10250 VDD VDD VNB|VSS
+ sky130_fd_sc_hd__edfxtp_1
X$14037 VNB|VSS synth_1662 synth_1898 synth_1663 synth_1660 VDD VDD VNB|VSS
+ sky130_fd_sc_hd__edfxtp_1
X$14038 VNB|VSS synth_1594 synth_1657 synth_478 synth_1658 VDD VDD VNB|VSS
+ sky130_fd_sc_hd__edfxtp_1
X$14039 VNB|VSS synth_179 synth_89 synth_118 synth_177 VDD VDD VNB|VSS
+ sky130_fd_sc_hd__edfxtp_1
X$14040 VNB|VSS synth_326 synth_276 synth_382 synth_381 VDD VDD VNB|VSS
+ sky130_fd_sc_hd__edfxtp_1
X$14041 VNB|VSS synth_5440 synth_5400 synth_4467 synth_5401 VDD VDD VNB|VSS
+ sky130_fd_sc_hd__edfxtp_1
X$14042 VNB|VSS synth_10251 synth_9986 synth_10225 synth_10250 VDD VDD VNB|VSS
+ sky130_fd_sc_hd__edfxtp_1
X$14043 VNB|VSS synth_452 synth_578 synth_478 synth_526 VDD VDD VNB|VSS
+ sky130_fd_sc_hd__edfxtp_1
X$14044 VNB|VSS synth_4073 synth_3557 synth_382 synth_4272 VDD VDD VNB|VSS
+ sky130_fd_sc_hd__edfxtp_1
X$14045 VNB|VSS synth_12141 synth_12202 synth_6987 synth_12086 VDD VDD VNB|VSS
+ sky130_fd_sc_hd__edfxtp_1
X$14046 VNB|VSS synth_5484 synth_5400 synth_1695 synth_5401 VDD VDD VNB|VSS
+ sky130_fd_sc_hd__edfxtp_1
X$14047 VNB|VSS synth_6287 synth_6237 synth_4111 synth_6297 VDD VDD VNB|VSS
+ sky130_fd_sc_hd__edfxtp_1
X$14048 VNB|VSS synth_4700 synth_4600 synth_626 synth_4601 VDD VDD VNB|VSS
+ sky130_fd_sc_hd__edfxtp_1
X$14049 VNB|VSS synth_5289 synth_4826 synth_5288 synth_5245 VDD VDD VNB|VSS
+ sky130_fd_sc_hd__edfxtp_1
X$14050 VNB|VSS synth_4957 synth_4826 synth_4774 synth_4481 VDD VDD VNB|VSS
+ sky130_fd_sc_hd__edfxtp_1
X$14051 VNB|VSS synth_618 synth_276 synth_183 synth_751 VDD VDD VNB|VSS
+ sky130_fd_sc_hd__edfxtp_1
X$14052 VNB|VSS synth_4622 synth_4600 synth_4111 synth_4601 VDD VDD VNB|VSS
+ sky130_fd_sc_hd__edfxtp_1
X$14053 VNB|VSS synth_5834 synth_5439 synth_626 synth_5571 VDD VDD VNB|VSS
+ sky130_fd_sc_hd__edfxtp_1
X$14054 VNB|VSS synth_10296 synth_9754 synth_6699 synth_10420 VDD VDD VNB|VSS
+ sky130_fd_sc_hd__edfxtp_1
X$14055 VNB|VSS synth_2499 synth_1906 synth_2606 synth_2133 VDD VDD VNB|VSS
+ sky130_fd_sc_hd__edfxtp_1
X$14056 VNB|VSS synth_2748 synth_2750 synth_626 synth_2733 VDD VDD VNB|VSS
+ sky130_fd_sc_hd__edfxtp_1
X$14057 VNB|VSS synth_1419 synth_1149 synth_1536 synth_1383 VDD VDD VNB|VSS
+ sky130_fd_sc_hd__edfxtp_1
X$14058 VNB|VSS synth_2809 synth_2750 synth_1908 synth_2733 VDD VDD VNB|VSS
+ sky130_fd_sc_hd__edfxtp_1
X$14059 VNB|VSS synth_3123 synth_2750 synth_1908 synth_3181 VDD VDD VNB|VSS
+ sky130_fd_sc_hd__edfxtp_1
X$14060 VNB|VSS synth_6165 synth_5447 synth_6318 synth_6164 VDD VDD VNB|VSS
+ sky130_fd_sc_hd__edfxtp_1
X$14061 VNB|VSS synth_7533 synth_6541 synth_387 synth_7388 VDD VDD VNB|VSS
+ sky130_fd_sc_hd__edfxtp_1
X$14062 VNB|VSS synth_12339 synth_12202 synth_6699 synth_12086 VDD VDD VNB|VSS
+ sky130_fd_sc_hd__edfxtp_1
X$14063 VNB|VSS synth_633 synth_578 synth_258 synth_526 VDD VDD VNB|VSS
+ sky130_fd_sc_hd__edfxtp_1
X$14064 VNB|VSS synth_7692 synth_7645 synth_7755 synth_7568 VDD VDD VNB|VSS
+ sky130_fd_sc_hd__edfxtp_1
X$14065 VNB|VSS synth_6182 synth_5531 synth_1695 synth_6022 VDD VDD VNB|VSS
+ sky130_fd_sc_hd__edfxtp_1
X$14066 VNB|VSS synth_12791 synth_11851 synth_12750 synth_12441 VDD VDD VNB|VSS
+ sky130_fd_sc_hd__edfxtp_1
X$14067 VNB|VSS synth_5814 synth_5227 synth_5783 synth_5870 VDD VDD VNB|VSS
+ sky130_fd_sc_hd__edfxtp_1
X$14068 VNB|VSS synth_12462 synth_11851 synth_12554 synth_12441 VDD VDD VNB|VSS
+ sky130_fd_sc_hd__edfxtp_1
X$14069 VNB|VSS synth_174 synth_53 synth_88 synth_12 VDD VDD VNB|VSS
+ sky130_fd_sc_hd__edfxtp_1
X$14070 VNB|VSS synth_12432 synth_11961 synth_6987 synth_12294 VDD VDD VNB|VSS
+ sky130_fd_sc_hd__edfxtp_1
X$14071 VNB|VSS synth_6419 synth_6347 synth_6372 synth_6373 VDD VDD VNB|VSS
+ sky130_fd_sc_hd__edfxtp_1
X$14072 VNB|VSS synth_12352 synth_11846 synth_12619 synth_12484 VDD VDD VNB|VSS
+ sky130_fd_sc_hd__edfxtp_1
X$14073 VNB|VSS synth_10976 synth_10538 synth_6987 synth_10857 VDD VDD VNB|VSS
+ sky130_fd_sc_hd__edfxtp_1
X$14074 VNB|VSS synth_589 synth_557 synth_387 synth_587 VDD VDD VNB|VSS
+ sky130_fd_sc_hd__edfxtp_1
X$14075 VNB|VSS synth_12327 synth_11846 synth_12373 synth_12484 VDD VDD VNB|VSS
+ sky130_fd_sc_hd__edfxtp_1
X$14076 VNB|VSS synth_366 synth_89 synth_607 synth_177 VDD VDD VNB|VSS
+ sky130_fd_sc_hd__edfxtp_1
X$14077 VNB|VSS synth_664 synth_89 synth_784 synth_736 VDD VDD VNB|VSS
+ sky130_fd_sc_hd__edfxtp_1
X$14078 VNB|VSS synth_1457 synth_840 synth_626 synth_1205 VDD VDD VNB|VSS
+ sky130_fd_sc_hd__edfxtp_1
X$14079 VNB|VSS synth_839 synth_25 synth_1097 synth_766 VDD VDD VNB|VSS
+ sky130_fd_sc_hd__edfxtp_1
X$14080 VNB|VSS synth_5994 synth_5159 synth_6036 synth_5990 VDD VDD VNB|VSS
+ sky130_fd_sc_hd__edfxtp_1
X$14081 VNB|VSS synth_1386 synth_840 synth_258 synth_1205 VDD VDD VNB|VSS
+ sky130_fd_sc_hd__edfxtp_1
X$14082 VNB|VSS synth_3725 synth_3794 synth_626 synth_3766 VDD VDD VNB|VSS
+ sky130_fd_sc_hd__edfxtp_1
X$14083 VNB|VSS synth_797 synth_51 synth_796 synth_512 VDD VDD VNB|VSS
+ sky130_fd_sc_hd__edfxtp_1
X$14084 VNB|VSS synth_3935 synth_3937 synth_966 synth_3766 VDD VDD VNB|VSS
+ sky130_fd_sc_hd__edfxtp_1
X$14085 VNB|VSS synth_4493 synth_3557 synth_387 synth_4272 VDD VDD VNB|VSS
+ sky130_fd_sc_hd__edfxtp_1
X$14086 VNB|VSS synth_12769 synth_11527 synth_12768 synth_12484 VDD VDD VNB|VSS
+ sky130_fd_sc_hd__edfxtp_1
X$14087 VNB|VSS synth_6270 synth_6241 synth_3656 synth_6158 VDD VDD VNB|VSS
+ sky130_fd_sc_hd__edfxtp_1
X$14088 VNB|VSS synth_3799 synth_3374 synth_3869 synth_3301 VDD VDD VNB|VSS
+ sky130_fd_sc_hd__edfxtp_1
X$14089 VNB|VSS synth_12584 synth_12024 synth_12778 synth_12205 VDD VDD VNB|VSS
+ sky130_fd_sc_hd__edfxtp_1
X$14090 VNB|VSS synth_5663 synth_5531 synth_4467 synth_5448 VDD VDD VNB|VSS
+ sky130_fd_sc_hd__edfxtp_1
X$14091 VNB|VSS synth_4877 synth_4600 synth_626 synth_4976 VDD VDD VNB|VSS
+ sky130_fd_sc_hd__edfxtp_1
X$14092 VNB|VSS synth_6423 synth_6237 synth_626 synth_6297 VDD VDD VNB|VSS
+ sky130_fd_sc_hd__edfxtp_1
X$14093 VNB|VSS synth_9988 synth_10226 synth_10300 synth_10198 VDD VDD VNB|VSS
+ sky130_fd_sc_hd__edfxtp_1
X$14094 VNB|VSS synth_5742 synth_5217 synth_5329 synth_5669 VDD VDD VNB|VSS
+ sky130_fd_sc_hd__edfxtp_1
X$14095 VNB|VSS synth_5049 synth_4575 synth_5120 synth_4925 VDD VDD VNB|VSS
+ sky130_fd_sc_hd__edfxtp_1
X$14096 VNB|VSS synth_609 synth_557 synth_88 synth_587 VDD VDD VNB|VSS
+ sky130_fd_sc_hd__edfxtp_1
X$14097 VNB|VSS synth_11121 synth_10538 synth_6699 synth_10857 VDD VDD VNB|VSS
+ sky130_fd_sc_hd__edfxtp_1
X$14098 VNB|VSS synth_5381 synth_4651 synth_2777 synth_5448 VDD VDD VNB|VSS
+ sky130_fd_sc_hd__edfxtp_1
X$14099 VNB|VSS synth_5308 synth_4575 synth_5548 synth_4925 VDD VDD VNB|VSS
+ sky130_fd_sc_hd__edfxtp_1
X$14100 VNB|VSS synth_10786 synth_10628 synth_10830 synth_10301 VDD VDD VNB|VSS
+ sky130_fd_sc_hd__edfxtp_1
X$14101 VNB|VSS synth_5873 synth_5249 synth_449 synth_5746 VDD VDD VNB|VSS
+ sky130_fd_sc_hd__edfxtp_1
X$14102 VNB|VSS synth_3930 synth_3794 synth_1908 synth_3766 VDD VDD VNB|VSS
+ sky130_fd_sc_hd__edfxtp_1
X$14103 VNB|VSS synth_6070 synth_6069 synth_382 synth_5746 VDD VDD VNB|VSS
+ sky130_fd_sc_hd__edfxtp_1
X$14104 VNB|VSS synth_6148 synth_6347 synth_6235 synth_5870 VDD VDD VNB|VSS
+ sky130_fd_sc_hd__edfxtp_1
X$14105 VNB|VSS synth_6600 synth_6347 synth_6547 synth_6373 VDD VDD VNB|VSS
+ sky130_fd_sc_hd__edfxtp_1
X$14106 VNB|VSS synth_5487 synth_5531 synth_1695 synth_5448 VDD VDD VNB|VSS
+ sky130_fd_sc_hd__edfxtp_1
X$14107 VNB|VSS synth_7989 synth_7645 synth_8273 synth_7885 VDD VDD VNB|VSS
+ sky130_fd_sc_hd__edfxtp_1
X$14108 VNB|VSS synth_5150 synth_4934 synth_5149 synth_5115 VDD VDD VNB|VSS
+ sky130_fd_sc_hd__edfxtp_1
X$14109 VNB|VSS synth_5074 synth_4934 synth_5118 synth_5115 VDD VDD VNB|VSS
+ sky130_fd_sc_hd__edfxtp_1
X$14110 VNB|VSS synth_2174 synth_1727 synth_2047 synth_2172 VDD VDD VNB|VSS
+ sky130_fd_sc_hd__edfxtp_1
X$14111 VNB|VSS synth_7922 synth_6897 synth_7997 synth_7620 VDD VDD VNB|VSS
+ sky130_fd_sc_hd__edfxtp_1
X$14112 VNB|VSS synth_2842 synth_2044 synth_1337 synth_2863 VDD VDD VNB|VSS
+ sky130_fd_sc_hd__edfxtp_1
X$14113 VNB|VSS synth_11525 synth_11294 synth_6564 synth_11231 VDD VDD VNB|VSS
+ sky130_fd_sc_hd__edfxtp_1
X$14114 VNB|VSS synth_5000 synth_4999 synth_2777 synth_4950 VDD VDD VNB|VSS
+ sky130_fd_sc_hd__edfxtp_1
X$14115 VNB|VSS synth_562 synth_51 synth_882 synth_512 VDD VDD VNB|VSS
+ sky130_fd_sc_hd__edfxtp_1
X$14116 VNB|VSS synth_7879 synth_7814 synth_7877 synth_7772 VDD VDD VNB|VSS
+ sky130_fd_sc_hd__edfxtp_1
X$14117 VNB|VSS synth_5692 synth_4999 synth_88 synth_5432 VDD VDD VNB|VSS
+ sky130_fd_sc_hd__edfxtp_1
X$14118 VNB|VSS synth_12635 synth_12163 synth_12551 synth_12401 VDD VDD VNB|VSS
+ sky130_fd_sc_hd__edfxtp_1
X$14119 VNB|VSS synth_5550 synth_5089 synth_5600 synth_5395 VDD VDD VNB|VSS
+ sky130_fd_sc_hd__edfxtp_1
X$14120 VNB|VSS synth_7902 synth_7576 synth_6198 synth_7860 VDD VDD VNB|VSS
+ sky130_fd_sc_hd__edfxtp_1
X$14121 VNB|VSS synth_8455 synth_7644 synth_2777 synth_8346 VDD VDD VNB|VSS
+ sky130_fd_sc_hd__edfxtp_1
X$14122 VNB|VSS synth_7124 synth_6927 synth_7223 synth_7068 VDD VDD VNB|VSS
+ sky130_fd_sc_hd__edfxtp_1
X$14123 VNB|VSS synth_1144 synth_840 synth_183 synth_1205 VDD VDD VNB|VSS
+ sky130_fd_sc_hd__edfxtp_1
X$14124 VNB|VSS synth_7383 synth_6734 synth_7717 synth_7139 VDD VDD VNB|VSS
+ sky130_fd_sc_hd__edfxtp_1
X$14125 VNB|VSS synth_5416 synth_4934 synth_5610 synth_5115 VDD VDD VNB|VSS
+ sky130_fd_sc_hd__edfxtp_1
X$14126 VNB|VSS synth_1436 synth_1437 synth_382 synth_1414 VDD VDD VNB|VSS
+ sky130_fd_sc_hd__edfxtp_1
X$14127 VNB|VSS synth_6519 synth_6347 synth_6649 synth_6279 VDD VDD VNB|VSS
+ sky130_fd_sc_hd__edfxtp_1
X$14128 VNB|VSS synth_5995 synth_5715 synth_6106 synth_5850 VDD VDD VNB|VSS
+ sky130_fd_sc_hd__edfxtp_1
X$14129 VNB|VSS synth_12260 synth_11961 synth_8337 synth_12294 VDD VDD VNB|VSS
+ sky130_fd_sc_hd__edfxtp_1
X$14130 VNB|VSS synth_11368 synth_11489 synth_11492 synth_11264 VDD VDD VNB|VSS
+ sky130_fd_sc_hd__edfxtp_1
X$14131 VNB|VSS synth_158 synth_36 synth_114 synth_96 VDD VDD VNB|VSS
+ sky130_fd_sc_hd__edfxtp_1
X$14132 VNB|VSS synth_8110 synth_8228 synth_6699 synth_8148 VDD VDD VNB|VSS
+ sky130_fd_sc_hd__edfxtp_1
X$14133 VNB|VSS synth_7988 synth_6734 synth_8343 synth_7885 VDD VDD VNB|VSS
+ sky130_fd_sc_hd__edfxtp_1
X$14134 VNB|VSS synth_7378 synth_7022 synth_5329 synth_7105 VDD VDD VNB|VSS
+ sky130_fd_sc_hd__edfxtp_1
X$14135 VNB|VSS synth_7002 synth_6897 synth_7001 synth_6967 VDD VDD VNB|VSS
+ sky130_fd_sc_hd__edfxtp_1
X$14136 VNB|VSS synth_518 synth_517 synth_183 synth_445 VDD VDD VNB|VSS
+ sky130_fd_sc_hd__edfxtp_1
X$14137 VNB|VSS synth_683 synth_571 synth_705 synth_645 VDD VDD VNB|VSS
+ sky130_fd_sc_hd__edfxtp_1
X$14138 VNB|VSS synth_573 synth_571 synth_572 synth_645 VDD VDD VNB|VSS
+ sky130_fd_sc_hd__edfxtp_1
X$14139 VNB|VSS synth_6007 synth_5172 synth_6094 synth_6090 VDD VDD VNB|VSS
+ sky130_fd_sc_hd__edfxtp_1
X$14140 VNB|VSS synth_539 synth_446 synth_478 synth_479 VDD VDD VNB|VSS
+ sky130_fd_sc_hd__edfxtp_1
X$14141 VNB|VSS synth_7194 synth_6897 synth_7462 synth_6967 VDD VDD VNB|VSS
+ sky130_fd_sc_hd__edfxtp_1
X$14142 VNB|VSS synth_7912 synth_7645 synth_8275 synth_7992 VDD VDD VNB|VSS
+ sky130_fd_sc_hd__edfxtp_1
X$14143 VNB|VSS synth_1640 synth_1810 synth_1938 synth_1359 VDD VDD VNB|VSS
+ sky130_fd_sc_hd__edfxtp_1
X$14144 VNB|VSS synth_3303 synth_3284 synth_478 synth_3302 VDD VDD VNB|VSS
+ sky130_fd_sc_hd__edfxtp_1
X$14145 VNB|VSS synth_3778 synth_3413 synth_3779 synth_3650 VDD VDD VNB|VSS
+ sky130_fd_sc_hd__edfxtp_1
X$14146 VNB|VSS synth_7547 synth_6897 synth_7619 synth_7620 VDD VDD VNB|VSS
+ sky130_fd_sc_hd__edfxtp_1
X$14147 VNB|VSS synth_8996 synth_9270 synth_8899 synth_8790 VDD VDD VNB|VSS
+ sky130_fd_sc_hd__edfxtp_1
X$14148 VNB|VSS synth_3528 synth_3284 synth_449 synth_3302 VDD VDD VNB|VSS
+ sky130_fd_sc_hd__edfxtp_1
X$14149 VNB|VSS synth_5094 synth_4299 synth_1695 synth_4953 VDD VDD VNB|VSS
+ sky130_fd_sc_hd__edfxtp_1
X$14150 VNB|VSS synth_7926 synth_7022 synth_5329 synth_7999 VDD VDD VNB|VSS
+ sky130_fd_sc_hd__edfxtp_1
X$14151 VNB|VSS synth_4930 synth_4657 synth_4588 synth_4989 VDD VDD VNB|VSS
+ sky130_fd_sc_hd__edfxtp_1
X$14152 VNB|VSS synth_6755 synth_6459 synth_4588 synth_6460 VDD VDD VNB|VSS
+ sky130_fd_sc_hd__edfxtp_1
X$14153 VNB|VSS synth_4738 synth_4657 synth_4111 synth_4989 VDD VDD VNB|VSS
+ sky130_fd_sc_hd__edfxtp_1
X$14154 VNB|VSS synth_5256 synth_5016 synth_4111 synth_4932 VDD VDD VNB|VSS
+ sky130_fd_sc_hd__edfxtp_1
X$14155 VNB|VSS synth_6786 synth_6069 synth_4588 synth_6802 VDD VDD VNB|VSS
+ sky130_fd_sc_hd__edfxtp_1
X$14156 VNB|VSS synth_2464 synth_2465 synth_2612 synth_2185 VDD VDD VNB|VSS
+ sky130_fd_sc_hd__edfxtp_1
X$14157 VNB|VSS synth_9265 synth_8533 synth_9263 synth_9164 VDD VDD VNB|VSS
+ sky130_fd_sc_hd__edfxtp_1
X$14158 VNB|VSS synth_3484 synth_3413 synth_3578 synth_3185 VDD VDD VNB|VSS
+ sky130_fd_sc_hd__edfxtp_1
X$14159 VNB|VSS synth_6785 synth_6069 synth_5329 synth_6802 VDD VDD VNB|VSS
+ sky130_fd_sc_hd__edfxtp_1
X$14160 VNB|VSS synth_819 synth_484 synth_258 synth_748 VDD VDD VNB|VSS
+ sky130_fd_sc_hd__edfxtp_1
X$14161 VNB|VSS synth_5109 synth_5016 synth_501 synth_4932 VDD VDD VNB|VSS
+ sky130_fd_sc_hd__edfxtp_1
X$14162 VNB|VSS synth_1180 synth_484 synth_183 synth_1114 VDD VDD VNB|VSS
+ sky130_fd_sc_hd__edfxtp_1
X$14163 VNB|VSS synth_7400 synth_7023 synth_7549 synth_7623 VDD VDD VNB|VSS
+ sky130_fd_sc_hd__edfxtp_1
X$14164 VNB|VSS synth_7901 synth_7023 synth_7782 synth_7859 VDD VDD VNB|VSS
+ sky130_fd_sc_hd__edfxtp_1
X$14165 VNB|VSS synth_5189 synth_4299 synth_88 synth_4953 VDD VDD VNB|VSS
+ sky130_fd_sc_hd__edfxtp_1
X$14166 VNB|VSS synth_2933 synth_2320 synth_2777 synth_3017 VDD VDD VNB|VSS
+ sky130_fd_sc_hd__edfxtp_1
X$14167 VNB|VSS synth_1403 synth_1265 synth_1181 synth_1114 VDD VDD VNB|VSS
+ sky130_fd_sc_hd__edfxtp_1
X$14168 VNB|VSS synth_8226 synth_8165 synth_5329 synth_8166 VDD VDD VNB|VSS
+ sky130_fd_sc_hd__edfxtp_1
X$14169 VNB|VSS synth_3190 synth_2320 synth_37 synth_3017 VDD VDD VNB|VSS
+ sky130_fd_sc_hd__edfxtp_1
X$14170 VNB|VSS synth_2526 synth_2339 synth_2634 synth_2172 VDD VDD VNB|VSS
+ sky130_fd_sc_hd__edfxtp_1
X$14171 VNB|VSS synth_7484 synth_6897 synth_7622 synth_7623 VDD VDD VNB|VSS
+ sky130_fd_sc_hd__edfxtp_1
X$14172 VNB|VSS synth_2702 synth_2044 synth_382 synth_2635 VDD VDD VNB|VSS
+ sky130_fd_sc_hd__edfxtp_1
X$14173 VNB|VSS synth_2636 synth_2044 synth_1181 synth_2635 VDD VDD VNB|VSS
+ sky130_fd_sc_hd__edfxtp_1
X$14174 VNB|VSS synth_2585 synth_2339 synth_2773 synth_2172 VDD VDD VNB|VSS
+ sky130_fd_sc_hd__edfxtp_1
X$14175 VNB|VSS synth_2931 synth_1437 synth_449 synth_2868 VDD VDD VNB|VSS
+ sky130_fd_sc_hd__edfxtp_1
X$14176 VNB|VSS synth_849 synth_840 synth_478 synth_767 VDD VDD VNB|VSS
+ sky130_fd_sc_hd__edfxtp_1
X$14177 VNB|VSS synth_11523 synth_11489 synth_11555 synth_11363 VDD VDD VNB|VSS
+ sky130_fd_sc_hd__edfxtp_1
X$14178 VNB|VSS synth_2819 synth_2320 synth_2777 synth_2599 VDD VDD VNB|VSS
+ sky130_fd_sc_hd__edfxtp_1
X$14179 VNB|VSS synth_11553 synth_11294 synth_6987 synth_11442 VDD VDD VNB|VSS
+ sky130_fd_sc_hd__edfxtp_1
X$14180 VNB|VSS synth_2528 synth_2320 synth_88 synth_2599 VDD VDD VNB|VSS
+ sky130_fd_sc_hd__edfxtp_1
X$14181 VNB|VSS synth_7931 synth_7576 synth_5329 synth_7860 VDD VDD VNB|VSS
+ sky130_fd_sc_hd__edfxtp_1
X$14182 VNB|VSS synth_750 synth_484 synth_37 synth_748 VDD VDD VNB|VSS
+ sky130_fd_sc_hd__edfxtp_1
X$14183 VNB|VSS synth_1227 synth_439 synth_382 synth_1184 VDD VDD VNB|VSS
+ sky130_fd_sc_hd__edfxtp_1
X$14184 VNB|VSS synth_989 synth_756 synth_986 synth_755 VDD VDD VNB|VSS
+ sky130_fd_sc_hd__edfxtp_1
X$14185 VNB|VSS synth_822 synth_282 synth_966 synth_656 VDD VDD VNB|VSS
+ sky130_fd_sc_hd__edfxtp_1
X$14186 VNB|VSS synth_3297 synth_2533 synth_3296 synth_3295 VDD VDD VNB|VSS
+ sky130_fd_sc_hd__edfxtp_1
X$14187 VNB|VSS synth_184 synth_54 synth_88 synth_182 VDD VDD VNB|VSS
+ sky130_fd_sc_hd__edfxtp_1
X$14188 VNB|VSS synth_12335 synth_11849 synth_6699 synth_12166 VDD VDD VNB|VSS
+ sky130_fd_sc_hd__edfxtp_1
X$14189 VNB|VSS synth_6173 synth_5400 synth_2777 synth_6015 VDD VDD VNB|VSS
+ sky130_fd_sc_hd__edfxtp_1
X$14190 VNB|VSS synth_3738 synth_3397 synth_3801 synth_3764 VDD VDD VNB|VSS
+ sky130_fd_sc_hd__edfxtp_1
X$14191 VNB|VSS synth_2796 synth_2339 synth_2724 synth_2727 VDD VDD VNB|VSS
+ sky130_fd_sc_hd__edfxtp_1
X$14192 VNB|VSS synth_5730 synth_5089 synth_6014 synth_5833 VDD VDD VNB|VSS
+ sky130_fd_sc_hd__edfxtp_1
X$14193 VNB|VSS synth_2652 synth_2193 synth_1908 synth_2863 VDD VDD VNB|VSS
+ sky130_fd_sc_hd__edfxtp_1
X$14194 VNB|VSS synth_5838 synth_5439 synth_626 synth_5686 VDD VDD VNB|VSS
+ sky130_fd_sc_hd__edfxtp_1
X$14195 VNB|VSS synth_2651 synth_2339 synth_2650 synth_2727 VDD VDD VNB|VSS
+ sky130_fd_sc_hd__edfxtp_1
X$14196 VNB|VSS synth_9684 synth_9912 synth_6564 synth_9840 VDD VDD VNB|VSS
+ sky130_fd_sc_hd__edfxtp_1
X$14197 VNB|VSS synth_9404 synth_8659 synth_6699 synth_9570 VDD VDD VNB|VSS
+ sky130_fd_sc_hd__edfxtp_1
X$14198 VNB|VSS synth_5624 synth_5172 synth_5761 synth_5516 VDD VDD VNB|VSS
+ sky130_fd_sc_hd__edfxtp_1
X$14199 VNB|VSS synth_6313 synth_6059 synth_6216 synth_6254 VDD VDD VNB|VSS
+ sky130_fd_sc_hd__edfxtp_1
X$14200 VNB|VSS synth_10541 synth_10538 synth_6564 synth_10424 VDD VDD VNB|VSS
+ sky130_fd_sc_hd__edfxtp_1
X$14201 VNB|VSS synth_10685 synth_10538 synth_6699 synth_10424 VDD VDD VNB|VSS
+ sky130_fd_sc_hd__edfxtp_1
X$14202 VNB|VSS synth_12266 synth_11961 synth_8337 synth_12196 VDD VDD VNB|VSS
+ sky130_fd_sc_hd__edfxtp_1
X$14203 VNB|VSS synth_12102 synth_11840 synth_8337 synth_11885 VDD VDD VNB|VSS
+ sky130_fd_sc_hd__edfxtp_1
X$14204 VNB|VSS synth_12738 synth_11846 synth_12770 synth_12508 VDD VDD VNB|VSS
+ sky130_fd_sc_hd__edfxtp_1
X$14205 VNB|VSS synth_5790 synth_5089 synth_5835 synth_5833 VDD VDD VNB|VSS
+ sky130_fd_sc_hd__edfxtp_1
X$14206 VNB|VSS synth_3765 synth_3703 synth_3803 synth_3764 VDD VDD VNB|VSS
+ sky130_fd_sc_hd__edfxtp_1
X$14207 VNB|VSS synth_717 synth_282 synth_183 synth_656 VDD VDD VNB|VSS
+ sky130_fd_sc_hd__edfxtp_1
X$14208 VNB|VSS synth_3300 synth_2533 synth_3340 synth_3298 VDD VDD VNB|VSS
+ sky130_fd_sc_hd__edfxtp_1
X$14209 VNB|VSS synth_341 synth_484 synth_88 synth_419 VDD VDD VNB|VSS
+ sky130_fd_sc_hd__edfxtp_1
X$14210 VNB|VSS synth_210 synth_51 synth_544 synth_50 VDD VDD VNB|VSS
+ sky130_fd_sc_hd__edfxtp_1
X$14211 VNB|VSS synth_12443 synth_11849 synth_8337 synth_12166 VDD VDD VNB|VSS
+ sky130_fd_sc_hd__edfxtp_1
X$14212 VNB|VSS synth_3354 synth_3169 synth_1337 synth_3170 VDD VDD VNB|VSS
+ sky130_fd_sc_hd__edfxtp_1
X$14213 VNB|VSS synth_619 synth_63 synth_658 synth_565 VDD VDD VNB|VSS
+ sky130_fd_sc_hd__edfxtp_1
X$14214 VNB|VSS synth_3350 synth_3169 synth_1337 synth_3214 VDD VDD VNB|VSS
+ sky130_fd_sc_hd__edfxtp_1
X$14215 VNB|VSS synth_3346 synth_3374 synth_3227 synth_3301 VDD VDD VNB|VSS
+ sky130_fd_sc_hd__edfxtp_1
X$14216 VNB|VSS synth_34 synth_36 synth_115 synth_96 VDD VDD VNB|VSS
+ sky130_fd_sc_hd__edfxtp_1
X$14217 VNB|VSS synth_6618 synth_6531 synth_1695 synth_6424 VDD VDD VNB|VSS
+ sky130_fd_sc_hd__edfxtp_1
X$14218 VNB|VSS synth_9165 synth_8533 synth_9261 synth_9164 VDD VDD VNB|VSS
+ sky130_fd_sc_hd__edfxtp_1
X$14219 VNB|VSS synth_485 synth_484 synth_37 synth_419 VDD VDD VNB|VSS
+ sky130_fd_sc_hd__edfxtp_1
X$14220 VNB|VSS synth_5877 synth_6059 synth_5876 synth_5833 VDD VDD VNB|VSS
+ sky130_fd_sc_hd__edfxtp_1
X$14221 VNB|VSS synth_3083 synth_2800 synth_478 synth_2868 VDD VDD VNB|VSS
+ sky130_fd_sc_hd__edfxtp_1
X$14222 VNB|VSS synth_2438 synth_2179 synth_2410 synth_2292 VDD VDD VNB|VSS
+ sky130_fd_sc_hd__edfxtp_1
X$14223 VNB|VSS synth_1792 synth_1576 synth_1695 synth_1534 VDD VDD VNB|VSS
+ sky130_fd_sc_hd__edfxtp_1
X$14224 VNB|VSS synth_3109 synth_2339 synth_3171 synth_3172 VDD VDD VNB|VSS
+ sky130_fd_sc_hd__edfxtp_1
X$14225 VNB|VSS synth_6176 synth_6059 synth_6175 synth_6174 VDD VDD VNB|VSS
+ sky130_fd_sc_hd__edfxtp_1
X$14226 VNB|VSS synth_764 synth_640 synth_778 synth_575 VDD VDD VNB|VSS
+ sky130_fd_sc_hd__edfxtp_1
X$14227 VNB|VSS synth_639 synth_640 synth_574 synth_575 VDD VDD VNB|VSS
+ sky130_fd_sc_hd__edfxtp_1
X$14228 VNB|VSS synth_7174 synth_7022 synth_5329 synth_6968 VDD VDD VNB|VSS
+ sky130_fd_sc_hd__edfxtp_1
X$14229 VNB|VSS synth_7108 synth_7023 synth_7177 synth_7179 VDD VDD VNB|VSS
+ sky130_fd_sc_hd__edfxtp_1
X$14230 VNB|VSS synth_2866 synth_2339 synth_3003 synth_2727 VDD VDD VNB|VSS
+ sky130_fd_sc_hd__edfxtp_1
X$14231 VNB|VSS synth_8270 synth_7814 synth_8411 synth_7772 VDD VDD VNB|VSS
+ sky130_fd_sc_hd__edfxtp_1
X$14232 VNB|VSS synth_6289 synth_6059 synth_6392 synth_6254 VDD VDD VNB|VSS
+ sky130_fd_sc_hd__edfxtp_1
X$14233 VNB|VSS synth_2070 synth_1576 synth_88 synth_1981 VDD VDD VNB|VSS
+ sky130_fd_sc_hd__edfxtp_1
X$14234 VNB|VSS synth_100 synth_25 synth_101 synth_23 VDD VDD VNB|VSS
+ sky130_fd_sc_hd__edfxtp_1
X$14235 VNB|VSS synth_7107 synth_7023 synth_7178 synth_7179 VDD VDD VNB|VSS
+ sky130_fd_sc_hd__edfxtp_1
X$14236 VNB|VSS synth_983 synth_439 synth_382 synth_1074 VDD VDD VNB|VSS
+ sky130_fd_sc_hd__edfxtp_1
X$14237 VNB|VSS synth_2460 synth_2339 synth_2459 synth_2318 VDD VDD VNB|VSS
+ sky130_fd_sc_hd__edfxtp_1
X$14238 VNB|VSS synth_2021 synth_1727 synth_2251 synth_1638 VDD VDD VNB|VSS
+ sky130_fd_sc_hd__edfxtp_1
X$14239 VNB|VSS synth_4445 synth_3703 synth_4568 synth_4105 VDD VDD VNB|VSS
+ sky130_fd_sc_hd__edfxtp_1
X$14240 VNB|VSS synth_708 synth_517 synth_258 synth_762 VDD VDD VNB|VSS
+ sky130_fd_sc_hd__edfxtp_1
X$14241 VNB|VSS synth_2163 synth_1136 synth_88 synth_2111 VDD VDD VNB|VSS
+ sky130_fd_sc_hd__edfxtp_1
X$14242 VNB|VSS synth_2025 synth_1265 synth_1181 synth_1639 VDD VDD VNB|VSS
+ sky130_fd_sc_hd__edfxtp_1
X$14243 VNB|VSS synth_5154 synth_5478 synth_5152 synth_4739 VDD VDD VNB|VSS
+ sky130_fd_sc_hd__edfxtp_1
X$14244 VNB|VSS synth_9449 synth_8659 synth_6987 synth_9570 VDD VDD VNB|VSS
+ sky130_fd_sc_hd__edfxtp_1
X$14245 VNB|VSS synth_6315 synth_6059 synth_6218 synth_6174 VDD VDD VNB|VSS
+ sky130_fd_sc_hd__edfxtp_1
X$14246 VNB|VSS synth_8318 synth_8082 synth_8439 synth_8004 VDD VDD VNB|VSS
+ sky130_fd_sc_hd__edfxtp_1
X$14247 VNB|VSS synth_1363 synth_1276 synth_1277 synth_909 VDD VDD VNB|VSS
+ sky130_fd_sc_hd__edfxtp_1
X$14248 VNB|VSS synth_5541 synth_4657 synth_626 synth_5255 VDD VDD VNB|VSS
+ sky130_fd_sc_hd__edfxtp_1
X$14249 VNB|VSS synth_242 synth_446 synth_449 synth_401 VDD VDD VNB|VSS
+ sky130_fd_sc_hd__edfxtp_1
X$14250 VDD synth_33 VNB|VSS VDD VNB|VSS sky130_fd_sc_hd__clkbuf_1
X$14251 VNB|VSS synth_1567 synth_439 synth_501 synth_1414 VDD VDD VNB|VSS
+ sky130_fd_sc_hd__edfxtp_1
X$14252 VNB|VSS synth_5719 synth_4934 synth_5716 synth_5671 VDD VDD VNB|VSS
+ sky130_fd_sc_hd__edfxtp_1
X$14253 VNB|VSS synth_1334 synth_439 synth_183 synth_1414 VDD VDD VNB|VSS
+ sky130_fd_sc_hd__edfxtp_1
X$14254 VNB|VSS synth_2661 synth_2432 synth_478 synth_2684 VDD VDD VNB|VSS
+ sky130_fd_sc_hd__edfxtp_1
X$14255 VNB|VSS synth_12424 synth_12036 synth_6564 synth_12222 VDD VDD VNB|VSS
+ sky130_fd_sc_hd__edfxtp_1
X$14256 VNB|VSS synth_11979 synth_12036 synth_6564 synth_11761 VDD VDD VNB|VSS
+ sky130_fd_sc_hd__edfxtp_1
X$14257 VNB|VSS synth_2915 synth_2804 synth_449 synth_2684 VDD VDD VNB|VSS
+ sky130_fd_sc_hd__edfxtp_1
X$14258 VNB|VSS synth_3178 synth_1970 synth_3215 synth_3091 VDD VDD VNB|VSS
+ sky130_fd_sc_hd__edfxtp_1
X$14259 VNB|VSS synth_1601 synth_571 synth_1679 synth_1491 VDD VDD VNB|VSS
+ sky130_fd_sc_hd__edfxtp_1
X$14260 VNB|VSS synth_10811 synth_10467 synth_6564 synth_10748 VDD VDD VNB|VSS
+ sky130_fd_sc_hd__edfxtp_1
X$14261 VNB|VSS synth_6385 synth_6459 synth_4111 synth_6460 VDD VDD VNB|VSS
+ sky130_fd_sc_hd__edfxtp_1
X$14262 VNB|VSS synth_7301 synth_7022 synth_4566 synth_7105 VDD VDD VNB|VSS
+ sky130_fd_sc_hd__edfxtp_1
X$14263 VNB|VSS synth_785 synth_53 synth_501 synth_734 VDD VDD VNB|VSS
+ sky130_fd_sc_hd__edfxtp_1
X$14264 VNB|VSS synth_5170 synth_5515 synth_5443 synth_4942 VDD VDD VNB|VSS
+ sky130_fd_sc_hd__edfxtp_1
X$14265 VNB|VSS synth_11512 synth_11536 synth_4467 synth_11380 VDD VDD VNB|VSS
+ sky130_fd_sc_hd__edfxtp_1
X$14266 VNB|VSS synth_11071 synth_10804 synth_11188 synth_10812 VDD VDD VNB|VSS
+ sky130_fd_sc_hd__edfxtp_1
X$14267 VNB|VSS synth_265 synth_89 synth_310 synth_177 VDD VDD VNB|VSS
+ sky130_fd_sc_hd__edfxtp_1
X$14268 VNB|VSS synth_12167 synth_11536 synth_6564 synth_12047 VDD VDD VNB|VSS
+ sky130_fd_sc_hd__edfxtp_1
X$14269 VNB|VSS synth_6260 synth_6611 synth_4111 synth_6626 VDD VDD VNB|VSS
+ sky130_fd_sc_hd__edfxtp_1
X$14270 VNB|VSS synth_11722 synth_11719 synth_11838 synth_11672 VDD VDD VNB|VSS
+ sky130_fd_sc_hd__edfxtp_1
X$14271 VNB|VSS synth_11381 synth_10090 synth_11577 synth_10937 VDD VDD VNB|VSS
+ sky130_fd_sc_hd__edfxtp_1
X$14272 VNB|VSS synth_4018 synth_4019 synth_4152 synth_3998 VDD VDD VNB|VSS
+ sky130_fd_sc_hd__edfxtp_1
X$14273 VNB|VSS synth_11042 synth_10804 synth_11115 synth_10812 VDD VDD VNB|VSS
+ sky130_fd_sc_hd__edfxtp_1
X$14274 VNB|VSS synth_11824 synth_11294 synth_6699 synth_11761 VDD VDD VNB|VSS
+ sky130_fd_sc_hd__edfxtp_1
X$14275 VNB|VSS synth_5425 synth_5082 synth_966 synth_5508 VDD VDD VNB|VSS
+ sky130_fd_sc_hd__edfxtp_1
X$14276 VNB|VSS synth_1766 synth_1142 synth_183 synth_1677 VDD VDD VNB|VSS
+ sky130_fd_sc_hd__edfxtp_1
X$14277 VNB|VSS synth_11449 synth_10549 synth_6564 synth_11421 VDD VDD VNB|VSS
+ sky130_fd_sc_hd__edfxtp_1
X$14278 VNB|VSS synth_11295 synth_11294 synth_8337 synth_11231 VDD VDD VNB|VSS
+ sky130_fd_sc_hd__edfxtp_1
X$14279 VNB|VSS synth_12445 synth_12202 synth_8337 synth_12227 VDD VDD VNB|VSS
+ sky130_fd_sc_hd__edfxtp_1
X$14280 VNB|VSS synth_848 synth_1011 synth_501 synth_892 VDD VDD VNB|VSS
+ sky130_fd_sc_hd__edfxtp_1
X$14281 VNB|VSS synth_3605 synth_3025 synth_2860 synth_3454 VDD VDD VNB|VSS
+ sky130_fd_sc_hd__edfxtp_1
X$14282 VNB|VSS synth_12066 synth_11917 synth_12064 synth_11839 VDD VDD VNB|VSS
+ sky130_fd_sc_hd__edfxtp_1
X$14283 VNB|VSS synth_12275 synth_11536 synth_6987 synth_12227 VDD VDD VNB|VSS
+ sky130_fd_sc_hd__edfxtp_1
X$14284 VNB|VSS synth_11916 synth_11489 synth_11943 synth_11839 VDD VDD VNB|VSS
+ sky130_fd_sc_hd__edfxtp_1
X$14285 VNB|VSS synth_6102 synth_5447 synth_6179 synth_6164 VDD VDD VNB|VSS
+ sky130_fd_sc_hd__edfxtp_1
X$14286 VNB|VSS synth_12457 synth_12036 synth_6987 synth_12222 VDD VDD VNB|VSS
+ sky130_fd_sc_hd__edfxtp_1
X$14287 VNB|VSS synth_12588 synth_12024 synth_12779 synth_12761 VDD VDD VNB|VSS
+ sky130_fd_sc_hd__edfxtp_1
X$14288 VNB|VSS synth_4703 synth_4264 synth_1181 synth_4486 VDD VDD VNB|VSS
+ sky130_fd_sc_hd__edfxtp_1
X$14289 VNB|VSS synth_1145 synth_1011 synth_88 synth_892 VDD VDD VNB|VSS
+ sky130_fd_sc_hd__edfxtp_1
X$14290 VDD synth_1234 synth_1304 VNB|VSS VDD VNB|VSS sky130_fd_sc_hd__buf_1
X$14291 VNB|VSS synth_3630 synth_3820 synth_3740 synth_3755 VDD VDD VNB|VSS
+ sky130_fd_sc_hd__edfxtp_1
X$14292 VNB|VSS synth_7581 synth_6939 synth_7634 synth_7410 VDD VDD VNB|VSS
+ sky130_fd_sc_hd__edfxtp_1
X$14293 VNB|VSS synth_6689 synth_6611 synth_4111 synth_6505 VDD VDD VNB|VSS
+ sky130_fd_sc_hd__edfxtp_1
X$14294 VNB|VSS synth_10508 synth_9896 synth_387 synth_10279 VDD VDD VNB|VSS
+ sky130_fd_sc_hd__edfxtp_1
X$14295 VNB|VSS synth_10842 synth_10616 synth_10841 synth_10765 VDD VDD VNB|VSS
+ sky130_fd_sc_hd__edfxtp_1
X$14296 VNB|VSS synth_6811 synth_6939 synth_6883 synth_6813 VDD VDD VNB|VSS
+ sky130_fd_sc_hd__edfxtp_1
X$14297 VNB|VSS synth_3203 synth_2432 synth_478 synth_3204 VDD VDD VNB|VSS
+ sky130_fd_sc_hd__edfxtp_1
X$14298 VNB|VSS synth_3724 synth_3569 synth_3790 synth_3676 VDD VDD VNB|VSS
+ sky130_fd_sc_hd__edfxtp_1
X$14299 VNB|VSS synth_3045 synth_3043 synth_3134 synth_3312 VDD VDD VNB|VSS
+ sky130_fd_sc_hd__edfxtp_1
X$14300 VNB|VSS synth_5596 synth_5407 synth_4566 synth_5408 VDD VDD VNB|VSS
+ sky130_fd_sc_hd__edfxtp_1
X$14301 VNB|VSS synth_11087 synth_10616 synth_11213 synth_10765 VDD VDD VNB|VSS
+ sky130_fd_sc_hd__edfxtp_1
X$14302 VNB|VSS synth_11741 synth_11536 synth_1695 synth_11717 VDD VDD VNB|VSS
+ sky130_fd_sc_hd__edfxtp_1
X$14303 VNB|VSS synth_5242 synth_4461 synth_5437 synth_5395 VDD VDD VNB|VSS
+ sky130_fd_sc_hd__edfxtp_1
X$14304 VNB|VSS synth_8323 synth_8553 synth_8377 synth_7864 VDD VDD VNB|VSS
+ sky130_fd_sc_hd__edfxtp_1
X$14305 VNB|VSS synth_4338 synth_3543 synth_4339 synth_4476 VDD VDD VNB|VSS
+ sky130_fd_sc_hd__edfxtp_1
X$14306 VNB|VSS synth_12351 synth_12036 synth_8337 synth_12291 VDD VDD VNB|VSS
+ sky130_fd_sc_hd__edfxtp_1
X$14307 VNB|VSS synth_7899 synth_6939 synth_7900 synth_7864 VDD VDD VNB|VSS
+ sky130_fd_sc_hd__edfxtp_1
X$14308 VNB|VSS synth_8170 synth_8082 synth_8373 synth_8004 VDD VDD VNB|VSS
+ sky130_fd_sc_hd__edfxtp_1
X$14309 VNB|VSS synth_10985 synth_10616 synth_10983 synth_10765 VDD VDD VNB|VSS
+ sky130_fd_sc_hd__edfxtp_1
X$14310 VNB|VSS synth_5666 synth_5407 synth_5329 synth_5408 VDD VDD VNB|VSS
+ sky130_fd_sc_hd__edfxtp_1
X$14311 VNB|VSS synth_5214 synth_4833 synth_5300 synth_4791 VDD VDD VNB|VSS
+ sky130_fd_sc_hd__edfxtp_1
X$14312 VNB|VSS synth_5460 synth_5407 synth_2860 synth_5408 VDD VDD VNB|VSS
+ sky130_fd_sc_hd__edfxtp_1
X$14313 VNB|VSS synth_10280 synth_9896 synth_1695 synth_10279 VDD VDD VNB|VSS
+ sky130_fd_sc_hd__edfxtp_1
X$14314 VNB|VSS synth_5135 synth_5008 synth_387 synth_4910 VDD VDD VNB|VSS
+ sky130_fd_sc_hd__edfxtp_1
X$14315 VNB|VSS synth_1391 synth_557 synth_387 synth_1248 VDD VDD VNB|VSS
+ sky130_fd_sc_hd__edfxtp_1
X$14316 VNB|VSS synth_2341 synth_1810 synth_2461 synth_2274 VDD VDD VNB|VSS
+ sky130_fd_sc_hd__edfxtp_1
X$14317 VNB|VSS synth_10306 synth_9896 synth_4467 synth_10279 VDD VDD VNB|VSS
+ sky130_fd_sc_hd__edfxtp_1
X$14318 VNB|VSS synth_6928 synth_6929 synth_6997 synth_6976 VDD VDD VNB|VSS
+ sky130_fd_sc_hd__edfxtp_1
X$14319 VNB|VSS synth_1175 synth_557 synth_387 synth_949 VDD VDD VNB|VSS
+ sky130_fd_sc_hd__edfxtp_1
X$14320 VNB|VSS synth_808 synth_557 synth_37 synth_949 VDD VDD VNB|VSS
+ sky130_fd_sc_hd__edfxtp_1
X$14321 VNB|VSS synth_2907 synth_2432 synth_626 synth_2756 VDD VDD VNB|VSS
+ sky130_fd_sc_hd__edfxtp_1
X$14322 VNB|VSS synth_2315 synth_1810 synth_2316 synth_2274 VDD VDD VNB|VSS
+ sky130_fd_sc_hd__edfxtp_1
X$14323 VNB|VSS synth_5011 synth_5327 synth_5247 synth_4787 VDD VDD VNB|VSS
+ sky130_fd_sc_hd__edfxtp_1
X$14324 VNB|VSS synth_5452 synth_5327 synth_5536 synth_5294 VDD VDD VNB|VSS
+ sky130_fd_sc_hd__edfxtp_1
X$14325 VNB|VSS synth_5703 synth_5008 synth_4467 synth_5590 VDD VDD VNB|VSS
+ sky130_fd_sc_hd__edfxtp_1
X$14326 VNB|VSS synth_10767 synth_10616 synth_10763 synth_10765 VDD VDD VNB|VSS
+ sky130_fd_sc_hd__edfxtp_1
X$14327 VNB|VSS synth_2992 synth_2432 synth_1908 synth_2756 VDD VDD VNB|VSS
+ sky130_fd_sc_hd__edfxtp_1
X$14328 VNB|VSS synth_3079 synth_3043 synth_3139 synth_3312 VDD VDD VNB|VSS
+ sky130_fd_sc_hd__edfxtp_1
X$14329 VNB|VSS synth_424 synth_19 synth_631 synth_386 VDD VDD VNB|VSS
+ sky130_fd_sc_hd__edfxtp_1
X$14330 VNB|VSS synth_3455 synth_3025 synth_1459 synth_3454 VDD VDD VNB|VSS
+ sky130_fd_sc_hd__edfxtp_1
X$14331 VNB|VSS synth_3116 synth_3043 synth_3213 synth_2874 VDD VDD VNB|VSS
+ sky130_fd_sc_hd__edfxtp_1
X$14332 VNB|VSS synth_2918 synth_2208 synth_1908 synth_2616 VDD VDD VNB|VSS
+ sky130_fd_sc_hd__edfxtp_1
X$14333 VNB|VSS synth_2957 synth_3043 synth_3084 synth_2874 VDD VDD VNB|VSS
+ sky130_fd_sc_hd__edfxtp_1
X$14334 VNB|VSS synth_875 synth_443 synth_449 synth_911 VDD VDD VNB|VSS
+ sky130_fd_sc_hd__edfxtp_1
X$14335 VNB|VSS synth_420 synth_235 synth_37 synth_494 VDD VDD VNB|VSS
+ sky130_fd_sc_hd__edfxtp_1
X$14336 VNB|VSS synth_950 synth_640 synth_954 synth_575 VDD VDD VNB|VSS
+ sky130_fd_sc_hd__edfxtp_1
X$14337 VNB|VSS synth_3522 synth_3169 synth_1181 synth_3214 VDD VDD VNB|VSS
+ sky130_fd_sc_hd__edfxtp_1
X$14338 VNB|VSS synth_4805 synth_4657 synth_382 synth_4732 VDD VDD VNB|VSS
+ sky130_fd_sc_hd__edfxtp_1
X$14339 VNB|VSS synth_2762 synth_2208 synth_449 synth_2616 VDD VDD VNB|VSS
+ sky130_fd_sc_hd__edfxtp_1
X$14340 VNB|VSS synth_11949 synth_11840 synth_6987 synth_11880 VDD VDD VNB|VSS
+ sky130_fd_sc_hd__edfxtp_1
X$14341 VNB|VSS synth_12592 synth_12299 synth_12784 synth_12448 VDD VDD VNB|VSS
+ sky130_fd_sc_hd__edfxtp_1
X$14342 VNB|VSS synth_12038 synth_11527 synth_12189 synth_11800 VDD VDD VNB|VSS
+ sky130_fd_sc_hd__edfxtp_1
X$14343 VNB|VSS synth_1413 synth_1280 synth_449 synth_1219 VDD VDD VNB|VSS
+ sky130_fd_sc_hd__edfxtp_1
X$14344 VNB|VSS synth_12071 synth_12036 synth_8337 synth_11880 VDD VDD VNB|VSS
+ sky130_fd_sc_hd__edfxtp_1
X$14345 VNB|VSS synth_3836 synth_3569 synth_3928 synth_3676 VDD VDD VNB|VSS
+ sky130_fd_sc_hd__edfxtp_1
X$14346 VNB|VSS synth_1055 synth_443 synth_478 synth_911 VDD VDD VNB|VSS
+ sky130_fd_sc_hd__edfxtp_1
X$14347 VNB|VSS synth_1644 synth_1518 synth_1684 synth_1681 VDD VDD VNB|VSS
+ sky130_fd_sc_hd__edfxtp_1
X$14348 VNB|VSS synth_1749 synth_1657 synth_183 synth_1658 VDD VDD VNB|VSS
+ sky130_fd_sc_hd__edfxtp_1
X$14349 VNB|VSS synth_1905 synth_1657 synth_626 synth_1658 VDD VDD VNB|VSS
+ sky130_fd_sc_hd__edfxtp_1
X$14350 VNB|VSS synth_10064 synth_9986 synth_10065 synth_9838 VDD VDD VNB|VSS
+ sky130_fd_sc_hd__edfxtp_1
X$14351 VNB|VSS synth_693 synth_840 synth_183 synth_526 VDD VDD VNB|VSS
+ sky130_fd_sc_hd__edfxtp_1
X$14352 VNB|VSS synth_165 synth_19 synth_105 synth_8 VDD VDD VNB|VSS
+ sky130_fd_sc_hd__edfxtp_1
X$14353 VNB|VSS synth_3698 synth_3820 synth_3874 synth_3755 VDD VDD VNB|VSS
+ sky130_fd_sc_hd__edfxtp_1
X$14354 VNB|VSS synth_1608 synth_1280 synth_478 synth_1643 VDD VDD VNB|VSS
+ sky130_fd_sc_hd__edfxtp_1
X$14355 VNB|VSS synth_3430 synth_3818 synth_3507 synth_3295 VDD VDD VNB|VSS
+ sky130_fd_sc_hd__edfxtp_1
X$14356 VNB|VSS synth_3633 synth_3820 synth_3684 synth_3755 VDD VDD VNB|VSS
+ sky130_fd_sc_hd__edfxtp_1
X$14357 VNB|VSS synth_3440 synth_3169 synth_1181 synth_3170 VDD VDD VNB|VSS
+ sky130_fd_sc_hd__edfxtp_1
X$14358 VNB|VSS synth_2956 synth_2205 synth_3088 synth_2874 VDD VDD VNB|VSS
+ sky130_fd_sc_hd__edfxtp_1
X$14359 VNB|VSS synth_1034 synth_1142 synth_478 synth_781 VDD VDD VNB|VSS
+ sky130_fd_sc_hd__edfxtp_1
X$14360 VNB|VSS synth_498 synth_19 synth_691 synth_386 VDD VDD VNB|VSS
+ sky130_fd_sc_hd__edfxtp_1
X$14361 VNB|VSS synth_10992 synth_10804 synth_11257 synth_10880 VDD VDD VNB|VSS
+ sky130_fd_sc_hd__edfxtp_1
X$14362 VNB|VSS synth_695 synth_235 synth_387 synth_694 VDD VDD VNB|VSS
+ sky130_fd_sc_hd__edfxtp_1
X$14363 VNB|VSS synth_527 synth_235 synth_501 synth_236 VDD VDD VNB|VSS
+ sky130_fd_sc_hd__edfxtp_1
X$14364 VNB|VSS synth_3693 synth_2533 synth_3939 synth_3298 VDD VDD VNB|VSS
+ sky130_fd_sc_hd__edfxtp_1
X$14365 VNB|VSS synth_4182 synth_4019 synth_4434 synth_4089 VDD VDD VNB|VSS
+ sky130_fd_sc_hd__edfxtp_1
X$14366 VNB|VSS synth_11691 synth_11294 synth_6564 synth_11442 VDD VDD VNB|VSS
+ sky130_fd_sc_hd__edfxtp_1
X$14367 VNB|VSS synth_2441 synth_1906 synth_2444 synth_2442 VDD VDD VNB|VSS
+ sky130_fd_sc_hd__edfxtp_1
X$14368 VNB|VSS synth_1115 synth_1142 synth_258 synth_781 VDD VDD VNB|VSS
+ sky130_fd_sc_hd__edfxtp_1
X$14369 VNB|VSS synth_2069 synth_1657 synth_626 synth_2135 VDD VDD VNB|VSS
+ sky130_fd_sc_hd__edfxtp_1
X$14370 VNB|VSS synth_5998 synth_5515 synth_6178 synth_5445 VDD VDD VNB|VSS
+ sky130_fd_sc_hd__edfxtp_1
X$14371 VNB|VSS synth_2220 synth_1657 synth_478 synth_2135 VDD VDD VNB|VSS
+ sky130_fd_sc_hd__edfxtp_1
X$14372 VNB|VSS synth_5947 synth_5753 synth_6041 synth_5909 VDD VDD VNB|VSS
+ sky130_fd_sc_hd__edfxtp_1
X$14373 VNB|VSS synth_3956 synth_4264 synth_387 synth_4315 VDD VDD VNB|VSS
+ sky130_fd_sc_hd__edfxtp_1
X$14374 VNB|VSS synth_12466 synth_12299 synth_12465 synth_12448 VDD VDD VNB|VSS
+ sky130_fd_sc_hd__edfxtp_1
X$14375 VNB|VSS synth_11861 synth_11536 synth_6198 synth_11717 VDD VDD VNB|VSS
+ sky130_fd_sc_hd__edfxtp_1
X$14376 VNB|VSS synth_3092 synth_1970 synth_3090 synth_3091 VDD VDD VNB|VSS
+ sky130_fd_sc_hd__edfxtp_1
X$14377 VNB|VSS synth_5914 synth_5439 synth_4111 synth_5620 VDD VDD VNB|VSS
+ sky130_fd_sc_hd__edfxtp_1
X$14378 VNB|VSS synth_12030 synth_11536 synth_4467 synth_12047 VDD VDD VNB|VSS
+ sky130_fd_sc_hd__edfxtp_1
X$14379 VNB|VSS synth_5040 synth_3937 synth_966 synth_4987 VDD VDD VNB|VSS
+ sky130_fd_sc_hd__edfxtp_1
X$14380 VNB|VSS synth_5527 synth_5082 synth_3656 synth_5508 VDD VDD VNB|VSS
+ sky130_fd_sc_hd__edfxtp_1
X$14381 VNB|VSS synth_5037 synth_5082 synth_4111 synth_4987 VDD VDD VNB|VSS
+ sky130_fd_sc_hd__edfxtp_1
X$14382 VNB|VSS synth_4269 synth_4264 synth_4566 synth_4486 VDD VDD VNB|VSS
+ sky130_fd_sc_hd__edfxtp_1
X$14383 VNB|VSS synth_11524 synth_11489 synth_11617 synth_11264 VDD VDD VNB|VSS
+ sky130_fd_sc_hd__edfxtp_1
X$14384 VNB|VSS synth_4483 synth_4264 synth_1181 synth_4315 VDD VDD VNB|VSS
+ sky130_fd_sc_hd__edfxtp_1
X$14385 VNB|VSS synth_4788 synth_4019 synth_4786 synth_4787 VDD VDD VNB|VSS
+ sky130_fd_sc_hd__edfxtp_1
X$14386 VNB|VSS synth_4922 synth_3374 synth_4981 synth_4793 VDD VDD VNB|VSS
+ sky130_fd_sc_hd__edfxtp_1
X$14387 VNB|VSS synth_4344 synth_3818 synth_4518 synth_4147 VDD VDD VNB|VSS
+ sky130_fd_sc_hd__edfxtp_1
X$14388 VNB|VSS synth_4789 synth_4019 synth_4883 synth_4787 VDD VDD VNB|VSS
+ sky130_fd_sc_hd__edfxtp_1
X$14389 VNB|VSS synth_4438 synth_3557 synth_4588 synth_4272 VDD VDD VNB|VSS
+ sky130_fd_sc_hd__edfxtp_1
X$14390 VNB|VSS synth_1282 synth_1280 synth_478 synth_1219 VDD VDD VNB|VSS
+ sky130_fd_sc_hd__edfxtp_1
X$14391 VNB|VSS synth_4181 synth_4019 synth_4318 synth_4089 VDD VDD VNB|VSS
+ sky130_fd_sc_hd__edfxtp_1
X$14392 VNB|VSS synth_4439 synth_3820 synth_4352 synth_3958 VDD VDD VNB|VSS
+ sky130_fd_sc_hd__edfxtp_1
X$14393 VDD synth_3527 synth_4353 synth_4439 synth_4574 VNB|VSS synth_4494 VDD
+ VNB|VSS sky130_fd_sc_hd__nor4b_1
X$14394 VNB|VSS synth_12213 synth_12299 synth_12232 synth_11927 VDD VDD VNB|VSS
+ sky130_fd_sc_hd__edfxtp_1
X$14395 VNB|VSS synth_12451 synth_11379 synth_8337 synth_12228 VDD VDD VNB|VSS
+ sky130_fd_sc_hd__edfxtp_1
X$14396 VNB|VSS synth_12340 synth_11379 synth_4467 synth_12228 VDD VDD VNB|VSS
+ sky130_fd_sc_hd__edfxtp_1
X$14397 VNB|VSS synth_6386 synth_5515 synth_6486 synth_6312 VDD VDD VNB|VSS
+ sky130_fd_sc_hd__edfxtp_1
X$14398 VNB|VSS synth_12708 synth_12299 synth_12561 synth_12761 VDD VDD VNB|VSS
+ sky130_fd_sc_hd__edfxtp_1
X$14399 VNB|VSS synth_12591 synth_12299 synth_12782 synth_12448 VDD VDD VNB|VSS
+ sky130_fd_sc_hd__edfxtp_1
X$14400 VNB|VSS synth_2126 synth_2201 synth_1908 synth_2162 VDD VDD VNB|VSS
+ sky130_fd_sc_hd__edfxtp_1
X$14401 VNB|VSS synth_893 synth_1149 synth_1204 synth_1056 VDD VDD VNB|VSS
+ sky130_fd_sc_hd__edfxtp_1
X$14402 VNB|VSS synth_12093 synth_11719 synth_12092 synth_11927 VDD VDD VNB|VSS
+ sky130_fd_sc_hd__edfxtp_1
X$14403 VNB|VSS synth_6498 synth_5450 synth_6357 synth_6440 VDD VDD VNB|VSS
+ sky130_fd_sc_hd__edfxtp_1
X$14404 VNB|VSS synth_6024 synth_5057 synth_6062 synth_5802 VDD VDD VNB|VSS
+ sky130_fd_sc_hd__edfxtp_1
X$14405 VNB|VSS synth_3331 synth_3242 synth_1908 synth_3204 VDD VDD VNB|VSS
+ sky130_fd_sc_hd__edfxtp_1
X$14406 VNB|VSS synth_4980 synth_5303 synth_5222 synth_4793 VDD VDD VNB|VSS
+ sky130_fd_sc_hd__edfxtp_1
X$14407 VNB|VSS synth_9909 synth_9754 synth_6987 synth_9874 VDD VDD VNB|VSS
+ sky130_fd_sc_hd__edfxtp_1
X$14408 VNB|VSS synth_9911 synth_9986 synth_9951 synth_9838 VDD VDD VNB|VSS
+ sky130_fd_sc_hd__edfxtp_1
X$14409 VNB|VSS synth_10037 synth_9717 synth_6699 synth_9989 VDD VDD VNB|VSS
+ sky130_fd_sc_hd__edfxtp_1
X$14410 VNB|VSS synth_5385 synth_5217 synth_382 synth_5304 VDD VDD VNB|VSS
+ sky130_fd_sc_hd__edfxtp_1
X$14411 VNB|VSS synth_8375 synth_7933 synth_6198 synth_8006 VDD VDD VNB|VSS
+ sky130_fd_sc_hd__edfxtp_1
X$14412 VNB|VSS synth_11987 synth_12163 synth_12138 synth_11662 VDD VDD VNB|VSS
+ sky130_fd_sc_hd__edfxtp_1
X$14413 VNB|VSS synth_3186 synth_2602 synth_3187 synth_3185 VDD VDD VNB|VSS
+ sky130_fd_sc_hd__edfxtp_1
X$14414 VNB|VSS synth_5956 synth_5217 synth_382 synth_5669 VDD VDD VNB|VSS
+ sky130_fd_sc_hd__edfxtp_1
X$14415 VNB|VSS synth_1388 synth_699 synth_1337 synth_940 VDD VDD VNB|VSS
+ sky130_fd_sc_hd__edfxtp_1
X$14416 VNB|VSS synth_6122 synth_5217 synth_6198 synth_5669 VDD VDD VNB|VSS
+ sky130_fd_sc_hd__edfxtp_1
X$14417 VNB|VSS synth_11739 synth_10538 synth_6699 synth_11737 VDD VDD VNB|VSS
+ sky130_fd_sc_hd__edfxtp_1
X$14418 VNB|VSS synth_6514 synth_6069 synth_4588 synth_6343 VDD VDD VNB|VSS
+ sky130_fd_sc_hd__edfxtp_1
X$14419 VNB|VSS synth_554 synth_699 synth_387 synth_606 VDD VDD VNB|VSS
+ sky130_fd_sc_hd__edfxtp_1
X$14420 VNB|VSS synth_3270 synth_2804 synth_626 synth_3313 VDD VDD VNB|VSS
+ sky130_fd_sc_hd__edfxtp_1
X$14421 VNB|VSS synth_5595 synth_4836 synth_382 synth_5073 VDD VDD VNB|VSS
+ sky130_fd_sc_hd__edfxtp_1
X$14422 VNB|VSS synth_1061 synth_30 synth_1155 synth_1105 VDD VDD VNB|VSS
+ sky130_fd_sc_hd__edfxtp_1
X$14423 VNB|VSS synth_3323 synth_3247 synth_478 synth_3184 VDD VDD VNB|VSS
+ sky130_fd_sc_hd__edfxtp_1
X$14424 VNB|VSS synth_1065 synth_30 synth_1106 synth_1105 VDD VDD VNB|VSS
+ sky130_fd_sc_hd__edfxtp_1
X$14425 VNB|VSS synth_11924 synth_11849 synth_8337 synth_11835 VDD VDD VNB|VSS
+ sky130_fd_sc_hd__edfxtp_1
X$14426 VNB|VSS synth_12140 synth_11849 synth_6987 synth_12165 VDD VDD VNB|VSS
+ sky130_fd_sc_hd__edfxtp_1
X$14427 VNB|VSS synth_5552 synth_5057 synth_5604 synth_5245 VDD VDD VNB|VSS
+ sky130_fd_sc_hd__edfxtp_1
X$14428 VNB|VSS synth_12267 synth_10538 synth_6564 synth_12165 VDD VDD VNB|VSS
+ sky130_fd_sc_hd__edfxtp_1
X$14429 VNB|VSS synth_5496 synth_5217 synth_5329 synth_5304 VDD VDD VNB|VSS
+ sky130_fd_sc_hd__edfxtp_1
X$14430 VNB|VSS synth_12439 synth_11849 synth_6699 synth_12165 VDD VDD VNB|VSS
+ sky130_fd_sc_hd__edfxtp_1
X$14431 VNB|VSS synth_10063 synth_9754 synth_6564 synth_9874 VDD VDD VNB|VSS
+ sky130_fd_sc_hd__edfxtp_1
X$14432 VNB|VSS synth_10597 synth_9754 synth_6564 synth_10325 VDD VDD VNB|VSS
+ sky130_fd_sc_hd__edfxtp_1
X$14433 VNB|VSS synth_329 synth_235 synth_37 synth_236 VDD VDD VNB|VSS
+ sky130_fd_sc_hd__edfxtp_1
X$14434 VNB|VSS synth_2889 synth_2602 synth_2818 synth_2596 VDD VDD VNB|VSS
+ sky130_fd_sc_hd__edfxtp_1
X$14435 VNB|VSS synth_5649 synth_5303 synth_5712 synth_5670 VDD VDD VNB|VSS
+ sky130_fd_sc_hd__edfxtp_1
X$14436 VNB|VSS synth_5580 synth_5087 synth_5513 synth_5569 VDD VDD VNB|VSS
+ sky130_fd_sc_hd__edfxtp_1
X$14437 VNB|VSS synth_10462 synth_9754 synth_8337 synth_10325 VDD VDD VNB|VSS
+ sky130_fd_sc_hd__edfxtp_1
X$14438 VNB|VSS synth_3329 synth_3242 synth_478 synth_3181 VDD VDD VNB|VSS
+ sky130_fd_sc_hd__edfxtp_1
X$14439 VNB|VSS synth_3510 synth_2804 synth_1908 synth_3313 VDD VDD VNB|VSS
+ sky130_fd_sc_hd__edfxtp_1
X$14440 VNB|VSS synth_2972 synth_2750 synth_1908 synth_2742 VDD VDD VNB|VSS
+ sky130_fd_sc_hd__edfxtp_1
X$14441 VNB|VSS synth_6344 synth_6069 synth_6198 synth_6343 VDD VDD VNB|VSS
+ sky130_fd_sc_hd__edfxtp_1
X$14442 VNB|VSS synth_11887 synth_11846 synth_11919 synth_11801 VDD VDD VNB|VSS
+ sky130_fd_sc_hd__edfxtp_1
X$14443 VNB|VSS synth_11985 synth_11840 synth_6987 synth_11885 VDD VDD VNB|VSS
+ sky130_fd_sc_hd__edfxtp_1
X$14444 VNB|VSS synth_660 synth_19 synth_933 synth_386 VDD VDD VNB|VSS
+ sky130_fd_sc_hd__edfxtp_1
X$14445 VNB|VSS synth_894 synth_19 synth_1091 synth_1056 VDD VDD VNB|VSS
+ sky130_fd_sc_hd__edfxtp_1
X$14446 VNB|VSS synth_10500 synth_9912 synth_8337 synth_10420 VDD VDD VNB|VSS
+ sky130_fd_sc_hd__edfxtp_1
X$14447 VNB|VSS synth_505 synth_53 synth_387 synth_12 VDD VDD VNB|VSS
+ sky130_fd_sc_hd__edfxtp_1
X$14448 VNB|VSS synth_12040 synth_11961 synth_6564 synth_11737 VDD VDD VNB|VSS
+ sky130_fd_sc_hd__edfxtp_1
X$14449 VNB|VSS synth_2631 synth_1437 synth_501 synth_2523 VDD VDD VNB|VSS
+ sky130_fd_sc_hd__edfxtp_1
X$14450 VNB|VSS synth_6101 synth_5531 synth_5787 synth_6022 VDD VDD VNB|VSS
+ sky130_fd_sc_hd__edfxtp_1
X$14451 VNB|VSS synth_5897 synth_5227 synth_6071 synth_5870 VDD VDD VNB|VSS
+ sky130_fd_sc_hd__edfxtp_1
X$14452 VNB|VSS synth_1670 synth_840 synth_478 synth_1671 VDD VDD VNB|VSS
+ sky130_fd_sc_hd__edfxtp_1
X$14453 VNB|VSS synth_6166 synth_5447 synth_6181 synth_6164 VDD VDD VNB|VSS
+ sky130_fd_sc_hd__edfxtp_1
X$14454 VNB|VSS synth_334 synth_699 synth_501 synth_606 VDD VDD VNB|VSS
+ sky130_fd_sc_hd__edfxtp_1
X$14455 VNB|VSS synth_6624 synth_5057 synth_6623 synth_6491 VDD VDD VNB|VSS
+ sky130_fd_sc_hd__edfxtp_1
X$14456 VNB|VSS synth_2067 synth_1906 synth_1983 synth_2133 VDD VDD VNB|VSS
+ sky130_fd_sc_hd__edfxtp_1
X$14457 VNB|VSS synth_6038 synth_3937 synth_4111 synth_6158 VDD VDD VNB|VSS
+ sky130_fd_sc_hd__edfxtp_1
X$14458 VNB|VSS synth_2952 synth_2205 synth_3013 synth_2592 VDD VDD VNB|VSS
+ sky130_fd_sc_hd__edfxtp_1
X$14459 VNB|VSS synth_5987 synth_5478 synth_6197 synth_5611 VDD VDD VNB|VSS
+ sky130_fd_sc_hd__edfxtp_1
X$14460 VNB|VSS synth_2591 synth_2205 synth_2619 synth_2592 VDD VDD VNB|VSS
+ sky130_fd_sc_hd__edfxtp_1
X$14461 VNB|VSS synth_6627 synth_6541 synth_1695 synth_6323 VDD VDD VNB|VSS
+ sky130_fd_sc_hd__edfxtp_1
X$14462 VNB|VSS synth_10422 synth_9986 synth_10327 synth_10250 VDD VDD VNB|VSS
+ sky130_fd_sc_hd__edfxtp_1
X$14463 VNB|VSS synth_2141 synth_1898 synth_2140 synth_2139 VDD VDD VNB|VSS
+ sky130_fd_sc_hd__edfxtp_1
X$14464 VNB|VSS synth_943 synth_53 synth_37 synth_734 VDD VDD VNB|VSS
+ sky130_fd_sc_hd__edfxtp_1
X$14465 VNB|VSS synth_333 synth_89 synth_531 synth_10 VDD VDD VNB|VSS
+ sky130_fd_sc_hd__edfxtp_1
X$14466 VNB|VSS synth_2886 synth_2750 synth_478 synth_2742 VDD VDD VNB|VSS
+ sky130_fd_sc_hd__edfxtp_1
X$14467 VNB|VSS synth_172 synth_89 synth_112 synth_10 VDD VDD VNB|VSS
+ sky130_fd_sc_hd__edfxtp_1
X$14468 VNB|VSS synth_2586 synth_2730 synth_2711 synth_2274 VDD VDD VNB|VSS
+ sky130_fd_sc_hd__edfxtp_1
X$14469 VNB|VSS synth_2924 synth_2845 synth_449 synth_2620 VDD VDD VNB|VSS
+ sky130_fd_sc_hd__edfxtp_1
X$14470 VNB|VSS synth_12017 synth_11846 synth_12129 synth_11801 VDD VDD VNB|VSS
+ sky130_fd_sc_hd__edfxtp_1
X$14471 VNB|VSS synth_2492 synth_2602 synth_2550 synth_2139 VDD VDD VNB|VSS
+ sky130_fd_sc_hd__edfxtp_1
X$14472 VNB|VSS synth_4749 synth_4487 synth_4792 synth_4497 VDD VDD VNB|VSS
+ sky130_fd_sc_hd__edfxtp_1
X$14473 VNB|VSS synth_2741 synth_2750 synth_626 synth_2742 VDD VDD VNB|VSS
+ sky130_fd_sc_hd__edfxtp_1
X$14474 VNB|VSS synth_3193 synth_3247 synth_626 synth_3184 VDD VDD VNB|VSS
+ sky130_fd_sc_hd__edfxtp_1
X$14475 VNB|VSS synth_2138 synth_1898 synth_2218 synth_2139 VDD VDD VNB|VSS
+ sky130_fd_sc_hd__edfxtp_1
X$14476 VNB|VSS synth_5656 synth_5016 synth_3656 synth_5820 VDD VDD VNB|VSS
+ sky130_fd_sc_hd__edfxtp_1
X$14477 VNB|VSS synth_896 synth_1423 synth_861 synth_736 VDD VDD VNB|VSS
+ sky130_fd_sc_hd__edfxtp_1
X$14478 VNB|VSS synth_3348 synth_3385 synth_3349 synth_3219 VDD VDD VNB|VSS
+ sky130_fd_sc_hd__edfxtp_1
X$14479 VNB|VSS synth_12505 synth_11917 synth_12686 synth_12615 VDD VDD VNB|VSS
+ sky130_fd_sc_hd__edfxtp_1
X$14480 VNB|VSS synth_12503 synth_11840 synth_6987 synth_12291 VDD VDD VNB|VSS
+ sky130_fd_sc_hd__edfxtp_1
X$14481 VNB|VSS synth_3197 synth_2602 synth_3200 synth_3182 VDD VDD VNB|VSS
+ sky130_fd_sc_hd__edfxtp_1
X$14482 VNB|VSS synth_5501 synth_4934 synth_5539 synth_5316 VDD VDD VNB|VSS
+ sky130_fd_sc_hd__edfxtp_1
X$14483 VNB|VSS synth_5317 synth_4934 synth_5315 synth_5316 VDD VDD VNB|VSS
+ sky130_fd_sc_hd__edfxtp_1
X$14484 VNB|VSS synth_11968 synth_11849 synth_6987 synth_11835 VDD VDD VNB|VSS
+ sky130_fd_sc_hd__edfxtp_1
X$14485 VNB|VSS synth_12786 synth_11917 synth_12685 synth_12615 VDD VDD VNB|VSS
+ sky130_fd_sc_hd__edfxtp_1
X$14486 VNB|VSS synth_2671 synth_2602 synth_3054 synth_2442 VDD VDD VNB|VSS
+ sky130_fd_sc_hd__edfxtp_1
X$14487 VNB|VSS synth_10701 synth_10804 synth_10803 synth_10465 VDD VDD VNB|VSS
+ sky130_fd_sc_hd__edfxtp_1
X$14488 VNB|VSS synth_5819 synth_4836 synth_3656 synth_5815 VDD VDD VNB|VSS
+ sky130_fd_sc_hd__edfxtp_1
X$14489 VNB|VSS synth_11654 synth_11489 synth_11763 synth_11363 VDD VDD VNB|VSS
+ sky130_fd_sc_hd__edfxtp_1
X$14490 VNB|VSS synth_6032 synth_5407 synth_4566 synth_5974 VDD VDD VNB|VSS
+ sky130_fd_sc_hd__edfxtp_1
X$14491 VNB|VSS synth_10919 synth_10467 synth_8337 synth_10918 VDD VDD VNB|VSS
+ sky130_fd_sc_hd__edfxtp_1
X$14492 VNB|VSS synth_6067 synth_5953 synth_6274 synth_6033 VDD VDD VNB|VSS
+ sky130_fd_sc_hd__edfxtp_1
X$14493 VNB|VSS synth_3747 synth_3781 synth_2777 synth_3782 VDD VDD VNB|VSS
+ sky130_fd_sc_hd__edfxtp_1
X$14494 VNB|VSS synth_8372 synth_7933 synth_6198 synth_8057 VDD VDD VNB|VSS
+ sky130_fd_sc_hd__edfxtp_1
X$14495 VNB|VSS synth_5841 synth_5439 synth_966 synth_5620 VDD VDD VNB|VSS
+ sky130_fd_sc_hd__edfxtp_1
X$14496 VNB|VSS synth_8248 synth_7334 synth_8371 synth_7963 VDD VDD VNB|VSS
+ sky130_fd_sc_hd__edfxtp_1
X$14497 VNB|VSS synth_4721 synth_4461 synth_4767 synth_4617 VDD VDD VNB|VSS
+ sky130_fd_sc_hd__edfxtp_1
X$14498 VNB|VSS synth_9915 synth_9811 synth_9993 synth_9842 VDD VDD VNB|VSS
+ sky130_fd_sc_hd__edfxtp_1
X$14499 VNB|VSS synth_9731 synth_10047 synth_2777 synth_9660 VDD VDD VNB|VSS
+ sky130_fd_sc_hd__edfxtp_1
X$14500 VNB|VSS synth_2608 synth_1906 synth_2609 synth_2595 VDD VDD VNB|VSS
+ sky130_fd_sc_hd__edfxtp_1
X$14501 VNB|VSS synth_9997 synth_9760 synth_9916 synth_9917 VDD VDD VNB|VSS
+ sky130_fd_sc_hd__edfxtp_1
X$14502 VNB|VSS synth_11336 synth_11294 synth_6699 synth_10918 VDD VDD VNB|VSS
+ sky130_fd_sc_hd__edfxtp_1
X$14503 VNB|VSS synth_9759 synth_9760 synth_10048 synth_9225 VDD VDD VNB|VSS
+ sky130_fd_sc_hd__edfxtp_1
X$14504 VNB|VSS synth_9922 synth_9896 synth_387 synth_9897 VDD VDD VNB|VSS
+ sky130_fd_sc_hd__edfxtp_1
X$14505 VNB|VSS synth_1026 synth_1423 synth_1340 synth_736 VDD VDD VNB|VSS
+ sky130_fd_sc_hd__edfxtp_1
X$14506 VNB|VSS synth_6586 synth_6454 synth_6655 synth_6605 VDD VDD VNB|VSS
+ sky130_fd_sc_hd__edfxtp_1
X$14507 VNB|VSS synth_10056 synth_10090 synth_10054 synth_9898 VDD VDD VNB|VSS
+ sky130_fd_sc_hd__edfxtp_1
X$14508 VNB|VSS synth_10990 synth_10804 synth_11108 synth_10880 VDD VDD VNB|VSS
+ sky130_fd_sc_hd__edfxtp_1
X$14509 VNB|VSS synth_6285 synth_6237 synth_3656 synth_6151 VDD VDD VNB|VSS
+ sky130_fd_sc_hd__edfxtp_1
X$14510 VNB|VSS synth_6031 synth_5407 synth_2860 synth_5974 VDD VDD VNB|VSS
+ sky130_fd_sc_hd__edfxtp_1
X$14511 VNB|VSS synth_6121 synth_6237 synth_626 synth_6151 VDD VDD VNB|VSS
+ sky130_fd_sc_hd__edfxtp_1
X$14512 VNB|VSS synth_8246 synth_7490 synth_4588 synth_8045 VDD VDD VNB|VSS
+ sky130_fd_sc_hd__edfxtp_1
X$14513 VNB|VSS synth_4831 synth_4833 synth_4888 synth_4791 VDD VDD VNB|VSS
+ sky130_fd_sc_hd__edfxtp_1
X$14514 VNB|VSS synth_5212 synth_5008 synth_2860 synth_5108 VDD VDD VNB|VSS
+ sky130_fd_sc_hd__edfxtp_1
X$14515 VNB|VSS synth_4916 synth_5008 synth_449 synth_5108 VDD VDD VNB|VSS
+ sky130_fd_sc_hd__edfxtp_1
X$14516 VNB|VSS synth_5736 synth_5531 synth_1181 synth_5448 VDD VDD VNB|VSS
+ sky130_fd_sc_hd__edfxtp_1
X$14517 VNB|VSS synth_5771 synth_5057 synth_5854 synth_5802 VDD VDD VNB|VSS
+ sky130_fd_sc_hd__edfxtp_1
X$14518 VNB|VSS synth_11661 synth_11495 synth_11708 synth_11662 VDD VDD VNB|VSS
+ sky130_fd_sc_hd__edfxtp_1
X$14519 VNB|VSS synth_5593 synth_4833 synth_5540 synth_5455 VDD VDD VNB|VSS
+ sky130_fd_sc_hd__edfxtp_1
X$14520 VNB|VSS synth_5779 synth_5953 synth_6193 synth_5455 VDD VDD VNB|VSS
+ sky130_fd_sc_hd__edfxtp_1
X$14521 VNB|VSS synth_3282 synth_3284 synth_1908 synth_3302 VDD VDD VNB|VSS
+ sky130_fd_sc_hd__edfxtp_1
X$14522 VNB|VSS synth_1500 synth_1576 synth_37 synth_1385 VDD VDD VNB|VSS
+ sky130_fd_sc_hd__edfxtp_1
X$14523 VNB|VSS synth_5117 synth_4836 synth_4111 synth_5073 VDD VDD VNB|VSS
+ sky130_fd_sc_hd__edfxtp_1
X$14524 VNB|VSS synth_2598 synth_1898 synth_2600 synth_2596 VDD VDD VNB|VSS
+ sky130_fd_sc_hd__edfxtp_1
X$14525 VNB|VSS synth_2343 synth_1970 synth_2342 synth_2427 VDD VDD VNB|VSS
+ sky130_fd_sc_hd__edfxtp_1
X$14526 VNB|VSS synth_6635 synth_6611 synth_3656 synth_6505 VDD VDD VNB|VSS
+ sky130_fd_sc_hd__edfxtp_1
X$14527 VNB|VSS synth_5390 synth_5249 synth_382 synth_5414 VDD VDD VNB|VSS
+ sky130_fd_sc_hd__edfxtp_1
X$14528 VNB|VSS synth_5650 synth_5249 synth_449 synth_5414 VDD VDD VNB|VSS
+ sky130_fd_sc_hd__edfxtp_1
X$14529 VNB|VSS synth_775 synth_1011 synth_501 synth_694 VDD VDD VNB|VSS
+ sky130_fd_sc_hd__edfxtp_1
X$14530 VNB|VSS synth_6338 synth_5407 synth_6198 synth_5974 VDD VDD VNB|VSS
+ sky130_fd_sc_hd__edfxtp_1
X$14531 VNB|VSS synth_2883 synth_3122 synth_3126 synth_2595 VDD VDD VNB|VSS
+ sky130_fd_sc_hd__edfxtp_1
X$14532 VNB|VSS synth_6153 synth_6454 synth_6378 synth_6420 VDD VDD VNB|VSS
+ sky130_fd_sc_hd__edfxtp_1
X$14533 VNB|VSS synth_5825 synth_5715 synth_5849 synth_5850 VDD VDD VNB|VSS
+ sky130_fd_sc_hd__edfxtp_1
X$14534 VNB|VSS synth_8475 synth_8391 synth_8602 synth_8175 VDD VDD VNB|VSS
+ sky130_fd_sc_hd__edfxtp_1
X$14535 VNB|VSS synth_8554 synth_8391 synth_8681 synth_8175 VDD VDD VNB|VSS
+ sky130_fd_sc_hd__edfxtp_1
X$14536 VNB|VSS synth_8328 synth_8391 synth_8392 synth_8175 VDD VDD VNB|VSS
+ sky130_fd_sc_hd__edfxtp_1
X$14537 VNB|VSS synth_10342 synth_10355 synth_6564 synth_10426 VDD VDD VNB|VSS
+ sky130_fd_sc_hd__edfxtp_1
X$14538 VNB|VSS synth_12290 synth_11917 synth_12317 synth_12318 VDD VDD VNB|VSS
+ sky130_fd_sc_hd__edfxtp_1
X$14539 VNB|VSS synth_5861 synth_5008 synth_1181 synth_5590 VDD VDD VNB|VSS
+ sky130_fd_sc_hd__edfxtp_1
X$14540 VNB|VSS synth_6273 synth_6241 synth_4588 synth_6196 VDD VDD VNB|VSS
+ sky130_fd_sc_hd__edfxtp_1
X$14541 VNB|VSS synth_6415 synth_6241 synth_3656 synth_6196 VDD VDD VNB|VSS
+ sky130_fd_sc_hd__edfxtp_1
X$14542 VNB|VSS synth_5035 synth_5087 synth_5349 synth_4970 VDD VDD VNB|VSS
+ sky130_fd_sc_hd__edfxtp_1
X$14543 VNB|VSS synth_5427 synth_5087 synth_5616 synth_4939 VDD VDD VNB|VSS
+ sky130_fd_sc_hd__edfxtp_1
X$14544 VNB|VSS synth_6640 synth_5953 synth_6599 synth_6335 VDD VDD VNB|VSS
+ sky130_fd_sc_hd__edfxtp_1
X$14545 VNB|VSS synth_6367 synth_5953 synth_6510 synth_6335 VDD VDD VNB|VSS
+ sky130_fd_sc_hd__edfxtp_1
X$14546 VNB|VSS synth_2617 synth_2208 synth_1908 synth_2515 VDD VDD VNB|VSS
+ sky130_fd_sc_hd__edfxtp_1
X$14547 VNB|VSS synth_5938 synth_5082 synth_4111 synth_5853 VDD VDD VNB|VSS
+ sky130_fd_sc_hd__edfxtp_1
X$14548 VNB|VSS synth_12684 synth_11917 synth_12680 synth_12318 VDD VDD VNB|VSS
+ sky130_fd_sc_hd__edfxtp_1
X$14549 VNB|VSS synth_10358 synth_10355 synth_2777 synth_10426 VDD VDD VNB|VSS
+ sky130_fd_sc_hd__edfxtp_1
X$14550 VNB|VSS synth_542 synth_54 synth_258 synth_182 VDD VDD VNB|VSS
+ sky130_fd_sc_hd__edfxtp_1
X$14551 VNB|VSS synth_9349 synth_8928 synth_6564 synth_8992 VDD VDD VNB|VSS
+ sky130_fd_sc_hd__edfxtp_1
X$14552 VNB|VSS synth_10998 synth_10549 synth_6198 synth_10913 VDD VDD VNB|VSS
+ sky130_fd_sc_hd__edfxtp_1
X$14553 VNB|VSS synth_10981 synth_10549 synth_1695 synth_10913 VDD VDD VNB|VSS
+ sky130_fd_sc_hd__edfxtp_1
X$14554 VNB|VSS synth_703 synth_54 synth_88 synth_741 VDD VDD VNB|VSS
+ sky130_fd_sc_hd__edfxtp_1
X$14555 VNB|VSS synth_2718 synth_2330 synth_2763 synth_2719 VDD VDD VNB|VSS
+ sky130_fd_sc_hd__edfxtp_1
X$14556 VNB|VSS synth_1649 synth_1518 synth_1775 synth_1491 VDD VDD VNB|VSS
+ sky130_fd_sc_hd__edfxtp_1
X$14557 VNB|VSS synth_2101 synth_2179 synth_2291 synth_1982 VDD VDD VNB|VSS
+ sky130_fd_sc_hd__edfxtp_1
X$14558 VNB|VSS synth_2063 synth_1518 synth_2153 synth_2129 VDD VDD VNB|VSS
+ sky130_fd_sc_hd__edfxtp_1
X$14559 VNB|VSS synth_1740 synth_1518 synth_1998 synth_1491 VDD VDD VNB|VSS
+ sky130_fd_sc_hd__edfxtp_1
X$14560 VNB|VSS synth_6609 synth_6815 synth_6772 synth_6813 VDD VDD VNB|VSS
+ sky130_fd_sc_hd__edfxtp_1
X$14561 VNB|VSS synth_8866 synth_8864 synth_1695 synth_8842 VDD VDD VNB|VSS
+ sky130_fd_sc_hd__edfxtp_1
X$14562 VNB|VSS synth_7454 synth_7115 synth_7412 synth_7413 VDD VDD VNB|VSS
+ sky130_fd_sc_hd__edfxtp_1
X$14563 VNB|VSS synth_1566 synth_517 synth_449 synth_1215 VDD VDD VNB|VSS
+ sky130_fd_sc_hd__edfxtp_1
X$14564 VNB|VSS synth_698 synth_578 synth_626 synth_533 VDD VDD VNB|VSS
+ sky130_fd_sc_hd__edfxtp_1
X$14565 VNB|VSS synth_585 synth_578 synth_478 synth_533 VDD VDD VNB|VSS
+ sky130_fd_sc_hd__edfxtp_1
X$14566 VNB|VSS synth_2283 synth_2080 synth_2455 synth_2129 VDD VDD VNB|VSS
+ sky130_fd_sc_hd__edfxtp_1
X$14567 VNB|VSS synth_1042 synth_517 synth_478 synth_762 VDD VDD VNB|VSS
+ sky130_fd_sc_hd__edfxtp_1
X$14568 VNB|VSS synth_4779 synth_5087 synth_4875 synth_4450 VDD VDD VNB|VSS
+ sky130_fd_sc_hd__edfxtp_1
X$14569 VNB|VSS synth_10718 synth_10081 synth_10630 synth_10717 VDD VDD VNB|VSS
+ sky130_fd_sc_hd__edfxtp_1
X$14570 VNB|VSS synth_10613 synth_10549 synth_387 synth_10273 VDD VDD VNB|VSS
+ sky130_fd_sc_hd__edfxtp_1
X$14571 VNB|VSS synth_4496 synth_3794 synth_3656 synth_4227 VDD VDD VNB|VSS
+ sky130_fd_sc_hd__edfxtp_1
X$14572 VNB|VSS synth_10360 synth_10047 synth_4467 synth_10273 VDD VDD VNB|VSS
+ sky130_fd_sc_hd__edfxtp_1
X$14573 VNB|VSS synth_4714 synth_4422 synth_4810 synth_4595 VDD VDD VNB|VSS
+ sky130_fd_sc_hd__edfxtp_1
X$14574 VNB|VSS synth_8044 synth_7490 synth_5329 synth_8045 VDD VDD VNB|VSS
+ sky130_fd_sc_hd__edfxtp_1
X$14575 VNB|VSS synth_369 synth_54 synth_37 synth_182 VDD VDD VNB|VSS
+ sky130_fd_sc_hd__edfxtp_1
X$14576 VNB|VSS synth_9747 synth_9402 synth_9876 synth_9838 VDD VDD VNB|VSS
+ sky130_fd_sc_hd__edfxtp_1
X$14577 VNB|VSS synth_9532 synth_9402 synth_9531 synth_9601 VDD VDD VNB|VSS
+ sky130_fd_sc_hd__edfxtp_1
X$14578 VNB|VSS synth_10274 synth_10047 synth_6198 synth_10273 VDD VDD VNB|VSS
+ sky130_fd_sc_hd__edfxtp_1
X$14579 VNB|VSS synth_8223 synth_8367 synth_8369 synth_7859 VDD VDD VNB|VSS
+ sky130_fd_sc_hd__edfxtp_1
X$14580 VNB|VSS synth_7736 synth_7334 synth_7843 synth_7413 VDD VDD VNB|VSS
+ sky130_fd_sc_hd__edfxtp_1
X$14581 VNB|VSS synth_8214 synth_7490 synth_6198 synth_8045 VDD VDD VNB|VSS
+ sky130_fd_sc_hd__edfxtp_1
X$14582 VNB|VSS synth_8867 synth_8165 synth_4467 synth_8841 VDD VDD VNB|VSS
+ sky130_fd_sc_hd__edfxtp_1
X$14583 VNB|VSS synth_10084 synth_10047 synth_387 synth_9995 VDD VDD VNB|VSS
+ sky130_fd_sc_hd__edfxtp_1
X$14584 VNB|VSS synth_7761 synth_7490 synth_5329 synth_7458 VDD VDD VNB|VSS
+ sky130_fd_sc_hd__edfxtp_1
X$14585 VNB|VSS synth_9475 synth_8864 synth_1695 synth_9227 VDD VDD VNB|VSS
+ sky130_fd_sc_hd__edfxtp_1
X$14586 VNB|VSS synth_7449 synth_7335 synth_6198 synth_7034 VDD VDD VNB|VSS
+ sky130_fd_sc_hd__edfxtp_1
X$14587 VNB|VSS synth_9530 synth_9402 synth_9598 synth_9601 VDD VDD VNB|VSS
+ sky130_fd_sc_hd__edfxtp_1
X$14588 VNB|VSS synth_2429 synth_1970 synth_2770 synth_2427 VDD VDD VNB|VSS
+ sky130_fd_sc_hd__edfxtp_1
X$14589 VNB|VSS synth_5030 synth_4541 synth_3656 synth_4752 VDD VDD VNB|VSS
+ sky130_fd_sc_hd__edfxtp_1
X$14590 VNB|VSS synth_8616 synth_8488 synth_8716 synth_8451 VDD VDD VNB|VSS
+ sky130_fd_sc_hd__edfxtp_1
X$14591 VNB|VSS synth_8491 synth_8488 synth_8489 synth_8451 VDD VDD VNB|VSS
+ sky130_fd_sc_hd__edfxtp_1
X$14592 VNB|VSS synth_2788 synth_3025 synth_1908 synth_2913 VDD VDD VNB|VSS
+ sky130_fd_sc_hd__edfxtp_1
X$14593 VNB|VSS synth_9078 synth_8928 synth_6564 synth_8816 VDD VDD VNB|VSS
+ sky130_fd_sc_hd__edfxtp_1
X$14594 VNB|VSS synth_936 synth_30 synth_1152 synth_635 VDD VDD VNB|VSS
+ sky130_fd_sc_hd__edfxtp_1
X$14595 VNB|VSS synth_2448 synth_2330 synth_2449 synth_2450 VDD VDD VNB|VSS
+ sky130_fd_sc_hd__edfxtp_1
X$14596 VNB|VSS synth_9050 synth_8488 synth_9131 synth_8929 VDD VDD VNB|VSS
+ sky130_fd_sc_hd__edfxtp_1
X$14597 VNB|VSS synth_4986 synth_3937 synth_626 synth_4987 VDD VDD VNB|VSS
+ sky130_fd_sc_hd__edfxtp_1
X$14598 VNB|VSS synth_8892 synth_8488 synth_8960 synth_8929 VDD VDD VNB|VSS
+ sky130_fd_sc_hd__edfxtp_1
X$14599 VNB|VSS synth_8820 synth_8659 synth_2777 synth_8492 VDD VDD VNB|VSS
+ sky130_fd_sc_hd__edfxtp_1
X$14600 VNB|VSS synth_3216 synth_2845 synth_501 synth_2926 VDD VDD VNB|VSS
+ sky130_fd_sc_hd__edfxtp_1
X$14601 VNB|VSS synth_8697 synth_8928 synth_8337 synth_8816 VDD VDD VNB|VSS
+ sky130_fd_sc_hd__edfxtp_1
X$14602 VNB|VSS synth_1402 synth_517 synth_478 synth_1215 VDD VDD VNB|VSS
+ sky130_fd_sc_hd__edfxtp_1
X$14603 VNB|VSS synth_2858 synth_2330 synth_2941 synth_2719 VDD VDD VNB|VSS
+ sky130_fd_sc_hd__edfxtp_1
X$14604 VNB|VSS synth_3167 synth_2643 synth_3370 synth_3061 VDD VDD VNB|VSS
+ sky130_fd_sc_hd__edfxtp_1
X$14605 VNB|VSS synth_4226 synth_3794 synth_1908 synth_4227 VDD VDD VNB|VSS
+ sky130_fd_sc_hd__edfxtp_1
X$14606 VNB|VSS synth_11006 synth_10090 synth_11136 synth_10937 VDD VDD VNB|VSS
+ sky130_fd_sc_hd__edfxtp_1
X$14607 VNB|VSS synth_2348 synth_2208 synth_1908 synth_2128 VDD VDD VNB|VSS
+ sky130_fd_sc_hd__edfxtp_1
X$14608 VNB|VSS synth_2303 synth_2208 synth_478 synth_2128 VDD VDD VNB|VSS
+ sky130_fd_sc_hd__edfxtp_1
X$14609 VNB|VSS synth_55 synth_270 synth_186 synth_90 VDD VDD VNB|VSS
+ sky130_fd_sc_hd__edfxtp_1
X$14610 VNB|VSS synth_1668 synth_1576 synth_1337 synth_1385 VDD VDD VNB|VSS
+ sky130_fd_sc_hd__edfxtp_1
X$14611 VNB|VSS synth_9298 synth_9402 synth_9536 synth_8929 VDD VDD VNB|VSS
+ sky130_fd_sc_hd__edfxtp_1
X$14612 VNB|VSS synth_3089 synth_2201 synth_478 synth_2926 VDD VDD VNB|VSS
+ sky130_fd_sc_hd__edfxtp_1
X$14613 VNB|VSS synth_9347 synth_8928 synth_6699 synth_9128 VDD VDD VNB|VSS
+ sky130_fd_sc_hd__edfxtp_1
X$14614 VNB|VSS synth_5279 synth_4541 synth_966 synth_5187 VDD VDD VNB|VSS
+ sky130_fd_sc_hd__edfxtp_1
X$14615 VNB|VSS synth_3668 synth_3335 synth_1459 synth_3504 VDD VDD VNB|VSS
+ sky130_fd_sc_hd__edfxtp_1
X$14616 VNB|VSS synth_7297 synth_6611 synth_4588 synth_7034 VDD VDD VNB|VSS
+ sky130_fd_sc_hd__edfxtp_1
X$14617 VNB|VSS synth_7155 synth_6611 synth_5329 synth_7034 VDD VDD VNB|VSS
+ sky130_fd_sc_hd__edfxtp_1
X$14618 VNB|VSS synth_9899 synth_9896 synth_4467 synth_9897 VDD VDD VNB|VSS
+ sky130_fd_sc_hd__edfxtp_1
X$14619 VNB|VSS synth_9712 synth_9402 synth_9710 synth_9711 VDD VDD VNB|VSS
+ sky130_fd_sc_hd__edfxtp_1
X$14620 VNB|VSS synth_5830 synth_5172 synth_6171 synth_5516 VDD VDD VNB|VSS
+ sky130_fd_sc_hd__edfxtp_1
X$14621 VNB|VSS synth_760 synth_568 synth_1053 synth_914 VDD VDD VNB|VSS
+ sky130_fd_sc_hd__edfxtp_1
X$14622 VNB|VSS synth_7363 synth_7490 synth_382 synth_7458 VDD VDD VNB|VSS
+ sky130_fd_sc_hd__edfxtp_1
X$14623 VNB|VSS synth_5377 synth_4600 synth_3656 synth_4976 VDD VDD VNB|VSS
+ sky130_fd_sc_hd__edfxtp_1
X$14624 VNB|VSS synth_5097 synth_4600 synth_966 synth_4976 VDD VDD VNB|VSS
+ sky130_fd_sc_hd__edfxtp_1
X$14625 VNB|VSS synth_11532 synth_10549 synth_8337 synth_11421 VDD VDD VNB|VSS
+ sky130_fd_sc_hd__edfxtp_1
X$14626 VNB|VSS synth_2722 synth_2533 synth_2720 synth_2769 VDD VDD VNB|VSS
+ sky130_fd_sc_hd__edfxtp_1
X$14627 VNB|VSS synth_7687 synth_7335 synth_382 synth_7585 VDD VDD VNB|VSS
+ sky130_fd_sc_hd__edfxtp_1
X$14628 VNB|VSS synth_5568 synth_5166 synth_966 synth_5454 VDD VDD VNB|VSS
+ sky130_fd_sc_hd__edfxtp_1
X$14629 VNB|VSS synth_5642 synth_5166 synth_4111 synth_5454 VDD VDD VNB|VSS
+ sky130_fd_sc_hd__edfxtp_1
X$14630 VNB|VSS synth_4311 synth_4651 synth_1459 synth_4431 VDD VDD VNB|VSS
+ sky130_fd_sc_hd__edfxtp_1
X$14631 VNB|VSS synth_10168 synth_10090 synth_10155 synth_9898 VDD VDD VNB|VSS
+ sky130_fd_sc_hd__edfxtp_1
X$14632 VNB|VSS synth_10211 synth_9896 synth_1695 synth_9897 VDD VDD VNB|VSS
+ sky130_fd_sc_hd__edfxtp_1
X$14633 VNB|VSS synth_7532 synth_6824 synth_6198 synth_7336 VDD VDD VNB|VSS
+ sky130_fd_sc_hd__edfxtp_1
X$14634 VNB|VSS synth_1416 synth_1437 synth_183 synth_1184 VDD VDD VNB|VSS
+ sky130_fd_sc_hd__edfxtp_1
X$14635 VNB|VSS synth_8445 synth_8367 synth_8522 synth_8386 VDD VDD VNB|VSS
+ sky130_fd_sc_hd__edfxtp_1
X$14636 VNB|VSS synth_7401 synth_7023 synth_7629 synth_7179 VDD VDD VNB|VSS
+ sky130_fd_sc_hd__edfxtp_1
X$14637 VNB|VSS synth_7032 synth_6939 synth_7461 synth_6651 VDD VDD VNB|VSS
+ sky130_fd_sc_hd__edfxtp_1
X$14638 VNB|VSS synth_7113 synth_6237 synth_4588 synth_7110 VDD VDD VNB|VSS
+ sky130_fd_sc_hd__edfxtp_1
X$14639 VNB|VSS synth_8936 synth_9045 synth_8911 synth_8999 VDD VDD VNB|VSS
+ sky130_fd_sc_hd__edfxtp_1
X$14640 VNB|VSS synth_6884 synth_6454 synth_6882 synth_6651 VDD VDD VNB|VSS
+ sky130_fd_sc_hd__edfxtp_1
X$14641 VNB|VSS synth_10814 synth_10030 synth_10813 synth_10812 VDD VDD VNB|VSS
+ sky130_fd_sc_hd__edfxtp_1
X$14642 VNB|VSS synth_10886 synth_10030 synth_10967 synth_10812 VDD VDD VNB|VSS
+ sky130_fd_sc_hd__edfxtp_1
X$14643 VNB|VSS synth_1714 synth_1717 synth_1716 synth_1685 VDD VDD VNB|VSS
+ sky130_fd_sc_hd__edfxtp_1
X$14644 VNB|VSS synth_908 synth_756 synth_967 synth_755 VDD VDD VNB|VSS
+ sky130_fd_sc_hd__edfxtp_1
X$14645 VNB|VSS synth_761 synth_568 synth_913 synth_914 VDD VDD VNB|VSS
+ sky130_fd_sc_hd__edfxtp_1
X$14646 VNB|VSS synth_6729 synth_6950 synth_6780 synth_6781 VDD VDD VNB|VSS
+ sky130_fd_sc_hd__edfxtp_1
X$14647 VNB|VSS synth_9502 synth_9102 synth_6699 synth_9660 VDD VDD VNB|VSS
+ sky130_fd_sc_hd__edfxtp_1
X$14648 VNB|VSS synth_9818 synth_9102 synth_6987 synth_9660 VDD VDD VNB|VSS
+ sky130_fd_sc_hd__edfxtp_1
X$14649 VNB|VSS synth_6743 synth_6347 synth_6877 synth_6781 VDD VDD VNB|VSS
+ sky130_fd_sc_hd__edfxtp_1
X$14650 VNB|VSS synth_1192 synth_571 synth_1189 synth_1188 VDD VDD VNB|VSS
+ sky130_fd_sc_hd__edfxtp_1
X$14651 VNB|VSS synth_1287 synth_1518 synth_1364 synth_1188 VDD VDD VNB|VSS
+ sky130_fd_sc_hd__edfxtp_1
X$14652 VNB|VSS synth_5164 synth_4600 synth_4111 synth_4976 VDD VDD VNB|VSS
+ sky130_fd_sc_hd__edfxtp_1
X$14653 VNB|VSS synth_3815 synth_3543 synth_4134 synth_3658 VDD VDD VNB|VSS
+ sky130_fd_sc_hd__edfxtp_1
X$14654 VNB|VSS synth_1570 synth_1437 synth_966 synth_1184 VDD VDD VNB|VSS
+ sky130_fd_sc_hd__edfxtp_1
X$14655 VNB|VSS synth_4583 synth_4826 synth_4865 synth_4481 VDD VDD VNB|VSS
+ sky130_fd_sc_hd__edfxtp_1
X$14656 VNB|VSS synth_9286 synth_9102 synth_1695 synth_9147 VDD VDD VNB|VSS
+ sky130_fd_sc_hd__edfxtp_1
X$14657 VNB|VSS synth_842 synth_521 synth_932 synth_523 VDD VDD VNB|VSS
+ sky130_fd_sc_hd__edfxtp_1
X$14658 VNB|VSS synth_9312 synth_9102 synth_6198 synth_9147 VDD VDD VNB|VSS
+ sky130_fd_sc_hd__edfxtp_1
X$14659 VNB|VSS synth_1200 synth_521 synth_1202 synth_1197 VDD VDD VNB|VSS
+ sky130_fd_sc_hd__edfxtp_1
X$14660 VNB|VSS synth_4771 synth_3781 synth_1181 synth_4479 VDD VDD VNB|VSS
+ sky130_fd_sc_hd__edfxtp_1
X$14661 VNB|VSS synth_8520 synth_8367 synth_8523 synth_8386 VDD VDD VNB|VSS
+ sky130_fd_sc_hd__edfxtp_1
X$14662 VNB|VSS synth_4551 synth_3781 synth_1695 synth_4479 VDD VDD VNB|VSS
+ sky130_fd_sc_hd__edfxtp_1
X$14663 VNB|VSS synth_8690 synth_8367 synth_8691 synth_8469 VDD VDD VNB|VSS
+ sky130_fd_sc_hd__edfxtp_1
X$14664 VNB|VSS synth_8233 synth_7637 synth_2777 synth_8032 VDD VDD VNB|VSS
+ sky130_fd_sc_hd__edfxtp_1
X$14665 VNB|VSS synth_4637 synth_4422 synth_4640 synth_4595 VDD VDD VNB|VSS
+ sky130_fd_sc_hd__edfxtp_1
X$14666 VNB|VSS synth_4400 synth_3781 synth_2860 synth_4479 VDD VDD VNB|VSS
+ sky130_fd_sc_hd__edfxtp_1
X$14667 VNB|VSS synth_7865 synth_7335 synth_5329 synth_7585 VDD VDD VNB|VSS
+ sky130_fd_sc_hd__edfxtp_1
X$14668 VNB|VSS synth_11289 synth_11379 synth_1695 synth_11380 VDD VDD VNB|VSS
+ sky130_fd_sc_hd__edfxtp_1
X$14669 VNB|VSS synth_4361 synth_3703 synth_4564 synth_4105 VDD VDD VNB|VSS
+ sky130_fd_sc_hd__edfxtp_1
X$14670 VNB|VSS synth_930 synth_521 synth_1019 synth_523 VDD VDD VNB|VSS
+ sky130_fd_sc_hd__edfxtp_1
X$14671 VNB|VSS synth_8429 synth_7534 synth_4467 synth_8507 VDD VDD VNB|VSS
+ sky130_fd_sc_hd__edfxtp_1
X$14672 VNB|VSS synth_4063 synth_4651 synth_387 synth_4431 VDD VDD VNB|VSS
+ sky130_fd_sc_hd__edfxtp_1
X$14673 VNB|VSS synth_4872 synth_4826 synth_4958 synth_4723 VDD VDD VNB|VSS
+ sky130_fd_sc_hd__edfxtp_1
X$14674 VNB|VSS synth_522 synth_521 synth_524 synth_523 VDD VDD VNB|VSS
+ sky130_fd_sc_hd__edfxtp_1
X$14675 VNB|VSS synth_6493 synth_6824 synth_626 synth_6626 VDD VDD VNB|VSS
+ sky130_fd_sc_hd__edfxtp_1
X$14676 VNB|VSS synth_8134 synth_7335 synth_6198 synth_7895 VDD VDD VNB|VSS
+ sky130_fd_sc_hd__edfxtp_1
X$14677 VNB|VSS synth_8682 synth_7826 synth_8985 synth_8356 VDD VDD VNB|VSS
+ sky130_fd_sc_hd__edfxtp_1
X$14678 VNB|VSS synth_10436 synth_10090 synth_10479 synth_10480 VDD VDD VNB|VSS
+ sky130_fd_sc_hd__edfxtp_1
X$14679 VNB|VSS synth_6087 synth_5515 synth_6169 synth_6090 VDD VDD VNB|VSS
+ sky130_fd_sc_hd__edfxtp_1
X$14680 VNB|VSS synth_629 synth_521 synth_630 synth_523 VDD VDD VNB|VSS
+ sky130_fd_sc_hd__edfxtp_1
X$14681 VNB|VSS synth_6978 synth_6927 synth_7073 synth_7068 VDD VDD VNB|VSS
+ sky130_fd_sc_hd__edfxtp_1
X$14682 VNB|VSS synth_3027 synth_2044 synth_1908 synth_2920 VDD VDD VNB|VSS
+ sky130_fd_sc_hd__edfxtp_1
X$14683 VNB|VSS synth_3028 synth_2044 synth_1337 synth_2920 VDD VDD VNB|VSS
+ sky130_fd_sc_hd__edfxtp_1
X$14684 VNB|VSS synth_8801 synth_8367 synth_9059 synth_8469 VDD VDD VNB|VSS
+ sky130_fd_sc_hd__edfxtp_1
X$14685 VNB|VSS synth_10214 synth_10090 synth_10409 synth_9898 VDD VDD VNB|VSS
+ sky130_fd_sc_hd__edfxtp_1
X$14686 VNB|VSS synth_7940 synth_6583 synth_5329 synth_7895 VDD VDD VNB|VSS
+ sky130_fd_sc_hd__edfxtp_1
X$14687 VNB|VSS synth_9150 synth_9102 synth_4467 synth_9147 VDD VDD VNB|VSS
+ sky130_fd_sc_hd__edfxtp_1
X$14688 VNB|VSS synth_2792 synth_2044 synth_2860 synth_2920 VDD VDD VNB|VSS
+ sky130_fd_sc_hd__edfxtp_1
X$14690 VNB|VSS synth_3382 synth_3385 synth_3609 synth_3351 VDD VDD VNB|VSS
+ sky130_fd_sc_hd__edfxtp_1
X$14691 VNB|VSS synth_6429 synth_6733 synth_6841 synth_6174 VDD VDD VNB|VSS
+ sky130_fd_sc_hd__edfxtp_1
X$14692 VNB|VSS synth_7254 synth_6853 synth_7221 synth_7222 VDD VDD VNB|VSS
+ sky130_fd_sc_hd__edfxtp_1
X$14693 VNB|VSS synth_3087 synth_2800 synth_1908 synth_2871 VDD VDD VNB|VSS
+ sky130_fd_sc_hd__edfxtp_1
X$14694 VNB|VSS synth_3218 synth_2730 synth_3174 synth_3219 VDD VDD VNB|VSS
+ sky130_fd_sc_hd__edfxtp_1
X$14695 VNB|VSS synth_7520 synth_6890 synth_6699 synth_7277 VDD VDD VNB|VSS
+ sky130_fd_sc_hd__edfxtp_1
X$14696 VNB|VSS synth_644 synth_270 synth_642 synth_610 VDD VDD VNB|VSS
+ sky130_fd_sc_hd__edfxtp_1
X$14697 VNB|VSS synth_2474 synth_2330 synth_2623 synth_2473 VDD VDD VNB|VSS
+ sky130_fd_sc_hd__edfxtp_1
X$14698 VNB|VSS synth_6710 synth_6853 synth_6855 synth_6440 VDD VDD VNB|VSS
+ sky130_fd_sc_hd__edfxtp_1
X$14699 VNB|VSS synth_10278 synth_9760 synth_10276 synth_10277 VDD VDD VNB|VSS
+ sky130_fd_sc_hd__edfxtp_1
X$14700 VNB|VSS synth_1177 synth_1345 synth_1226 synth_1135 VDD VDD VNB|VSS
+ sky130_fd_sc_hd__edfxtp_1
X$14701 VNB|VSS synth_744 synth_270 synth_1032 synth_610 VDD VDD VNB|VSS
+ sky130_fd_sc_hd__edfxtp_1
X$14702 VNB|VSS synth_3023 synth_1872 synth_3059 synth_3061 VDD VDD VNB|VSS
+ sky130_fd_sc_hd__edfxtp_1
X$14703 VNB|VSS synth_2532 synth_2643 synth_2784 synth_2450 VDD VDD VNB|VSS
+ sky130_fd_sc_hd__edfxtp_1
X$14704 VNB|VSS synth_5524 synth_5166 synth_626 synth_5620 VDD VDD VNB|VSS
+ sky130_fd_sc_hd__edfxtp_1
X$14705 VNB|VSS synth_5573 synth_5172 synth_5518 synth_5516 VDD VDD VNB|VSS
+ sky130_fd_sc_hd__edfxtp_1
X$14706 VNB|VSS synth_2570 synth_2643 synth_2761 synth_2450 VDD VDD VNB|VSS
+ sky130_fd_sc_hd__edfxtp_1
X$14707 VNB|VSS synth_1349 synth_1345 synth_1477 synth_1232 VDD VDD VNB|VSS
+ sky130_fd_sc_hd__edfxtp_1
X$14708 VNB|VSS synth_4298 synth_3413 synth_4300 synth_4123 VDD VDD VNB|VSS
+ sky130_fd_sc_hd__edfxtp_1
X$14709 VNB|VSS synth_1228 synth_1136 synth_501 synth_962 VDD VDD VNB|VSS
+ sky130_fd_sc_hd__edfxtp_1
X$14710 VNB|VSS synth_1111 synth_48 synth_88 synth_962 VDD VDD VNB|VSS
+ sky130_fd_sc_hd__edfxtp_1
X$14711 VNB|VSS synth_5169 synth_5515 synth_5367 synth_4942 VDD VDD VNB|VSS
+ sky130_fd_sc_hd__edfxtp_1
X$14712 VNB|VSS synth_3654 synth_3247 synth_626 synth_3646 VDD VDD VNB|VSS
+ sky130_fd_sc_hd__edfxtp_1
X$14713 VNB|VSS synth_7874 synth_7814 synth_7873 synth_7769 VDD VDD VNB|VSS
+ sky130_fd_sc_hd__edfxtp_1
X$14714 VNB|VSS synth_3414 synth_3247 synth_1908 synth_3184 VDD VDD VNB|VSS
+ sky130_fd_sc_hd__edfxtp_1
X$14715 VNB|VSS synth_6859 synth_6853 synth_6926 synth_6440 VDD VDD VNB|VSS
+ sky130_fd_sc_hd__edfxtp_1
X$14716 VNB|VSS synth_3165 synth_2468 synth_1337 synth_3022 VDD VDD VNB|VSS
+ sky130_fd_sc_hd__edfxtp_1
X$14717 VNB|VSS synth_7348 synth_6733 synth_7427 synth_7249 VDD VDD VNB|VSS
+ sky130_fd_sc_hd__edfxtp_1
X$14718 VNB|VSS synth_2780 synth_1872 synth_2781 synth_2822 VDD VDD VNB|VSS
+ sky130_fd_sc_hd__edfxtp_1
X$14719 VNB|VSS synth_7088 synth_6531 synth_2777 synth_6952 VDD VDD VNB|VSS
+ sky130_fd_sc_hd__edfxtp_1
X$14720 VNB|VSS synth_6954 synth_6531 synth_6564 synth_6952 VDD VDD VNB|VSS
+ sky130_fd_sc_hd__edfxtp_1
X$14721 VNB|VSS synth_7140 synth_6734 synth_7138 synth_7139 VDD VDD VNB|VSS
+ sky130_fd_sc_hd__edfxtp_1
X$14722 VNB|VSS synth_11210 synth_10081 synth_11208 synth_11127 VDD VDD VNB|VSS
+ sky130_fd_sc_hd__edfxtp_1
X$14723 VNB|VSS synth_7276 synth_6734 synth_7218 synth_7139 VDD VDD VNB|VSS
+ sky130_fd_sc_hd__edfxtp_1
X$14724 VNB|VSS synth_6533 synth_6531 synth_2777 synth_6424 VDD VDD VNB|VSS
+ sky130_fd_sc_hd__edfxtp_1
X$14725 VNB|VSS synth_7774 synth_7644 synth_2777 synth_7565 VDD VDD VNB|VSS
+ sky130_fd_sc_hd__edfxtp_1
X$14726 VNB|VSS synth_7566 synth_7644 synth_1695 synth_7565 VDD VDD VNB|VSS
+ sky130_fd_sc_hd__edfxtp_1
X$14727 VNB|VSS synth_2501 synth_2465 synth_2531 synth_2378 VDD VDD VNB|VSS
+ sky130_fd_sc_hd__edfxtp_1
X$14728 VNB|VSS synth_7017 synth_6890 synth_2777 synth_6845 VDD VDD VNB|VSS
+ sky130_fd_sc_hd__edfxtp_1
X$14729 VNB|VSS synth_7987 synth_7144 synth_7953 synth_7885 VDD VDD VNB|VSS
+ sky130_fd_sc_hd__edfxtp_1
X$14730 VNB|VSS synth_4759 synth_3413 synth_4764 synth_4610 VDD VDD VNB|VSS
+ sky130_fd_sc_hd__edfxtp_1
X$14731 VNB|VSS synth_3804 synth_3806 synth_478 synth_3762 VDD VDD VNB|VSS
+ sky130_fd_sc_hd__edfxtp_1
X$14732 VNB|VSS synth_3137 synth_2643 synth_3207 synth_3061 VDD VDD VNB|VSS
+ sky130_fd_sc_hd__edfxtp_1
X$14733 VNB|VSS synth_10304 synth_10081 synth_10545 synth_10082 VDD VDD VNB|VSS
+ sky130_fd_sc_hd__edfxtp_1
X$14734 VNB|VSS synth_6922 synth_6890 synth_4467 synth_6845 VDD VDD VNB|VSS
+ sky130_fd_sc_hd__edfxtp_1
X$14735 VNB|VSS synth_2377 synth_1872 synth_2326 synth_2378 VDD VDD VNB|VSS
+ sky130_fd_sc_hd__edfxtp_1
X$14736 VNB|VSS synth_3763 synth_3806 synth_1908 synth_3762 VDD VDD VNB|VSS
+ sky130_fd_sc_hd__edfxtp_1
X$14737 VNB|VSS synth_2299 synth_2077 synth_387 synth_1988 VDD VDD VNB|VSS
+ sky130_fd_sc_hd__edfxtp_1
X$14738 VNB|VSS synth_2146 synth_2077 synth_1337 synth_1988 VDD VDD VNB|VSS
+ sky130_fd_sc_hd__edfxtp_1
X$14739 VNB|VSS synth_7883 synth_6890 synth_6564 synth_7718 VDD VDD VNB|VSS
+ sky130_fd_sc_hd__edfxtp_1
X$14740 VNB|VSS synth_10083 synth_10081 synth_10141 synth_10082 VDD VDD VNB|VSS
+ sky130_fd_sc_hd__edfxtp_1
X$14741 VNB|VSS synth_10978 synth_10355 synth_6699 synth_10709 VDD VDD VNB|VSS
+ sky130_fd_sc_hd__edfxtp_1
X$14742 VNB|VSS synth_7530 synth_7645 synth_7720 synth_7222 VDD VDD VNB|VSS
+ sky130_fd_sc_hd__edfxtp_1
X$14743 VNB|VSS synth_7990 synth_7645 synth_8208 synth_7992 VDD VDD VNB|VSS
+ sky130_fd_sc_hd__edfxtp_1
X$14744 VNB|VSS synth_2569 synth_2468 synth_1337 synth_2505 VDD VDD VNB|VSS
+ sky130_fd_sc_hd__edfxtp_1
X$14745 VNB|VSS synth_180 synth_282 synth_183 synth_147 VDD VDD VNB|VSS
+ sky130_fd_sc_hd__edfxtp_1
X$14746 VNB|VSS synth_219 synth_282 synth_88 synth_147 VDD VDD VNB|VSS
+ sky130_fd_sc_hd__edfxtp_1
X$14747 VNB|VSS synth_5173 synth_5172 synth_5434 synth_5277 VDD VDD VNB|VSS
+ sky130_fd_sc_hd__edfxtp_1
X$14748 VNB|VSS synth_2825 synth_2465 synth_2853 synth_2822 VDD VDD VNB|VSS
+ sky130_fd_sc_hd__edfxtp_1
X$14749 VNB|VSS synth_10756 synth_10355 synth_6987 synth_10709 VDD VDD VNB|VSS
+ sky130_fd_sc_hd__edfxtp_1
X$14750 VNB|VSS synth_10713 synth_10355 synth_2777 synth_10709 VDD VDD VNB|VSS
+ sky130_fd_sc_hd__edfxtp_1
X$14751 VNB|VSS synth_5351 synth_5166 synth_4111 synth_5270 VDD VDD VNB|VSS
+ sky130_fd_sc_hd__edfxtp_1
X$14752 VNB|VSS synth_11373 synth_10549 synth_6987 synth_11421 VDD VDD VNB|VSS
+ sky130_fd_sc_hd__edfxtp_1
X$14753 VNB|VSS synth_2778 synth_1872 synth_2982 synth_2822 VDD VDD VNB|VSS
+ sky130_fd_sc_hd__edfxtp_1
X$14754 VNB|VSS synth_7385 synth_7144 synth_7439 synth_7253 VDD VDD VNB|VSS
+ sky130_fd_sc_hd__edfxtp_1
X$14755 VNB|VSS synth_7281 synth_7144 synth_7279 synth_7253 VDD VDD VNB|VSS
+ sky130_fd_sc_hd__edfxtp_1
X$14756 VNB|VSS synth_8038 synth_7644 synth_1695 synth_7886 VDD VDD VNB|VSS
+ sky130_fd_sc_hd__edfxtp_1
X$14757 VNB|VSS synth_622 synth_568 synth_652 synth_515 VDD VDD VNB|VSS
+ sky130_fd_sc_hd__edfxtp_1
X$14758 VNB|VSS synth_6788 synth_7144 synth_7059 synth_6491 VDD VDD VNB|VSS
+ sky130_fd_sc_hd__edfxtp_1
X$14759 VNB|VSS synth_5193 synth_5166 synth_626 synth_5270 VDD VDD VNB|VSS
+ sky130_fd_sc_hd__edfxtp_1
X$14760 VNB|VSS synth_1843 synth_1136 synth_37 synth_1584 VDD VDD VNB|VSS
+ sky130_fd_sc_hd__edfxtp_1
X$14761 VNB|VSS synth_2542 synth_2201 synth_478 synth_2520 VDD VDD VNB|VSS
+ sky130_fd_sc_hd__edfxtp_1
X$14762 VNB|VSS synth_169 synth_30 synth_108 synth_8 VDD VDD VNB|VSS
+ sky130_fd_sc_hd__edfxtp_1
X$14763 VDD synth_199 synth_134 synth_169 synth_361 VNB|VSS VDD VNB|VSS
+ sky130_fd_sc_hd__nand3b_1
X$14764 VNB|VSS synth_2228 synth_2145 synth_258 synth_2132 VDD VDD VNB|VSS
+ sky130_fd_sc_hd__edfxtp_1
X$14765 VNB|VSS synth_7513 synth_7637 synth_2777 synth_7714 VDD VDD VNB|VSS
+ sky130_fd_sc_hd__edfxtp_1
X$14766 VNB|VSS synth_2066 synth_2145 synth_478 synth_2132 VDD VDD VNB|VSS
+ sky130_fd_sc_hd__edfxtp_1
X$14767 VNB|VSS synth_7671 synth_7637 synth_6564 synth_7714 VDD VDD VNB|VSS
+ sky130_fd_sc_hd__edfxtp_1
X$14768 VNB|VSS synth_9171 synth_8864 synth_387 synth_9227 VDD VDD VNB|VSS
+ sky130_fd_sc_hd__edfxtp_1
X$14769 VNB|VSS synth_1896 synth_2145 synth_626 synth_1671 VDD VDD VNB|VSS
+ sky130_fd_sc_hd__edfxtp_1
X$14770 VNB|VSS synth_483 synth_443 synth_478 synth_445 VDD VDD VNB|VSS
+ sky130_fd_sc_hd__edfxtp_1
X$14771 VNB|VSS synth_899 synth_54 synth_37 synth_741 VDD VDD VNB|VSS
+ sky130_fd_sc_hd__edfxtp_1
X$14772 VNB|VSS synth_2540 synth_2730 synth_2707 synth_2274 VDD VDD VNB|VSS
+ sky130_fd_sc_hd__edfxtp_1
X$14773 VNB|VSS synth_9058 synth_9291 synth_9211 synth_8628 VDD VDD VNB|VSS
+ sky130_fd_sc_hd__edfxtp_1
X$14774 VNB|VSS synth_1614 synth_557 synth_37 synth_1248 VDD VDD VNB|VSS
+ sky130_fd_sc_hd__edfxtp_1
X$14775 VNB|VSS synth_9479 synth_9291 synth_9389 synth_9478 VDD VDD VNB|VSS
+ sky130_fd_sc_hd__edfxtp_1
X$14776 VNB|VSS synth_7318 synth_6733 synth_7596 synth_7249 VDD VDD VNB|VSS
+ sky130_fd_sc_hd__edfxtp_1
X$14777 VNB|VSS synth_1251 synth_1345 synth_1472 synth_1135 VDD VDD VNB|VSS
+ sky130_fd_sc_hd__edfxtp_1
X$14778 VNB|VSS synth_344 synth_282 synth_258 synth_395 VDD VDD VNB|VSS
+ sky130_fd_sc_hd__edfxtp_1
X$14779 VNB|VSS synth_831 synth_571 synth_1153 synth_645 VDD VDD VNB|VSS
+ sky130_fd_sc_hd__edfxtp_1
X$14780 VNB|VSS synth_9764 synth_9291 synth_9831 synth_9478 VDD VDD VNB|VSS
+ sky130_fd_sc_hd__edfxtp_1
X$14781 VNB|VSS synth_8619 synth_8228 synth_6699 synth_8492 VDD VDD VNB|VSS
+ sky130_fd_sc_hd__edfxtp_1
X$14782 VNB|VSS synth_7908 synth_7814 synth_8113 synth_7769 VDD VDD VNB|VSS
+ sky130_fd_sc_hd__edfxtp_1
X$14783 VNB|VSS synth_3961 synth_3385 synth_3901 synth_3809 VDD VDD VNB|VSS
+ sky130_fd_sc_hd__edfxtp_1
X$14784 VNB|VSS synth_3760 synth_3385 synth_3808 synth_3809 VDD VDD VNB|VSS
+ sky130_fd_sc_hd__edfxtp_1
X$14785 VNB|VSS synth_1918 synth_1136 synth_501 synth_1584 VDD VDD VNB|VSS
+ sky130_fd_sc_hd__edfxtp_1
X$14786 VNB|VSS synth_827 synth_568 synth_960 synth_914 VDD VDD VNB|VSS
+ sky130_fd_sc_hd__edfxtp_1
X$14787 VNB|VSS synth_396 synth_439 synth_88 synth_395 VDD VDD VNB|VSS
+ sky130_fd_sc_hd__edfxtp_1
X$14788 VNB|VSS synth_1654 synth_840 synth_258 synth_1671 VDD VDD VNB|VSS
+ sky130_fd_sc_hd__edfxtp_1
X$14789 VNB|VSS synth_8549 synth_8315 synth_8687 synth_8628 VDD VDD VNB|VSS
+ sky130_fd_sc_hd__edfxtp_1
X$14790 VNB|VSS synth_10835 synth_10081 synth_10904 synth_10717 VDD VDD VNB|VSS
+ sky130_fd_sc_hd__edfxtp_1
X$14791 VNB|VSS synth_11052 synth_10628 synth_11124 synth_11079 VDD VDD VNB|VSS
+ sky130_fd_sc_hd__edfxtp_1
X$14792 VNB|VSS synth_2305 synth_1136 synth_183 synth_2111 VDD VDD VNB|VSS
+ sky130_fd_sc_hd__edfxtp_1
X$14793 VNB|VSS synth_1952 synth_1717 synth_2087 synth_1685 VDD VDD VNB|VSS
+ sky130_fd_sc_hd__edfxtp_1
X$14794 VNB|VSS synth_3464 synth_3385 synth_3687 synth_3351 VDD VDD VNB|VSS
+ sky130_fd_sc_hd__edfxtp_1
X$14795 VNB|VSS synth_4547 synth_4541 synth_626 synth_4120 VDD VDD VNB|VSS
+ sky130_fd_sc_hd__edfxtp_1
X$14796 VNB|VSS synth_4599 synth_4505 synth_4626 synth_4497 VDD VDD VNB|VSS
+ sky130_fd_sc_hd__edfxtp_1
X$14797 VNB|VSS synth_4685 synth_4541 synth_4111 synth_4752 VDD VDD VNB|VSS
+ sky130_fd_sc_hd__edfxtp_1
X$14798 VNB|VSS synth_7057 synth_6459 synth_3656 synth_6858 VDD VDD VNB|VSS
+ sky130_fd_sc_hd__edfxtp_1
X$14799 VNB|VSS synth_8066 synth_7814 synth_8118 synth_7772 VDD VDD VNB|VSS
+ sky130_fd_sc_hd__edfxtp_1
X$14800 VNB|VSS synth_1623 synth_1576 synth_37 synth_1534 VDD VDD VNB|VSS
+ sky130_fd_sc_hd__edfxtp_1
X$14801 VNB|VSS synth_5699 synth_5439 synth_3656 synth_5686 VDD VDD VNB|VSS
+ sky130_fd_sc_hd__edfxtp_1
X$14802 VNB|VSS synth_6906 synth_6828 synth_6921 synth_6850 VDD VDD VNB|VSS
+ sky130_fd_sc_hd__edfxtp_1
X$14803 VNB|VSS synth_9426 synth_9291 synth_9388 synth_9478 VDD VDD VNB|VSS
+ sky130_fd_sc_hd__edfxtp_1
X$14804 VNB|VSS synth_8192 synth_8228 synth_6987 synth_8148 VDD VDD VNB|VSS
+ sky130_fd_sc_hd__edfxtp_1
X$14805 VNB|VSS synth_6784 synth_6801 synth_6868 synth_6445 VDD VDD VNB|VSS
+ sky130_fd_sc_hd__edfxtp_1
X$14806 VNB|VSS synth_4387 synth_4293 synth_4464 synth_4123 VDD VDD VNB|VSS
+ sky130_fd_sc_hd__edfxtp_1
X$14807 VNB|VSS synth_7103 synth_7190 synth_4566 synth_7162 VDD VDD VNB|VSS
+ sky130_fd_sc_hd__edfxtp_1
X$14808 VNB|VSS synth_7020 synth_7190 synth_5329 synth_7162 VDD VDD VNB|VSS
+ sky130_fd_sc_hd__edfxtp_1
X$14809 VNB|VSS synth_7781 synth_7190 synth_4566 synth_7617 VDD VDD VNB|VSS
+ sky130_fd_sc_hd__edfxtp_1
X$14810 VNB|VSS synth_7649 synth_7190 synth_6198 synth_7617 VDD VDD VNB|VSS
+ sky130_fd_sc_hd__edfxtp_1
X$14811 VNB|VSS synth_3908 synth_3413 synth_4047 synth_3650 VDD VDD VNB|VSS
+ sky130_fd_sc_hd__edfxtp_1
X$14812 VNB|VSS synth_7947 synth_7814 synth_8026 synth_7769 VDD VDD VNB|VSS
+ sky130_fd_sc_hd__edfxtp_1
X$14813 VNB|VSS synth_9577 synth_9291 synth_9678 synth_9478 VDD VDD VNB|VSS
+ sky130_fd_sc_hd__edfxtp_1
X$14814 VNB|VSS synth_1224 synth_54 synth_183 synth_1108 VDD VDD VNB|VSS
+ sky130_fd_sc_hd__edfxtp_1
X$14815 VNB|VSS synth_3100 synth_2465 synth_3199 synth_3055 VDD VDD VNB|VSS
+ sky130_fd_sc_hd__edfxtp_1
X$14816 VNB|VSS synth_6620 synth_6733 synth_6840 synth_6254 VDD VDD VNB|VSS
+ sky130_fd_sc_hd__edfxtp_1
X$14817 VNB|VSS synth_1396 synth_1136 synth_88 synth_1108 VDD VDD VNB|VSS
+ sky130_fd_sc_hd__edfxtp_1
X$14818 VNB|VSS synth_7984 synth_7637 synth_6699 synth_8032 VDD VDD VNB|VSS
+ sky130_fd_sc_hd__edfxtp_1
X$14819 VNB|VSS synth_2854 synth_2077 synth_387 synth_2715 VDD VDD VNB|VSS
+ sky130_fd_sc_hd__edfxtp_1
X$14820 VNB|VSS synth_8300 synth_8165 synth_4566 synth_8166 VDD VDD VNB|VSS
+ sky130_fd_sc_hd__edfxtp_1
X$14821 VNB|VSS synth_4757 synth_4293 synth_4955 synth_4610 VDD VDD VNB|VSS
+ sky130_fd_sc_hd__edfxtp_1
X$14822 VNB|VSS synth_8281 synth_7534 synth_6198 synth_7993 VDD VDD VNB|VSS
+ sky130_fd_sc_hd__edfxtp_1
X$14823 VNB|VSS synth_7770 synth_7637 synth_2777 synth_7560 VDD VDD VNB|VSS
+ sky130_fd_sc_hd__edfxtp_1
X$14824 VNB|VSS synth_9212 synth_8864 synth_6198 synth_9155 VDD VDD VNB|VSS
+ sky130_fd_sc_hd__edfxtp_1
X$14825 VNB|VSS synth_9422 synth_8864 synth_4467 synth_9155 VDD VDD VNB|VSS
+ sky130_fd_sc_hd__edfxtp_1
X$14826 VNB|VSS synth_9507 synth_9291 synth_9508 synth_9573 VDD VDD VNB|VSS
+ sky130_fd_sc_hd__edfxtp_1
X$14827 VNB|VSS synth_9670 synth_8863 synth_9827 synth_9573 VDD VDD VNB|VSS
+ sky130_fd_sc_hd__edfxtp_1
X$14828 VNB|VSS synth_2847 synth_2800 synth_501 synth_2871 VDD VDD VNB|VSS
+ sky130_fd_sc_hd__edfxtp_1
X$14829 VNB|VSS synth_2899 synth_2077 synth_37 synth_2715 VDD VDD VNB|VSS
+ sky130_fd_sc_hd__edfxtp_1
X$14830 VNB|VSS synth_8365 synth_8165 synth_6198 synth_7999 VDD VDD VNB|VSS
+ sky130_fd_sc_hd__edfxtp_1
X$14831 VNB|VSS synth_3503 synth_2804 synth_626 synth_3204 VDD VDD VNB|VSS
+ sky130_fd_sc_hd__edfxtp_1
X$14832 VNB|VSS synth_3574 synth_3478 synth_3573 synth_3479 VDD VDD VNB|VSS
+ sky130_fd_sc_hd__edfxtp_1
X$14833 VNB|VSS synth_7149 synth_6824 synth_3656 synth_6996 VDD VDD VNB|VSS
+ sky130_fd_sc_hd__edfxtp_1
X$14834 VNB|VSS synth_4148 synth_2804 synth_3656 synth_3972 VDD VDD VNB|VSS
+ sky130_fd_sc_hd__edfxtp_1
X$14835 VNB|VSS synth_6444 synth_6794 synth_4467 synth_6795 VDD VDD VNB|VSS
+ sky130_fd_sc_hd__edfxtp_1
X$14836 VNB|VSS synth_7188 synth_6794 synth_6198 synth_7151 VDD VDD VNB|VSS
+ sky130_fd_sc_hd__edfxtp_1
X$14837 VNB|VSS synth_8225 synth_7933 synth_4566 synth_8057 VDD VDD VNB|VSS
+ sky130_fd_sc_hd__edfxtp_1
X$14838 VNB|VSS synth_7158 synth_6801 synth_7156 synth_7098 VDD VDD VNB|VSS
+ sky130_fd_sc_hd__edfxtp_1
X$14839 VNB|VSS synth_3931 synth_3569 synth_3932 synth_3676 VDD VDD VNB|VSS
+ sky130_fd_sc_hd__edfxtp_1
X$14840 VNB|VSS synth_3987 synth_3478 synth_4054 synth_3771 VDD VDD VNB|VSS
+ sky130_fd_sc_hd__edfxtp_1
X$14841 VNB|VSS synth_4898 synth_3937 synth_626 synth_4932 VDD VDD VNB|VSS
+ sky130_fd_sc_hd__edfxtp_1
X$14842 VNB|VSS synth_4389 synth_4461 synth_4578 synth_4476 VDD VDD VNB|VSS
+ sky130_fd_sc_hd__edfxtp_1
X$14843 VNB|VSS synth_3547 synth_3221 synth_2777 synth_3196 VDD VDD VNB|VSS
+ sky130_fd_sc_hd__edfxtp_1
X$14844 VNB|VSS synth_3492 synth_3576 synth_3497 synth_3182 VDD VDD VNB|VSS
+ sky130_fd_sc_hd__edfxtp_1
X$14845 VNB|VSS synth_4362 synth_2845 synth_4111 synth_4321 VDD VDD VNB|VSS
+ sky130_fd_sc_hd__edfxtp_1
X$14846 VNB|VSS synth_7224 synth_6824 synth_4111 synth_6996 VDD VDD VNB|VSS
+ sky130_fd_sc_hd__edfxtp_1
X$14847 VNB|VSS synth_12658 synth_11527 synth_12617 synth_12615 VDD VDD VNB|VSS
+ sky130_fd_sc_hd__edfxtp_1
X$14848 VNB|VSS synth_4391 synth_4461 synth_4689 synth_4476 VDD VDD VNB|VSS
+ sky130_fd_sc_hd__edfxtp_1
X$14849 VNB|VSS synth_9086 synth_8659 synth_6699 synth_8747 VDD VDD VNB|VSS
+ sky130_fd_sc_hd__edfxtp_1
X$14850 VNB|VSS synth_7794 synth_6929 synth_7832 synth_7616 VDD VDD VNB|VSS
+ sky130_fd_sc_hd__edfxtp_1
X$14851 VNB|VSS synth_7615 synth_7190 synth_6198 synth_7293 VDD VDD VNB|VSS
+ sky130_fd_sc_hd__edfxtp_1
X$14852 VNB|VSS synth_1851 synth_1280 synth_966 synth_1643 VDD VDD VNB|VSS
+ sky130_fd_sc_hd__edfxtp_1
X$14853 VNB|VSS synth_4005 synth_3284 synth_449 synth_3879 VDD VDD VNB|VSS
+ sky130_fd_sc_hd__edfxtp_1
X$14854 VNB|VSS synth_4511 synth_2845 synth_501 synth_4321 VDD VDD VNB|VSS
+ sky130_fd_sc_hd__edfxtp_1
X$14855 VNB|VSS synth_2245 synth_2205 synth_2306 synth_1973 VDD VDD VNB|VSS
+ sky130_fd_sc_hd__edfxtp_1
X$14856 VNB|VSS synth_904 synth_61 synth_887 synth_655 VDD VDD VNB|VSS
+ sky130_fd_sc_hd__edfxtp_1
X$14857 VNB|VSS synth_4238 synth_2845 synth_626 synth_4321 VDD VDD VNB|VSS
+ sky130_fd_sc_hd__edfxtp_1
X$14858 VNB|VSS synth_1099 synth_450 synth_1148 synth_766 VDD VDD VNB|VSS
+ sky130_fd_sc_hd__edfxtp_1
X$14859 VNB|VSS synth_7392 synth_6961 synth_7482 synth_7568 VDD VDD VNB|VSS
+ sky130_fd_sc_hd__edfxtp_1
X$14860 VNB|VSS synth_2094 synth_1727 synth_2170 synth_1638 VDD VDD VNB|VSS
+ sky130_fd_sc_hd__edfxtp_1
X$14861 VNB|VSS synth_1408 synth_1265 synth_501 synth_1117 VDD VDD VNB|VSS
+ sky130_fd_sc_hd__edfxtp_1
X$14862 VNB|VSS synth_7446 synth_6824 synth_4111 synth_7336 VDD VDD VNB|VSS
+ sky130_fd_sc_hd__edfxtp_1
X$14863 VNB|VSS synth_8621 synth_8533 synth_8622 synth_8453 VDD VDD VNB|VSS
+ sky130_fd_sc_hd__edfxtp_1
X$14864 VNB|VSS synth_7932 synth_8082 synth_8227 synth_7729 VDD VDD VNB|VSS
+ sky130_fd_sc_hd__edfxtp_1
X$14865 VNB|VSS synth_6051 synth_4836 synth_4588 synth_5815 VDD VDD VNB|VSS
+ sky130_fd_sc_hd__edfxtp_1
X$14866 VNB|VSS synth_6615 synth_6927 synth_6766 synth_6319 VDD VDD VNB|VSS
+ sky130_fd_sc_hd__edfxtp_1
X$14867 VNB|VSS synth_3420 synth_3221 synth_1695 synth_3196 VDD VDD VNB|VSS
+ sky130_fd_sc_hd__edfxtp_1
X$14868 VNB|VSS synth_4871 synth_4487 synth_4969 synth_4970 VDD VDD VNB|VSS
+ sky130_fd_sc_hd__edfxtp_1
X$14869 VNB|VSS synth_3912 synth_3950 synth_88 synth_3846 VDD VDD VNB|VSS
+ sky130_fd_sc_hd__edfxtp_1
X$14870 VNB|VSS synth_7976 synth_7576 synth_382 synth_8057 VDD VDD VNB|VSS
+ sky130_fd_sc_hd__edfxtp_1
X$14871 VNB|VSS synth_8896 synth_8659 synth_2777 synth_8747 VDD VDD VNB|VSS
+ sky130_fd_sc_hd__edfxtp_1
X$14872 VNB|VSS synth_7395 synth_6961 synth_7453 synth_7098 VDD VDD VNB|VSS
+ sky130_fd_sc_hd__edfxtp_1
X$14873 VNB|VSS synth_1309 synth_450 synth_1394 synth_1377 VDD VDD VNB|VSS
+ sky130_fd_sc_hd__edfxtp_1
X$14874 VNB|VSS synth_3485 synth_3221 synth_88 synth_3416 VDD VDD VNB|VSS
+ sky130_fd_sc_hd__edfxtp_1
X$14875 VNB|VSS synth_7406 synth_7576 synth_4566 synth_7577 VDD VDD VNB|VSS
+ sky130_fd_sc_hd__edfxtp_1
X$14876 VNB|VSS synth_4301 synth_4299 synth_1695 synth_4254 VDD VDD VNB|VSS
+ sky130_fd_sc_hd__edfxtp_1
X$14877 VNB|VSS synth_6638 synth_6794 synth_6198 synth_6795 VDD VDD VNB|VSS
+ sky130_fd_sc_hd__edfxtp_1
X$14878 VNB|VSS synth_4040 synth_3478 synth_4306 synth_3771 VDD VDD VNB|VSS
+ sky130_fd_sc_hd__edfxtp_1
X$14879 VNB|VSS synth_4824 synth_4299 synth_4467 synth_4953 VDD VDD VNB|VSS
+ sky130_fd_sc_hd__edfxtp_1
X$14880 VNB|VSS synth_11899 synth_11851 synth_12021 synth_11804 VDD VDD VNB|VSS
+ sky130_fd_sc_hd__edfxtp_1
X$14881 VNB|VSS synth_8826 synth_8659 synth_6987 synth_8747 VDD VDD VNB|VSS
+ sky130_fd_sc_hd__edfxtp_1
X$14882 VNB|VSS synth_3904 synth_3478 synth_3926 synth_3771 VDD VDD VNB|VSS
+ sky130_fd_sc_hd__edfxtp_1
X$14883 VNB|VSS synth_3542 synth_3221 synth_2777 synth_3416 VDD VDD VNB|VSS
+ sky130_fd_sc_hd__edfxtp_1
X$14884 VNB|VSS synth_1961 synth_1727 synth_1934 synth_1804 VDD VDD VNB|VSS
+ sky130_fd_sc_hd__edfxtp_1
X$14885 VNB|VSS synth_4750 synth_4487 synth_4848 synth_4450 VDD VDD VNB|VSS
+ sky130_fd_sc_hd__edfxtp_1
X$14886 VNB|VSS synth_2272 synth_1727 synth_2319 synth_2172 VDD VDD VNB|VSS
+ sky130_fd_sc_hd__edfxtp_1
X$14887 VNB|VSS synth_4099 synth_3385 synth_4165 synth_4166 VDD VDD VNB|VSS
+ sky130_fd_sc_hd__edfxtp_1
X$14888 VNB|VSS synth_4280 synth_4422 synth_4506 synth_4166 VDD VDD VNB|VSS
+ sky130_fd_sc_hd__edfxtp_1
X$14889 VNB|VSS synth_7696 synth_6961 synth_7646 synth_7724 VDD VDD VNB|VSS
+ sky130_fd_sc_hd__edfxtp_1
X$14890 VNB|VSS synth_7779 synth_6961 synth_7695 synth_7724 VDD VDD VNB|VSS
+ sky130_fd_sc_hd__edfxtp_1
X$14891 VNB|VSS synth_1434 synth_1432 synth_1563 synth_1404 VDD VDD VNB|VSS
+ sky130_fd_sc_hd__edfxtp_1
X$14892 VNB|VSS synth_1977 synth_2080 synth_2150 synth_1820 VDD VDD VNB|VSS
+ sky130_fd_sc_hd__edfxtp_1
X$14893 VNB|VSS synth_2496 synth_2465 synth_2610 synth_2185 VDD VDD VNB|VSS
+ sky130_fd_sc_hd__edfxtp_1
X$14894 VNB|VSS synth_1816 synth_1518 synth_1889 synth_1681 VDD VDD VNB|VSS
+ sky130_fd_sc_hd__edfxtp_1
X$14895 VNB|VSS synth_4760 synth_3950 synth_88 synth_4460 VDD VDD VNB|VSS
+ sky130_fd_sc_hd__edfxtp_1
X$14896 VNB|VSS synth_1041 synth_276 synth_382 synth_1117 VDD VDD VNB|VSS
+ sky130_fd_sc_hd__edfxtp_1
X$14897 VNB|VSS synth_7408 synth_6950 synth_7558 synth_7258 VDD VDD VNB|VSS
+ sky130_fd_sc_hd__edfxtp_1
X$14898 VNB|VSS synth_7199 synth_6583 synth_4111 synth_7110 VDD VDD VNB|VSS
+ sky130_fd_sc_hd__edfxtp_1
X$14899 VNB|VSS synth_8007 synth_6583 synth_5329 synth_8006 VDD VDD VNB|VSS
+ sky130_fd_sc_hd__edfxtp_1
X$14900 VNB|VSS synth_2451 synth_2432 synth_478 synth_2300 VDD VDD VNB|VSS
+ sky130_fd_sc_hd__edfxtp_1
X$14901 VNB|VSS synth_2287 synth_2145 synth_1908 synth_2300 VDD VDD VNB|VSS
+ sky130_fd_sc_hd__edfxtp_1
X$14902 VNB|VSS synth_7706 synth_6583 synth_6198 synth_7730 VDD VDD VNB|VSS
+ sky130_fd_sc_hd__edfxtp_1
X$14903 VNB|VSS synth_9841 synth_9717 synth_6699 synth_9685 VDD VDD VNB|VSS
+ sky130_fd_sc_hd__edfxtp_1
X$14904 VNB|VSS synth_7845 synth_7576 synth_382 synth_7730 VDD VDD VNB|VSS
+ sky130_fd_sc_hd__edfxtp_1
X$14905 VNB|VSS synth_7580 synth_6939 synth_7636 synth_7410 VDD VDD VNB|VSS
+ sky130_fd_sc_hd__edfxtp_1
X$14906 VNB|VSS synth_4620 synth_4487 synth_4604 synth_4450 VDD VDD VNB|VSS
+ sky130_fd_sc_hd__edfxtp_1
X$14907 VNB|VSS synth_9364 synth_9717 synth_2777 synth_9685 VDD VDD VNB|VSS
+ sky130_fd_sc_hd__edfxtp_1
X$14908 VNB|VSS synth_4385 synth_3950 synth_2777 synth_4460 VDD VDD VNB|VSS
+ sky130_fd_sc_hd__edfxtp_1
X$14909 VNB|VSS synth_193 synth_61 synth_127 synth_18 VDD VDD VNB|VSS
+ sky130_fd_sc_hd__edfxtp_1
X$14910 VNB|VSS synth_7582 synth_6939 synth_7654 synth_7410 VDD VDD VNB|VSS
+ sky130_fd_sc_hd__edfxtp_1
X$14911 VNB|VSS synth_623 synth_36 synth_710 synth_14 VDD VDD VNB|VSS
+ sky130_fd_sc_hd__edfxtp_1
X$14912 VDD synth_961 synth_870 synth_994 synth_869 VDD VNB|VSS VNB|VSS
+ sky130_fd_sc_hd__mux2i_1
X$14913 VNB|VSS synth_7798 synth_6929 synth_7944 synth_7616 VDD VDD VNB|VSS
+ sky130_fd_sc_hd__edfxtp_1
X$14914 VNB|VSS synth_4335 synth_4461 synth_4382 synth_4297 VDD VDD VNB|VSS
+ sky130_fd_sc_hd__edfxtp_1
X$14915 VNB|VSS synth_4716 synth_4422 synth_4838 synth_4595 VDD VDD VNB|VSS
+ sky130_fd_sc_hd__edfxtp_1
X$14916 VNB|VSS synth_7994 synth_7534 synth_4467 synth_7993 VDD VDD VNB|VSS
+ sky130_fd_sc_hd__edfxtp_1
X$14917 VNB|VSS synth_8158 synth_7534 synth_1695 synth_7993 VDD VDD VNB|VSS
+ sky130_fd_sc_hd__edfxtp_1
X$14918 VNB|VSS synth_4332 synth_3284 synth_501 synth_3879 VDD VDD VNB|VSS
+ sky130_fd_sc_hd__edfxtp_1
X$14919 VNB|VSS synth_2207 synth_2205 synth_2456 synth_1973 VDD VDD VNB|VSS
+ sky130_fd_sc_hd__edfxtp_1
X$14920 VNB|VSS synth_7684 synth_6929 synth_7665 synth_7616 VDD VDD VNB|VSS
+ sky130_fd_sc_hd__edfxtp_1
X$14921 VDD synth_6452 VNB|VSS synth_7742 VDD VNB|VSS sky130_fd_sc_hd__clkbuf_4
X$14922 VNB|VSS synth_5470 synth_4836 synth_626 synth_5073 VDD VDD VNB|VSS
+ sky130_fd_sc_hd__edfxtp_1
X$14923 VNB|VSS synth_1802 synth_1727 synth_1850 synth_1638 VDD VDD VNB|VSS
+ sky130_fd_sc_hd__edfxtp_1
X$14924 VNB|VSS synth_2801 synth_2730 synth_2929 synth_2869 VDD VDD VNB|VSS
+ sky130_fd_sc_hd__edfxtp_1
X$14925 VNB|VSS synth_723 synth_61 synth_799 synth_655 VDD VDD VNB|VSS
+ sky130_fd_sc_hd__edfxtp_1
X$14926 VNB|VSS synth_4003 synth_3806 synth_501 synth_3761 VDD VDD VNB|VSS
+ sky130_fd_sc_hd__edfxtp_1
X$14927 VNB|VSS synth_613 synth_61 synth_654 synth_655 VDD VDD VNB|VSS
+ sky130_fd_sc_hd__edfxtp_1
X$14928 VNB|VSS synth_4503 synth_3462 synth_4502 synth_4442 VDD VDD VNB|VSS
+ sky130_fd_sc_hd__edfxtp_1
X$14929 VNB|VSS synth_486 synth_443 synth_183 synth_488 VDD VDD VNB|VSS
+ sky130_fd_sc_hd__edfxtp_1
X$14930 VNB|VSS synth_3826 synth_3703 synth_4159 synth_3764 VDD VDD VNB|VSS
+ sky130_fd_sc_hd__edfxtp_1
X$14931 VNB|VSS synth_7612 synth_6961 synth_7756 synth_7568 VDD VDD VNB|VSS
+ sky130_fd_sc_hd__edfxtp_1
X$14932 VNB|VSS synth_2935 synth_2179 synth_3052 synth_2894 VDD VDD VNB|VSS
+ sky130_fd_sc_hd__edfxtp_1
X$14933 VNB|VSS synth_3742 synth_3806 synth_478 synth_3761 VDD VDD VNB|VSS
+ sky130_fd_sc_hd__edfxtp_1
X$14934 VNB|VSS synth_342 synth_61 synth_548 synth_18 VDD VDD VNB|VSS
+ sky130_fd_sc_hd__edfxtp_1
X$14935 VDD synth_602 synth_487 synth_194 synth_489 VNB|VSS synth_548 VDD
+ VNB|VSS sky130_fd_sc_hd__a2bb2oi_1
X$14936 VNB|VSS synth_1824 synth_2080 synth_1767 synth_1820 VDD VDD VNB|VSS
+ sky130_fd_sc_hd__edfxtp_1
X$14937 VNB|VSS synth_9304 synth_8533 synth_9491 synth_9164 VDD VDD VNB|VSS
+ sky130_fd_sc_hd__edfxtp_1
X$14938 VNB|VSS synth_2060 synth_2205 synth_2160 synth_1973 VDD VDD VNB|VSS
+ sky130_fd_sc_hd__edfxtp_1
X$14939 VNB|VSS synth_1183 synth_63 synth_1139 synth_1073 VDD VDD VNB|VSS
+ sky130_fd_sc_hd__edfxtp_1
X$14940 VNB|VSS synth_4837 synth_4836 synth_4111 synth_4732 VDD VDD VNB|VSS
+ sky130_fd_sc_hd__edfxtp_1
X$14941 VNB|VSS synth_64 synth_36 synth_117 synth_14 VDD VDD VNB|VSS
+ sky130_fd_sc_hd__edfxtp_1
X$14942 VNB|VSS synth_12428 synth_11840 synth_6699 synth_12162 VDD VDD VNB|VSS
+ sky130_fd_sc_hd__edfxtp_1
X$14943 VNB|VSS synth_4130 synth_3781 synth_88 synth_3782 VDD VDD VNB|VSS
+ sky130_fd_sc_hd__edfxtp_1
X$14944 VNB|VSS synth_10069 synth_9912 synth_6699 synth_9840 VDD VDD VNB|VSS
+ sky130_fd_sc_hd__edfxtp_1
X$14945 VNB|VSS synth_2098 synth_1727 synth_2023 synth_1804 VDD VDD VNB|VSS
+ sky130_fd_sc_hd__edfxtp_1
X$14946 VNB|VSS synth_595 synth_48 synth_183 synth_511 VDD VDD VNB|VSS
+ sky130_fd_sc_hd__edfxtp_1
X$14947 VNB|VSS synth_3883 synth_3318 synth_3913 synth_3914 VDD VDD VNB|VSS
+ sky130_fd_sc_hd__edfxtp_1
X$14948 VNB|VSS synth_2338 synth_2268 synth_2458 synth_2318 VDD VDD VNB|VSS
+ sky130_fd_sc_hd__edfxtp_1
X$14949 VNB|VSS synth_675 synth_63 synth_798 synth_565 VDD VDD VNB|VSS
+ sky130_fd_sc_hd__edfxtp_1
X$14950 VNB|VSS synth_7295 synth_7190 synth_2860 synth_7293 VDD VDD VNB|VSS
+ sky130_fd_sc_hd__edfxtp_1
X$14951 VNB|VSS synth_1800 synth_1265 synth_382 synth_1956 VDD VDD VNB|VSS
+ sky130_fd_sc_hd__edfxtp_1
X$14952 VNB|VSS synth_1809 synth_1727 synth_1855 synth_1804 VDD VDD VNB|VSS
+ sky130_fd_sc_hd__edfxtp_1
X$14953 VNB|VSS synth_6126 synth_4836 synth_4588 synth_6150 VDD VDD VNB|VSS
+ sky130_fd_sc_hd__edfxtp_1
X$14954 VNB|VSS synth_7261 synth_7576 synth_5329 synth_7577 VDD VDD VNB|VSS
+ sky130_fd_sc_hd__edfxtp_1
X$14955 VNB|VSS synth_6799 synth_6794 synth_6198 synth_6964 VDD VDD VNB|VSS
+ sky130_fd_sc_hd__edfxtp_1
X$14956 VNB|VSS synth_890 synth_276 synth_382 synth_751 VDD VDD VNB|VSS
+ sky130_fd_sc_hd__edfxtp_1
X$14957 VNB|VSS synth_8514 synth_7826 synth_8512 synth_8356 VDD VDD VNB|VSS
+ sky130_fd_sc_hd__edfxtp_1
X$14958 VNB|VSS synth_7329 synth_6950 synth_7468 synth_7258 VDD VDD VNB|VSS
+ sky130_fd_sc_hd__edfxtp_1
X$14959 VNB|VSS synth_7369 synth_7190 synth_5329 synth_7293 VDD VDD VNB|VSS
+ sky130_fd_sc_hd__edfxtp_1
X$14960 VNB|VSS synth_1854 synth_1265 synth_501 synth_1639 VDD VDD VNB|VSS
+ sky130_fd_sc_hd__edfxtp_1
X$14961 VNB|VSS synth_1075 synth_439 synth_501 synth_1074 VDD VDD VNB|VSS
+ sky130_fd_sc_hd__edfxtp_1
X$14962 VNB|VSS synth_1625 synth_1833 synth_1756 synth_1383 VDD VDD VNB|VSS
+ sky130_fd_sc_hd__edfxtp_1
X$14963 VNB|VSS synth_6895 synth_6794 synth_5329 synth_6964 VDD VDD VNB|VSS
+ sky130_fd_sc_hd__edfxtp_1
X$14964 VNB|VSS synth_3884 synth_3318 synth_4006 synth_3914 VDD VDD VNB|VSS
+ sky130_fd_sc_hd__edfxtp_1
X$14965 VNB|VSS synth_7209 synth_6929 synth_7448 synth_6976 VDD VDD VNB|VSS
+ sky130_fd_sc_hd__edfxtp_1
X$14966 VNB|VSS synth_2194 synth_2193 synth_1908 synth_2269 VDD VDD VNB|VSS
+ sky130_fd_sc_hd__edfxtp_1
X$14967 VNB|VSS synth_2115 synth_2044 synth_501 synth_1956 VDD VDD VNB|VSS
+ sky130_fd_sc_hd__edfxtp_1
X$14968 VNB|VSS synth_8706 synth_7826 synth_8545 synth_8356 VDD VDD VNB|VSS
+ sky130_fd_sc_hd__edfxtp_1
X$14969 VNB|VSS synth_6529 synth_6237 synth_3656 synth_6150 VDD VDD VNB|VSS
+ sky130_fd_sc_hd__edfxtp_1
X$14970 VNB|VSS synth_794 synth_48 synth_37 synth_511 VDD VDD VNB|VSS
+ sky130_fd_sc_hd__edfxtp_1
X$14971 VNB|VSS synth_7026 synth_6950 synth_7084 synth_6781 VDD VDD VNB|VSS
+ sky130_fd_sc_hd__edfxtp_1
X$14972 VNB|VSS synth_8457 synth_8380 synth_8500 synth_8348 VDD VDD VNB|VSS
+ sky130_fd_sc_hd__edfxtp_1
X$14973 VNB|VSS synth_3362 synth_3318 synth_3486 synth_3285 VDD VDD VNB|VSS
+ sky130_fd_sc_hd__edfxtp_1
X$14974 VNB|VSS synth_7419 synth_6927 synth_7443 synth_7445 VDD VDD VNB|VSS
+ sky130_fd_sc_hd__edfxtp_1
X$14975 VNB|VSS synth_417 synth_48 synth_258 synth_15 VDD VDD VNB|VSS
+ sky130_fd_sc_hd__edfxtp_1
X$14976 VNB|VSS synth_1107 synth_578 synth_478 synth_774 VDD VDD VNB|VSS
+ sky130_fd_sc_hd__edfxtp_1
X$14977 VNB|VSS synth_9814 synth_9811 synth_9888 synth_9842 VDD VDD VNB|VSS
+ sky130_fd_sc_hd__edfxtp_1
X$14978 VNB|VSS synth_8674 synth_7534 synth_1695 synth_8507 VDD VDD VNB|VSS
+ sky130_fd_sc_hd__edfxtp_1
X$14979 VNB|VSS synth_7172 synth_6950 synth_7085 synth_6605 VDD VDD VNB|VSS
+ sky130_fd_sc_hd__edfxtp_1
X$14980 VNB|VSS synth_8671 synth_7534 synth_6198 synth_8352 VDD VDD VNB|VSS
+ sky130_fd_sc_hd__edfxtp_1
X$14981 VNB|VSS synth_4428 synth_4299 synth_88 synth_4254 VDD VDD VNB|VSS
+ sky130_fd_sc_hd__edfxtp_1
X$14982 VNB|VSS synth_12161 synth_11527 synth_12254 synth_11800 VDD VDD VNB|VSS
+ sky130_fd_sc_hd__edfxtp_1
X$14983 VNB|VSS synth_8471 synth_8082 synth_8686 synth_8386 VDD VDD VNB|VSS
+ sky130_fd_sc_hd__edfxtp_1
X$14984 VNB|VSS synth_188 synth_48 synth_88 synth_15 VDD VDD VNB|VSS
+ sky130_fd_sc_hd__edfxtp_1
X$14985 VNB|VSS synth_836 synth_578 synth_183 synth_774 VDD VDD VNB|VSS
+ sky130_fd_sc_hd__edfxtp_1
X$14986 VNB|VSS synth_4124 synth_3950 synth_37 synth_3846 VDD VDD VNB|VSS
+ sky130_fd_sc_hd__edfxtp_1
X$14987 VNB|VSS synth_8535 synth_8659 synth_4467 synth_8346 VDD VDD VNB|VSS
+ sky130_fd_sc_hd__edfxtp_1
X$14988 VNB|VSS synth_252 synth_48 synth_183 synth_15 VDD VDD VNB|VSS
+ sky130_fd_sc_hd__edfxtp_1
X$14989 VNB|VSS synth_6350 synth_6237 synth_626 synth_6150 VDD VDD VNB|VSS
+ sky130_fd_sc_hd__edfxtp_1
X$14990 VNB|VSS synth_5655 synth_5478 synth_5723 synth_5611 VDD VDD VNB|VSS
+ sky130_fd_sc_hd__edfxtp_1
X$14991 VNB|VSS synth_4719 synth_4461 synth_4858 synth_4297 VDD VDD VNB|VSS
+ sky130_fd_sc_hd__edfxtp_1
X$14992 VNB|VSS synth_3919 synth_3781 synth_1695 synth_3782 VDD VDD VNB|VSS
+ sky130_fd_sc_hd__edfxtp_1
X$14993 VNB|VSS synth_1199 synth_521 synth_1381 synth_1197 VDD VDD VNB|VSS
+ sky130_fd_sc_hd__edfxtp_1
X$14994 VNB|VSS synth_7728 synth_6950 synth_7765 synth_7729 VDD VDD VNB|VSS
+ sky130_fd_sc_hd__edfxtp_1
X$14995 VNB|VSS synth_3664 synth_3478 synth_3720 synth_3479 VDD VDD VNB|VSS
+ sky130_fd_sc_hd__edfxtp_1
X$14996 VNB|VSS synth_8506 synth_7534 synth_1695 synth_8352 VDD VDD VNB|VSS
+ sky130_fd_sc_hd__edfxtp_1
X$14997 VNB|VSS synth_3709 synth_3413 synth_3651 synth_3650 VDD VDD VNB|VSS
+ sky130_fd_sc_hd__edfxtp_1
X$14998 VNB|VSS synth_1940 synth_1810 synth_1939 synth_1359 VDD VDD VNB|VSS
+ sky130_fd_sc_hd__edfxtp_1
X$14999 VNB|VSS synth_4278 synth_3284 synth_1908 synth_3879 VDD VDD VNB|VSS
+ sky130_fd_sc_hd__edfxtp_1
X$15000 VNB|VSS synth_2290 synth_1906 synth_2503 synth_2133 VDD VDD VNB|VSS
+ sky130_fd_sc_hd__edfxtp_1
X$15001 VNB|VSS synth_1587 synth_1518 synth_1646 synth_1681 VDD VDD VNB|VSS
+ sky130_fd_sc_hd__edfxtp_1
X$15002 VNB|VSS synth_2433 synth_2432 synth_966 synth_2300 VDD VDD VNB|VSS
+ sky130_fd_sc_hd__edfxtp_1
X$15003 VNB|VSS synth_2601 synth_2320 synth_37 synth_2599 VDD VDD VNB|VSS
+ sky130_fd_sc_hd__edfxtp_1
X$15004 VNB|VSS synth_2483 synth_2201 synth_966 synth_2162 VDD VDD VNB|VSS
+ sky130_fd_sc_hd__edfxtp_1
X$15005 VNB|VSS synth_2749 synth_2077 synth_1337 synth_2715 VDD VDD VNB|VSS
+ sky130_fd_sc_hd__edfxtp_1
X$15006 VNB|VSS synth_1645 synth_1518 synth_1849 synth_1681 VDD VDD VNB|VSS
+ sky130_fd_sc_hd__edfxtp_1
X$15007 VNB|VSS synth_10303 synth_10081 synth_10547 synth_10082 VDD VDD VNB|VSS
+ sky130_fd_sc_hd__edfxtp_1
X$15008 VNB|VSS synth_4242 synth_3820 synth_4155 synth_3958 VDD VDD VNB|VSS
+ sky130_fd_sc_hd__edfxtp_1
X$15009 VNB|VSS synth_2086 synth_1518 synth_2061 synth_1973 VDD VDD VNB|VSS
+ sky130_fd_sc_hd__edfxtp_1
X$15010 VNB|VSS synth_3358 synth_3462 synth_3525 synth_3172 VDD VDD VNB|VSS
+ sky130_fd_sc_hd__edfxtp_1
X$15011 VNB|VSS synth_12429 synth_11840 synth_6564 synth_12162 VDD VDD VNB|VSS
+ sky130_fd_sc_hd__edfxtp_1
X$15012 VNB|VSS synth_11526 synth_11489 synth_11700 synth_11264 VDD VDD VNB|VSS
+ sky130_fd_sc_hd__edfxtp_1
X$15013 VNB|VSS synth_12379 synth_11961 synth_6564 synth_12294 VDD VDD VNB|VSS
+ sky130_fd_sc_hd__edfxtp_1
X$15014 VNB|VSS synth_3129 synth_2465 synth_3056 synth_3055 VDD VDD VNB|VSS
+ sky130_fd_sc_hd__edfxtp_1
X$15015 VNB|VSS synth_11576 synth_11536 synth_6198 synth_11380 VDD VDD VNB|VSS
+ sky130_fd_sc_hd__edfxtp_1
X$15016 VNB|VSS synth_2897 synth_2077 synth_88 synth_2715 VDD VDD VNB|VSS
+ sky130_fd_sc_hd__edfxtp_1
X$15017 VNB|VSS synth_4528 synth_3462 synth_4443 synth_4442 VDD VDD VNB|VSS
+ sky130_fd_sc_hd__edfxtp_1
X$15018 VNB|VSS synth_2955 synth_2205 synth_2875 synth_2874 VDD VDD VNB|VSS
+ sky130_fd_sc_hd__edfxtp_1
X$15019 VNB|VSS synth_2071 synth_1576 synth_37 synth_1981 VDD VDD VNB|VSS
+ sky130_fd_sc_hd__edfxtp_1
X$15020 VNB|VSS synth_5055 synth_4299 synth_2777 synth_4953 VDD VDD VNB|VSS
+ sky130_fd_sc_hd__edfxtp_1
X$15021 VNB|VSS synth_4684 synth_3413 synth_4611 synth_4610 VDD VDD VNB|VSS
+ sky130_fd_sc_hd__edfxtp_1
X$15022 VNB|VSS synth_1832 synth_1898 synth_1834 synth_1660 VDD VDD VNB|VSS
+ sky130_fd_sc_hd__edfxtp_1
X$15023 VNB|VSS synth_3256 synth_3413 synth_3320 synth_3185 VDD VDD VNB|VSS
+ sky130_fd_sc_hd__edfxtp_1
X$15024 VNB|VSS synth_2806 synth_3122 synth_2988 synth_2595 VDD VDD VNB|VSS
+ sky130_fd_sc_hd__edfxtp_1
X$15025 VNB|VSS synth_2663 synth_1906 synth_2678 synth_2595 VDD VDD VNB|VSS
+ sky130_fd_sc_hd__edfxtp_1
X$15026 VNB|VSS synth_12369 synth_11917 synth_12502 synth_12318 VDD VDD VNB|VSS
+ sky130_fd_sc_hd__edfxtp_1
X$15027 VNB|VSS synth_2359 synth_2145 synth_1908 synth_2132 VDD VDD VNB|VSS
+ sky130_fd_sc_hd__edfxtp_1
X$15028 VNB|VSS synth_10143 synth_9760 synth_9994 synth_10082 VDD VDD VNB|VSS
+ sky130_fd_sc_hd__edfxtp_1
X$15029 VNB|VSS synth_10145 synth_10047 synth_6198 synth_9995 VDD VDD VNB|VSS
+ sky130_fd_sc_hd__edfxtp_1
X$15030 VNB|VSS synth_3364 synth_3318 synth_3319 synth_3285 VDD VDD VNB|VSS
+ sky130_fd_sc_hd__edfxtp_1
X$15031 VNB|VSS synth_1574 synth_1576 synth_387 synth_1534 VDD VDD VNB|VSS
+ sky130_fd_sc_hd__edfxtp_1
X$15032 VNB|VSS synth_1703 synth_1872 synth_1764 synth_1336 VDD VDD VNB|VSS
+ sky130_fd_sc_hd__edfxtp_1
X$15033 VNB|VSS synth_1613 synth_439 synth_1181 synth_1414 VDD VDD VNB|VSS
+ sky130_fd_sc_hd__edfxtp_1
X$15034 VNB|VSS synth_1894 synth_1453 synth_1913 synth_1820 VDD VDD VNB|VSS
+ sky130_fd_sc_hd__edfxtp_1
X$15035 VNB|VSS synth_5878 synth_6059 synth_6010 synth_5833 VDD VDD VNB|VSS
+ sky130_fd_sc_hd__edfxtp_1
X$15036 VNB|VSS synth_2226 synth_2145 synth_626 synth_2132 VDD VDD VNB|VSS
+ sky130_fd_sc_hd__edfxtp_1
X$15037 VNB|VSS synth_4612 synth_3950 synth_1695 synth_4460 VDD VDD VNB|VSS
+ sky130_fd_sc_hd__edfxtp_1
X$15038 VNB|VSS synth_2176 synth_1576 synth_1695 synth_1981 VDD VDD VNB|VSS
+ sky130_fd_sc_hd__edfxtp_1
X$15039 VNB|VSS synth_2882 synth_2432 synth_966 synth_2756 VDD VDD VNB|VSS
+ sky130_fd_sc_hd__edfxtp_1
X$15040 VNB|VSS synth_2103 synth_2320 synth_387 synth_1981 VDD VDD VNB|VSS
+ sky130_fd_sc_hd__edfxtp_1
X$15041 VNB|VSS synth_3149 synth_2800 synth_478 synth_2871 VDD VDD VNB|VSS
+ sky130_fd_sc_hd__edfxtp_1
X$15042 VNB|VSS synth_2772 synth_2201 synth_449 synth_2520 VDD VDD VNB|VSS
+ sky130_fd_sc_hd__edfxtp_1
X$15043 VNB|VSS synth_2805 synth_2432 synth_478 synth_2756 VDD VDD VNB|VSS
+ sky130_fd_sc_hd__edfxtp_1
X$15044 VNB|VSS synth_4007 synth_3950 synth_2777 synth_3846 VDD VDD VNB|VSS
+ sky130_fd_sc_hd__edfxtp_1
X$15045 VNB|VSS synth_2356 synth_1453 synth_2298 synth_2235 VDD VDD VNB|VSS
+ sky130_fd_sc_hd__edfxtp_1
X$15046 VNB|VSS synth_3910 synth_3413 synth_3909 synth_3650 VDD VDD VNB|VSS
+ sky130_fd_sc_hd__edfxtp_1
X$15047 VNB|VSS synth_2514 synth_2208 synth_478 synth_2515 VDD VDD VNB|VSS
+ sky130_fd_sc_hd__edfxtp_1
X$15048 VNB|VSS synth_2486 synth_3122 synth_2611 synth_2235 VDD VDD VNB|VSS
+ sky130_fd_sc_hd__edfxtp_1
X$15049 VNB|VSS synth_4768 synth_4541 synth_626 synth_4752 VDD VDD VNB|VSS
+ sky130_fd_sc_hd__edfxtp_1
X$15050 VNB|VSS synth_2687 synth_2208 synth_966 synth_2515 VDD VDD VNB|VSS
+ sky130_fd_sc_hd__edfxtp_1
X$15051 VNB|VSS synth_2838 synth_2208 synth_449 synth_2515 VDD VDD VNB|VSS
+ sky130_fd_sc_hd__edfxtp_1
X$15052 VNB|VSS synth_12031 synth_11719 synth_11974 synth_11927 VDD VDD VNB|VSS
+ sky130_fd_sc_hd__edfxtp_1
X$15053 VNB|VSS synth_4756 synth_4293 synth_4860 synth_4610 VDD VDD VNB|VSS
+ sky130_fd_sc_hd__edfxtp_1
X$15054 VNB|VSS synth_12370 synth_12036 synth_6564 synth_12291 VDD VDD VNB|VSS
+ sky130_fd_sc_hd__edfxtp_1
X$15055 VNB|VSS synth_1656 synth_1453 synth_1597 synth_1377 VDD VDD VNB|VSS
+ sky130_fd_sc_hd__edfxtp_1
X$15056 VNB|VSS synth_12463 synth_11379 synth_6564 synth_12228 VDD VDD VNB|VSS
+ sky130_fd_sc_hd__edfxtp_1
X$15057 VNB|VSS synth_3057 synth_2468 synth_37 synth_3022 VDD VDD VNB|VSS
+ sky130_fd_sc_hd__edfxtp_1
X$15058 VNB|VSS synth_11983 synth_11527 synth_11918 synth_11800 VDD VDD VNB|VSS
+ sky130_fd_sc_hd__edfxtp_1
X$15059 VNB|VSS synth_4589 synth_3820 synth_4590 synth_3958 VDD VDD VNB|VSS
+ sky130_fd_sc_hd__edfxtp_1
X$15060 VNB|VSS synth_5283 synth_5172 synth_5179 synth_5277 VDD VDD VNB|VSS
+ sky130_fd_sc_hd__edfxtp_1
X$15061 VNB|VSS synth_2607 synth_2320 synth_37 synth_2439 VDD VDD VNB|VSS
+ sky130_fd_sc_hd__edfxtp_1
X$15062 VNB|VSS synth_11609 synth_11294 synth_6699 synth_11442 VDD VDD VNB|VSS
+ sky130_fd_sc_hd__edfxtp_1
X$15063 VNB|VSS synth_5128 synth_5089 synth_5241 synth_5029 VDD VDD VNB|VSS
+ sky130_fd_sc_hd__edfxtp_1
X$15064 VNB|VSS synth_3024 synth_1872 synth_3060 synth_3061 VDD VDD VNB|VSS
+ sky130_fd_sc_hd__edfxtp_1
X$15065 VNB|VSS synth_4770 synth_4461 synth_4769 synth_4617 VDD VDD VNB|VSS
+ sky130_fd_sc_hd__edfxtp_1
X$15066 VNB|VSS synth_5657 synth_4999 synth_1695 synth_5432 VDD VDD VNB|VSS
+ sky130_fd_sc_hd__edfxtp_1
X$15067 VNB|VSS synth_11879 synth_11294 synth_6987 synth_11761 VDD VDD VNB|VSS
+ sky130_fd_sc_hd__edfxtp_1
X$15068 VNB|VSS synth_3438 synth_3169 synth_1908 synth_3214 VDD VDD VNB|VSS
+ sky130_fd_sc_hd__edfxtp_1
X$15069 VNB|VSS synth_12393 synth_11379 synth_6198 synth_12228 VDD VDD VNB|VSS
+ sky130_fd_sc_hd__edfxtp_1
X$15070 VNB|VSS synth_4075 synth_3820 synth_3959 synth_3958 VDD VDD VNB|VSS
+ sky130_fd_sc_hd__edfxtp_1
X$15071 VNB|VSS synth_3417 synth_3247 synth_966 synth_3184 VDD VDD VNB|VSS
+ sky130_fd_sc_hd__edfxtp_1
X$15072 VNB|VSS synth_5180 synth_4999 synth_88 synth_4950 VDD VDD VNB|VSS
+ sky130_fd_sc_hd__edfxtp_1
X$15073 VNB|VSS synth_4903 synth_4999 synth_2860 synth_4950 VDD VDD VNB|VSS
+ sky130_fd_sc_hd__edfxtp_1
X$15074 VNB|VSS synth_2446 synth_1872 synth_2375 synth_2378 VDD VDD VNB|VSS
+ sky130_fd_sc_hd__edfxtp_1
X$15075 VNB|VSS synth_2509 synth_2330 synth_2508 synth_2450 VDD VDD VNB|VSS
+ sky130_fd_sc_hd__edfxtp_1
X$15076 VNB|VSS synth_5598 synth_4999 synth_2777 synth_5432 VDD VDD VNB|VSS
+ sky130_fd_sc_hd__edfxtp_1
X$15077 VNB|VSS synth_6308 synth_5515 synth_6396 synth_6312 VDD VDD VNB|VSS
+ sky130_fd_sc_hd__edfxtp_1
X$15078 VNB|VSS synth_923 synth_578 synth_258 synth_774 VDD VDD VNB|VSS
+ sky130_fd_sc_hd__edfxtp_1
X$15079 VNB|VSS synth_2328 synth_2468 synth_183 synth_2505 VDD VDD VNB|VSS
+ sky130_fd_sc_hd__edfxtp_1
X$15080 VNB|VSS synth_12257 synth_11840 synth_8337 synth_12162 VDD VDD VNB|VSS
+ sky130_fd_sc_hd__edfxtp_1
X$15081 VNB|VSS synth_4470 synth_4299 synth_4467 synth_4254 VDD VDD VNB|VSS
+ sky130_fd_sc_hd__edfxtp_1
X$15082 VNB|VSS synth_12723 synth_12299 synth_12562 synth_12761 VDD VDD VNB|VSS
+ sky130_fd_sc_hd__edfxtp_1
X$15083 VNB|VSS synth_5362 synth_4461 synth_5436 synth_5395 VDD VDD VNB|VSS
+ sky130_fd_sc_hd__edfxtp_1
X$15084 VNB|VSS synth_11653 synth_11294 synth_8337 synth_11442 VDD VDD VNB|VSS
+ sky130_fd_sc_hd__edfxtp_1
X$15085 VNB|VSS synth_3016 synth_2800 synth_449 synth_2871 VDD VDD VNB|VSS
+ sky130_fd_sc_hd__edfxtp_1
X$15086 VNB|VSS synth_1455 synth_450 synth_1392 synth_1377 VDD VDD VNB|VSS
+ sky130_fd_sc_hd__edfxtp_1
X$15087 VNB|VSS synth_4209 synth_3413 synth_4121 synth_4123 VDD VDD VNB|VSS
+ sky130_fd_sc_hd__edfxtp_1
X$15088 VNB|VSS synth_2685 synth_2468 synth_88 synth_2505 VDD VDD VNB|VSS
+ sky130_fd_sc_hd__edfxtp_1
X$15089 VNB|VSS synth_1497 synth_1011 synth_88 synth_1534 VDD VDD VNB|VSS
+ sky130_fd_sc_hd__edfxtp_1
X$15090 VNB|VSS synth_6167 synth_5447 synth_6168 synth_6164 VDD VDD VNB|VSS
+ sky130_fd_sc_hd__edfxtp_1
X$15091 VNB|VSS synth_4337 synth_4299 synth_2777 synth_4254 VDD VDD VNB|VSS
+ sky130_fd_sc_hd__edfxtp_1
X$15092 VNB|VSS synth_5549 synth_5089 synth_5574 synth_5395 VDD VDD VNB|VSS
+ sky130_fd_sc_hd__edfxtp_1
X$15093 VNB|VSS synth_3811 synth_3284 synth_382 synth_3879 VDD VDD VNB|VSS
+ sky130_fd_sc_hd__edfxtp_1
X$15094 VNB|VSS synth_2826 synth_2468 synth_37 synth_2505 VDD VDD VNB|VSS
+ sky130_fd_sc_hd__edfxtp_1
X$15095 VNB|VSS synth_4415 synth_3557 synth_1181 synth_4272 VDD VDD VNB|VSS
+ sky130_fd_sc_hd__edfxtp_1
X$15096 VNB|VSS synth_2908 synth_2330 synth_3064 synth_2719 VDD VDD VNB|VSS
+ sky130_fd_sc_hd__edfxtp_1
X$15097 VNB|VSS synth_10347 synth_9760 synth_10345 synth_10277 VDD VDD VNB|VSS
+ sky130_fd_sc_hd__edfxtp_1
X$15098 VNB|VSS synth_692 synth_235 synth_501 synth_494 VDD VDD VNB|VSS
+ sky130_fd_sc_hd__edfxtp_1
X$15099 VNB|VSS synth_11843 synth_11527 synth_11883 synth_11800 VDD VDD VNB|VSS
+ sky130_fd_sc_hd__edfxtp_1
X$15100 VNB|VSS synth_12286 synth_12036 synth_8337 synth_12222 VDD VDD VNB|VSS
+ sky130_fd_sc_hd__edfxtp_1
X$15101 VNB|VSS synth_2229 synth_2077 synth_37 synth_1988 VDD VDD VNB|VSS
+ sky130_fd_sc_hd__edfxtp_1
X$15102 VNB|VSS synth_12372 synth_11840 synth_6987 synth_12162 VDD VDD VNB|VSS
+ sky130_fd_sc_hd__edfxtp_1
X$15103 VNB|VSS synth_12449 synth_12299 synth_12447 synth_12448 VDD VDD VNB|VSS
+ sky130_fd_sc_hd__edfxtp_1
X$15104 VNB|VSS synth_2323 synth_2465 synth_2297 synth_2185 VDD VDD VNB|VSS
+ sky130_fd_sc_hd__edfxtp_1
X$15105 VNB|VSS synth_2416 synth_2465 synth_2500 synth_2378 VDD VDD VNB|VSS
+ sky130_fd_sc_hd__edfxtp_1
X$15106 VNB|VSS synth_4336 synth_3318 synth_4383 synth_4297 VDD VDD VNB|VSS
+ sky130_fd_sc_hd__edfxtp_1
X$15107 VNB|VSS synth_11584 synth_11489 synth_11656 synth_11363 VDD VDD VNB|VSS
+ sky130_fd_sc_hd__edfxtp_1
X$15108 VNB|VSS synth_11641 synth_11719 synth_11904 synth_11672 VDD VDD VNB|VSS
+ sky130_fd_sc_hd__edfxtp_1
X$15109 VNB|VSS synth_4647 synth_4461 synth_4686 synth_4297 VDD VDD VNB|VSS
+ sky130_fd_sc_hd__edfxtp_1
X$15110 VNB|VSS synth_4708 synth_4657 synth_449 synth_4732 VDD VDD VNB|VSS
+ sky130_fd_sc_hd__edfxtp_1
X$15111 VNB|VSS synth_12048 synth_11536 synth_6198 synth_12047 VDD VDD VNB|VSS
+ sky130_fd_sc_hd__edfxtp_1
X$15112 VNB|VSS synth_1750 synth_1898 synth_1753 synth_1660 VDD VDD VNB|VSS
+ sky130_fd_sc_hd__edfxtp_1
X$15113 VNB|VSS synth_6006 synth_5172 synth_6093 synth_6090 VDD VDD VNB|VSS
+ sky130_fd_sc_hd__edfxtp_1
X$15114 VNB|VSS synth_2682 synth_2804 synth_1908 synth_2684 VDD VDD VNB|VSS
+ sky130_fd_sc_hd__edfxtp_1
X$15115 VNB|VSS synth_6492 synth_6459 synth_3656 synth_6460 VDD VDD VNB|VSS
+ sky130_fd_sc_hd__edfxtp_1
X$15116 VNB|VSS synth_2977 synth_2179 synth_2976 synth_2894 VDD VDD VNB|VSS
+ sky130_fd_sc_hd__edfxtp_1
X$15117 VNB|VSS synth_551 synth_235 synth_88 synth_494 VDD VDD VNB|VSS
+ sky130_fd_sc_hd__edfxtp_1
X$15118 VNB|VSS synth_11745 synth_11719 synth_11720 synth_11672 VDD VDD VNB|VSS
+ sky130_fd_sc_hd__edfxtp_1
X$15119 VNB|VSS synth_3697 synth_3820 synth_3739 synth_3755 VDD VDD VNB|VSS
+ sky130_fd_sc_hd__edfxtp_1
X$15120 VNB|VSS synth_5759 synth_5515 synth_5935 synth_5445 VDD VDD VNB|VSS
+ sky130_fd_sc_hd__edfxtp_1
X$15121 VNB|VSS synth_2522 synth_1437 synth_478 synth_2523 VDD VDD VNB|VSS
+ sky130_fd_sc_hd__edfxtp_1
X$15122 VNB|VSS synth_3050 synth_2320 synth_1695 synth_3017 VDD VDD VNB|VSS
+ sky130_fd_sc_hd__edfxtp_1
X$15123 VNB|VSS synth_5520 synth_4999 synth_2860 synth_5432 VDD VDD VNB|VSS
+ sky130_fd_sc_hd__edfxtp_1
X$15124 VNB|VSS synth_12476 synth_12036 synth_6699 synth_12222 VDD VDD VNB|VSS
+ sky130_fd_sc_hd__edfxtp_1
X$15125 VNB|VSS synth_11211 synth_10081 synth_11209 synth_11127 VDD VDD VNB|VSS
+ sky130_fd_sc_hd__edfxtp_1
X$15126 VNB|VSS synth_1014 synth_1011 synth_387 synth_892 VDD VDD VNB|VSS
+ sky130_fd_sc_hd__edfxtp_1
X$15127 VNB|VSS synth_2717 synth_2465 synth_2821 synth_2822 VDD VDD VNB|VSS
+ sky130_fd_sc_hd__edfxtp_1
X$15128 VNB|VSS synth_4126 synth_3247 synth_966 synth_4120 VDD VDD VNB|VSS
+ sky130_fd_sc_hd__edfxtp_1
X$15129 VNB|VSS synth_1057 synth_1011 synth_37 synth_892 VDD VDD VNB|VSS
+ sky130_fd_sc_hd__edfxtp_1
X$15130 VNB|VSS synth_12070 synth_12036 synth_6564 synth_11880 VDD VDD VNB|VSS
+ sky130_fd_sc_hd__edfxtp_1
X$15131 VNB|VSS synth_12013 synth_12036 synth_6699 synth_11880 VDD VDD VNB|VSS
+ sky130_fd_sc_hd__edfxtp_1
X$15132 VNB|VSS synth_10086 synth_9760 synth_10144 synth_9917 VDD VDD VNB|VSS
+ sky130_fd_sc_hd__edfxtp_1
X$15133 VNB|VSS synth_2565 synth_2320 synth_1695 synth_2599 VDD VDD VNB|VSS
+ sky130_fd_sc_hd__edfxtp_1
X$15134 VNB|VSS synth_3978 synth_3318 synth_4125 synth_3914 VDD VDD VNB|VSS
+ sky130_fd_sc_hd__edfxtp_1
X$15135 VNB|VSS synth_2614 synth_2432 synth_966 synth_2684 VDD VDD VNB|VSS
+ sky130_fd_sc_hd__edfxtp_1
X$15136 VNB|VSS synth_3355 synth_3169 synth_478 synth_3170 VDD VDD VNB|VSS
+ sky130_fd_sc_hd__edfxtp_1
X$15137 VNB|VSS synth_4122 synth_3413 synth_4384 synth_4123 VDD VDD VNB|VSS
+ sky130_fd_sc_hd__edfxtp_1
X$15138 VNB|VSS synth_4206 synth_3247 synth_1908 synth_4120 VDD VDD VNB|VSS
+ sky130_fd_sc_hd__edfxtp_1
X$15139 VNB|VSS synth_12715 synth_11846 synth_12713 synth_12484 VDD VDD VNB|VSS
+ sky130_fd_sc_hd__edfxtp_1
X$15140 VNB|VSS synth_12075 synth_11840 synth_6699 synth_11885 VDD VDD VNB|VSS
+ sky130_fd_sc_hd__edfxtp_1
X$15141 VNB|VSS synth_4941 synth_4487 synth_4971 synth_4970 VDD VDD VNB|VSS
+ sky130_fd_sc_hd__edfxtp_1
X$15142 VNB|VSS synth_11920 synth_11840 synth_6564 synth_11885 VDD VDD VNB|VSS
+ sky130_fd_sc_hd__edfxtp_1
X$15143 VNB|VSS synth_6496 synth_6611 synth_3656 synth_6626 VDD VDD VNB|VSS
+ sky130_fd_sc_hd__edfxtp_1
X$15144 VNB|VSS synth_6482 synth_5515 synth_6572 synth_6312 VDD VDD VNB|VSS
+ sky130_fd_sc_hd__edfxtp_1
X$15145 VNB|VSS synth_3916 synth_3543 synth_3953 synth_3914 VDD VDD VNB|VSS
+ sky130_fd_sc_hd__edfxtp_1
X$15146 VNB|VSS synth_6009 synth_5172 synth_6012 synth_5516 VDD VDD VNB|VSS
+ sky130_fd_sc_hd__edfxtp_1
X$15147 VNB|VSS synth_12718 synth_12163 synth_12696 synth_12295 VDD VDD VNB|VSS
+ sky130_fd_sc_hd__edfxtp_1
X$15148 VNB|VSS synth_12485 synth_11961 synth_6699 synth_12294 VDD VDD VNB|VSS
+ sky130_fd_sc_hd__edfxtp_1
X$15149 VNB|VSS synth_5435 synth_4999 synth_2860 synth_5433 VDD VDD VNB|VSS
+ sky130_fd_sc_hd__edfxtp_1
X$15150 VNB|VSS synth_11856 synth_10910 synth_11836 synth_11804 VDD VDD VNB|VSS
+ sky130_fd_sc_hd__edfxtp_1
X$15151 VNB|VSS synth_11452 synth_10910 synth_11534 synth_11127 VDD VDD VNB|VSS
+ sky130_fd_sc_hd__edfxtp_1
X$15152 VNB|VSS synth_3450 synth_3318 synth_3487 synth_3285 VDD VDD VNB|VSS
+ sky130_fd_sc_hd__edfxtp_1
X$15153 VNB|VSS synth_2105 synth_1833 synth_2181 synth_1982 VDD VDD VNB|VSS
+ sky130_fd_sc_hd__edfxtp_1
X$15154 VNB|VSS synth_5735 synth_5531 synth_4467 synth_6022 VDD VDD VNB|VSS
+ sky130_fd_sc_hd__edfxtp_1
X$15155 VNB|VSS synth_12270 synth_11849 synth_6987 synth_12166 VDD VDD VNB|VSS
+ sky130_fd_sc_hd__edfxtp_1
X$15156 VNB|VSS synth_6052 synth_4836 synth_4111 synth_5815 VDD VDD VNB|VSS
+ sky130_fd_sc_hd__edfxtp_1
X$15157 VNB|VSS synth_6523 synth_6583 synth_626 synth_6301 VDD VDD VNB|VSS
+ sky130_fd_sc_hd__edfxtp_1
X$15158 VNB|VSS synth_8943 synth_8367 synth_8924 synth_8469 VDD VDD VNB|VSS
+ sky130_fd_sc_hd__edfxtp_1
X$15159 VNB|VSS synth_6333 synth_6241 synth_626 synth_6158 VDD VDD VNB|VSS
+ sky130_fd_sc_hd__edfxtp_1
X$15160 VNB|VSS synth_10051 synth_9896 synth_6198 synth_9897 VDD VDD VNB|VSS
+ sky130_fd_sc_hd__edfxtp_1
X$15161 VNB|VSS synth_2413 synth_2077 synth_1695 synth_2439 VDD VDD VNB|VSS
+ sky130_fd_sc_hd__edfxtp_1
X$15162 VNB|VSS synth_5006 synth_5057 synth_5095 synth_4617 VDD VDD VNB|VSS
+ sky130_fd_sc_hd__edfxtp_1
X$15163 VNB|VSS synth_5402 synth_5400 synth_1181 synth_5401 VDD VDD VNB|VSS
+ sky130_fd_sc_hd__edfxtp_1
X$15164 VNB|VSS synth_12271 synth_12202 synth_6564 synth_12086 VDD VDD VNB|VSS
+ sky130_fd_sc_hd__edfxtp_1
X$15165 VNB|VSS synth_10638 synth_10090 synth_10617 synth_10480 VDD VDD VNB|VSS
+ sky130_fd_sc_hd__edfxtp_1
X$15166 VNB|VSS synth_12226 synth_12024 synth_12204 synth_12205 VDD VDD VNB|VSS
+ sky130_fd_sc_hd__edfxtp_1
X$15167 VNB|VSS synth_6621 synth_5515 synth_6566 synth_6312 VDD VDD VNB|VSS
+ sky130_fd_sc_hd__edfxtp_1
X$15168 VNB|VSS synth_9970 synth_10047 synth_1695 synth_9995 VDD VDD VNB|VSS
+ sky130_fd_sc_hd__edfxtp_1
X$15169 VNB|VSS synth_3847 synth_3950 synth_1695 synth_3846 VDD VDD VNB|VSS
+ sky130_fd_sc_hd__edfxtp_1
X$15170 VNB|VSS synth_12760 synth_11846 synth_12789 synth_12508 VDD VDD VNB|VSS
+ sky130_fd_sc_hd__edfxtp_1
X$15171 VNB|VSS synth_6625 synth_6459 synth_626 synth_6460 VDD VDD VNB|VSS
+ sky130_fd_sc_hd__edfxtp_1
X$15172 VNB|VSS synth_10986 synth_10616 synth_11061 synth_10937 VDD VDD VNB|VSS
+ sky130_fd_sc_hd__edfxtp_1
X$15173 VNB|VSS synth_3652 synth_3221 synth_1695 synth_3416 VDD VDD VNB|VSS
+ sky130_fd_sc_hd__edfxtp_1
X$15174 VNB|VSS synth_10550 synth_10047 synth_1695 synth_10273 VDD VDD VNB|VSS
+ sky130_fd_sc_hd__edfxtp_1
X$15175 VNB|VSS synth_2621 synth_2201 synth_501 synth_2520 VDD VDD VNB|VSS
+ sky130_fd_sc_hd__edfxtp_1
X$15176 VNB|VSS synth_5002 synth_5089 synth_5122 synth_5029 VDD VDD VNB|VSS
+ sky130_fd_sc_hd__edfxtp_1
X$15177 VNB|VSS synth_10032 synth_9717 synth_6987 synth_9840 VDD VDD VNB|VSS
+ sky130_fd_sc_hd__edfxtp_1
X$15178 VNB|VSS synth_5826 synth_5715 synth_6028 synth_5569 VDD VDD VNB|VSS
+ sky130_fd_sc_hd__edfxtp_1
X$15179 VNB|VSS synth_10789 synth_10081 synth_10758 synth_10717 VDD VDD VNB|VSS
+ sky130_fd_sc_hd__edfxtp_1
X$15180 VNB|VSS synth_1384 synth_1149 synth_1460 synth_1383 VDD VDD VNB|VSS
+ sky130_fd_sc_hd__edfxtp_1
X$15181 VNB|VSS synth_5709 synth_5447 synth_5847 synth_5569 VDD VDD VNB|VSS
+ sky130_fd_sc_hd__edfxtp_1
X$15182 VNB|VSS synth_11435 synth_10090 synth_11433 synth_10937 VDD VDD VNB|VSS
+ sky130_fd_sc_hd__edfxtp_1
X$15183 VNB|VSS synth_3852 synth_3221 synth_2860 synth_3782 VDD VDD VNB|VSS
+ sky130_fd_sc_hd__edfxtp_1
X$15184 VNB|VSS synth_1700 synth_1576 synth_387 synth_1385 VDD VDD VNB|VSS
+ sky130_fd_sc_hd__edfxtp_1
X$15185 VNB|VSS synth_5396 synth_4999 synth_2777 synth_5433 VDD VDD VNB|VSS
+ sky130_fd_sc_hd__edfxtp_1
X$15186 VNB|VSS synth_2462 synth_2179 synth_2493 synth_2292 VDD VDD VNB|VSS
+ sky130_fd_sc_hd__edfxtp_1
X$15187 VNB|VSS synth_6089 synth_5515 synth_6258 synth_6090 VDD VDD VNB|VSS
+ sky130_fd_sc_hd__edfxtp_1
X$15188 VNB|VSS synth_5868 synth_4836 synth_626 synth_5815 VDD VDD VNB|VSS
+ sky130_fd_sc_hd__edfxtp_1
X$15189 VNB|VSS synth_6579 synth_5057 synth_6488 synth_6491 VDD VDD VNB|VSS
+ sky130_fd_sc_hd__edfxtp_1
X$15190 VNB|VSS synth_4514 synth_3781 synth_2777 synth_4479 VDD VDD VNB|VSS
+ sky130_fd_sc_hd__edfxtp_1
X$15191 VNB|VSS synth_6063 synth_5531 synth_2777 synth_6022 VDD VDD VNB|VSS
+ sky130_fd_sc_hd__edfxtp_1
X$15192 VNB|VSS synth_5762 synth_4999 synth_88 synth_5433 VDD VDD VNB|VSS
+ sky130_fd_sc_hd__edfxtp_1
X$15193 VNB|VSS synth_3655 synth_3318 synth_3581 synth_3285 VDD VDD VNB|VSS
+ sky130_fd_sc_hd__edfxtp_1
X$15194 VNB|VSS synth_3449 synth_3221 synth_37 synth_3416 VDD VDD VNB|VSS
+ sky130_fd_sc_hd__edfxtp_1
X$15195 VNB|VSS synth_2286 synth_2080 synth_2593 synth_2235 VDD VDD VNB|VSS
+ sky130_fd_sc_hd__edfxtp_1
X$15196 VNB|VSS synth_6245 synth_5159 synth_6328 synth_5990 VDD VDD VNB|VSS
+ sky130_fd_sc_hd__edfxtp_1
X$15197 VNB|VSS synth_1941 synth_1833 synth_2073 synth_1982 VDD VDD VNB|VSS
+ sky130_fd_sc_hd__edfxtp_1
X$15198 VNB|VSS synth_2104 synth_2179 synth_2143 synth_1982 VDD VDD VNB|VSS
+ sky130_fd_sc_hd__edfxtp_1
X$15199 VNB|VSS synth_5201 synth_4651 synth_2777 synth_5290 VDD VDD VNB|VSS
+ sky130_fd_sc_hd__edfxtp_1
X$15200 VNB|VSS synth_3164 synth_2468 synth_88 synth_3022 VDD VDD VNB|VSS
+ sky130_fd_sc_hd__edfxtp_1
X$15201 VNB|VSS synth_11805 synth_11851 synth_11803 synth_11804 VDD VDD VNB|VSS
+ sky130_fd_sc_hd__edfxtp_1
X$15202 VNB|VSS synth_858 synth_578 synth_626 synth_774 VDD VDD VNB|VSS
+ sky130_fd_sc_hd__edfxtp_1
X$15203 VNB|VSS synth_11266 synth_10804 synth_11263 synth_11264 VDD VDD VNB|VSS
+ sky130_fd_sc_hd__edfxtp_1
X$15204 VNB|VSS synth_3848 synth_3247 synth_966 synth_3646 VDD VDD VNB|VSS
+ sky130_fd_sc_hd__edfxtp_1
X$15205 VNB|VSS synth_3411 synth_3576 synth_3657 synth_3182 VDD VDD VNB|VSS
+ sky130_fd_sc_hd__edfxtp_1
X$15206 VNB|VSS synth_6271 synth_6241 synth_4588 synth_6158 VDD VDD VNB|VSS
+ sky130_fd_sc_hd__edfxtp_1
X$15207 VNB|VSS synth_6236 synth_6237 synth_4111 synth_6150 VDD VDD VNB|VSS
+ sky130_fd_sc_hd__edfxtp_1
X$15208 VNB|VSS synth_3714 synth_3247 synth_3656 synth_3646 VDD VDD VNB|VSS
+ sky130_fd_sc_hd__edfxtp_1
X$15209 VNB|VSS synth_12382 synth_11961 synth_6699 synth_12196 VDD VDD VNB|VSS
+ sky130_fd_sc_hd__edfxtp_1
X$15210 VNB|VSS synth_1975 synth_2080 synth_2151 synth_1820 VDD VDD VNB|VSS
+ sky130_fd_sc_hd__edfxtp_1
X$15211 VNB|VSS synth_5687 synth_5439 synth_3656 synth_5571 VDD VDD VNB|VSS
+ sky130_fd_sc_hd__edfxtp_1
X$15212 VNB|VSS synth_11854 synth_11851 synth_12042 synth_11804 VDD VDD VNB|VSS
+ sky130_fd_sc_hd__edfxtp_1
X$15213 VNB|VSS synth_5519 synth_4541 synth_966 synth_5571 VDD VDD VNB|VSS
+ sky130_fd_sc_hd__edfxtp_1
X$15214 VNB|VSS synth_3915 synth_3247 synth_1908 synth_3646 VDD VDD VNB|VSS
+ sky130_fd_sc_hd__edfxtp_1
X$15215 VNB|VSS synth_2693 synth_2201 synth_478 synth_2620 VDD VDD VNB|VSS
+ sky130_fd_sc_hd__edfxtp_1
X$15216 VNB|VSS synth_6076 synth_5753 synth_6040 synth_5909 VDD VDD VNB|VSS
+ sky130_fd_sc_hd__edfxtp_1
X$15217 VNB|VSS synth_4555 synth_3263 synth_4480 synth_4481 VDD VDD VNB|VSS
+ sky130_fd_sc_hd__edfxtp_1
X$15218 VNB|VSS synth_6303 synth_5753 synth_6455 synth_5909 VDD VDD VNB|VSS
+ sky130_fd_sc_hd__edfxtp_1
X$15219 VNB|VSS synth_2844 synth_2845 synth_966 synth_2620 VDD VDD VNB|VSS
+ sky130_fd_sc_hd__edfxtp_1
X$15220 VNB|VSS synth_6154 synth_6454 synth_6726 synth_6420 VDD VDD VNB|VSS
+ sky130_fd_sc_hd__edfxtp_1
X$15221 VNB|VSS synth_10624 synth_10030 synth_10623 synth_10250 VDD VDD VNB|VSS
+ sky130_fd_sc_hd__edfxtp_1
X$15222 VNB|VSS synth_12629 synth_12163 synth_12626 synth_12295 VDD VDD VNB|VSS
+ sky130_fd_sc_hd__edfxtp_1
X$15223 VNB|VSS synth_3481 synth_3478 synth_3645 synth_3479 VDD VDD VNB|VSS
+ sky130_fd_sc_hd__edfxtp_1
X$15224 VNB|VSS synth_3315 synth_3242 synth_626 synth_3181 VDD VDD VNB|VSS
+ sky130_fd_sc_hd__edfxtp_1
X$15225 VNB|VSS synth_6339 synth_6241 synth_4111 synth_6301 VDD VDD VNB|VSS
+ sky130_fd_sc_hd__edfxtp_1
X$15226 VNB|VSS synth_5526 synth_5057 synth_5661 synth_5245 VDD VDD VNB|VSS
+ sky130_fd_sc_hd__edfxtp_1
X$15227 VNB|VSS synth_298 synth_25 synth_163 synth_23 VDD VDD VNB|VSS
+ sky130_fd_sc_hd__edfxtp_1
X$15228 VNB|VSS synth_12143 synth_12202 synth_8337 synth_12086 VDD VDD VNB|VSS
+ sky130_fd_sc_hd__edfxtp_1
X$15229 VNB|VSS synth_4587 synth_4651 synth_2860 synth_4431 VDD VDD VNB|VSS
+ sky130_fd_sc_hd__edfxtp_1
X$15230 VNB|VSS synth_5602 synth_5400 synth_2777 synth_5401 VDD VDD VNB|VSS
+ sky130_fd_sc_hd__edfxtp_1
X$15231 VNB|VSS synth_6632 synth_6611 synth_626 synth_6505 VDD VDD VNB|VSS
+ sky130_fd_sc_hd__edfxtp_1
X$15232 VNB|VSS synth_3014 synth_2845 synth_1908 synth_2620 VDD VDD VNB|VSS
+ sky130_fd_sc_hd__edfxtp_1
X$15233 VNB|VSS synth_5373 synth_4826 synth_5244 synth_5245 VDD VDD VNB|VSS
+ sky130_fd_sc_hd__edfxtp_1
X$15234 VNB|VSS synth_5926 synth_5439 synth_4111 synth_5686 VDD VDD VNB|VSS
+ sky130_fd_sc_hd__edfxtp_1
X$15235 VNB|VSS synth_12391 synth_12024 synth_12338 synth_12205 VDD VDD VNB|VSS
+ sky130_fd_sc_hd__edfxtp_1
X$15236 VNB|VSS synth_11374 synth_11851 synth_11632 synth_11127 VDD VDD VNB|VSS
+ sky130_fd_sc_hd__edfxtp_1
X$15237 VNB|VSS synth_2870 synth_2730 synth_3031 synth_2869 VDD VDD VNB|VSS
+ sky130_fd_sc_hd__edfxtp_1
X$15238 VNB|VSS synth_12583 synth_12024 synth_12752 synth_12205 VDD VDD VNB|VSS
+ sky130_fd_sc_hd__edfxtp_1
X$15239 VNB|VSS synth_10330 synth_9912 synth_6699 synth_10070 VDD VDD VNB|VSS
+ sky130_fd_sc_hd__edfxtp_1
X$15240 VNB|VSS synth_2247 synth_1280 synth_478 synth_2162 VDD VDD VNB|VSS
+ sky130_fd_sc_hd__edfxtp_1
X$15241 VNB|VSS synth_4829 synth_4826 synth_4778 synth_4723 VDD VDD VNB|VSS
+ sky130_fd_sc_hd__edfxtp_1
X$15242 VNB|VSS synth_6748 synth_6454 synth_6654 synth_6605 VDD VDD VNB|VSS
+ sky130_fd_sc_hd__edfxtp_1
X$15243 VNB|VSS synth_2879 synth_3122 synth_3069 synth_2758 VDD VDD VNB|VSS
+ sky130_fd_sc_hd__edfxtp_1
X$15244 VNB|VSS synth_4907 synth_4651 synth_1695 synth_5290 VDD VDD VNB|VSS
+ sky130_fd_sc_hd__edfxtp_1
X$15245 VNB|VSS synth_6807 synth_7023 synth_6949 synth_6781 VDD VDD VNB|VSS
+ sky130_fd_sc_hd__edfxtp_1
X$15246 VNB|VSS synth_2848 synth_2730 synth_3007 synth_2869 VDD VDD VNB|VSS
+ sky130_fd_sc_hd__edfxtp_1
X$15247 VNB|VSS synth_4469 synth_4541 synth_3656 synth_4120 VDD VDD VNB|VSS
+ sky130_fd_sc_hd__edfxtp_1
X$15248 VNB|VSS synth_7259 synth_6950 synth_7307 synth_7258 VDD VDD VNB|VSS
+ sky130_fd_sc_hd__edfxtp_1
X$15249 VNB|VSS synth_10253 synth_9912 synth_6987 synth_10070 VDD VDD VNB|VSS
+ sky130_fd_sc_hd__edfxtp_1
X$15250 VNB|VSS synth_6709 synth_6541 synth_4467 synth_6323 VDD VDD VNB|VSS
+ sky130_fd_sc_hd__edfxtp_1
X$15251 VNB|VSS synth_10787 synth_10081 synth_10907 synth_10717 VDD VDD VNB|VSS
+ sky130_fd_sc_hd__edfxtp_1
X$15252 VNB|VSS synth_6256 synth_5400 synth_1695 synth_6015 VDD VDD VNB|VSS
+ sky130_fd_sc_hd__edfxtp_1
X$15253 VNB|VSS synth_5321 synth_5478 synth_5388 synth_4739 VDD VDD VNB|VSS
+ sky130_fd_sc_hd__edfxtp_1
X$15254 VNB|VSS synth_12033 synth_11917 synth_12098 synth_11839 VDD VDD VNB|VSS
+ sky130_fd_sc_hd__edfxtp_1
X$15255 VNB|VSS synth_6155 synth_6241 synth_626 synth_6196 VDD VDD VNB|VSS
+ sky130_fd_sc_hd__edfxtp_1
X$15256 VNB|VSS synth_4997 synth_4934 synth_4998 synth_4739 VDD VDD VNB|VSS
+ sky130_fd_sc_hd__edfxtp_1
X$15257 VNB|VSS synth_4819 synth_3703 synth_4820 synth_4739 VDD VDD VNB|VSS
+ sky130_fd_sc_hd__edfxtp_1
X$15258 VNB|VSS synth_4822 synth_4024 synth_4725 synth_1972 synth_4896
+ synth_4740 VDD VDD VNB|VSS sky130_fd_sc_hd__o2111a_1
X$15259 VNB|VSS synth_12519 synth_11851 synth_12637 synth_12441 VDD VDD VNB|VSS
+ sky130_fd_sc_hd__edfxtp_1
X$15260 VNB|VSS synth_5177 synth_4541 synth_4111 synth_5187 VDD VDD VNB|VSS
+ sky130_fd_sc_hd__edfxtp_1
X$15261 VNB|VSS synth_3429 synth_2804 synth_966 synth_3313 VDD VDD VNB|VSS
+ sky130_fd_sc_hd__edfxtp_1
X$15262 VNB|VSS synth_4855 synth_3950 synth_2860 synth_4460 VDD VDD VNB|VSS
+ sky130_fd_sc_hd__edfxtp_1
X$15263 VNB|VSS synth_9968 synth_10047 synth_4467 synth_9995 VDD VDD VNB|VSS
+ sky130_fd_sc_hd__edfxtp_1
X$15264 VNB|VSS synth_4509 synth_3703 synth_4567 synth_4105 VDD VDD VNB|VSS
+ sky130_fd_sc_hd__edfxtp_1
X$15265 VNB|VSS synth_5086 synth_5087 synth_5203 synth_4970 VDD VDD VNB|VSS
+ sky130_fd_sc_hd__edfxtp_1
X$15266 VNB|VSS synth_2212 synth_1453 synth_2234 synth_2235 VDD VDD VNB|VSS
+ sky130_fd_sc_hd__edfxtp_1
X$15267 VNB|VSS synth_2630 synth_1437 synth_1908 synth_2523 VDD VDD VNB|VSS
+ sky130_fd_sc_hd__edfxtp_1
X$15268 VNB|VSS synth_12683 synth_11917 synth_12785 synth_12318 VDD VDD VNB|VSS
+ sky130_fd_sc_hd__edfxtp_1
X$15269 VNB|VSS synth_1101 synth_699 synth_37 synth_940 VDD VDD VNB|VSS
+ sky130_fd_sc_hd__edfxtp_1
X$15270 VNB|VSS synth_1465 synth_1149 synth_1464 synth_1336 VDD VDD VNB|VSS
+ sky130_fd_sc_hd__edfxtp_1
X$15271 VNB|VSS synth_6077 synth_6241 synth_4111 synth_6196 VDD VDD VNB|VSS
+ sky130_fd_sc_hd__edfxtp_1
X$15272 VNB|VSS synth_12100 synth_12036 synth_8337 synth_11761 VDD VDD VNB|VSS
+ sky130_fd_sc_hd__edfxtp_1
X$15273 VNB|VSS synth_3036 synth_2800 synth_449 synth_2926 VDD VDD VNB|VSS
+ sky130_fd_sc_hd__edfxtp_1
X$15274 VNB|VSS synth_6427 synth_6059 synth_6568 synth_6174 VDD VDD VNB|VSS
+ sky130_fd_sc_hd__edfxtp_1
X$15275 VNB|VSS synth_5575 synth_5447 synth_5635 synth_5445 VDD VDD VNB|VSS
+ sky130_fd_sc_hd__edfxtp_1
X$15276 VNB|VSS synth_1543 synth_1149 synth_1541 synth_1336 VDD VDD VNB|VSS
+ sky130_fd_sc_hd__edfxtp_1
X$15277 VNB|VSS synth_801 synth_1149 synth_1171 synth_635 VDD VDD VNB|VSS
+ sky130_fd_sc_hd__edfxtp_1
X$15278 VNB|VSS synth_4619 synth_3543 synth_4690 synth_4617 VDD VDD VNB|VSS
+ sky130_fd_sc_hd__edfxtp_1
X$15279 VNB|VSS synth_10634 synth_10616 synth_10573 synth_10277 VDD VDD VNB|VSS
+ sky130_fd_sc_hd__edfxtp_1
X$15280 VNB|VSS synth_2482 synth_2201 synth_1908 synth_2520 VDD VDD VNB|VSS
+ sky130_fd_sc_hd__edfxtp_1
X$15281 VNB|VSS synth_6468 synth_6531 synth_2860 synth_6424 VDD VDD VNB|VSS
+ sky130_fd_sc_hd__edfxtp_1
X$15282 VNB|VSS synth_11955 synth_11846 synth_12131 synth_11801 VDD VDD VNB|VSS
+ sky130_fd_sc_hd__edfxtp_1
X$15283 VNB|VSS synth_4478 synth_3543 synth_4477 synth_4476 VDD VDD VNB|VSS
+ sky130_fd_sc_hd__edfxtp_1
X$15284 VNB|VSS synth_1907 synth_1657 synth_1908 synth_1671 VDD VDD VNB|VSS
+ sky130_fd_sc_hd__edfxtp_1
X$15285 VNB|VSS synth_12482 synth_12036 synth_6699 synth_12291 VDD VDD VNB|VSS
+ sky130_fd_sc_hd__edfxtp_1
X$15286 VNB|VSS synth_12613 synth_11917 synth_12614 synth_12615 VDD VDD VNB|VSS
+ sky130_fd_sc_hd__edfxtp_1
X$15287 VNB|VSS synth_3921 synth_3543 synth_4132 synth_3658 VDD VDD VNB|VSS
+ sky130_fd_sc_hd__edfxtp_1
X$15288 VNB|VSS synth_2519 synth_1970 synth_2481 synth_2427 VDD VDD VNB|VSS
+ sky130_fd_sc_hd__edfxtp_1
X$15289 VNB|VSS synth_199 synth_19 synth_500 synth_8 VDD VDD VNB|VSS
+ sky130_fd_sc_hd__edfxtp_1
X$15290 VNB|VSS synth_4827 synth_4826 synth_4956 synth_4481 VDD VDD VNB|VSS
+ sky130_fd_sc_hd__edfxtp_1
X$15291 VNB|VSS synth_4951 synth_4999 synth_1695 synth_4950 VDD VDD VNB|VSS
+ sky130_fd_sc_hd__edfxtp_1
X$15292 VNB|VSS synth_3923 synth_3543 synth_3984 synth_3658 VDD VDD VNB|VSS
+ sky130_fd_sc_hd__edfxtp_1
X$15293 VNB|VSS synth_5764 synth_5439 synth_966 synth_5686 VDD VDD VNB|VSS
+ sky130_fd_sc_hd__edfxtp_1
X$15294 VNB|VSS synth_1769 synth_557 synth_88 synth_1248 VDD VDD VNB|VSS
+ sky130_fd_sc_hd__edfxtp_1
X$15295 VNB|VSS synth_3365 synth_3543 synth_3494 synth_3055 VDD VDD VNB|VSS
+ sky130_fd_sc_hd__edfxtp_1
X$15296 VNB|VSS synth_6017 synth_5400 synth_2860 synth_6015 VDD VDD VNB|VSS
+ sky130_fd_sc_hd__edfxtp_1
X$15297 VNB|VSS synth_773 synth_30 synth_854 synth_635 VDD VDD VNB|VSS
+ sky130_fd_sc_hd__edfxtp_1
X$15298 VNB|VSS synth_1575 synth_1149 synth_1499 synth_1383 VDD VDD VNB|VSS
+ sky130_fd_sc_hd__edfxtp_1
X$15299 VNB|VSS synth_4909 synth_4826 synth_4959 synth_4723 VDD VDD VNB|VSS
+ sky130_fd_sc_hd__edfxtp_1
X$15300 VNB|VSS synth_662 synth_30 synth_697 synth_635 VDD VDD VNB|VSS
+ sky130_fd_sc_hd__edfxtp_1
X$15301 VNB|VSS synth_6131 synth_5400 synth_5787 synth_6015 VDD VDD VNB|VSS
+ sky130_fd_sc_hd__edfxtp_1
X$15302 VNB|VSS synth_11848 synth_11495 synth_11802 synth_11801 VDD VDD VNB|VSS
+ sky130_fd_sc_hd__edfxtp_1
X$15303 VNB|VSS synth_11947 synth_11917 synth_11945 synth_11839 VDD VDD VNB|VSS
+ sky130_fd_sc_hd__edfxtp_1
X$15304 VNB|VSS synth_2714 synth_2320 synth_88 synth_2439 VDD VDD VNB|VSS
+ sky130_fd_sc_hd__edfxtp_1
X$15305 VNB|VSS synth_4933 synth_5016 synth_3656 synth_4932 VDD VDD VNB|VSS
+ sky130_fd_sc_hd__edfxtp_1
X$15306 VNB|VSS synth_2686 synth_1142 synth_478 synth_2616 VDD VDD VNB|VSS
+ sky130_fd_sc_hd__edfxtp_1
X$15307 VNB|VSS synth_3511 synth_2804 synth_478 synth_3313 VDD VDD VNB|VSS
+ sky130_fd_sc_hd__edfxtp_1
X$15308 VNB|VSS synth_421 synth_19 synth_385 synth_386 VDD VDD VNB|VSS
+ sky130_fd_sc_hd__edfxtp_1
X$15309 VNB|VSS synth_237 synth_235 synth_88 synth_236 VDD VDD VNB|VSS
+ sky130_fd_sc_hd__edfxtp_1
X$15310 VNB|VSS synth_5637 synth_5087 synth_5639 synth_5569 VDD VDD VNB|VSS
+ sky130_fd_sc_hd__edfxtp_1
X$15311 VNB|VSS synth_4236 synth_3703 synth_4237 synth_4105 VDD VDD VNB|VSS
+ sky130_fd_sc_hd__edfxtp_1
X$15312 VNB|VSS synth_10636 synth_10090 synth_10721 synth_10480 VDD VDD VNB|VSS
+ sky130_fd_sc_hd__edfxtp_1
X$15313 VNB|VSS synth_800 synth_235 synth_387 synth_494 VDD VDD VNB|VSS
+ sky130_fd_sc_hd__edfxtp_1
X$15314 VNB|VSS synth_2712 synth_2179 synth_2743 synth_2292 VDD VDD VNB|VSS
+ sky130_fd_sc_hd__edfxtp_1
X$15315 VNB|VSS synth_10555 synth_10616 synth_10693 synth_10480 VDD VDD VNB|VSS
+ sky130_fd_sc_hd__edfxtp_1
X$15316 VNB|VSS synth_6439 synth_5450 synth_6494 synth_6440 VDD VDD VNB|VSS
+ sky130_fd_sc_hd__edfxtp_1
X$15317 VNB|VSS synth_1628 synth_1833 synth_1904 synth_1336 VDD VDD VNB|VSS
+ sky130_fd_sc_hd__edfxtp_1
X$15318 VNB|VSS synth_12402 synth_11851 synth_12442 synth_12441 VDD VDD VNB|VSS
+ sky130_fd_sc_hd__edfxtp_1
X$15319 VNB|VSS synth_12336 synth_11849 synth_6564 synth_12166 VDD VDD VNB|VSS
+ sky130_fd_sc_hd__edfxtp_1
X$15320 VNB|VSS synth_4990 synth_4657 synth_626 synth_4989 VDD VDD VNB|VSS
+ sky130_fd_sc_hd__edfxtp_1
X$15321 VNB|VSS synth_2834 synth_2208 synth_966 synth_2616 VDD VDD VNB|VSS
+ sky130_fd_sc_hd__edfxtp_1
X$15322 VNB|VSS synth_10791 synth_10047 synth_387 synth_10913 VDD VDD VNB|VSS
+ sky130_fd_sc_hd__edfxtp_1
X$15323 VNB|VSS synth_3689 synth_3543 synth_3659 synth_3658 VDD VDD VNB|VSS
+ sky130_fd_sc_hd__edfxtp_1
X$15324 VNB|VSS synth_4662 synth_4422 synth_4928 synth_4442 VDD VDD VNB|VSS
+ sky130_fd_sc_hd__edfxtp_1
X$15325 VNB|VSS synth_10935 synth_10549 synth_4467 synth_10913 VDD VDD VNB|VSS
+ sky130_fd_sc_hd__edfxtp_1
X$15326 VNB|VSS synth_11088 synth_11379 synth_387 synth_11380 VDD VDD VNB|VSS
+ sky130_fd_sc_hd__edfxtp_1
X$15327 VNB|VSS synth_1739 synth_1280 synth_183 synth_1643 VDD VDD VNB|VSS
+ sky130_fd_sc_hd__edfxtp_1
X$15328 VNB|VSS synth_11833 synth_10538 synth_6987 synth_11737 VDD VDD VNB|VSS
+ sky130_fd_sc_hd__edfxtp_1
X$15329 VNB|VSS synth_10504 synth_10616 synth_10691 synth_10277 VDD VDD VNB|VSS
+ sky130_fd_sc_hd__edfxtp_1
X$15330 VNB|VSS synth_6185 synth_5057 synth_6103 synth_5802 VDD VDD VNB|VSS
+ sky130_fd_sc_hd__edfxtp_1
X$15331 VNB|VSS synth_2131 synth_2080 synth_2130 synth_2129 VDD VDD VNB|VSS
+ sky130_fd_sc_hd__edfxtp_1
X$15332 VNB|VSS synth_3015 synth_2201 synth_1908 synth_2926 VDD VDD VNB|VSS
+ sky130_fd_sc_hd__edfxtp_1
X$15333 VNB|VSS synth_5521 synth_5447 synth_5446 synth_5445 VDD VDD VNB|VSS
+ sky130_fd_sc_hd__edfxtp_1
X$15334 VNB|VSS synth_2078 synth_2077 synth_88 synth_1988 VDD VDD VNB|VSS
+ sky130_fd_sc_hd__edfxtp_1
X$15335 VNB|VSS synth_11238 synth_11495 synth_11203 synth_11079 VDD VDD VNB|VSS
+ sky130_fd_sc_hd__edfxtp_1
X$15336 VNB|VSS synth_2369 synth_2179 synth_2367 synth_2292 VDD VDD VNB|VSS
+ sky130_fd_sc_hd__edfxtp_1
X$15337 VNB|VSS synth_12263 synth_11961 synth_6564 synth_12196 VDD VDD VNB|VSS
+ sky130_fd_sc_hd__edfxtp_1
X$15338 VNB|VSS synth_5486 synth_4651 synth_4467 synth_5290 VDD VDD VNB|VSS
+ sky130_fd_sc_hd__edfxtp_1
X$15339 VNB|VSS synth_5438 synth_5439 synth_3656 synth_5187 VDD VDD VNB|VSS
+ sky130_fd_sc_hd__edfxtp_1
X$15340 VNB|VSS synth_6358 synth_6541 synth_5787 synth_6323 VDD VDD VNB|VSS
+ sky130_fd_sc_hd__edfxtp_1
X$15341 VNB|VSS synth_2426 synth_2800 synth_1181 synth_2523 VDD VDD VNB|VSS
+ sky130_fd_sc_hd__edfxtp_1
X$15342 VNB|VSS synth_6326 synth_5531 synth_2777 synth_6323 VDD VDD VNB|VSS
+ sky130_fd_sc_hd__edfxtp_1
X$15343 VNB|VSS synth_1463 synth_1011 synth_88 synth_1385 VDD VDD VNB|VSS
+ sky130_fd_sc_hd__edfxtp_1
X$15344 VNB|VSS synth_6311 synth_6531 synth_6699 synth_6424 VDD VDD VNB|VSS
+ sky130_fd_sc_hd__edfxtp_1
X$15345 VNB|VSS synth_1122 synth_439 synth_183 synth_1074 VDD VDD VNB|VSS
+ sky130_fd_sc_hd__edfxtp_1
X$15346 VNB|VSS synth_5800 synth_5057 synth_5852 synth_5802 VDD VDD VNB|VSS
+ sky130_fd_sc_hd__edfxtp_1
X$15347 VNB|VSS synth_6425 synth_6059 synth_6562 synth_6254 VDD VDD VNB|VSS
+ sky130_fd_sc_hd__edfxtp_1
X$15348 VNB|VSS synth_1020 synth_1011 synth_37 synth_694 VDD VDD VNB|VSS
+ sky130_fd_sc_hd__edfxtp_1
X$15349 VNB|VSS synth_5024 synth_4487 synth_4963 synth_4942 VDD VDD VNB|VSS
+ sky130_fd_sc_hd__edfxtp_1
X$15350 VNB|VSS synth_1238 synth_1149 synth_1151 synth_1056 VDD VDD VNB|VSS
+ sky130_fd_sc_hd__edfxtp_1
X$15351 VNB|VSS synth_2544 synth_1970 synth_2846 synth_2427 VDD VDD VNB|VSS
+ sky130_fd_sc_hd__edfxtp_1
X$15352 VNB|VSS synth_2084 synth_2208 synth_449 synth_2128 VDD VDD VNB|VSS
+ sky130_fd_sc_hd__edfxtp_1
X$15353 VNB|VSS synth_12018 synth_11961 synth_8337 synth_11737 VDD VDD VNB|VSS
+ sky130_fd_sc_hd__edfxtp_1
X$15354 VNB|VSS synth_972 synth_1149 synth_1016 synth_1056 VDD VDD VNB|VSS
+ sky130_fd_sc_hd__edfxtp_1
X$15355 VNB|VSS synth_853 synth_235 synth_88 synth_694 VDD VDD VNB|VSS
+ sky130_fd_sc_hd__edfxtp_1
X$15356 VNB|VSS synth_3407 synth_3478 synth_3425 synth_3479 VDD VDD VNB|VSS
+ sky130_fd_sc_hd__edfxtp_1
X$15357 VNB|VSS synth_2304 synth_2208 synth_966 synth_2128 VDD VDD VNB|VSS
+ sky130_fd_sc_hd__edfxtp_1
X$15358 VNB|VSS synth_1140 synth_439 synth_1181 synth_1074 VDD VDD VNB|VSS
+ sky130_fd_sc_hd__edfxtp_1
X$15359 VNB|VSS synth_5364 synth_4541 synth_626 synth_5187 VDD VDD VNB|VSS
+ sky130_fd_sc_hd__edfxtp_1
X$15360 VNB|VSS synth_321 synth_36 synth_251 synth_14 VDD VDD VNB|VSS
+ sky130_fd_sc_hd__edfxtp_1
X$15361 VNB|VSS synth_7685 synth_6929 synth_7618 synth_7616 VDD VDD VNB|VSS
+ sky130_fd_sc_hd__edfxtp_1
X$15362 VNB|VSS synth_81 synth_36 synth_35 synth_14 VDD VDD VNB|VSS
+ sky130_fd_sc_hd__edfxtp_1
X$15363 VNB|VSS synth_1163 synth_63 synth_1119 synth_1073 VDD VDD VNB|VSS
+ sky130_fd_sc_hd__edfxtp_1
X$15364 VNB|VSS synth_9302 synth_8533 synth_9217 synth_9164 VDD VDD VNB|VSS
+ sky130_fd_sc_hd__edfxtp_1
X$15365 VNB|VSS synth_9755 synth_9717 synth_6987 synth_9685 VDD VDD VNB|VSS
+ sky130_fd_sc_hd__edfxtp_1
X$15366 VNB|VSS synth_9687 synth_9717 synth_6564 synth_9685 VDD VDD VNB|VSS
+ sky130_fd_sc_hd__edfxtp_1
X$15367 VNB|VSS synth_2270 synth_2193 synth_501 synth_2269 VDD VDD VNB|VSS
+ sky130_fd_sc_hd__edfxtp_1
X$15368 VNB|VSS synth_1959 synth_1727 synth_2097 synth_1804 VDD VDD VNB|VSS
+ sky130_fd_sc_hd__edfxtp_1
X$15369 VNB|VSS synth_672 synth_276 synth_258 synth_751 VDD VDD VNB|VSS
+ sky130_fd_sc_hd__edfxtp_1
X$15370 VNB|VSS synth_1052 synth_756 synth_1051 synth_909 VDD VDD VNB|VSS
+ sky130_fd_sc_hd__edfxtp_1
X$15371 VNB|VSS synth_7698 synth_7826 synth_7725 synth_7724 VDD VDD VNB|VSS
+ sky130_fd_sc_hd__edfxtp_1
X$15372 VNB|VSS synth_4104 synth_4422 synth_4444 synth_4166 VDD VDD VNB|VSS
+ sky130_fd_sc_hd__edfxtp_1
X$15373 VNB|VSS synth_8298 synth_7933 synth_382 synth_8006 VDD VDD VNB|VSS
+ sky130_fd_sc_hd__edfxtp_1
X$15374 VNB|VSS synth_7896 synth_7826 synth_8137 synth_7724 VDD VDD VNB|VSS
+ sky130_fd_sc_hd__edfxtp_1
X$15375 VNB|VSS synth_8052 synth_6583 synth_4588 synth_8006 VDD VDD VNB|VSS
+ sky130_fd_sc_hd__edfxtp_1
X$15376 VNB|VSS synth_7863 synth_7933 synth_5329 synth_7730 VDD VDD VNB|VSS
+ sky130_fd_sc_hd__edfxtp_1
X$15377 VNB|VSS synth_4074 synth_3806 synth_449 synth_3761 VDD VDD VNB|VSS
+ sky130_fd_sc_hd__edfxtp_1
X$15378 VNB|VSS synth_749 synth_484 synth_88 synth_748 VDD VDD VNB|VSS
+ sky130_fd_sc_hd__edfxtp_1
X$15379 VNB|VSS synth_3877 synth_3806 synth_1908 synth_3761 VDD VDD VNB|VSS
+ sky130_fd_sc_hd__edfxtp_1
X$15380 VNB|VSS synth_3391 synth_3385 synth_3533 synth_3219 VDD VDD VNB|VSS
+ sky130_fd_sc_hd__edfxtp_1
X$15381 VNB|VSS synth_8085 synth_8082 synth_8005 synth_8004 VDD VDD VNB|VSS
+ sky130_fd_sc_hd__edfxtp_1
X$15382 VNB|VSS synth_2407 synth_2268 synth_2404 synth_2318 VDD VDD VNB|VSS
+ sky130_fd_sc_hd__edfxtp_1
X$15383 VNB|VSS synth_6668 synth_6801 synth_6866 synth_6445 VDD VDD VNB|VSS
+ sky130_fd_sc_hd__edfxtp_1
X$15384 VNB|VSS synth_6965 synth_6794 synth_4566 synth_6964 VDD VDD VNB|VSS
+ sky130_fd_sc_hd__edfxtp_1
X$15385 VNB|VSS synth_2117 synth_2044 synth_1908 synth_1956 VDD VDD VNB|VSS
+ sky130_fd_sc_hd__edfxtp_1
X$15386 VNB|VSS synth_6742 synth_6794 synth_2860 synth_6964 VDD VDD VNB|VSS
+ sky130_fd_sc_hd__edfxtp_1
X$15387 VNB|VSS synth_965 synth_276 synth_88 synth_751 VDD VDD VNB|VSS
+ sky130_fd_sc_hd__edfxtp_1
X$15388 VNB|VSS synth_1165 synth_276 synth_183 synth_1117 VDD VDD VNB|VSS
+ sky130_fd_sc_hd__edfxtp_1
X$15389 VNB|VSS synth_543 synth_443 synth_258 synth_488 VDD VDD VNB|VSS
+ sky130_fd_sc_hd__edfxtp_1
X$15390 VNB|VSS synth_651 synth_443 synth_382 synth_488 VDD VDD VNB|VSS
+ sky130_fd_sc_hd__edfxtp_1
X$15391 VNB|VSS synth_7531 synth_6824 synth_3656 synth_7336 VDD VDD VNB|VSS
+ sky130_fd_sc_hd__edfxtp_1
X$15392 VNB|VSS synth_1331 synth_1265 synth_1181 synth_1117 VDD VDD VNB|VSS
+ sky130_fd_sc_hd__edfxtp_1
X$15393 VNB|VSS synth_7393 synth_7534 synth_387 synth_7151 VDD VDD VNB|VSS
+ sky130_fd_sc_hd__edfxtp_1
X$15394 VNB|VSS synth_6598 synth_6794 synth_1695 synth_6795 VDD VDD VNB|VSS
+ sky130_fd_sc_hd__edfxtp_1
X$15395 VNB|VSS synth_7037 synth_6824 synth_6198 synth_6996 VDD VDD VNB|VSS
+ sky130_fd_sc_hd__edfxtp_1
X$15396 VNB|VSS synth_6796 synth_6794 synth_387 synth_6795 VDD VDD VNB|VSS
+ sky130_fd_sc_hd__edfxtp_1
X$15397 VNB|VSS synth_7153 synth_6794 synth_4467 synth_7151 VDD VDD VNB|VSS
+ sky130_fd_sc_hd__edfxtp_1
X$15398 VNB|VSS synth_7256 synth_6794 synth_1695 synth_7151 VDD VDD VNB|VSS
+ sky130_fd_sc_hd__edfxtp_1
X$15399 VNB|VSS synth_7150 synth_6824 synth_4588 synth_6996 VDD VDD VNB|VSS
+ sky130_fd_sc_hd__edfxtp_1
X$15400 VNB|VSS synth_1358 synth_1432 synth_1357 synth_1073 VDD VDD VNB|VSS
+ sky130_fd_sc_hd__edfxtp_1
X$15401 VNB|VSS synth_7678 synth_6824 synth_4588 synth_7336 VDD VDD VNB|VSS
+ sky130_fd_sc_hd__edfxtp_1
X$15402 VNB|VSS synth_8072 synth_7534 synth_387 synth_7993 VDD VDD VNB|VSS
+ sky130_fd_sc_hd__edfxtp_1
X$15403 VNB|VSS synth_6691 synth_6927 synth_6864 synth_6319 VDD VDD VNB|VSS
+ sky130_fd_sc_hd__edfxtp_1
X$15404 VNB|VSS synth_7788 synth_6950 synth_7766 synth_7729 VDD VDD VNB|VSS
+ sky130_fd_sc_hd__edfxtp_1
X$15405 VNB|VSS synth_8623 synth_8659 synth_1695 synth_8346 VDD VDD VNB|VSS
+ sky130_fd_sc_hd__edfxtp_1
X$15406 VNB|VSS synth_7122 synth_6927 synth_7226 synth_7068 VDD VDD VNB|VSS
+ sky130_fd_sc_hd__edfxtp_1
X$15407 VNB|VSS synth_6899 synth_6950 synth_6945 synth_6605 VDD VDD VNB|VSS
+ sky130_fd_sc_hd__edfxtp_1
X$15408 VNB|VSS synth_8458 synth_8380 synth_8459 synth_8348 VDD VDD VNB|VSS
+ sky130_fd_sc_hd__edfxtp_1
X$15409 VNB|VSS synth_1936 synth_1265 synth_183 synth_1639 VDD VDD VNB|VSS
+ sky130_fd_sc_hd__edfxtp_1
X$15410 VNB|VSS synth_593 synth_48 synth_258 synth_511 VDD VDD VNB|VSS
+ sky130_fd_sc_hd__edfxtp_1
X$15411 VNB|VSS synth_1493 synth_756 synth_1492 synth_1359 VDD VDD VNB|VSS
+ sky130_fd_sc_hd__edfxtp_1
X$15412 VNB|VSS synth_649 synth_48 synth_88 synth_511 VDD VDD VNB|VSS
+ sky130_fd_sc_hd__edfxtp_1
X$15413 VNB|VSS synth_4633 synth_4422 synth_4596 synth_4595 VDD VDD VNB|VSS
+ sky130_fd_sc_hd__edfxtp_1
X$15414 VNB|VSS synth_4098 synth_4422 synth_4252 synth_3809 VDD VDD VNB|VSS
+ sky130_fd_sc_hd__edfxtp_1
X$15415 VNB|VSS synth_1586 synth_756 synth_1569 synth_1359 VDD VDD VNB|VSS
+ sky130_fd_sc_hd__edfxtp_1
X$15416 VNB|VSS synth_1185 synth_439 synth_1181 synth_1184 VDD VDD VNB|VSS
+ sky130_fd_sc_hd__edfxtp_1
X$15417 VNB|VSS synth_8510 synth_7534 synth_387 synth_8507 VDD VDD VNB|VSS
+ sky130_fd_sc_hd__edfxtp_1
X$15418 VNB|VSS synth_8678 synth_7534 synth_6198 synth_8507 VDD VDD VNB|VSS
+ sky130_fd_sc_hd__edfxtp_1
X$15419 VNB|VSS synth_907 synth_756 synth_1121 synth_755 VDD VDD VNB|VSS
+ sky130_fd_sc_hd__edfxtp_1
X$15420 VNB|VSS synth_2039 synth_1717 synth_1919 synth_1685 VDD VDD VNB|VSS
+ sky130_fd_sc_hd__edfxtp_1
X$15421 VNB|VSS synth_9380 synth_9045 synth_9378 synth_9225 VDD VDD VNB|VSS
+ sky130_fd_sc_hd__edfxtp_1
X$15422 VNB|VSS synth_83 synth_48 synth_37 synth_15 VDD VDD VNB|VSS
+ sky130_fd_sc_hd__edfxtp_1
X$15423 VNB|VSS synth_7554 synth_6939 synth_7409 synth_7410 VDD VDD VNB|VSS
+ sky130_fd_sc_hd__edfxtp_1
X$15424 VNB|VSS synth_7314 synth_6583 synth_6198 synth_7110 VDD VDD VNB|VSS
+ sky130_fd_sc_hd__edfxtp_1
X$15425 VNB|VSS synth_7405 synth_6950 synth_7404 synth_7258 VDD VDD VNB|VSS
+ sky130_fd_sc_hd__edfxtp_1
X$15426 VNB|VSS synth_8074 synth_6961 synth_8161 synth_7757 VDD VDD VNB|VSS
+ sky130_fd_sc_hd__edfxtp_1
X$15427 VNB|VSS synth_7653 synth_6583 synth_4588 synth_7730 VDD VDD VNB|VSS
+ sky130_fd_sc_hd__edfxtp_1
X$15428 VNB|VSS synth_888 synth_61 synth_1036 synth_655 VDD VDD VNB|VSS
+ sky130_fd_sc_hd__edfxtp_1
X$15429 VNB|VSS synth_8827 synth_8659 synth_6564 synth_8747 VDD VDD VNB|VSS
+ sky130_fd_sc_hd__edfxtp_1
X$15430 VNB|VSS synth_4512 synth_3806 synth_3656 synth_4321 VDD VDD VNB|VSS
+ sky130_fd_sc_hd__edfxtp_1
X$15431 VNB|VSS synth_7189 synth_6801 synth_7228 synth_7098 VDD VDD VNB|VSS
+ sky130_fd_sc_hd__edfxtp_1
X$15432 VNB|VSS synth_3428 synth_3122 synth_3334 synth_3180 VDD VDD VNB|VSS
+ sky130_fd_sc_hd__edfxtp_1
X$15433 VNB|VSS synth_3838 synth_3478 synth_3837 synth_3771 VDD VDD VNB|VSS
+ sky130_fd_sc_hd__edfxtp_1
X$15434 VNB|VSS synth_8084 synth_7933 synth_5329 synth_8057 VDD VDD VNB|VSS
+ sky130_fd_sc_hd__edfxtp_1
X$15435 VNB|VSS synth_7842 synth_7576 synth_6198 synth_7577 VDD VDD VNB|VSS
+ sky130_fd_sc_hd__edfxtp_1
X$15436 VNB|VSS synth_8579 synth_8533 synth_8534 synth_8453 VDD VDD VNB|VSS
+ sky130_fd_sc_hd__edfxtp_1
X$15437 VNB|VSS synth_4114 synth_3242 synth_4111 synth_3972 VDD VDD VNB|VSS
+ sky130_fd_sc_hd__edfxtp_1
X$15438 VNB|VSS synth_4536 synth_4487 synth_4451 synth_4450 VDD VDD VNB|VSS
+ sky130_fd_sc_hd__edfxtp_1
X$15439 VNB|VSS synth_7631 synth_7576 synth_382 synth_7577 VDD VDD VNB|VSS
+ sky130_fd_sc_hd__edfxtp_1
X$15440 VNB|VSS synth_7397 synth_6961 synth_7571 synth_7098 VDD VDD VNB|VSS
+ sky130_fd_sc_hd__edfxtp_1
X$15441 VNB|VSS synth_4603 synth_4600 synth_966 synth_4601 VDD VDD VNB|VSS
+ sky130_fd_sc_hd__edfxtp_1
X$15442 VNB|VSS synth_7825 synth_6961 synth_7824 synth_7757 VDD VDD VNB|VSS
+ sky130_fd_sc_hd__edfxtp_1
X$15443 VNB|VSS synth_7850 synth_6961 synth_7891 synth_7757 VDD VDD VNB|VSS
+ sky130_fd_sc_hd__edfxtp_1
X$15444 VNB|VSS synth_209 synth_51 synth_189 synth_50 VDD VDD VNB|VSS
+ sky130_fd_sc_hd__edfxtp_1
X$15445 VNB|VSS synth_8146 synth_8082 synth_8301 synth_7729 VDD VDD VNB|VSS
+ sky130_fd_sc_hd__edfxtp_1
X$15446 VNB|VSS synth_4222 synth_3569 synth_4225 synth_4151 VDD VDD VNB|VSS
+ sky130_fd_sc_hd__edfxtp_1
X$15447 VNB|VSS synth_7995 synth_6961 synth_8071 synth_7757 VDD VDD VNB|VSS
+ sky130_fd_sc_hd__edfxtp_1
X$15448 VNB|VSS synth_4307 synth_3242 synth_966 synth_3972 VDD VDD VNB|VSS
+ sky130_fd_sc_hd__edfxtp_1
X$15449 VNB|VSS synth_3032 synth_2800 synth_1908 synth_2868 VDD VDD VNB|VSS
+ sky130_fd_sc_hd__edfxtp_1
X$15450 VNB|VSS synth_2950 synth_2800 synth_501 synth_2868 VDD VDD VNB|VSS
+ sky130_fd_sc_hd__edfxtp_1
X$15451 VNB|VSS synth_759 synth_568 synth_883 synth_515 VDD VDD VNB|VSS
+ sky130_fd_sc_hd__edfxtp_1
X$15452 VNB|VSS synth_8775 synth_8533 synth_8893 synth_8453 VDD VDD VNB|VSS
+ sky130_fd_sc_hd__edfxtp_1
X$15453 VNB|VSS synth_11921 synth_11495 synth_12083 synth_11662 VDD VDD VNB|VSS
+ sky130_fd_sc_hd__edfxtp_1
X$15454 VNB|VSS synth_7106 synth_7022 synth_6198 synth_6968 VDD VDD VNB|VSS
+ sky130_fd_sc_hd__edfxtp_1
X$15455 VNB|VSS synth_7175 synth_7022 synth_4588 synth_6968 VDD VDD VNB|VSS
+ sky130_fd_sc_hd__edfxtp_1
X$15456 VNB|VSS synth_7082 synth_7022 synth_382 synth_6968 VDD VDD VNB|VSS
+ sky130_fd_sc_hd__edfxtp_1
X$15457 VNB|VSS synth_638 synth_446 synth_478 synth_401 VDD VDD VNB|VSS
+ sky130_fd_sc_hd__edfxtp_1
X$15458 VNB|VSS synth_684 synth_450 synth_624 VDD VDD VNB|VSS
+ sky130_fd_sc_hd__dfxtp_1
X$15459 VNB|VSS synth_5471 synth_4934 synth_5561 synth_5115 VDD VDD VNB|VSS
+ sky130_fd_sc_hd__edfxtp_1
X$15460 VNB|VSS synth_9913 synth_9811 synth_9959 synth_9842 VDD VDD VNB|VSS
+ sky130_fd_sc_hd__edfxtp_1
X$15461 VNB|VSS synth_6854 synth_6459 synth_4588 synth_6858 VDD VDD VNB|VSS
+ sky130_fd_sc_hd__edfxtp_1
X$15462 VNB|VSS synth_7195 synth_7022 synth_382 synth_7105 VDD VDD VNB|VSS
+ sky130_fd_sc_hd__edfxtp_1
X$15463 VNB|VSS synth_7483 synth_7022 synth_6198 synth_7105 VDD VDD VNB|VSS
+ sky130_fd_sc_hd__edfxtp_1
X$15464 VNB|VSS synth_7193 synth_6897 synth_7298 synth_6967 VDD VDD VNB|VSS
+ sky130_fd_sc_hd__edfxtp_1
X$15465 VNB|VSS synth_7081 synth_6897 synth_7078 synth_6967 VDD VDD VNB|VSS
+ sky130_fd_sc_hd__edfxtp_1
X$15466 VNB|VSS synth_6722 synth_6069 synth_5329 synth_6343 VDD VDD VNB|VSS
+ sky130_fd_sc_hd__edfxtp_1
X$15467 VNB|VSS synth_2729 synth_2339 synth_2728 synth_2727 VDD VDD VNB|VSS
+ sky130_fd_sc_hd__edfxtp_1
X$15468 VNB|VSS synth_8347 synth_7644 synth_5787 synth_8346 VDD VDD VNB|VSS
+ sky130_fd_sc_hd__edfxtp_1
X$15469 VNB|VSS synth_8232 synth_8488 synth_8263 synth_7769 VDD VDD VNB|VSS
+ sky130_fd_sc_hd__edfxtp_1
X$15470 VNB|VSS synth_8198 synth_7814 synth_8150 synth_7772 VDD VDD VNB|VSS
+ sky130_fd_sc_hd__edfxtp_1
X$15471 VNB|VSS synth_3828 synth_3397 synth_3868 synth_3764 VDD VDD VNB|VSS
+ sky130_fd_sc_hd__edfxtp_1
X$15472 VNB|VSS synth_9878 synth_9912 synth_8337 synth_9840 VDD VDD VNB|VSS
+ sky130_fd_sc_hd__edfxtp_1
X$15473 VNB|VSS synth_1504 synth_470 synth_1551 synth_1341 VDD VDD VNB|VSS
+ sky130_fd_sc_hd__edfxtp_1
X$15474 VNB|VSS synth_1583 synth_1795 synth_1842 synth_1341 VDD VDD VNB|VSS
+ sky130_fd_sc_hd__edfxtp_1
X$15475 VNB|VSS synth_1582 synth_1795 synth_2085 synth_1341 VDD VDD VNB|VSS
+ sky130_fd_sc_hd__edfxtp_1
X$15476 VNB|VSS synth_8417 synth_7645 synth_8310 synth_8348 VDD VDD VNB|VSS
+ sky130_fd_sc_hd__edfxtp_1
X$15477 VNB|VSS synth_9540 synth_9754 synth_2777 synth_9570 VDD VDD VNB|VSS
+ sky130_fd_sc_hd__edfxtp_1
X$15478 VNB|VSS synth_59 synth_61 synth_195 synth_18 VDD VDD VNB|VSS
+ sky130_fd_sc_hd__edfxtp_1
X$15479 VNB|VSS synth_2161 synth_1136 synth_37 synth_2111 VDD VDD VNB|VSS
+ sky130_fd_sc_hd__edfxtp_1
X$15480 VNB|VSS synth_9408 synth_8659 synth_6564 synth_9570 VDD VDD VNB|VSS
+ sky130_fd_sc_hd__edfxtp_1
X$15481 VNB|VSS synth_418 synth_484 synth_258 synth_419 VDD VDD VNB|VSS
+ sky130_fd_sc_hd__edfxtp_1
X$15482 VNB|VSS synth_5113 synth_4657 synth_3656 synth_4989 VDD VDD VNB|VSS
+ sky130_fd_sc_hd__edfxtp_1
X$15483 VNB|VSS synth_2333 synth_1136 synth_501 synth_2111 VDD VDD VNB|VSS
+ sky130_fd_sc_hd__edfxtp_1
X$15484 VNB|VSS synth_2472 synth_2330 synth_2510 synth_2473 VDD VDD VNB|VSS
+ sky130_fd_sc_hd__edfxtp_1
X$15485 VNB|VSS synth_8388 synth_8082 synth_8304 synth_8004 VDD VDD VNB|VSS
+ sky130_fd_sc_hd__edfxtp_1
X$15486 VNB|VSS synth_2583 synth_2193 synth_1181 synth_2269 VDD VDD VNB|VSS
+ sky130_fd_sc_hd__edfxtp_1
X$15487 VNB|VSS synth_2830 synth_2643 synth_2984 synth_2719 VDD VDD VNB|VSS
+ sky130_fd_sc_hd__edfxtp_1
X$15488 VNB|VSS synth_602 synth_484 synth_183 synth_419 VDD VDD VNB|VSS
+ sky130_fd_sc_hd__edfxtp_1
X$15489 VNB|VSS synth_6876 synth_6347 synth_6804 synth_6373 VDD VDD VNB|VSS
+ sky130_fd_sc_hd__edfxtp_1
X$15490 VNB|VSS synth_5718 synth_4934 synth_5672 synth_5671 VDD VDD VNB|VSS
+ sky130_fd_sc_hd__edfxtp_1
X$15491 VNB|VSS synth_5472 synth_4657 synth_3656 synth_5255 VDD VDD VNB|VSS
+ sky130_fd_sc_hd__edfxtp_1
X$15492 VNB|VSS synth_5335 synth_4657 synth_4588 synth_5255 VDD VDD VNB|VSS
+ sky130_fd_sc_hd__edfxtp_1
X$15493 VNB|VSS synth_2480 synth_2193 synth_478 synth_2269 VDD VDD VNB|VSS
+ sky130_fd_sc_hd__edfxtp_1
X$15494 VNB|VSS synth_466 synth_446 synth_183 synth_401 VDD VDD VNB|VSS
+ sky130_fd_sc_hd__edfxtp_1
X$15495 VNB|VSS synth_1299 synth_521 synth_1307 synth_1197 VDD VDD VNB|VSS
+ sky130_fd_sc_hd__edfxtp_1
X$15496 VNB|VSS synth_7548 synth_6897 synth_7708 synth_7623 VDD VDD VNB|VSS
+ sky130_fd_sc_hd__edfxtp_1
X$15497 VNB|VSS synth_9272 synth_9270 synth_9268 synth_9218 VDD VDD VNB|VSS
+ sky130_fd_sc_hd__edfxtp_1
X$15498 VNB|VSS synth_1268 synth_1432 synth_1325 synth_1404 VDD VDD VNB|VSS
+ sky130_fd_sc_hd__edfxtp_1
X$15499 VNB|VSS synth_8292 synth_8165 synth_382 synth_7999 VDD VDD VNB|VSS
+ sky130_fd_sc_hd__edfxtp_1
X$15500 VNB|VSS synth_8078 synth_7022 synth_4566 synth_7999 VDD VDD VNB|VSS
+ sky130_fd_sc_hd__edfxtp_1
X$15501 VNB|VSS synth_1166 synth_484 synth_382 synth_1114 VDD VDD VNB|VSS
+ sky130_fd_sc_hd__edfxtp_1
X$15502 VNB|VSS synth_1324 synth_1265 synth_501 synth_1114 VDD VDD VNB|VSS
+ sky130_fd_sc_hd__edfxtp_1
X$15503 VNB|VSS synth_6803 synth_6069 synth_382 synth_6802 VDD VDD VNB|VSS
+ sky130_fd_sc_hd__edfxtp_1
X$15504 VNB|VSS synth_7881 synth_6890 synth_2777 synth_7718 VDD VDD VNB|VSS
+ sky130_fd_sc_hd__edfxtp_1
X$15505 VNB|VSS synth_8995 synth_8533 synth_9138 synth_8790 VDD VDD VNB|VSS
+ sky130_fd_sc_hd__edfxtp_1
X$15506 VNB|VSS synth_903 synth_484 synth_183 synth_748 VDD VDD VNB|VSS
+ sky130_fd_sc_hd__edfxtp_1
X$15507 VNB|VSS synth_5503 synth_5478 synth_5502 synth_5316 VDD VDD VNB|VSS
+ sky130_fd_sc_hd__edfxtp_1
X$15508 VNB|VSS synth_8441 synth_8082 synth_8473 synth_8386 VDD VDD VNB|VSS
+ sky130_fd_sc_hd__edfxtp_1
X$15509 VNB|VSS synth_5752 synth_5478 synth_5722 synth_5611 VDD VDD VNB|VSS
+ sky130_fd_sc_hd__edfxtp_1
X$15510 VNB|VSS synth_674 synth_63 synth_891 synth_565 VDD VDD VNB|VSS
+ sky130_fd_sc_hd__edfxtp_1
X$15511 VNB|VSS synth_8853 synth_8533 synth_8897 synth_8790 VDD VDD VNB|VSS
+ sky130_fd_sc_hd__edfxtp_1
X$15512 VNB|VSS synth_2019 synth_2044 synth_1181 synth_1956 VDD VDD VNB|VSS
+ sky130_fd_sc_hd__edfxtp_1
X$15513 VNB|VSS synth_7539 synth_7190 synth_4566 synth_7293 VDD VDD VNB|VSS
+ sky130_fd_sc_hd__edfxtp_1
X$15514 VNB|VSS synth_1785 synth_1727 synth_1728 synth_1638 VDD VDD VNB|VSS
+ sky130_fd_sc_hd__edfxtp_1
X$15515 VNB|VSS synth_7003 synth_6069 synth_6198 synth_6802 VDD VDD VNB|VSS
+ sky130_fd_sc_hd__edfxtp_1
X$15516 VNB|VSS synth_2704 synth_2044 synth_501 synth_2635 VDD VDD VNB|VSS
+ sky130_fd_sc_hd__edfxtp_1
X$15517 VNB|VSS synth_2582 synth_2193 synth_1908 synth_2635 VDD VDD VNB|VSS
+ sky130_fd_sc_hd__edfxtp_1
X$15518 VNB|VSS synth_7858 synth_6897 synth_8142 synth_7620 VDD VDD VNB|VSS
+ sky130_fd_sc_hd__edfxtp_1
X$15519 VNB|VSS synth_7621 synth_6897 synth_7573 synth_7620 VDD VDD VNB|VSS
+ sky130_fd_sc_hd__edfxtp_1
X$15520 VNB|VSS synth_2864 synth_2193 synth_1181 synth_2863 VDD VDD VNB|VSS
+ sky130_fd_sc_hd__edfxtp_1
X$15521 VNB|VSS synth_7562 synth_6734 synth_7600 synth_7139 VDD VDD VNB|VSS
+ sky130_fd_sc_hd__edfxtp_1
X$15522 VNB|VSS synth_8231 synth_8228 synth_8337 synth_8148 VDD VDD VNB|VSS
+ sky130_fd_sc_hd__edfxtp_1
X$15523 VNB|VSS synth_2945 synth_2193 synth_478 synth_2863 VDD VDD VNB|VSS
+ sky130_fd_sc_hd__edfxtp_1
X$15524 VNB|VSS synth_8306 synth_8228 synth_6564 synth_8032 VDD VDD VNB|VSS
+ sky130_fd_sc_hd__edfxtp_1
X$15525 VNB|VSS synth_8538 synth_8380 synth_8729 synth_8348 VDD VDD VNB|VSS
+ sky130_fd_sc_hd__edfxtp_1
X$15526 VNB|VSS synth_1009 synth_840 synth_183 synth_767 VDD VDD VNB|VSS
+ sky130_fd_sc_hd__edfxtp_1
X$15527 VNB|VSS synth_7485 synth_7023 synth_7550 synth_7623 VDD VDD VNB|VSS
+ sky130_fd_sc_hd__edfxtp_1
X$15528 VNB|VSS synth_9494 synth_9270 synth_9802 synth_9218 VDD VDD VNB|VSS
+ sky130_fd_sc_hd__edfxtp_1
X$15529 VNB|VSS synth_1361 synth_1276 synth_1495 synth_909 VDD VDD VNB|VSS
+ sky130_fd_sc_hd__edfxtp_1
X$15530 VNB|VSS synth_8147 synth_7576 synth_4566 synth_7860 VDD VDD VNB|VSS
+ sky130_fd_sc_hd__edfxtp_1
X$15531 VNB|VSS synth_934 synth_840 synth_258 synth_767 VDD VDD VNB|VSS
+ sky130_fd_sc_hd__edfxtp_1
X$15532 VNB|VSS synth_7327 synth_7023 synth_7628 synth_7179 VDD VDD VNB|VSS
+ sky130_fd_sc_hd__edfxtp_1
X$15533 VNB|VSS synth_8299 synth_8165 synth_382 synth_8166 VDD VDD VNB|VSS
+ sky130_fd_sc_hd__edfxtp_1
X$15534 VNB|VSS synth_7928 synth_7023 synth_7977 synth_7859 VDD VDD VNB|VSS
+ sky130_fd_sc_hd__edfxtp_1
X$15535 VNB|VSS synth_1507 synth_1432 synth_1558 synth_1404 VDD VDD VNB|VSS
+ sky130_fd_sc_hd__edfxtp_1
X$15536 VNB|VSS synth_9410 synth_9270 synth_9363 synth_9218 VDD VDD VNB|VSS
+ sky130_fd_sc_hd__edfxtp_1
X$15537 VNB|VSS synth_7839 synth_7576 synth_382 synth_7860 VDD VDD VNB|VSS
+ sky130_fd_sc_hd__edfxtp_1
X$15538 VNB|VSS synth_9496 synth_9270 synth_9884 synth_9218 VDD VDD VNB|VSS
+ sky130_fd_sc_hd__edfxtp_1
X$15539 VNB|VSS synth_9213 synth_8864 synth_1695 synth_9155 VDD VDD VNB|VSS
+ sky130_fd_sc_hd__edfxtp_1
X$15540 VNB|VSS synth_7983 synth_7637 synth_6987 synth_8032 VDD VDD VNB|VSS
+ sky130_fd_sc_hd__edfxtp_1
X$15541 VNB|VSS synth_9386 synth_8864 synth_387 synth_9155 VDD VDD VNB|VSS
+ sky130_fd_sc_hd__edfxtp_1
X$15542 VNB|VSS synth_4795 synth_4505 synth_4797 synth_4497 VDD VDD VNB|VSS
+ sky130_fd_sc_hd__edfxtp_1
X$15543 VNB|VSS synth_7876 synth_7637 synth_6699 synth_7560 VDD VDD VNB|VSS
+ sky130_fd_sc_hd__edfxtp_1
X$15544 VNB|VSS synth_7476 synth_7637 synth_6564 synth_7560 VDD VDD VNB|VSS
+ sky130_fd_sc_hd__edfxtp_1
X$15545 VNB|VSS synth_6756 synth_6459 synth_4111 synth_6858 VDD VDD VNB|VSS
+ sky130_fd_sc_hd__edfxtp_1
X$15546 VNB|VSS synth_7598 synth_7637 synth_6987 synth_7560 VDD VDD VNB|VSS
+ sky130_fd_sc_hd__edfxtp_1
X$15547 VNB|VSS synth_6857 synth_6459 synth_626 synth_6858 VDD VDD VNB|VSS
+ sky130_fd_sc_hd__edfxtp_1
X$15548 VNB|VSS synth_6721 synth_6801 synth_6942 synth_6445 VDD VDD VNB|VSS
+ sky130_fd_sc_hd__edfxtp_1
X$15549 VNB|VSS synth_1777 synth_1717 synth_1776 synth_1685 VDD VDD VNB|VSS
+ sky130_fd_sc_hd__edfxtp_1
X$15550 VNB|VSS synth_7595 synth_7637 synth_6699 synth_7714 VDD VDD VNB|VSS
+ sky130_fd_sc_hd__edfxtp_1
X$15551 VNB|VSS synth_7541 synth_7190 synth_6198 synth_7162 VDD VDD VNB|VSS
+ sky130_fd_sc_hd__edfxtp_1
X$15552 VNB|VSS synth_7373 synth_7190 synth_2860 synth_7162 VDD VDD VNB|VSS
+ sky130_fd_sc_hd__edfxtp_1
X$15553 VNB|VSS synth_7650 synth_7190 synth_2860 synth_7617 VDD VDD VNB|VSS
+ sky130_fd_sc_hd__edfxtp_1
X$15554 VNB|VSS synth_7473 synth_7637 synth_6987 synth_7714 VDD VDD VNB|VSS
+ sky130_fd_sc_hd__edfxtp_1
X$15555 VNB|VSS synth_1179 synth_1345 synth_1479 synth_1232 VDD VDD VNB|VSS
+ sky130_fd_sc_hd__edfxtp_1
X$15556 VNB|VSS synth_7975 synth_7190 synth_5329 synth_7617 VDD VDD VNB|VSS
+ sky130_fd_sc_hd__edfxtp_1
X$15557 VNB|VSS synth_979 synth_48 synth_37 synth_962 VDD VDD VNB|VSS
+ sky130_fd_sc_hd__edfxtp_1
X$15558 VNB|VSS synth_1071 synth_48 synth_183 synth_962 VDD VDD VNB|VSS
+ sky130_fd_sc_hd__edfxtp_1
X$15559 VNB|VSS synth_8430 synth_7826 synth_8354 synth_8356 VDD VDD VNB|VSS
+ sky130_fd_sc_hd__edfxtp_1
X$15560 VNB|VSS synth_8193 synth_8228 synth_6564 synth_8148 VDD VDD VNB|VSS
+ sky130_fd_sc_hd__edfxtp_1
X$15561 VNB|VSS synth_2647 synth_2330 synth_2833 synth_2769 VDD VDD VNB|VSS
+ sky130_fd_sc_hd__edfxtp_1
X$15562 VNB|VSS synth_1214 synth_517 synth_258 synth_1215 VDD VDD VNB|VSS
+ sky130_fd_sc_hd__edfxtp_1
X$15563 VNB|VSS synth_397 synth_282 synth_183 synth_395 VDD VDD VNB|VSS
+ sky130_fd_sc_hd__edfxtp_1
X$15564 VNB|VSS synth_8744 synth_8315 synth_8742 synth_8628 VDD VDD VNB|VSS
+ sky130_fd_sc_hd__edfxtp_1
X$15565 VNB|VSS synth_3383 synth_3385 synth_3529 synth_3351 VDD VDD VNB|VSS
+ sky130_fd_sc_hd__edfxtp_1
X$15566 VNB|VSS synth_826 synth_568 synth_959 synth_914 VDD VDD VNB|VSS
+ sky130_fd_sc_hd__edfxtp_1
X$15567 VNB|VSS synth_3352 synth_3385 synth_3304 synth_3351 VDD VDD VNB|VSS
+ sky130_fd_sc_hd__edfxtp_1
X$15568 VNB|VSS synth_384 synth_439 synth_382 synth_395 VDD VDD VNB|VSS
+ sky130_fd_sc_hd__edfxtp_1
X$15569 VNB|VSS synth_1078 synth_517 synth_183 synth_762 VDD VDD VNB|VSS
+ sky130_fd_sc_hd__edfxtp_1
X$15570 VNB|VSS synth_1879 synth_1136 synth_183 synth_1584 VDD VDD VNB|VSS
+ sky130_fd_sc_hd__edfxtp_1
X$15571 VNB|VSS synth_6885 synth_6733 synth_7051 synth_6953 VDD VDD VNB|VSS
+ sky130_fd_sc_hd__edfxtp_1
X$15572 VNB|VSS synth_9156 synth_8864 synth_6198 synth_8842 VDD VDD VNB|VSS
+ sky130_fd_sc_hd__edfxtp_1
X$15573 VNB|VSS synth_866 synth_517 synth_449 synth_762 VDD VDD VNB|VSS
+ sky130_fd_sc_hd__edfxtp_1
X$15574 VNB|VSS synth_225 synth_36 synth_250 synth_96 VDD VDD VNB|VSS
+ sky130_fd_sc_hd__edfxtp_1
X$15575 VNB|VSS synth_373 synth_517 synth_258 synth_445 VDD VDD VNB|VSS
+ sky130_fd_sc_hd__edfxtp_1
X$15576 VNB|VSS synth_7316 synth_6733 synth_7382 synth_7249 VDD VDD VNB|VSS
+ sky130_fd_sc_hd__edfxtp_1
X$15577 VNB|VSS synth_376 synth_517 synth_449 synth_445 VDD VDD VNB|VSS
+ sky130_fd_sc_hd__edfxtp_1
X$15578 VNB|VSS synth_900 synth_54 synth_183 synth_741 VDD VDD VNB|VSS
+ sky130_fd_sc_hd__edfxtp_1
X$15579 VNB|VSS synth_1225 synth_54 synth_501 synth_1108 VDD VDD VNB|VSS
+ sky130_fd_sc_hd__edfxtp_1
X$15580 VNB|VSS synth_977 synth_54 synth_37 synth_1108 VDD VDD VNB|VSS
+ sky130_fd_sc_hd__edfxtp_1
X$15581 VNB|VSS synth_6989 synth_6733 synth_7130 synth_6953 VDD VDD VNB|VSS
+ sky130_fd_sc_hd__edfxtp_1
X$15582 VNB|VSS synth_1289 synth_1518 synth_1405 synth_1188 VDD VDD VNB|VSS
+ sky130_fd_sc_hd__edfxtp_1
X$15583 VNB|VSS synth_414 synth_282 synth_382 synth_147 VDD VDD VNB|VSS
+ sky130_fd_sc_hd__edfxtp_1
X$15584 VNB|VSS synth_256 synth_282 synth_258 synth_147 VDD VDD VNB|VSS
+ sky130_fd_sc_hd__edfxtp_1
X$15585 VNB|VSS synth_7438 synth_6890 synth_6564 synth_7277 VDD VDD VNB|VSS
+ sky130_fd_sc_hd__edfxtp_1
X$15586 VNB|VSS synth_7252 synth_6890 synth_6987 synth_7277 VDD VDD VNB|VSS
+ sky130_fd_sc_hd__edfxtp_1
X$15587 VNB|VSS synth_621 synth_568 synth_719 synth_515 VDD VDD VNB|VSS
+ sky130_fd_sc_hd__edfxtp_1
X$15588 VNB|VSS synth_5273 synth_5166 synth_966 synth_5270 VDD VDD VNB|VSS
+ sky130_fd_sc_hd__edfxtp_1
X$15589 VNB|VSS synth_5374 synth_5166 synth_3656 synth_5270 VDD VDD VNB|VSS
+ sky130_fd_sc_hd__edfxtp_1
X$15590 VNB|VSS synth_7753 synth_7644 synth_5787 synth_7565 VDD VDD VNB|VSS
+ sky130_fd_sc_hd__edfxtp_1
X$15591 VNB|VSS synth_7444 synth_7644 synth_4467 synth_7565 VDD VDD VNB|VSS
+ sky130_fd_sc_hd__edfxtp_1
X$15592 VNB|VSS synth_8145 synth_8367 synth_8366 synth_7859 VDD VDD VNB|VSS
+ sky130_fd_sc_hd__edfxtp_1
X$15593 VNB|VSS synth_3539 synth_3385 synth_3537 synth_3219 VDD VDD VNB|VSS
+ sky130_fd_sc_hd__edfxtp_1
X$15594 VNB|VSS synth_3963 synth_3806 synth_449 synth_3762 VDD VDD VNB|VSS
+ sky130_fd_sc_hd__edfxtp_1
X$15595 VNB|VSS synth_6923 synth_6890 synth_5787 synth_6845 VDD VDD VNB|VSS
+ sky130_fd_sc_hd__edfxtp_1
X$15596 VNB|VSS synth_6991 synth_6890 synth_1695 synth_6845 VDD VDD VNB|VSS
+ sky130_fd_sc_hd__edfxtp_1
X$15597 VNB|VSS synth_3875 synth_3806 synth_501 synth_3762 VDD VDD VNB|VSS
+ sky130_fd_sc_hd__edfxtp_1
X$15598 VNB|VSS synth_3236 synth_3703 synth_3600 synth_3091 VDD VDD VNB|VSS
+ sky130_fd_sc_hd__edfxtp_1
X$15599 VNB|VSS synth_7846 synth_6890 synth_6699 synth_7718 VDD VDD VNB|VSS
+ sky130_fd_sc_hd__edfxtp_1
X$15600 VNB|VSS synth_7563 synth_7144 synth_7680 synth_7253 VDD VDD VNB|VSS
+ sky130_fd_sc_hd__edfxtp_1
X$15601 VNB|VSS synth_7719 synth_6890 synth_6987 synth_7718 VDD VDD VNB|VSS
+ sky130_fd_sc_hd__edfxtp_1
X$15602 VNB|VSS synth_7642 synth_6890 synth_2777 synth_7277 VDD VDD VNB|VSS
+ sky130_fd_sc_hd__edfxtp_1
X$15603 VNB|VSS synth_7847 synth_7144 synth_7884 synth_7885 VDD VDD VNB|VSS
+ sky130_fd_sc_hd__edfxtp_1
X$15604 VNB|VSS synth_8448 synth_8165 synth_6198 synth_8166 VDD VDD VNB|VSS
+ sky130_fd_sc_hd__edfxtp_1
X$15605 VNB|VSS synth_7087 synth_6531 synth_2860 synth_6952 VDD VDD VNB|VSS
+ sky130_fd_sc_hd__edfxtp_1
X$15606 VNB|VSS synth_7010 synth_6531 synth_6699 synth_6952 VDD VDD VNB|VSS
+ sky130_fd_sc_hd__edfxtp_1
X$15607 VNB|VSS synth_7315 synth_6733 synth_7273 synth_7249 VDD VDD VNB|VSS
+ sky130_fd_sc_hd__edfxtp_1
X$15608 VNB|VSS synth_6914 synth_6733 synth_7012 synth_6953 VDD VDD VNB|VSS
+ sky130_fd_sc_hd__edfxtp_1
X$15609 VNB|VSS synth_128 synth_270 synth_249 synth_90 VDD VDD VNB|VSS
+ sky130_fd_sc_hd__edfxtp_1
X$15610 VNB|VSS synth_3447 synth_3284 synth_501 synth_3302 VDD VDD VNB|VSS
+ sky130_fd_sc_hd__edfxtp_1
X$15611 VNB|VSS synth_7011 synth_6733 synth_7136 synth_6953 VDD VDD VNB|VSS
+ sky130_fd_sc_hd__edfxtp_1
X$15612 VNB|VSS synth_742 synth_54 synth_501 synth_741 VDD VDD VNB|VSS
+ sky130_fd_sc_hd__edfxtp_1
X$15613 VNB|VSS synth_7386 synth_7144 synth_7442 synth_7222 VDD VDD VNB|VSS
+ sky130_fd_sc_hd__edfxtp_1
X$15614 VNB|VSS synth_667 synth_270 synth_706 synth_610 VDD VDD VNB|VSS
+ sky130_fd_sc_hd__edfxtp_1
X$15615 VNB|VSS synth_815 synth_270 synth_1110 synth_610 VDD VDD VNB|VSS
+ sky130_fd_sc_hd__edfxtp_1
X$15616 VNB|VSS synth_7849 synth_7644 synth_2777 synth_7886 VDD VDD VNB|VSS
+ sky130_fd_sc_hd__edfxtp_1
X$15617 VNB|VSS synth_7321 synth_6853 synth_7288 synth_7222 VDD VDD VNB|VSS
+ sky130_fd_sc_hd__edfxtp_1
X$15618 VNB|VSS synth_1254 synth_1345 synth_1399 synth_1135 VDD VDD VNB|VSS
+ sky130_fd_sc_hd__edfxtp_1
X$15619 VNB|VSS synth_7320 synth_7144 synth_7282 synth_7253 VDD VDD VNB|VSS
+ sky130_fd_sc_hd__edfxtp_1
X$15620 VNB|VSS synth_7063 synth_6853 synth_7061 synth_6491 VDD VDD VNB|VSS
+ sky130_fd_sc_hd__edfxtp_1
X$15621 VNB|VSS synth_8206 synth_7644 synth_5787 synth_7886 VDD VDD VNB|VSS
+ sky130_fd_sc_hd__edfxtp_1
X$15622 VNB|VSS synth_8068 synth_7644 synth_4467 synth_7886 VDD VDD VNB|VSS
+ sky130_fd_sc_hd__edfxtp_1
X$15623 VNB|VSS synth_5700 synth_5439 synth_3656 synth_5620 VDD VDD VNB|VSS
+ sky130_fd_sc_hd__edfxtp_1
X$15624 VNB|VSS synth_435 synth_270 synth_477 synth_90 VDD VDD VNB|VSS
+ sky130_fd_sc_hd__edfxtp_1
X$15625 VNB|VSS synth_8287 synth_7334 synth_8174 synth_8175 VDD VDD VNB|VSS
+ sky130_fd_sc_hd__edfxtp_1
X$15626 VNB|VSS synth_847 synth_578 synth_626 synth_767 VDD VDD VNB|VSS
+ sky130_fd_sc_hd__edfxtp_1
X$15627 VNB|VSS synth_6861 synth_6824 synth_4588 synth_6626 VDD VDD VNB|VSS
+ sky130_fd_sc_hd__edfxtp_1
X$15628 VNB|VSS synth_7967 synth_7335 synth_4588 synth_7895 VDD VDD VNB|VSS
+ sky130_fd_sc_hd__edfxtp_1
X$15629 VNB|VSS synth_8860 synth_9045 synth_8983 synth_8999 VDD VDD VNB|VSS
+ sky130_fd_sc_hd__edfxtp_1
X$15630 VNB|VSS synth_6982 synth_6927 synth_6980 synth_7068 VDD VDD VNB|VSS
+ sky130_fd_sc_hd__edfxtp_1
X$15631 VNB|VSS synth_2943 synth_2044 synth_1181 synth_2920 VDD VDD VNB|VSS
+ sky130_fd_sc_hd__edfxtp_1
X$15632 VNB|VSS synth_8088 synth_7490 synth_382 synth_7895 VDD VDD VNB|VSS
+ sky130_fd_sc_hd__edfxtp_1
X$15633 VNB|VSS synth_8793 synth_9045 synth_8846 synth_8999 VDD VDD VNB|VSS
+ sky130_fd_sc_hd__edfxtp_1
X$15634 VNB|VSS synth_2944 synth_2268 synth_2861 synth_2839 VDD VDD VNB|VSS
+ sky130_fd_sc_hd__edfxtp_1
X$15635 VNB|VSS synth_9159 synth_8165 synth_1695 synth_8841 VDD VDD VNB|VSS
+ sky130_fd_sc_hd__edfxtp_1
X$15636 VNB|VSS synth_9505 synth_9045 synth_9472 synth_9225 VDD VDD VNB|VSS
+ sky130_fd_sc_hd__edfxtp_1
X$15637 VNB|VSS synth_9665 synth_9760 synth_9966 synth_9225 VDD VDD VNB|VSS
+ sky130_fd_sc_hd__edfxtp_1
X$15638 VNB|VSS synth_917 synth_571 synth_1083 synth_645 VDD VDD VNB|VSS
+ sky130_fd_sc_hd__edfxtp_1
X$15639 VNB|VSS synth_4424 synth_4422 synth_4423 synth_3809 VDD VDD VNB|VSS
+ sky130_fd_sc_hd__edfxtp_1
X$15640 VNB|VSS synth_1198 synth_521 synth_1537 synth_1197 VDD VDD VNB|VSS
+ sky130_fd_sc_hd__edfxtp_1
X$15641 VNB|VSS synth_4663 synth_4422 synth_4641 synth_4442 VDD VDD VNB|VSS
+ sky130_fd_sc_hd__edfxtp_1
X$15642 VNB|VSS synth_7797 synth_7335 synth_4588 synth_7585 VDD VDD VNB|VSS
+ sky130_fd_sc_hd__edfxtp_1
X$15643 VNB|VSS synth_7689 synth_7335 synth_6198 synth_7585 VDD VDD VNB|VSS
+ sky130_fd_sc_hd__edfxtp_1
X$15644 VNB|VSS synth_4557 synth_4505 synth_4498 synth_4497 VDD VDD VNB|VSS
+ sky130_fd_sc_hd__edfxtp_1
X$15645 VNB|VSS synth_9195 synth_8928 synth_6987 synth_9128 VDD VDD VNB|VSS
+ sky130_fd_sc_hd__edfxtp_1
X$15646 VNB|VSS synth_9210 synth_9102 synth_387 synth_9147 VDD VDD VNB|VSS
+ sky130_fd_sc_hd__edfxtp_1
X$15647 VNB|VSS synth_7243 synth_6583 synth_3656 synth_7110 VDD VDD VNB|VSS
+ sky130_fd_sc_hd__edfxtp_1
X$15648 VNB|VSS synth_190 synth_51 synth_480 synth_50 VDD VDD VNB|VSS
+ sky130_fd_sc_hd__edfxtp_1
X$15649 VNB|VSS synth_5619 synth_5166 synth_3656 synth_5454 VDD VDD VNB|VSS
+ sky130_fd_sc_hd__edfxtp_1
X$15650 VNB|VSS synth_4193 synth_4422 synth_4323 synth_4166 VDD VDD VNB|VSS
+ sky130_fd_sc_hd__edfxtp_1
X$15651 VNB|VSS synth_6120 synth_6454 synth_6810 synth_6420 VDD VDD VNB|VSS
+ sky130_fd_sc_hd__edfxtp_1
X$15652 VNB|VSS synth_9819 synth_9102 synth_6564 synth_9660 VDD VDD VNB|VSS
+ sky130_fd_sc_hd__edfxtp_1
X$15653 VNB|VSS synth_5429 synth_5166 synth_626 synth_5454 VDD VDD VNB|VSS
+ sky130_fd_sc_hd__edfxtp_1
X$15654 VNB|VSS synth_1190 synth_568 synth_1187 synth_1188 VDD VDD VNB|VSS
+ sky130_fd_sc_hd__edfxtp_1
X$15655 VNB|VSS synth_407 synth_446 synth_258 synth_401 VDD VDD VNB|VSS
+ sky130_fd_sc_hd__edfxtp_1
X$15656 VNB|VSS synth_2334 synth_1717 synth_2513 synth_2473 VDD VDD VNB|VSS
+ sky130_fd_sc_hd__edfxtp_1
X$15657 VNB|VSS synth_9154 synth_8863 synth_9151 synth_9152 VDD VDD VNB|VSS
+ sky130_fd_sc_hd__edfxtp_1
X$15658 VNB|VSS synth_7498 synth_6927 synth_7526 synth_7445 VDD VDD VNB|VSS
+ sky130_fd_sc_hd__edfxtp_1
X$15659 VNB|VSS synth_7666 synth_7868 synth_7827 synth_7445 VDD VDD VNB|VSS
+ sky130_fd_sc_hd__edfxtp_1
X$15660 VNB|VSS synth_7667 synth_7868 synth_7869 synth_7445 VDD VDD VNB|VSS
+ sky130_fd_sc_hd__edfxtp_1
X$15661 VNB|VSS synth_7792 synth_7334 synth_7791 synth_7413 VDD VDD VNB|VSS
+ sky130_fd_sc_hd__edfxtp_1
X$15662 VNB|VSS synth_7544 synth_7115 synth_7455 synth_7413 VDD VDD VNB|VSS
+ sky130_fd_sc_hd__edfxtp_1
X$15663 VNB|VSS synth_9317 synth_8863 synth_9287 synth_9152 VDD VDD VNB|VSS
+ sky130_fd_sc_hd__edfxtp_1
X$15664 VNB|VSS synth_5188 synth_5087 synth_5168 synth_4942 VDD VDD VNB|VSS
+ sky130_fd_sc_hd__edfxtp_1
X$15665 VNB|VSS synth_9420 synth_9760 synth_9556 synth_9152 VDD VDD VNB|VSS
+ sky130_fd_sc_hd__edfxtp_1
X$15666 VNB|VSS synth_9693 synth_9760 synth_9667 synth_9152 VDD VDD VNB|VSS
+ sky130_fd_sc_hd__edfxtp_1
X$15667 VNB|VSS synth_8830 synth_8380 synth_8791 synth_8790 VDD VDD VNB|VSS
+ sky130_fd_sc_hd__edfxtp_1
X$15668 VNB|VSS synth_2791 synth_2533 synth_3072 synth_2769 VDD VDD VNB|VSS
+ sky130_fd_sc_hd__edfxtp_1
X$15669 VNB|VSS synth_6680 synth_6815 synth_6775 synth_6813 VDD VDD VNB|VSS
+ sky130_fd_sc_hd__edfxtp_1
X$15670 VNB|VSS synth_9161 synth_9402 synth_9403 synth_8929 VDD VDD VNB|VSS
+ sky130_fd_sc_hd__edfxtp_1
X$15671 VNB|VSS synth_9569 synth_9402 synth_9640 synth_9601 VDD VDD VNB|VSS
+ sky130_fd_sc_hd__edfxtp_1
X$15672 VNB|VSS synth_530 synth_578 synth_258 synth_533 VDD VDD VNB|VSS
+ sky130_fd_sc_hd__edfxtp_1
X$15673 VNB|VSS synth_164 synth_450 synth_403 synth_9 VDD VDD VNB|VSS
+ sky130_fd_sc_hd__edfxtp_1
X$15674 VNB|VSS synth_9623 synth_9291 synth_9612 synth_9573 VDD VDD VNB|VSS
+ sky130_fd_sc_hd__edfxtp_1
X$15675 VNB|VSS synth_240 synth_33 synth_160 synth_9 VDD VDD VNB|VSS
+ sky130_fd_sc_hd__edfxtp_1
X$15676 VNB|VSS synth_9979 synth_9291 synth_9975 synth_9898 VDD VDD VNB|VSS
+ sky130_fd_sc_hd__edfxtp_1
X$15677 VNB|VSS synth_9319 synth_8864 synth_4467 synth_9227 VDD VDD VNB|VSS
+ sky130_fd_sc_hd__edfxtp_1
X$15678 VNB|VSS synth_9318 synth_8864 synth_6198 synth_9227 VDD VDD VNB|VSS
+ sky130_fd_sc_hd__edfxtp_1
X$15679 VNB|VSS synth_8574 synth_8488 synth_8452 synth_8451 VDD VDD VNB|VSS
+ sky130_fd_sc_hd__edfxtp_1
X$15680 VNB|VSS synth_9348 synth_8928 synth_6564 synth_9128 VDD VDD VNB|VSS
+ sky130_fd_sc_hd__edfxtp_1
X$15681 VNB|VSS synth_9398 synth_8928 synth_8337 synth_9128 VDD VDD VNB|VSS
+ sky130_fd_sc_hd__edfxtp_1
X$15682 VNB|VSS synth_7235 synth_7335 synth_382 synth_7034 VDD VDD VNB|VSS
+ sky130_fd_sc_hd__edfxtp_1
X$15683 VNB|VSS synth_9746 synth_9754 synth_6699 synth_9874 VDD VDD VNB|VSS
+ sky130_fd_sc_hd__edfxtp_1
X$15684 VNB|VSS synth_9022 synth_8928 synth_6699 synth_8816 VDD VDD VNB|VSS
+ sky130_fd_sc_hd__edfxtp_1
X$15685 VNB|VSS synth_8817 synth_8228 synth_6987 synth_8816 VDD VDD VNB|VSS
+ sky130_fd_sc_hd__edfxtp_1
X$15686 VNB|VSS synth_8532 synth_8228 synth_6564 synth_8492 VDD VDD VNB|VSS
+ sky130_fd_sc_hd__edfxtp_1
X$15687 VNB|VSS synth_1559 synth_571 synth_1489 synth_1491 VDD VDD VNB|VSS
+ sky130_fd_sc_hd__edfxtp_1
X$15688 VNB|VSS synth_8576 synth_8228 synth_6987 synth_8492 VDD VDD VNB|VSS
+ sky130_fd_sc_hd__edfxtp_1
X$15689 VNB|VSS synth_1250 synth_1345 synth_1554 synth_1135 VDD VDD VNB|VSS
+ sky130_fd_sc_hd__edfxtp_1
X$15690 VNB|VSS synth_9624 synth_9291 synth_9574 synth_9573 VDD VDD VNB|VSS
+ sky130_fd_sc_hd__edfxtp_1
X$15691 VNB|VSS synth_8689 synth_8367 synth_8629 synth_8628 VDD VDD VNB|VSS
+ sky130_fd_sc_hd__edfxtp_1
X$15692 VNB|VSS synth_339 synth_270 synth_472 synth_90 VDD VDD VNB|VSS
+ sky130_fd_sc_hd__edfxtp_1
X$15693 VNB|VSS synth_476 synth_54 synth_183 synth_182 VDD VDD VNB|VSS
+ sky130_fd_sc_hd__edfxtp_1
X$15694 VNB|VSS synth_8293 synth_7490 synth_382 synth_8045 VDD VDD VNB|VSS
+ sky130_fd_sc_hd__edfxtp_1
X$15695 VNB|VSS synth_8614 synth_8367 synth_8611 synth_8469 VDD VDD VNB|VSS
+ sky130_fd_sc_hd__edfxtp_1
X$15696 VNB|VSS synth_8869 synth_8165 synth_387 synth_8841 VDD VDD VNB|VSS
+ sky130_fd_sc_hd__edfxtp_1
X$15697 VNB|VSS synth_8800 synth_8165 synth_6198 synth_8841 VDD VDD VNB|VSS
+ sky130_fd_sc_hd__edfxtp_1
X$15698 VNB|VSS synth_9535 synth_9402 synth_9600 synth_9601 VDD VDD VNB|VSS
+ sky130_fd_sc_hd__edfxtp_1
X$15699 VNB|VSS synth_2993 synth_3025 synth_1181 synth_2913 VDD VDD VNB|VSS
+ sky130_fd_sc_hd__edfxtp_1
X$15700 VNB|VSS synth_2721 synth_3025 synth_1459 synth_2913 VDD VDD VNB|VSS
+ sky130_fd_sc_hd__edfxtp_1
X$15701 VNB|VSS synth_4286 synth_3794 synth_626 synth_4227 VDD VDD VNB|VSS
+ sky130_fd_sc_hd__edfxtp_1
X$15702 VNB|VSS synth_9294 synth_8928 synth_8337 synth_8992 VDD VDD VNB|VSS
+ sky130_fd_sc_hd__edfxtp_1
X$15703 VNB|VSS synth_2265 synth_2330 synth_2692 synth_2473 VDD VDD VNB|VSS
+ sky130_fd_sc_hd__edfxtp_1
X$15704 VNB|VSS synth_9132 synth_8928 synth_6987 synth_8992 VDD VDD VNB|VSS
+ sky130_fd_sc_hd__edfxtp_1
X$15705 VNB|VSS synth_9024 synth_8928 synth_6699 synth_8992 VDD VDD VNB|VSS
+ sky130_fd_sc_hd__edfxtp_1
X$15706 VNB|VSS synth_8696 synth_8488 synth_8818 synth_8451 VDD VDD VNB|VSS
+ sky130_fd_sc_hd__edfxtp_1
X$15707 VNB|VSS synth_8786 synth_8864 synth_4467 synth_8842 VDD VDD VNB|VSS
+ sky130_fd_sc_hd__edfxtp_1
X$15708 VNB|VSS synth_9004 synth_8864 synth_387 synth_8842 VDD VDD VNB|VSS
+ sky130_fd_sc_hd__edfxtp_1
X$15709 VNB|VSS synth_579 synth_578 synth_183 synth_533 VDD VDD VNB|VSS
+ sky130_fd_sc_hd__edfxtp_1
X$15710 VNB|VSS synth_1368 synth_517 synth_183 synth_1215 VDD VDD VNB|VSS
+ sky130_fd_sc_hd__edfxtp_1
X$15711 VNB|VSS synth_9793 synth_9402 synth_9839 synth_9711 VDD VDD VNB|VSS
+ sky130_fd_sc_hd__edfxtp_1
X$15712 VNB|VSS synth_7364 synth_7490 synth_6198 synth_7458 VDD VDD VNB|VSS
+ sky130_fd_sc_hd__edfxtp_1
X$15713 VNB|VSS synth_7734 synth_7490 synth_4588 synth_7458 VDD VDD VNB|VSS
+ sky130_fd_sc_hd__edfxtp_1
X$15714 VNB|VSS synth_6238 synth_6237 synth_4111 synth_6151 VDD VDD VNB|VSS
+ sky130_fd_sc_hd__edfxtp_1
X$15715 VNB|VSS synth_6206 synth_6237 synth_4588 synth_6151 VDD VDD VNB|VSS
+ sky130_fd_sc_hd__edfxtp_1
X$15716 VNB|VSS synth_1162 synth_557 synth_501 synth_949 VDD VDD VNB|VSS
+ sky130_fd_sc_hd__edfxtp_1
X$15717 VNB|VSS synth_5959 synth_5016 synth_626 synth_5820 VDD VDD VNB|VSS
+ sky130_fd_sc_hd__edfxtp_1
X$15718 VNB|VSS synth_6074 synth_5016 synth_4588 synth_5820 VDD VDD VNB|VSS
+ sky130_fd_sc_hd__edfxtp_1
X$15719 VNB|VSS synth_5562 synth_4934 synth_5592 synth_5316 VDD VDD VNB|VSS
+ sky130_fd_sc_hd__edfxtp_1
X$15720 VNB|VSS synth_2664 synth_2602 synth_2735 synth_2442 VDD VDD VNB|VSS
+ sky130_fd_sc_hd__edfxtp_1
X$15721 VNB|VSS synth_11029 synth_10467 synth_6564 synth_10918 VDD VDD VNB|VSS
+ sky130_fd_sc_hd__edfxtp_1
X$15722 VNB|VSS synth_5389 synth_4657 synth_4111 synth_5255 VDD VDD VNB|VSS
+ sky130_fd_sc_hd__edfxtp_1
X$15723 VNB|VSS synth_6346 synth_6347 synth_6296 synth_6279 VDD VDD VNB|VSS
+ sky130_fd_sc_hd__edfxtp_1
X$15724 VNB|VSS synth_5975 synth_5407 synth_5329 synth_5974 VDD VDD VNB|VSS
+ sky130_fd_sc_hd__edfxtp_1
X$15725 VNB|VSS synth_6543 synth_5953 synth_6511 synth_6445 VDD VDD VNB|VSS
+ sky130_fd_sc_hd__edfxtp_1
X$15726 VNB|VSS synth_5907 synth_5016 synth_4111 synth_5820 VDD VDD VNB|VSS
+ sky130_fd_sc_hd__edfxtp_1
X$15727 VNB|VSS synth_5205 synth_5159 synth_5208 synth_4939 VDD VDD VNB|VSS
+ sky130_fd_sc_hd__edfxtp_1
X$15728 VNB|VSS synth_10340 synth_9811 synth_10302 synth_10301 VDD VDD VNB|VSS
+ sky130_fd_sc_hd__edfxtp_1
X$15729 VNB|VSS synth_6200 synth_6454 synth_6281 synth_6420 VDD VDD VNB|VSS
+ sky130_fd_sc_hd__edfxtp_1
X$15730 VNB|VSS synth_10357 synth_10355 synth_6699 synth_10426 VDD VDD VNB|VSS
+ sky130_fd_sc_hd__edfxtp_1
X$15731 VNB|VSS synth_10571 synth_10355 synth_6987 synth_10426 VDD VDD VNB|VSS
+ sky130_fd_sc_hd__edfxtp_1
X$15732 VNB|VSS synth_5985 synth_5478 synth_6057 synth_5611 VDD VDD VNB|VSS
+ sky130_fd_sc_hd__edfxtp_1
X$15733 VNB|VSS synth_11049 synth_10538 synth_6564 synth_10857 VDD VDD VNB|VSS
+ sky130_fd_sc_hd__edfxtp_1
X$15734 VNB|VSS synth_10702 synth_10804 synth_10876 synth_10465 VDD VDD VNB|VSS
+ sky130_fd_sc_hd__edfxtp_1
X$15735 VNB|VSS synth_203 synth_89 synth_468 synth_177 VDD VDD VNB|VSS
+ sky130_fd_sc_hd__edfxtp_1
X$15736 VNB|VSS synth_5665 synth_5303 synth_5706 synth_5558 VDD VDD VNB|VSS
+ sky130_fd_sc_hd__edfxtp_1
X$15737 VNB|VSS synth_9918 synth_9760 synth_9973 synth_9917 VDD VDD VNB|VSS
+ sky130_fd_sc_hd__edfxtp_1
X$15738 VNB|VSS synth_7208 synth_6929 synth_7268 synth_6976 VDD VDD VNB|VSS
+ sky130_fd_sc_hd__edfxtp_1
X$15739 VNB|VSS synth_1393 synth_557 synth_501 synth_1248 VDD VDD VNB|VSS
+ sky130_fd_sc_hd__edfxtp_1
X$15740 VNB|VSS synth_10434 synth_9896 synth_6198 synth_10279 VDD VDD VNB|VSS
+ sky130_fd_sc_hd__edfxtp_1
X$15741 VNB|VSS synth_786 synth_557 synth_88 synth_949 VDD VDD VNB|VSS
+ sky130_fd_sc_hd__edfxtp_1
X$15742 VNB|VSS synth_5555 synth_5008 synth_387 synth_5590 VDD VDD VNB|VSS
+ sky130_fd_sc_hd__edfxtp_1
X$15743 VNB|VSS synth_5664 synth_5008 synth_1695 synth_5590 VDD VDD VNB|VSS
+ sky130_fd_sc_hd__edfxtp_1
X$15744 VNB|VSS synth_7036 synth_6929 synth_7075 synth_6976 VDD VDD VNB|VSS
+ sky130_fd_sc_hd__edfxtp_1
X$15745 VNB|VSS synth_11109 synth_10467 synth_6987 synth_10918 VDD VDD VNB|VSS
+ sky130_fd_sc_hd__edfxtp_1
X$15746 VNB|VSS synth_6814 synth_6815 synth_6812 synth_6813 VDD VDD VNB|VSS
+ sky130_fd_sc_hd__edfxtp_1
X$15747 VNB|VSS synth_5010 synth_5327 synth_5296 synth_4787 VDD VDD VNB|VSS
+ sky130_fd_sc_hd__edfxtp_1
X$15748 VNB|VSS synth_11673 synth_11536 synth_387 synth_11717 VDD VDD VNB|VSS
+ sky130_fd_sc_hd__edfxtp_1
X$15749 VNB|VSS synth_8322 synth_8553 synth_8605 synth_7864 VDD VDD VNB|VSS
+ sky130_fd_sc_hd__edfxtp_1
X$15750 VNB|VSS synth_8594 synth_7534 synth_387 synth_8352 VDD VDD VNB|VSS
+ sky130_fd_sc_hd__edfxtp_1
X$15751 VNB|VSS synth_4223 synth_3794 synth_966 synth_4227 VDD VDD VNB|VSS
+ sky130_fd_sc_hd__edfxtp_1
X$15752 VNB|VSS synth_8858 synth_8380 synth_8906 synth_8999 VDD VDD VNB|VSS
+ sky130_fd_sc_hd__edfxtp_1
X$15753 VNB|VSS synth_7938 synth_6939 synth_7973 synth_7864 VDD VDD VNB|VSS
+ sky130_fd_sc_hd__edfxtp_1
X$15754 VNB|VSS synth_4370 synth_3569 synth_4495 synth_4151 VDD VDD VNB|VSS
+ sky130_fd_sc_hd__edfxtp_1
X$15755 VNB|VSS synth_4977 synth_4505 synth_4938 synth_4939 VDD VDD VNB|VSS
+ sky130_fd_sc_hd__edfxtp_1
X$15756 VNB|VSS synth_7200 synth_6939 synth_7262 synth_6651 VDD VDD VNB|VSS
+ sky130_fd_sc_hd__edfxtp_1
X$15757 VNB|VSS synth_5652 synth_4836 synth_4588 synth_5073 VDD VDD VNB|VSS
+ sky130_fd_sc_hd__edfxtp_1
X$15758 VNB|VSS synth_5147 synth_5249 synth_4111 synth_5414 VDD VDD VNB|VSS
+ sky130_fd_sc_hd__edfxtp_1
X$15759 VNB|VSS synth_5468 synth_5249 synth_4588 synth_5414 VDD VDD VNB|VSS
+ sky130_fd_sc_hd__edfxtp_1
X$15760 VNB|VSS synth_1173 synth_1423 synth_1339 synth_1105 VDD VDD VNB|VSS
+ sky130_fd_sc_hd__edfxtp_1
X$15761 VNB|VSS synth_12268 synth_11849 synth_8337 synth_12165 VDD VDD VNB|VSS
+ sky130_fd_sc_hd__edfxtp_1
X$15762 VNB|VSS synth_12356 synth_12163 synth_12333 synth_12295 VDD VDD VNB|VSS
+ sky130_fd_sc_hd__edfxtp_1
X$15763 VNB|VSS synth_12440 synth_12163 synth_12438 synth_12401 VDD VDD VNB|VSS
+ sky130_fd_sc_hd__edfxtp_1
X$15764 VNB|VSS synth_10116 synth_9754 synth_8337 synth_9874 VDD VDD VNB|VSS
+ sky130_fd_sc_hd__edfxtp_1
X$15765 VNB|VSS synth_10525 synth_9754 synth_6699 synth_10325 VDD VDD VNB|VSS
+ sky130_fd_sc_hd__edfxtp_1
X$15766 VNB|VSS synth_5428 synth_5715 synth_5713 synth_4939 VDD VDD VNB|VSS
+ sky130_fd_sc_hd__edfxtp_1
X$15767 VNB|VSS synth_5305 synth_5249 synth_449 synth_5304 VDD VDD VNB|VSS
+ sky130_fd_sc_hd__edfxtp_1
X$15768 VNB|VSS synth_10397 synth_9754 synth_6987 synth_10325 VDD VDD VNB|VSS
+ sky130_fd_sc_hd__edfxtp_1
X$15769 VNB|VSS synth_5786 synth_5217 synth_4588 synth_5669 VDD VDD VNB|VSS
+ sky130_fd_sc_hd__edfxtp_1
X$15770 VNB|VSS synth_5409 synth_5217 synth_4588 synth_5304 VDD VDD VNB|VSS
+ sky130_fd_sc_hd__edfxtp_1
X$15771 VNB|VSS synth_2667 synth_1898 synth_2597 synth_2596 VDD VDD VNB|VSS
+ sky130_fd_sc_hd__edfxtp_1
X$15772 VNB|VSS synth_2890 synth_2602 synth_3049 synth_2596 VDD VDD VNB|VSS
+ sky130_fd_sc_hd__edfxtp_1
X$15773 VNB|VSS synth_12514 synth_12163 synth_12790 synth_12401 VDD VDD VNB|VSS
+ sky130_fd_sc_hd__edfxtp_1
X$15774 VNB|VSS synth_2551 synth_1906 synth_2497 synth_2442 VDD VDD VNB|VSS
+ sky130_fd_sc_hd__edfxtp_1
X$15775 VNB|VSS synth_5745 synth_5303 synth_5711 synth_5670 VDD VDD VNB|VSS
+ sky130_fd_sc_hd__edfxtp_1
X$15776 VNB|VSS synth_6337 synth_5953 synth_6412 synth_6335 VDD VDD VNB|VSS
+ sky130_fd_sc_hd__edfxtp_1
X$15777 VNB|VSS synth_6365 synth_5327 synth_6509 synth_6335 VDD VDD VNB|VSS
+ sky130_fd_sc_hd__edfxtp_1
X$15778 VNB|VSS synth_5943 synth_5082 synth_4588 synth_5853 VDD VDD VNB|VSS
+ sky130_fd_sc_hd__edfxtp_1
X$15779 VNB|VSS synth_10712 synth_10355 synth_6564 synth_10709 VDD VDD VNB|VSS
+ sky130_fd_sc_hd__edfxtp_1
X$15780 VNB|VSS synth_6030 synth_5082 synth_3656 synth_5853 VDD VDD VNB|VSS
+ sky130_fd_sc_hd__edfxtp_1
X$15781 VNB|VSS synth_5061 synth_5008 synth_4566 synth_5108 VDD VDD VNB|VSS
+ sky130_fd_sc_hd__edfxtp_1
X$15782 VNB|VSS synth_11207 synth_10628 synth_11352 synth_11079 VDD VDD VNB|VSS
+ sky130_fd_sc_hd__edfxtp_1
X$15783 VNB|VSS synth_6246 synth_5082 synth_626 synth_5853 VDD VDD VNB|VSS
+ sky130_fd_sc_hd__edfxtp_1
X$15784 VNB|VSS synth_1132 synth_699 synth_387 synth_940 VDD VDD VNB|VSS
+ sky130_fd_sc_hd__edfxtp_1
X$15785 VNB|VSS synth_5406 synth_4833 synth_5456 synth_5455 VDD VDD VNB|VSS
+ sky130_fd_sc_hd__edfxtp_1
X$15786 VNB|VSS synth_11855 synth_11849 synth_6564 synth_11835 VDD VDD VNB|VSS
+ sky130_fd_sc_hd__edfxtp_1
X$15787 VNB|VSS synth_5865 synth_5327 synth_5864 synth_5455 VDD VDD VNB|VSS
+ sky130_fd_sc_hd__edfxtp_1
X$15788 VNB|VSS synth_5071 synth_5227 synth_5233 synth_5069 VDD VDD VNB|VSS
+ sky130_fd_sc_hd__edfxtp_1
X$15789 VNB|VSS synth_5146 synth_5227 synth_5311 synth_5069 VDD VDD VNB|VSS
+ sky130_fd_sc_hd__edfxtp_1
X$15790 VNB|VSS synth_6307 synth_5715 synth_6324 synth_5990 VDD VDD VNB|VSS
+ sky130_fd_sc_hd__edfxtp_1
X$15791 VNB|VSS synth_6555 synth_6611 synth_4588 synth_6505 VDD VDD VNB|VSS
+ sky130_fd_sc_hd__edfxtp_1
X$15792 VNB|VSS synth_5070 synth_5227 synth_5228 synth_5069 VDD VDD VNB|VSS
+ sky130_fd_sc_hd__edfxtp_1
X$15793 VNB|VSS synth_11423 synth_10549 synth_6699 synth_11421 VDD VDD VNB|VSS
+ sky130_fd_sc_hd__edfxtp_1
X$15794 VNB|VSS synth_5072 synth_5227 synth_5310 synth_5069 VDD VDD VNB|VSS
+ sky130_fd_sc_hd__edfxtp_1
X$15795 VNB|VSS synth_8699 synth_7814 synth_8722 synth_8453 VDD VDD VNB|VSS
+ sky130_fd_sc_hd__edfxtp_1
X$15796 VNB|VSS synth_11852 synth_11849 synth_6699 synth_11835 VDD VDD VNB|VSS
+ sky130_fd_sc_hd__edfxtp_1
X$15797 VNB|VSS synth_5248 synth_5008 synth_387 synth_5108 VDD VDD VNB|VSS
+ sky130_fd_sc_hd__edfxtp_1
X$15798 VNB|VSS synth_348 synth_443 synth_88 synth_488 VDD VDD VNB|VSS
+ sky130_fd_sc_hd__edfxtp_1
X$15799 VNB|VSS synth_915 synth_443 synth_183 synth_911 VDD VDD VNB|VSS
+ sky130_fd_sc_hd__edfxtp_1
X$15800 VNB|VSS synth_3260 synth_3242 synth_966 synth_3181 VDD VDD VNB|VSS
+ sky130_fd_sc_hd__edfxtp_1
X$15801 VNB|VSS synth_2849 synth_2730 synth_3153 synth_2869 VDD VDD VNB|VSS
+ sky130_fd_sc_hd__edfxtp_1
X$15802 VNB|VSS synth_3788 synth_3122 synth_3723 synth_3180 VDD VDD VNB|VSS
+ sky130_fd_sc_hd__edfxtp_1
X$15803 VNB|VSS synth_3991 synth_2804 synth_626 synth_3972 VDD VDD VNB|VSS
+ sky130_fd_sc_hd__edfxtp_1
X$15804 VNB|VSS synth_961 synth_443 synth_966 synth_911 VDD VDD VNB|VSS
+ sky130_fd_sc_hd__edfxtp_1
X$15805 VNB|VSS synth_10882 synth_9986 synth_10881 synth_10880 VDD VDD VNB|VSS
+ sky130_fd_sc_hd__edfxtp_1
X$15806 VNB|VSS synth_5559 synth_4833 synth_5609 synth_5558 VDD VDD VNB|VSS
+ sky130_fd_sc_hd__edfxtp_1
X$15807 VNB|VSS synth_11726 synth_10090 synth_11746 synth_11672 VDD VDD VNB|VSS
+ sky130_fd_sc_hd__edfxtp_1
X$15808 VNB|VSS synth_4317 synth_4264 synth_2860 synth_4315 VDD VDD VNB|VSS
+ sky130_fd_sc_hd__edfxtp_1
X$15809 VNB|VSS synth_4565 synth_4264 synth_1459 synth_4315 VDD VDD VNB|VSS
+ sky130_fd_sc_hd__edfxtp_1
X$15810 VNB|VSS synth_3643 synth_3122 synth_3644 synth_3180 VDD VDD VNB|VSS
+ sky130_fd_sc_hd__edfxtp_1
X$15811 VNB|VSS synth_1409 synth_1280 synth_966 synth_1219 VDD VDD VNB|VSS
+ sky130_fd_sc_hd__edfxtp_1
X$15812 VNB|VSS synth_10531 synth_9986 synth_10704 synth_10465 VDD VDD VNB|VSS
+ sky130_fd_sc_hd__edfxtp_1
X$15813 VNB|VSS synth_3040 synth_2205 synth_3144 synth_2592 VDD VDD VNB|VSS
+ sky130_fd_sc_hd__edfxtp_1
X$15814 VNB|VSS synth_1929 synth_1280 synth_449 synth_1643 VDD VDD VNB|VSS
+ sky130_fd_sc_hd__edfxtp_1
X$15815 VNB|VSS synth_12104 synth_11719 synth_12297 synth_11927 VDD VDD VNB|VSS
+ sky130_fd_sc_hd__edfxtp_1
X$15816 VNB|VSS synth_4411 synth_4264 synth_387 synth_4486 VDD VDD VNB|VSS
+ sky130_fd_sc_hd__edfxtp_1
X$15817 VNB|VSS synth_1284 synth_1280 synth_183 synth_1219 VDD VDD VNB|VSS
+ sky130_fd_sc_hd__edfxtp_1
X$15818 VNB|VSS synth_68 synth_25 synth_24 synth_23 VDD VDD VNB|VSS
+ sky130_fd_sc_hd__edfxtp_1
X$15819 VNB|VSS synth_358 synth_521 synth_583 synth_23 VDD VDD VNB|VSS
+ sky130_fd_sc_hd__edfxtp_1
X$15820 VNB|VSS synth_10466 synth_9986 synth_10419 synth_10465 VDD VDD VNB|VSS
+ sky130_fd_sc_hd__edfxtp_1
X$15821 VNB|VSS synth_10120 synth_9986 synth_10243 synth_9838 VDD VDD VNB|VSS
+ sky130_fd_sc_hd__edfxtp_1
X$15822 VNB|VSS synth_10749 synth_10467 synth_6987 synth_10748 VDD VDD VNB|VSS
+ sky130_fd_sc_hd__edfxtp_1
X$15823 VNB|VSS synth_11484 synth_10804 synth_11407 synth_11363 VDD VDD VNB|VSS
+ sky130_fd_sc_hd__edfxtp_1
X$15824 VNB|VSS synth_3375 synth_3374 synth_3342 synth_3298 VDD VDD VNB|VSS
+ sky130_fd_sc_hd__edfxtp_1
X$15825 VNB|VSS synth_3680 synth_3557 synth_1337 synth_3515 VDD VDD VNB|VSS
+ sky130_fd_sc_hd__edfxtp_1
X$15826 VNB|VSS synth_3459 synth_3557 synth_1908 synth_3515 VDD VDD VNB|VSS
+ sky130_fd_sc_hd__edfxtp_1
X$15827 VNB|VSS synth_12211 synth_11379 synth_8337 synth_12047 VDD VDD VNB|VSS
+ sky130_fd_sc_hd__edfxtp_1
X$15828 VNB|VSS synth_3241 synth_3122 synth_3268 synth_3180 VDD VDD VNB|VSS
+ sky130_fd_sc_hd__edfxtp_1
X$15829 VNB|VSS synth_3941 synth_3557 synth_1181 synth_3515 VDD VDD VNB|VSS
+ sky130_fd_sc_hd__edfxtp_1
X$15830 VNB|VSS synth_11031 synth_10804 synth_11230 synth_10880 VDD VDD VNB|VSS
+ sky130_fd_sc_hd__edfxtp_1
X$15831 VNB|VSS synth_3266 synth_3242 synth_966 synth_3204 VDD VDD VNB|VSS
+ sky130_fd_sc_hd__edfxtp_1
X$15832 VNB|VSS synth_388 synth_235 synth_387 synth_236 VDD VDD VNB|VSS
+ sky130_fd_sc_hd__edfxtp_1
X$15833 VNB|VSS synth_3602 synth_3818 synth_3752 synth_3295 VDD VDD VNB|VSS
+ sky130_fd_sc_hd__edfxtp_1
X$15834 VNB|VSS synth_3246 synth_2602 synth_3183 synth_3182 VDD VDD VNB|VSS
+ sky130_fd_sc_hd__edfxtp_1
X$15835 VNB|VSS synth_3628 synth_3025 synth_1181 synth_3454 VDD VDD VNB|VSS
+ sky130_fd_sc_hd__edfxtp_1
X$15836 VNB|VSS synth_3253 synth_2602 synth_3259 synth_3185 VDD VDD VNB|VSS
+ sky130_fd_sc_hd__edfxtp_1
X$15837 VNB|VSS synth_3792 synth_3557 synth_382 synth_3515 VDD VDD VNB|VSS
+ sky130_fd_sc_hd__edfxtp_1
X$15838 VNB|VSS synth_3996 synth_4019 synth_3999 synth_3998 VDD VDD VNB|VSS
+ sky130_fd_sc_hd__edfxtp_1
X$15839 VNB|VSS synth_2284 synth_2080 synth_2387 synth_2129 VDD VDD VNB|VSS
+ sky130_fd_sc_hd__edfxtp_1
X$15840 VNB|VSS synth_4088 synth_4019 synth_4485 synth_3998 VDD VDD VNB|VSS
+ sky130_fd_sc_hd__edfxtp_1
X$15841 VNB|VSS synth_4728 synth_4019 synth_4790 synth_4791 VDD VDD VNB|VSS
+ sky130_fd_sc_hd__edfxtp_1
X$15842 VNB|VSS synth_12721 synth_12024 synth_12792 synth_12761 VDD VDD VNB|VSS
+ sky130_fd_sc_hd__edfxtp_1
X$15843 VNB|VSS synth_11488 synth_11294 synth_6987 synth_11231 VDD VDD VNB|VSS
+ sky130_fd_sc_hd__edfxtp_1
X$15844 VNB|VSS synth_1244 synth_1423 synth_1211 synth_1105 VDD VDD VNB|VSS
+ sky130_fd_sc_hd__edfxtp_1
X$15845 VNB|VSS synth_5218 synth_5217 synth_449 synth_5114 VDD VDD VNB|VSS
+ sky130_fd_sc_hd__edfxtp_1
X$15846 VNB|VSS synth_10964 synth_10467 synth_6699 synth_10748 VDD VDD VNB|VSS
+ sky130_fd_sc_hd__edfxtp_1
X$15847 VNB|VSS synth_919 synth_640 synth_999 synth_575 VDD VDD VNB|VSS
+ sky130_fd_sc_hd__edfxtp_1
X$15848 VNB|VSS synth_2877 synth_2080 synth_2960 synth_2758 VDD VDD VNB|VSS
+ sky130_fd_sc_hd__edfxtp_1
X$15849 VNB|VSS synth_700 synth_53 synth_88 synth_734 VDD VDD VNB|VSS
+ sky130_fd_sc_hd__edfxtp_1
X$15850 VNB|VSS synth_2961 synth_3569 synth_3473 synth_3312 VDD VDD VNB|VSS
+ sky130_fd_sc_hd__edfxtp_1
X$15851 VNB|VSS synth_2959 synth_3043 synth_3131 synth_3312 VDD VDD VNB|VSS
+ sky130_fd_sc_hd__edfxtp_1
X$15852 VNB|VSS synth_8013 synth_7334 synth_8041 synth_7963 VDD VDD VNB|VSS
+ sky130_fd_sc_hd__edfxtp_1
X$15853 VNB|VSS synth_3674 synth_3569 synth_3677 synth_3676 VDD VDD VNB|VSS
+ sky130_fd_sc_hd__edfxtp_1
X$15854 VNB|VSS synth_782 synth_699 synth_88 synth_606 VDD VDD VNB|VSS
+ sky130_fd_sc_hd__edfxtp_1
X$15855 VNB|VSS synth_7939 synth_7334 synth_7964 synth_7963 VDD VDD VNB|VSS
+ sky130_fd_sc_hd__edfxtp_1
X$15856 VNB|VSS synth_10087 synth_9760 synth_10210 synth_9917 VDD VDD VNB|VSS
+ sky130_fd_sc_hd__edfxtp_1
X$15857 VNB|VSS synth_5301 synth_5407 synth_449 synth_5408 VDD VDD VNB|VSS
+ sky130_fd_sc_hd__edfxtp_1
X$15858 VNB|VSS synth_10815 synth_10467 synth_8337 synth_10748 VDD VDD VNB|VSS
+ sky130_fd_sc_hd__edfxtp_1
X$15859 VNB|VSS synth_1757 synth_1898 synth_1903 synth_1660 VDD VDD VNB|VSS
+ sky130_fd_sc_hd__edfxtp_1
X$15860 VNB|VSS synth_1664 synth_1657 synth_258 synth_1658 VDD VDD VNB|VSS
+ sky130_fd_sc_hd__edfxtp_1
X$15861 VNB|VSS synth_4488 synth_4264 synth_2860 synth_4486 VDD VDD VNB|VSS
+ sky130_fd_sc_hd__edfxtp_1
X$15862 VNB|VSS synth_2279 synth_2201 synth_449 synth_2162 VDD VDD VNB|VSS
+ sky130_fd_sc_hd__edfxtp_1
X$15863 VNB|VSS synth_2366 synth_1657 synth_1908 synth_2135 VDD VDD VNB|VSS
+ sky130_fd_sc_hd__edfxtp_1
X$15864 VNB|VSS synth_2221 synth_1657 synth_258 synth_2135 VDD VDD VNB|VSS
+ sky130_fd_sc_hd__edfxtp_1
X$15865 VNB|VSS synth_11808 synth_11536 synth_4467 synth_11717 VDD VDD VNB|VSS
+ sky130_fd_sc_hd__edfxtp_1
X$15866 VNB|VSS synth_3957 synth_4019 synth_4067 synth_3998 VDD VDD VNB|VSS
+ sky130_fd_sc_hd__edfxtp_1
X$15867 VNB|VSS synth_5019 synth_3937 synth_3656 synth_4987 VDD VDD VNB|VSS
+ sky130_fd_sc_hd__edfxtp_1
X$15868 VNB|VSS synth_4183 synth_3374 synth_4233 synth_4089 VDD VDD VNB|VSS
+ sky130_fd_sc_hd__edfxtp_1
X$15869 VNB|VSS synth_807 synth_89 synth_862 synth_736 VDD VDD VNB|VSS
+ sky130_fd_sc_hd__edfxtp_1
X$15870 VNB|VSS synth_5464 synth_5082 synth_626 synth_5508 VDD VDD VNB|VSS
+ sky130_fd_sc_hd__edfxtp_1
X$15871 VNB|VSS synth_1673 synth_1142 synth_258 synth_1677 VDD VDD VNB|VSS
+ sky130_fd_sc_hd__edfxtp_1
X$15872 VNB|VSS synth_5567 synth_5082 synth_4111 synth_5508 VDD VDD VNB|VSS
+ sky130_fd_sc_hd__edfxtp_1
X$15873 VNB|VSS synth_1916 synth_1142 synth_478 synth_1677 VDD VDD VNB|VSS
+ sky130_fd_sc_hd__edfxtp_1
X$15874 VNB|VSS synth_3512 synth_3025 synth_1908 synth_3454 VDD VDD VNB|VSS
+ sky130_fd_sc_hd__edfxtp_1
X$15875 VNB|VSS synth_3753 synth_2533 synth_3791 synth_3298 VDD VDD VNB|VSS
+ sky130_fd_sc_hd__edfxtp_1
X$15876 VNB|VSS synth_2082 synth_1142 synth_449 synth_1677 VDD VDD VNB|VSS
+ sky130_fd_sc_hd__edfxtp_1
X$15877 VNB|VSS synth_12498 synth_12202 synth_6564 synth_12227 VDD VDD VNB|VSS
+ sky130_fd_sc_hd__edfxtp_1
X$15878 VNB|VSS synth_2360 synth_2602 synth_2670 synth_2139 VDD VDD VNB|VSS
+ sky130_fd_sc_hd__edfxtp_1
X$15879 VNB|VSS synth_12392 synth_11536 synth_6699 synth_12227 VDD VDD VNB|VSS
+ sky130_fd_sc_hd__edfxtp_1
X$15880 VNB|VSS synth_11260 synth_10467 synth_6699 synth_11231 VDD VDD VNB|VSS
+ sky130_fd_sc_hd__edfxtp_1
X$15881 VNB|VSS synth_416 synth_276 synth_258 synth_381 VDD VDD VNB|VSS
+ sky130_fd_sc_hd__edfxtp_1
X$15882 VNB|VSS synth_11153 synth_10628 synth_11280 synth_11079 VDD VDD VNB|VSS
+ sky130_fd_sc_hd__edfxtp_1
X$15883 VNB|VSS synth_5302 synth_5407 synth_382 synth_5114 VDD VDD VNB|VSS
+ sky130_fd_sc_hd__edfxtp_1
X$15884 VNB|VSS synth_75 synth_89 synth_40 synth_13 VDD VDD VNB|VSS
+ sky130_fd_sc_hd__edfxtp_1
X$15885 VNB|VSS synth_4921 synth_5217 synth_4588 synth_5114 VDD VDD VNB|VSS
+ sky130_fd_sc_hd__edfxtp_1
X$15886 VNB|VSS synth_6831 synth_6828 synth_6849 synth_6850 VDD VDD VNB|VSS
+ sky130_fd_sc_hd__edfxtp_1
X$15887 VNB|VSS synth_5646 synth_5953 synth_5869 synth_5558 VDD VDD VNB|VSS
+ sky130_fd_sc_hd__edfxtp_1
X$15888 VNB|VSS synth_6231 synth_5953 synth_6342 synth_6033 VDD VDD VNB|VSS
+ sky130_fd_sc_hd__edfxtp_1
X$15889 VNB|VSS synth_10706 synth_10628 synth_10829 synth_10301 VDD VDD VNB|VSS
+ sky130_fd_sc_hd__edfxtp_1
X$15890 VNB|VSS synth_838 synth_450 synth_856 synth_766 VDD VDD VNB|VSS
+ sky130_fd_sc_hd__edfxtp_1
X$15891 VNB|VSS synth_58 synth_51 synth_17 synth_50 VDD VDD VNB|VSS
+ sky130_fd_sc_hd__edfxtp_1
X$15892 VNB|VSS synth_87 synth_61 synth_49 synth_18 VDD VDD VNB|VSS
+ sky130_fd_sc_hd__edfxtp_1
X$15893 VDD synth_62 synth_20 synth_86 VNB|VSS VDD VNB|VSS
+ sky130_fd_sc_hd__nor2_1
X$15894 VNB|VSS synth_4983 synth_4575 synth_4982 synth_4925 VDD VDD VNB|VSS
+ sky130_fd_sc_hd__edfxtp_1
X$15895 VNB|VSS synth_6829 synth_6828 synth_7055 synth_6850 VDD VDD VNB|VSS
+ sky130_fd_sc_hd__edfxtp_1
X$15896 VNB|VSS synth_2990 synth_3335 synth_387 synth_3208 VDD VDD VNB|VSS
+ sky130_fd_sc_hd__edfxtp_1
X$15897 VNB|VSS synth_3395 synth_3397 synth_3307 synth_3091 VDD VDD VNB|VSS
+ sky130_fd_sc_hd__edfxtp_1
X$15898 VNB|VSS synth_3625 synth_3335 synth_387 synth_3504 VDD VDD VNB|VSS
+ sky130_fd_sc_hd__edfxtp_1
X$15899 VNB|VSS synth_3506 synth_3335 synth_2860 synth_3504 VDD VDD VNB|VSS
+ sky130_fd_sc_hd__edfxtp_1
X$15900 VNB|VSS synth_3669 synth_3335 synth_1181 synth_3504 VDD VDD VNB|VSS
+ sky130_fd_sc_hd__edfxtp_1
X$15901 VNB|VSS synth_3271 synth_3025 synth_2860 synth_2913 VDD VDD VNB|VSS
+ sky130_fd_sc_hd__edfxtp_1
X$15902 VNB|VSS synth_10900 synth_10538 synth_2777 synth_10857 VDD VDD VNB|VSS
+ sky130_fd_sc_hd__edfxtp_1
X$15903 VNB|VSS synth_4785 synth_4600 synth_3656 synth_4601 VDD VDD VNB|VSS
+ sky130_fd_sc_hd__edfxtp_1
X$15904 VNB|VSS synth_10856 synth_10226 synth_11047 synth_10604 VDD VDD VNB|VSS
+ sky130_fd_sc_hd__edfxtp_1
X$15905 VNB|VSS synth_634 synth_578 synth_626 synth_526 VDD VDD VNB|VSS
+ sky130_fd_sc_hd__edfxtp_1
X$15906 VNB|VSS synth_10683 synth_10226 synth_10603 synth_10604 VDD VDD VNB|VSS
+ sky130_fd_sc_hd__edfxtp_1
X$15907 VNB|VSS synth_1088 synth_450 synth_1102 synth_766 VDD VDD VNB|VSS
+ sky130_fd_sc_hd__edfxtp_1
X$15908 VNB|VSS synth_1203 synth_840 synth_478 synth_1205 VDD VDD VNB|VSS
+ sky130_fd_sc_hd__edfxtp_1
X$15909 VNB|VSS synth_4288 synth_4487 synth_4449 synth_4151 VDD VDD VNB|VSS
+ sky130_fd_sc_hd__edfxtp_1
X$15910 VNB|VSS synth_10705 synth_10226 synth_10753 synth_10604 VDD VDD VNB|VSS
+ sky130_fd_sc_hd__edfxtp_1
X$15911 VNB|VSS synth_5818 synth_5227 synth_6212 synth_5671 VDD VDD VNB|VSS
+ sky130_fd_sc_hd__edfxtp_1
X$15912 VNB|VSS synth_5901 synth_5227 synth_6055 synth_5671 VDD VDD VNB|VSS
+ sky130_fd_sc_hd__edfxtp_1
X$15913 VNB|VSS synth_10133 synth_9811 synth_10261 synth_10198 VDD VDD VNB|VSS
+ sky130_fd_sc_hd__edfxtp_1
X$15914 VNB|VSS synth_5413 synth_5303 synth_5547 synth_4925 VDD VDD VNB|VSS
+ sky130_fd_sc_hd__edfxtp_1
X$15915 VNB|VSS synth_3866 synth_3794 synth_3656 synth_3766 VDD VDD VNB|VSS
+ sky130_fd_sc_hd__edfxtp_1
X$15916 VNB|VSS synth_4926 synth_4836 synth_501 synth_4732 VDD VDD VNB|VSS
+ sky130_fd_sc_hd__edfxtp_1
X$15917 VNB|VSS synth_3345 synth_3374 synth_3434 synth_3301 VDD VDD VNB|VSS
+ sky130_fd_sc_hd__edfxtp_1
X$15918 VNB|VSS synth_549 synth_276 synth_88 synth_381 VDD VDD VNB|VSS
+ sky130_fd_sc_hd__edfxtp_1
X$15919 VNB|VSS synth_11773 synth_11495 synth_11709 synth_11662 VDD VDD VNB|VSS
+ sky130_fd_sc_hd__edfxtp_1
X$15920 VNB|VSS synth_4271 synth_3374 synth_4491 synth_4089 VDD VDD VNB|VSS
+ sky130_fd_sc_hd__edfxtp_1
X$15921 VNB|VSS synth_4974 synth_4833 synth_4975 synth_4791 VDD VDD VNB|VSS
+ sky130_fd_sc_hd__edfxtp_1
X$15922 VNB|VSS synth_4794 synth_4833 synth_4729 synth_4793 VDD VDD VNB|VSS
+ sky130_fd_sc_hd__edfxtp_1
X$15923 VNB|VSS synth_588 synth_557 synth_37 synth_587 VDD VDD VNB|VSS
+ sky130_fd_sc_hd__edfxtp_1
X$15924 VNB|VSS synth_10540 synth_10355 synth_6987 synth_10424 VDD VDD VNB|VSS
+ sky130_fd_sc_hd__edfxtp_1
X$15925 VNB|VSS synth_5325 synth_5450 synth_5701 synth_5294 VDD VDD VNB|VSS
+ sky130_fd_sc_hd__edfxtp_1
X$15926 VNB|VSS synth_1233 synth_51 synth_1230 synth_1232 VDD VDD VNB|VSS
+ sky130_fd_sc_hd__edfxtp_1
X$15927 VNB|VSS synth_9992 synth_9717 synth_6987 synth_9989 VDD VDD VNB|VSS
+ sky130_fd_sc_hd__edfxtp_1
X$15928 VNB|VSS synth_746 synth_51 synth_880 synth_512 VDD VDD VNB|VSS
+ sky130_fd_sc_hd__edfxtp_1
X$15929 VNB|VSS synth_10076 synth_9811 synth_10204 synth_9842 VDD VDD VNB|VSS
+ sky130_fd_sc_hd__edfxtp_1
X$15930 VNB|VSS synth_679 synth_282 synth_88 synth_656 VDD VDD VNB|VSS
+ sky130_fd_sc_hd__edfxtp_1
X$15931 VNB|VSS synth_884 synth_282 synth_382 synth_656 VDD VDD VNB|VSS
+ sky130_fd_sc_hd__edfxtp_1
X$15932 VNB|VSS synth_885 synth_756 synth_886 synth_755 VDD VDD VNB|VSS
+ sky130_fd_sc_hd__edfxtp_1
X$15933 VNB|VSS synth_10130 synth_9717 synth_2777 synth_10070 VDD VDD VNB|VSS
+ sky130_fd_sc_hd__edfxtp_1
X$15934 VNB|VSS synth_563 synth_51 synth_598 synth_512 VDD VDD VNB|VSS
+ sky130_fd_sc_hd__edfxtp_1
X$15935 VNB|VSS synth_1160 synth_756 synth_1123 synth_909 VDD VDD VNB|VSS
+ sky130_fd_sc_hd__edfxtp_1
X$15936 VNB|VSS synth_2479 synth_2268 synth_2478 synth_2318 VDD VDD VNB|VSS
+ sky130_fd_sc_hd__edfxtp_1
X$15937 VNB|VSS synth_337 synth_470 synth_413 synth_13 VDD VDD VNB|VSS
+ sky130_fd_sc_hd__edfxtp_1
X$15938 VNB|VSS synth_559 synth_470 synth_590 synth_13 VDD VDD VNB|VSS
+ sky130_fd_sc_hd__edfxtp_1
X$15939 VNB|VSS synth_809 synth_470 synth_739 synth_740 VDD VDD VNB|VSS
+ sky130_fd_sc_hd__edfxtp_1
X$15940 VNB|VSS synth_898 synth_470 synth_952 synth_740 VDD VDD VNB|VSS
+ sky130_fd_sc_hd__edfxtp_1
X$15941 VNB|VSS synth_1069 synth_470 synth_1217 synth_740 VDD VDD VNB|VSS
+ sky130_fd_sc_hd__edfxtp_1
X$15942 VNB|VSS synth_1164 synth_470 synth_1068 synth_740 VDD VDD VNB|VSS
+ sky130_fd_sc_hd__edfxtp_1
X$15943 VNB|VSS synth_1427 synth_470 synth_1468 synth_1341 VDD VDD VNB|VSS
+ sky130_fd_sc_hd__edfxtp_1
X$15944 VNB|VSS synth_677 synth_756 synth_725 synth_565 VDD VDD VNB|VSS
+ sky130_fd_sc_hd__edfxtp_1
X$15945 VNB|VSS synth_2835 synth_2533 synth_3212 synth_2769 VDD VDD VNB|VSS
+ sky130_fd_sc_hd__edfxtp_1
X$15946 VNB|VSS synth_6422 synth_6237 synth_4588 synth_6297 VDD VDD VNB|VSS
+ sky130_fd_sc_hd__edfxtp_1
X$15947 VNB|VSS synth_3277 synth_3169 synth_382 synth_3214 VDD VDD VNB|VSS
+ sky130_fd_sc_hd__edfxtp_1
X$15948 VNB|VSS synth_3230 synth_2339 synth_3279 synth_3172 VDD VDD VNB|VSS
+ sky130_fd_sc_hd__edfxtp_1
X$15949 VNB|VSS synth_3232 synth_2339 synth_3156 synth_3172 VDD VDD VNB|VSS
+ sky130_fd_sc_hd__edfxtp_1
X$15950 VNB|VSS synth_3155 synth_3169 synth_1908 synth_3170 VDD VDD VNB|VSS
+ sky130_fd_sc_hd__edfxtp_1
X$15951 VNB|VSS synth_3148 synth_2533 synth_3143 synth_2839 VDD VDD VNB|VSS
+ sky130_fd_sc_hd__edfxtp_1
X$15952 VNB|VSS synth_3191 synth_3221 synth_88 synth_3017 VDD VDD VNB|VSS
+ sky130_fd_sc_hd__edfxtp_1
X$15953 VNB|VSS synth_3198 synth_3221 synth_88 synth_3196 VDD VDD VNB|VSS
+ sky130_fd_sc_hd__edfxtp_1
X$15954 VNB|VSS synth_3159 synth_2179 synth_3194 synth_2894 VDD VDD VNB|VSS
+ sky130_fd_sc_hd__edfxtp_1
X$15955 VNB|VSS synth_5326 synth_4826 synth_5292 synth_5294 VDD VDD VNB|VSS
+ sky130_fd_sc_hd__edfxtp_1
X$15956 VNB|VSS synth_3066 synth_2468 synth_2860 synth_3208 VDD VDD VNB|VSS
+ sky130_fd_sc_hd__edfxtp_1
X$15957 VNB|VSS synth_10537 synth_9912 synth_2777 synth_10423 VDD VDD VNB|VSS
+ sky130_fd_sc_hd__edfxtp_1
X$15958 VNB|VSS synth_3267 synth_2468 synth_387 synth_3022 VDD VDD VNB|VSS
+ sky130_fd_sc_hd__edfxtp_1
X$15959 VNB|VSS synth_3262 synth_2465 synth_3163 synth_3055 VDD VDD VNB|VSS
+ sky130_fd_sc_hd__edfxtp_1
X$15960 VNB|VSS synth_4012 synth_3818 synth_4176 synth_4147 VDD VDD VNB|VSS
+ sky130_fd_sc_hd__edfxtp_1
X$15961 VNB|VSS synth_6405 synth_5715 synth_6320 synth_6319 VDD VDD VNB|VSS
+ sky130_fd_sc_hd__edfxtp_1
X$15962 VNB|VSS synth_4559 synth_3335 synth_1181 synth_4431 VDD VDD VNB|VSS
+ sky130_fd_sc_hd__edfxtp_1
X$15963 VNB|VSS synth_4912 synth_5008 synth_1181 synth_4910 VDD VDD VNB|VSS
+ sky130_fd_sc_hd__edfxtp_1
X$15964 VNB|VSS synth_5912 synth_5715 synth_6163 synth_5850 VDD VDD VNB|VSS
+ sky130_fd_sc_hd__edfxtp_1
X$15965 VNB|VSS synth_5491 synth_5450 synth_5449 synth_5294 VDD VDD VNB|VSS
+ sky130_fd_sc_hd__edfxtp_1
X$15966 VNB|VSS synth_10535 synth_9912 synth_6987 synth_10423 VDD VDD VNB|VSS
+ sky130_fd_sc_hd__edfxtp_1
X$15967 VNB|VSS synth_540 synth_557 synth_501 synth_587 VDD VDD VNB|VSS
+ sky130_fd_sc_hd__edfxtp_1
X$15968 VNB|VSS synth_8423 synth_7534 synth_4467 synth_8352 VDD VDD VNB|VSS
+ sky130_fd_sc_hd__edfxtp_1
X$15969 VNB|VSS synth_6201 synth_5303 synth_6278 synth_6279 VDD VDD VNB|VSS
+ sky130_fd_sc_hd__edfxtp_1
X$15970 VNB|VSS synth_39 synth_53 synth_37 synth_12 VDD VDD VNB|VSS
+ sky130_fd_sc_hd__edfxtp_1
X$15971 VNB|VSS synth_2887 synth_2750 synth_966 synth_2742 VDD VDD VNB|VSS
+ sky130_fd_sc_hd__edfxtp_1
X$15972 VNB|VSS synth_448 synth_446 synth_183 synth_479 VDD VDD VNB|VSS
+ sky130_fd_sc_hd__edfxtp_1
X$15973 VNB|VSS synth_9751 synth_9986 synth_10195 synth_9711 VDD VDD VNB|VSS
+ sky130_fd_sc_hd__edfxtp_1
X$15974 VNB|VSS synth_7915 synth_7645 synth_8157 synth_7992 VDD VDD VNB|VSS
+ sky130_fd_sc_hd__edfxtp_1
X$15975 VNB|VSS synth_6520 synth_6347 synth_6515 synth_6279 VDD VDD VNB|VSS
+ sky130_fd_sc_hd__edfxtp_1
X$15976 VNB|VSS synth_641 synth_446 synth_449 synth_479 VDD VDD VNB|VSS
+ sky130_fd_sc_hd__edfxtp_1
X$15977 VNB|VSS synth_6205 synth_6347 synth_6207 synth_5870 VDD VDD VNB|VSS
+ sky130_fd_sc_hd__edfxtp_1
X$15978 VNB|VSS synth_9753 synth_10030 synth_10066 synth_9711 VDD VDD VNB|VSS
+ sky130_fd_sc_hd__edfxtp_1
X$15979 VNB|VSS synth_10468 synth_10467 synth_6987 synth_10420 VDD VDD VNB|VSS
+ sky130_fd_sc_hd__edfxtp_1
X$15980 VNB|VSS synth_10674 synth_10467 synth_6564 synth_10420 VDD VDD VNB|VSS
+ sky130_fd_sc_hd__edfxtp_1
X$15981 VNB|VSS synth_780 synth_446 synth_449 synth_781 VDD VDD VNB|VSS
+ sky130_fd_sc_hd__edfxtp_1
X$15982 VNB|VSS synth_7913 synth_7645 synth_7961 synth_7992 VDD VDD VNB|VSS
+ sky130_fd_sc_hd__edfxtp_1
X$15983 VNB|VSS synth_537 synth_53 synth_501 synth_12 VDD VDD VNB|VSS
+ sky130_fd_sc_hd__edfxtp_1
X$15984 VNB|VSS synth_6149 synth_6069 synth_4588 synth_5746 VDD VDD VNB|VSS
+ sky130_fd_sc_hd__edfxtp_1
X$15985 VNB|VSS synth_7723 synth_7645 synth_7889 synth_7568 VDD VDD VNB|VSS
+ sky130_fd_sc_hd__edfxtp_1
X$15986 VNB|VSS synth_1533 synth_1906 synth_1839 synth_1377 VDD VDD VNB|VSS
+ sky130_fd_sc_hd__edfxtp_1
X$15987 VNB|VSS synth_636 synth_699 synth_37 synth_606 VDD VDD VNB|VSS
+ sky130_fd_sc_hd__edfxtp_1
X$15988 VNB|VSS synth_7721 synth_6541 synth_5787 synth_7388 VDD VDD VNB|VSS
+ sky130_fd_sc_hd__edfxtp_1
X$15989 VNB|VSS synth_7610 synth_6541 synth_4467 synth_7388 VDD VDD VNB|VSS
+ sky130_fd_sc_hd__edfxtp_1
X$15990 VNB|VSS synth_946 synth_53 synth_387 synth_734 VDD VDD VNB|VSS
+ sky130_fd_sc_hd__edfxtp_1
X$15991 VNB|VSS synth_73 synth_30 synth_32 synth_10 VDD VDD VNB|VSS
+ sky130_fd_sc_hd__edfxtp_1
X$15992 VNB|VSS synth_307 synth_30 synth_239 synth_10 VDD VDD VNB|VSS
+ sky130_fd_sc_hd__edfxtp_1
X$15993 VDD synth_308 synth_172 synth_363 VDD VNB|VSS VNB|VSS
+ sky130_fd_sc_hd__xnor2_1
X$15994 VNB|VSS synth_5981 synth_5303 synth_6042 synth_5670 VDD VDD VNB|VSS
+ sky130_fd_sc_hd__edfxtp_1
X$15995 VNB|VSS synth_2903 synth_2750 synth_478 synth_2733 VDD VDD VNB|VSS
+ sky130_fd_sc_hd__edfxtp_1
X$15996 VNB|VSS synth_2734 synth_2750 synth_966 synth_2733 VDD VDD VNB|VSS
+ sky130_fd_sc_hd__edfxtp_1
X$15997 VNB|VSS synth_69 synth_25 synth_27 synth_9 VDD VDD VNB|VSS
+ sky130_fd_sc_hd__edfxtp_1
X$15998 VNB|VSS synth_360 synth_25 synth_404 synth_9 VDD VDD VNB|VSS
+ sky130_fd_sc_hd__edfxtp_1
X$15999 VNB|VSS synth_6552 synth_6237 synth_3656 synth_6297 VDD VDD VNB|VSS
+ sky130_fd_sc_hd__edfxtp_1
X$16000 VNB|VSS synth_5957 synth_5303 synth_5810 synth_5670 VDD VDD VNB|VSS
+ sky130_fd_sc_hd__edfxtp_1
X$16001 VNB|VSS synth_1002 synth_446 synth_183 synth_781 VDD VDD VNB|VSS
+ sky130_fd_sc_hd__edfxtp_1
X$16002 VNB|VSS synth_7390 synth_6541 synth_1695 synth_7388 VDD VDD VNB|VSS
+ sky130_fd_sc_hd__edfxtp_1
X$16003 VNB|VSS synth_2214 synth_1906 synth_2134 synth_2133 VDD VDD VNB|VSS
+ sky130_fd_sc_hd__edfxtp_1
X$16004 VNB|VSS synth_4533 synth_4487 synth_4532 synth_4151 VDD VDD VNB|VSS
+ sky130_fd_sc_hd__edfxtp_1
X$16005 VNB|VSS synth_410 synth_446 synth_258 synth_479 VDD VDD VNB|VSS
+ sky130_fd_sc_hd__edfxtp_1
X$16006 VNB|VSS synth_1023 synth_699 synth_88 synth_940 VDD VDD VNB|VSS
+ sky130_fd_sc_hd__edfxtp_1
X$16007 VNB|VSS synth_5813 synth_5249 synth_5329 synth_5746 VDD VDD VNB|VSS
+ sky130_fd_sc_hd__edfxtp_1
X$16008 VNB|VSS synth_6527 synth_6347 synth_6522 synth_6373 VDD VDD VNB|VSS
+ sky130_fd_sc_hd__edfxtp_1
X$16009 VNB|VSS synth_3796 synth_3374 synth_4001 synth_3301 VDD VDD VNB|VSS
+ sky130_fd_sc_hd__edfxtp_1
X$16018 VDD synth_8765 synth_10275 synth_10147 VDD VNB|VSS synth_9242 VNB|VSS
+ sky130_fd_sc_hd__o21ba_2
X$16329 VDD synth_8604 synth_8831 VDD VNB|VSS synth_8949 VNB|VSS
+ sky130_fd_sc_hd__nand2b_2
X$16416 VNB|VSS synth_6449 synth_6375 synth_6374 VDD VDD VNB|VSS
+ sky130_fd_sc_hd__dlclkp_1
X$16487 VDD synth_9062 synth_11290 synth_10233 synth_11318 synth_11012 VNB|VSS
+ VDD VNB|VSS sky130_fd_sc_hd__nor4bb_1
X$16630 VDD synth_9387 synth_11909 synth_10312 synth_11930 synth_9895
+ synth_10840 synth_11865 VNB|VSS VDD VNB|VSS sky130_fd_sc_hd__a222oi_1
X$16756 VDD synth_1523 synth_3759 synth_1294 synth_3823 synth_1588 VDD VNB|VSS
+ synth_4816 VNB|VSS sky130_fd_sc_hd__o32ai_1
X$17015 VDD synth_1293 synth_1400 synth_1194 synth_1212 VNB|VSS synth_1372 VDD
+ VNB|VSS sky130_fd_sc_hd__a211oi_1
X$17142 VDD synth_7338 synth_7286 VDD synth_7339 VNB|VSS VNB|VSS
+ sky130_fd_sc_hd__xor2_1
X$17146 VNB|VSS synth_7500 synth_7421 synth_510 VDD VDD VNB|VSS
+ sky130_fd_sc_hd__nand2_8
X$17147 VNB|VSS synth_7499 synth_7341 synth_7286 VDD VDD VNB|VSS
+ sky130_fd_sc_hd__nor2b_4
X$17220 VNB|VSS synth_10723 synth_10560 synth_8710 synth_10640 synth_9474
+ synth_10696 VDD VDD VNB|VSS sky130_fd_sc_hd__a2111oi_2
X$17294 VDD synth_192 synth_58 synth_346 synth_273 VDD VNB|VSS VNB|VSS
+ sky130_fd_sc_hd__or3_1
X$17302 VDD synth_8803 VNB|VSS VDD synth_10096 VNB|VSS sky130_fd_sc_hd__inv_2
X$17401 VDD synth_1141 synth_1294 synth_1452 synth_1290 VDD VNB|VSS VNB|VSS
+ sky130_fd_sc_hd__or3b_1
X$17408 VDD synth_1142 VDD VNB|VSS VNB|VSS sky130_fd_sc_hd__clkinvlp_4
X$17457 VNB|VSS synth_10049 VDD VDD VNB|VSS sky130_fd_sc_hd__inv_16
X$17749 VDD synth_190 synth_209 synth_58 synth_191 VNB|VSS VDD VNB|VSS
+ sky130_fd_sc_hd__nor3_1
X$17750 VDD synth_92 synth_192 synth_133 VNB|VSS VDD synth_17 VNB|VSS
+ sky130_fd_sc_hd__a21oi_1
X$17913 VNB|VSS synth_1459 synth_1695 VDD VDD VNB|VSS sky130_fd_sc_hd__buf_6
X$18057 VDD synth_2145 VNB|VSS VDD VNB|VSS sky130_fd_sc_hd__clkinv_4
X$18099 VDD synth_2032 synth_1990 synth_1999 synth_2033 VNB|VSS VDD synth_2035
+ VNB|VSS sky130_fd_sc_hd__and4_1
X$18100 VDD synth_1990 synth_2033 synth_1999 synth_2032 VDD synth_2152 VNB|VSS
+ VNB|VSS sky130_fd_sc_hd__nand4_1
X$18273 VDD synth_1196 synth_1451 synth_1525 VNB|VSS VDD VNB|VSS
+ sky130_fd_sc_hd__nor2b_1
X$18530 VDD synth_501 VDD VNB|VSS synth_258 VNB|VSS sky130_fd_sc_hd__buf_4
X$18573 VNB|VSS synth_77 synth_79 synth_43 VDD synth_78 VDD VNB|VSS
+ sky130_fd_sc_hd__ha_1
X$19056 VNB|VSS synth_71 synth_19 synth_26 synth_8 VDD VDD VNB|VSS
+ sky130_fd_sc_hd__edfxtp_1
X$19752 VDD synth_34 VDD VNB|VSS synth_80 VNB|VSS sky130_fd_sc_hd__inv_1
X$19917 VDD synth_8945 synth_9006 synth_8738 synth_9007 VNB|VSS synth_9108 VDD
+ VNB|VSS sky130_fd_sc_hd__a22o_1
X$20229 VDD synth_5528 synth_5675 synth_5676 VNB|VSS synth_5721 VDD VNB|VSS
+ sky130_fd_sc_hd__o21ai_2
X$20820 VNB|VSS synth_8314 synth_8238 synth_8311 synth_6325 synth_4994 VDD VDD
+ VNB|VSS sky130_fd_sc_hd__o31ai_4
X$20905 VNB|VSS synth_4652 synth_5848 synth_5855 synth_5967 synth_6023
+ synth_2231 VDD VDD VNB|VSS sky130_fd_sc_hd__o311ai_2
X$21218 VNB|VSS synth_1718 synth_2042 synth_2059 synth_2040 synth_2041 VDD VDD
+ VNB|VSS sky130_fd_sc_hd__o211ai_2
X$21479 VNB|VSS synth_4566 synth_4588 VDD VDD VNB|VSS sky130_fd_sc_hd__buf_12
X$21634 VDD synth_4531 synth_4598 VNB|VSS VDD synth_4628 VNB|VSS
+ sky130_fd_sc_hd__nor2b_2
X$22207 VNB|VSS synth_7422 synth_8020 synth_8188 synth_8484 synth_8575
+ synth_8400 VDD VDD VNB|VSS sky130_fd_sc_hd__a41oi_2
X$23127 VDD synth_39 VDD synth_74 VNB|VSS VNB|VSS sky130_fd_sc_hd__dlygate4sd3_1
X$25406 VDD synth_7601 synth_7602 synth_6759 synth_7505 VDD synth_7504 VNB|VSS
+ VNB|VSS sky130_fd_sc_hd__a22oi_1
X$25536 VDD synth_6138 synth_6223 synth_6501 VNB|VSS VDD synth_6499 VNB|VSS
+ sky130_fd_sc_hd__a21boi_0
X$25546 VDD synth_3704 synth_3736 synth_3641 VDD synth_3735 VNB|VSS VNB|VSS
+ sky130_fd_sc_hd__o21a_1
X$25722 VDD synth_52 synth_102 synth_196 VDD VNB|VSS VNB|VSS
+ sky130_fd_sc_hd__nand2_1
X$25784 VDD synth_9677 synth_10312 synth_10060 VDD VNB|VSS VNB|VSS
+ sky130_fd_sc_hd__and2_0
X$25786 VNB|VSS synth_8408 synth_8566 synth_8651 synth_8338 synth_8565 VDD VDD
+ VNB|VSS sky130_fd_sc_hd__fa_1
X$25925 VDD synth_6065 synth_6269 synth_6109 synth_6332 synth_6291 VDD VNB|VSS
+ synth_6268 VNB|VSS sky130_fd_sc_hd__a221oi_1
X$26941 VNB|VSS synth_5821 synth_5984 synth_5891 synth_4097 synth_5900 VDD VDD
+ VNB|VSS sky130_fd_sc_hd__nor4b_2
X$27066 VDD synth_3948 synth_4161 synth_4163 VNB|VSS VDD synth_4024 VNB|VSS
+ sky130_fd_sc_hd__a21o_1
X$28625 VNB|VSS synth_38 VDD VDD VNB|VSS sky130_fd_sc_hd__clkinv_8
X$28776 VDD synth_3523 synth_3593 synth_3729 synth_3273 synth_3566 VDD
+ synth_3728 VNB|VSS VNB|VSS sky130_fd_sc_hd__a311oi_1
X$28840 VDD synth_7742 VNB|VSS VDD synth_7802 VNB|VSS
+ sky130_fd_sc_hd__clkdlybuf4s50_1
X$29384 VDD synth_3719 synth_3367 synth_3550 synth_3549 synth_3622 synth_3717
+ VDD VNB|VSS VNB|VSS sky130_fd_sc_hd__o32a_1
X$29708 VNB|VSS synth_4710 synth_4709 synth_5322 synth_3471 synth_3735
+ synth_4630 VDD VDD VNB|VSS sky130_fd_sc_hd__o221a_2
X$29965 VNB|VSS synth_4343 synth_5846 synth_5882 synth_5848 synth_5734 VDD VDD
+ VNB|VSS sky130_fd_sc_hd__nor4_4
X$29998 VDD synth_10641 synth_10577 synth_10510 synth_8764 synth_9923
+ synth_10696 VDD VNB|VSS VNB|VSS sky130_fd_sc_hd__a221o_1
X$30401 VDD synth_8803 synth_9903 synth_9983 synth_9982 VDD synth_9855 VNB|VSS
+ VNB|VSS sky130_fd_sc_hd__o2bb2ai_1
X$30516 VNB|VSS synth_2713 VDD synth_4627 synth_4530 VDD VNB|VSS
+ sky130_fd_sc_hd__nand2_2
X$30936 VDD synth_1813 synth_2099 synth_1866 synth_2011 VNB|VSS VDD VNB|VSS
+ sky130_fd_sc_hd__nor3b_1
X$30946 VNB|VSS synth_2627 synth_2697 synth_2629 synth_2699 synth_2400 VDD VDD
+ VNB|VSS sky130_fd_sc_hd__a31oi_2
X$32528 VDD synth_5917 VNB|VSS synth_5920 VDD VNB|VSS sky130_fd_sc_hd__buf_2
X$33292 VDD synth_9434 synth_10062 synth_10097 synth_9895 synth_8764
+ synth_10061 VDD VNB|VSS VNB|VSS sky130_fd_sc_hd__o221ai_1
X$33552 VNB|VSS synth_7423 synth_7501 synth_4653 synth_7738 VDD VDD VNB|VSS
+ sky130_fd_sc_hd__nor3_4
X$33674 VNB|VSS synth_6325 synth_2152 synth_4649 synth_4343 synth_4061 VDD VDD
+ VNB|VSS sky130_fd_sc_hd__a211oi_2
X$33825 VDD synth_10376 synth_11937 synth_12488 synth_10312 synth_12380 VNB|VSS
+ VDD VNB|VSS sky130_fd_sc_hd__o22a_1
X$33895 VNB|VSS synth_11832 synth_9042 synth_9039 synth_11902 synth_11867
+ synth_11903 VDD VDD VNB|VSS sky130_fd_sc_hd__a2111o_1
X$34094 VNB|VSS synth_11081 synth_11083 synth_11084 synth_11082 synth_8237 VDD
+ VDD VNB|VSS sky130_fd_sc_hd__nand4_4
X$34193 VDD synth_2200 synth_4558 synth_1650 synth_4042 synth_4454 VNB|VSS VDD
+ synth_4560 VNB|VSS sky130_fd_sc_hd__a2111oi_0
X$34242 VDD synth_1209 synth_1196 synth_1208 VNB|VSS VDD synth_1141 VNB|VSS
+ sky130_fd_sc_hd__and3_1
X$34344 VNB|VSS synth_8738 synth_8553 synth_8739 VDD VDD VNB|VSS
+ sky130_fd_sc_hd__dfxtp_2
X$34481 VDD synth_21 VDD VNB|VSS VNB|VSS sky130_fd_sc_hd__inv_6
X$34526 VNB|VSS synth_2431 synth_4598 synth_4531 synth_4530 VDD VDD VNB|VSS
+ sky130_fd_sc_hd__nand3_2
X$34610 VDD synth_235 VDD VNB|VSS synth_12823 VNB|VSS sky130_fd_sc_hd__clkinv_1
.ENDS ecg_snn_core

.SUBCKT sky130_fd_sc_hd__or4b_1 VPB D_N A B C VPWR VGND X VNB
M$1 synth_3 synth_1 synth_2 VPB pfet_01v8_hvt L=150000U W=420000U
+ AS=109200000000P AD=68250000000P PS=1360000U PD=745000U
M$2 synth_5 C synth_3 VPB pfet_01v8_hvt L=150000U W=420000U AS=68250000000P
+ AD=45150000000P PS=745000U PD=635000U
M$3 synth_4 B synth_5 VPB pfet_01v8_hvt L=150000U W=420000U AS=45150000000P
+ AD=64050000000P PS=635000U PD=725000U
M$4 VPWR A synth_4 VPB pfet_01v8_hvt L=150000U W=420000U AS=64050000000P
+ AD=148250000000P PS=725000U PD=1340000U
M$5 X synth_2 VPWR VPB pfet_01v8_hvt L=150000U W=1000000U AS=148250000000P
+ AD=275000000000P PS=1340000U PD=2550000U
M$6 synth_1 D_N VPWR VPB pfet_01v8_hvt L=150000U W=420000U AS=109200000000P
+ AD=109200000000P PS=1360000U PD=1360000U
M$7 synth_2 synth_1 VGND VNB nfet_01v8 L=150000U W=420000U AS=109200000000P
+ AD=64050000000P PS=1360000U PD=725000U
M$8 VGND C synth_2 VNB nfet_01v8 L=150000U W=420000U AS=64050000000P
+ AD=56700000000P PS=725000U PD=690000U
M$9 synth_2 B VGND VNB nfet_01v8 L=150000U W=420000U AS=56700000000P
+ AD=56700000000P PS=690000U PD=690000U
M$10 synth_2 A VGND VNB nfet_01v8 L=150000U W=420000U AS=101875000000P
+ AD=56700000000P PS=990000U PD=690000U
M$11 X synth_2 VGND VNB nfet_01v8 L=150000U W=650000U AS=101875000000P
+ AD=178750000000P PS=990000U PD=1850000U
M$12 synth_1 D_N VGND VNB nfet_01v8 L=150000U W=420000U AS=109200000000P
+ AD=109200000000P PS=1360000U PD=1360000U
.ENDS sky130_fd_sc_hd__or4b_1

.SUBCKT sky130_fd_sc_hd__or3b_1 VPB A B C_N X VPWR VGND VNB
M$1 synth_3 synth_1 synth_2 VPB pfet_01v8_hvt L=150000U W=420000U
+ AS=109200000000P AD=44100000000P PS=1360000U PD=630000U
M$2 synth_4 B synth_3 VPB pfet_01v8_hvt L=150000U W=420000U AS=44100000000P
+ AD=68250000000P PS=630000U PD=745000U
M$3 VPWR A synth_4 VPB pfet_01v8_hvt L=150000U W=420000U AS=68250000000P
+ AD=148250000000P PS=745000U PD=1340000U
M$4 X synth_2 VPWR VPB pfet_01v8_hvt L=150000U W=1000000U AS=148250000000P
+ AD=275000000000P PS=1340000U PD=2550000U
M$5 synth_1 C_N VPWR VPB pfet_01v8_hvt L=150000U W=420000U AS=109200000000P
+ AD=109200000000P PS=1360000U PD=1360000U
M$6 VGND synth_1 synth_2 VNB nfet_01v8 L=150000U W=420000U AS=109200000000P
+ AD=56700000000P PS=1360000U PD=690000U
M$7 synth_2 B VGND VNB nfet_01v8 L=150000U W=420000U AS=56700000000P
+ AD=56700000000P PS=690000U PD=690000U
M$8 synth_2 A VGND VNB nfet_01v8 L=150000U W=420000U AS=100250000000P
+ AD=56700000000P PS=985000U PD=690000U
M$9 X synth_2 VGND VNB nfet_01v8 L=150000U W=650000U AS=100250000000P
+ AD=178750000000P PS=985000U PD=1850000U
M$10 synth_1 C_N VGND VNB nfet_01v8 L=150000U W=420000U AS=109200000000P
+ AD=109200000000P PS=1360000U PD=1360000U
.ENDS sky130_fd_sc_hd__or3b_1

.SUBCKT sky130_fd_sc_hd__o2111a_1 VGND X C1 D1 B1 A2 A1 VPWR VPB VNB
M$1 VPWR synth_1 X VPB pfet_01v8_hvt L=150000U W=1000000U AS=260000000000P
+ AD=382500000000P PS=2520000U PD=1765000U
M$2 synth_1 D1 VPWR VPB pfet_01v8_hvt L=150000U W=1000000U AS=382500000000P
+ AD=217500000000P PS=1765000U PD=1435000U
M$3 VPWR C1 synth_1 VPB pfet_01v8_hvt L=150000U W=1000000U AS=217500000000P
+ AD=305000000000P PS=1435000U PD=1610000U
M$4 synth_1 B1 VPWR VPB pfet_01v8_hvt L=150000U W=1000000U AS=305000000000P
+ AD=212500000000P PS=1610000U PD=1425000U
M$5 synth_5 A2 synth_1 VPB pfet_01v8_hvt L=150000U W=1000000U AS=212500000000P
+ AD=105000000000P PS=1425000U PD=1210000U
M$6 VPWR A1 synth_5 VPB pfet_01v8_hvt L=150000U W=1000000U AS=105000000000P
+ AD=265000000000P PS=1210000U PD=2530000U
M$7 synth_3 D1 synth_1 VNB nfet_01v8 L=150000U W=650000U AS=198250000000P
+ AD=118625000000P PS=1910000U PD=1015000U
M$8 synth_4 C1 synth_3 VNB nfet_01v8 L=150000U W=650000U AS=118625000000P
+ AD=118625000000P PS=1015000U PD=1015000U
M$9 synth_2 B1 synth_4 VNB nfet_01v8 L=150000U W=650000U AS=118625000000P
+ AD=198250000000P PS=1015000U PD=1260000U
M$10 VGND A2 synth_2 VNB nfet_01v8 L=150000U W=650000U AS=198250000000P
+ AD=87750000000P PS=1260000U PD=920000U
M$11 synth_2 A1 VGND VNB nfet_01v8 L=150000U W=650000U AS=87750000000P
+ AD=172250000000P PS=920000U PD=1830000U
M$12 VGND synth_1 X VNB nfet_01v8 L=150000U W=650000U AS=169000000000P
+ AD=169000000000P PS=1820000U PD=1820000U
.ENDS sky130_fd_sc_hd__o2111a_1

.SUBCKT sky130_fd_sc_hd__o21ai_2 VPB A1 A2 B1 VGND Y VPWR VNB
M$1 synth_2 A1 VPWR VPB pfet_01v8_hvt L=150000U W=2000000U AS=440000000000P
+ AD=300000000000P PS=3880000U PD=2600000U
M$2 Y A2 synth_2 VPB pfet_01v8_hvt L=150000U W=2000000U AS=280000000000P
+ AD=315000000000P PS=2560000U PD=2630000U
M$5 Y B1 VPWR VPB pfet_01v8_hvt L=150000U W=2000000U AS=300000000000P
+ AD=405000000000P PS=2600000U PD=3810000U
M$7 VGND A1 synth_1 VNB nfet_01v8 L=150000U W=1300000U AS=299000000000P
+ AD=182000000000P PS=2870000U PD=1860000U
M$8 synth_1 A2 VGND VNB nfet_01v8 L=150000U W=1300000U AS=182000000000P
+ AD=217750000000P PS=1860000U PD=1970000U
M$11 Y B1 synth_1 VNB nfet_01v8 L=150000U W=1300000U AS=182000000000P
+ AD=263250000000P PS=1860000U PD=2760000U
.ENDS sky130_fd_sc_hd__o21ai_2

.SUBCKT sky130_fd_sc_hd__o211ai_2 VGND Y A1 C1 B1 A2 VPWR VPB VNB
M$1 Y A2 synth_3 VPB pfet_01v8_hvt L=150000U W=2000000U AS=405000000000P
+ AD=280000000000P PS=3810000U PD=2560000U
M$3 VPWR A1 synth_3 VPB pfet_01v8_hvt L=150000U W=2000000U AS=280000000000P
+ AD=405000000000P PS=2560000U PD=3810000U
M$5 Y C1 VPWR VPB pfet_01v8_hvt L=150000U W=2000000U AS=405000000000P
+ AD=280000000000P PS=3810000U PD=2560000U
M$7 Y B1 VPWR VPB pfet_01v8_hvt L=150000U W=2000000U AS=280000000000P
+ AD=405000000000P PS=2560000U PD=3810000U
M$9 synth_2 A2 VGND VNB nfet_01v8 L=150000U W=1300000U AS=276250000000P
+ AD=182000000000P PS=2800000U PD=1860000U
M$11 synth_2 A1 VGND VNB nfet_01v8 L=150000U W=1300000U AS=182000000000P
+ AD=276250000000P PS=1860000U PD=2800000U
M$13 Y C1 synth_1 VNB nfet_01v8 L=150000U W=1300000U AS=276250000000P
+ AD=182000000000P PS=2800000U PD=1860000U
M$15 synth_2 B1 synth_1 VNB nfet_01v8 L=150000U W=1300000U AS=182000000000P
+ AD=276250000000P PS=1860000U PD=2800000U
.ENDS sky130_fd_sc_hd__o211ai_2

.SUBCKT sky130_fd_sc_hd__a31oi_2 VGND Y A3 A2 A1 B1 VPWR VPB VNB
M$1 VPWR A3 synth_3 VPB pfet_01v8_hvt L=150000U W=2000000U AS=395000000000P
+ AD=270000000000P PS=3790000U PD=2540000U
M$3 VPWR A2 synth_3 VPB pfet_01v8_hvt L=150000U W=2000000U AS=270000000000P
+ AD=270000000000P PS=2540000U PD=2540000U
M$5 VPWR A1 synth_3 VPB pfet_01v8_hvt L=150000U W=2000000U AS=545000000000P
+ AD=590000000000P PS=3090000U PD=3180000U
M$7 Y B1 synth_3 VPB pfet_01v8_hvt L=150000U W=2000000U AS=355000000000P
+ AD=435000000000P PS=2710000U PD=3870000U
M$9 synth_2 A1 Y VNB nfet_01v8 L=150000U W=1300000U AS=266500000000P
+ AD=214500000000P PS=2770000U PD=1960000U
M$11 VGND B1 Y VNB nfet_01v8 L=150000U W=1300000U AS=230750000000P
+ AD=282750000000P PS=2010000U PD=2820000U
M$13 VGND A3 synth_1 VNB nfet_01v8 L=150000U W=1300000U AS=256750000000P
+ AD=175500000000P PS=2740000U PD=1840000U
M$15 synth_2 A2 synth_1 VNB nfet_01v8 L=150000U W=1300000U AS=175500000000P
+ AD=256750000000P PS=1840000U PD=2740000U
.ENDS sky130_fd_sc_hd__a31oi_2

.SUBCKT sky130_fd_sc_hd__a211oi_2 VGND Y C1 B1 A1 A2 VPWR VPB VNB
M$1 synth_3 A1 VPWR VPB pfet_01v8_hvt L=150000U W=2000000U AS=405000000000P
+ AD=280000000000P PS=3810000U PD=2560000U
M$3 synth_3 A2 VPWR VPB pfet_01v8_hvt L=150000U W=2000000U AS=280000000000P
+ AD=405000000000P PS=2560000U PD=3810000U
M$5 Y C1 synth_2 VPB pfet_01v8_hvt L=150000U W=2000000U AS=405000000000P
+ AD=280000000000P PS=3810000U PD=2560000U
M$7 synth_3 B1 synth_2 VPB pfet_01v8_hvt L=150000U W=2000000U AS=280000000000P
+ AD=405000000000P PS=2560000U PD=3810000U
M$9 Y A1 synth_1 VNB nfet_01v8 L=150000U W=1300000U AS=263250000000P
+ AD=182000000000P PS=2760000U PD=1860000U
M$11 VGND A2 synth_1 VNB nfet_01v8 L=150000U W=1300000U AS=182000000000P
+ AD=263250000000P PS=1860000U PD=2760000U
M$13 Y C1 VGND VNB nfet_01v8 L=150000U W=1300000U AS=263250000000P
+ AD=182000000000P PS=2760000U PD=1860000U
M$15 Y B1 VGND VNB nfet_01v8 L=150000U W=1300000U AS=182000000000P
+ AD=263250000000P PS=1860000U PD=2760000U
.ENDS sky130_fd_sc_hd__a211oi_2

.SUBCKT sky130_fd_sc_hd__o221a_2 VGND C1 B1 B2 A2 A1 X VPWR VPB VNB
M$1 VPWR C1 synth_1 VPB pfet_01v8_hvt L=150000U W=1000000U AS=325000000000P
+ AD=165000000000P PS=2650000U PD=1330000U
M$2 synth_4 B1 VPWR VPB pfet_01v8_hvt L=150000U W=1000000U AS=165000000000P
+ AD=112500000000P PS=1330000U PD=1225000U
M$3 synth_1 B2 synth_4 VPB pfet_01v8_hvt L=150000U W=1000000U AS=112500000000P
+ AD=387500000000P PS=1225000U PD=1775000U
M$4 synth_5 A2 synth_1 VPB pfet_01v8_hvt L=150000U W=1000000U AS=387500000000P
+ AD=105000000000P PS=1775000U PD=1210000U
M$5 VPWR A1 synth_5 VPB pfet_01v8_hvt L=150000U W=1000000U AS=105000000000P
+ AD=165000000000P PS=1210000U PD=1330000U
M$6 X synth_1 VPWR VPB pfet_01v8_hvt L=150000U W=2000000U AS=300000000000P
+ AD=395000000000P PS=2600000U PD=3790000U
M$8 synth_3 A2 VGND VNB nfet_01v8 L=150000U W=650000U AS=169000000000P
+ AD=87750000000P PS=1820000U PD=920000U
M$9 VGND A1 synth_3 VNB nfet_01v8 L=150000U W=650000U AS=87750000000P
+ AD=87750000000P PS=920000U PD=920000U
M$10 X synth_1 VGND VNB nfet_01v8 L=150000U W=1300000U AS=175500000000P
+ AD=256750000000P PS=1840000U PD=2740000U
M$12 synth_2 C1 synth_1 VNB nfet_01v8 L=150000U W=650000U AS=237250000000P
+ AD=87750000000P PS=2030000U PD=920000U
M$13 synth_3 B1 synth_2 VNB nfet_01v8 L=150000U W=650000U AS=87750000000P
+ AD=87750000000P PS=920000U PD=920000U
M$14 synth_2 B2 synth_3 VNB nfet_01v8 L=150000U W=650000U AS=87750000000P
+ AD=169000000000P PS=920000U PD=1820000U
.ENDS sky130_fd_sc_hd__o221a_2

.SUBCKT sky130_fd_sc_hd__o311ai_2 VGND Y A1 A2 A3 B1 C1 VPWR VPB VNB
M$1 synth_4 A3 Y VPB pfet_01v8_hvt L=150000U W=2000000U AS=395000000000P
+ AD=270000000000P PS=3790000U PD=2540000U
M$3 VPWR B1 Y VPB pfet_01v8_hvt L=150000U W=2000000U AS=440000000000P
+ AD=510000000000P PS=2880000U PD=3020000U
M$5 VPWR C1 Y VPB pfet_01v8_hvt L=150000U W=2000000U AS=340000000000P
+ AD=395000000000P PS=2680000U PD=3790000U
M$7 VPWR A1 synth_3 VPB pfet_01v8_hvt L=150000U W=2000000U AS=395000000000P
+ AD=270000000000P PS=3790000U PD=2540000U
M$9 synth_4 A2 synth_3 VPB pfet_01v8_hvt L=150000U W=2000000U AS=270000000000P
+ AD=395000000000P PS=2540000U PD=3790000U
M$11 synth_2 C1 Y VNB nfet_01v8 L=150000U W=1300000U AS=269750000000P
+ AD=256750000000P PS=2780000U PD=2740000U
M$13 VGND A1 synth_1 VNB nfet_01v8 L=150000U W=1300000U AS=256750000000P
+ AD=175500000000P PS=2740000U PD=1840000U
M$15 VGND A2 synth_1 VNB nfet_01v8 L=150000U W=1300000U AS=175500000000P
+ AD=175500000000P PS=1840000U PD=1840000U
M$17 VGND A3 synth_1 VNB nfet_01v8 L=150000U W=1300000U AS=318500000000P
+ AD=318500000000P PS=2280000U PD=2280000U
M$19 synth_2 B1 synth_1 VNB nfet_01v8 L=150000U W=1300000U AS=175500000000P
+ AD=269750000000P PS=1840000U PD=2780000U
.ENDS sky130_fd_sc_hd__o311ai_2

.SUBCKT sky130_fd_sc_hd__nor3_2 VPB A B C Y VGND VPWR VNB
M$1 Y C synth_2 VPB pfet_01v8_hvt L=150000U W=2000000U AS=395000000000P
+ AD=395000000000P PS=3790000U PD=3790000U
M$3 VPWR A synth_1 VPB pfet_01v8_hvt L=150000U W=2000000U AS=415000000000P
+ AD=270000000000P PS=3830000U PD=2540000U
M$5 synth_2 B synth_1 VPB pfet_01v8_hvt L=150000U W=2000000U AS=270000000000P
+ AD=415000000000P PS=2540000U PD=3830000U
M$7 Y C VGND VNB nfet_01v8 L=150000U W=1300000U AS=256750000000P
+ AD=256750000000P PS=2740000U PD=2740000U
M$9 Y A VGND VNB nfet_01v8 L=150000U W=1300000U AS=266500000000P
+ AD=175500000000P PS=2770000U PD=1840000U
M$11 Y B VGND VNB nfet_01v8 L=150000U W=1300000U AS=175500000000P
+ AD=256750000000P PS=1840000U PD=2740000U
.ENDS sky130_fd_sc_hd__nor3_2

.SUBCKT sky130_fd_sc_hd__buf_12 VGND A X VPWR VPB VNB
M$1 synth_1 A VPWR VPB pfet_01v8_hvt L=150000U W=4000000U AS=665000000000P
+ AD=540000000000P PS=6330000U PD=5080000U
M$5 X synth_1 VPWR VPB pfet_01v8_hvt L=150000U W=12000000U AS=1.62e+12P
+ AD=1.865e+12P PS=15240000U PD=16730000U
M$17 synth_1 A VGND VNB nfet_01v8 L=150000U W=2600000U AS=432250000000P
+ AD=351000000000P PS=4580000U PD=3680000U
M$21 X synth_1 VGND VNB nfet_01v8 L=150000U W=7800000U AS=1.053e+12P
+ AD=1.21225e+12P PS=11040000U PD=12180000U
.ENDS sky130_fd_sc_hd__buf_12

.SUBCKT sky130_fd_sc_hd__nor4b_2 VGND Y A B C D_N VPWR VPB VNB
M$1 VPWR D_N synth_1 VPB pfet_01v8_hvt L=150000U W=420000U AS=109200000000P
+ AD=109200000000P PS=1360000U PD=1360000U
M$2 synth_4 C synth_3 VPB pfet_01v8_hvt L=150000U W=2000000U AS=395000000000P
+ AD=270000000000P PS=3790000U PD=2540000U
M$4 Y synth_1 synth_3 VPB pfet_01v8_hvt L=150000U W=2000000U AS=270000000000P
+ AD=395000000000P PS=2540000U PD=3790000U
M$6 VPWR A synth_2 VPB pfet_01v8_hvt L=150000U W=2000000U AS=395000000000P
+ AD=270000000000P PS=3790000U PD=2540000U
M$8 synth_4 B synth_2 VPB pfet_01v8_hvt L=150000U W=2000000U AS=270000000000P
+ AD=395000000000P PS=2540000U PD=3790000U
M$10 VGND D_N synth_1 VNB nfet_01v8 L=150000U W=420000U AS=109200000000P
+ AD=109200000000P PS=1360000U PD=1360000U
M$11 Y C VGND VNB nfet_01v8 L=150000U W=1300000U AS=256750000000P
+ AD=175500000000P PS=2740000U PD=1840000U
M$13 Y synth_1 VGND VNB nfet_01v8 L=150000U W=1300000U AS=175500000000P
+ AD=256750000000P PS=1840000U PD=2740000U
M$15 Y A VGND VNB nfet_01v8 L=150000U W=1300000U AS=256750000000P
+ AD=175500000000P PS=2740000U PD=1840000U
M$17 Y B VGND VNB nfet_01v8 L=150000U W=1300000U AS=175500000000P
+ AD=256750000000P PS=1840000U PD=2740000U
.ENDS sky130_fd_sc_hd__nor4b_2

.SUBCKT sky130_fd_sc_hd__o21ai_1 VPB A1 B1 A2 VPWR VGND Y VNB
M$1 synth_2 A1 VPWR VPB pfet_01v8_hvt L=150000U W=1000000U AS=260000000000P
+ AD=105000000000P PS=2520000U PD=1210000U
M$2 Y A2 synth_2 VPB pfet_01v8_hvt L=150000U W=1000000U AS=105000000000P
+ AD=174000000000P PS=1210000U PD=1390000U
M$3 VPWR B1 Y VPB pfet_01v8_hvt L=150000U W=700000U AS=174000000000P
+ AD=182000000000P PS=1390000U PD=1920000U
M$4 VGND A1 synth_1 VNB nfet_01v8 L=150000U W=650000U AS=169000000000P
+ AD=107250000000P PS=1820000U PD=980000U
M$5 synth_1 A2 VGND VNB nfet_01v8 L=150000U W=650000U AS=107250000000P
+ AD=87750000000P PS=980000U PD=920000U
M$6 Y B1 synth_1 VNB nfet_01v8 L=150000U W=650000U AS=87750000000P
+ AD=169000000000P PS=920000U PD=1820000U
.ENDS sky130_fd_sc_hd__o21ai_1

.SUBCKT sky130_fd_sc_hd__o211a_1 VPB C1 B1 A2 A1 VGND VPWR X VNB
M$1 synth_3 A1 VPWR VPB pfet_01v8_hvt L=150000U W=1000000U AS=260000000000P
+ AD=162500000000P PS=2520000U PD=1325000U
M$2 synth_1 A2 synth_3 VPB pfet_01v8_hvt L=150000U W=1000000U AS=162500000000P
+ AD=220000000000P PS=1325000U PD=1440000U
M$3 VPWR B1 synth_1 VPB pfet_01v8_hvt L=150000U W=1000000U AS=220000000000P
+ AD=175000000000P PS=1440000U PD=1350000U
M$4 synth_1 C1 VPWR VPB pfet_01v8_hvt L=150000U W=1000000U AS=175000000000P
+ AD=300000000000P PS=1350000U PD=2600000U
M$5 VPWR synth_1 X VPB pfet_01v8_hvt L=150000U W=1000000U AS=260000000000P
+ AD=260000000000P PS=2520000U PD=2520000U
M$6 VGND A1 synth_2 VNB nfet_01v8 L=150000U W=650000U AS=169000000000P
+ AD=105625000000P PS=1820000U PD=975000U
M$7 synth_2 A2 VGND VNB nfet_01v8 L=150000U W=650000U AS=105625000000P
+ AD=143000000000P PS=975000U PD=1090000U
M$8 synth_4 B1 synth_2 VNB nfet_01v8 L=150000U W=650000U AS=143000000000P
+ AD=113750000000P PS=1090000U PD=1000000U
M$9 synth_1 C1 synth_4 VNB nfet_01v8 L=150000U W=650000U AS=113750000000P
+ AD=195000000000P PS=1000000U PD=1900000U
M$10 VGND synth_1 X VNB nfet_01v8 L=150000U W=650000U AS=169000000000P
+ AD=169000000000P PS=1820000U PD=1820000U
.ENDS sky130_fd_sc_hd__o211a_1

.SUBCKT sky130_fd_sc_hd__or3b_2 VPB B A C_N X VGND VPWR VNB
M$1 synth_4 A VPWR VPB pfet_01v8_hvt L=150000U W=420000U AS=148250000000P
+ AD=56700000000P PS=1340000U PD=690000U
M$2 synth_3 B synth_4 VPB pfet_01v8_hvt L=150000U W=420000U AS=56700000000P
+ AD=56700000000P PS=690000U PD=690000U
M$3 synth_2 synth_1 synth_3 VPB pfet_01v8_hvt L=150000U W=420000U
+ AS=56700000000P AD=109200000000P PS=690000U PD=1360000U
M$4 synth_1 C_N VPWR VPB pfet_01v8_hvt L=150000U W=420000U AS=145750000000P
+ AD=109200000000P PS=1335000U PD=1360000U
M$5 X synth_2 VPWR VPB pfet_01v8_hvt L=150000U W=2000000U AS=280750000000P
+ AD=283250000000P PS=2605000U PD=2610000U
M$7 VGND C_N synth_1 VNB nfet_01v8 L=150000U W=420000U AS=109200000000P
+ AD=100250000000P PS=1360000U PD=985000U
M$8 synth_2 A VGND VNB nfet_01v8 L=150000U W=420000U AS=101875000000P
+ AD=56700000000P PS=990000U PD=690000U
M$9 VGND B synth_2 VNB nfet_01v8 L=150000U W=420000U AS=56700000000P
+ AD=56700000000P PS=690000U PD=690000U
M$10 synth_2 synth_1 VGND VNB nfet_01v8 L=150000U W=420000U AS=56700000000P
+ AD=109200000000P PS=690000U PD=1360000U
M$11 X synth_2 VGND VNB nfet_01v8 L=150000U W=1300000U AS=188000000000P
+ AD=189625000000P PS=1905000U PD=1910000U
.ENDS sky130_fd_sc_hd__or3b_2

.SUBCKT sky130_fd_sc_hd__or4_4 VGND X D C B A VPWR VPB VNB
M$1 synth_2 D synth_1 VPB pfet_01v8_hvt L=150000U W=1000000U AS=260000000000P
+ AD=190000000000P PS=2520000U PD=1380000U
M$2 synth_4 C synth_2 VPB pfet_01v8_hvt L=150000U W=1000000U AS=190000000000P
+ AD=135000000000P PS=1380000U PD=1270000U
M$3 synth_3 B synth_4 VPB pfet_01v8_hvt L=150000U W=1000000U AS=135000000000P
+ AD=135000000000P PS=1270000U PD=1270000U
M$4 VPWR A synth_3 VPB pfet_01v8_hvt L=150000U W=1000000U AS=135000000000P
+ AD=190000000000P PS=1270000U PD=1380000U
M$5 X synth_1 VPWR VPB pfet_01v8_hvt L=150000U W=4000000U AS=595000000000P
+ AD=675000000000P PS=5190000U PD=6350000U
M$9 synth_1 D VGND VNB nfet_01v8 L=150000U W=650000U AS=169000000000P
+ AD=123500000000P PS=1820000U PD=1030000U
M$10 VGND C synth_1 VNB nfet_01v8 L=150000U W=650000U AS=123500000000P
+ AD=87750000000P PS=1030000U PD=920000U
M$11 synth_1 B VGND VNB nfet_01v8 L=150000U W=650000U AS=87750000000P
+ AD=87750000000P PS=920000U PD=920000U
M$12 VGND A synth_1 VNB nfet_01v8 L=150000U W=650000U AS=87750000000P
+ AD=123500000000P PS=920000U PD=1030000U
M$13 X synth_1 VGND VNB nfet_01v8 L=150000U W=2600000U AS=386750000000P
+ AD=442000000000P PS=3790000U PD=4610000U
.ENDS sky130_fd_sc_hd__or4_4

.SUBCKT sky130_fd_sc_hd__inv_4 VPB A VGND VPWR VNB
M$1 Y A VPWR VPB pfet_01v8_hvt L=150000U W=4000000U AS=665000000000P
+ AD=665000000000P PS=6330000U PD=6330000U
M$5 Y A VGND VNB nfet_01v8 L=150000U W=2600000U AS=432250000000P
+ AD=432250000000P PS=4580000U PD=4580000U
.ENDS sky130_fd_sc_hd__inv_4

.SUBCKT sky130_fd_sc_hd__and2b_1 VPB B A_N X VGND VPWR VNB
M$1 VPWR A_N synth_2 VPB pfet_01v8_hvt L=150000U W=420000U AS=109200000000P
+ AD=71400000000P PS=1360000U PD=760000U
M$2 synth_1 synth_2 VPWR VPB pfet_01v8_hvt L=150000U W=420000U AS=71400000000P
+ AD=60900000000P PS=760000U PD=710000U
M$3 synth_1 B VPWR VPB pfet_01v8_hvt L=150000U W=420000U AS=227900000000P
+ AD=60900000000P PS=1740000U PD=710000U
M$4 X synth_1 VPWR VPB pfet_01v8_hvt L=150000U W=1000000U AS=227900000000P
+ AD=260000000000P PS=1740000U PD=2520000U
M$5 synth_3 synth_2 synth_1 VNB nfet_01v8 L=150000U W=420000U AS=109200000000P
+ AD=50400000000P PS=1360000U PD=660000U
M$6 VGND B synth_3 VNB nfet_01v8 L=150000U W=420000U AS=50400000000P
+ AD=101300000000P PS=660000U PD=990000U
M$7 X synth_1 VGND VNB nfet_01v8 L=150000U W=650000U AS=101300000000P
+ AD=169000000000P PS=990000U PD=1820000U
M$8 synth_2 A_N VGND VNB nfet_01v8 L=150000U W=420000U AS=109200000000P
+ AD=109200000000P PS=1360000U PD=1360000U
.ENDS sky130_fd_sc_hd__and2b_1

.SUBCKT sky130_fd_sc_hd__nand4_2 VGND Y D C B A VPWR VPB VNB
M$1 Y D VPWR VPB pfet_01v8_hvt L=150000U W=2000000U AS=395000000000P
+ AD=270000000000P PS=3790000U PD=2540000U
M$3 Y C VPWR VPB pfet_01v8_hvt L=150000U W=2000000U AS=270000000000P
+ AD=350000000000P PS=2540000U PD=2700000U
M$5 Y B VPWR VPB pfet_01v8_hvt L=150000U W=2000000U AS=350000000000P
+ AD=470000000000P PS=2700000U PD=2940000U
M$7 Y A VPWR VPB pfet_01v8_hvt L=150000U W=2000000U AS=470000000000P
+ AD=555000000000P PS=2940000U PD=4110000U
M$9 synth_2 B synth_3 VNB nfet_01v8 L=150000U W=1300000U AS=269750000000P
+ AD=175500000000P PS=2780000U PD=1840000U
M$11 Y A synth_3 VNB nfet_01v8 L=150000U W=1300000U AS=175500000000P
+ AD=321750000000P PS=1840000U PD=2940000U
M$13 VGND D synth_1 VNB nfet_01v8 L=150000U W=1300000U AS=256750000000P
+ AD=175500000000P PS=2740000U PD=1840000U
M$15 synth_2 C synth_1 VNB nfet_01v8 L=150000U W=1300000U AS=175500000000P
+ AD=269750000000P PS=1840000U PD=2780000U
.ENDS sky130_fd_sc_hd__nand4_2

.SUBCKT sky130_fd_sc_hd__a32o_1 VGND X A2 A1 B1 A3 B2 VPWR VPB VNB
M$1 VPWR synth_1 X VPB pfet_01v8_hvt L=150000U W=1000000U AS=330000000000P
+ AD=242500000000P PS=2660000U PD=1485000U
M$2 synth_5 A3 VPWR VPB pfet_01v8_hvt L=150000U W=1000000U AS=242500000000P
+ AD=165000000000P PS=1485000U PD=1330000U
M$3 VPWR A2 synth_5 VPB pfet_01v8_hvt L=150000U W=1000000U AS=165000000000P
+ AD=225000000000P PS=1330000U PD=1450000U
M$4 synth_5 A1 VPWR VPB pfet_01v8_hvt L=150000U W=1000000U AS=225000000000P
+ AD=185000000000P PS=1450000U PD=1370000U
M$5 synth_1 B1 synth_5 VPB pfet_01v8_hvt L=150000U W=1000000U AS=185000000000P
+ AD=140000000000P PS=1370000U PD=1280000U
M$6 synth_5 B2 synth_1 VPB pfet_01v8_hvt L=150000U W=1000000U AS=140000000000P
+ AD=265000000000P PS=1280000U PD=2530000U
M$7 VGND synth_1 X VNB nfet_01v8 L=150000U W=650000U AS=214500000000P
+ AD=167375000000P PS=1960000U PD=1165000U
M$8 synth_2 A3 VGND VNB nfet_01v8 L=150000U W=650000U AS=167375000000P
+ AD=97500000000P PS=1165000U PD=950000U
M$9 synth_4 A2 synth_2 VNB nfet_01v8 L=150000U W=650000U AS=97500000000P
+ AD=146250000000P PS=950000U PD=1100000U
M$10 synth_1 A1 synth_4 VNB nfet_01v8 L=150000U W=650000U AS=146250000000P
+ AD=143000000000P PS=1100000U PD=1090000U
M$11 synth_3 B1 synth_1 VNB nfet_01v8 L=150000U W=650000U AS=143000000000P
+ AD=68250000000P PS=1090000U PD=860000U
M$12 VGND B2 synth_3 VNB nfet_01v8 L=150000U W=650000U AS=68250000000P
+ AD=172250000000P PS=860000U PD=1830000U
.ENDS sky130_fd_sc_hd__a32o_1

.SUBCKT sky130_fd_sc_hd__a31o_2 VPB B1 A1 A2 A3 X VPWR VGND VNB
M$1 X synth_2 VPWR VPB pfet_01v8_hvt L=150000U W=2000000U AS=395000000000P
+ AD=270000000000P PS=3790000U PD=2540000U
M$3 synth_1 A3 VPWR VPB pfet_01v8_hvt L=150000U W=1000000U AS=135000000000P
+ AD=135000000000P PS=1270000U PD=1270000U
M$4 VPWR A2 synth_1 VPB pfet_01v8_hvt L=150000U W=1000000U AS=135000000000P
+ AD=165000000000P PS=1270000U PD=1330000U
M$5 synth_1 A1 VPWR VPB pfet_01v8_hvt L=150000U W=1000000U AS=165000000000P
+ AD=165000000000P PS=1330000U PD=1330000U
M$6 synth_2 B1 synth_1 VPB pfet_01v8_hvt L=150000U W=1000000U AS=165000000000P
+ AD=320000000000P PS=1330000U PD=2640000U
M$7 X synth_2 VGND VNB nfet_01v8 L=150000U W=1300000U AS=256750000000P
+ AD=175500000000P PS=2740000U PD=1840000U
M$9 synth_4 A3 VGND VNB nfet_01v8 L=150000U W=650000U AS=87750000000P
+ AD=87750000000P PS=920000U PD=920000U
M$10 synth_3 A2 synth_4 VNB nfet_01v8 L=150000U W=650000U AS=87750000000P
+ AD=107250000000P PS=920000U PD=980000U
M$11 synth_2 A1 synth_3 VNB nfet_01v8 L=150000U W=650000U AS=107250000000P
+ AD=126750000000P PS=980000U PD=1040000U
M$12 VGND B1 synth_2 VNB nfet_01v8 L=150000U W=650000U AS=126750000000P
+ AD=169000000000P PS=1040000U PD=1820000U
.ENDS sky130_fd_sc_hd__a31o_2

.SUBCKT sky130_fd_sc_hd__inv_2 VPB A VGND VPWR Y VNB
M$1 Y A VPWR VPB pfet_01v8_hvt L=150000U W=2000000U AS=395000000000P
+ AD=395000000000P PS=3790000U PD=3790000U
M$3 Y A VGND VNB nfet_01v8 L=150000U W=1300000U AS=256750000000P
+ AD=256750000000P PS=2740000U PD=2740000U
.ENDS sky130_fd_sc_hd__inv_2

.SUBCKT sky130_fd_sc_hd__inv_16 VGND A VPWR VPB VNB
M$1 Y A VPWR VPB pfet_01v8_hvt L=150000U W=16000000U AS=2.285e+12P
+ AD=2.285e+12P PS=21570000U PD=21570000U
M$17 Y A VGND VNB nfet_01v8 L=150000U W=10400000U AS=1.48525e+12P
+ AD=1.48525e+12P PS=15620000U PD=15620000U
.ENDS sky130_fd_sc_hd__inv_16

.SUBCKT sky130_fd_sc_hd__nand4_4 VGND D A C B Y VPWR VPB VNB
M$1 Y D VPWR VPB pfet_01v8_hvt L=150000U W=4000000U AS=665000000000P
+ AD=540000000000P PS=6330000U PD=5080000U
M$5 Y C VPWR VPB pfet_01v8_hvt L=150000U W=4000000U AS=540000000000P
+ AD=800000000000P PS=5080000U PD=5600000U
M$9 Y B VPWR VPB pfet_01v8_hvt L=150000U W=4000000U AS=800000000000P
+ AD=570000000000P PS=5600000U PD=5140000U
M$13 Y A VPWR VPB pfet_01v8_hvt L=150000U W=4000000U AS=570000000000P
+ AD=665000000000P PS=5140000U PD=6330000U
M$17 synth_2 B synth_3 VNB nfet_01v8 L=150000U W=2600000U AS=432250000000P
+ AD=370500000000P PS=4580000U PD=3740000U
M$21 Y A synth_3 VNB nfet_01v8 L=150000U W=2600000U AS=370500000000P
+ AD=432250000000P PS=3740000U PD=4580000U
M$25 VGND D synth_1 VNB nfet_01v8 L=150000U W=2600000U AS=432250000000P
+ AD=351000000000P PS=4580000U PD=3680000U
M$29 synth_2 C synth_1 VNB nfet_01v8 L=150000U W=2600000U AS=351000000000P
+ AD=432250000000P PS=3680000U PD=4580000U
.ENDS sky130_fd_sc_hd__nand4_4

.SUBCKT sky130_fd_sc_hd__o31ai_4 VGND B1 A1 A2 A3 Y VPWR VPB VNB
M$1 synth_3 A3 Y VPB pfet_01v8_hvt L=150000U W=4000000U AS=667800000000P
+ AD=540000000000P PS=6380000U PD=5080000U
M$5 VPWR B1 Y VPB pfet_01v8_hvt L=150000U W=4000000U AS=540000000000P
+ AD=665000000000P PS=5080000U PD=6330000U
M$9 VPWR A1 synth_2 VPB pfet_01v8_hvt L=150000U W=4000000U AS=685000000000P
+ AD=540000000000P PS=6370000U PD=5080000U
M$13 synth_3 A2 synth_2 VPB pfet_01v8_hvt L=150000U W=4000000U AS=540000000000P
+ AD=665500000000P PS=5080000U PD=6370000U
M$17 VGND A1 synth_1 VNB nfet_01v8 L=150000U W=2600000U AS=432250000000P
+ AD=351000000000P PS=4580000U PD=3680000U
M$21 VGND A2 synth_1 VNB nfet_01v8 L=150000U W=2600000U AS=351000000000P
+ AD=351000000000P PS=3680000U PD=3680000U
M$25 VGND A3 synth_1 VNB nfet_01v8 L=150000U W=2600000U AS=524875000000P
+ AD=524875000000P PS=4215000U PD=4215000U
M$29 Y B1 synth_1 VNB nfet_01v8 L=150000U W=2600000U AS=351000000000P
+ AD=432250000000P PS=3680000U PD=4580000U
.ENDS sky130_fd_sc_hd__o31ai_4

.SUBCKT sky130_fd_sc_hd__nor4_2 VGND Y A B C D VPWR VPB VNB
M$1 synth_2 C synth_3 VPB pfet_01v8_hvt L=150000U W=2000000U AS=415000000000P
+ AD=270000000000P PS=3830000U PD=2540000U
M$3 Y D synth_3 VPB pfet_01v8_hvt L=150000U W=2000000U AS=270000000000P
+ AD=395000000000P PS=2540000U PD=3790000U
M$5 VPWR A synth_1 VPB pfet_01v8_hvt L=150000U W=2000000U AS=415000000000P
+ AD=270000000000P PS=3830000U PD=2540000U
M$7 synth_2 B synth_1 VPB pfet_01v8_hvt L=150000U W=2000000U AS=270000000000P
+ AD=415000000000P PS=2540000U PD=3830000U
M$9 Y C VGND VNB nfet_01v8 L=150000U W=1300000U AS=269750000000P
+ AD=175500000000P PS=2780000U PD=1840000U
M$11 Y D VGND VNB nfet_01v8 L=150000U W=1300000U AS=175500000000P
+ AD=256750000000P PS=1840000U PD=2740000U
M$13 Y A VGND VNB nfet_01v8 L=150000U W=1300000U AS=269750000000P
+ AD=175500000000P PS=2780000U PD=1840000U
M$15 Y B VGND VNB nfet_01v8 L=150000U W=1300000U AS=175500000000P
+ AD=269750000000P PS=1840000U PD=2780000U
.ENDS sky130_fd_sc_hd__nor4_2

.SUBCKT sky130_fd_sc_hd__nor4_4 VGND Y A B C D VPWR VPB VNB
M$1 synth_2 C synth_3 VPB pfet_01v8_hvt L=150000U W=4000000U AS=665000000000P
+ AD=540000000000P PS=6330000U PD=5080000U
M$5 Y D synth_3 VPB pfet_01v8_hvt L=150000U W=4000000U AS=540000000000P
+ AD=665000000000P PS=5080000U PD=6330000U
M$9 VPWR A synth_1 VPB pfet_01v8_hvt L=150000U W=4000000U AS=685000000000P
+ AD=540000000000P PS=6370000U PD=5080000U
M$13 synth_2 B synth_1 VPB pfet_01v8_hvt L=150000U W=4000000U AS=540000000000P
+ AD=665000000000P PS=5080000U PD=6330000U
M$17 Y A VGND VNB nfet_01v8 L=150000U W=2600000U AS=445250000000P
+ AD=351000000000P PS=4620000U PD=3680000U
M$21 Y B VGND VNB nfet_01v8 L=150000U W=2600000U AS=351000000000P
+ AD=520000000000P PS=3680000U PD=4200000U
M$25 Y C VGND VNB nfet_01v8 L=150000U W=2600000U AS=520000000000P
+ AD=351000000000P PS=4200000U PD=3680000U
M$29 Y D VGND VNB nfet_01v8 L=150000U W=2600000U AS=351000000000P
+ AD=432250000000P PS=3680000U PD=4580000U
.ENDS sky130_fd_sc_hd__nor4_4

.SUBCKT sky130_fd_sc_hd__mux2_2 VGND X A0 A1 S VPWR VPB VNB
M$1 X synth_1 VPWR VPB pfet_01v8_hvt L=150000U W=2000000U AS=395000000000P
+ AD=312800000000P PS=3790000U PD=2685000U
M$3 synth_5 synth_4 VPWR VPB pfet_01v8_hvt L=150000U W=640000U AS=177800000000P
+ AD=228800000000P PS=1415000U PD=1355000U
M$4 synth_1 A1 synth_5 VPB pfet_01v8_hvt L=150000U W=640000U AS=228800000000P
+ AD=131200000000P PS=1355000U PD=1050000U
M$5 synth_6 A0 synth_1 VPB pfet_01v8_hvt L=150000U W=640000U AS=131200000000P
+ AD=67200000000P PS=1050000U PD=850000U
M$6 VPWR S synth_6 VPB pfet_01v8_hvt L=150000U W=640000U AS=67200000000P
+ AD=86400000000P PS=850000U PD=910000U
M$7 synth_4 S VPWR VPB pfet_01v8_hvt L=150000U W=640000U AS=86400000000P
+ AD=172800000000P PS=910000U PD=1820000U
M$8 synth_2 synth_4 VGND VNB nfet_01v8 L=150000U W=420000U AS=97000000000P
+ AD=68250000000P PS=975000U PD=745000U
M$9 synth_1 A0 synth_2 VNB nfet_01v8 L=150000U W=420000U AS=68250000000P
+ AD=173250000000P PS=745000U PD=1245000U
M$10 synth_3 A1 synth_1 VNB nfet_01v8 L=150000U W=420000U AS=173250000000P
+ AD=57750000000P PS=1245000U PD=695000U
M$11 VGND S synth_3 VNB nfet_01v8 L=150000U W=420000U AS=57750000000P
+ AD=56700000000P PS=695000U PD=690000U
M$12 synth_4 S VGND VNB nfet_01v8 L=150000U W=420000U AS=56700000000P
+ AD=113400000000P PS=690000U PD=1380000U
M$13 X synth_1 VGND VNB nfet_01v8 L=150000U W=1300000U AS=256750000000P
+ AD=184750000000P PS=2740000U PD=1895000U
.ENDS sky130_fd_sc_hd__mux2_2

.SUBCKT sky130_fd_sc_hd__and4_1 VPB D C B A VGND VPWR X VNB
M$1 synth_1 A VPWR VPB pfet_01v8_hvt L=150000U W=420000U AS=109200000000P
+ AD=73500000000P PS=1360000U PD=770000U
M$2 VPWR B synth_1 VPB pfet_01v8_hvt L=150000U W=420000U AS=73500000000P
+ AD=77700000000P PS=770000U PD=790000U
M$3 synth_1 C VPWR VPB pfet_01v8_hvt L=150000U W=420000U AS=77700000000P
+ AD=58800000000P PS=790000U PD=700000U
M$4 synth_1 D VPWR VPB pfet_01v8_hvt L=150000U W=420000U AS=312450000000P
+ AD=58800000000P PS=1680000U PD=700000U
M$5 X synth_1 VPWR VPB pfet_01v8_hvt L=150000U W=1000000U AS=312450000000P
+ AD=260000000000P PS=1680000U PD=2520000U
M$6 synth_4 A synth_1 VNB nfet_01v8 L=150000U W=420000U AS=109200000000P
+ AD=60900000000P PS=1360000U PD=710000U
M$7 synth_2 B synth_4 VNB nfet_01v8 L=150000U W=420000U AS=60900000000P
+ AD=79800000000P PS=710000U PD=800000U
M$8 synth_3 C synth_2 VNB nfet_01v8 L=150000U W=420000U AS=79800000000P
+ AD=69300000000P PS=800000U PD=750000U
M$9 VGND D synth_3 VNB nfet_01v8 L=150000U W=420000U AS=69300000000P
+ AD=196275000000P PS=750000U PD=1330000U
M$10 X synth_1 VGND VNB nfet_01v8 L=150000U W=650000U AS=196275000000P
+ AD=169000000000P PS=1330000U PD=1820000U
.ENDS sky130_fd_sc_hd__and4_1

.SUBCKT sky130_fd_sc_hd__and2_2 VPB A B VPWR X VGND VNB
M$1 synth_1 A VPWR VPB pfet_01v8_hvt L=150000U W=420000U AS=117600000000P
+ AD=56700000000P PS=1400000U PD=690000U
M$2 synth_1 B VPWR VPB pfet_01v8_hvt L=150000U W=420000U AS=166550000000P
+ AD=56700000000P PS=1390000U PD=690000U
M$3 X synth_1 VPWR VPB pfet_01v8_hvt L=150000U W=2000000U AS=361550000000P
+ AD=575000000000P PS=2780000U PD=4150000U
M$5 synth_2 A synth_1 VNB nfet_01v8 L=150000U W=420000U AS=117600000000P
+ AD=56700000000P PS=1400000U PD=690000U
M$6 synth_2 B VGND VNB nfet_01v8 L=150000U W=420000U AS=111800000000P
+ AD=56700000000P PS=1040000U PD=690000U
M$7 X synth_1 VGND VNB nfet_01v8 L=150000U W=1300000U AS=238550000000P
+ AD=373750000000P PS=2080000U PD=3100000U
.ENDS sky130_fd_sc_hd__and2_2

.SUBCKT sky130_fd_sc_hd__clkdlybuf4s15_2 VPB A VPWR VGND X VNB
M$1 synth_3 synth_2 VPWR VPB pfet_01v8_hvt L=150000U W=820000U AS=313600000000P
+ AD=217300000000P PS=1710000U PD=2170000U
M$2 X synth_3 VPWR VPB pfet_01v8_hvt L=150000U W=2000000U AS=453600000000P
+ AD=630000000000P PS=2990000U PD=4260000U
M$4 VPWR A synth_1 VPB pfet_01v8_hvt L=150000U W=1000000U AS=270000000000P
+ AD=200850000000P PS=2540000U PD=1435000U
M$5 synth_2 synth_1 VPWR VPB pfet_01v8_hvt L=150000U W=820000U AS=200850000000P
+ AD=311600000000P PS=1435000U PD=2400000U
M$6 X synth_3 VGND VNB nfet_01v8 L=150000U W=840000U AS=238375000000P
+ AD=264600000000P PS=2060000U PD=2520000U
M$8 VGND synth_2 synth_3 VNB nfet_01v8 L=150000U W=650000U AS=169000000000P
+ AD=179575000000P PS=1820000U PD=1360000U
M$9 VGND A synth_1 VNB nfet_01v8 L=150000U W=420000U AS=113400000000P
+ AD=128725000000P PS=1380000U PD=1085000U
M$10 synth_2 synth_1 VGND VNB nfet_01v8 L=150000U W=650000U AS=128725000000P
+ AD=263250000000P PS=1085000U PD=2110000U
.ENDS sky130_fd_sc_hd__clkdlybuf4s15_2

.SUBCKT sky130_fd_sc_hd__a21oi_2 VPB A1 B1 A2 VPWR Y VGND VNB
M$1 VPWR A2 synth_1 VPB pfet_01v8_hvt L=150000U W=2000000U AS=415000000000P
+ AD=275000000000P PS=3830000U PD=2550000U
M$2 synth_1 A1 VPWR VPB pfet_01v8_hvt L=150000U W=2000000U AS=280000000000P
+ AD=275000000000P PS=2560000U PD=2550000U
M$5 Y B1 synth_1 VPB pfet_01v8_hvt L=150000U W=2000000U AS=270000000000P
+ AD=495000000000P PS=2540000U PD=3990000U
M$7 synth_2 A2 VGND VNB nfet_01v8 L=150000U W=1300000U AS=253500000000P
+ AD=196625000000P PS=2730000U PD=1905000U
M$8 Y A1 synth_2 VNB nfet_01v8 L=150000U W=1300000U AS=180375000000P
+ AD=159250000000P PS=1855000U PD=1790000U
M$11 Y B1 VGND VNB nfet_01v8 L=150000U W=1300000U AS=195000000000P
+ AD=347750000000P PS=1900000U PD=3020000U
.ENDS sky130_fd_sc_hd__a21oi_2

.SUBCKT sky130_fd_sc_hd__clkbuf_4 VPB A VGND X VPWR VNB
M$1 VPWR A synth_1 VPB pfet_01v8_hvt L=150000U W=1000000U AS=265000000000P
+ AD=165000000000P PS=2530000U PD=1330000U
M$2 X synth_1 VPWR VPB pfet_01v8_hvt L=150000U W=4000000U AS=585000000000P
+ AD=720000000000P PS=5170000U PD=6440000U
M$6 VGND A synth_1 VNB nfet_01v8 L=150000U W=420000U AS=111300000000P
+ AD=70350000000P PS=1370000U PD=755000U
M$7 X synth_1 VGND VNB nfet_01v8 L=150000U W=1680000U AS=246750000000P
+ AD=298200000000P PS=2855000U PD=3520000U
.ENDS sky130_fd_sc_hd__clkbuf_4

.SUBCKT sky130_fd_sc_hd__and3_2 VPB A B C VGND VPWR X VNB
M$1 VPWR C synth_1 VPB pfet_01v8_hvt L=150000U W=420000U AS=74375000000P
+ AD=150750000000P PS=815000U PD=1345000U
M$2 VPWR A synth_1 VPB pfet_01v8_hvt L=150000U W=420000U AS=109200000000P
+ AD=56700000000P PS=1360000U PD=690000U
M$3 VPWR B synth_1 VPB pfet_01v8_hvt L=150000U W=420000U AS=74375000000P
+ AD=56700000000P PS=815000U PD=690000U
M$4 X synth_1 VPWR VPB pfet_01v8_hvt L=150000U W=2000000U AS=285750000000P
+ AD=395000000000P PS=2615000U PD=3790000U
M$6 synth_3 A synth_1 VNB nfet_01v8 L=150000U W=420000U AS=109200000000P
+ AD=44100000000P PS=1360000U PD=630000U
M$7 synth_2 B synth_3 VNB nfet_01v8 L=150000U W=420000U AS=44100000000P
+ AD=53550000000P PS=630000U PD=675000U
M$8 synth_2 C VGND VNB nfet_01v8 L=150000U W=420000U AS=130400000000P
+ AD=53550000000P PS=1105000U PD=675000U
M$9 X synth_1 VGND VNB nfet_01v8 L=150000U W=1300000U AS=218150000000P
+ AD=266500000000P PS=2025000U PD=2770000U
.ENDS sky130_fd_sc_hd__and3_2

.SUBCKT sky130_fd_sc_hd__clkdlybuf4s50_1 VPB A VGND VPWR X VNB
M$1 synth_3 synth_2 VPWR VPB pfet_01v8_hvt L=500000U W=820000U AS=155750000000P
+ AD=217300000000P PS=1325000U PD=2170000U
M$2 X synth_3 VPWR VPB pfet_01v8_hvt L=150000U W=1000000U AS=155750000000P
+ AD=355000000000P PS=1325000U PD=2710000U
M$3 VPWR A synth_1 VPB pfet_01v8_hvt L=150000U W=1000000U AS=270000000000P
+ AD=170100000000P PS=2540000U PD=1360000U
M$4 synth_2 synth_1 VPWR VPB pfet_01v8_hvt L=500000U W=820000U AS=170100000000P
+ AD=217300000000P PS=1360000U PD=2170000U
M$5 X synth_3 VGND VNB nfet_01v8 L=150000U W=420000U AS=97000000000P
+ AD=149100000000P PS=975000U PD=1550000U
M$6 VGND synth_2 synth_3 VNB nfet_01v8 L=500000U W=650000U AS=172250000000P
+ AD=97000000000P PS=1830000U PD=975000U
M$7 VGND A synth_1 VNB nfet_01v8 L=150000U W=420000U AS=113400000000P
+ AD=104350000000P PS=1380000U PD=1010000U
M$8 synth_2 synth_1 VGND VNB nfet_01v8 L=500000U W=650000U AS=104350000000P
+ AD=169000000000P PS=1010000U PD=1820000U
.ENDS sky130_fd_sc_hd__clkdlybuf4s50_1

.SUBCKT sky130_fd_sc_hd__or3_2 VPB B A C VPWR VGND X VNB
M$1 synth_3 C synth_1 VPB pfet_01v8_hvt L=150000U W=420000U AS=109200000000P
+ AD=44100000000P PS=1360000U PD=630000U
M$2 synth_2 B synth_3 VPB pfet_01v8_hvt L=150000U W=420000U AS=44100000000P
+ AD=69300000000P PS=630000U PD=750000U
M$3 VPWR A synth_2 VPB pfet_01v8_hvt L=150000U W=420000U AS=69300000000P
+ AD=148250000000P PS=750000U PD=1340000U
M$4 X synth_1 VPWR VPB pfet_01v8_hvt L=150000U W=2000000U AS=283250000000P
+ AD=450000000000P PS=2610000U PD=3900000U
M$6 VGND C synth_1 VNB nfet_01v8 L=150000U W=420000U AS=109200000000P
+ AD=56700000000P PS=1360000U PD=690000U
M$7 synth_1 B VGND VNB nfet_01v8 L=150000U W=420000U AS=56700000000P
+ AD=56700000000P PS=690000U PD=690000U
M$8 synth_1 A VGND VNB nfet_01v8 L=150000U W=420000U AS=101875000000P
+ AD=56700000000P PS=990000U PD=690000U
M$9 X synth_1 VGND VNB nfet_01v8 L=150000U W=1300000U AS=189625000000P
+ AD=273000000000P PS=1910000U PD=2790000U
.ENDS sky130_fd_sc_hd__or3_2

.SUBCKT sky130_fd_sc_hd__buf_2 VPB A VGND X VPWR VNB
M$1 synth_1 A VPWR VPB pfet_01v8_hvt L=150000U W=640000U AS=149000000000P
+ AD=166400000000P PS=1325000U PD=1800000U
M$2 X synth_1 VPWR VPB pfet_01v8_hvt L=150000U W=2000000U AS=284000000000P
+ AD=400000000000P PS=2595000U PD=3800000U
M$4 VGND A synth_1 VNB nfet_01v8 L=150000U W=420000U AS=109200000000P
+ AD=97000000000P PS=1360000U PD=975000U
M$5 X synth_1 VGND VNB nfet_01v8 L=150000U W=1300000U AS=184750000000P
+ AD=260000000000P PS=1895000U PD=2750000U
.ENDS sky130_fd_sc_hd__buf_2

.SUBCKT sky130_fd_sc_hd__clkbuf_2 VPB A VPWR VGND X VNB
M$1 VPWR A synth_1 VPB pfet_01v8_hvt L=150000U W=1000000U AS=265000000000P
+ AD=162500000000P PS=2530000U PD=1325000U
M$2 X synth_1 VPWR VPB pfet_01v8_hvt L=150000U W=2000000U AS=297500000000P
+ AD=395000000000P PS=2595000U PD=3790000U
M$4 VGND A synth_1 VNB nfet_01v8 L=150000U W=420000U AS=111300000000P
+ AD=68250000000P PS=1370000U PD=745000U
M$5 X synth_1 VGND VNB nfet_01v8 L=150000U W=840000U AS=124950000000P
+ AD=165900000000P PS=1435000U PD=2050000U
.ENDS sky130_fd_sc_hd__clkbuf_2

.SUBCKT sky130_fd_sc_hd__a211o_1 VPB B1 C1 A1 A2 VPWR X VGND VNB
M$1 VPWR A2 synth_2 VPB pfet_01v8_hvt L=150000U W=1000000U AS=265000000000P
+ AD=140000000000P PS=2530000U PD=1280000U
M$2 synth_2 A1 VPWR VPB pfet_01v8_hvt L=150000U W=1000000U AS=140000000000P
+ AD=140000000000P PS=1280000U PD=1280000U
M$3 synth_3 B1 synth_2 VPB pfet_01v8_hvt L=150000U W=1000000U AS=140000000000P
+ AD=155000000000P PS=1280000U PD=1310000U
M$4 synth_1 C1 synth_3 VPB pfet_01v8_hvt L=150000U W=1000000U AS=155000000000P
+ AD=265000000000P PS=1310000U PD=2530000U
M$5 VPWR synth_1 X VPB pfet_01v8_hvt L=150000U W=1000000U AS=265000000000P
+ AD=265000000000P PS=2530000U PD=2530000U
M$6 VGND synth_1 X VNB nfet_01v8 L=150000U W=650000U AS=172250000000P
+ AD=260000000000P PS=1830000U PD=1450000U
M$7 synth_4 A2 VGND VNB nfet_01v8 L=150000U W=650000U AS=260000000000P
+ AD=91000000000P PS=1450000U PD=930000U
M$8 synth_1 A1 synth_4 VNB nfet_01v8 L=150000U W=650000U AS=91000000000P
+ AD=91000000000P PS=930000U PD=930000U
M$9 VGND B1 synth_1 VNB nfet_01v8 L=150000U W=650000U AS=91000000000P
+ AD=100750000000P PS=930000U PD=960000U
M$10 synth_1 C1 VGND VNB nfet_01v8 L=150000U W=650000U AS=100750000000P
+ AD=172250000000P PS=960000U PD=1830000U
.ENDS sky130_fd_sc_hd__a211o_1

.SUBCKT sky130_fd_sc_hd__a41oi_2 VGND Y B1 A1 A2 A3 A4 VPWR VPB VNB
M$1 Y B1 synth_4 VPB pfet_01v8_hvt L=150000U W=2000000U AS=395000000000P
+ AD=270000000000P PS=3790000U PD=2540000U
M$3 VPWR A1 synth_4 VPB pfet_01v8_hvt L=150000U W=2000000U AS=270000000000P
+ AD=270000000000P PS=2540000U PD=2540000U
M$5 VPWR A2 synth_4 VPB pfet_01v8_hvt L=150000U W=2000000U AS=270000000000P
+ AD=280000000000P PS=2540000U PD=2560000U
M$7 VPWR A3 synth_4 VPB pfet_01v8_hvt L=150000U W=2000000U AS=530000000000P
+ AD=520000000000P PS=3060000U PD=3040000U
M$9 VPWR A4 synth_4 VPB pfet_01v8_hvt L=150000U W=2000000U AS=270000000000P
+ AD=395000000000P PS=2540000U PD=3790000U
M$11 synth_2 A3 synth_3 VNB nfet_01v8 L=150000U W=1300000U AS=256750000000P
+ AD=175500000000P PS=2740000U PD=1840000U
M$13 VGND A4 synth_3 VNB nfet_01v8 L=150000U W=1300000U AS=175500000000P
+ AD=256750000000P PS=1840000U PD=2740000U
M$15 Y A1 synth_1 VNB nfet_01v8 L=150000U W=1300000U AS=256750000000P
+ AD=175500000000P PS=2740000U PD=1840000U
M$17 synth_2 A2 synth_1 VNB nfet_01v8 L=150000U W=1300000U AS=175500000000P
+ AD=256750000000P PS=1840000U PD=2740000U
M$19 Y B1 VGND VNB nfet_01v8 L=150000U W=1300000U AS=256750000000P
+ AD=256750000000P PS=2740000U PD=2740000U
.ENDS sky130_fd_sc_hd__a41oi_2

.SUBCKT sky130_fd_sc_hd__nor2b_4 VGND Y A B_N VPWR VPB VNB
M$1 VPWR B_N synth_1 VPB pfet_01v8_hvt L=150000U W=1000000U AS=270000000000P
+ AD=280000000000P PS=2540000U PD=2560000U
M$2 VPWR A synth_2 VPB pfet_01v8_hvt L=150000U W=4000000U AS=685000000000P
+ AD=540000000000P PS=6370000U PD=5080000U
M$6 Y synth_1 synth_2 VPB pfet_01v8_hvt L=150000U W=4000000U AS=540000000000P
+ AD=685000000000P PS=5080000U PD=6370000U
M$10 VGND B_N synth_1 VNB nfet_01v8 L=150000U W=650000U AS=182000000000P
+ AD=175500000000P PS=1860000U PD=1840000U
M$11 Y A VGND VNB nfet_01v8 L=150000U W=2600000U AS=445250000000P
+ AD=351000000000P PS=4620000U PD=3680000U
M$15 Y synth_1 VGND VNB nfet_01v8 L=150000U W=2600000U AS=351000000000P
+ AD=432250000000P PS=3680000U PD=4580000U
.ENDS sky130_fd_sc_hd__nor2b_4

.SUBCKT sky130_fd_sc_hd__nand2_8 VGND B A Y VPWR VPB VNB
M$1 Y B VPWR VPB pfet_01v8_hvt L=150000U W=8000000U AS=1.205e+12P AD=1.08e+12P
+ PS=11410000U PD=10160000U
M$9 Y A VPWR VPB pfet_01v8_hvt L=150000U W=8000000U AS=1.08e+12P AD=1.325e+12P
+ PS=10160000U PD=11650000U
M$17 VGND B synth_1 VNB nfet_01v8 L=150000U W=5200000U AS=783250000000P
+ AD=702000000000P PS=8260000U PD=7360000U
M$25 Y A synth_1 VNB nfet_01v8 L=150000U W=5200000U AS=702000000000P
+ AD=861250000000P PS=7360000U PD=8500000U
.ENDS sky130_fd_sc_hd__nand2_8

.SUBCKT sky130_fd_sc_hd__nor4b_1 VPB C B A D_N VGND Y VPWR VNB
M$1 synth_1 D_N VPWR VPB pfet_01v8_hvt L=150000U W=420000U AS=145750000000P
+ AD=109200000000P PS=1335000U PD=1360000U
M$2 synth_4 synth_1 Y VPB pfet_01v8_hvt L=150000U W=1000000U AS=520000000000P
+ AD=135000000000P PS=3040000U PD=1270000U
M$3 synth_3 C synth_4 VPB pfet_01v8_hvt L=150000U W=1000000U AS=135000000000P
+ AD=165000000000P PS=1270000U PD=1330000U
M$4 synth_2 B synth_3 VPB pfet_01v8_hvt L=150000U W=1000000U AS=165000000000P
+ AD=135000000000P PS=1330000U PD=1270000U
M$5 VPWR A synth_2 VPB pfet_01v8_hvt L=150000U W=1000000U AS=135000000000P
+ AD=145750000000P PS=1270000U PD=1335000U
M$6 Y synth_1 VGND VNB nfet_01v8 L=150000U W=650000U AS=182000000000P
+ AD=87750000000P PS=1860000U PD=920000U
M$7 VGND C Y VNB nfet_01v8 L=150000U W=650000U AS=87750000000P AD=107250000000P
+ PS=920000U PD=980000U
M$8 Y B VGND VNB nfet_01v8 L=150000U W=650000U AS=107250000000P AD=87750000000P
+ PS=980000U PD=920000U
M$9 VGND A Y VNB nfet_01v8 L=150000U W=650000U AS=87750000000P AD=100250000000P
+ PS=920000U PD=985000U
M$10 synth_1 D_N VGND VNB nfet_01v8 L=150000U W=420000U AS=100250000000P
+ AD=109200000000P PS=985000U PD=1360000U
.ENDS sky130_fd_sc_hd__nor4b_1

.SUBCKT sky130_fd_sc_hd__nand3_2 VGND Y A B C VPWR VPB VNB
M$1 Y C VPWR VPB pfet_01v8_hvt L=150000U W=2000000U AS=395000000000P
+ AD=445000000000P PS=3790000U PD=3890000U
M$3 Y A VPWR VPB pfet_01v8_hvt L=150000U W=2000000U AS=395000000000P
+ AD=270000000000P PS=3790000U PD=2540000U
M$5 Y B VPWR VPB pfet_01v8_hvt L=150000U W=2000000U AS=270000000000P
+ AD=395000000000P PS=2540000U PD=3790000U
M$7 synth_2 C VGND VNB nfet_01v8 L=150000U W=1300000U AS=256750000000P
+ AD=289250000000P PS=2740000U PD=2840000U
M$9 Y A synth_1 VNB nfet_01v8 L=150000U W=1300000U AS=256750000000P
+ AD=175500000000P PS=2740000U PD=1840000U
M$11 synth_2 B synth_1 VNB nfet_01v8 L=150000U W=1300000U AS=175500000000P
+ AD=256750000000P PS=1840000U PD=2740000U
.ENDS sky130_fd_sc_hd__nand3_2

.SUBCKT sky130_fd_sc_hd__o41ai_1 VPB B1 A4 A3 A1 A2 VGND Y VPWR VNB
M$1 Y B1 VPWR VPB pfet_01v8_hvt L=150000U W=1000000U AS=260000000000P
+ AD=135000000000P PS=2520000U PD=1270000U
M$2 synth_4 A4 Y VPB pfet_01v8_hvt L=150000U W=1000000U AS=135000000000P
+ AD=312500000000P PS=1270000U PD=1625000U
M$3 synth_3 A3 synth_4 VPB pfet_01v8_hvt L=150000U W=1000000U AS=312500000000P
+ AD=135000000000P PS=1625000U PD=1270000U
M$4 synth_2 A2 synth_3 VPB pfet_01v8_hvt L=150000U W=1000000U AS=135000000000P
+ AD=175000000000P PS=1270000U PD=1350000U
M$5 VPWR A1 synth_2 VPB pfet_01v8_hvt L=150000U W=1000000U AS=175000000000P
+ AD=280000000000P PS=1350000U PD=2560000U
M$6 synth_1 B1 Y VNB nfet_01v8 L=150000U W=650000U AS=169000000000P
+ AD=203125000000P PS=1820000U PD=1275000U
M$7 VGND A4 synth_1 VNB nfet_01v8 L=150000U W=650000U AS=203125000000P
+ AD=87750000000P PS=1275000U PD=920000U
M$8 synth_1 A3 VGND VNB nfet_01v8 L=150000U W=650000U AS=87750000000P
+ AD=87750000000P PS=920000U PD=920000U
M$9 VGND A2 synth_1 VNB nfet_01v8 L=150000U W=650000U AS=87750000000P
+ AD=113750000000P PS=920000U PD=1000000U
M$10 synth_1 A1 VGND VNB nfet_01v8 L=150000U W=650000U AS=113750000000P
+ AD=182000000000P PS=1000000U PD=1860000U
.ENDS sky130_fd_sc_hd__o41ai_1

.SUBCKT sky130_fd_sc_hd__nor3_4 VGND B A Y C VPWR VPB VNB
M$1 VPWR A synth_1 VPB pfet_01v8_hvt L=150000U W=4000000U AS=685000000000P
+ AD=540000000000P PS=6370000U PD=5080000U
M$5 synth_2 B synth_1 VPB pfet_01v8_hvt L=150000U W=4000000U AS=540000000000P
+ AD=665000000000P PS=5080000U PD=6330000U
M$8 Y C synth_2 VPB pfet_01v8_hvt L=150000U W=4000000U AS=540000000000P
+ AD=540000000000P PS=5080000U PD=5080000U
M$13 Y A VGND VNB nfet_01v8 L=150000U W=2600000U AS=445250000000P
+ AD=351000000000P PS=4620000U PD=3680000U
M$17 Y B VGND VNB nfet_01v8 L=150000U W=2600000U AS=351000000000P
+ AD=432250000000P PS=3680000U PD=4580000U
M$20 VGND C Y VNB nfet_01v8 L=150000U W=2600000U AS=351000000000P
+ AD=351000000000P PS=3680000U PD=3680000U
.ENDS sky130_fd_sc_hd__nor3_4

.SUBCKT sky130_fd_sc_hd__nor3b_2 VGND Y A B C_N VPWR VPB VNB
M$1 Y synth_1 synth_3 VPB pfet_01v8_hvt L=150000U W=2000000U AS=415000000000P
+ AD=415000000000P PS=3830000U PD=3830000U
M$3 VPWR A synth_2 VPB pfet_01v8_hvt L=150000U W=2000000U AS=415000000000P
+ AD=270000000000P PS=3830000U PD=2540000U
M$5 synth_3 B synth_2 VPB pfet_01v8_hvt L=150000U W=2000000U AS=270000000000P
+ AD=415000000000P PS=2540000U PD=3830000U
M$7 VPWR C_N synth_1 VPB pfet_01v8_hvt L=150000U W=420000U AS=109200000000P
+ AD=109200000000P PS=1360000U PD=1360000U
M$8 VGND C_N synth_1 VNB nfet_01v8 L=150000U W=420000U AS=109200000000P
+ AD=109200000000P PS=1360000U PD=1360000U
M$9 Y synth_1 VGND VNB nfet_01v8 L=150000U W=1300000U AS=256750000000P
+ AD=269750000000P PS=2740000U PD=2780000U
M$11 Y A VGND VNB nfet_01v8 L=150000U W=1300000U AS=269750000000P
+ AD=175500000000P PS=2780000U PD=1840000U
M$13 Y B VGND VNB nfet_01v8 L=150000U W=1300000U AS=175500000000P
+ AD=256750000000P PS=1840000U PD=2740000U
.ENDS sky130_fd_sc_hd__nor3b_2

.SUBCKT sky130_fd_sc_hd__nor3b_4 VGND A Y C_N B VPWR VPB VNB
M$1 synth_2 B synth_3 VPB pfet_01v8_hvt L=150000U W=4000000U AS=665000000000P
+ AD=540000000000P PS=6330000U PD=5080000U
M$5 Y synth_1 synth_3 VPB pfet_01v8_hvt L=150000U W=4000000U AS=540000000000P
+ AD=665000000000P PS=5080000U PD=6330000U
M$9 VPWR C_N synth_1 VPB pfet_01v8_hvt L=150000U W=1000000U AS=280000000000P
+ AD=135000000000P PS=2560000U PD=1270000U
M$10 synth_2 A VPWR VPB pfet_01v8_hvt L=150000U W=4000000U AS=540000000000P
+ AD=665000000000P PS=5080000U PD=6330000U
M$14 VGND C_N synth_1 VNB nfet_01v8 L=150000U W=650000U AS=182000000000P
+ AD=87750000000P PS=1860000U PD=920000U
M$15 Y A VGND VNB nfet_01v8 L=150000U W=2600000U AS=351000000000P
+ AD=520000000000P PS=3680000U PD=4200000U
M$19 Y B VGND VNB nfet_01v8 L=150000U W=2600000U AS=520000000000P
+ AD=351000000000P PS=4200000U PD=3680000U
M$23 Y synth_1 VGND VNB nfet_01v8 L=150000U W=2600000U AS=351000000000P
+ AD=432250000000P PS=3680000U PD=4580000U
.ENDS sky130_fd_sc_hd__nor3b_4

.SUBCKT sky130_fd_sc_hd__buf_6 VGND A X VPWR VPB VNB
M$1 synth_1 A VPWR VPB pfet_01v8_hvt L=150000U W=2000000U AS=395000000000P
+ AD=270000000000P PS=3790000U PD=2540000U
M$3 X synth_1 VPWR VPB pfet_01v8_hvt L=150000U W=6000000U AS=810000000000P
+ AD=935000000000P PS=7620000U PD=8870000U
M$9 synth_1 A VGND VNB nfet_01v8 L=150000U W=1300000U AS=256750000000P
+ AD=175500000000P PS=2740000U PD=1840000U
M$11 X synth_1 VGND VNB nfet_01v8 L=150000U W=3900000U AS=526500000000P
+ AD=607750000000P PS=5520000U PD=6420000U
.ENDS sky130_fd_sc_hd__buf_6

.SUBCKT sky130_fd_sc_hd__dfxtp_2 VGND Q CLK D VPWR VPB VNB
M$1 VPWR synth_6 synth_7 VPB pfet_01v8_hvt L=150000U W=1000000U
+ AS=270000000000P AD=135000000000P PS=2540000U PD=1270000U
M$2 Q synth_7 VPWR VPB pfet_01v8_hvt L=150000U W=2000000U AS=270000000000P
+ AD=395000000000P PS=2540000U PD=3790000U
M$4 synth_3 D VPWR VPB pfet_01v8_hvt L=150000U W=420000U AS=109200000000P
+ AD=57750000000P PS=1360000U PD=695000U
M$5 synth_4 synth_2 synth_3 VPB pfet_01v8_hvt L=150000U W=420000U
+ AS=57750000000P AD=68250000000P PS=695000U PD=745000U
M$6 synth_10 synth_1 synth_4 VPB pfet_01v8_hvt L=150000U W=420000U
+ AS=68250000000P AD=76650000000P PS=745000U PD=785000U
M$7 synth_10 synth_5 VPWR VPB pfet_01v8_hvt L=150000U W=420000U
+ AS=178875000000P AD=76650000000P PS=1260000U PD=785000U
M$8 synth_5 synth_4 VPWR VPB pfet_01v8_hvt L=150000U W=750000U AS=178875000000P
+ AD=109500000000P PS=1260000U PD=1075000U
M$9 synth_6 synth_1 synth_5 VPB pfet_01v8_hvt L=150000U W=420000U
+ AS=109500000000P AD=56700000000P PS=1075000U PD=690000U
M$10 synth_11 synth_2 synth_6 VPB pfet_01v8_hvt L=150000U W=420000U
+ AS=56700000000P AD=88200000000P PS=690000U PD=840000U
M$11 VPWR synth_7 synth_11 VPB pfet_01v8_hvt L=150000U W=420000U
+ AS=88200000000P AD=111300000000P PS=840000U PD=1370000U
M$12 VPWR CLK synth_1 VPB pfet_01v8_hvt L=150000U W=640000U AS=166400000000P
+ AD=86400000000P PS=1800000U PD=910000U
M$13 synth_2 synth_1 VPWR VPB pfet_01v8_hvt L=150000U W=640000U AS=86400000000P
+ AD=166400000000P PS=910000U PD=1800000U
M$14 VGND synth_6 synth_7 VNB nfet_01v8 L=150000U W=650000U AS=169000000000P
+ AD=87750000000P PS=1820000U PD=920000U
M$15 Q synth_7 VGND VNB nfet_01v8 L=150000U W=1300000U AS=175500000000P
+ AD=256750000000P PS=1840000U PD=2740000U
M$17 VGND CLK synth_1 VNB nfet_01v8 L=150000U W=420000U AS=109200000000P
+ AD=56700000000P PS=1360000U PD=690000U
M$18 synth_2 synth_1 VGND VNB nfet_01v8 L=150000U W=420000U AS=56700000000P
+ AD=109200000000P PS=690000U PD=1360000U
M$19 synth_4 synth_1 synth_3 VNB nfet_01v8 L=150000U W=360000U AS=81300000000P
+ AD=62100000000P PS=830000U PD=705000U
M$20 synth_8 synth_2 synth_4 VNB nfet_01v8 L=150000U W=360000U AS=62100000000P
+ AD=69600000000P PS=705000U PD=765000U
M$21 synth_6 synth_2 synth_5 VNB nfet_01v8 L=150000U W=360000U AS=98900000000P
+ AD=68400000000P PS=995000U PD=740000U
M$22 synth_9 synth_1 synth_6 VNB nfet_01v8 L=150000U W=360000U AS=68400000000P
+ AD=66000000000P PS=740000U PD=745000U
M$23 synth_3 D VGND VNB nfet_01v8 L=150000U W=420000U AS=109200000000P
+ AD=81300000000P PS=1360000U PD=830000U
M$24 VGND synth_5 synth_8 VNB nfet_01v8 L=150000U W=420000U AS=69600000000P
+ AD=120950000000P PS=765000U PD=1085000U
M$25 VGND synth_7 synth_9 VNB nfet_01v8 L=150000U W=420000U AS=66000000000P
+ AD=109200000000P PS=745000U PD=1360000U
M$26 synth_5 synth_4 VGND VNB nfet_01v8 L=150000U W=640000U AS=120950000000P
+ AD=98900000000P PS=1085000U PD=995000U
.ENDS sky130_fd_sc_hd__dfxtp_2

.SUBCKT sky130_fd_sc_hd__nand2b_2 VPB B A_N VPWR VGND Y VNB
M$1 VPWR A_N synth_1 VPB pfet_01v8_hvt L=150000U W=420000U AS=109200000000P
+ AD=146800000000P PS=1360000U PD=1340000U
M$2 Y synth_1 VPWR VPB pfet_01v8_hvt L=150000U W=2000000U AS=311800000000P
+ AD=500000000000P PS=2670000U PD=3000000U
M$4 Y B VPWR VPB pfet_01v8_hvt L=150000U W=2000000U AS=470000000000P
+ AD=410000000000P PS=2940000U PD=3820000U
M$6 Y synth_1 synth_2 VNB nfet_01v8 L=150000U W=1300000U AS=256750000000P
+ AD=175500000000P PS=2740000U PD=1840000U
M$8 VGND B synth_2 VNB nfet_01v8 L=150000U W=1300000U AS=175500000000P
+ AD=256750000000P PS=1840000U PD=2740000U
M$10 synth_1 A_N VGND VNB nfet_01v8 L=150000U W=420000U AS=194000000000P
+ AD=109200000000P PS=1950000U PD=1360000U
.ENDS sky130_fd_sc_hd__nand2b_2

.SUBCKT sky130_fd_sc_hd__o21ba_2 VPB B1_N A1 A2 VPWR VGND X VNB
M$1 VPWR B1_N synth_1 VPB pfet_01v8_hvt L=150000U W=420000U AS=109200000000P
+ AD=145750000000P PS=1360000U PD=1335000U
M$2 X synth_2 VPWR VPB pfet_01v8_hvt L=150000U W=2000000U AS=280750000000P
+ AD=530000000000P PS=2605000U PD=3060000U
M$4 synth_2 synth_1 VPWR VPB pfet_01v8_hvt L=150000U W=1000000U
+ AS=395000000000P AD=165000000000P PS=1790000U PD=1330000U
M$5 synth_4 A2 synth_2 VPB pfet_01v8_hvt L=150000U W=1000000U AS=165000000000P
+ AD=105000000000P PS=1330000U PD=1210000U
M$6 VPWR A1 synth_4 VPB pfet_01v8_hvt L=150000U W=1000000U AS=105000000000P
+ AD=280000000000P PS=1210000U PD=2560000U
M$7 synth_3 synth_1 synth_2 VNB nfet_01v8 L=150000U W=650000U AS=169000000000P
+ AD=105625000000P PS=1820000U PD=975000U
M$8 VGND A2 synth_3 VNB nfet_01v8 L=150000U W=650000U AS=105625000000P
+ AD=87750000000P PS=975000U PD=920000U
M$9 synth_3 A1 VGND VNB nfet_01v8 L=150000U W=650000U AS=87750000000P
+ AD=169000000000P PS=920000U PD=1820000U
M$10 synth_1 B1_N VGND VNB nfet_01v8 L=150000U W=420000U AS=97000000000P
+ AD=109200000000P PS=975000U PD=1360000U
M$11 X synth_2 VGND VNB nfet_01v8 L=150000U W=1300000U AS=184750000000P
+ AD=256750000000P PS=1895000U PD=2740000U
.ENDS sky130_fd_sc_hd__o21ba_2

.SUBCKT sky130_fd_sc_hd__nand2_2 VGND Y VPB B A VPWR VNB
M$1 Y B VPWR VPB pfet_01v8_hvt L=150000U W=2000000U AS=395000000000P
+ AD=270000000000P PS=3790000U PD=2540000U
M$3 Y A VPWR VPB pfet_01v8_hvt L=150000U W=2000000U AS=270000000000P
+ AD=395000000000P PS=2540000U PD=3790000U
M$5 VGND B synth_1 VNB nfet_01v8 L=150000U W=1300000U AS=256750000000P
+ AD=175500000000P PS=2740000U PD=1840000U
M$7 Y A synth_1 VNB nfet_01v8 L=150000U W=1300000U AS=175500000000P
+ AD=256750000000P PS=1840000U PD=2740000U
.ENDS sky130_fd_sc_hd__nand2_2

.SUBCKT sky130_fd_sc_hd__a32oi_1 VPB B2 B1 A3 A2 A1 Y VGND VPWR VNB
M$1 Y B2 synth_1 VPB pfet_01v8_hvt L=150000U W=1000000U AS=260000000000P
+ AD=135000000000P PS=2520000U PD=1270000U
M$2 synth_1 B1 Y VPB pfet_01v8_hvt L=150000U W=1000000U AS=135000000000P
+ AD=215000000000P PS=1270000U PD=1430000U
M$3 VPWR A1 synth_1 VPB pfet_01v8_hvt L=150000U W=1000000U AS=215000000000P
+ AD=135000000000P PS=1430000U PD=1270000U
M$4 synth_1 A2 VPWR VPB pfet_01v8_hvt L=150000U W=1000000U AS=135000000000P
+ AD=140000000000P PS=1270000U PD=1280000U
M$5 VPWR A3 synth_1 VPB pfet_01v8_hvt L=150000U W=1000000U AS=140000000000P
+ AD=260000000000P PS=1280000U PD=2520000U
M$6 synth_4 B2 VGND VNB nfet_01v8 L=150000U W=650000U AS=169000000000P
+ AD=74750000000P PS=1820000U PD=880000U
M$7 Y B1 synth_4 VNB nfet_01v8 L=150000U W=650000U AS=74750000000P
+ AD=152750000000P PS=880000U PD=1120000U
M$8 synth_2 A1 Y VNB nfet_01v8 L=150000U W=650000U AS=152750000000P
+ AD=71500000000P PS=1120000U PD=870000U
M$9 synth_3 A2 synth_2 VNB nfet_01v8 L=150000U W=650000U AS=71500000000P
+ AD=107250000000P PS=870000U PD=980000U
M$10 VGND A3 synth_3 VNB nfet_01v8 L=150000U W=650000U AS=107250000000P
+ AD=169000000000P PS=980000U PD=1820000U
.ENDS sky130_fd_sc_hd__a32oi_1

.SUBCKT sky130_fd_sc_hd__nor4bb_1 VPB C_N D_N B A Y VGND VPWR VNB
M$1 synth_5 synth_2 Y VPB pfet_01v8_hvt L=150000U W=1000000U AS=255900000000P
+ AD=135000000000P PS=2520000U PD=1270000U
M$2 synth_4 synth_1 synth_5 VPB pfet_01v8_hvt L=150000U W=1000000U
+ AS=135000000000P AD=165000000000P PS=1270000U PD=1330000U
M$3 synth_3 B synth_4 VPB pfet_01v8_hvt L=150000U W=1000000U AS=165000000000P
+ AD=135000000000P PS=1330000U PD=1270000U
M$4 VPWR A synth_3 VPB pfet_01v8_hvt L=150000U W=1000000U AS=135000000000P
+ AD=260000000000P PS=1270000U PD=2520000U
M$5 synth_2 D_N VPWR VPB pfet_01v8_hvt L=150000U W=420000U AS=122612500000P
+ AD=108500000000P PS=1320000U PD=1360000U
M$6 synth_1 C_N VPWR VPB pfet_01v8_hvt L=150000U W=420000U AS=122612500000P
+ AD=109200000000P PS=1320000U PD=1360000U
M$7 Y synth_2 VGND VNB nfet_01v8 L=150000U W=650000U AS=169000000000P
+ AD=87750000000P PS=1820000U PD=920000U
M$8 VGND synth_1 Y VNB nfet_01v8 L=150000U W=650000U AS=87750000000P
+ AD=107250000000P PS=920000U PD=980000U
M$9 Y B VGND VNB nfet_01v8 L=150000U W=650000U AS=107250000000P AD=87750000000P
+ PS=980000U PD=920000U
M$10 VGND A Y VNB nfet_01v8 L=150000U W=650000U AS=87750000000P
+ AD=169000000000P PS=920000U PD=1820000U
M$11 VGND C_N synth_1 VNB nfet_01v8 L=150000U W=420000U AS=109200000000P
+ AD=60900000000P PS=1360000U PD=710000U
M$12 synth_2 D_N VGND VNB nfet_01v8 L=150000U W=420000U AS=60900000000P
+ AD=109200000000P PS=710000U PD=1360000U
.ENDS sky130_fd_sc_hd__nor4bb_1

.SUBCKT sky130_fd_sc_hd__o2111ai_1 VPB D1 C1 B1 A2 A1 VPWR Y VGND VNB
M$1 Y D1 VPWR VPB pfet_01v8_hvt L=150000U W=1000000U AS=265000000000P
+ AD=140000000000P PS=2530000U PD=1280000U
M$2 VPWR C1 Y VPB pfet_01v8_hvt L=150000U W=1000000U AS=140000000000P
+ AD=195000000000P PS=1280000U PD=1390000U
M$3 Y B1 VPWR VPB pfet_01v8_hvt L=150000U W=1000000U AS=195000000000P
+ AD=202500000000P PS=1390000U PD=1405000U
M$4 synth_2 A2 Y VPB pfet_01v8_hvt L=150000U W=1000000U AS=202500000000P
+ AD=195000000000P PS=1405000U PD=1390000U
M$5 VPWR A1 synth_2 VPB pfet_01v8_hvt L=150000U W=1000000U AS=195000000000P
+ AD=265000000000P PS=1390000U PD=2530000U
M$6 synth_4 D1 Y VNB nfet_01v8 L=150000U W=650000U AS=172250000000P
+ AD=68250000000P PS=1830000U PD=860000U
M$7 synth_3 C1 synth_4 VNB nfet_01v8 L=150000U W=650000U AS=68250000000P
+ AD=126750000000P PS=860000U PD=1040000U
M$8 synth_1 B1 synth_3 VNB nfet_01v8 L=150000U W=650000U AS=126750000000P
+ AD=131625000000P PS=1040000U PD=1055000U
M$9 VGND A2 synth_1 VNB nfet_01v8 L=150000U W=650000U AS=131625000000P
+ AD=126750000000P PS=1055000U PD=1040000U
M$10 synth_1 A1 VGND VNB nfet_01v8 L=150000U W=650000U AS=126750000000P
+ AD=172250000000P PS=1040000U PD=1830000U
.ENDS sky130_fd_sc_hd__o2111ai_1

.SUBCKT sky130_fd_sc_hd__and2_0 VPB A B X VPWR VGND VNB
M$1 synth_1 A VPWR VPB pfet_01v8_hvt L=150000U W=420000U AS=111300000000P
+ AD=60900000000P PS=1370000U PD=710000U
M$2 synth_1 B VPWR VPB pfet_01v8_hvt L=150000U W=420000U AS=184100000000P
+ AD=60900000000P PS=1260000U PD=710000U
M$3 X synth_1 VPWR VPB pfet_01v8_hvt L=150000U W=640000U AS=184100000000P
+ AD=169600000000P PS=1260000U PD=1810000U
M$4 synth_2 A synth_1 VNB nfet_01v8 L=150000U W=420000U AS=111300000000P
+ AD=44100000000P PS=1370000U PD=630000U
M$5 VGND B synth_2 VNB nfet_01v8 L=150000U W=420000U AS=44100000000P
+ AD=96600000000P PS=630000U PD=880000U
M$6 X synth_1 VGND VNB nfet_01v8 L=150000U W=420000U AS=96600000000P
+ AD=111300000000P PS=880000U PD=1370000U
.ENDS sky130_fd_sc_hd__and2_0

.SUBCKT sky130_fd_sc_hd__o2bb2ai_1 VPB A1_N A2_N B2 B1 VPWR Y VGND VNB
M$1 synth_1 A1_N VPWR VPB pfet_01v8_hvt L=150000U W=1000000U AS=275000000000P
+ AD=135000000000P PS=2550000U PD=1270000U
M$2 VPWR A2_N synth_1 VPB pfet_01v8_hvt L=150000U W=1000000U AS=135000000000P
+ AD=420000000000P PS=1270000U PD=1840000U
M$3 Y synth_1 VPWR VPB pfet_01v8_hvt L=150000U W=1000000U AS=420000000000P
+ AD=135000000000P PS=1840000U PD=1270000U
M$4 synth_3 B2 Y VPB pfet_01v8_hvt L=150000U W=1000000U AS=135000000000P
+ AD=135000000000P PS=1270000U PD=1270000U
M$5 VPWR B1 synth_3 VPB pfet_01v8_hvt L=150000U W=1000000U AS=135000000000P
+ AD=275000000000P PS=1270000U PD=2550000U
M$6 synth_2 synth_1 Y VNB nfet_01v8 L=150000U W=650000U AS=169000000000P
+ AD=87750000000P PS=1820000U PD=920000U
M$7 VGND B2 synth_2 VNB nfet_01v8 L=150000U W=650000U AS=87750000000P
+ AD=87750000000P PS=920000U PD=920000U
M$8 synth_2 B1 VGND VNB nfet_01v8 L=150000U W=650000U AS=87750000000P
+ AD=169000000000P PS=920000U PD=1820000U
M$9 synth_4 A1_N VGND VNB nfet_01v8 L=150000U W=650000U AS=178750000000P
+ AD=68250000000P PS=1850000U PD=860000U
M$10 synth_1 A2_N synth_4 VNB nfet_01v8 L=150000U W=650000U AS=68250000000P
+ AD=240500000000P PS=860000U PD=2040000U
.ENDS sky130_fd_sc_hd__o2bb2ai_1

.SUBCKT sky130_fd_sc_hd__o311ai_0 VPB C1 B1 A3 A2 A1 VPWR Y VGND VNB
M$1 synth_3 A1 VPWR VPB pfet_01v8_hvt L=150000U W=640000U AS=179200000000P
+ AD=86400000000P PS=1840000U PD=910000U
M$2 synth_2 A2 synth_3 VPB pfet_01v8_hvt L=150000U W=640000U AS=86400000000P
+ AD=86400000000P PS=910000U PD=910000U
M$3 Y A3 synth_2 VPB pfet_01v8_hvt L=150000U W=640000U AS=86400000000P
+ AD=144000000000P PS=910000U PD=1090000U
M$4 VPWR B1 Y VPB pfet_01v8_hvt L=150000U W=640000U AS=144000000000P
+ AD=118400000000P PS=1090000U PD=1010000U
M$5 Y C1 VPWR VPB pfet_01v8_hvt L=150000U W=640000U AS=118400000000P
+ AD=198400000000P PS=1010000U PD=1900000U
M$6 synth_1 A1 VGND VNB nfet_01v8 L=150000U W=420000U AS=117600000000P
+ AD=56700000000P PS=1400000U PD=690000U
M$7 VGND A2 synth_1 VNB nfet_01v8 L=150000U W=420000U AS=56700000000P
+ AD=56700000000P PS=690000U PD=690000U
M$8 synth_1 A3 VGND VNB nfet_01v8 L=150000U W=420000U AS=56700000000P
+ AD=128100000000P PS=690000U PD=1030000U
M$9 synth_4 B1 synth_1 VNB nfet_01v8 L=150000U W=420000U AS=128100000000P
+ AD=44100000000P PS=1030000U PD=630000U
M$10 Y C1 synth_4 VNB nfet_01v8 L=150000U W=420000U AS=44100000000P
+ AD=117600000000P PS=630000U PD=1400000U
.ENDS sky130_fd_sc_hd__o311ai_0

.SUBCKT sky130_fd_sc_hd__nor2b_2 VPB B_N A VGND VPWR Y VNB
M$1 VPWR B_N synth_1 VPB pfet_01v8_hvt L=150000U W=420000U AS=109200000000P
+ AD=109200000000P PS=1360000U PD=1360000U
M$2 VPWR A synth_2 VPB pfet_01v8_hvt L=150000U W=2000000U AS=415000000000P
+ AD=270000000000P PS=3830000U PD=2540000U
M$4 Y synth_1 synth_2 VPB pfet_01v8_hvt L=150000U W=2000000U AS=270000000000P
+ AD=395000000000P PS=2540000U PD=3790000U
M$6 VGND B_N synth_1 VNB nfet_01v8 L=150000U W=420000U AS=109200000000P
+ AD=109200000000P PS=1360000U PD=1360000U
M$7 Y A VGND VNB nfet_01v8 L=150000U W=1300000U AS=266500000000P
+ AD=175500000000P PS=2770000U PD=1840000U
M$9 Y synth_1 VGND VNB nfet_01v8 L=150000U W=1300000U AS=175500000000P
+ AD=256750000000P PS=1840000U PD=2740000U
.ENDS sky130_fd_sc_hd__nor2b_2

.SUBCKT sky130_fd_sc_hd__a222oi_1 VPB C1 C2 B2 B1 A1 A2 Y VGND VPWR VNB
M$1 synth_1 B2 synth_2 VPB pfet_01v8_hvt L=150000U W=1000000U AS=260000000000P
+ AD=135000000000P PS=2520000U PD=1270000U
M$2 synth_2 B1 synth_1 VPB pfet_01v8_hvt L=150000U W=1000000U AS=135000000000P
+ AD=135000000000P PS=1270000U PD=1270000U
M$3 VPWR A1 synth_2 VPB pfet_01v8_hvt L=150000U W=1000000U AS=135000000000P
+ AD=165000000000P PS=1270000U PD=1330000U
M$4 synth_2 A2 VPWR VPB pfet_01v8_hvt L=150000U W=1000000U AS=165000000000P
+ AD=260000000000P PS=1330000U PD=2520000U
M$5 synth_1 C1 Y VPB pfet_01v8_hvt L=150000U W=1000000U AS=260000000000P
+ AD=135000000000P PS=2520000U PD=1270000U
M$6 Y C2 synth_1 VPB pfet_01v8_hvt L=150000U W=1000000U AS=135000000000P
+ AD=260000000000P PS=1270000U PD=2520000U
M$7 synth_5 C1 Y VNB nfet_01v8 L=150000U W=640000U AS=166400000000P
+ AD=67200000000P PS=1800000U PD=850000U
M$8 VGND C2 synth_5 VNB nfet_01v8 L=150000U W=640000U AS=67200000000P
+ AD=291200000000P PS=850000U PD=1550000U
M$9 synth_4 B2 VGND VNB nfet_01v8 L=150000U W=640000U AS=291200000000P
+ AD=67200000000P PS=1550000U PD=850000U
M$10 Y B1 synth_4 VNB nfet_01v8 L=150000U W=640000U AS=67200000000P
+ AD=105600000000P PS=850000U PD=970000U
M$11 synth_3 A1 Y VNB nfet_01v8 L=150000U W=640000U AS=105600000000P
+ AD=105600000000P PS=970000U PD=970000U
M$12 VGND A2 synth_3 VNB nfet_01v8 L=150000U W=640000U AS=105600000000P
+ AD=166400000000P PS=970000U PD=1800000U
.ENDS sky130_fd_sc_hd__a222oi_1

.SUBCKT sky130_fd_sc_hd__a311oi_1 VPB A3 A2 B1 A1 C1 VPWR Y VGND VNB
M$1 synth_1 A3 VPWR VPB pfet_01v8_hvt L=150000U W=1000000U AS=260000000000P
+ AD=137500000000P PS=2520000U PD=1275000U
M$2 VPWR A2 synth_1 VPB pfet_01v8_hvt L=150000U W=1000000U AS=137500000000P
+ AD=140000000000P PS=1275000U PD=1280000U
M$3 synth_1 A1 VPWR VPB pfet_01v8_hvt L=150000U W=1000000U AS=140000000000P
+ AD=165000000000P PS=1280000U PD=1330000U
M$4 synth_2 B1 synth_1 VPB pfet_01v8_hvt L=150000U W=1000000U AS=165000000000P
+ AD=172500000000P PS=1330000U PD=1345000U
M$5 Y C1 synth_2 VPB pfet_01v8_hvt L=150000U W=1000000U AS=172500000000P
+ AD=260000000000P PS=1345000U PD=2520000U
M$6 synth_4 A3 VGND VNB nfet_01v8 L=150000U W=650000U AS=169000000000P
+ AD=89375000000P PS=1820000U PD=925000U
M$7 synth_3 A2 synth_4 VNB nfet_01v8 L=150000U W=650000U AS=89375000000P
+ AD=91000000000P PS=925000U PD=930000U
M$8 Y A1 synth_3 VNB nfet_01v8 L=150000U W=650000U AS=91000000000P
+ AD=115375000000P PS=930000U PD=1005000U
M$9 VGND B1 Y VNB nfet_01v8 L=150000U W=650000U AS=115375000000P
+ AD=112125000000P PS=1005000U PD=995000U
M$10 Y C1 VGND VNB nfet_01v8 L=150000U W=650000U AS=112125000000P
+ AD=169000000000P PS=995000U PD=1820000U
.ENDS sky130_fd_sc_hd__a311oi_1

.SUBCKT sky130_fd_sc_hd__a2111o_1 VGND X A1 D1 C1 B1 A2 VPWR VPB VNB
M$1 synth_4 D1 synth_1 VPB pfet_01v8_hvt L=150000U W=1000000U AS=385000000000P
+ AD=125000000000P PS=2770000U PD=1250000U
M$2 synth_5 C1 synth_4 VPB pfet_01v8_hvt L=150000U W=1000000U AS=125000000000P
+ AD=180000000000P PS=1250000U PD=1360000U
M$3 synth_3 B1 synth_5 VPB pfet_01v8_hvt L=150000U W=1000000U AS=180000000000P
+ AD=280000000000P PS=1360000U PD=1560000U
M$4 VPWR A1 synth_3 VPB pfet_01v8_hvt L=150000U W=1000000U AS=280000000000P
+ AD=135000000000P PS=1560000U PD=1270000U
M$5 synth_3 A2 VPWR VPB pfet_01v8_hvt L=150000U W=1000000U AS=135000000000P
+ AD=290000000000P PS=1270000U PD=2580000U
M$6 VPWR synth_1 X VPB pfet_01v8_hvt L=150000U W=1000000U AS=290000000000P
+ AD=265000000000P PS=2580000U PD=2530000U
M$7 VGND synth_1 X VNB nfet_01v8 L=150000U W=650000U AS=214500000000P
+ AD=274625000000P PS=1960000U PD=1495000U
M$8 synth_1 D1 VGND VNB nfet_01v8 L=150000U W=650000U AS=274625000000P
+ AD=100750000000P PS=1495000U PD=960000U
M$9 VGND C1 synth_1 VNB nfet_01v8 L=150000U W=650000U AS=100750000000P
+ AD=117000000000P PS=960000U PD=1010000U
M$10 synth_1 B1 VGND VNB nfet_01v8 L=150000U W=650000U AS=117000000000P
+ AD=185250000000P PS=1010000U PD=1220000U
M$11 synth_2 A1 synth_1 VNB nfet_01v8 L=150000U W=650000U AS=185250000000P
+ AD=82875000000P PS=1220000U PD=905000U
M$12 VGND A2 synth_2 VNB nfet_01v8 L=150000U W=650000U AS=82875000000P
+ AD=188500000000P PS=905000U PD=1880000U
.ENDS sky130_fd_sc_hd__a2111o_1

.SUBCKT sky130_fd_sc_hd__o22a_1 VPB B1 B2 A2 A1 X VGND VPWR VNB
M$1 VPWR synth_1 X VPB pfet_01v8_hvt L=150000U W=1000000U AS=280000000000P
+ AD=372500000000P PS=2560000U PD=1745000U
M$2 synth_4 B1 VPWR VPB pfet_01v8_hvt L=150000U W=1000000U AS=372500000000P
+ AD=117500000000P PS=1745000U PD=1235000U
M$3 synth_1 B2 synth_4 VPB pfet_01v8_hvt L=150000U W=1000000U AS=117500000000P
+ AD=235000000000P PS=1235000U PD=1470000U
M$4 synth_3 A2 synth_1 VPB pfet_01v8_hvt L=150000U W=1000000U AS=235000000000P
+ AD=105000000000P PS=1470000U PD=1210000U
M$5 VPWR A1 synth_3 VPB pfet_01v8_hvt L=150000U W=1000000U AS=105000000000P
+ AD=260000000000P PS=1210000U PD=2520000U
M$6 synth_1 B1 synth_2 VNB nfet_01v8 L=150000U W=650000U AS=169000000000P
+ AD=87750000000P PS=1820000U PD=920000U
M$7 synth_2 B2 synth_1 VNB nfet_01v8 L=150000U W=650000U AS=87750000000P
+ AD=113750000000P PS=920000U PD=1000000U
M$8 VGND A2 synth_2 VNB nfet_01v8 L=150000U W=650000U AS=113750000000P
+ AD=87750000000P PS=1000000U PD=920000U
M$9 synth_2 A1 VGND VNB nfet_01v8 L=150000U W=650000U AS=87750000000P
+ AD=169000000000P PS=920000U PD=1820000U
M$10 VGND synth_1 X VNB nfet_01v8 L=150000U W=650000U AS=169000000000P
+ AD=169000000000P PS=1820000U PD=1820000U
.ENDS sky130_fd_sc_hd__o22a_1

.SUBCKT sky130_fd_sc_hd__a221o_1 VPB C1 B2 B1 A1 A2 X VPWR VGND VNB
M$1 synth_1 A1 VPWR VPB pfet_01v8_hvt L=150000U W=1000000U AS=260000000000P
+ AD=165000000000P PS=2520000U PD=1330000U
M$2 VPWR A2 synth_1 VPB pfet_01v8_hvt L=150000U W=1000000U AS=165000000000P
+ AD=157500000000P PS=1330000U PD=1315000U
M$3 X synth_2 VPWR VPB pfet_01v8_hvt L=150000U W=1000000U AS=157500000000P
+ AD=260000000000P PS=1315000U PD=2520000U
M$4 synth_3 C1 synth_2 VPB pfet_01v8_hvt L=150000U W=1000000U AS=260000000000P
+ AD=135000000000P PS=2520000U PD=1270000U
M$5 synth_1 B2 synth_3 VPB pfet_01v8_hvt L=150000U W=1000000U AS=135000000000P
+ AD=135000000000P PS=1270000U PD=1270000U
M$6 synth_3 B1 synth_1 VPB pfet_01v8_hvt L=150000U W=1000000U AS=135000000000P
+ AD=260000000000P PS=1270000U PD=2520000U
M$7 synth_4 A1 synth_2 VNB nfet_01v8 L=150000U W=650000U AS=169000000000P
+ AD=107250000000P PS=1820000U PD=980000U
M$8 VGND A2 synth_4 VNB nfet_01v8 L=150000U W=650000U AS=107250000000P
+ AD=102375000000P PS=980000U PD=965000U
M$9 X synth_2 VGND VNB nfet_01v8 L=150000U W=650000U AS=102375000000P
+ AD=169000000000P PS=965000U PD=1820000U
M$10 VGND C1 synth_2 VNB nfet_01v8 L=150000U W=650000U AS=169000000000P
+ AD=107250000000P PS=1820000U PD=980000U
M$11 synth_5 B2 VGND VNB nfet_01v8 L=150000U W=650000U AS=107250000000P
+ AD=68250000000P PS=980000U PD=860000U
M$12 synth_2 B1 synth_5 VNB nfet_01v8 L=150000U W=650000U AS=68250000000P
+ AD=169000000000P PS=860000U PD=1820000U
.ENDS sky130_fd_sc_hd__a221o_1

.SUBCKT sky130_fd_sc_hd__a2bb2oi_1 VPB A1_N A2_N B2 B1 VGND Y VPWR VNB
M$1 synth_1 synth_2 Y VPB pfet_01v8_hvt L=150000U W=1000000U AS=340000000000P
+ AD=135000000000P PS=2680000U PD=1270000U
M$2 VPWR B2 synth_1 VPB pfet_01v8_hvt L=150000U W=1000000U AS=135000000000P
+ AD=135000000000P PS=1270000U PD=1270000U
M$3 synth_1 B1 VPWR VPB pfet_01v8_hvt L=150000U W=1000000U AS=135000000000P
+ AD=260000000000P PS=1270000U PD=2520000U
M$4 synth_3 A1_N VPWR VPB pfet_01v8_hvt L=150000U W=1000000U AS=260000000000P
+ AD=105000000000P PS=2520000U PD=1210000U
M$5 synth_2 A2_N synth_3 VPB pfet_01v8_hvt L=150000U W=1000000U
+ AS=105000000000P AD=260000000000P PS=1210000U PD=2520000U
M$6 synth_2 A1_N VGND VNB nfet_01v8 L=150000U W=650000U AS=169000000000P
+ AD=87750000000P PS=1820000U PD=920000U
M$7 VGND A2_N synth_2 VNB nfet_01v8 L=150000U W=650000U AS=87750000000P
+ AD=282750000000P PS=920000U PD=1520000U
M$8 Y synth_2 VGND VNB nfet_01v8 L=150000U W=650000U AS=282750000000P
+ AD=87750000000P PS=1520000U PD=920000U
M$9 synth_4 B2 Y VNB nfet_01v8 L=150000U W=650000U AS=87750000000P
+ AD=87750000000P PS=920000U PD=920000U
M$10 VGND B1 synth_4 VNB nfet_01v8 L=150000U W=650000U AS=87750000000P
+ AD=169000000000P PS=920000U PD=1820000U
.ENDS sky130_fd_sc_hd__a2bb2oi_1

.SUBCKT sky130_fd_sc_hd__a311o_1 VPB C1 B1 A1 A2 A3 X VGND VPWR VNB
M$1 VPWR synth_2 X VPB pfet_01v8_hvt L=150000U W=1000000U AS=285000000000P
+ AD=142500000000P PS=2570000U PD=1285000U
M$2 synth_1 A3 VPWR VPB pfet_01v8_hvt L=150000U W=1000000U AS=142500000000P
+ AD=165000000000P PS=1285000U PD=1330000U
M$3 VPWR A2 synth_1 VPB pfet_01v8_hvt L=150000U W=1000000U AS=165000000000P
+ AD=305000000000P PS=1330000U PD=1610000U
M$4 synth_1 A1 VPWR VPB pfet_01v8_hvt L=150000U W=1000000U AS=305000000000P
+ AD=162500000000P PS=1610000U PD=1325000U
M$5 synth_3 B1 synth_1 VPB pfet_01v8_hvt L=150000U W=1000000U AS=162500000000P
+ AD=207500000000P PS=1325000U PD=1415000U
M$6 synth_2 C1 synth_3 VPB pfet_01v8_hvt L=150000U W=1000000U AS=207500000000P
+ AD=260000000000P PS=1415000U PD=2520000U
M$7 VGND synth_2 X VNB nfet_01v8 L=150000U W=650000U AS=169000000000P
+ AD=112125000000P PS=1820000U PD=995000U
M$8 synth_5 A3 VGND VNB nfet_01v8 L=150000U W=650000U AS=112125000000P
+ AD=125125000000P PS=995000U PD=1035000U
M$9 synth_4 A2 synth_5 VNB nfet_01v8 L=150000U W=650000U AS=125125000000P
+ AD=169000000000P PS=1035000U PD=1170000U
M$10 synth_2 A1 synth_4 VNB nfet_01v8 L=150000U W=650000U AS=169000000000P
+ AD=105625000000P PS=1170000U PD=975000U
M$11 VGND B1 synth_2 VNB nfet_01v8 L=150000U W=650000U AS=105625000000P
+ AD=134875000000P PS=975000U PD=1065000U
M$12 synth_2 C1 VGND VNB nfet_01v8 L=150000U W=650000U AS=134875000000P
+ AD=169000000000P PS=1065000U PD=1820000U
.ENDS sky130_fd_sc_hd__a311o_1

.SUBCKT sky130_fd_sc_hd__a221oi_1 VPB A2 A1 B1 B2 C1 VPWR VGND Y VNB
M$1 synth_2 A1 VPWR VPB pfet_01v8_hvt L=150000U W=1000000U AS=260000000000P
+ AD=152500000000P PS=2520000U PD=1305000U
M$2 VPWR A2 synth_2 VPB pfet_01v8_hvt L=150000U W=1000000U AS=152500000000P
+ AD=305000000000P PS=1305000U PD=2610000U
M$3 synth_1 C1 Y VPB pfet_01v8_hvt L=150000U W=1000000U AS=260000000000P
+ AD=135000000000P PS=2520000U PD=1270000U
M$4 synth_2 B2 synth_1 VPB pfet_01v8_hvt L=150000U W=1000000U AS=135000000000P
+ AD=135000000000P PS=1270000U PD=1270000U
M$5 synth_1 B1 synth_2 VPB pfet_01v8_hvt L=150000U W=1000000U AS=135000000000P
+ AD=260000000000P PS=1270000U PD=2520000U
M$6 synth_3 A1 Y VNB nfet_01v8 L=150000U W=650000U AS=169000000000P
+ AD=99125000000P PS=1820000U PD=955000U
M$7 VGND A2 synth_3 VNB nfet_01v8 L=150000U W=650000U AS=99125000000P
+ AD=198250000000P PS=955000U PD=1910000U
M$8 VGND C1 Y VNB nfet_01v8 L=150000U W=650000U AS=169000000000P
+ AD=105625000000P PS=1820000U PD=975000U
M$9 synth_4 B2 VGND VNB nfet_01v8 L=150000U W=650000U AS=105625000000P
+ AD=69875000000P PS=975000U PD=865000U
M$10 Y B1 synth_4 VNB nfet_01v8 L=150000U W=650000U AS=69875000000P
+ AD=169000000000P PS=865000U PD=1820000U
.ENDS sky130_fd_sc_hd__a221oi_1

.SUBCKT sky130_fd_sc_hd__o32a_1 VPB A2 A1 B2 A3 B1 X VPWR VGND VNB
M$1 VPWR synth_2 X VPB pfet_01v8_hvt L=150000U W=1000000U AS=335000000000P
+ AD=135000000000P PS=2670000U PD=1270000U
M$2 synth_5 A1 VPWR VPB pfet_01v8_hvt L=150000U W=1000000U AS=135000000000P
+ AD=165000000000P PS=1270000U PD=1330000U
M$3 synth_4 A2 synth_5 VPB pfet_01v8_hvt L=150000U W=1000000U AS=165000000000P
+ AD=195000000000P PS=1330000U PD=1390000U
M$4 synth_2 A3 synth_4 VPB pfet_01v8_hvt L=150000U W=1000000U AS=195000000000P
+ AD=195000000000P PS=1390000U PD=1390000U
M$5 synth_3 B2 synth_2 VPB pfet_01v8_hvt L=150000U W=1000000U AS=195000000000P
+ AD=205000000000P PS=1390000U PD=1410000U
M$6 VPWR B1 synth_3 VPB pfet_01v8_hvt L=150000U W=1000000U AS=205000000000P
+ AD=290000000000P PS=1410000U PD=2580000U
M$7 VGND synth_2 X VNB nfet_01v8 L=150000U W=650000U AS=169000000000P
+ AD=87750000000P PS=1820000U PD=920000U
M$8 synth_1 A1 VGND VNB nfet_01v8 L=150000U W=650000U AS=87750000000P
+ AD=107250000000P PS=920000U PD=980000U
M$9 VGND A2 synth_1 VNB nfet_01v8 L=150000U W=650000U AS=107250000000P
+ AD=126750000000P PS=980000U PD=1040000U
M$10 synth_1 A3 VGND VNB nfet_01v8 L=150000U W=650000U AS=126750000000P
+ AD=126750000000P PS=1040000U PD=1040000U
M$11 synth_2 B2 synth_1 VNB nfet_01v8 L=150000U W=650000U AS=126750000000P
+ AD=133250000000P PS=1040000U PD=1060000U
M$12 synth_1 B1 synth_2 VNB nfet_01v8 L=150000U W=650000U AS=133250000000P
+ AD=188500000000P PS=1060000U PD=1880000U
.ENDS sky130_fd_sc_hd__o32a_1

.SUBCKT sky130_fd_sc_hd__clkbuf_1 VPB A VGND VPWR VNB
M$1 VPWR synth_1 X VPB pfet_01v8_hvt L=150000U W=790000U AS=205400000000P
+ AD=114550000000P PS=2100000U PD=1080000U
M$2 synth_1 A VPWR VPB pfet_01v8_hvt L=150000U W=790000U AS=114550000000P
+ AD=205400000000P PS=1080000U PD=2100000U
M$3 VGND synth_1 X VNB nfet_01v8 L=150000U W=520000U AS=135200000000P
+ AD=75400000000P PS=1560000U PD=810000U
M$4 synth_1 A VGND VNB nfet_01v8 L=150000U W=520000U AS=75400000000P
+ AD=135200000000P PS=810000U PD=1560000U
.ENDS sky130_fd_sc_hd__clkbuf_1

.SUBCKT sky130_fd_sc_hd__clkbuf_8 VGND A VPWR VPB VNB
M$1 synth_1 A VPWR VPB pfet_01v8_hvt L=150000U W=2000000U AS=405000000000P
+ AD=280000000000P PS=3810000U PD=2560000U
M$3 X synth_1 VPWR VPB pfet_01v8_hvt L=150000U W=8000000U AS=1.12e+12P
+ AD=1.245e+12P PS=10240000U PD=11490000U
M$11 synth_1 A VGND VNB nfet_01v8 L=150000U W=840000U AS=170100000000P
+ AD=117600000000P PS=2070000U PD=1400000U
M$13 X synth_1 VGND VNB nfet_01v8 L=150000U W=3360000U AS=470400000000P
+ AD=525000000000P PS=5600000U PD=6280000U
.ENDS sky130_fd_sc_hd__clkbuf_8

.SUBCKT sky130_fd_sc_hd__clkinv_16 VGND A VPWR VPB VNB
M$1 Y A VPWR VPB pfet_01v8_hvt L=150000U W=24000000U AS=3.59e+12P AD=3.58e+12P
+ PS=32180000U PD=32160000U
M$25 Y A VGND VNB nfet_01v8 L=150000U W=6720000U AS=1.0332e+12P AD=1.0332e+12P
+ PS=12060000U PD=12060000U
.ENDS sky130_fd_sc_hd__clkinv_16

.SUBCKT sky130_fd_sc_hd__clkinv_8 VGND A VPWR VPB VNB
M$1 Y A VPWR VPB pfet_01v8_hvt L=150000U W=12000000U AS=1.7475e+12P
+ AD=1.7475e+12P PS=16495000U PD=16495000U
M$13 Y A VGND VNB nfet_01v8 L=150000U W=3360000U AS=522900000000P
+ AD=522900000000P PS=6270000U PD=6270000U
.ENDS sky130_fd_sc_hd__clkinv_8

.SUBCKT sky130_fd_sc_hd__clkinvlp_4 VPB A VPWR VGND VNB
M$1 Y A VPWR VPB pfet_01v8_hvt L=250000U W=4000000U AS=685000000000P
+ AD=685000000000P PS=6370000U PD=6370000U
M$5 synth_1 A VGND VNB nfet_01v8 L=150000U W=1100000U AS=203500000000P
+ AD=203500000000P PS=2390000U PD=2390000U
M$6 Y A synth_1 VNB nfet_01v8 L=150000U W=1100000U AS=134750000000P
+ AD=134750000000P PS=1590000U PD=1590000U
.ENDS sky130_fd_sc_hd__clkinvlp_4

.SUBCKT sky130_fd_sc_hd__a41oi_1 VPB A1 A2 A3 A4 B1 VPWR Y VGND VNB
M$1 synth_1 B1 Y VPB pfet_01v8_hvt L=150000U W=1000000U AS=260000000000P
+ AD=212500000000P PS=2520000U PD=1425000U
M$2 VPWR A4 synth_1 VPB pfet_01v8_hvt L=150000U W=1000000U AS=212500000000P
+ AD=205000000000P PS=1425000U PD=1410000U
M$3 synth_1 A3 VPWR VPB pfet_01v8_hvt L=150000U W=1000000U AS=205000000000P
+ AD=155000000000P PS=1410000U PD=1310000U
M$4 VPWR A2 synth_1 VPB pfet_01v8_hvt L=150000U W=1000000U AS=155000000000P
+ AD=212500000000P PS=1310000U PD=1425000U
M$5 synth_1 A1 VPWR VPB pfet_01v8_hvt L=150000U W=1000000U AS=212500000000P
+ AD=370000000000P PS=1425000U PD=2740000U
M$6 Y B1 VGND VNB nfet_01v8 L=150000U W=650000U AS=163425000000P
+ AD=169000000000P PS=1175000U PD=1820000U
M$7 synth_4 A4 VGND VNB nfet_01v8 L=150000U W=650000U AS=163425000000P
+ AD=113750000000P PS=1175000U PD=1000000U
M$8 synth_3 A3 synth_4 VNB nfet_01v8 L=150000U W=650000U AS=113750000000P
+ AD=100750000000P PS=1000000U PD=960000U
M$9 synth_2 A2 synth_3 VNB nfet_01v8 L=150000U W=650000U AS=100750000000P
+ AD=138125000000P PS=960000U PD=1075000U
M$10 Y A1 synth_2 VNB nfet_01v8 L=150000U W=650000U AS=138125000000P
+ AD=240500000000P PS=1075000U PD=2040000U
.ENDS sky130_fd_sc_hd__a41oi_1

.SUBCKT sky130_fd_sc_hd__inv_6 VPB A VPWR VGND VNB
M$1 Y A VPWR VPB pfet_01v8_hvt L=150000U W=6000000U AS=1.105e+12P
+ AD=945000000000P PS=9210000U PD=8890000U
M$7 Y A VGND VNB nfet_01v8 L=150000U W=3900000U AS=685750000000P
+ AD=614250000000P PS=6660000U PD=6440000U
.ENDS sky130_fd_sc_hd__inv_6

.SUBCKT sky130_fd_sc_hd__mux2i_1 VPB A0 A1 S Y VPWR VGND VNB
M$1 VPWR S synth_1 VPB pfet_01v8_hvt L=150000U W=1000000U AS=290000000000P
+ AD=260000000000P PS=2580000U PD=2520000U
M$2 Y A0 synth_3 VPB pfet_01v8_hvt L=150000U W=1000000U AS=280000000000P
+ AD=152500000000P PS=2560000U PD=1305000U
M$3 synth_5 A1 Y VPB pfet_01v8_hvt L=150000U W=1000000U AS=152500000000P
+ AD=197500000000P PS=1305000U PD=1395000U
M$4 VPWR synth_1 synth_5 VPB pfet_01v8_hvt L=150000U W=1000000U
+ AS=197500000000P AD=300000000000P PS=1395000U PD=1600000U
M$5 synth_3 S VPWR VPB pfet_01v8_hvt L=150000U W=1000000U AS=300000000000P
+ AD=260000000000P PS=1600000U PD=2520000U
M$6 VGND S synth_1 VNB nfet_01v8 L=150000U W=650000U AS=169000000000P
+ AD=169000000000P PS=1820000U PD=1820000U
M$7 VGND synth_1 synth_2 VNB nfet_01v8 L=150000U W=650000U AS=169000000000P
+ AD=87750000000P PS=1820000U PD=920000U
M$8 synth_4 S VGND VNB nfet_01v8 L=150000U W=650000U AS=87750000000P
+ AD=169000000000P PS=920000U PD=1820000U
M$9 Y A0 synth_2 VNB nfet_01v8 L=150000U W=650000U AS=169000000000P
+ AD=87750000000P PS=1820000U PD=920000U
M$10 synth_4 A1 Y VNB nfet_01v8 L=150000U W=650000U AS=87750000000P
+ AD=182000000000P PS=920000U PD=1860000U
.ENDS sky130_fd_sc_hd__mux2i_1

.SUBCKT sky130_fd_sc_hd__clkinv_4 VPB A VGND VPWR VNB
M$1 Y A VPWR VPB pfet_01v8_hvt L=150000U W=6000000U AS=1.005e+12P AD=1.045e+12P
+ PS=9010000U PD=9090000U
M$7 Y A VGND VNB nfet_01v8 L=150000U W=1680000U AS=315000000000P
+ AD=342300000000P PS=3600000U PD=3730000U
.ENDS sky130_fd_sc_hd__clkinv_4

.SUBCKT sky130_fd_sc_hd__nor2_2 VGND Y VPB A B VPWR VNB
M$1 VPWR A synth_1 VPB pfet_01v8_hvt L=150000U W=2000000U AS=415000000000P
+ AD=270000000000P PS=3830000U PD=2540000U
M$3 Y B synth_1 VPB pfet_01v8_hvt L=150000U W=2000000U AS=270000000000P
+ AD=395000000000P PS=2540000U PD=3790000U
M$5 Y A VGND VNB nfet_01v8 L=150000U W=1300000U AS=269750000000P
+ AD=175500000000P PS=2780000U PD=1840000U
M$7 Y B VGND VNB nfet_01v8 L=150000U W=1300000U AS=175500000000P
+ AD=256750000000P PS=1840000U PD=2740000U
.ENDS sky130_fd_sc_hd__nor2_2

.SUBCKT sky130_fd_sc_hd__o31ai_2 VGND A1 A2 A3 B1 VPWR Y VPB VNB
M$1 synth_3 A3 Y VPB pfet_01v8_hvt L=150000U W=2000000U AS=415000000000P
+ AD=270000000000P PS=3830000U PD=2540000U
M$3 VPWR B1 Y VPB pfet_01v8_hvt L=150000U W=2000000U AS=330000000000P
+ AD=455000000000P PS=2660000U PD=3910000U
M$5 VPWR A1 synth_2 VPB pfet_01v8_hvt L=150000U W=2000000U AS=415000000000P
+ AD=270000000000P PS=3830000U PD=2540000U
M$7 synth_3 A2 synth_2 VPB pfet_01v8_hvt L=150000U W=2000000U AS=270000000000P
+ AD=395000000000P PS=2540000U PD=3790000U
M$9 VGND A1 synth_1 VNB nfet_01v8 L=150000U W=1300000U AS=269750000000P
+ AD=175500000000P PS=2780000U PD=1840000U
M$11 VGND A2 synth_1 VNB nfet_01v8 L=150000U W=1300000U AS=286000000000P
+ AD=325000000000P PS=2180000U PD=2300000U
M$13 VGND A3 synth_1 VNB nfet_01v8 L=150000U W=1300000U AS=240500000000P
+ AD=201500000000P PS=2040000U PD=1920000U
M$15 Y B1 synth_1 VNB nfet_01v8 L=150000U W=1300000U AS=214500000000P
+ AD=295750000000P PS=1960000U PD=2860000U
.ENDS sky130_fd_sc_hd__o31ai_2

.SUBCKT sky130_fd_sc_hd__buf_1 VPB A X VGND VPWR VNB
M$1 VPWR A synth_1 VPB pfet_01v8_hvt L=150000U W=790000U AS=205400000000P
+ AD=114550000000P PS=2100000U PD=1080000U
M$2 X synth_1 VPWR VPB pfet_01v8_hvt L=150000U W=790000U AS=114550000000P
+ AD=205400000000P PS=1080000U PD=2100000U
M$3 VGND A synth_1 VNB nfet_01v8 L=150000U W=520000U AS=135200000000P
+ AD=75400000000P PS=1560000U PD=810000U
M$4 X synth_1 VGND VNB nfet_01v8 L=150000U W=520000U AS=75400000000P
+ AD=135200000000P PS=810000U PD=1560000U
.ENDS sky130_fd_sc_hd__buf_1

.SUBCKT sky130_fd_sc_hd__clkinv_2 VPB A VPWR VGND VNB
M$1 VPWR A Y VPB pfet_01v8_hvt L=150000U W=3000000U AS=545000000000P
+ AD=545000000000P PS=5090000U PD=5090000U
M$4 Y A VGND VNB nfet_01v8 L=150000U W=840000U AS=170100000000P
+ AD=168000000000P PS=2070000U PD=2060000U
.ENDS sky130_fd_sc_hd__clkinv_2

.SUBCKT sky130_fd_sc_hd__or4_1 VPB A B C D X VPWR VGND VNB
M$1 synth_4 D synth_1 VPB pfet_01v8_hvt L=150000U W=420000U AS=109200000000P
+ AD=69300000000P PS=1360000U PD=750000U
M$2 synth_3 C synth_4 VPB pfet_01v8_hvt L=150000U W=420000U AS=69300000000P
+ AD=44100000000P PS=750000U PD=630000U
M$3 synth_2 B synth_3 VPB pfet_01v8_hvt L=150000U W=420000U AS=44100000000P
+ AD=69300000000P PS=630000U PD=750000U
M$4 VPWR A synth_2 VPB pfet_01v8_hvt L=150000U W=420000U AS=69300000000P
+ AD=148250000000P PS=750000U PD=1340000U
M$5 X synth_1 VPWR VPB pfet_01v8_hvt L=150000U W=1000000U AS=148250000000P
+ AD=270000000000P PS=1340000U PD=2540000U
M$6 synth_1 D VGND VNB nfet_01v8 L=150000U W=420000U AS=109200000000P
+ AD=69300000000P PS=1360000U PD=750000U
M$7 VGND C synth_1 VNB nfet_01v8 L=150000U W=420000U AS=69300000000P
+ AD=56700000000P PS=750000U PD=690000U
M$8 synth_1 B VGND VNB nfet_01v8 L=150000U W=420000U AS=56700000000P
+ AD=56700000000P PS=690000U PD=690000U
M$9 synth_1 A VGND VNB nfet_01v8 L=150000U W=420000U AS=101875000000P
+ AD=56700000000P PS=990000U PD=690000U
M$10 X synth_1 VGND VNB nfet_01v8 L=150000U W=650000U AS=101875000000P
+ AD=175500000000P PS=990000U PD=1840000U
.ENDS sky130_fd_sc_hd__or4_1

.SUBCKT sky130_fd_sc_hd__o31ai_1 VPB A1 A2 A3 B1 VPWR VGND Y VNB
M$1 synth_3 A1 VPWR VPB pfet_01v8_hvt L=150000U W=1000000U AS=260000000000P
+ AD=135000000000P PS=2520000U PD=1270000U
M$2 synth_2 A2 synth_3 VPB pfet_01v8_hvt L=150000U W=1000000U AS=135000000000P
+ AD=135000000000P PS=1270000U PD=1270000U
M$3 Y A3 synth_2 VPB pfet_01v8_hvt L=150000U W=1000000U AS=135000000000P
+ AD=392500000000P PS=1270000U PD=1785000U
M$4 VPWR B1 Y VPB pfet_01v8_hvt L=150000U W=1000000U AS=392500000000P
+ AD=300000000000P PS=1785000U PD=2600000U
M$5 synth_1 A1 VGND VNB nfet_01v8 L=150000U W=650000U AS=169000000000P
+ AD=87750000000P PS=1820000U PD=920000U
M$6 VGND A2 synth_1 VNB nfet_01v8 L=150000U W=650000U AS=87750000000P
+ AD=87750000000P PS=920000U PD=920000U
M$7 synth_1 A3 VGND VNB nfet_01v8 L=150000U W=650000U AS=87750000000P
+ AD=198250000000P PS=920000U PD=1260000U
M$8 Y B1 synth_1 VNB nfet_01v8 L=150000U W=650000U AS=198250000000P
+ AD=221000000000P PS=1260000U PD=1980000U
.ENDS sky130_fd_sc_hd__o31ai_1

.SUBCKT sky130_fd_sc_hd__a211oi_1 VPB A2 A1 C1 B1 VGND Y VPWR VNB
M$1 VPWR A2 synth_1 VPB pfet_01v8_hvt L=150000U W=1000000U AS=265000000000P
+ AD=140000000000P PS=2530000U PD=1280000U
M$2 synth_1 A1 VPWR VPB pfet_01v8_hvt L=150000U W=1000000U AS=140000000000P
+ AD=140000000000P PS=1280000U PD=1280000U
M$3 synth_2 B1 synth_1 VPB pfet_01v8_hvt L=150000U W=1000000U AS=140000000000P
+ AD=155000000000P PS=1280000U PD=1310000U
M$4 Y C1 synth_2 VPB pfet_01v8_hvt L=150000U W=1000000U AS=155000000000P
+ AD=265000000000P PS=1310000U PD=2530000U
M$5 synth_3 A2 VGND VNB nfet_01v8 L=150000U W=650000U AS=266500000000P
+ AD=91000000000P PS=2120000U PD=930000U
M$6 Y A1 synth_3 VNB nfet_01v8 L=150000U W=650000U AS=91000000000P
+ AD=91000000000P PS=930000U PD=930000U
M$7 VGND B1 Y VNB nfet_01v8 L=150000U W=650000U AS=91000000000P
+ AD=100750000000P PS=930000U PD=960000U
M$8 Y C1 VGND VNB nfet_01v8 L=150000U W=650000U AS=100750000000P
+ AD=172250000000P PS=960000U PD=1830000U
.ENDS sky130_fd_sc_hd__a211oi_1

.SUBCKT sky130_fd_sc_hd__bufinv_16 VGND A VPWR VPB VNB
M$1 VPWR A synth_1 VPB pfet_01v8_hvt L=150000U W=3000000U AS=530000000000P
+ AD=405000000000P PS=5060000U PD=3810000U
M$4 synth_2 synth_1 VPWR VPB pfet_01v8_hvt L=150000U W=6000000U
+ AS=810000000000P AD=810000000000P PS=7620000U PD=7620000U
M$10 Y synth_2 VPWR VPB pfet_01v8_hvt L=150000U W=16000000U AS=2.16e+12P
+ AD=2.285e+12P PS=20320000U PD=21570000U
M$26 VGND A synth_1 VNB nfet_01v8 L=150000U W=1950000U AS=344500000000P
+ AD=263250000000P PS=3660000U PD=2760000U
M$29 synth_2 synth_1 VGND VNB nfet_01v8 L=150000U W=3900000U AS=526500000000P
+ AD=526500000000P PS=5520000U PD=5520000U
M$35 Y synth_2 VGND VNB nfet_01v8 L=150000U W=10400000U AS=1.404e+12P
+ AD=1.48525e+12P PS=14720000U PD=15620000U
.ENDS sky130_fd_sc_hd__bufinv_16

.SUBCKT sky130_fd_sc_hd__nand4_1 VPB C A B D VPWR Y VGND VNB
M$1 Y D VPWR VPB pfet_01v8_hvt L=150000U W=1000000U AS=260000000000P
+ AD=135000000000P PS=2520000U PD=1270000U
M$2 VPWR C Y VPB pfet_01v8_hvt L=150000U W=1000000U AS=135000000000P
+ AD=135000000000P PS=1270000U PD=1270000U
M$3 Y B VPWR VPB pfet_01v8_hvt L=150000U W=1000000U AS=135000000000P
+ AD=165000000000P PS=1270000U PD=1330000U
M$4 VPWR A Y VPB pfet_01v8_hvt L=150000U W=1000000U AS=165000000000P
+ AD=300000000000P PS=1330000U PD=2600000U
M$5 synth_3 D VGND VNB nfet_01v8 L=150000U W=650000U AS=169000000000P
+ AD=87750000000P PS=1820000U PD=920000U
M$6 synth_2 C synth_3 VNB nfet_01v8 L=150000U W=650000U AS=87750000000P
+ AD=87750000000P PS=920000U PD=920000U
M$7 synth_1 B synth_2 VNB nfet_01v8 L=150000U W=650000U AS=87750000000P
+ AD=107250000000P PS=920000U PD=980000U
M$8 Y A synth_1 VNB nfet_01v8 L=150000U W=650000U AS=107250000000P
+ AD=195000000000P PS=980000U PD=1900000U
.ENDS sky130_fd_sc_hd__nand4_1

.SUBCKT sky130_fd_sc_hd__o21a_1 VPB B1 A2 A1 VPWR X VGND VNB
M$1 VPWR synth_2 X VPB pfet_01v8_hvt L=150000U W=1000000U AS=280000000000P
+ AD=327500000000P PS=2560000U PD=1655000U
M$2 synth_2 B1 VPWR VPB pfet_01v8_hvt L=150000U W=1000000U AS=327500000000P
+ AD=195000000000P PS=1655000U PD=1390000U
M$3 synth_3 A2 synth_2 VPB pfet_01v8_hvt L=150000U W=1000000U AS=195000000000P
+ AD=152500000000P PS=1390000U PD=1305000U
M$4 VPWR A1 synth_3 VPB pfet_01v8_hvt L=150000U W=1000000U AS=152500000000P
+ AD=260000000000P PS=1305000U PD=2520000U
M$5 synth_1 B1 synth_2 VNB nfet_01v8 L=150000U W=650000U AS=169000000000P
+ AD=100750000000P PS=1820000U PD=960000U
M$6 VGND A2 synth_1 VNB nfet_01v8 L=150000U W=650000U AS=100750000000P
+ AD=87750000000P PS=960000U PD=920000U
M$7 synth_1 A1 VGND VNB nfet_01v8 L=150000U W=650000U AS=87750000000P
+ AD=169000000000P PS=920000U PD=1820000U
M$8 VGND synth_2 X VNB nfet_01v8 L=150000U W=650000U AS=169000000000P
+ AD=169000000000P PS=1820000U PD=1820000U
.ENDS sky130_fd_sc_hd__o21a_1

.SUBCKT sky130_fd_sc_hd__nor2b_1 VPB A B_N Y VGND VPWR VNB
M$1 VPWR B_N synth_1 VPB pfet_01v8_hvt L=150000U W=420000U AS=109200000000P
+ AD=157300000000P PS=1360000U PD=1390000U
M$2 synth_2 A VPWR VPB pfet_01v8_hvt L=150000U W=1000000U AS=157300000000P
+ AD=105000000000P PS=1390000U PD=1210000U
M$3 Y synth_1 synth_2 VPB pfet_01v8_hvt L=150000U W=1000000U AS=105000000000P
+ AD=260000000000P PS=1210000U PD=2520000U
M$4 VGND B_N synth_1 VNB nfet_01v8 L=150000U W=420000U AS=109200000000P
+ AD=100250000000P PS=1360000U PD=985000U
M$5 Y A VGND VNB nfet_01v8 L=150000U W=650000U AS=100250000000P AD=87750000000P
+ PS=985000U PD=920000U
M$6 VGND synth_1 Y VNB nfet_01v8 L=150000U W=650000U AS=87750000000P
+ AD=169000000000P PS=920000U PD=1820000U
.ENDS sky130_fd_sc_hd__nor2b_1

.SUBCKT sky130_fd_sc_hd__fa_1 VGND COUT CIN SUM A B VPWR VPB VNB
M$1 VPWR synth_1 COUT VPB pfet_01v8_hvt L=150000U W=1000000U AS=260000000000P
+ AD=147850000000P PS=2520000U PD=1345000U
M$2 synth_10 A VPWR VPB pfet_01v8_hvt L=150000U W=420000U AS=147850000000P
+ AD=63000000000P PS=1345000U PD=720000U
M$3 synth_1 B synth_10 VPB pfet_01v8_hvt L=150000U W=420000U AS=63000000000P
+ AD=56700000000P PS=720000U PD=690000U
M$4 synth_8 CIN synth_1 VPB pfet_01v8_hvt L=150000U W=420000U AS=56700000000P
+ AD=56700000000P PS=690000U PD=690000U
M$5 VPWR A synth_8 VPB pfet_01v8_hvt L=150000U W=420000U AS=56700000000P
+ AD=56700000000P PS=690000U PD=690000U
M$6 synth_8 B VPWR VPB pfet_01v8_hvt L=150000U W=420000U AS=56700000000P
+ AD=109200000000P PS=690000U PD=1360000U
M$7 synth_9 B VPWR VPB pfet_01v8_hvt L=150000U W=420000U AS=109200000000P
+ AD=56700000000P PS=1360000U PD=690000U
M$8 VPWR CIN synth_9 VPB pfet_01v8_hvt L=150000U W=420000U AS=56700000000P
+ AD=56700000000P PS=690000U PD=690000U
M$9 synth_9 A VPWR VPB pfet_01v8_hvt L=150000U W=420000U AS=56700000000P
+ AD=61950000000P PS=690000U PD=715000U
M$10 synth_4 synth_1 synth_9 VPB pfet_01v8_hvt L=150000U W=420000U
+ AS=61950000000P AD=69300000000P PS=715000U PD=750000U
M$11 synth_11 CIN synth_4 VPB pfet_01v8_hvt L=150000U W=420000U AS=69300000000P
+ AD=44100000000P PS=750000U PD=630000U
M$12 synth_12 B synth_11 VPB pfet_01v8_hvt L=150000U W=420000U AS=44100000000P
+ AD=69300000000P PS=630000U PD=750000U
M$13 synth_12 A VPWR VPB pfet_01v8_hvt L=150000U W=420000U AS=147850000000P
+ AD=69300000000P PS=1345000U PD=750000U
M$14 SUM synth_4 VPWR VPB pfet_01v8_hvt L=150000U W=1000000U AS=147850000000P
+ AD=260000000000P PS=1345000U PD=2520000U
M$15 synth_5 A VGND VNB nfet_01v8 L=150000U W=420000U AS=102350000000P
+ AD=63000000000P PS=995000U PD=720000U
M$16 synth_1 B synth_5 VNB nfet_01v8 L=150000U W=420000U AS=63000000000P
+ AD=56700000000P PS=720000U PD=690000U
M$17 synth_2 CIN synth_1 VNB nfet_01v8 L=150000U W=420000U AS=56700000000P
+ AD=56700000000P PS=690000U PD=690000U
M$18 VGND A synth_2 VNB nfet_01v8 L=150000U W=420000U AS=56700000000P
+ AD=56700000000P PS=690000U PD=690000U
M$19 synth_2 B VGND VNB nfet_01v8 L=150000U W=420000U AS=56700000000P
+ AD=109200000000P PS=690000U PD=1360000U
M$20 VGND synth_1 COUT VNB nfet_01v8 L=150000U W=650000U AS=169000000000P
+ AD=102350000000P PS=1820000U PD=995000U
M$21 synth_3 B VGND VNB nfet_01v8 L=150000U W=420000U AS=109200000000P
+ AD=56700000000P PS=1360000U PD=690000U
M$22 VGND CIN synth_3 VNB nfet_01v8 L=150000U W=420000U AS=56700000000P
+ AD=56700000000P PS=690000U PD=690000U
M$23 synth_3 A VGND VNB nfet_01v8 L=150000U W=420000U AS=56700000000P
+ AD=61950000000P PS=690000U PD=715000U
M$24 synth_4 synth_1 synth_3 VNB nfet_01v8 L=150000U W=420000U AS=61950000000P
+ AD=69300000000P PS=715000U PD=750000U
M$25 synth_6 CIN synth_4 VNB nfet_01v8 L=150000U W=420000U AS=69300000000P
+ AD=44100000000P PS=750000U PD=630000U
M$26 synth_7 B synth_6 VNB nfet_01v8 L=150000U W=420000U AS=44100000000P
+ AD=69300000000P PS=630000U PD=750000U
M$27 VGND A synth_7 VNB nfet_01v8 L=150000U W=420000U AS=69300000000P
+ AD=102350000000P PS=750000U PD=995000U
M$28 SUM synth_4 VGND VNB nfet_01v8 L=150000U W=650000U AS=102350000000P
+ AD=169000000000P PS=995000U PD=1820000U
.ENDS sky130_fd_sc_hd__fa_1

.SUBCKT sky130_fd_sc_hd__nor3b_1 VPB B A C_N Y VGND VPWR VNB
M$1 synth_1 C_N VPWR VPB pfet_01v8_hvt L=150000U W=420000U AS=145750000000P
+ AD=109200000000P PS=1335000U PD=1360000U
M$2 synth_3 synth_1 Y VPB pfet_01v8_hvt L=150000U W=1000000U AS=320000000000P
+ AD=135000000000P PS=2640000U PD=1270000U
M$3 synth_2 B synth_3 VPB pfet_01v8_hvt L=150000U W=1000000U AS=135000000000P
+ AD=135000000000P PS=1270000U PD=1270000U
M$4 VPWR A synth_2 VPB pfet_01v8_hvt L=150000U W=1000000U AS=135000000000P
+ AD=145750000000P PS=1270000U PD=1335000U
M$5 VGND synth_1 Y VNB nfet_01v8 L=150000U W=650000U AS=221000000000P
+ AD=87750000000P PS=1980000U PD=920000U
M$6 Y B VGND VNB nfet_01v8 L=150000U W=650000U AS=87750000000P AD=87750000000P
+ PS=920000U PD=920000U
M$7 VGND A Y VNB nfet_01v8 L=150000U W=650000U AS=87750000000P AD=100250000000P
+ PS=920000U PD=985000U
M$8 synth_1 C_N VGND VNB nfet_01v8 L=150000U W=420000U AS=100250000000P
+ AD=109200000000P PS=985000U PD=1360000U
.ENDS sky130_fd_sc_hd__nor3b_1

.SUBCKT sky130_fd_sc_hd__and3_1 VPB C A B VGND VPWR X VNB
M$1 VPWR A synth_1 VPB pfet_01v8_hvt L=150000U W=420000U AS=109200000000P
+ AD=56700000000P PS=1360000U PD=690000U
M$2 synth_1 B VPWR VPB pfet_01v8_hvt L=150000U W=420000U AS=56700000000P
+ AD=66150000000P PS=690000U PD=735000U
M$3 synth_1 C VPWR VPB pfet_01v8_hvt L=150000U W=420000U AS=142225000000P
+ AD=66150000000P PS=1335000U PD=735000U
M$4 X synth_1 VPWR VPB pfet_01v8_hvt L=150000U W=1000000U AS=142225000000P
+ AD=260000000000P PS=1335000U PD=2520000U
M$5 synth_3 A synth_1 VNB nfet_01v8 L=150000U W=420000U AS=109200000000P
+ AD=44100000000P PS=1360000U PD=630000U
M$6 synth_2 B synth_3 VNB nfet_01v8 L=150000U W=420000U AS=44100000000P
+ AD=44100000000P PS=630000U PD=630000U
M$7 VGND C synth_2 VNB nfet_01v8 L=150000U W=420000U AS=44100000000P
+ AD=131650000000P PS=630000U PD=1140000U
M$8 X synth_1 VGND VNB nfet_01v8 L=150000U W=650000U AS=131650000000P
+ AD=169000000000P PS=1140000U PD=1820000U
.ENDS sky130_fd_sc_hd__and3_1

.SUBCKT sky130_fd_sc_hd__conb_1
.ENDS sky130_fd_sc_hd__conb_1

.SUBCKT sky130_fd_sc_hd__xor2_1 VPB B A VPWR X VGND VNB
M$1 X synth_1 synth_2 VPB pfet_01v8_hvt L=150000U W=1000000U AS=260000000000P
+ AD=300000000000P PS=2520000U PD=2600000U
M$2 synth_3 B synth_1 VPB pfet_01v8_hvt L=150000U W=1000000U AS=260000000000P
+ AD=135000000000P PS=2520000U PD=1270000U
M$3 VPWR A synth_3 VPB pfet_01v8_hvt L=150000U W=1000000U AS=135000000000P
+ AD=135000000000P PS=1270000U PD=1270000U
M$4 synth_2 A VPWR VPB pfet_01v8_hvt L=150000U W=1000000U AS=135000000000P
+ AD=135000000000P PS=1270000U PD=1270000U
M$5 VPWR B synth_2 VPB pfet_01v8_hvt L=150000U W=1000000U AS=135000000000P
+ AD=260000000000P PS=1270000U PD=2520000U
M$6 synth_1 B VGND VNB nfet_01v8 L=150000U W=650000U AS=169000000000P
+ AD=87750000000P PS=1820000U PD=920000U
M$7 VGND A synth_1 VNB nfet_01v8 L=150000U W=650000U AS=87750000000P
+ AD=87750000000P PS=920000U PD=920000U
M$8 synth_4 A VGND VNB nfet_01v8 L=150000U W=650000U AS=87750000000P
+ AD=87750000000P PS=920000U PD=920000U
M$9 X B synth_4 VNB nfet_01v8 L=150000U W=650000U AS=87750000000P
+ AD=250250000000P PS=920000U PD=1420000U
M$10 VGND synth_1 X VNB nfet_01v8 L=150000U W=650000U AS=250250000000P
+ AD=208000000000P PS=1420000U PD=1940000U
.ENDS sky130_fd_sc_hd__xor2_1

.SUBCKT sky130_fd_sc_hd__a21boi_0 VPB B1_N A1 A2 VGND VPWR Y VNB
M$1 synth_1 synth_2 Y VPB pfet_01v8_hvt L=150000U W=640000U AS=169600000000P
+ AD=89600000000P PS=1810000U PD=920000U
M$2 VPWR A1 synth_1 VPB pfet_01v8_hvt L=150000U W=640000U AS=89600000000P
+ AD=89600000000P PS=920000U PD=920000U
M$3 synth_1 A2 VPWR VPB pfet_01v8_hvt L=150000U W=640000U AS=89600000000P
+ AD=169600000000P PS=920000U PD=1810000U
M$4 VPWR B1_N synth_2 VPB pfet_01v8_hvt L=150000U W=420000U AS=111300000000P
+ AD=111300000000P PS=1370000U PD=1370000U
M$5 VGND B1_N synth_2 VNB nfet_01v8 L=150000U W=420000U AS=111300000000P
+ AD=130200000000P PS=1370000U PD=1040000U
M$6 Y synth_2 VGND VNB nfet_01v8 L=150000U W=420000U AS=130200000000P
+ AD=111300000000P PS=1040000U PD=950000U
M$7 synth_3 A1 Y VNB nfet_01v8 L=150000U W=420000U AS=111300000000P
+ AD=44100000000P PS=950000U PD=630000U
M$8 VGND A2 synth_3 VNB nfet_01v8 L=150000U W=420000U AS=44100000000P
+ AD=111300000000P PS=630000U PD=1370000U
.ENDS sky130_fd_sc_hd__a21boi_0

.SUBCKT sky130_fd_sc_hd__a22o_1 VPB B2 B1 A1 A2 VGND X VPWR VNB
M$1 synth_1 A1 VPWR VPB pfet_01v8_hvt L=150000U W=1000000U AS=252900000000P
+ AD=160000000000P PS=2520000U PD=1320000U
M$2 VPWR A2 synth_1 VPB pfet_01v8_hvt L=150000U W=1000000U AS=160000000000P
+ AD=155000000000P PS=1320000U PD=1310000U
M$3 X synth_2 VPWR VPB pfet_01v8_hvt L=150000U W=1000000U AS=155000000000P
+ AD=260000000000P PS=1310000U PD=2520000U
M$4 synth_1 B2 synth_2 VPB pfet_01v8_hvt L=150000U W=1000000U AS=260000000000P
+ AD=135000000000P PS=2520000U PD=1270000U
M$5 synth_2 B1 synth_1 VPB pfet_01v8_hvt L=150000U W=1000000U AS=135000000000P
+ AD=252850000000P PS=1270000U PD=2520000U
M$6 synth_3 A1 synth_2 VNB nfet_01v8 L=150000U W=650000U AS=169000000000P
+ AD=113750000000P PS=1820000U PD=1000000U
M$7 VGND A2 synth_3 VNB nfet_01v8 L=150000U W=650000U AS=113750000000P
+ AD=100750000000P PS=1000000U PD=960000U
M$8 X synth_2 VGND VNB nfet_01v8 L=150000U W=650000U AS=100750000000P
+ AD=169000000000P PS=960000U PD=1820000U
M$9 synth_4 B2 VGND VNB nfet_01v8 L=150000U W=650000U AS=169000000000P
+ AD=74750000000P PS=1820000U PD=880000U
M$10 synth_2 B1 synth_4 VNB nfet_01v8 L=150000U W=650000U AS=74750000000P
+ AD=169000000000P PS=880000U PD=1820000U
.ENDS sky130_fd_sc_hd__a22o_1

.SUBCKT sky130_fd_sc_hd__a21o_1 VPB A1 A2 B1 VGND VPWR X VNB
M$1 synth_1 B1 synth_2 VPB pfet_01v8_hvt L=150000U W=1000000U AS=260000000000P
+ AD=137500000000P PS=2520000U PD=1275000U
M$2 VPWR A1 synth_1 VPB pfet_01v8_hvt L=150000U W=1000000U AS=137500000000P
+ AD=140000000000P PS=1275000U PD=1280000U
M$3 synth_1 A2 VPWR VPB pfet_01v8_hvt L=150000U W=1000000U AS=140000000000P
+ AD=265000000000P PS=1280000U PD=2530000U
M$4 VPWR synth_2 X VPB pfet_01v8_hvt L=150000U W=1000000U AS=260000000000P
+ AD=260000000000P PS=2520000U PD=2520000U
M$5 VGND synth_2 X VNB nfet_01v8 L=150000U W=650000U AS=169000000000P
+ AD=256750000000P PS=1820000U PD=1440000U
M$6 synth_2 B1 VGND VNB nfet_01v8 L=150000U W=650000U AS=256750000000P
+ AD=89375000000P PS=1440000U PD=925000U
M$7 synth_3 A1 synth_2 VNB nfet_01v8 L=150000U W=650000U AS=89375000000P
+ AD=91000000000P PS=925000U PD=930000U
M$8 VGND A2 synth_3 VNB nfet_01v8 L=150000U W=650000U AS=91000000000P
+ AD=172250000000P PS=930000U PD=1830000U
.ENDS sky130_fd_sc_hd__a21o_1

.SUBCKT sky130_fd_sc_hd__nor2_4 VGND B Y A VPWR VPB VNB
M$1 VPWR A synth_1 VPB pfet_01v8_hvt L=150000U W=4000000U AS=685000000000P
+ AD=540000000000P PS=6370000U PD=5080000U
M$5 Y B synth_1 VPB pfet_01v8_hvt L=150000U W=4000000U AS=540000000000P
+ AD=675000000000P PS=5080000U PD=6350000U
M$9 Y A VGND VNB nfet_01v8 L=150000U W=2600000U AS=445250000000P
+ AD=351000000000P PS=4620000U PD=3680000U
M$13 Y B VGND VNB nfet_01v8 L=150000U W=2600000U AS=351000000000P
+ AD=432250000000P PS=3680000U PD=4580000U
.ENDS sky130_fd_sc_hd__nor2_4

.SUBCKT sky130_fd_sc_hd__a2111oi_0 VPB D1 C1 B1 A1 A2 VGND VPWR Y VNB
M$1 synth_3 D1 Y VPB pfet_01v8_hvt L=150000U W=640000U AS=188800000000P
+ AD=67200000000P PS=1870000U PD=850000U
M$2 synth_2 C1 synth_3 VPB pfet_01v8_hvt L=150000U W=640000U AS=67200000000P
+ AD=67200000000P PS=850000U PD=850000U
M$3 synth_1 B1 synth_2 VPB pfet_01v8_hvt L=150000U W=640000U AS=67200000000P
+ AD=89600000000P PS=850000U PD=920000U
M$4 VPWR A1 synth_1 VPB pfet_01v8_hvt L=150000U W=640000U AS=89600000000P
+ AD=121600000000P PS=920000U PD=1020000U
M$5 synth_1 A2 VPWR VPB pfet_01v8_hvt L=150000U W=640000U AS=121600000000P
+ AD=195200000000P PS=1020000U PD=1890000U
M$6 Y D1 VGND VNB nfet_01v8 L=150000U W=420000U AS=126000000000P
+ AD=58800000000P PS=1440000U PD=700000U
M$7 VGND C1 Y VNB nfet_01v8 L=150000U W=420000U AS=58800000000P AD=73500000000P
+ PS=700000U PD=770000U
M$8 Y B1 VGND VNB nfet_01v8 L=150000U W=420000U AS=73500000000P AD=58800000000P
+ PS=770000U PD=700000U
M$9 synth_4 A1 Y VNB nfet_01v8 L=150000U W=420000U AS=58800000000P
+ AD=44100000000P PS=700000U PD=630000U
M$10 VGND A2 synth_4 VNB nfet_01v8 L=150000U W=420000U AS=44100000000P
+ AD=119700000000P PS=630000U PD=1410000U
.ENDS sky130_fd_sc_hd__a2111oi_0

.SUBCKT sky130_fd_sc_hd__a22oi_1 VPB B2 B1 A1 A2 VPWR Y VGND VNB
M$1 synth_1 A1 VPWR VPB pfet_01v8_hvt L=150000U W=1000000U AS=260000000000P
+ AD=135000000000P PS=2520000U PD=1270000U
M$2 VPWR A2 synth_1 VPB pfet_01v8_hvt L=150000U W=1000000U AS=135000000000P
+ AD=300000000000P PS=1270000U PD=2600000U
M$3 synth_1 B2 Y VPB pfet_01v8_hvt L=150000U W=1000000U AS=260000000000P
+ AD=135000000000P PS=2520000U PD=1270000U
M$4 Y B1 synth_1 VPB pfet_01v8_hvt L=150000U W=1000000U AS=135000000000P
+ AD=260000000000P PS=1270000U PD=2520000U
M$5 synth_2 A1 Y VNB nfet_01v8 L=150000U W=650000U AS=169000000000P
+ AD=68250000000P PS=1820000U PD=860000U
M$6 VGND A2 synth_2 VNB nfet_01v8 L=150000U W=650000U AS=68250000000P
+ AD=234000000000P PS=860000U PD=2020000U
M$7 synth_3 B2 VGND VNB nfet_01v8 L=150000U W=650000U AS=169000000000P
+ AD=74750000000P PS=1820000U PD=880000U
M$8 Y B1 synth_3 VNB nfet_01v8 L=150000U W=650000U AS=74750000000P
+ AD=169000000000P PS=880000U PD=1820000U
.ENDS sky130_fd_sc_hd__a22oi_1

.SUBCKT sky130_fd_sc_hd__o221ai_1 VPB C1 B1 A2 A1 B2 Y VPWR VGND VNB
M$1 VPWR C1 Y VPB pfet_01v8_hvt L=150000U W=1000000U AS=280000000000P
+ AD=380000000000P PS=2560000U PD=1760000U
M$2 synth_4 B1 VPWR VPB pfet_01v8_hvt L=150000U W=1000000U AS=380000000000P
+ AD=120000000000P PS=1760000U PD=1240000U
M$3 Y B2 synth_4 VPB pfet_01v8_hvt L=150000U W=1000000U AS=120000000000P
+ AD=225000000000P PS=1240000U PD=1450000U
M$4 synth_3 A2 Y VPB pfet_01v8_hvt L=150000U W=1000000U AS=225000000000P
+ AD=105000000000P PS=1450000U PD=1210000U
M$5 VPWR A1 synth_3 VPB pfet_01v8_hvt L=150000U W=1000000U AS=105000000000P
+ AD=260000000000P PS=1210000U PD=2520000U
M$6 synth_2 B1 synth_1 VNB nfet_01v8 L=150000U W=650000U AS=165200000000P
+ AD=87750000000P PS=1820000U PD=920000U
M$7 synth_1 B2 synth_2 VNB nfet_01v8 L=150000U W=650000U AS=87750000000P
+ AD=117000000000P PS=920000U PD=1010000U
M$8 VGND A2 synth_1 VNB nfet_01v8 L=150000U W=650000U AS=117000000000P
+ AD=87750000000P PS=1010000U PD=920000U
M$9 synth_1 A1 VGND VNB nfet_01v8 L=150000U W=650000U AS=87750000000P
+ AD=169000000000P PS=920000U PD=1820000U
M$10 synth_2 C1 Y VNB nfet_01v8 L=150000U W=650000U AS=169000000000P
+ AD=165400000000P PS=1820000U PD=1820000U
.ENDS sky130_fd_sc_hd__o221ai_1

.SUBCKT sky130_fd_sc_hd__and2_1 VPB A B X VPWR VGND VNB
M$1 synth_1 A VPWR VPB pfet_01v8_hvt L=150000U W=420000U AS=117600000000P
+ AD=56700000000P PS=1400000U PD=690000U
M$2 synth_1 B VPWR VPB pfet_01v8_hvt L=150000U W=420000U AS=166550000000P
+ AD=56700000000P PS=1390000U PD=690000U
M$3 X synth_1 VPWR VPB pfet_01v8_hvt L=150000U W=1000000U AS=166550000000P
+ AD=475000000000P PS=1390000U PD=2950000U
M$4 synth_2 A synth_1 VNB nfet_01v8 L=150000U W=420000U AS=117600000000P
+ AD=56700000000P PS=1400000U PD=690000U
M$5 synth_2 B VGND VNB nfet_01v8 L=150000U W=420000U AS=111800000000P
+ AD=56700000000P PS=1040000U PD=690000U
M$6 X synth_1 VGND VNB nfet_01v8 L=150000U W=650000U AS=111800000000P
+ AD=182000000000P PS=1040000U PD=1860000U
.ENDS sky130_fd_sc_hd__and2_1

.SUBCKT sky130_fd_sc_hd__xnor2_1 VPB B A Y VPWR VGND VNB
M$1 synth_2 B VPWR VPB pfet_01v8_hvt L=150000U W=1000000U AS=300000000000P
+ AD=135000000000P PS=2600000U PD=1270000U
M$2 VPWR A synth_2 VPB pfet_01v8_hvt L=150000U W=1000000U AS=135000000000P
+ AD=365000000000P PS=1270000U PD=1730000U
M$3 synth_3 A VPWR VPB pfet_01v8_hvt L=150000U W=1000000U AS=365000000000P
+ AD=105000000000P PS=1730000U PD=1210000U
M$4 Y B synth_3 VPB pfet_01v8_hvt L=150000U W=1000000U AS=105000000000P
+ AD=165000000000P PS=1210000U PD=1330000U
M$5 VPWR synth_2 Y VPB pfet_01v8_hvt L=150000U W=1000000U AS=165000000000P
+ AD=360000000000P PS=1330000U PD=2720000U
M$6 synth_1 B VGND VNB nfet_01v8 L=150000U W=650000U AS=169000000000P
+ AD=87750000000P PS=1820000U PD=920000U
M$7 Y synth_2 synth_1 VNB nfet_01v8 L=150000U W=650000U AS=87750000000P
+ AD=195000000000P PS=920000U PD=1900000U
M$8 synth_4 B synth_2 VNB nfet_01v8 L=150000U W=650000U AS=169000000000P
+ AD=68250000000P PS=1820000U PD=860000U
M$9 VGND A synth_4 VNB nfet_01v8 L=150000U W=650000U AS=68250000000P
+ AD=87750000000P PS=860000U PD=920000U
M$10 synth_1 A VGND VNB nfet_01v8 L=150000U W=650000U AS=87750000000P
+ AD=169000000000P PS=920000U PD=1820000U
.ENDS sky130_fd_sc_hd__xnor2_1

.SUBCKT sky130_fd_sc_hd__or2_2 VPB A B X VPWR VGND VNB
M$1 synth_2 B synth_1 VPB pfet_01v8_hvt L=150000U W=420000U AS=109200000000P
+ AD=44100000000P PS=1360000U PD=630000U
M$2 VPWR A synth_2 VPB pfet_01v8_hvt L=150000U W=420000U AS=44100000000P
+ AD=155750000000P PS=630000U PD=1355000U
M$3 X synth_1 VPWR VPB pfet_01v8_hvt L=150000U W=2000000U AS=290750000000P
+ AD=395000000000P PS=2625000U PD=3790000U
M$5 synth_1 B VGND VNB nfet_01v8 L=150000U W=420000U AS=109200000000P
+ AD=56700000000P PS=1360000U PD=690000U
M$6 VGND A synth_1 VNB nfet_01v8 L=150000U W=420000U AS=56700000000P
+ AD=106750000000P PS=690000U PD=1005000U
M$7 X synth_1 VGND VNB nfet_01v8 L=150000U W=1300000U AS=194500000000P
+ AD=256750000000P PS=1925000U PD=2740000U
.ENDS sky130_fd_sc_hd__or2_2

.SUBCKT sky130_fd_sc_hd__buf_4 VPB A VPWR VGND X VNB
M$1 VPWR A synth_1 VPB pfet_01v8_hvt L=150000U W=1000000U AS=260000000000P
+ AD=135000000000P PS=2520000U PD=1270000U
M$2 X synth_1 VPWR VPB pfet_01v8_hvt L=150000U W=4000000U AS=540000000000P
+ AD=665000000000P PS=5080000U PD=6330000U
M$6 VGND A synth_1 VNB nfet_01v8 L=150000U W=650000U AS=169000000000P
+ AD=87750000000P PS=1820000U PD=920000U
M$7 X synth_1 VGND VNB nfet_01v8 L=150000U W=2600000U AS=351000000000P
+ AD=432250000000P PS=3680000U PD=4580000U
.ENDS sky130_fd_sc_hd__buf_4

.SUBCKT sky130_fd_sc_hd__edfxtp_1 VGND Q CLK D DE VPWR VPB VNB
M$1 synth_5 synth_8 VPWR VPB pfet_01v8_hvt L=150000U W=640000U AS=154000000000P
+ AD=172800000000P PS=1335000U PD=1820000U
M$2 Q synth_8 VPWR VPB pfet_01v8_hvt L=150000U W=1000000U AS=154000000000P
+ AD=280000000000P PS=1335000U PD=2560000U
M$3 synth_17 synth_7 VPWR VPB pfet_01v8_hvt L=150000U W=420000U
+ AS=109200000000P AD=64050000000P PS=1360000U PD=725000U
M$4 synth_8 synth_1 synth_17 VPB pfet_01v8_hvt L=150000U W=420000U
+ AS=64050000000P AD=56700000000P PS=725000U PD=690000U
M$5 synth_18 synth_2 synth_8 VPB pfet_01v8_hvt L=150000U W=420000U
+ AS=56700000000P AD=88200000000P PS=690000U PD=840000U
M$6 VPWR synth_5 synth_18 VPB pfet_01v8_hvt L=150000U W=420000U AS=88200000000P
+ AD=111300000000P PS=840000U PD=1370000U
M$7 synth_14 D synth_3 VPB pfet_01v8_hvt L=150000U W=640000U AS=166400000000P
+ AD=67200000000P PS=1800000U PD=850000U
M$8 VPWR synth_4 synth_14 VPB pfet_01v8_hvt L=150000U W=640000U AS=67200000000P
+ AD=166400000000P PS=850000U PD=1800000U
M$9 VPWR CLK synth_1 VPB pfet_01v8_hvt L=150000U W=640000U AS=166400000000P
+ AD=86400000000P PS=1800000U PD=910000U
M$10 synth_2 synth_1 VPWR VPB pfet_01v8_hvt L=150000U W=640000U AS=86400000000P
+ AD=166400000000P PS=910000U PD=1800000U
M$11 VPWR DE synth_4 VPB pfet_01v8_hvt L=150000U W=640000U AS=166400000000P
+ AD=92800000000P PS=1800000U PD=930000U
M$12 synth_15 DE VPWR VPB pfet_01v8_hvt L=150000U W=640000U AS=92800000000P
+ AD=115200000000P PS=930000U PD=1000000U
M$13 synth_3 synth_5 synth_15 VPB pfet_01v8_hvt L=150000U W=640000U
+ AS=115200000000P AD=159850000000P PS=1000000U PD=1265000U
M$14 synth_6 synth_2 synth_3 VPB pfet_01v8_hvt L=150000U W=420000U
+ AS=159850000000P AD=64050000000P PS=1265000U PD=725000U
M$15 synth_16 synth_1 synth_6 VPB pfet_01v8_hvt L=150000U W=420000U
+ AS=64050000000P AD=76650000000P PS=725000U PD=785000U
M$16 synth_16 synth_7 VPWR VPB pfet_01v8_hvt L=150000U W=420000U
+ AS=178875000000P AD=76650000000P PS=1260000U PD=785000U
M$17 synth_7 synth_6 VPWR VPB pfet_01v8_hvt L=150000U W=750000U
+ AS=178875000000P AD=195000000000P PS=1260000U PD=2020000U
M$18 VGND synth_8 synth_5 VNB nfet_01v8 L=150000U W=420000U AS=109200000000P
+ AD=100250000000P PS=1360000U PD=985000U
M$19 Q synth_8 VGND VNB nfet_01v8 L=150000U W=650000U AS=100250000000P
+ AD=182000000000P PS=985000U PD=1860000U
M$20 synth_8 synth_2 synth_12 VNB nfet_01v8 L=150000U W=360000U AS=67800000000P
+ AD=68400000000P PS=755000U PD=740000U
M$21 synth_10 synth_1 synth_8 VNB nfet_01v8 L=150000U W=360000U AS=68400000000P
+ AD=66000000000P PS=740000U PD=745000U
M$22 synth_12 synth_7 VGND VNB nfet_01v8 L=150000U W=420000U AS=109200000000P
+ AD=67800000000P PS=1360000U PD=755000U
M$23 VGND synth_5 synth_10 VNB nfet_01v8 L=150000U W=420000U AS=66000000000P
+ AD=109200000000P PS=745000U PD=1360000U
M$24 VGND CLK synth_1 VNB nfet_01v8 L=150000U W=420000U AS=109200000000P
+ AD=56700000000P PS=1360000U PD=690000U
M$25 synth_2 synth_1 VGND VNB nfet_01v8 L=150000U W=420000U AS=56700000000P
+ AD=109200000000P PS=690000U PD=1360000U
M$26 synth_6 synth_1 synth_3 VNB nfet_01v8 L=150000U W=360000U AS=144600000000P
+ AD=52200000000P PS=1180000U PD=650000U
M$27 synth_13 synth_2 synth_6 VNB nfet_01v8 L=150000U W=360000U AS=52200000000P
+ AD=75900000000P PS=650000U PD=800000U
M$28 VGND DE synth_4 VNB nfet_01v8 L=150000U W=420000U AS=109200000000P
+ AD=60900000000P PS=1360000U PD=710000U
M$29 synth_11 synth_4 VGND VNB nfet_01v8 L=150000U W=420000U AS=60900000000P
+ AD=75600000000P PS=710000U PD=780000U
M$30 synth_3 synth_5 synth_11 VNB nfet_01v8 L=150000U W=420000U AS=75600000000P
+ AD=144600000000P PS=780000U PD=1180000U
M$31 VGND synth_7 synth_13 VNB nfet_01v8 L=150000U W=420000U AS=75900000000P
+ AD=120950000000P PS=800000U PD=1085000U
M$32 synth_7 synth_6 VGND VNB nfet_01v8 L=150000U W=640000U AS=120950000000P
+ AD=166400000000P PS=1085000U PD=1800000U
M$33 synth_9 D synth_3 VNB nfet_01v8 L=150000U W=420000U AS=109200000000P
+ AD=44100000000P PS=1360000U PD=630000U
M$34 VGND DE synth_9 VNB nfet_01v8 L=150000U W=420000U AS=44100000000P
+ AD=109200000000P PS=630000U PD=1360000U
.ENDS sky130_fd_sc_hd__edfxtp_1

.SUBCKT sky130_fd_sc_hd__dlclkp_1 VGND GCLK CLK GATE VPWR VPB VNB
M$1 VPWR synth_3 synth_4 VPB pfet_01v8_hvt L=150000U W=1000000U
+ AS=270000000000P AD=149000000000P PS=2540000U PD=1325000U
M$2 synth_5 synth_4 VPWR VPB pfet_01v8_hvt L=150000U W=640000U AS=149000000000P
+ AD=203200000000P PS=1325000U PD=1275000U
M$3 synth_5 CLK VPWR VPB pfet_01v8_hvt L=150000U W=640000U AS=149000000000P
+ AD=203200000000P PS=1325000U PD=1275000U
M$4 GCLK synth_5 VPWR VPB pfet_01v8_hvt L=150000U W=1000000U AS=149000000000P
+ AD=260000000000P PS=1325000U PD=2520000U
M$5 synth_9 GATE VPWR VPB pfet_01v8_hvt L=150000U W=640000U AS=166400000000P
+ AD=95750000000P PS=1800000U PD=965000U
M$6 synth_3 synth_2 synth_9 VPB pfet_01v8_hvt L=150000U W=420000U
+ AS=95750000000P AD=98700000000P PS=965000U PD=890000U
M$7 synth_10 synth_1 synth_3 VPB pfet_01v8_hvt L=150000U W=420000U
+ AS=98700000000P AD=44100000000P PS=890000U PD=630000U
M$8 VPWR synth_4 synth_10 VPB pfet_01v8_hvt L=150000U W=420000U AS=44100000000P
+ AD=109200000000P PS=630000U PD=1360000U
M$9 VPWR CLK synth_1 VPB pfet_01v8_hvt L=150000U W=640000U AS=166400000000P
+ AD=86400000000P PS=1800000U PD=910000U
M$10 synth_2 synth_1 VPWR VPB pfet_01v8_hvt L=150000U W=640000U AS=86400000000P
+ AD=166400000000P PS=910000U PD=1800000U
M$11 synth_6 synth_4 synth_5 VNB nfet_01v8 L=150000U W=420000U AS=109200000000P
+ AD=44100000000P PS=1360000U PD=630000U
M$12 VGND CLK synth_6 VNB nfet_01v8 L=150000U W=420000U AS=44100000000P
+ AD=97000000000P PS=630000U PD=975000U
M$13 GCLK synth_5 VGND VNB nfet_01v8 L=150000U W=650000U AS=97000000000P
+ AD=169000000000P PS=975000U PD=1820000U
M$14 synth_7 synth_2 synth_3 VNB nfet_01v8 L=150000U W=390000U AS=119200000000P
+ AD=67125000000P PS=1090000U PD=745000U
M$15 VGND synth_4 synth_7 VNB nfet_01v8 L=150000U W=420000U AS=67125000000P
+ AD=118125000000P PS=745000U PD=1040000U
M$16 synth_8 synth_1 synth_3 VNB nfet_01v8 L=150000U W=420000U AS=119200000000P
+ AD=117125000000P PS=1090000U PD=1085000U
M$17 synth_4 synth_3 VGND VNB nfet_01v8 L=150000U W=650000U AS=118125000000P
+ AD=169000000000P PS=1040000U PD=1820000U
M$18 VGND GATE synth_8 VNB nfet_01v8 L=150000U W=420000U AS=117125000000P
+ AD=128100000000P PS=1085000U PD=1450000U
M$19 VGND CLK synth_1 VNB nfet_01v8 L=150000U W=420000U AS=109200000000P
+ AD=56700000000P PS=1360000U PD=690000U
M$20 synth_2 synth_1 VGND VNB nfet_01v8 L=150000U W=420000U AS=56700000000P
+ AD=109200000000P PS=690000U PD=1360000U
.ENDS sky130_fd_sc_hd__dlclkp_1

.SUBCKT sky130_fd_sc_hd__dlygate4sd3_1 VPB A VPWR X VGND VNB
M$1 synth_3 synth_1 VPWR VPB pfet_01v8_hvt L=500000U W=420000U AS=140750000000P
+ AD=109200000000P PS=1325000U PD=1360000U
M$2 X synth_3 VPWR VPB pfet_01v8_hvt L=150000U W=1000000U AS=140750000000P
+ AD=260000000000P PS=1325000U PD=2520000U
M$3 VPWR A synth_2 VPB pfet_01v8_hvt L=150000U W=420000U AS=109200000000P
+ AD=56700000000P PS=1360000U PD=690000U
M$4 synth_1 synth_2 VPWR VPB pfet_01v8_hvt L=500000U W=420000U AS=56700000000P
+ AD=109200000000P PS=690000U PD=1360000U
M$5 VGND synth_1 synth_3 VNB nfet_01v8 L=500000U W=420000U AS=109200000000P
+ AD=97000000000P PS=1360000U PD=975000U
M$6 X synth_3 VGND VNB nfet_01v8 L=150000U W=650000U AS=97000000000P
+ AD=169000000000P PS=975000U PD=1820000U
M$7 VGND A synth_2 VNB nfet_01v8 L=150000U W=420000U AS=109200000000P
+ AD=56700000000P PS=1360000U PD=690000U
M$8 synth_1 synth_2 VGND VNB nfet_01v8 L=500000U W=420000U AS=56700000000P
+ AD=109200000000P PS=690000U PD=1360000U
.ENDS sky130_fd_sc_hd__dlygate4sd3_1

.SUBCKT sky130_fd_sc_hd__clkbuf_16 VGND A X VPWR VPB VNB
M$1 synth_1 A VPWR VPB pfet_01v8_hvt L=150000U W=4000000U AS=685000000000P
+ AD=560000000000P PS=6370000U PD=5120000U
M$5 X synth_1 VPWR VPB pfet_01v8_hvt L=150000U W=16000000U AS=2.2375e+12P
+ AD=2.3625e+12P PS=20475000U PD=21725000U
M$21 synth_1 A VGND VNB nfet_01v8 L=150000U W=1680000U AS=287700000000P
+ AD=235200000000P PS=3470000U PD=2800000U
M$25 X synth_1 VGND VNB nfet_01v8 L=150000U W=6720000U AS=939750000000P
+ AD=992250000000P PS=11195000U PD=11865000U
.ENDS sky130_fd_sc_hd__clkbuf_16

.SUBCKT sky130_fd_sc_hd__dfxtp_1 VGND Q CLK D VPWR VPB VNB
M$1 synth_3 D VPWR VPB pfet_01v8_hvt L=150000U W=420000U AS=109200000000P
+ AD=57750000000P PS=1360000U PD=695000U
M$2 synth_4 synth_2 synth_3 VPB pfet_01v8_hvt L=150000U W=420000U
+ AS=57750000000P AD=68250000000P PS=695000U PD=745000U
M$3 synth_10 synth_1 synth_4 VPB pfet_01v8_hvt L=150000U W=420000U
+ AS=68250000000P AD=76650000000P PS=745000U PD=785000U
M$4 synth_10 synth_5 VPWR VPB pfet_01v8_hvt L=150000U W=420000U
+ AS=178875000000P AD=76650000000P PS=1260000U PD=785000U
M$5 synth_5 synth_4 VPWR VPB pfet_01v8_hvt L=150000U W=750000U AS=178875000000P
+ AD=109500000000P PS=1260000U PD=1075000U
M$6 synth_6 synth_1 synth_5 VPB pfet_01v8_hvt L=150000U W=420000U
+ AS=109500000000P AD=56700000000P PS=1075000U PD=690000U
M$7 synth_11 synth_2 synth_6 VPB pfet_01v8_hvt L=150000U W=420000U
+ AS=56700000000P AD=88200000000P PS=690000U PD=840000U
M$8 VPWR synth_7 synth_11 VPB pfet_01v8_hvt L=150000U W=420000U AS=88200000000P
+ AD=111300000000P PS=840000U PD=1370000U
M$9 VPWR CLK synth_1 VPB pfet_01v8_hvt L=150000U W=640000U AS=166400000000P
+ AD=86400000000P PS=1800000U PD=910000U
M$10 synth_2 synth_1 VPWR VPB pfet_01v8_hvt L=150000U W=640000U AS=86400000000P
+ AD=166400000000P PS=910000U PD=1800000U
M$11 VPWR synth_6 synth_7 VPB pfet_01v8_hvt L=150000U W=1000000U
+ AS=270000000000P AD=135000000000P PS=2540000U PD=1270000U
M$12 Q synth_7 VPWR VPB pfet_01v8_hvt L=150000U W=1000000U AS=135000000000P
+ AD=260000000000P PS=1270000U PD=2520000U
M$13 VGND synth_6 synth_7 VNB nfet_01v8 L=150000U W=650000U AS=169000000000P
+ AD=87750000000P PS=1820000U PD=920000U
M$14 Q synth_7 VGND VNB nfet_01v8 L=150000U W=650000U AS=87750000000P
+ AD=169000000000P PS=920000U PD=1820000U
M$15 VGND CLK synth_1 VNB nfet_01v8 L=150000U W=420000U AS=109200000000P
+ AD=56700000000P PS=1360000U PD=690000U
M$16 synth_2 synth_1 VGND VNB nfet_01v8 L=150000U W=420000U AS=56700000000P
+ AD=109200000000P PS=690000U PD=1360000U
M$17 synth_4 synth_1 synth_3 VNB nfet_01v8 L=150000U W=360000U AS=81300000000P
+ AD=62100000000P PS=830000U PD=705000U
M$18 synth_9 synth_2 synth_4 VNB nfet_01v8 L=150000U W=360000U AS=62100000000P
+ AD=69600000000P PS=705000U PD=765000U
M$19 synth_6 synth_2 synth_5 VNB nfet_01v8 L=150000U W=360000U AS=98900000000P
+ AD=68400000000P PS=995000U PD=740000U
M$20 synth_8 synth_1 synth_6 VNB nfet_01v8 L=150000U W=360000U AS=68400000000P
+ AD=66000000000P PS=740000U PD=745000U
M$21 synth_3 D VGND VNB nfet_01v8 L=150000U W=420000U AS=109200000000P
+ AD=81300000000P PS=1360000U PD=830000U
M$22 VGND synth_5 synth_9 VNB nfet_01v8 L=150000U W=420000U AS=69600000000P
+ AD=120950000000P PS=765000U PD=1085000U
M$23 VGND synth_7 synth_8 VNB nfet_01v8 L=150000U W=420000U AS=66000000000P
+ AD=109200000000P PS=745000U PD=1360000U
M$24 synth_5 synth_4 VGND VNB nfet_01v8 L=150000U W=640000U AS=120950000000P
+ AD=98900000000P PS=1085000U PD=995000U
.ENDS sky130_fd_sc_hd__dfxtp_1

.SUBCKT sky130_fd_sc_hd__ha_1 VGND SUM COUT A VPWR B VPB VNB
M$1 VPWR synth_1 SUM VPB pfet_01v8_hvt L=150000U W=1000000U AS=260000000000P
+ AD=236050000000P PS=2520000U PD=1765000U
M$2 synth_1 synth_3 VPWR VPB pfet_01v8_hvt L=150000U W=420000U AS=236050000000P
+ AD=56700000000P PS=1765000U PD=690000U
M$3 synth_5 B synth_1 VPB pfet_01v8_hvt L=150000U W=420000U AS=56700000000P
+ AD=84000000000P PS=690000U PD=820000U
M$4 VPWR A synth_5 VPB pfet_01v8_hvt L=150000U W=420000U AS=84000000000P
+ AD=149100000000P PS=820000U PD=1130000U
M$5 synth_3 B VPWR VPB pfet_01v8_hvt L=150000U W=420000U AS=149100000000P
+ AD=60900000000P PS=1130000U PD=710000U
M$6 synth_3 A VPWR VPB pfet_01v8_hvt L=150000U W=420000U AS=140750000000P
+ AD=60900000000P PS=1325000U PD=710000U
M$7 COUT synth_3 VPWR VPB pfet_01v8_hvt L=150000U W=1000000U AS=140750000000P
+ AD=260000000000P PS=1325000U PD=2520000U
M$8 synth_4 B synth_3 VNB nfet_01v8 L=150000U W=420000U AS=109200000000P
+ AD=44100000000P PS=1360000U PD=630000U
M$9 VGND A synth_4 VNB nfet_01v8 L=150000U W=420000U AS=44100000000P
+ AD=97000000000P PS=630000U PD=975000U
M$10 COUT synth_3 VGND VNB nfet_01v8 L=150000U W=650000U AS=97000000000P
+ AD=169000000000P PS=975000U PD=1820000U
M$11 synth_2 synth_3 synth_1 VNB nfet_01v8 L=150000U W=420000U AS=109200000000P
+ AD=56700000000P PS=1360000U PD=690000U
M$12 VGND B synth_2 VNB nfet_01v8 L=150000U W=420000U AS=56700000000P
+ AD=56700000000P PS=690000U PD=690000U
M$13 synth_2 A VGND VNB nfet_01v8 L=150000U W=420000U AS=56700000000P
+ AD=109200000000P PS=690000U PD=1360000U
M$14 VGND synth_1 SUM VNB nfet_01v8 L=150000U W=650000U AS=169000000000P
+ AD=169000000000P PS=1820000U PD=1820000U
.ENDS sky130_fd_sc_hd__ha_1

.SUBCKT sky130_fd_sc_hd__a41o_1 VGND X A2 A3 B1 A1 A4 VPWR VPB VNB
M$1 synth_5 B1 synth_1 VPB pfet_01v8_hvt L=150000U W=1000000U AS=260000000000P
+ AD=135000000000P PS=2520000U PD=1270000U
M$2 VPWR A1 synth_5 VPB pfet_01v8_hvt L=150000U W=1000000U AS=135000000000P
+ AD=135000000000P PS=1270000U PD=1270000U
M$3 synth_5 A2 VPWR VPB pfet_01v8_hvt L=150000U W=1000000U AS=135000000000P
+ AD=165000000000P PS=1270000U PD=1330000U
M$4 VPWR A3 synth_5 VPB pfet_01v8_hvt L=150000U W=1000000U AS=165000000000P
+ AD=165000000000P PS=1330000U PD=1330000U
M$5 synth_5 A4 VPWR VPB pfet_01v8_hvt L=150000U W=1000000U AS=165000000000P
+ AD=260000000000P PS=1330000U PD=2520000U
M$6 VPWR synth_1 X VPB pfet_01v8_hvt L=150000U W=1000000U AS=260000000000P
+ AD=260000000000P PS=2520000U PD=2520000U
M$7 VGND synth_1 X VNB nfet_01v8 L=150000U W=650000U AS=169000000000P
+ AD=160875000000P PS=1820000U PD=1145000U
M$8 synth_1 B1 VGND VNB nfet_01v8 L=150000U W=650000U AS=160875000000P
+ AD=183625000000P PS=1145000U PD=1215000U
M$9 synth_3 A1 synth_1 VNB nfet_01v8 L=150000U W=650000U AS=183625000000P
+ AD=87750000000P PS=1215000U PD=920000U
M$10 synth_4 A2 synth_3 VNB nfet_01v8 L=150000U W=650000U AS=87750000000P
+ AD=107250000000P PS=920000U PD=980000U
M$11 synth_2 A3 synth_4 VNB nfet_01v8 L=150000U W=650000U AS=107250000000P
+ AD=107250000000P PS=980000U PD=980000U
M$12 VGND A4 synth_2 VNB nfet_01v8 L=150000U W=650000U AS=107250000000P
+ AD=169000000000P PS=980000U PD=1820000U
.ENDS sky130_fd_sc_hd__a41o_1

.SUBCKT sky130_fd_sc_hd__o31a_1 VPB A1 A2 A3 B1 X VGND VPWR VNB
M$1 VPWR synth_2 X VPB pfet_01v8_hvt L=150000U W=1000000U AS=360000000000P
+ AD=195000000000P PS=2720000U PD=1390000U
M$2 synth_4 A1 VPWR VPB pfet_01v8_hvt L=150000U W=1000000U AS=195000000000P
+ AD=135000000000P PS=1390000U PD=1270000U
M$3 synth_3 A2 synth_4 VPB pfet_01v8_hvt L=150000U W=1000000U AS=135000000000P
+ AD=165000000000P PS=1270000U PD=1330000U
M$4 synth_2 A3 synth_3 VPB pfet_01v8_hvt L=150000U W=1000000U AS=165000000000P
+ AD=212500000000P PS=1330000U PD=1425000U
M$5 VPWR B1 synth_2 VPB pfet_01v8_hvt L=150000U W=1000000U AS=212500000000P
+ AD=345000000000P PS=1425000U PD=2690000U
M$6 VGND synth_2 X VNB nfet_01v8 L=150000U W=650000U AS=234000000000P
+ AD=126750000000P PS=2020000U PD=1040000U
M$7 synth_1 A1 VGND VNB nfet_01v8 L=150000U W=650000U AS=126750000000P
+ AD=87750000000P PS=1040000U PD=920000U
M$8 VGND A2 synth_1 VNB nfet_01v8 L=150000U W=650000U AS=87750000000P
+ AD=107250000000P PS=920000U PD=980000U
M$9 synth_1 A3 VGND VNB nfet_01v8 L=150000U W=650000U AS=107250000000P
+ AD=107250000000P PS=980000U PD=980000U
M$10 synth_2 B1 synth_1 VNB nfet_01v8 L=150000U W=650000U AS=107250000000P
+ AD=201500000000P PS=980000U PD=1920000U
.ENDS sky130_fd_sc_hd__o31a_1

.SUBCKT sky130_fd_sc_hd__o21bai_1 VPB B1_N A1 A2 VPWR VGND Y VNB
M$1 synth_1 B1_N VPWR VPB pfet_01v8_hvt L=150000U W=420000U AS=178250000000P
+ AD=109200000000P PS=1400000U PD=1360000U
M$2 Y synth_1 VPWR VPB pfet_01v8_hvt L=150000U W=1000000U AS=178250000000P
+ AD=152500000000P PS=1400000U PD=1305000U
M$3 synth_3 A2 Y VPB pfet_01v8_hvt L=150000U W=1000000U AS=152500000000P
+ AD=127500000000P PS=1305000U PD=1255000U
M$4 VPWR A1 synth_3 VPB pfet_01v8_hvt L=150000U W=1000000U AS=127500000000P
+ AD=280000000000P PS=1255000U PD=2560000U
M$5 synth_2 synth_1 Y VNB nfet_01v8 L=150000U W=650000U AS=169000000000P
+ AD=100750000000P PS=1820000U PD=960000U
M$6 VGND A2 synth_2 VNB nfet_01v8 L=150000U W=650000U AS=100750000000P
+ AD=87750000000P PS=960000U PD=920000U
M$7 synth_2 A1 VGND VNB nfet_01v8 L=150000U W=650000U AS=87750000000P
+ AD=169000000000P PS=920000U PD=1820000U
M$8 synth_1 B1_N VGND VNB nfet_01v8 L=150000U W=420000U AS=109200000000P
+ AD=109200000000P PS=1360000U PD=1360000U
.ENDS sky130_fd_sc_hd__o21bai_1

.SUBCKT sky130_fd_sc_hd__a2111oi_2 VGND Y C1 D1 B1 A1 A2 VPWR VPB VNB
M$1 VPWR A1 synth_2 VPB pfet_01v8_hvt L=150000U W=2000000U AS=420000000000P
+ AD=475000000000P PS=3840000U PD=3950000U
M$2 synth_2 A2 VPWR VPB pfet_01v8_hvt L=150000U W=2000000U AS=280000000000P
+ AD=300000000000P PS=2560000U PD=2600000U
M$5 synth_4 C1 synth_3 VPB pfet_01v8_hvt L=150000U W=2000000U AS=425000000000P
+ AD=300000000000P PS=3850000U PD=2600000U
M$6 Y D1 synth_4 VPB pfet_01v8_hvt L=150000U W=2000000U AS=280000000000P
+ AD=280000000000P PS=2560000U PD=2560000U
M$9 synth_2 B1 synth_3 VPB pfet_01v8_hvt L=150000U W=2000000U AS=300000000000P
+ AD=400000000000P PS=2600000U PD=3800000U
M$11 VGND C1 Y VNB nfet_01v8 L=150000U W=1300000U AS=312000000000P
+ AD=196625000000P PS=2910000U PD=1905000U
M$12 Y D1 VGND VNB nfet_01v8 L=150000U W=1300000U AS=182000000000P
+ AD=217750000000P PS=1860000U PD=1970000U
M$15 VGND B1 Y VNB nfet_01v8 L=150000U W=1300000U AS=232375000000P
+ AD=217750000000P PS=2015000U PD=1970000U
M$17 synth_1 A1 Y VNB nfet_01v8 L=150000U W=1300000U AS=182000000000P
+ AD=351000000000P PS=1860000U PD=3030000U
M$18 VGND A2 synth_1 VNB nfet_01v8 L=150000U W=1300000U AS=290875000000P
+ AD=203125000000P PS=2195000U PD=1925000U
.ENDS sky130_fd_sc_hd__a2111oi_2

.SUBCKT sky130_fd_sc_hd__o32ai_1 VPB A3 B1 A2 B2 A1 VPWR VGND Y VNB
M$1 synth_4 B1 VPWR VPB pfet_01v8_hvt L=150000U W=1000000U AS=260000000000P
+ AD=105000000000P PS=2520000U PD=1210000U
M$2 Y B2 synth_4 VPB pfet_01v8_hvt L=150000U W=1000000U AS=105000000000P
+ AD=305000000000P PS=1210000U PD=1610000U
M$3 synth_3 A3 Y VPB pfet_01v8_hvt L=150000U W=1000000U AS=305000000000P
+ AD=245000000000P PS=1610000U PD=1490000U
M$4 synth_2 A2 synth_3 VPB pfet_01v8_hvt L=150000U W=1000000U AS=245000000000P
+ AD=135000000000P PS=1490000U PD=1270000U
M$5 VPWR A1 synth_2 VPB pfet_01v8_hvt L=150000U W=1000000U AS=135000000000P
+ AD=280000000000P PS=1270000U PD=2560000U
M$6 Y B1 synth_1 VNB nfet_01v8 L=150000U W=650000U AS=169000000000P
+ AD=105625000000P PS=1820000U PD=975000U
M$7 synth_1 B2 Y VNB nfet_01v8 L=150000U W=650000U AS=105625000000P
+ AD=100750000000P PS=975000U PD=960000U
M$8 VGND A3 synth_1 VNB nfet_01v8 L=150000U W=650000U AS=100750000000P
+ AD=219375000000P PS=960000U PD=1325000U
M$9 synth_1 A2 VGND VNB nfet_01v8 L=150000U W=650000U AS=219375000000P
+ AD=87750000000P PS=1325000U PD=920000U
M$10 VGND A1 synth_1 VNB nfet_01v8 L=150000U W=650000U AS=87750000000P
+ AD=234000000000P PS=920000U PD=2020000U
.ENDS sky130_fd_sc_hd__o32ai_1

.SUBCKT sky130_fd_sc_hd__nor4_1 VPB D B A C VGND Y VPWR VNB
M$1 synth_2 D Y VPB pfet_01v8_hvt L=150000U W=1000000U AS=260000000000P
+ AD=130000000000P PS=2520000U PD=1260000U
M$2 synth_1 C synth_2 VPB pfet_01v8_hvt L=150000U W=1000000U AS=130000000000P
+ AD=190000000000P PS=1260000U PD=1380000U
M$3 synth_3 B synth_1 VPB pfet_01v8_hvt L=150000U W=1000000U AS=190000000000P
+ AD=135000000000P PS=1380000U PD=1270000U
M$4 VPWR A synth_3 VPB pfet_01v8_hvt L=150000U W=1000000U AS=135000000000P
+ AD=260000000000P PS=1270000U PD=2520000U
M$5 Y D VGND VNB nfet_01v8 L=150000U W=650000U AS=169000000000P
+ AD=118625000000P PS=1820000U PD=1015000U
M$6 VGND C Y VNB nfet_01v8 L=150000U W=650000U AS=118625000000P AD=89375000000P
+ PS=1015000U PD=925000U
M$7 Y B VGND VNB nfet_01v8 L=150000U W=650000U AS=89375000000P AD=87750000000P
+ PS=925000U PD=920000U
M$8 VGND A Y VNB nfet_01v8 L=150000U W=650000U AS=87750000000P AD=169000000000P
+ PS=920000U PD=1820000U
.ENDS sky130_fd_sc_hd__nor4_1

.SUBCKT sky130_fd_sc_hd__nand3b_1 VPB A_N C B Y VGND VPWR VNB
M$1 VPWR A_N synth_1 VPB pfet_01v8_hvt L=150000U W=420000U AS=109200000000P
+ AD=145750000000P PS=1360000U PD=1335000U
M$2 Y C VPWR VPB pfet_01v8_hvt L=150000U W=1000000U AS=145750000000P
+ AD=135000000000P PS=1335000U PD=1270000U
M$3 VPWR B Y VPB pfet_01v8_hvt L=150000U W=1000000U AS=135000000000P
+ AD=192500000000P PS=1270000U PD=1385000U
M$4 Y synth_1 VPWR VPB pfet_01v8_hvt L=150000U W=1000000U AS=192500000000P
+ AD=280000000000P PS=1385000U PD=2560000U
M$5 synth_1 A_N VGND VNB nfet_01v8 L=150000U W=420000U AS=100250000000P
+ AD=109200000000P PS=985000U PD=1360000U
M$6 synth_3 C VGND VNB nfet_01v8 L=150000U W=650000U AS=100250000000P
+ AD=87750000000P PS=985000U PD=920000U
M$7 synth_2 B synth_3 VNB nfet_01v8 L=150000U W=650000U AS=87750000000P
+ AD=125125000000P PS=920000U PD=1035000U
M$8 Y synth_1 synth_2 VNB nfet_01v8 L=150000U W=650000U AS=125125000000P
+ AD=182000000000P PS=1035000U PD=1860000U
.ENDS sky130_fd_sc_hd__nand3b_1

.SUBCKT sky130_fd_sc_hd__o311a_1 VGND X A1 A2 A3 B1 C1 VPWR VPB VNB
M$1 VPWR synth_2 X VPB pfet_01v8_hvt L=150000U W=1000000U AS=260000000000P
+ AD=312500000000P PS=2520000U PD=1625000U
M$2 synth_4 A1 VPWR VPB pfet_01v8_hvt L=150000U W=1000000U AS=312500000000P
+ AD=180000000000P PS=1625000U PD=1360000U
M$3 synth_5 A2 synth_4 VPB pfet_01v8_hvt L=150000U W=1000000U AS=180000000000P
+ AD=210000000000P PS=1360000U PD=1420000U
M$4 synth_2 A3 synth_5 VPB pfet_01v8_hvt L=150000U W=1000000U AS=210000000000P
+ AD=137500000000P PS=1420000U PD=1275000U
M$5 VPWR B1 synth_2 VPB pfet_01v8_hvt L=150000U W=1000000U AS=137500000000P
+ AD=150000000000P PS=1275000U PD=1300000U
M$6 synth_2 C1 VPWR VPB pfet_01v8_hvt L=150000U W=1000000U AS=150000000000P
+ AD=260000000000P PS=1300000U PD=2520000U
M$7 VGND synth_2 X VNB nfet_01v8 L=150000U W=650000U AS=169000000000P
+ AD=203125000000P PS=1820000U PD=1275000U
M$8 synth_1 A1 VGND VNB nfet_01v8 L=150000U W=650000U AS=203125000000P
+ AD=117000000000P PS=1275000U PD=1010000U
M$9 VGND A2 synth_1 VNB nfet_01v8 L=150000U W=650000U AS=117000000000P
+ AD=136500000000P PS=1010000U PD=1070000U
M$10 synth_1 A3 VGND VNB nfet_01v8 L=150000U W=650000U AS=136500000000P
+ AD=118625000000P PS=1070000U PD=1015000U
M$11 synth_3 B1 synth_1 VNB nfet_01v8 L=150000U W=650000U AS=118625000000P
+ AD=68250000000P PS=1015000U PD=860000U
M$12 synth_2 C1 synth_3 VNB nfet_01v8 L=150000U W=650000U AS=68250000000P
+ AD=169000000000P PS=860000U PD=1820000U
.ENDS sky130_fd_sc_hd__o311a_1

.SUBCKT sky130_fd_sc_hd__o211ai_1 VPB A1 A2 B1 C1 Y VPWR VGND VNB
M$1 synth_2 A1 VPWR VPB pfet_01v8_hvt L=150000U W=1000000U AS=265000000000P
+ AD=105000000000P PS=2530000U PD=1210000U
M$2 Y A2 synth_2 VPB pfet_01v8_hvt L=150000U W=1000000U AS=105000000000P
+ AD=195000000000P PS=1210000U PD=1390000U
M$3 VPWR B1 Y VPB pfet_01v8_hvt L=150000U W=1000000U AS=195000000000P
+ AD=195000000000P PS=1390000U PD=1390000U
M$4 Y C1 VPWR VPB pfet_01v8_hvt L=150000U W=1000000U AS=195000000000P
+ AD=635000000000P PS=1390000U PD=3270000U
M$5 VGND A1 synth_1 VNB nfet_01v8 L=150000U W=650000U AS=172250000000P
+ AD=126750000000P PS=1830000U PD=1040000U
M$6 synth_1 A2 VGND VNB nfet_01v8 L=150000U W=650000U AS=126750000000P
+ AD=126750000000P PS=1040000U PD=1040000U
M$7 synth_3 B1 synth_1 VNB nfet_01v8 L=150000U W=650000U AS=126750000000P
+ AD=68250000000P PS=1040000U PD=860000U
M$8 Y C1 synth_3 VNB nfet_01v8 L=150000U W=650000U AS=68250000000P
+ AD=393250000000P PS=860000U PD=2510000U
.ENDS sky130_fd_sc_hd__o211ai_1

.SUBCKT sky130_fd_sc_hd__nor3_1 VPB A B C Y VGND VPWR VNB
M$1 synth_2 C Y VPB pfet_01v8_hvt L=150000U W=1000000U AS=260000000000P
+ AD=135000000000P PS=2520000U PD=1270000U
M$2 synth_1 B synth_2 VPB pfet_01v8_hvt L=150000U W=1000000U AS=135000000000P
+ AD=135000000000P PS=1270000U PD=1270000U
M$3 VPWR A synth_1 VPB pfet_01v8_hvt L=150000U W=1000000U AS=135000000000P
+ AD=260000000000P PS=1270000U PD=2520000U
M$4 VGND C Y VNB nfet_01v8 L=150000U W=650000U AS=169000000000P AD=87750000000P
+ PS=1820000U PD=920000U
M$5 Y B VGND VNB nfet_01v8 L=150000U W=650000U AS=87750000000P AD=87750000000P
+ PS=920000U PD=920000U
M$6 VGND A Y VNB nfet_01v8 L=150000U W=650000U AS=87750000000P AD=169000000000P
+ PS=920000U PD=1820000U
.ENDS sky130_fd_sc_hd__nor3_1

.SUBCKT sky130_fd_sc_hd__clkinv_1 VPB A VPWR VGND Y VNB
M$1 Y A VPWR VPB pfet_01v8_hvt L=150000U W=1680000U AS=331800000000P
+ AD=348600000000P PS=3310000U PD=3350000U
M$3 VGND A Y VNB nfet_01v8 L=150000U W=420000U AS=109200000000P
+ AD=119700000000P PS=1360000U PD=1410000U
.ENDS sky130_fd_sc_hd__clkinv_1

.SUBCKT sky130_fd_sc_hd__or3_1 VPB A B C X VPWR VGND VNB
M$1 synth_3 C synth_1 VPB pfet_01v8_hvt L=150000U W=420000U AS=109200000000P
+ AD=44100000000P PS=1360000U PD=630000U
M$2 synth_2 B synth_3 VPB pfet_01v8_hvt L=150000U W=420000U AS=44100000000P
+ AD=69300000000P PS=630000U PD=750000U
M$3 VPWR A synth_2 VPB pfet_01v8_hvt L=150000U W=420000U AS=69300000000P
+ AD=148250000000P PS=750000U PD=1340000U
M$4 X synth_1 VPWR VPB pfet_01v8_hvt L=150000U W=1000000U AS=148250000000P
+ AD=280000000000P PS=1340000U PD=2560000U
M$5 VGND C synth_1 VNB nfet_01v8 L=150000U W=420000U AS=109200000000P
+ AD=56700000000P PS=1360000U PD=690000U
M$6 synth_1 B VGND VNB nfet_01v8 L=150000U W=420000U AS=56700000000P
+ AD=56700000000P PS=690000U PD=690000U
M$7 synth_1 A VGND VNB nfet_01v8 L=150000U W=420000U AS=101875000000P
+ AD=56700000000P PS=990000U PD=690000U
M$8 X synth_1 VGND VNB nfet_01v8 L=150000U W=650000U AS=101875000000P
+ AD=182000000000P PS=990000U PD=1860000U
.ENDS sky130_fd_sc_hd__or3_1

.SUBCKT sky130_fd_sc_hd__nand3_1 VPB A B C Y VPWR VGND VNB
M$1 Y C VPWR VPB pfet_01v8_hvt L=150000U W=1000000U AS=260000000000P
+ AD=135000000000P PS=2520000U PD=1270000U
M$2 VPWR B Y VPB pfet_01v8_hvt L=150000U W=1000000U AS=135000000000P
+ AD=165000000000P PS=1270000U PD=1330000U
M$3 Y A VPWR VPB pfet_01v8_hvt L=150000U W=1000000U AS=165000000000P
+ AD=260000000000P PS=1330000U PD=2520000U
M$4 synth_2 C VGND VNB nfet_01v8 L=150000U W=650000U AS=169000000000P
+ AD=87750000000P PS=1820000U PD=920000U
M$5 synth_1 B synth_2 VNB nfet_01v8 L=150000U W=650000U AS=87750000000P
+ AD=107250000000P PS=920000U PD=980000U
M$6 Y A synth_1 VNB nfet_01v8 L=150000U W=650000U AS=107250000000P
+ AD=169000000000P PS=980000U PD=1820000U
.ENDS sky130_fd_sc_hd__nand3_1

.SUBCKT sky130_fd_sc_hd__o22ai_1 VPB B1 B2 A2 A1 Y VGND VPWR VNB
M$1 synth_3 B1 VPWR VPB pfet_01v8_hvt L=150000U W=1000000U AS=260000000000P
+ AD=112500000000P PS=2520000U PD=1225000U
M$2 Y B2 synth_3 VPB pfet_01v8_hvt L=150000U W=1000000U AS=112500000000P
+ AD=232500000000P PS=1225000U PD=1465000U
M$3 synth_2 A2 Y VPB pfet_01v8_hvt L=150000U W=1000000U AS=232500000000P
+ AD=105000000000P PS=1465000U PD=1210000U
M$4 VPWR A1 synth_2 VPB pfet_01v8_hvt L=150000U W=1000000U AS=105000000000P
+ AD=270000000000P PS=1210000U PD=2540000U
M$5 Y B1 synth_1 VNB nfet_01v8 L=150000U W=650000U AS=169000000000P
+ AD=92625000000P PS=1820000U PD=935000U
M$6 synth_1 B2 Y VNB nfet_01v8 L=150000U W=650000U AS=92625000000P
+ AD=115375000000P PS=935000U PD=1005000U
M$7 VGND A2 synth_1 VNB nfet_01v8 L=150000U W=650000U AS=115375000000P
+ AD=87750000000P PS=1005000U PD=920000U
M$8 synth_1 A1 VGND VNB nfet_01v8 L=150000U W=650000U AS=87750000000P
+ AD=169000000000P PS=920000U PD=1820000U
.ENDS sky130_fd_sc_hd__o22ai_1

.SUBCKT sky130_fd_sc_hd__a31oi_1 VPB A3 A2 A1 B1 VGND VPWR Y VNB
M$1 synth_1 A3 VPWR VPB pfet_01v8_hvt L=150000U W=1000000U AS=260000000000P
+ AD=135000000000P PS=2520000U PD=1270000U
M$2 VPWR A2 synth_1 VPB pfet_01v8_hvt L=150000U W=1000000U AS=135000000000P
+ AD=152500000000P PS=1270000U PD=1305000U
M$3 synth_1 A1 VPWR VPB pfet_01v8_hvt L=150000U W=1000000U AS=152500000000P
+ AD=162500000000P PS=1305000U PD=1325000U
M$4 Y B1 synth_1 VPB pfet_01v8_hvt L=150000U W=1000000U AS=162500000000P
+ AD=270000000000P PS=1325000U PD=2540000U
M$5 synth_3 A3 VGND VNB nfet_01v8 L=150000U W=650000U AS=169000000000P
+ AD=68250000000P PS=1820000U PD=860000U
M$6 synth_2 A2 synth_3 VNB nfet_01v8 L=150000U W=650000U AS=68250000000P
+ AD=118625000000P PS=860000U PD=1015000U
M$7 Y A1 synth_2 VNB nfet_01v8 L=150000U W=650000U AS=118625000000P
+ AD=105625000000P PS=1015000U PD=975000U
M$8 VGND B1 Y VNB nfet_01v8 L=150000U W=650000U AS=105625000000P
+ AD=175500000000P PS=975000U PD=1840000U
.ENDS sky130_fd_sc_hd__a31oi_1

.SUBCKT sky130_fd_sc_hd__a21oi_1 VPB B1 A1 A2 VGND VPWR Y VNB
M$1 synth_1 B1 Y VPB pfet_01v8_hvt L=150000U W=1000000U AS=265000000000P
+ AD=140000000000P PS=2530000U PD=1280000U
M$2 VPWR A1 synth_1 VPB pfet_01v8_hvt L=150000U W=1000000U AS=140000000000P
+ AD=147500000000P PS=1280000U PD=1295000U
M$3 synth_1 A2 VPWR VPB pfet_01v8_hvt L=150000U W=1000000U AS=147500000000P
+ AD=265000000000P PS=1295000U PD=2530000U
M$4 Y B1 VGND VNB nfet_01v8 L=150000U W=650000U AS=172250000000P
+ AD=91000000000P PS=1830000U PD=930000U
M$5 synth_2 A1 Y VNB nfet_01v8 L=150000U W=650000U AS=91000000000P
+ AD=95875000000P PS=930000U PD=945000U
M$6 VGND A2 synth_2 VNB nfet_01v8 L=150000U W=650000U AS=95875000000P
+ AD=172250000000P PS=945000U PD=1830000U
.ENDS sky130_fd_sc_hd__a21oi_1

.SUBCKT sky130_fd_sc_hd__o21ai_0 VPB A1 A2 B1 VPWR Y VGND VNB
M$1 synth_2 A1 VPWR VPB pfet_01v8_hvt L=150000U W=640000U AS=169600000000P
+ AD=76800000000P PS=1810000U PD=880000U
M$2 Y A2 synth_2 VPB pfet_01v8_hvt L=150000U W=640000U AS=76800000000P
+ AD=89600000000P PS=880000U PD=920000U
M$3 VPWR B1 Y VPB pfet_01v8_hvt L=150000U W=640000U AS=89600000000P
+ AD=182400000000P PS=920000U PD=1850000U
M$4 VGND A1 synth_1 VNB nfet_01v8 L=150000U W=420000U AS=111300000000P
+ AD=58800000000P PS=1370000U PD=700000U
M$5 synth_1 A2 VGND VNB nfet_01v8 L=150000U W=420000U AS=58800000000P
+ AD=58800000000P PS=700000U PD=700000U
M$6 Y B1 synth_1 VNB nfet_01v8 L=150000U W=420000U AS=58800000000P
+ AD=111300000000P PS=700000U PD=1370000U
.ENDS sky130_fd_sc_hd__o21ai_0

.SUBCKT sky130_fd_sc_hd__nand2_1 VPB A B Y VPWR VGND VNB
M$1 Y B VPWR VPB pfet_01v8_hvt L=150000U W=1000000U AS=260000000000P
+ AD=135000000000P PS=2520000U PD=1270000U
M$2 VPWR A Y VPB pfet_01v8_hvt L=150000U W=1000000U AS=135000000000P
+ AD=260000000000P PS=1270000U PD=2520000U
M$3 synth_1 B VGND VNB nfet_01v8 L=150000U W=650000U AS=169000000000P
+ AD=87750000000P PS=1820000U PD=920000U
M$4 Y A synth_1 VNB nfet_01v8 L=150000U W=650000U AS=87750000000P
+ AD=169000000000P PS=920000U PD=1820000U
.ENDS sky130_fd_sc_hd__nand2_1

.SUBCKT sky130_fd_sc_hd__nor2_1 VPB A B Y VGND VPWR VNB
M$1 synth_1 B Y VPB pfet_01v8_hvt L=150000U W=1000000U AS=260000000000P
+ AD=105000000000P PS=2520000U PD=1210000U
M$2 VPWR A synth_1 VPB pfet_01v8_hvt L=150000U W=1000000U AS=105000000000P
+ AD=260000000000P PS=1210000U PD=2520000U
M$3 Y B VGND VNB nfet_01v8 L=150000U W=650000U AS=169000000000P AD=87750000000P
+ PS=1820000U PD=920000U
M$4 VGND A Y VNB nfet_01v8 L=150000U W=650000U AS=87750000000P AD=169000000000P
+ PS=920000U PD=1820000U
.ENDS sky130_fd_sc_hd__nor2_1

.SUBCKT sky130_fd_sc_hd__nand2b_1 VPB B A_N Y VGND VPWR VNB
M$1 VPWR A_N synth_1 VPB pfet_01v8_hvt L=150000U W=420000U AS=109200000000P
+ AD=145750000000P PS=1360000U PD=1335000U
M$2 Y B VPWR VPB pfet_01v8_hvt L=150000U W=1000000U AS=145750000000P
+ AD=135000000000P PS=1335000U PD=1270000U
M$3 VPWR synth_1 Y VPB pfet_01v8_hvt L=150000U W=1000000U AS=135000000000P
+ AD=265000000000P PS=1270000U PD=2530000U
M$4 synth_1 A_N VGND VNB nfet_01v8 L=150000U W=420000U AS=100250000000P
+ AD=109200000000P PS=985000U PD=1360000U
M$5 synth_2 B VGND VNB nfet_01v8 L=150000U W=650000U AS=100250000000P
+ AD=87750000000P PS=985000U PD=920000U
M$6 Y synth_1 synth_2 VNB nfet_01v8 L=150000U W=650000U AS=87750000000P
+ AD=169000000000P PS=920000U PD=1820000U
.ENDS sky130_fd_sc_hd__nand2b_1

.SUBCKT sky130_fd_sc_hd__inv_1 VPB A VPWR VGND Y VNB
M$1 Y A VPWR VPB pfet_01v8_hvt L=150000U W=1000000U AS=260000000000P
+ AD=260000000000P PS=2520000U PD=2520000U
M$2 Y A VGND VNB nfet_01v8 L=150000U W=650000U AS=169000000000P
+ AD=169000000000P PS=1820000U PD=1820000U
.ENDS sky130_fd_sc_hd__inv_1
