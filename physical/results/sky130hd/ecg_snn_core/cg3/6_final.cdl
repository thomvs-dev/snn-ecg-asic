* CDL Netlist generated by OpenROAD

*.BUSDELIMITER [

.SUBCKT ecg_snn_core busy clk done inference_cycles[0] inference_cycles[10]
+ inference_cycles[11] inference_cycles[12] inference_cycles[13]
+ inference_cycles[14] inference_cycles[15] inference_cycles[1]
+ inference_cycles[2] inference_cycles[3] inference_cycles[4]
+ inference_cycles[5] inference_cycles[6] inference_cycles[7]
+ inference_cycles[8] inference_cycles[9] input_complete load_data[0]
+ load_data[1] load_data[2] load_data[3] load_ready load_valid
+ no_spike reset result_class[0] result_class[1] start VDD VSS
X_09691_ network.neuron_hid0.IF0.ref_counter\[0\] VSS VSS
+ VDD VDD _00677_ sky130_fd_sc_hd__inv_1
X_09692_ network.neuron_hid1.IF0.ref_counter\[0\] VSS VSS
+ VDD VDD _01014_ sky130_fd_sc_hd__inv_1
X_09693_ network.neuron_hid2.IF0.ref_counter\[0\] VSS VSS
+ VDD VDD _00783_ sky130_fd_sc_hd__inv_1
X_09694_ network.neuron_hid3.IF0.ref_counter\[0\] VSS VSS
+ VDD VDD _00878_ sky130_fd_sc_hd__inv_1
X_09695_ network.neuron_hid4.IF0.ref_counter\[0\] VSS VSS
+ VDD VDD _01132_ sky130_fd_sc_hd__inv_1
X_09696_ network.neuron_hid5.IF0.ref_counter\[0\] VSS VSS
+ VDD VDD _00915_ sky130_fd_sc_hd__inv_1
X_09697_ network.neuron_hid6.IF0.ref_counter\[0\] VSS VSS
+ VDD VDD _00732_ sky130_fd_sc_hd__inv_1
X_09698_ network.neuron_hid7.IF0.ref_counter\[0\] VSS VSS
+ VDD VDD _01124_ sky130_fd_sc_hd__inv_1
X_09699_ network.arbit.counter\[0\] VSS VSS VDD VDD _00115_
+ sky130_fd_sc_hd__inv_1
X_09700_ network.neuron_in173.counter\[1\] VSS VSS VDD VDD
+ _00187_ sky130_fd_sc_hd__inv_1
Xclkload66 clknet_leaf_137_clk_net VSS VSS VDD VDD _unconnected_0
+ sky130_fd_sc_hd__clkbuf_16
Xclkload65 clknet_leaf_135_clk_net VSS VSS VDD VDD _unconnected_1
+ sky130_fd_sc_hd__clkinv_1
X_09703_ state\[0\] state\[1\] VSS VSS VDD VDD _06611_ sky130_fd_sc_hd__nand2b_1
X_09704_ net23 _06611_ VSS VSS VDD VDD _06612_ sky130_fd_sc_hd__nor2_1
Xclkload64 clknet_leaf_134_clk_net VSS VSS VDD VDD _unconnected_2
+ sky130_fd_sc_hd__clkbuf_8
Xclkload63 clknet_leaf_133_clk_net VSS VSS VDD VDD _unconnected_3
+ sky130_fd_sc_hd__clkinv_2
Xclkload62 clknet_leaf_132_clk_net VSS VSS VDD VDD _unconnected_4
+ sky130_fd_sc_hd__clkbuf_1
X_09708_ network.neuron_in159.counter\[2\] VSS VSS VDD VDD
+ _06616_ sky130_fd_sc_hd__inv_1
X_09709_ _06616_ _00639_ VSS VSS VDD VDD _06617_ sky130_fd_sc_hd__nand2_1
X_09710_ network.neuron_in159.counter\[3\] _06617_ VSS VSS
+ VDD VDD _06618_ sky130_fd_sc_hd__or2_2
X_09711_ net381 _06618_ VSS VSS VDD VDD _06619_ sky130_fd_sc_hd__nand2_1
X_09712_ network.in_period\[159\]\[1\] _06619_ VSS VSS VDD
+ VDD _06620_ sky130_fd_sc_hd__nand2_1
X_09713_ _00640_ _06619_ _06620_ VSS VSS VDD VDD _02700_ sky130_fd_sc_hd__o21ai_0
X_09714_ network.neuron_in077.counter\[0\] VSS VSS VDD VDD
+ _00102_ sky130_fd_sc_hd__inv_1
X_09715_ network.neuron_in109.counter\[1\] VSS VSS VDD VDD
+ _00552_ sky130_fd_sc_hd__inv_1
Xclkload61 clknet_leaf_131_clk_net VSS VSS VDD VDD _unconnected_5
+ sky130_fd_sc_hd__clkinv_2
Xclkload60 clknet_leaf_129_clk_net VSS VSS VDD VDD _unconnected_6
+ sky130_fd_sc_hd__clkbuf_1
Xclkload59 clknet_leaf_150_clk_net VSS VSS VDD VDD _unconnected_7
+ sky130_fd_sc_hd__clkinv_2
X_09719_ _01087_ network.neuron_in160.counter\[2\] VSS VSS
+ VDD VDD _06624_ sky130_fd_sc_hd__nand2b_1
X_09720_ network.neuron_in160.counter\[2\] _01087_ VSS VSS
+ VDD VDD _06625_ sky130_fd_sc_hd__nand2b_1
Xclkload58 clknet_leaf_148_clk_net VSS VSS VDD VDD _unconnected_8
+ sky130_fd_sc_hd__clkbuf_1
X_09722_ network.neuron_in160.counter\[3\] _01087_ VSS VSS
+ VDD VDD _06627_ sky130_fd_sc_hd__nand2b_1
X_09723_ net380 _06627_ network.in_period\[160\]\[2\] VSS
+ VSS VDD VDD _06628_ sky130_fd_sc_hd__a21oi_1
X_09724_ net380 _06624_ _06625_ _06628_ VSS VSS VDD VDD _02705_
+ sky130_fd_sc_hd__a31oi_1
X_09725_ network.neuron_in077.counter\[1\] VSS VSS VDD VDD
+ _00103_ sky130_fd_sc_hd__inv_1
X_09726_ network.neuron_in160.counter\[2\] _06627_ VSS VSS
+ VDD VDD _06629_ sky130_fd_sc_hd__or2_2
X_09727_ net380 _06629_ VSS VSS VDD VDD _06630_ sky130_fd_sc_hd__nand2_1
X_09728_ network.in_period\[160\]\[1\] _06630_ VSS VSS VDD
+ VDD _06631_ sky130_fd_sc_hd__nand2_1
X_09729_ _01088_ _06630_ _06631_ VSS VSS VDD VDD _02704_ sky130_fd_sc_hd__o21ai_0
X_09730_ network.neuron_in161.counter\[3\] _00777_ VSS VSS
+ VDD VDD _06632_ sky130_fd_sc_hd__nand2b_1
X_09731_ network.neuron_in161.counter\[2\] _06632_ VSS VSS
+ VDD VDD _06633_ sky130_fd_sc_hd__or2_2
X_09732_ net379 _06633_ VSS VSS VDD VDD _06634_ sky130_fd_sc_hd__nand2_1
X_09733_ network.in_period\[161\]\[1\] _06634_ VSS VSS VDD
+ VDD _06635_ sky130_fd_sc_hd__nand2_1
X_09734_ _00778_ _06634_ _06635_ VSS VSS VDD VDD _02708_ sky130_fd_sc_hd__o21ai_0
X_09735_ network.neuron_in239.counter\[1\] VSS VSS VDD VDD
+ _00510_ sky130_fd_sc_hd__inv_1
X_09736_ network.neuron_in150.counter\[0\] VSS VSS VDD VDD
+ _00517_ sky130_fd_sc_hd__inv_1
X_09737_ network.neuron_in040.counter\[1\] VSS VSS VDD VDD
+ _00322_ sky130_fd_sc_hd__inv_1
X_09738_ network.neuron_in161.counter\[0\] VSS VSS VDD VDD
+ _00775_ sky130_fd_sc_hd__inv_1
X_09739_ net749 _06634_ VSS VSS VDD VDD _06636_ sky130_fd_sc_hd__nand2_1
X_09740_ network.neuron_in161.counter\[0\] _06634_ _06636_
+ VSS VSS VDD VDD _02707_ sky130_fd_sc_hd__o21ai_0
X_09741_ network.neuron_in162.counter\[3\] _00793_ VSS VSS
+ VDD VDD _06637_ sky130_fd_sc_hd__nand2b_1
X_09742_ network.neuron_in162.counter\[2\] _06637_ VSS VSS
+ VDD VDD _06638_ sky130_fd_sc_hd__or2_2
X_09743_ net378 _06638_ VSS VSS VDD VDD _06639_ sky130_fd_sc_hd__nand2_1
X_09744_ net785 _06639_ VSS VSS VDD VDD _06640_ sky130_fd_sc_hd__nand2_1
X_09745_ _00794_ _06639_ _06640_ VSS VSS VDD VDD _02712_ sky130_fd_sc_hd__o21ai_0
Xclkload57 clknet_leaf_147_clk_net VSS VSS VDD VDD _unconnected_9
+ sky130_fd_sc_hd__clkinv_1
Xclkload56 clknet_leaf_146_clk_net VSS VSS VDD VDD _unconnected_10
+ sky130_fd_sc_hd__clkinv_2
X_09748_ network.neuron_in189.counter\[2\] _00976_ VSS VSS
+ VDD VDD _06643_ sky130_fd_sc_hd__xnor2_1
X_09749_ state\[1\] VSS VSS VDD VDD _06644_ sky130_fd_sc_hd__inv_1
X_09750_ _06644_ state\[0\] net23 VSS VSS VDD VDD _06645_
+ sky130_fd_sc_hd__or3_2
Xclkload55 clknet_leaf_22_clk_net VSS VSS VDD VDD _unconnected_11
+ sky130_fd_sc_hd__clkbuf_1
Xclkload54 clknet_leaf_21_clk_net VSS VSS VDD VDD _unconnected_12
+ sky130_fd_sc_hd__clkbuf_8
Xclkload53 clknet_leaf_20_clk_net VSS VSS VDD VDD _unconnected_13
+ sky130_fd_sc_hd__clkbuf_1
Xclkload52 clknet_leaf_19_clk_net VSS VSS VDD VDD _unconnected_14
+ sky130_fd_sc_hd__clkinv_2
X_09755_ network.neuron_in189.counter\[2\] network.neuron_in189.counter\[3\]
+ VSS VSS VDD VDD _06650_ sky130_fd_sc_hd__nor2_1
X_09756_ net362 _06650_ VSS VSS VDD VDD _06651_ sky130_fd_sc_hd__nor2_1
X_09757_ network.in_period\[189\]\[2\] _06651_ VSS VSS VDD
+ VDD _06652_ sky130_fd_sc_hd__nor2_1
X_09758_ net366 _06643_ _06652_ VSS VSS VDD VDD _02821_ sky130_fd_sc_hd__a21oi_1
X_09759_ network.neuron_in184.counter\[2\] _00984_ VSS VSS
+ VDD VDD _06653_ sky130_fd_sc_hd__xnor2_1
X_09760_ network.neuron_in184.counter\[2\] network.neuron_in184.counter\[3\]
+ VSS VSS VDD VDD _06654_ sky130_fd_sc_hd__nor2_1
X_09761_ net361 _06654_ VSS VSS VDD VDD _06655_ sky130_fd_sc_hd__nor2_1
X_09762_ network.in_period\[184\]\[2\] _06655_ VSS VSS VDD
+ VDD _06656_ sky130_fd_sc_hd__nor2_1
X_09763_ net379 _06653_ _06656_ VSS VSS VDD VDD _02801_ sky130_fd_sc_hd__a21oi_1
X_09764_ network.neuron_in188.counter\[0\] VSS VSS VDD VDD
+ _00229_ sky130_fd_sc_hd__inv_1
X_09765_ network.neuron_in188.counter\[3\] _00231_ VSS VSS
+ VDD VDD _06657_ sky130_fd_sc_hd__nand2b_1
X_09766_ network.neuron_in188.counter\[2\] _06657_ VSS VSS
+ VDD VDD _06658_ sky130_fd_sc_hd__or2_2
X_09767_ net366 _06658_ VSS VSS VDD VDD _06659_ sky130_fd_sc_hd__nand2_1
X_09768_ net794 _06659_ VSS VSS VDD VDD _06660_ sky130_fd_sc_hd__nand2_1
X_09769_ network.neuron_in188.counter\[0\] _06659_ _06660_
+ VSS VSS VDD VDD _02815_ sky130_fd_sc_hd__o21ai_0
X_09770_ network.neuron_in142.counter\[0\] VSS VSS VDD VDD
+ _00555_ sky130_fd_sc_hd__inv_1
X_09771_ network.neuron_in181.counter\[3\] _00847_ VSS VSS
+ VDD VDD _06661_ sky130_fd_sc_hd__nand2b_1
X_09772_ network.neuron_in181.counter\[2\] _06661_ VSS VSS
+ VDD VDD _06662_ sky130_fd_sc_hd__or2_2
X_09773_ net365 _06662_ VSS VSS VDD VDD _06663_ sky130_fd_sc_hd__nand2_1
X_09774_ net713 _06663_ VSS VSS VDD VDD _06664_ sky130_fd_sc_hd__nand2_1
X_09775_ _00848_ _06663_ _06664_ VSS VSS VDD VDD _02788_ sky130_fd_sc_hd__o21ai_0
X_09776_ network.neuron_in183.counter\[0\] VSS VSS VDD VDD
+ _01138_ sky130_fd_sc_hd__inv_1
X_09777_ network.neuron_in183.counter\[3\] _01140_ VSS VSS
+ VDD VDD _06665_ sky130_fd_sc_hd__nand2b_1
X_09778_ network.neuron_in183.counter\[2\] VSS VSS VDD VDD
+ _06666_ sky130_fd_sc_hd__inv_1
X_09779_ _06665_ _06666_ VSS VSS VDD VDD _06667_ sky130_fd_sc_hd__nand2b_1
X_09780_ net379 _06667_ VSS VSS VDD VDD _06668_ sky130_fd_sc_hd__nand2_1
X_09781_ net700 _06668_ VSS VSS VDD VDD _06669_ sky130_fd_sc_hd__nand2_1
X_09782_ network.neuron_in183.counter\[0\] _06668_ _06669_
+ VSS VSS VDD VDD _02795_ sky130_fd_sc_hd__o21ai_0
Xclkload51 clknet_leaf_18_clk_net VSS VSS VDD VDD _unconnected_15
+ sky130_fd_sc_hd__clkinv_2
Xclkload50 clknet_leaf_17_clk_net VSS VSS VDD VDD _unconnected_16
+ sky130_fd_sc_hd__clkbuf_8
X_09785_ network.neuron_in186.counter\[2\] network.neuron_in186.counter\[3\]
+ VSS VSS VDD VDD _06672_ sky130_fd_sc_hd__nor2_1
X_09786_ _00767_ _06672_ VSS VSS VDD VDD _06673_ sky130_fd_sc_hd__nand2_1
X_09787_ net379 _06673_ VSS VSS VDD VDD _06674_ sky130_fd_sc_hd__nand2_1
X_09788_ net722 _06674_ VSS VSS VDD VDD _06675_ sky130_fd_sc_hd__nand2_1
X_09789_ _00768_ _06674_ _06675_ VSS VSS VDD VDD _02808_ sky130_fd_sc_hd__o21ai_0
X_09790_ network.neuron_in186.counter\[0\] VSS VSS VDD VDD
+ _00765_ sky130_fd_sc_hd__inv_1
X_09791_ network.neuron_in219.counter\[0\] VSS VSS VDD VDD
+ _00313_ sky130_fd_sc_hd__inv_1
X_09792_ network.neuron_in076.counter\[1\] VSS VSS VDD VDD
+ _00112_ sky130_fd_sc_hd__inv_1
X_09793_ net682 _06659_ VSS VSS VDD VDD _06676_ sky130_fd_sc_hd__nand2_1
X_09794_ _00232_ _06659_ _06676_ VSS VSS VDD VDD _02816_ sky130_fd_sc_hd__o21ai_0
X_09795_ network.neuron_in180.counter\[2\] _00851_ VSS VSS
+ VDD VDD _06677_ sky130_fd_sc_hd__xnor2_1
X_09796_ network.neuron_in180.counter\[2\] network.neuron_in180.counter\[3\]
+ VSS VSS VDD VDD _06678_ sky130_fd_sc_hd__nor2_1
X_09797_ net363 _06678_ VSS VSS VDD VDD _06679_ sky130_fd_sc_hd__nor2_1
X_09798_ network.in_period\[180\]\[2\] _06679_ VSS VSS VDD
+ VDD _06680_ sky130_fd_sc_hd__nor2_1
X_09799_ net365 _06677_ _06680_ VSS VSS VDD VDD _02785_ sky130_fd_sc_hd__a21oi_1
X_09800_ network.neuron_in114.counter\[0\] VSS VSS VDD VDD
+ _00077_ sky130_fd_sc_hd__inv_1
X_09801_ network.neuron_in160.counter\[0\] VSS VSS VDD VDD
+ _01085_ sky130_fd_sc_hd__inv_1
X_09802_ network.neuron_in136.counter\[2\] VSS VSS VDD VDD
+ _06681_ sky130_fd_sc_hd__inv_1
X_09803_ _06681_ _01115_ VSS VSS VDD VDD _06682_ sky130_fd_sc_hd__nand2_1
X_09804_ network.neuron_in136.counter\[3\] _06682_ VSS VSS
+ VDD VDD _06683_ sky130_fd_sc_hd__or2_2
X_09805_ net384 _06683_ VSS VSS VDD VDD _06684_ sky130_fd_sc_hd__nand2_1
X_09806_ net706 _06684_ VSS VSS VDD VDD _06685_ sky130_fd_sc_hd__nand2_1
X_09807_ _01116_ _06684_ _06685_ VSS VSS VDD VDD _02608_ sky130_fd_sc_hd__o21ai_0
X_09808_ network.neuron_in181.counter\[2\] _00847_ VSS VSS
+ VDD VDD _06686_ sky130_fd_sc_hd__xnor2_1
X_09809_ network.neuron_in181.counter\[2\] network.neuron_in181.counter\[3\]
+ VSS VSS VDD VDD _06687_ sky130_fd_sc_hd__nor2_1
X_09810_ net363 _06687_ VSS VSS VDD VDD _06688_ sky130_fd_sc_hd__nor2_1
X_09811_ network.in_period\[181\]\[2\] _06688_ VSS VSS VDD
+ VDD _06689_ sky130_fd_sc_hd__nor2_1
X_09812_ net365 _06686_ _06689_ VSS VSS VDD VDD _02789_ sky130_fd_sc_hd__a21oi_1
X_09813_ network.neuron_in182.counter\[3\] _00839_ VSS VSS
+ VDD VDD _06690_ sky130_fd_sc_hd__nand2b_1
X_09814_ network.neuron_in182.counter\[2\] _06690_ VSS VSS
+ VDD VDD _06691_ sky130_fd_sc_hd__or2_2
X_09815_ net366 _06691_ VSS VSS VDD VDD _06692_ sky130_fd_sc_hd__nand2_1
X_09816_ net652 _06692_ VSS VSS VDD VDD _06693_ sky130_fd_sc_hd__nand2_1
X_09817_ _00840_ _06692_ _06693_ VSS VSS VDD VDD _02792_ sky130_fd_sc_hd__o21ai_0
X_09818_ net645 _06668_ VSS VSS VDD VDD _06694_ sky130_fd_sc_hd__nand2_1
X_09819_ _01141_ _06668_ _06694_ VSS VSS VDD VDD _02796_ sky130_fd_sc_hd__o21ai_0
X_09820_ network.neuron_in019.counter\[0\] VSS VSS VDD VDD
+ _00413_ sky130_fd_sc_hd__inv_1
X_09821_ network.neuron_in112.counter\[1\] VSS VSS VDD VDD
+ _00746_ sky130_fd_sc_hd__inv_1
X_09822_ network.neuron_in075.counter\[1\] VSS VSS VDD VDD
+ _00124_ sky130_fd_sc_hd__inv_1
X_09823_ network.neuron_in185.counter\[2\] _00763_ VSS VSS
+ VDD VDD _06695_ sky130_fd_sc_hd__xnor2_1
X_09824_ network.neuron_in185.counter\[2\] network.neuron_in185.counter\[3\]
+ VSS VSS VDD VDD _06696_ sky130_fd_sc_hd__nor2_1
X_09825_ net361 _06696_ VSS VSS VDD VDD _06697_ sky130_fd_sc_hd__nor2_1
X_09826_ network.in_period\[185\]\[2\] _06697_ VSS VSS VDD
+ VDD _06698_ sky130_fd_sc_hd__nor2_1
X_09827_ net379 _06695_ _06698_ VSS VSS VDD VDD _02805_ sky130_fd_sc_hd__a21oi_1
Xclkload49 clknet_leaf_16_clk_net VSS VSS VDD VDD _unconnected_17
+ sky130_fd_sc_hd__clkbuf_1
Xclkload48 clknet_leaf_14_clk_net VSS VSS VDD VDD _unconnected_18
+ sky130_fd_sc_hd__clkinv_1
X_09830_ net361 _06672_ VSS VSS VDD VDD _06701_ sky130_fd_sc_hd__nor2_1
X_09831_ network.neuron_in186.counter\[2\] _00767_ VSS VSS
+ VDD VDD _06702_ sky130_fd_sc_hd__xnor2_1
X_09832_ network.in_period\[186\]\[2\] _06701_ _06702_ net379
+ VSS VSS VDD VDD _02809_ sky130_fd_sc_hd__a2bb2oi_1
Xclkload47 clknet_leaf_13_clk_net VSS VSS VDD VDD _unconnected_19
+ sky130_fd_sc_hd__clkbuf_8
Xclkload46 clknet_leaf_12_clk_net VSS VSS VDD VDD _unconnected_20
+ sky130_fd_sc_hd__clkinv_2
X_09835_ network.neuron_in187.counter\[3\] _00742_ VSS VSS
+ VDD VDD _06705_ sky130_fd_sc_hd__nand2b_1
X_09836_ network.neuron_in187.counter\[2\] VSS VSS VDD VDD
+ _06706_ sky130_fd_sc_hd__inv_1
X_09837_ _06705_ _06706_ VSS VSS VDD VDD _06707_ sky130_fd_sc_hd__nand2b_1
X_09838_ net379 _06707_ VSS VSS VDD VDD _06708_ sky130_fd_sc_hd__nand2_1
X_09839_ net671 _06708_ VSS VSS VDD VDD _06709_ sky130_fd_sc_hd__nand2_1
X_09840_ _00743_ _06708_ _06709_ VSS VSS VDD VDD _02812_ sky130_fd_sc_hd__o21ai_0
X_09841_ network.neuron_in188.counter\[2\] _00231_ VSS VSS
+ VDD VDD _06710_ sky130_fd_sc_hd__xnor2_1
X_09842_ network.neuron_in188.counter\[2\] network.neuron_in188.counter\[3\]
+ VSS VSS VDD VDD _06711_ sky130_fd_sc_hd__nor2_1
X_09843_ net363 _06711_ VSS VSS VDD VDD _06712_ sky130_fd_sc_hd__nor2_1
X_09844_ network.in_period\[188\]\[2\] _06712_ VSS VSS VDD
+ VDD _06713_ sky130_fd_sc_hd__nor2_1
X_09845_ net366 _06710_ _06713_ VSS VSS VDD VDD _02817_ sky130_fd_sc_hd__a21oi_1
X_09846_ network.neuron_in073.counter\[1\] VSS VSS VDD VDD
+ _00132_ sky130_fd_sc_hd__inv_1
X_09847_ network.neuron_in203.counter\[0\] VSS VSS VDD VDD
+ _01192_ sky130_fd_sc_hd__inv_1
X_09848_ network.neuron_in074.counter\[1\] VSS VSS VDD VDD
+ _00120_ sky130_fd_sc_hd__inv_1
X_09849_ network.neuron_in162.counter\[0\] VSS VSS VDD VDD
+ _00791_ sky130_fd_sc_hd__inv_1
X_09850_ network.neuron_in041.counter\[1\] VSS VSS VDD VDD
+ _00310_ sky130_fd_sc_hd__inv_1
X_09851_ network.neuron_in179.counter\[3\] _00565_ VSS VSS
+ VDD VDD _06714_ sky130_fd_sc_hd__nand2b_1
X_09852_ network.neuron_in179.counter\[2\] VSS VSS VDD VDD
+ _06715_ sky130_fd_sc_hd__inv_1
X_09853_ _06714_ _06715_ VSS VSS VDD VDD _06716_ sky130_fd_sc_hd__nand2b_1
X_09854_ net365 _06716_ VSS VSS VDD VDD _06717_ sky130_fd_sc_hd__nand2_1
X_09855_ net673 _06717_ VSS VSS VDD VDD _06718_ sky130_fd_sc_hd__nand2_1
X_09856_ _00566_ _06717_ _06718_ VSS VSS VDD VDD _02780_ sky130_fd_sc_hd__o21ai_0
X_09857_ network.neuron_in140.counter\[1\] VSS VSS VDD VDD
+ _01080_ sky130_fd_sc_hd__inv_1
X_09858_ network.neuron_in179.counter\[0\] VSS VSS VDD VDD
+ _00563_ sky130_fd_sc_hd__inv_1
X_09859_ net668 _06717_ VSS VSS VDD VDD _06719_ sky130_fd_sc_hd__nand2_1
X_09860_ network.neuron_in179.counter\[0\] _06717_ _06719_
+ VSS VSS VDD VDD _02779_ sky130_fd_sc_hd__o21ai_0
X_09861_ network.neuron_in180.counter\[3\] _00851_ VSS VSS
+ VDD VDD _06720_ sky130_fd_sc_hd__nand2b_1
X_09862_ network.neuron_in180.counter\[2\] _06720_ VSS VSS
+ VDD VDD _06721_ sky130_fd_sc_hd__or2_2
X_09863_ net365 _06721_ VSS VSS VDD VDD _06722_ sky130_fd_sc_hd__nand2_1
X_09864_ net684 _06722_ VSS VSS VDD VDD _06723_ sky130_fd_sc_hd__nand2_1
X_09865_ _00852_ _06722_ _06723_ VSS VSS VDD VDD _02784_ sky130_fd_sc_hd__o21ai_0
X_09866_ network.neuron_in065.counter\[0\] VSS VSS VDD VDD
+ _00182_ sky130_fd_sc_hd__inv_1
X_09867_ network.neuron_in071.counter\[1\] VSS VSS VDD VDD
+ _00140_ sky130_fd_sc_hd__inv_1
X_09868_ network.neuron_in135.counter\[1\] VSS VSS VDD VDD
+ _00737_ sky130_fd_sc_hd__inv_1
X_09869_ network.neuron_in197.counter\[1\] VSS VSS VDD VDD
+ _01183_ sky130_fd_sc_hd__inv_1
X_09870_ network.neuron_in180.counter\[0\] VSS VSS VDD VDD
+ _00849_ sky130_fd_sc_hd__inv_1
X_09871_ network.in_period\[180\]\[0\] _06722_ VSS VSS VDD
+ VDD _06724_ sky130_fd_sc_hd__nand2_1
X_09872_ network.neuron_in180.counter\[0\] _06722_ _06724_
+ VSS VSS VDD VDD _02783_ sky130_fd_sc_hd__o21ai_0
X_09873_ network.neuron_in181.counter\[0\] VSS VSS VDD VDD
+ _00845_ sky130_fd_sc_hd__inv_1
X_09874_ net687 _06663_ VSS VSS VDD VDD _06725_ sky130_fd_sc_hd__nand2_1
X_09875_ network.neuron_in181.counter\[0\] _06663_ _06725_
+ VSS VSS VDD VDD _02787_ sky130_fd_sc_hd__o21ai_0
X_09876_ network.neuron_in140.counter\[0\] VSS VSS VDD VDD
+ _01079_ sky130_fd_sc_hd__inv_1
X_09877_ network.neuron_in070.counter\[1\] VSS VSS VDD VDD
+ _00149_ sky130_fd_sc_hd__inv_1
X_09878_ network.neuron_in203.counter\[1\] VSS VSS VDD VDD
+ _01193_ sky130_fd_sc_hd__inv_1
X_09879_ network.neuron_in041.counter\[0\] VSS VSS VDD VDD
+ _00309_ sky130_fd_sc_hd__inv_1
X_09880_ network.neuron_in156.counter\[1\] VSS VSS VDD VDD
+ _01076_ sky130_fd_sc_hd__inv_1
X_09881_ network.neuron_in127.counter\[0\] VSS VSS VDD VDD
+ _01105_ sky130_fd_sc_hd__inv_1
X_09882_ network.neuron_in069.counter\[1\] VSS VSS VDD VDD
+ _00153_ sky130_fd_sc_hd__inv_1
X_09883_ network.neuron_in248.counter\[1\] VSS VSS VDD VDD
+ _00560_ sky130_fd_sc_hd__inv_1
X_09884_ network.neuron_in204.counter\[1\] VSS VSS VDD VDD
+ _00788_ sky130_fd_sc_hd__inv_1
X_09885_ network.neuron_in182.counter\[2\] _00839_ VSS VSS
+ VDD VDD _06726_ sky130_fd_sc_hd__xnor2_1
X_09886_ network.neuron_in182.counter\[2\] network.neuron_in182.counter\[3\]
+ VSS VSS VDD VDD _06727_ sky130_fd_sc_hd__nor2_1
X_09887_ net362 _06727_ VSS VSS VDD VDD _06728_ sky130_fd_sc_hd__nor2_1
X_09888_ network.in_period\[182\]\[2\] _06728_ VSS VSS VDD
+ VDD _06729_ sky130_fd_sc_hd__nor2_1
X_09889_ net366 _06726_ _06729_ VSS VSS VDD VDD _02793_ sky130_fd_sc_hd__a21oi_1
X_09890_ network.neuron_in182.counter\[0\] VSS VSS VDD VDD
+ _00837_ sky130_fd_sc_hd__inv_1
X_09891_ net707 _06692_ VSS VSS VDD VDD _06730_ sky130_fd_sc_hd__nand2_1
X_09892_ network.neuron_in182.counter\[0\] _06692_ _06730_
+ VSS VSS VDD VDD _02791_ sky130_fd_sc_hd__o21ai_0
Xclkload45 clknet_leaf_11_clk_net VSS VSS VDD VDD _unconnected_21
+ sky130_fd_sc_hd__clkinv_1
Xclkload44 clknet_leaf_10_clk_net VSS VSS VDD VDD _unconnected_22
+ sky130_fd_sc_hd__clkinv_2
X_09895_ network.neuron_in183.counter\[3\] network.in_period\[183\]\[2\]
+ _01140_ net362 VSS VSS VDD VDD _06733_ sky130_fd_sc_hd__o22ai_1
Xclkload43 clknet_leaf_9_clk_net VSS VSS VDD VDD _unconnected_23
+ sky130_fd_sc_hd__clkbuf_8
Xclkload42 clknet_leaf_8_clk_net VSS VSS VDD VDD _unconnected_24
+ sky130_fd_sc_hd__clkbuf_8
X_09898_ network.neuron_in183.counter\[2\] _01140_ net379
+ VSS VSS VDD VDD _06736_ sky130_fd_sc_hd__nand3_1
X_09899_ network.in_period\[183\]\[2\] net379 _06736_ VSS
+ VSS VDD VDD _06737_ sky130_fd_sc_hd__o21ai_0
X_09900_ _06666_ _06733_ _06737_ VSS VSS VDD VDD _02797_ sky130_fd_sc_hd__a21oi_1
X_09901_ network.neuron_in184.counter\[3\] _00984_ VSS VSS
+ VDD VDD _06738_ sky130_fd_sc_hd__nand2b_1
X_09902_ network.neuron_in184.counter\[2\] _06738_ VSS VSS
+ VDD VDD _06739_ sky130_fd_sc_hd__or2_2
X_09903_ net379 _06739_ VSS VSS VDD VDD _06740_ sky130_fd_sc_hd__nand2_1
X_09904_ network.in_period\[184\]\[1\] _06740_ VSS VSS VDD
+ VDD _06741_ sky130_fd_sc_hd__nand2_1
X_09905_ _00985_ _06740_ _06741_ VSS VSS VDD VDD _02800_ sky130_fd_sc_hd__o21ai_0
X_09906_ network.neuron_in103.counter\[0\] VSS VSS VDD VDD
+ _00213_ sky130_fd_sc_hd__inv_1
X_09907_ network.neuron_in184.counter\[0\] VSS VSS VDD VDD
+ _00982_ sky130_fd_sc_hd__inv_1
X_09908_ network.in_period\[184\]\[0\] _06740_ VSS VSS VDD
+ VDD _06742_ sky130_fd_sc_hd__nand2_1
X_09909_ network.neuron_in184.counter\[0\] _06740_ _06742_
+ VSS VSS VDD VDD _02799_ sky130_fd_sc_hd__o21ai_0
X_09910_ network.neuron_in068.counter\[1\] VSS VSS VDD VDD
+ _00161_ sky130_fd_sc_hd__inv_1
X_09911_ network.neuron_in185.counter\[3\] _00763_ VSS VSS
+ VDD VDD _06743_ sky130_fd_sc_hd__nand2b_1
X_09912_ network.neuron_in185.counter\[2\] _06743_ VSS VSS
+ VDD VDD _06744_ sky130_fd_sc_hd__or2_2
X_09913_ net379 _06744_ VSS VSS VDD VDD _06745_ sky130_fd_sc_hd__nand2_1
X_09914_ net663 _06745_ VSS VSS VDD VDD _06746_ sky130_fd_sc_hd__nand2_1
X_09915_ _00764_ _06745_ _06746_ VSS VSS VDD VDD _02804_ sky130_fd_sc_hd__o21ai_0
X_09916_ network.neuron_in212.counter\[0\] VSS VSS VDD VDD
+ _01170_ sky130_fd_sc_hd__inv_1
X_09917_ network.neuron_in185.counter\[0\] VSS VSS VDD VDD
+ _00761_ sky130_fd_sc_hd__inv_1
X_09918_ net638 _06745_ VSS VSS VDD VDD _06747_ sky130_fd_sc_hd__nand2_1
X_09919_ network.neuron_in185.counter\[0\] _06745_ _06747_
+ VSS VSS VDD VDD _02803_ sky130_fd_sc_hd__o21ai_0
X_09920_ network.neuron_in067.counter\[1\] VSS VSS VDD VDD
+ _00167_ sky130_fd_sc_hd__inv_1
X_09921_ net614 _06674_ VSS VSS VDD VDD _06748_ sky130_fd_sc_hd__nand2_1
X_09922_ network.neuron_in186.counter\[0\] _06674_ _06748_
+ VSS VSS VDD VDD _02807_ sky130_fd_sc_hd__o21ai_0
X_09923_ network.neuron_in066.counter\[1\] VSS VSS VDD VDD
+ _00173_ sky130_fd_sc_hd__inv_1
X_09924_ network.neuron_in187.counter\[3\] network.in_period\[187\]\[2\]
+ _00742_ net362 VSS VSS VDD VDD _06749_ sky130_fd_sc_hd__o22ai_1
X_09925_ network.neuron_in187.counter\[2\] _00742_ net379
+ VSS VSS VDD VDD _06750_ sky130_fd_sc_hd__nand3_1
X_09926_ network.in_period\[187\]\[2\] net379 _06750_ VSS
+ VSS VDD VDD _06751_ sky130_fd_sc_hd__o21ai_0
X_09927_ _06706_ _06749_ _06751_ VSS VSS VDD VDD _02813_ sky130_fd_sc_hd__a21oi_1
X_09928_ network.neuron_in187.counter\[0\] VSS VSS VDD VDD
+ _00740_ sky130_fd_sc_hd__inv_1
X_09929_ net739 _06708_ VSS VSS VDD VDD _06752_ sky130_fd_sc_hd__nand2_1
X_09930_ network.neuron_in187.counter\[0\] _06708_ _06752_
+ VSS VSS VDD VDD _02811_ sky130_fd_sc_hd__o21ai_0
X_09931_ network.neuron_in199.counter\[2\] _01180_ VSS VSS
+ VDD VDD _06753_ sky130_fd_sc_hd__xnor2_1
X_09932_ network.neuron_in199.counter\[2\] network.neuron_in199.counter\[3\]
+ VSS VSS VDD VDD _06754_ sky130_fd_sc_hd__nor2_1
X_09933_ net364 _06754_ VSS VSS VDD VDD _06755_ sky130_fd_sc_hd__nor2_1
X_09934_ net501 _06755_ VSS VSS VDD VDD _06756_ sky130_fd_sc_hd__nor2_1
X_09935_ net376 _06753_ _06756_ VSS VSS VDD VDD _02861_ sky130_fd_sc_hd__a21oi_1
Xclkload41 clknet_leaf_7_clk_net VSS VSS VDD VDD _unconnected_25
+ sky130_fd_sc_hd__clkbuf_8
X_09937_ network.neuron_in194.counter\[2\] _01148_ VSS VSS
+ VDD VDD _06758_ sky130_fd_sc_hd__xnor2_1
X_09938_ network.neuron_in194.counter\[2\] network.neuron_in194.counter\[3\]
+ VSS VSS VDD VDD _06759_ sky130_fd_sc_hd__nor2_1
X_09939_ net364 _06759_ VSS VSS VDD VDD _06760_ sky130_fd_sc_hd__nor2_1
X_09940_ network.in_period\[194\]\[2\] _06760_ VSS VSS VDD
+ VDD _06761_ sky130_fd_sc_hd__nor2_1
X_09941_ net376 _06758_ _06761_ VSS VSS VDD VDD _02841_ sky130_fd_sc_hd__a21oi_1
X_09942_ network.neuron_in198.counter\[0\] VSS VSS VDD VDD
+ _01174_ sky130_fd_sc_hd__inv_1
X_09943_ network.neuron_in198.counter\[3\] _01176_ VSS VSS
+ VDD VDD _06762_ sky130_fd_sc_hd__nand2b_1
X_09944_ network.neuron_in198.counter\[2\] _06762_ VSS VSS
+ VDD VDD _06763_ sky130_fd_sc_hd__or2_2
X_09945_ net389 _06763_ VSS VSS VDD VDD _06764_ sky130_fd_sc_hd__nand2_1
X_09946_ net548 _06764_ VSS VSS VDD VDD _06765_ sky130_fd_sc_hd__nand2_1
X_09947_ network.neuron_in198.counter\[0\] _06764_ _06765_
+ VSS VSS VDD VDD _02855_ sky130_fd_sc_hd__o21ai_0
X_09948_ network.neuron_in191.counter\[3\] _00827_ VSS VSS
+ VDD VDD _06766_ sky130_fd_sc_hd__nand2b_1
X_09949_ network.neuron_in191.counter\[2\] VSS VSS VDD VDD
+ _06767_ sky130_fd_sc_hd__inv_1
X_09950_ _06766_ _06767_ VSS VSS VDD VDD _06768_ sky130_fd_sc_hd__nand2b_1
X_09951_ net366 _06768_ VSS VSS VDD VDD _06769_ sky130_fd_sc_hd__nand2_1
X_09952_ net802 _06769_ VSS VSS VDD VDD _06770_ sky130_fd_sc_hd__nand2_1
X_09953_ _00828_ _06769_ _06770_ VSS VSS VDD VDD _02828_ sky130_fd_sc_hd__o21ai_0
X_09954_ network.neuron_in251.counter\[1\] VSS VSS VDD VDD
+ _01110_ sky130_fd_sc_hd__inv_1
X_09955_ network.neuron_in066.counter\[0\] VSS VSS VDD VDD
+ _00172_ sky130_fd_sc_hd__inv_1
X_09956_ network.neuron_in193.counter\[0\] VSS VSS VDD VDD
+ _00249_ sky130_fd_sc_hd__inv_1
X_09957_ network.neuron_in193.counter\[3\] _00251_ VSS VSS
+ VDD VDD _06771_ sky130_fd_sc_hd__nand2b_1
X_09958_ network.neuron_in193.counter\[2\] VSS VSS VDD VDD
+ _06772_ sky130_fd_sc_hd__inv_1
X_09959_ _06771_ _06772_ VSS VSS VDD VDD _06773_ sky130_fd_sc_hd__nand2b_1
X_09960_ net376 _06773_ VSS VSS VDD VDD _06774_ sky130_fd_sc_hd__nand2_1
X_09961_ net538 _06774_ VSS VSS VDD VDD _06775_ sky130_fd_sc_hd__nand2_1
X_09962_ network.neuron_in193.counter\[0\] _06774_ _06775_
+ VSS VSS VDD VDD _02835_ sky130_fd_sc_hd__o21ai_0
X_09963_ network.neuron_in074.counter\[0\] VSS VSS VDD VDD
+ _00119_ sky130_fd_sc_hd__inv_1
X_09964_ network.neuron_in196.counter\[3\] _00972_ VSS VSS
+ VDD VDD _06776_ sky130_fd_sc_hd__nand2b_1
X_09965_ network.neuron_in196.counter\[2\] _06776_ VSS VSS
+ VDD VDD _06777_ sky130_fd_sc_hd__or2_2
X_09966_ net376 _06777_ VSS VSS VDD VDD _06778_ sky130_fd_sc_hd__nand2_1
X_09967_ net544 _06778_ VSS VSS VDD VDD _06779_ sky130_fd_sc_hd__nand2_1
X_09968_ _00973_ _06778_ _06779_ VSS VSS VDD VDD _02848_ sky130_fd_sc_hd__o21ai_0
X_09969_ net554 _06764_ VSS VSS VDD VDD _06780_ sky130_fd_sc_hd__nand2_1
X_09970_ _01177_ _06764_ _06780_ VSS VSS VDD VDD _02856_ sky130_fd_sc_hd__o21ai_0
X_09971_ network.neuron_in107.counter\[1\] VSS VSS VDD VDD
+ _00750_ sky130_fd_sc_hd__inv_1
X_09972_ network.neuron_in162.counter\[1\] VSS VSS VDD VDD
+ _00792_ sky130_fd_sc_hd__inv_1
X_09973_ network.neuron_in042.counter\[1\] VSS VSS VDD VDD
+ _00306_ sky130_fd_sc_hd__inv_1
X_09974_ network.neuron_in190.counter\[2\] VSS VSS VDD VDD
+ _06781_ sky130_fd_sc_hd__inv_1
X_09975_ network.neuron_in190.counter\[3\] network.in_period\[190\]\[2\]
+ _00831_ net363 VSS VSS VDD VDD _06782_ sky130_fd_sc_hd__o22ai_1
Xclkload40 clknet_leaf_6_clk_net VSS VSS VDD VDD _unconnected_26
+ sky130_fd_sc_hd__clkinv_1
X_09977_ network.neuron_in190.counter\[2\] _00831_ net366
+ VSS VSS VDD VDD _06784_ sky130_fd_sc_hd__nand3_1
X_09978_ network.in_period\[190\]\[2\] net366 _06784_ VSS
+ VSS VDD VDD _06785_ sky130_fd_sc_hd__o21ai_0
X_09979_ _06781_ _06782_ _06785_ VSS VSS VDD VDD _02825_ sky130_fd_sc_hd__a21oi_1
X_09980_ network.neuron_in191.counter\[3\] network.in_period\[191\]\[2\]
+ _00827_ net362 VSS VSS VDD VDD _06786_ sky130_fd_sc_hd__o22ai_1
X_09981_ network.neuron_in191.counter\[2\] _00827_ net366
+ VSS VSS VDD VDD _06787_ sky130_fd_sc_hd__nand3_1
X_09982_ network.in_period\[191\]\[2\] net366 _06787_ VSS
+ VSS VDD VDD _06788_ sky130_fd_sc_hd__o21ai_0
X_09983_ _06767_ _06786_ _06788_ VSS VSS VDD VDD _02829_ sky130_fd_sc_hd__a21oi_1
X_09984_ network.neuron_in065.counter\[1\] VSS VSS VDD VDD
+ _00183_ sky130_fd_sc_hd__inv_1
X_09985_ network.neuron_in156.counter\[0\] VSS VSS VDD VDD
+ _01075_ sky130_fd_sc_hd__inv_1
X_09986_ network.neuron_in192.counter\[3\] _01032_ VSS VSS
+ VDD VDD _06789_ sky130_fd_sc_hd__nand2b_1
X_09987_ network.neuron_in192.counter\[2\] VSS VSS VDD VDD
+ _06790_ sky130_fd_sc_hd__inv_1
X_09988_ _06789_ _06790_ VSS VSS VDD VDD _06791_ sky130_fd_sc_hd__nand2b_1
X_09989_ net376 _06791_ VSS VSS VDD VDD _06792_ sky130_fd_sc_hd__nand2_1
X_09990_ net556 _06792_ VSS VSS VDD VDD _06793_ sky130_fd_sc_hd__nand2_1
X_09991_ _01033_ _06792_ _06793_ VSS VSS VDD VDD _02832_ sky130_fd_sc_hd__o21ai_0
X_09992_ net555 _06774_ VSS VSS VDD VDD _06794_ sky130_fd_sc_hd__nand2_1
X_09993_ _00252_ _06774_ _06794_ VSS VSS VDD VDD _02836_ sky130_fd_sc_hd__o21ai_0
X_09994_ network.neuron_in195.counter\[2\] _00823_ VSS VSS
+ VDD VDD _06795_ sky130_fd_sc_hd__xnor2_1
X_09995_ network.neuron_in195.counter\[2\] network.neuron_in195.counter\[3\]
+ VSS VSS VDD VDD _06796_ sky130_fd_sc_hd__nor2_1
X_09996_ net364 _06796_ VSS VSS VDD VDD _06797_ sky130_fd_sc_hd__nor2_1
X_09997_ net506 _06797_ VSS VSS VDD VDD _06798_ sky130_fd_sc_hd__nor2_1
X_09998_ net376 _06795_ _06798_ VSS VSS VDD VDD _02845_ sky130_fd_sc_hd__a21oi_1
X_09999_ network.neuron_in121.counter\[1\] VSS VSS VDD VDD
+ _00294_ sky130_fd_sc_hd__inv_1
X_10000_ network.neuron_in179.counter\[1\] VSS VSS VDD VDD
+ _00564_ sky130_fd_sc_hd__inv_1
X_10001_ network.neuron_in178.counter\[2\] VSS VSS VDD VDD
+ _06799_ sky130_fd_sc_hd__inv_1
X_10002_ network.neuron_in178.counter\[3\] network.in_period\[178\]\[2\]
+ _00271_ net363 VSS VSS VDD VDD _06800_ sky130_fd_sc_hd__o22ai_1
X_10003_ network.neuron_in178.counter\[2\] _00271_ net365
+ VSS VSS VDD VDD _06801_ sky130_fd_sc_hd__nand3_1
X_10004_ network.in_period\[178\]\[2\] net365 _06801_ VSS
+ VSS VDD VDD _06802_ sky130_fd_sc_hd__o21ai_0
X_10005_ _06799_ _06800_ _06802_ VSS VSS VDD VDD _02777_ sky130_fd_sc_hd__a21oi_1
X_10006_ network.neuron_in126.counter\[1\] VSS VSS VDD VDD
+ _00724_ sky130_fd_sc_hd__inv_1
X_10007_ network.neuron_in114.counter\[1\] VSS VSS VDD VDD
+ _00078_ sky130_fd_sc_hd__inv_1
X_10008_ _00793_ network.neuron_in162.counter\[2\] VSS VSS
+ VDD VDD _06803_ sky130_fd_sc_hd__nand2b_1
X_10009_ network.neuron_in162.counter\[2\] _00793_ VSS VSS
+ VDD VDD _06804_ sky130_fd_sc_hd__nand2b_1
X_10010_ net378 _06637_ network.in_period\[162\]\[2\] VSS
+ VSS VDD VDD _06805_ sky130_fd_sc_hd__a21oi_1
X_10011_ net378 _06803_ _06804_ _06805_ VSS VSS VDD VDD _02713_
+ sky130_fd_sc_hd__a31oi_1
X_10012_ network.neuron_in196.counter\[2\] _00972_ VSS VSS
+ VDD VDD _06806_ sky130_fd_sc_hd__xnor2_1
X_10013_ network.neuron_in196.counter\[2\] network.neuron_in196.counter\[3\]
+ VSS VSS VDD VDD _06807_ sky130_fd_sc_hd__nor2_1
X_10014_ net364 _06807_ VSS VSS VDD VDD _06808_ sky130_fd_sc_hd__nor2_1
X_10015_ network.in_period\[196\]\[2\] _06808_ VSS VSS VDD
+ VDD _06809_ sky130_fd_sc_hd__nor2_1
X_10016_ net376 _06806_ _06809_ VSS VSS VDD VDD _02849_ sky130_fd_sc_hd__a21oi_1
Xclkload39 clknet_leaf_161_clk_net VSS VSS VDD VDD _unconnected_27
+ sky130_fd_sc_hd__clkbuf_1
X_10018_ network.neuron_in197.counter\[2\] net376 VSS VSS
+ VDD VDD _06811_ sky130_fd_sc_hd__nand2_1
X_10019_ network.in_period\[197\]\[2\] network.neuron_in197.counter\[3\]
+ _06811_ VSS VSS VDD VDD _06812_ sky130_fd_sc_hd__o21ai_0
X_10020_ _01184_ network.neuron_in197.counter\[2\] net364
+ VSS VSS VDD VDD _06813_ sky130_fd_sc_hd__or3_1
X_10021_ network.in_period\[197\]\[2\] net376 _06813_ VSS
+ VSS VDD VDD _06814_ sky130_fd_sc_hd__o21ai_0
X_10022_ _01184_ _06812_ _06814_ VSS VSS VDD VDD _02853_ sky130_fd_sc_hd__a21oi_1
X_10023_ network.neuron_in001.counter\[0\] VSS VSS VDD VDD
+ _00567_ sky130_fd_sc_hd__inv_1
X_10024_ network.neuron_in064.counter\[1\] VSS VSS VDD VDD
+ _00198_ sky130_fd_sc_hd__inv_1
X_10025_ network.neuron_in232.counter\[1\] VSS VSS VDD VDD
+ _01072_ sky130_fd_sc_hd__inv_1
X_10026_ network.neuron_in159.counter\[0\] VSS VSS VDD VDD
+ _00637_ sky130_fd_sc_hd__inv_1
X_10027_ net686 _06619_ VSS VSS VDD VDD _06815_ sky130_fd_sc_hd__nand2_1
X_10028_ network.neuron_in159.counter\[0\] _06619_ _06815_
+ VSS VSS VDD VDD _02699_ sky130_fd_sc_hd__o21ai_0
X_10029_ network.neuron_in103.counter\[1\] VSS VSS VDD VDD
+ _00214_ sky130_fd_sc_hd__inv_1
X_10030_ network.neuron_in001.counter\[1\] VSS VSS VDD VDD
+ _00568_ sky130_fd_sc_hd__inv_1
X_10031_ network.neuron_in061.counter\[1\] VSS VSS VDD VDD
+ _00592_ sky130_fd_sc_hd__inv_1
X_10032_ network.neuron_in060.counter\[1\] VSS VSS VDD VDD
+ _00210_ sky130_fd_sc_hd__inv_1
X_10033_ network.neuron_in042.counter\[0\] VSS VSS VDD VDD
+ _00305_ sky130_fd_sc_hd__inv_1
X_10034_ network.neuron_in092.counter\[0\] VSS VSS VDD VDD
+ _01227_ sky130_fd_sc_hd__inv_1
X_10035_ network.neuron_in198.counter\[2\] _01176_ VSS VSS
+ VDD VDD _06816_ sky130_fd_sc_hd__xnor2_1
X_10036_ network.neuron_in198.counter\[2\] network.neuron_in198.counter\[3\]
+ VSS VSS VDD VDD _06817_ sky130_fd_sc_hd__nor2_1
X_10037_ net364 _06817_ VSS VSS VDD VDD _06818_ sky130_fd_sc_hd__nor2_1
X_10038_ network.in_period\[198\]\[2\] _06818_ VSS VSS VDD
+ VDD _06819_ sky130_fd_sc_hd__nor2_1
X_10039_ net389 _06816_ _06819_ VSS VSS VDD VDD _02857_ sky130_fd_sc_hd__a21oi_1
Xclkload38 clknet_leaf_159_clk_net VSS VSS VDD VDD _unconnected_28
+ sky130_fd_sc_hd__clkinv_2
Xclkload37 clknet_leaf_158_clk_net VSS VSS VDD VDD _unconnected_29
+ sky130_fd_sc_hd__clkbuf_1
X_10042_ network.neuron_in189.counter\[3\] _00976_ VSS VSS
+ VDD VDD _06822_ sky130_fd_sc_hd__nand2b_1
X_10043_ network.neuron_in189.counter\[2\] _06822_ VSS VSS
+ VDD VDD _06823_ sky130_fd_sc_hd__or2_2
X_10044_ net366 _06823_ VSS VSS VDD VDD _06824_ sky130_fd_sc_hd__nand2_1
X_10045_ net618 _06824_ VSS VSS VDD VDD _06825_ sky130_fd_sc_hd__nand2_1
X_10046_ _00977_ _06824_ _06825_ VSS VSS VDD VDD _02820_ sky130_fd_sc_hd__o21ai_0
X_10047_ network.neuron_in189.counter\[0\] VSS VSS VDD VDD
+ _00974_ sky130_fd_sc_hd__inv_1
X_10048_ net719 _06824_ VSS VSS VDD VDD _06826_ sky130_fd_sc_hd__nand2_1
X_10049_ network.neuron_in189.counter\[0\] _06824_ _06826_
+ VSS VSS VDD VDD _02819_ sky130_fd_sc_hd__o21ai_0
X_10050_ network.neuron_in190.counter\[3\] _00831_ VSS VSS
+ VDD VDD _06827_ sky130_fd_sc_hd__nand2b_1
X_10051_ _06827_ _06781_ VSS VSS VDD VDD _06828_ sky130_fd_sc_hd__nand2b_1
X_10052_ net366 _06828_ VSS VSS VDD VDD _06829_ sky130_fd_sc_hd__nand2_1
X_10053_ net776 _06829_ VSS VSS VDD VDD _06830_ sky130_fd_sc_hd__nand2_1
X_10054_ _00832_ _06829_ _06830_ VSS VSS VDD VDD _02824_ sky130_fd_sc_hd__o21ai_0
X_10055_ network.neuron_in102.counter\[1\] VSS VSS VDD VDD
+ _00770_ sky130_fd_sc_hd__inv_1
X_10056_ network.neuron_in136.counter\[0\] VSS VSS VDD VDD
+ _01113_ sky130_fd_sc_hd__inv_1
X_10057_ net694 _06684_ VSS VSS VDD VDD _06831_ sky130_fd_sc_hd__nand2_1
X_10058_ network.neuron_in136.counter\[0\] _06684_ _06831_
+ VSS VSS VDD VDD _02607_ sky130_fd_sc_hd__o21ai_0
X_10059_ network.neuron_in059.counter\[1\] VSS VSS VDD VDD
+ _00222_ sky130_fd_sc_hd__inv_1
X_10060_ network.neuron_in190.counter\[0\] VSS VSS VDD VDD
+ _00829_ sky130_fd_sc_hd__inv_1
X_10061_ network.in_period\[190\]\[0\] _06829_ VSS VSS VDD
+ VDD _06832_ sky130_fd_sc_hd__nand2_1
X_10062_ network.neuron_in190.counter\[0\] _06829_ _06832_
+ VSS VSS VDD VDD _02823_ sky130_fd_sc_hd__o21ai_0
X_10063_ network.neuron_in191.counter\[0\] VSS VSS VDD VDD
+ _00825_ sky130_fd_sc_hd__inv_1
X_10064_ network.in_period\[191\]\[0\] _06769_ VSS VSS VDD
+ VDD _06833_ sky130_fd_sc_hd__nand2_1
X_10065_ network.neuron_in191.counter\[0\] _06769_ _06833_
+ VSS VSS VDD VDD _02827_ sky130_fd_sc_hd__o21ai_0
X_10066_ network.neuron_in192.counter\[3\] network.in_period\[192\]\[2\]
+ _01032_ net364 VSS VSS VDD VDD _06834_ sky130_fd_sc_hd__o22ai_1
X_10067_ network.neuron_in192.counter\[2\] _01032_ net376
+ VSS VSS VDD VDD _06835_ sky130_fd_sc_hd__nand3_1
X_10068_ network.in_period\[192\]\[2\] net376 _06835_ VSS
+ VSS VDD VDD _06836_ sky130_fd_sc_hd__o21ai_0
X_10069_ _06790_ _06834_ _06836_ VSS VSS VDD VDD _02833_ sky130_fd_sc_hd__a21oi_1
X_10070_ network.neuron_in232.counter\[0\] VSS VSS VDD VDD
+ _01071_ sky130_fd_sc_hd__inv_1
X_10071_ network.neuron_in183.counter\[1\] VSS VSS VDD VDD
+ _01139_ sky130_fd_sc_hd__inv_1
X_10072_ network.neuron_in231.counter\[0\] VSS VSS VDD VDD
+ _00571_ sky130_fd_sc_hd__inv_1
X_10073_ network.neuron_in192.counter\[0\] VSS VSS VDD VDD
+ _01030_ sky130_fd_sc_hd__inv_1
X_10074_ net562 _06792_ VSS VSS VDD VDD _06837_ sky130_fd_sc_hd__nand2_1
X_10075_ network.neuron_in192.counter\[0\] _06792_ _06837_
+ VSS VSS VDD VDD _02831_ sky130_fd_sc_hd__o21ai_0
X_10076_ network.neuron_in184.counter\[1\] VSS VSS VDD VDD
+ _00983_ sky130_fd_sc_hd__inv_1
X_10077_ network.neuron_in193.counter\[3\] network.in_period\[193\]\[2\]
+ _00251_ net364 VSS VSS VDD VDD _06838_ sky130_fd_sc_hd__o22ai_1
X_10078_ network.neuron_in193.counter\[2\] _00251_ net376
+ VSS VSS VDD VDD _06839_ sky130_fd_sc_hd__nand3_1
X_10079_ network.in_period\[193\]\[2\] net376 _06839_ VSS
+ VSS VDD VDD _06840_ sky130_fd_sc_hd__o21ai_0
X_10080_ _06772_ _06838_ _06840_ VSS VSS VDD VDD _02837_ sky130_fd_sc_hd__a21oi_1
X_10081_ network.neuron_in072.counter\[0\] VSS VSS VDD VDD
+ _00217_ sky130_fd_sc_hd__inv_1
X_10082_ network.neuron_in117.counter\[1\] VSS VSS VDD VDD
+ _00070_ sky130_fd_sc_hd__inv_1
X_10083_ network.neuron_in058.counter\[1\] VSS VSS VDD VDD
+ _00226_ sky130_fd_sc_hd__inv_1
X_10084_ network.neuron_in236.counter\[0\] VSS VSS VDD VDD
+ _00369_ sky130_fd_sc_hd__inv_1
X_10085_ network.neuron_in057.counter\[1\] VSS VSS VDD VDD
+ _00238_ sky130_fd_sc_hd__inv_1
X_10086_ network.neuron_in129.counter\[0\] VSS VSS VDD VDD
+ _00401_ sky130_fd_sc_hd__inv_1
X_10087_ network.neuron_in129.counter\[3\] _00403_ VSS VSS
+ VDD VDD _06841_ sky130_fd_sc_hd__nand2b_1
X_10088_ network.neuron_in129.counter\[2\] _06841_ VSS VSS
+ VDD VDD _06842_ sky130_fd_sc_hd__or2_2
X_10089_ net384 _06842_ VSS VSS VDD VDD _06843_ sky130_fd_sc_hd__nand2_1
X_10090_ net632 _06843_ VSS VSS VDD VDD _06844_ sky130_fd_sc_hd__nand2_1
X_10091_ network.neuron_in129.counter\[0\] _06843_ _06844_
+ VSS VSS VDD VDD _02579_ sky130_fd_sc_hd__o21ai_0
X_10092_ network.neuron_in215.counter\[1\] VSS VSS VDD VDD
+ _00302_ sky130_fd_sc_hd__inv_1
X_10093_ net634 _06843_ VSS VSS VDD VDD _06845_ sky130_fd_sc_hd__nand2_1
X_10094_ _00404_ _06843_ _06845_ VSS VSS VDD VDD _02580_ sky130_fd_sc_hd__o21ai_0
X_10095_ network.neuron_in194.counter\[3\] _01148_ VSS VSS
+ VDD VDD _06846_ sky130_fd_sc_hd__nand2b_1
X_10096_ network.neuron_in194.counter\[2\] _06846_ VSS VSS
+ VDD VDD _06847_ sky130_fd_sc_hd__or2_2
X_10097_ net376 _06847_ VSS VSS VDD VDD _06848_ sky130_fd_sc_hd__nand2_1
X_10098_ net543 _06848_ VSS VSS VDD VDD _06849_ sky130_fd_sc_hd__nand2_1
X_10099_ _01149_ _06848_ _06849_ VSS VSS VDD VDD _02840_ sky130_fd_sc_hd__o21ai_0
X_10100_ network.neuron_in194.counter\[0\] VSS VSS VDD VDD
+ _01146_ sky130_fd_sc_hd__inv_1
X_10101_ net542 _06848_ VSS VSS VDD VDD _06850_ sky130_fd_sc_hd__nand2_1
X_10102_ network.neuron_in194.counter\[0\] _06848_ _06850_
+ VSS VSS VDD VDD _02839_ sky130_fd_sc_hd__o21ai_0
X_10103_ network.neuron_in195.counter\[3\] _00823_ VSS VSS
+ VDD VDD _06851_ sky130_fd_sc_hd__nand2b_1
X_10104_ network.neuron_in195.counter\[2\] _06851_ VSS VSS
+ VDD VDD _06852_ sky130_fd_sc_hd__or2_2
X_10105_ net372 _06852_ VSS VSS VDD VDD _06853_ sky130_fd_sc_hd__nand2_1
X_10106_ net592 _06853_ VSS VSS VDD VDD _06854_ sky130_fd_sc_hd__nand2_1
X_10107_ _00824_ _06853_ _06854_ VSS VSS VDD VDD _02844_ sky130_fd_sc_hd__o21ai_0
X_10108_ network.neuron_in067.counter\[0\] VSS VSS VDD VDD
+ _00166_ sky130_fd_sc_hd__inv_1
X_10109_ network.neuron_in052.counter\[0\] VSS VSS VDD VDD
+ _00257_ sky130_fd_sc_hd__inv_1
X_10110_ network.neuron_in195.counter\[0\] VSS VSS VDD VDD
+ _00821_ sky130_fd_sc_hd__inv_1
X_10111_ net610 _06853_ VSS VSS VDD VDD _06855_ sky130_fd_sc_hd__nand2_1
X_10112_ network.neuron_in195.counter\[0\] _06853_ _06855_
+ VSS VSS VDD VDD _02843_ sky130_fd_sc_hd__o21ai_0
X_10113_ network.neuron_in196.counter\[0\] VSS VSS VDD VDD
+ _00970_ sky130_fd_sc_hd__inv_1
X_10114_ net537 _06778_ VSS VSS VDD VDD _06856_ sky130_fd_sc_hd__nand2_1
X_10115_ network.neuron_in196.counter\[0\] _06778_ _06856_
+ VSS VSS VDD VDD _02847_ sky130_fd_sc_hd__o21ai_0
X_10116_ network.neuron_in231.counter\[1\] VSS VSS VDD VDD
+ _00572_ sky130_fd_sc_hd__inv_1
X_10117_ network.neuron_in146.counter\[0\] VSS VSS VDD VDD
+ _00297_ sky130_fd_sc_hd__inv_1
X_10118_ network.neuron_in146.counter\[2\] _00299_ VSS VSS
+ VDD VDD _06857_ sky130_fd_sc_hd__nand2b_1
X_10119_ network.neuron_in146.counter\[3\] _06857_ VSS VSS
+ VDD VDD _06858_ sky130_fd_sc_hd__or2_2
X_10120_ net387 _06858_ VSS VSS VDD VDD _06859_ sky130_fd_sc_hd__nand2_1
X_10121_ net596 _06859_ VSS VSS VDD VDD _06860_ sky130_fd_sc_hd__nand2_1
X_10122_ network.neuron_in146.counter\[0\] _06859_ _06860_
+ VSS VSS VDD VDD _02647_ sky130_fd_sc_hd__o21ai_0
Xclkload36 clknet_leaf_157_clk_net VSS VSS VDD VDD _unconnected_30
+ sky130_fd_sc_hd__clkinv_2
X_10124_ network.neuron_in197.counter\[2\] network.neuron_in197.counter\[3\]
+ VSS VSS VDD VDD _06862_ sky130_fd_sc_hd__nor2_1
X_10125_ _01184_ _06862_ VSS VSS VDD VDD _06863_ sky130_fd_sc_hd__nand2_1
X_10126_ net376 _06863_ VSS VSS VDD VDD _06864_ sky130_fd_sc_hd__nand2_1
X_10127_ net563 _06864_ VSS VSS VDD VDD _06865_ sky130_fd_sc_hd__nand2_1
X_10128_ _01185_ _06864_ _06865_ VSS VSS VDD VDD _02852_ sky130_fd_sc_hd__o21ai_0
X_10129_ network.neuron_in197.counter\[0\] VSS VSS VDD VDD
+ _01182_ sky130_fd_sc_hd__inv_1
X_10130_ net557 _06864_ VSS VSS VDD VDD _06866_ sky130_fd_sc_hd__nand2_1
X_10131_ network.neuron_in197.counter\[0\] _06864_ _06866_
+ VSS VSS VDD VDD _02851_ sky130_fd_sc_hd__o21ai_0
X_10132_ network.neuron_in056.counter\[1\] VSS VSS VDD VDD
+ _00234_ sky130_fd_sc_hd__inv_1
X_10133_ network.neuron_in209.counter\[2\] _00811_ VSS VSS
+ VDD VDD _06867_ sky130_fd_sc_hd__xnor2_1
X_10134_ network.neuron_in209.counter\[2\] network.neuron_in209.counter\[3\]
+ VSS VSS VDD VDD _06868_ sky130_fd_sc_hd__nor2_1
X_10135_ net363 _06868_ VSS VSS VDD VDD _06869_ sky130_fd_sc_hd__nor2_1
X_10136_ net492 _06869_ VSS VSS VDD VDD _06870_ sky130_fd_sc_hd__nor2_1
X_10137_ net367 _06867_ _06870_ VSS VSS VDD VDD _02901_ sky130_fd_sc_hd__a21oi_1
X_10138_ network.neuron_in101.counter\[1\] VSS VSS VDD VDD
+ _00834_ sky130_fd_sc_hd__inv_1
X_10139_ network.neuron_in204.counter\[2\] net376 VSS VSS
+ VDD VDD _06871_ sky130_fd_sc_hd__nand2_1
X_10140_ network.in_period\[204\]\[2\] network.neuron_in204.counter\[3\]
+ _06871_ VSS VSS VDD VDD _06872_ sky130_fd_sc_hd__o21ai_0
X_10141_ _00789_ network.neuron_in204.counter\[2\] net364
+ VSS VSS VDD VDD _06873_ sky130_fd_sc_hd__or3_1
X_10142_ network.in_period\[204\]\[2\] net376 _06873_ VSS
+ VSS VDD VDD _06874_ sky130_fd_sc_hd__o21ai_0
X_10143_ _00789_ _06872_ _06874_ VSS VSS VDD VDD _02881_ sky130_fd_sc_hd__a21oi_1
X_10144_ network.neuron_in208.counter\[0\] VSS VSS VDD VDD
+ _00513_ sky130_fd_sc_hd__inv_1
X_10145_ network.neuron_in208.counter\[3\] _00515_ VSS VSS
+ VDD VDD _06875_ sky130_fd_sc_hd__nand2b_1
X_10146_ network.neuron_in208.counter\[2\] VSS VSS VDD VDD
+ _06876_ sky130_fd_sc_hd__inv_1
X_10147_ _06875_ _06876_ VSS VSS VDD VDD _06877_ sky130_fd_sc_hd__nand2b_1
X_10148_ net365 _06877_ VSS VSS VDD VDD _06878_ sky130_fd_sc_hd__nand2_1
X_10149_ net574 _06878_ VSS VSS VDD VDD _06879_ sky130_fd_sc_hd__nand2_1
X_10150_ network.neuron_in208.counter\[0\] _06878_ _06879_
+ VSS VSS VDD VDD _02895_ sky130_fd_sc_hd__o21ai_0
X_10151_ network.neuron_in078.counter\[1\] VSS VSS VDD VDD
+ _00099_ sky130_fd_sc_hd__inv_1
X_10152_ network.neuron_in072.counter\[1\] VSS VSS VDD VDD
+ _00218_ sky130_fd_sc_hd__inv_1
X_10153_ network.neuron_in201.counter\[3\] _01152_ VSS VSS
+ VDD VDD _06880_ sky130_fd_sc_hd__nand2b_1
X_10154_ network.neuron_in201.counter\[2\] VSS VSS VDD VDD
+ _06881_ sky130_fd_sc_hd__inv_1
X_10155_ _06880_ _06881_ VSS VSS VDD VDD _06882_ sky130_fd_sc_hd__nand2b_1
X_10156_ net376 _06882_ VSS VSS VDD VDD _06883_ sky130_fd_sc_hd__nand2_1
X_10157_ net530 _06883_ VSS VSS VDD VDD _06884_ sky130_fd_sc_hd__nand2_1
X_10158_ _01153_ _06883_ _06884_ VSS VSS VDD VDD _02868_ sky130_fd_sc_hd__o21ai_0
X_10159_ network.neuron_in203.counter\[2\] network.neuron_in203.counter\[3\]
+ VSS VSS VDD VDD _06885_ sky130_fd_sc_hd__nor2_1
X_10160_ _01194_ _06885_ VSS VSS VDD VDD _06886_ sky130_fd_sc_hd__nand2_1
X_10161_ net390 _06886_ VSS VSS VDD VDD _06887_ sky130_fd_sc_hd__nand2_1
X_10162_ net475 _06887_ VSS VSS VDD VDD _06888_ sky130_fd_sc_hd__nand2_1
X_10163_ network.neuron_in203.counter\[0\] _06887_ _06888_
+ VSS VSS VDD VDD _02875_ sky130_fd_sc_hd__o21ai_0
X_10164_ network.neuron_in033.counter\[0\] VSS VSS VDD VDD
+ _00575_ sky130_fd_sc_hd__inv_1
X_10165_ network.neuron_in122.counter\[1\] VSS VSS VDD VDD
+ _01059_ sky130_fd_sc_hd__inv_1
X_10166_ network.neuron_in240.counter\[1\] VSS VSS VDD VDD
+ _00522_ sky130_fd_sc_hd__inv_1
X_10167_ network.neuron_in206.counter\[3\] _00996_ VSS VSS
+ VDD VDD _06889_ sky130_fd_sc_hd__nand2b_1
X_10168_ network.neuron_in206.counter\[2\] VSS VSS VDD VDD
+ _06890_ sky130_fd_sc_hd__inv_1
X_10169_ _06889_ _06890_ VSS VSS VDD VDD _06891_ sky130_fd_sc_hd__nand2b_1
X_10170_ net367 _06891_ VSS VSS VDD VDD _06892_ sky130_fd_sc_hd__nand2_1
X_10171_ net509 _06892_ VSS VSS VDD VDD _06893_ sky130_fd_sc_hd__nand2_1
X_10172_ _00997_ _06892_ _06893_ VSS VSS VDD VDD _02888_ sky130_fd_sc_hd__o21ai_0
X_10173_ net581 _06878_ VSS VSS VDD VDD _06894_ sky130_fd_sc_hd__nand2_1
X_10174_ _00516_ _06878_ _06894_ VSS VSS VDD VDD _02896_ sky130_fd_sc_hd__o21ai_0
X_10175_ network.neuron_in200.counter\[2\] VSS VSS VDD VDD
+ _06895_ sky130_fd_sc_hd__inv_1
X_10176_ network.neuron_in200.counter\[3\] network.in_period\[200\]\[2\]
+ _00968_ net364 VSS VSS VDD VDD _06896_ sky130_fd_sc_hd__o22ai_1
Xclkload35 clknet_leaf_156_clk_net VSS VSS VDD VDD _unconnected_31
+ sky130_fd_sc_hd__clkbuf_8
X_10178_ network.neuron_in200.counter\[2\] _00968_ net372
+ VSS VSS VDD VDD _06898_ sky130_fd_sc_hd__nand3_1
X_10179_ network.in_period\[200\]\[2\] net372 _06898_ VSS
+ VSS VDD VDD _06899_ sky130_fd_sc_hd__o21ai_0
X_10180_ _06895_ _06896_ _06899_ VSS VSS VDD VDD _02865_ sky130_fd_sc_hd__a21oi_1
X_10181_ network.neuron_in201.counter\[3\] network.in_period\[201\]\[2\]
+ _01152_ net364 VSS VSS VDD VDD _06900_ sky130_fd_sc_hd__o22ai_1
X_10182_ network.neuron_in201.counter\[2\] _01152_ net376
+ VSS VSS VDD VDD _06901_ sky130_fd_sc_hd__nand3_1
X_10183_ network.in_period\[201\]\[2\] net376 _06901_ VSS
+ VSS VDD VDD _06902_ sky130_fd_sc_hd__o21ai_0
X_10184_ _06881_ _06900_ _06902_ VSS VSS VDD VDD _02869_ sky130_fd_sc_hd__a21oi_1
X_10185_ network.neuron_in055.counter\[1\] VSS VSS VDD VDD
+ _00242_ sky130_fd_sc_hd__inv_1
X_10186_ network.neuron_in194.counter\[1\] VSS VSS VDD VDD
+ _01147_ sky130_fd_sc_hd__inv_1
X_10187_ net751 _06859_ VSS VSS VDD VDD _06903_ sky130_fd_sc_hd__nand2_1
X_10188_ _00300_ _06859_ _06903_ VSS VSS VDD VDD _02648_ sky130_fd_sc_hd__o21ai_0
X_10189_ network.neuron_in202.counter\[3\] _00675_ VSS VSS
+ VDD VDD _06904_ sky130_fd_sc_hd__nand2b_1
X_10190_ network.neuron_in202.counter\[2\] VSS VSS VDD VDD
+ _06905_ sky130_fd_sc_hd__inv_1
X_10191_ _06904_ _06905_ VSS VSS VDD VDD _06906_ sky130_fd_sc_hd__nand2b_1
X_10192_ net367 _06906_ VSS VSS VDD VDD _06907_ sky130_fd_sc_hd__nand2_1
X_10193_ net514 _06907_ VSS VSS VDD VDD _06908_ sky130_fd_sc_hd__nand2_1
X_10194_ _00676_ _06907_ _06908_ VSS VSS VDD VDD _02872_ sky130_fd_sc_hd__o21ai_0
X_10195_ net473 _06887_ VSS VSS VDD VDD _06909_ sky130_fd_sc_hd__nand2_1
X_10196_ _01195_ _06887_ _06909_ VSS VSS VDD VDD _02876_ sky130_fd_sc_hd__o21ai_0
X_10197_ network.neuron_in054.counter\[1\] VSS VSS VDD VDD
+ _00246_ sky130_fd_sc_hd__inv_1
X_10198_ network.neuron_in236.counter\[1\] VSS VSS VDD VDD
+ _00370_ sky130_fd_sc_hd__inv_1
X_10199_ network.neuron_in053.counter\[1\] VSS VSS VDD VDD
+ _00254_ sky130_fd_sc_hd__inv_1
X_10200_ network.neuron_in078.counter\[0\] VSS VSS VDD VDD
+ _00098_ sky130_fd_sc_hd__inv_1
X_10201_ network.neuron_in205.counter\[2\] VSS VSS VDD VDD
+ _06910_ sky130_fd_sc_hd__inv_1
X_10202_ network.neuron_in205.counter\[3\] network.in_period\[205\]\[2\]
+ _00960_ net363 VSS VSS VDD VDD _06911_ sky130_fd_sc_hd__o22ai_1
X_10203_ network.neuron_in205.counter\[2\] _00960_ net367
+ VSS VSS VDD VDD _06912_ sky130_fd_sc_hd__nand3_1
X_10204_ network.in_period\[205\]\[2\] net367 _06912_ VSS
+ VSS VDD VDD _06913_ sky130_fd_sc_hd__o21ai_0
X_10205_ _06910_ _06911_ _06913_ VSS VSS VDD VDD _02885_ sky130_fd_sc_hd__a21oi_1
Xclkload34 clknet_leaf_155_clk_net VSS VSS VDD VDD _unconnected_32
+ sky130_fd_sc_hd__clkinv_2
Xclkload33 clknet_leaf_154_clk_net VSS VSS VDD VDD _unconnected_33
+ sky130_fd_sc_hd__clkbuf_1
X_10208_ network.neuron_in206.counter\[3\] network.in_period\[206\]\[2\]
+ _00996_ net363 VSS VSS VDD VDD _06916_ sky130_fd_sc_hd__o22ai_1
Xclkload32 clknet_leaf_153_clk_net VSS VSS VDD VDD _unconnected_34
+ sky130_fd_sc_hd__clkbuf_1
Xclkload31 clknet_leaf_152_clk_net VSS VSS VDD VDD _unconnected_35
+ sky130_fd_sc_hd__clkbuf_8
X_10211_ network.neuron_in206.counter\[2\] _00996_ net367
+ VSS VSS VDD VDD _06919_ sky130_fd_sc_hd__nand3_1
X_10212_ network.in_period\[206\]\[2\] net367 _06919_ VSS
+ VSS VDD VDD _06920_ sky130_fd_sc_hd__o21ai_0
X_10213_ _06890_ _06916_ _06920_ VSS VSS VDD VDD _02889_ sky130_fd_sc_hd__a21oi_1
X_10214_ network.neuron_in207.counter\[2\] VSS VSS VDD VDD
+ _06921_ sky130_fd_sc_hd__inv_1
X_10215_ network.neuron_in207.counter\[3\] network.in_period\[207\]\[2\]
+ _00815_ net363 VSS VSS VDD VDD _06922_ sky130_fd_sc_hd__o22ai_1
X_10216_ network.neuron_in207.counter\[2\] _00815_ net367
+ VSS VSS VDD VDD _06923_ sky130_fd_sc_hd__nand3_1
X_10217_ network.in_period\[207\]\[2\] net367 _06923_ VSS
+ VSS VDD VDD _06924_ sky130_fd_sc_hd__o21ai_0
X_10218_ _06921_ _06922_ _06924_ VSS VSS VDD VDD _02893_ sky130_fd_sc_hd__a21oi_1
X_10219_ network.neuron_in068.counter\[0\] VSS VSS VDD VDD
+ _00160_ sky130_fd_sc_hd__inv_1
X_10220_ network.neuron_in208.counter\[3\] network.in_period\[208\]\[2\]
+ _00515_ net363 VSS VSS VDD VDD _06925_ sky130_fd_sc_hd__o22ai_1
X_10221_ network.neuron_in208.counter\[2\] _00515_ net365
+ VSS VSS VDD VDD _06926_ sky130_fd_sc_hd__nand3_1
X_10222_ network.in_period\[208\]\[2\] net365 _06926_ VSS
+ VSS VDD VDD _06927_ sky130_fd_sc_hd__o21ai_0
X_10223_ _06876_ _06925_ _06927_ VSS VSS VDD VDD _02897_ sky130_fd_sc_hd__a21oi_1
Xclkload30 clknet_leaf_151_clk_net VSS VSS VDD VDD _unconnected_36
+ sky130_fd_sc_hd__clkbuf_8
X_10225_ network.neuron_in199.counter\[3\] _01180_ VSS VSS
+ VDD VDD _06929_ sky130_fd_sc_hd__nand2b_1
X_10226_ network.neuron_in199.counter\[2\] _06929_ VSS VSS
+ VDD VDD _06930_ sky130_fd_sc_hd__or2_2
X_10227_ net376 _06930_ VSS VSS VDD VDD _06931_ sky130_fd_sc_hd__nand2_1
X_10228_ net535 _06931_ VSS VSS VDD VDD _06932_ sky130_fd_sc_hd__nand2_1
X_10229_ _01181_ _06931_ _06932_ VSS VSS VDD VDD _02860_ sky130_fd_sc_hd__o21ai_0
X_10230_ network.neuron_in199.counter\[0\] VSS VSS VDD VDD
+ _01178_ sky130_fd_sc_hd__inv_1
X_10231_ net550 _06931_ VSS VSS VDD VDD _06933_ sky130_fd_sc_hd__nand2_1
X_10232_ network.neuron_in199.counter\[0\] _06931_ _06933_
+ VSS VSS VDD VDD _02859_ sky130_fd_sc_hd__o21ai_0
X_10233_ network.neuron_in081.counter\[0\] VSS VSS VDD VDD
+ _00081_ sky130_fd_sc_hd__inv_1
X_10234_ network.neuron_in141.counter\[1\] VSS VSS VDD VDD
+ _00157_ sky130_fd_sc_hd__inv_1
X_10235_ network.neuron_in059.counter\[0\] VSS VSS VDD VDD
+ _00221_ sky130_fd_sc_hd__inv_1
X_10236_ network.neuron_in219.counter\[1\] VSS VSS VDD VDD
+ _00314_ sky130_fd_sc_hd__inv_1
X_10237_ network.neuron_in110.counter\[1\] VSS VSS VDD VDD
+ _00548_ sky130_fd_sc_hd__inv_1
X_10238_ network.neuron_in122.counter\[0\] VSS VSS VDD VDD
+ _01058_ sky130_fd_sc_hd__inv_1
X_10239_ network.neuron_in033.counter\[1\] VSS VSS VDD VDD
+ _00576_ sky130_fd_sc_hd__inv_1
X_10240_ network.neuron_in215.counter\[0\] VSS VSS VDD VDD
+ _00301_ sky130_fd_sc_hd__inv_1
X_10241_ network.neuron_in129.counter\[2\] _00403_ VSS VSS
+ VDD VDD _06934_ sky130_fd_sc_hd__xnor2_1
X_10242_ network.neuron_in129.counter\[2\] network.neuron_in129.counter\[3\]
+ VSS VSS VDD VDD _06935_ sky130_fd_sc_hd__nor2_1
X_10243_ net357 _06935_ VSS VSS VDD VDD _06936_ sky130_fd_sc_hd__nor2_1
X_10244_ network.in_period\[129\]\[2\] _06936_ VSS VSS VDD
+ VDD _06937_ sky130_fd_sc_hd__nor2_1
X_10245_ net384 _06934_ _06937_ VSS VSS VDD VDD _02581_ sky130_fd_sc_hd__a21oi_1
X_10246_ network.neuron_in198.counter\[1\] VSS VSS VDD VDD
+ _01175_ sky130_fd_sc_hd__inv_1
X_10247_ network.neuron_in052.counter\[1\] VSS VSS VDD VDD
+ _00258_ sky130_fd_sc_hd__inv_1
X_10248_ network.neuron_in146.counter\[1\] VSS VSS VDD VDD
+ _00298_ sky130_fd_sc_hd__inv_1
X_10249_ network.neuron_in144.counter\[2\] network.neuron_in144.counter\[3\]
+ VSS VSS VDD VDD _06938_ sky130_fd_sc_hd__nor2_1
X_10250_ _00667_ _06938_ VSS VSS VDD VDD _06939_ sky130_fd_sc_hd__nand2_1
X_10251_ net387 _06939_ VSS VSS VDD VDD _06940_ sky130_fd_sc_hd__nand2_1
X_10252_ net759 _06940_ VSS VSS VDD VDD _06941_ sky130_fd_sc_hd__nand2_1
X_10253_ _00668_ _06940_ _06941_ VSS VSS VDD VDD _02640_ sky130_fd_sc_hd__o21ai_0
X_10254_ network.neuron_in155.counter\[3\] _01099_ VSS VSS
+ VDD VDD _06942_ sky130_fd_sc_hd__nand2b_1
X_10255_ network.neuron_in155.counter\[2\] VSS VSS VDD VDD
+ _06943_ sky130_fd_sc_hd__inv_1
X_10256_ _06942_ _06943_ VSS VSS VDD VDD _06944_ sky130_fd_sc_hd__nand2b_1
X_10257_ net384 _06944_ VSS VSS VDD VDD _06945_ sky130_fd_sc_hd__nand2_1
X_10258_ net709 _06945_ VSS VSS VDD VDD _06946_ sky130_fd_sc_hd__nand2_1
X_10259_ _01100_ _06945_ _06946_ VSS VSS VDD VDD _02684_ sky130_fd_sc_hd__o21ai_0
X_10260_ network.neuron_in155.counter\[3\] network.in_period\[155\]\[2\]
+ _01099_ net357 VSS VSS VDD VDD _06947_ sky130_fd_sc_hd__o22ai_1
X_10261_ network.neuron_in155.counter\[2\] _01099_ net384
+ VSS VSS VDD VDD _06948_ sky130_fd_sc_hd__nand3_1
X_10262_ network.in_period\[155\]\[2\] net384 _06948_ VSS
+ VSS VDD VDD _06949_ sky130_fd_sc_hd__o21ai_0
X_10263_ _06943_ _06947_ _06949_ VSS VSS VDD VDD _02685_ sky130_fd_sc_hd__a21oi_1
X_10264_ network.neuron_in172.counter\[1\] VSS VSS VDD VDD
+ _01049_ sky130_fd_sc_hd__inv_1
X_10265_ network.neuron_in234.counter\[1\] VSS VSS VDD VDD
+ _00580_ sky130_fd_sc_hd__inv_1
X_10266_ network.neuron_in148.counter\[0\] VSS VSS VDD VDD
+ _00533_ sky130_fd_sc_hd__inv_1
X_10267_ network.neuron_in148.counter\[2\] VSS VSS VDD VDD
+ _06950_ sky130_fd_sc_hd__inv_1
X_10268_ _06950_ _00535_ VSS VSS VDD VDD _06951_ sky130_fd_sc_hd__nand2_1
X_10269_ network.neuron_in148.counter\[3\] _06951_ VSS VSS
+ VDD VDD _06952_ sky130_fd_sc_hd__or2_2
X_10270_ net387 _06952_ VSS VSS VDD VDD _06953_ sky130_fd_sc_hd__nand2_1
X_10271_ net660 _06953_ VSS VSS VDD VDD _06954_ sky130_fd_sc_hd__nand2_1
X_10272_ network.neuron_in148.counter\[0\] _06953_ _06954_
+ VSS VSS VDD VDD _02655_ sky130_fd_sc_hd__o21ai_0
X_10273_ network.neuron_in049.counter\[1\] VSS VSS VDD VDD
+ _00262_ sky130_fd_sc_hd__inv_1
X_10274_ network.neuron_in048.counter\[1\] VSS VSS VDD VDD
+ _00266_ sky130_fd_sc_hd__inv_1
X_10275_ network.neuron_in047.counter\[1\] VSS VSS VDD VDD
+ _00274_ sky130_fd_sc_hd__inv_1
X_10276_ network.neuron_in050.counter\[0\] VSS VSS VDD VDD
+ _00333_ sky130_fd_sc_hd__inv_1
X_10277_ network.neuron_in143.counter\[0\] VSS VSS VDD VDD
+ _00715_ sky130_fd_sc_hd__inv_1
X_10278_ network.neuron_in143.counter\[2\] network.neuron_in143.counter\[3\]
+ VSS VSS VDD VDD _06955_ sky130_fd_sc_hd__nor2_1
X_10279_ _00717_ _06955_ VSS VSS VDD VDD _06956_ sky130_fd_sc_hd__nand2_1
X_10280_ net377 _06956_ VSS VSS VDD VDD _06957_ sky130_fd_sc_hd__nand2_1
X_10281_ network.in_period\[143\]\[0\] _06957_ VSS VSS VDD
+ VDD _06958_ sky130_fd_sc_hd__nand2_1
X_10282_ network.neuron_in143.counter\[0\] _06957_ _06958_
+ VSS VSS VDD VDD _02635_ sky130_fd_sc_hd__o21ai_0
X_10283_ network.neuron_in172.counter\[0\] VSS VSS VDD VDD
+ _01048_ sky130_fd_sc_hd__inv_1
X_10284_ network.neuron_in062.counter\[0\] VSS VSS VDD VDD
+ _00583_ sky130_fd_sc_hd__inv_1
X_10285_ net356 _06938_ VSS VSS VDD VDD _06959_ sky130_fd_sc_hd__nor2_1
X_10286_ network.neuron_in144.counter\[2\] _00667_ VSS VSS
+ VDD VDD _06960_ sky130_fd_sc_hd__xnor2_1
X_10287_ network.in_period\[144\]\[2\] _06959_ _06960_ net386
+ VSS VSS VDD VDD _02641_ sky130_fd_sc_hd__a2bb2oi_1
X_10288_ network.neuron_in210.counter\[1\] VSS VSS VDD VDD
+ _01143_ sky130_fd_sc_hd__inv_1
X_10289_ network.neuron_in113.counter\[1\] VSS VSS VDD VDD
+ _01090_ sky130_fd_sc_hd__inv_1
X_10290_ network.neuron_in128.counter\[1\] VSS VSS VDD VDD
+ _01045_ sky130_fd_sc_hd__inv_1
X_10291_ network.neuron_in212.counter\[1\] VSS VSS VDD VDD
+ _01171_ sky130_fd_sc_hd__inv_1
X_10292_ network.neuron_in046.counter\[1\] VSS VSS VDD VDD
+ _00278_ sky130_fd_sc_hd__inv_1
X_10293_ network.neuron_in044.counter\[1\] VSS VSS VDD VDD
+ _00282_ sky130_fd_sc_hd__inv_1
X_10294_ network.neuron_in174.counter\[1\] VSS VSS VDD VDD
+ _00908_ sky130_fd_sc_hd__inv_1
X_10295_ network.neuron_hid4.IF0.ref_counter\[1\] VSS VSS
+ VDD VDD _01133_ sky130_fd_sc_hd__inv_1
X_10296_ network.neuron_in045.counter\[1\] VSS VSS VDD VDD
+ _00286_ sky130_fd_sc_hd__inv_1
X_10297_ network.neuron_in157.counter\[2\] network.neuron_in157.counter\[3\]
+ VSS VSS VDD VDD _06961_ sky130_fd_sc_hd__nor2_1
X_10298_ _00691_ _06961_ VSS VSS VDD VDD _06962_ sky130_fd_sc_hd__nand2_1
X_10299_ net381 _06962_ VSS VSS VDD VDD _06963_ sky130_fd_sc_hd__nand2_1
X_10300_ net752 _06963_ VSS VSS VDD VDD _06964_ sky130_fd_sc_hd__nand2_1
X_10301_ _00692_ _06963_ _06964_ VSS VSS VDD VDD _02692_ sky130_fd_sc_hd__o21ai_0
X_10302_ network.neuron_in160.counter\[1\] VSS VSS VDD VDD
+ _01086_ sky130_fd_sc_hd__inv_1
X_10303_ network.in_period\[143\]\[1\] _06957_ VSS VSS VDD
+ VDD _06965_ sky130_fd_sc_hd__nand2_1
X_10304_ _00718_ _06957_ _06965_ VSS VSS VDD VDD _02636_ sky130_fd_sc_hd__o21ai_0
X_10305_ network.neuron_in213.counter\[1\] VSS VSS VDD VDD
+ _00991_ sky130_fd_sc_hd__inv_1
X_10306_ network.neuron_in062.counter\[1\] VSS VSS VDD VDD
+ _00584_ sky130_fd_sc_hd__inv_1
X_10307_ network.neuron_in124.counter\[1\] VSS VSS VDD VDD
+ _00366_ sky130_fd_sc_hd__inv_1
X_10308_ network.neuron_in134.counter\[1\] VSS VSS VDD VDD
+ _00884_ sky130_fd_sc_hd__inv_1
X_10309_ network.neuron_in128.counter\[0\] VSS VSS VDD VDD
+ _01044_ sky130_fd_sc_hd__inv_1
X_10310_ network.neuron_in200.counter\[3\] _00968_ VSS VSS
+ VDD VDD _06966_ sky130_fd_sc_hd__nand2b_1
X_10311_ _06966_ _06895_ VSS VSS VDD VDD _06967_ sky130_fd_sc_hd__nand2b_1
X_10312_ net375 _06967_ VSS VSS VDD VDD _06968_ sky130_fd_sc_hd__nand2_1
X_10313_ net607 _06968_ VSS VSS VDD VDD _06969_ sky130_fd_sc_hd__nand2_1
X_10314_ _00969_ _06968_ _06969_ VSS VSS VDD VDD _02864_ sky130_fd_sc_hd__o21ai_0
X_10315_ network.neuron_in063.counter\[1\] VSS VSS VDD VDD
+ _00202_ sky130_fd_sc_hd__inv_1
X_10316_ network.neuron_in200.counter\[0\] VSS VSS VDD VDD
+ _00966_ sky130_fd_sc_hd__inv_1
X_10317_ net624 _06968_ VSS VSS VDD VDD _06970_ sky130_fd_sc_hd__nand2_1
X_10318_ network.neuron_in200.counter\[0\] _06968_ _06970_
+ VSS VSS VDD VDD _02863_ sky130_fd_sc_hd__o21ai_0
X_10319_ network.neuron_in201.counter\[0\] VSS VSS VDD VDD
+ _01150_ sky130_fd_sc_hd__inv_1
X_10320_ net526 _06883_ VSS VSS VDD VDD _06971_ sky130_fd_sc_hd__nand2_1
X_10321_ network.neuron_in201.counter\[0\] _06883_ _06971_
+ VSS VSS VDD VDD _02867_ sky130_fd_sc_hd__o21ai_0
X_10322_ network.neuron_in202.counter\[3\] network.in_period\[202\]\[2\]
+ _00675_ net364 VSS VSS VDD VDD _06972_ sky130_fd_sc_hd__o22ai_1
X_10323_ network.neuron_in202.counter\[2\] _00675_ net367
+ VSS VSS VDD VDD _06973_ sky130_fd_sc_hd__nand3_1
X_10324_ network.in_period\[202\]\[2\] net367 _06973_ VSS
+ VSS VDD VDD _06974_ sky130_fd_sc_hd__o21ai_0
X_10325_ _06905_ _06972_ _06974_ VSS VSS VDD VDD _02873_ sky130_fd_sc_hd__a21oi_1
X_10326_ network.neuron_in202.counter\[0\] VSS VSS VDD VDD
+ _00673_ sky130_fd_sc_hd__inv_1
X_10327_ net522 _06907_ VSS VSS VDD VDD _06975_ sky130_fd_sc_hd__nand2_1
X_10328_ network.neuron_in202.counter\[0\] _06907_ _06975_
+ VSS VSS VDD VDD _02871_ sky130_fd_sc_hd__o21ai_0
X_10329_ network.neuron_in203.counter\[2\] VSS VSS VDD VDD
+ _06976_ sky130_fd_sc_hd__inv_1
X_10330_ network.neuron_in203.counter\[3\] network.in_period\[203\]\[2\]
+ _01194_ net364 VSS VSS VDD VDD _06977_ sky130_fd_sc_hd__o22ai_1
X_10331_ network.neuron_in203.counter\[2\] _01194_ net390
+ VSS VSS VDD VDD _06978_ sky130_fd_sc_hd__nand3_1
X_10332_ network.in_period\[203\]\[2\] net390 _06978_ VSS
+ VSS VDD VDD _06979_ sky130_fd_sc_hd__o21ai_0
X_10333_ _06976_ _06977_ _06979_ VSS VSS VDD VDD _02877_ sky130_fd_sc_hd__a21oi_1
X_10334_ network.neuron_in050.counter\[1\] VSS VSS VDD VDD
+ _00334_ sky130_fd_sc_hd__inv_1
X_10335_ network.neuron_in177.counter\[0\] VSS VSS VDD VDD
+ _00587_ sky130_fd_sc_hd__inv_1
X_10336_ network.neuron_in123.counter\[1\] VSS VSS VDD VDD
+ _00206_ sky130_fd_sc_hd__inv_1
X_10337_ network.neuron_in176.counter\[1\] VSS VSS VDD VDD
+ _00728_ sky130_fd_sc_hd__inv_1
X_10338_ network.neuron_in204.counter\[2\] network.neuron_in204.counter\[3\]
+ VSS VSS VDD VDD _06980_ sky130_fd_sc_hd__nor2_1
X_10339_ _00789_ _06980_ VSS VSS VDD VDD _06981_ sky130_fd_sc_hd__nand2_1
X_10340_ net376 _06981_ VSS VSS VDD VDD _06982_ sky130_fd_sc_hd__nand2_1
X_10341_ net571 _06982_ VSS VSS VDD VDD _06983_ sky130_fd_sc_hd__nand2_1
X_10342_ _00790_ _06982_ _06983_ VSS VSS VDD VDD _02880_ sky130_fd_sc_hd__o21ai_0
X_10343_ network.neuron_in204.counter\[0\] VSS VSS VDD VDD
+ _00787_ sky130_fd_sc_hd__inv_1
X_10344_ net559 _06982_ VSS VSS VDD VDD _06984_ sky130_fd_sc_hd__nand2_1
X_10345_ network.neuron_in204.counter\[0\] _06982_ _06984_
+ VSS VSS VDD VDD _02879_ sky130_fd_sc_hd__o21ai_0
X_10346_ network.neuron_in205.counter\[3\] _00960_ VSS VSS
+ VDD VDD _06985_ sky130_fd_sc_hd__nand2b_1
X_10347_ _06985_ _06910_ VSS VSS VDD VDD _06986_ sky130_fd_sc_hd__nand2b_1
X_10348_ net367 _06986_ VSS VSS VDD VDD _06987_ sky130_fd_sc_hd__nand2_1
X_10349_ net515 _06987_ VSS VSS VDD VDD _06988_ sky130_fd_sc_hd__nand2_1
X_10350_ _00961_ _06987_ _06988_ VSS VSS VDD VDD _02884_ sky130_fd_sc_hd__o21ai_0
X_10351_ network.neuron_in043.counter\[1\] VSS VSS VDD VDD
+ _00290_ sky130_fd_sc_hd__inv_1
X_10352_ network.neuron_in082.counter\[1\] VSS VSS VDD VDD
+ _00058_ sky130_fd_sc_hd__inv_1
X_10353_ network.neuron_in255.counter\[1\] VSS VSS VDD VDD
+ _01039_ sky130_fd_sc_hd__inv_1
X_10354_ network.neuron_in205.counter\[0\] VSS VSS VDD VDD
+ _00958_ sky130_fd_sc_hd__inv_1
X_10355_ net519 _06987_ VSS VSS VDD VDD _06989_ sky130_fd_sc_hd__nand2_1
X_10356_ network.neuron_in205.counter\[0\] _06987_ _06989_
+ VSS VSS VDD VDD _02883_ sky130_fd_sc_hd__o21ai_0
X_10357_ network.neuron_in157.counter\[0\] VSS VSS VDD VDD
+ _00689_ sky130_fd_sc_hd__inv_1
X_10358_ network.neuron_in142.counter\[2\] network.neuron_in142.counter\[3\]
+ VSS VSS VDD VDD _06990_ sky130_fd_sc_hd__nor2_1
X_10359_ _00557_ _06990_ VSS VSS VDD VDD _06991_ sky130_fd_sc_hd__nand2_1
X_10360_ net377 _06991_ VSS VSS VDD VDD _06992_ sky130_fd_sc_hd__nand2_1
X_10361_ net629 _06992_ VSS VSS VDD VDD _06993_ sky130_fd_sc_hd__nand2_1
X_10362_ network.neuron_in142.counter\[0\] _06992_ _06993_
+ VSS VSS VDD VDD _02631_ sky130_fd_sc_hd__o21ai_0
Xclkload29 clknet_leaf_168_clk_net VSS VSS VDD VDD _unconnected_37
+ sky130_fd_sc_hd__clkbuf_8
X_10364_ net360 _06955_ VSS VSS VDD VDD _06995_ sky130_fd_sc_hd__nor2_1
X_10365_ network.neuron_in143.counter\[2\] _00717_ VSS VSS
+ VDD VDD _06996_ sky130_fd_sc_hd__xnor2_1
X_10366_ network.in_period\[143\]\[2\] _06995_ _06996_ net377
+ VSS VSS VDD VDD _02637_ sky130_fd_sc_hd__a2bb2oi_1
X_10367_ network.neuron_in079.counter\[1\] VSS VSS VDD VDD
+ _00095_ sky130_fd_sc_hd__inv_1
X_10368_ network.neuron_in144.counter\[0\] VSS VSS VDD VDD
+ _00665_ sky130_fd_sc_hd__inv_1
X_10369_ network.neuron_in024.counter\[1\] VSS VSS VDD VDD
+ _00394_ sky130_fd_sc_hd__inv_1
X_10370_ network.neuron_in218.counter\[1\] VSS VSS VDD VDD
+ _00987_ sky130_fd_sc_hd__inv_1
X_10371_ network.neuron_in141.counter\[0\] VSS VSS VDD VDD
+ _00156_ sky130_fd_sc_hd__inv_1
X_10372_ network.neuron_in206.counter\[0\] VSS VSS VDD VDD
+ _00994_ sky130_fd_sc_hd__inv_1
X_10373_ net510 _06892_ VSS VSS VDD VDD _06997_ sky130_fd_sc_hd__nand2_1
X_10374_ network.neuron_in206.counter\[0\] _06892_ _06997_
+ VSS VSS VDD VDD _02887_ sky130_fd_sc_hd__o21ai_0
X_10375_ network.neuron_in115.counter\[1\] VSS VSS VDD VDD
+ _01223_ sky130_fd_sc_hd__inv_1
X_10376_ network.neuron_in177.counter\[1\] VSS VSS VDD VDD
+ _00588_ sky130_fd_sc_hd__inv_1
X_10377_ network.neuron_in255.counter\[0\] VSS VSS VDD VDD
+ _01038_ sky130_fd_sc_hd__inv_1
X_10378_ network.neuron_in207.counter\[2\] network.neuron_in207.counter\[3\]
+ VSS VSS VDD VDD _06998_ sky130_fd_sc_hd__nor2_1
X_10379_ _00815_ _06998_ VSS VSS VDD VDD _06999_ sky130_fd_sc_hd__nand2_1
X_10380_ net367 _06999_ VSS VSS VDD VDD _07000_ sky130_fd_sc_hd__nand2_1
X_10381_ net551 _07000_ VSS VSS VDD VDD _07001_ sky130_fd_sc_hd__nand2_1
X_10382_ _00816_ _07000_ _07001_ VSS VSS VDD VDD _02892_ sky130_fd_sc_hd__o21ai_0
X_10383_ network.neuron_in039.counter\[1\] VSS VSS VDD VDD
+ _00326_ sky130_fd_sc_hd__inv_1
X_10384_ network.neuron_in207.counter\[0\] VSS VSS VDD VDD
+ _00813_ sky130_fd_sc_hd__inv_1
X_10385_ net540 _07000_ VSS VSS VDD VDD _07002_ sky130_fd_sc_hd__nand2_1
X_10386_ network.neuron_in207.counter\[0\] _07000_ _07002_
+ VSS VSS VDD VDD _02891_ sky130_fd_sc_hd__o21ai_0
X_10387_ network.neuron_in219.counter\[2\] VSS VSS VDD VDD
+ _07003_ sky130_fd_sc_hd__inv_1
X_10388_ network.neuron_in219.counter\[3\] network.in_period\[219\]\[2\]
+ _00315_ net362 VSS VSS VDD VDD _07004_ sky130_fd_sc_hd__o22ai_1
X_10389_ network.neuron_in219.counter\[2\] _00315_ net366
+ VSS VSS VDD VDD _07005_ sky130_fd_sc_hd__nand3_1
X_10390_ network.in_period\[219\]\[2\] net366 _07005_ VSS
+ VSS VDD VDD _07006_ sky130_fd_sc_hd__o21ai_0
X_10391_ _07003_ _07004_ _07006_ VSS VSS VDD VDD _02941_ sky130_fd_sc_hd__a21oi_1
X_10392_ network.neuron_in214.counter\[2\] VSS VSS VDD VDD
+ _07007_ sky130_fd_sc_hd__inv_1
X_10393_ network.neuron_in214.counter\[3\] network.in_period\[214\]\[2\]
+ _01000_ net363 VSS VSS VDD VDD _07008_ sky130_fd_sc_hd__o22ai_1
Xclkload28 clknet_leaf_167_clk_net VSS VSS VDD VDD _unconnected_38
+ sky130_fd_sc_hd__clkbuf_8
X_10395_ network.neuron_in214.counter\[2\] _01000_ net365
+ VSS VSS VDD VDD _07010_ sky130_fd_sc_hd__nand3_1
X_10396_ network.in_period\[214\]\[2\] net365 _07010_ VSS
+ VSS VDD VDD _07011_ sky130_fd_sc_hd__o21ai_0
X_10397_ _07007_ _07008_ _07011_ VSS VSS VDD VDD _02921_ sky130_fd_sc_hd__a21oi_1
X_10398_ net615 _06992_ VSS VSS VDD VDD _07012_ sky130_fd_sc_hd__nand2_1
X_10399_ _00558_ _06992_ _07012_ VSS VSS VDD VDD _02632_ sky130_fd_sc_hd__o21ai_0
X_10400_ network.neuron_in220.counter\[1\] VSS VSS VDD VDD
+ _01035_ sky130_fd_sc_hd__inv_1
X_10401_ network.neuron_in245.counter\[1\] VSS VSS VDD VDD
+ _00696_ sky130_fd_sc_hd__inv_1
X_10402_ network.neuron_in218.counter\[0\] VSS VSS VDD VDD
+ _00986_ sky130_fd_sc_hd__inv_1
X_10403_ network.neuron_in218.counter\[3\] _00988_ VSS VSS
+ VDD VDD _07013_ sky130_fd_sc_hd__nand2b_1
X_10404_ network.neuron_in218.counter\[2\] VSS VSS VDD VDD
+ _07014_ sky130_fd_sc_hd__inv_1
X_10405_ _07013_ _07014_ VSS VSS VDD VDD _07015_ sky130_fd_sc_hd__nand2b_1
X_10406_ net365 _07015_ VSS VSS VDD VDD _07016_ sky130_fd_sc_hd__nand2_1
X_10407_ net578 _07016_ VSS VSS VDD VDD _07017_ sky130_fd_sc_hd__nand2_1
X_10408_ network.neuron_in218.counter\[0\] _07016_ _07017_
+ VSS VSS VDD VDD _02935_ sky130_fd_sc_hd__o21ai_0
X_10409_ network.neuron_in211.counter\[3\] _00956_ VSS VSS
+ VDD VDD _07018_ sky130_fd_sc_hd__nand2b_1
X_10410_ network.neuron_in211.counter\[2\] VSS VSS VDD VDD
+ _07019_ sky130_fd_sc_hd__inv_1
X_10411_ _07018_ _07019_ VSS VSS VDD VDD _07020_ sky130_fd_sc_hd__nand2b_1
X_10412_ net367 _07020_ VSS VSS VDD VDD _07021_ sky130_fd_sc_hd__nand2_1
X_10413_ net513 _07021_ VSS VSS VDD VDD _07022_ sky130_fd_sc_hd__nand2_1
X_10414_ _00957_ _07021_ _07022_ VSS VSS VDD VDD _02908_ sky130_fd_sc_hd__o21ai_0
X_10415_ network.neuron_in061.counter\[0\] VSS VSS VDD VDD
+ _00591_ sky130_fd_sc_hd__inv_1
X_10416_ network.neuron_in213.counter\[0\] VSS VSS VDD VDD
+ _00990_ sky130_fd_sc_hd__inv_1
X_10417_ network.neuron_in213.counter\[3\] _00992_ VSS VSS
+ VDD VDD _07023_ sky130_fd_sc_hd__nand2b_1
X_10418_ network.neuron_in213.counter\[2\] VSS VSS VDD VDD
+ _07024_ sky130_fd_sc_hd__inv_1
X_10419_ _07023_ _07024_ VSS VSS VDD VDD _07025_ sky130_fd_sc_hd__nand2b_1
X_10420_ net365 _07025_ VSS VSS VDD VDD _07026_ sky130_fd_sc_hd__nand2_1
X_10421_ net584 _07026_ VSS VSS VDD VDD _07027_ sky130_fd_sc_hd__nand2_1
X_10422_ network.neuron_in213.counter\[0\] _07026_ _07027_
+ VSS VSS VDD VDD _02915_ sky130_fd_sc_hd__o21ai_0
X_10423_ network.neuron_in216.counter\[2\] VSS VSS VDD VDD
+ _07028_ sky130_fd_sc_hd__inv_1
X_10424_ network.neuron_in216.counter\[3\] network.in_period\[216\]\[2\]
+ _00938_ net363 VSS VSS VDD VDD _07029_ sky130_fd_sc_hd__o22ai_1
X_10425_ network.neuron_in216.counter\[2\] _00938_ net366
+ VSS VSS VDD VDD _07030_ sky130_fd_sc_hd__nand3_1
X_10426_ network.in_period\[216\]\[2\] net366 _07030_ VSS
+ VSS VDD VDD _07031_ sky130_fd_sc_hd__o21ai_0
X_10427_ _07028_ _07029_ _07031_ VSS VSS VDD VDD _02929_ sky130_fd_sc_hd__a21oi_1
X_10428_ network.neuron_in038.counter\[1\] VSS VSS VDD VDD
+ _00330_ sky130_fd_sc_hd__inv_1
X_10429_ net573 _07016_ VSS VSS VDD VDD _07032_ sky130_fd_sc_hd__nand2_1
X_10430_ _00989_ _07016_ _07032_ VSS VSS VDD VDD _02936_ sky130_fd_sc_hd__o21ai_0
X_10431_ network.neuron_in224.counter\[1\] VSS VSS VDD VDD
+ _01189_ sky130_fd_sc_hd__inv_1
X_10432_ network.neuron_in133.counter\[0\] VSS VSS VDD VDD
+ _00472_ sky130_fd_sc_hd__inv_1
Xclkload27 clknet_leaf_166_clk_net VSS VSS VDD VDD _unconnected_39
+ sky130_fd_sc_hd__clkbuf_1
X_10434_ network.neuron_in133.counter\[3\] _00474_ VSS VSS
+ VDD VDD _07034_ sky130_fd_sc_hd__nand2b_1
X_10435_ network.neuron_in133.counter\[2\] VSS VSS VDD VDD
+ _07035_ sky130_fd_sc_hd__inv_1
X_10436_ _07034_ _07035_ VSS VSS VDD VDD _07036_ sky130_fd_sc_hd__nand2b_1
X_10437_ net381 _07036_ VSS VSS VDD VDD _07037_ sky130_fd_sc_hd__nand2_1
X_10438_ network.in_period\[133\]\[0\] _07037_ VSS VSS VDD
+ VDD _07038_ sky130_fd_sc_hd__nand2_1
X_10439_ network.neuron_in133.counter\[0\] _07037_ _07038_
+ VSS VSS VDD VDD _02595_ sky130_fd_sc_hd__o21ai_0
X_10440_ network.neuron_in210.counter\[2\] net367 VSS VSS
+ VDD VDD _07039_ sky130_fd_sc_hd__nand2_1
X_10441_ network.neuron_in210.counter\[3\] network.in_period\[210\]\[2\]
+ _07039_ VSS VSS VDD VDD _07040_ sky130_fd_sc_hd__o21ai_0
X_10442_ _01144_ network.neuron_in210.counter\[2\] net363
+ VSS VSS VDD VDD _07041_ sky130_fd_sc_hd__or3_1
X_10443_ network.in_period\[210\]\[2\] net367 _07041_ VSS
+ VSS VDD VDD _07042_ sky130_fd_sc_hd__o21ai_0
X_10444_ _01144_ _07040_ _07042_ VSS VSS VDD VDD _02905_ sky130_fd_sc_hd__a21oi_1
X_10445_ network.neuron_in211.counter\[3\] network.in_period\[211\]\[2\]
+ _00956_ net363 VSS VSS VDD VDD _07043_ sky130_fd_sc_hd__o22ai_1
Xclkload26 clknet_leaf_165_clk_net VSS VSS VDD VDD _unconnected_40
+ sky130_fd_sc_hd__clkbuf_8
X_10447_ network.neuron_in211.counter\[2\] _00956_ net367
+ VSS VSS VDD VDD _07045_ sky130_fd_sc_hd__nand3_1
X_10448_ network.in_period\[211\]\[2\] net367 _07045_ VSS
+ VSS VDD VDD _07046_ sky130_fd_sc_hd__o21ai_0
X_10449_ _07019_ _07043_ _07046_ VSS VSS VDD VDD _02909_ sky130_fd_sc_hd__a21oi_1
X_10450_ network.neuron_in212.counter\[2\] VSS VSS VDD VDD
+ _07047_ sky130_fd_sc_hd__inv_1
X_10451_ _07047_ _01172_ VSS VSS VDD VDD _07048_ sky130_fd_sc_hd__nand2_1
X_10452_ network.neuron_in212.counter\[3\] _07048_ VSS VSS
+ VDD VDD _07049_ sky130_fd_sc_hd__or2_2
X_10453_ net367 _07049_ VSS VSS VDD VDD _07050_ sky130_fd_sc_hd__nand2_1
X_10454_ net518 _07050_ VSS VSS VDD VDD _07051_ sky130_fd_sc_hd__nand2_1
X_10455_ _01173_ _07050_ _07051_ VSS VSS VDD VDD _02912_ sky130_fd_sc_hd__o21ai_0
X_10456_ net590 _07026_ VSS VSS VDD VDD _07052_ sky130_fd_sc_hd__nand2_1
X_10457_ _00993_ _07026_ _07052_ VSS VSS VDD VDD _02916_ sky130_fd_sc_hd__o21ai_0
X_10458_ network.neuron_in215.counter\[2\] VSS VSS VDD VDD
+ _07053_ sky130_fd_sc_hd__inv_1
Xclkload25 clknet_leaf_164_clk_net VSS VSS VDD VDD _unconnected_41
+ sky130_fd_sc_hd__clkbuf_1
X_10460_ network.neuron_in215.counter\[3\] network.in_period\[215\]\[2\]
+ net363 _00303_ VSS VSS VDD VDD _07055_ sky130_fd_sc_hd__o22ai_1
X_10461_ network.neuron_in215.counter\[2\] _00303_ net365
+ VSS VSS VDD VDD _07056_ sky130_fd_sc_hd__nand3_1
X_10462_ network.in_period\[215\]\[2\] net365 _07056_ VSS
+ VSS VDD VDD _07057_ sky130_fd_sc_hd__o21ai_0
X_10463_ _07053_ _07055_ _07057_ VSS VSS VDD VDD _02925_ sky130_fd_sc_hd__a21oi_1
X_10464_ network.neuron_in093.counter\[0\] VSS VSS VDD VDD
+ _01231_ sky130_fd_sc_hd__inv_1
X_10465_ network.neuron_in069.counter\[0\] VSS VSS VDD VDD
+ _00152_ sky130_fd_sc_hd__inv_1
X_10466_ network.neuron_in234.counter\[0\] VSS VSS VDD VDD
+ _00579_ sky130_fd_sc_hd__inv_1
X_10467_ network.neuron_in215.counter\[3\] _00303_ VSS VSS
+ VDD VDD _07058_ sky130_fd_sc_hd__nand2b_1
X_10468_ _07058_ _07053_ VSS VSS VDD VDD _07059_ sky130_fd_sc_hd__nand2b_1
X_10469_ net365 _07059_ VSS VSS VDD VDD _07060_ sky130_fd_sc_hd__nand2_1
X_10470_ net621 _07060_ VSS VSS VDD VDD _07061_ sky130_fd_sc_hd__nand2_1
X_10471_ network.neuron_in215.counter\[0\] _07060_ _07061_
+ VSS VSS VDD VDD _02923_ sky130_fd_sc_hd__o21ai_0
X_10472_ network.neuron_in217.counter\[2\] VSS VSS VDD VDD
+ _07062_ sky130_fd_sc_hd__inv_1
Xclkload24 clknet_leaf_163_clk_net VSS VSS VDD VDD _unconnected_42
+ sky130_fd_sc_hd__clkinv_2
X_10474_ network.neuron_in217.counter\[3\] network.in_period\[217\]\[2\]
+ _00948_ net363 VSS VSS VDD VDD _07064_ sky130_fd_sc_hd__o22ai_1
X_10475_ network.neuron_in217.counter\[2\] _00948_ net366
+ VSS VSS VDD VDD _07065_ sky130_fd_sc_hd__nand3_1
X_10476_ network.in_period\[217\]\[2\] net366 _07065_ VSS
+ VSS VDD VDD _07066_ sky130_fd_sc_hd__o21ai_0
X_10477_ _07062_ _07064_ _07066_ VSS VSS VDD VDD _02933_ sky130_fd_sc_hd__a21oi_1
X_10478_ network.neuron_in218.counter\[3\] network.in_period\[218\]\[2\]
+ _00988_ net363 VSS VSS VDD VDD _07067_ sky130_fd_sc_hd__o22ai_1
X_10479_ network.neuron_in218.counter\[2\] _00988_ net365
+ VSS VSS VDD VDD _07068_ sky130_fd_sc_hd__nand3_1
X_10480_ network.in_period\[218\]\[2\] net365 _07068_ VSS
+ VSS VDD VDD _07069_ sky130_fd_sc_hd__o21ai_0
X_10481_ _07014_ _07067_ _07069_ VSS VSS VDD VDD _02937_ sky130_fd_sc_hd__a21oi_1
X_10482_ network.neuron_in142.counter\[2\] net377 VSS VSS
+ VDD VDD _07070_ sky130_fd_sc_hd__nand2_1
X_10483_ network.in_period\[142\]\[2\] network.neuron_in142.counter\[3\]
+ _07070_ VSS VSS VDD VDD _07071_ sky130_fd_sc_hd__o21ai_0
X_10484_ _00557_ network.neuron_in142.counter\[2\] net360
+ VSS VSS VDD VDD _07072_ sky130_fd_sc_hd__or3_1
X_10485_ network.in_period\[142\]\[2\] net377 _07072_ VSS
+ VSS VDD VDD _07073_ sky130_fd_sc_hd__o21ai_0
X_10486_ _00557_ _07071_ _07073_ VSS VSS VDD VDD _02633_ sky130_fd_sc_hd__a21oi_1
X_10487_ network.neuron_in209.counter\[3\] _00811_ VSS VSS
+ VDD VDD _07074_ sky130_fd_sc_hd__nand2b_1
X_10488_ network.neuron_in209.counter\[2\] _07074_ VSS VSS
+ VDD VDD _07075_ sky130_fd_sc_hd__or2_2
X_10489_ net367 _07075_ VSS VSS VDD VDD _07076_ sky130_fd_sc_hd__nand2_1
X_10490_ net511 _07076_ VSS VSS VDD VDD _07077_ sky130_fd_sc_hd__nand2_1
X_10491_ _00812_ _07076_ _07077_ VSS VSS VDD VDD _02900_ sky130_fd_sc_hd__o21ai_0
X_10492_ network.neuron_in209.counter\[0\] VSS VSS VDD VDD
+ _00809_ sky130_fd_sc_hd__inv_1
X_10493_ net516 _07076_ VSS VSS VDD VDD _07078_ sky130_fd_sc_hd__nand2_1
X_10494_ network.neuron_in209.counter\[0\] _07076_ _07078_
+ VSS VSS VDD VDD _02899_ sky130_fd_sc_hd__o21ai_0
X_10495_ network.neuron_in141.counter\[2\] network.neuron_in141.counter\[3\]
+ VSS VSS VDD VDD _07079_ sky130_fd_sc_hd__nor2_1
X_10496_ _00158_ _07079_ VSS VSS VDD VDD _07080_ sky130_fd_sc_hd__nand2_1
X_10497_ net377 _07080_ VSS VSS VDD VDD _07081_ sky130_fd_sc_hd__nand2_1
X_10498_ network.in_period\[141\]\[0\] _07081_ VSS VSS VDD
+ VDD _07082_ sky130_fd_sc_hd__nand2_1
X_10499_ network.neuron_in141.counter\[0\] _07081_ _07082_
+ VSS VSS VDD VDD _02627_ sky130_fd_sc_hd__o21ai_0
X_10500_ network.neuron_in210.counter\[3\] _01144_ VSS VSS
+ VDD VDD _07083_ sky130_fd_sc_hd__nand2b_1
X_10501_ network.neuron_in210.counter\[2\] _07083_ VSS VSS
+ VDD VDD _07084_ sky130_fd_sc_hd__or2_2
X_10502_ net367 _07084_ VSS VSS VDD VDD _07085_ sky130_fd_sc_hd__nand2_1
X_10503_ net512 _07085_ VSS VSS VDD VDD _07086_ sky130_fd_sc_hd__nand2_1
X_10504_ _01145_ _07085_ _07086_ VSS VSS VDD VDD _02904_ sky130_fd_sc_hd__o21ai_0
X_10505_ network.neuron_in210.counter\[0\] VSS VSS VDD VDD
+ _01142_ sky130_fd_sc_hd__inv_1
X_10506_ net521 _07085_ VSS VSS VDD VDD _07087_ sky130_fd_sc_hd__nand2_1
X_10507_ network.neuron_in210.counter\[0\] _07085_ _07087_
+ VSS VSS VDD VDD _02903_ sky130_fd_sc_hd__o21ai_0
X_10508_ network.neuron_in152.counter\[0\] VSS VSS VDD VDD
+ _00500_ sky130_fd_sc_hd__inv_1
X_10509_ network.neuron_in211.counter\[0\] VSS VSS VDD VDD
+ _00954_ sky130_fd_sc_hd__inv_1
X_10510_ net517 _07021_ VSS VSS VDD VDD _07088_ sky130_fd_sc_hd__nand2_1
X_10511_ network.neuron_in211.counter\[0\] _07021_ _07088_
+ VSS VSS VDD VDD _02907_ sky130_fd_sc_hd__o21ai_0
Xclkload23 clknet_leaf_5_clk_net VSS VSS VDD VDD _unconnected_43
+ sky130_fd_sc_hd__clkinv_1
X_10513_ network.neuron_in212.counter\[3\] network.in_period\[212\]\[2\]
+ net363 _01172_ VSS VSS VDD VDD _07090_ sky130_fd_sc_hd__o22ai_1
X_10514_ network.neuron_in212.counter\[2\] _01172_ net367
+ VSS VSS VDD VDD _07091_ sky130_fd_sc_hd__nand3_1
X_10515_ network.in_period\[212\]\[2\] net367 _07091_ VSS
+ VSS VDD VDD _07092_ sky130_fd_sc_hd__o21ai_0
X_10516_ _07047_ _07090_ _07092_ VSS VSS VDD VDD _02913_ sky130_fd_sc_hd__a21oi_1
X_10517_ network.neuron_in220.counter\[0\] VSS VSS VDD VDD
+ _01034_ sky130_fd_sc_hd__inv_1
X_10518_ network.neuron_in070.counter\[0\] VSS VSS VDD VDD
+ _00148_ sky130_fd_sc_hd__inv_1
X_10519_ network.neuron_in037.counter\[1\] VSS VSS VDD VDD
+ _00342_ sky130_fd_sc_hd__inv_1
X_10520_ net524 _07050_ VSS VSS VDD VDD _07093_ sky130_fd_sc_hd__nand2_1
X_10521_ network.neuron_in212.counter\[0\] _07050_ _07093_
+ VSS VSS VDD VDD _02911_ sky130_fd_sc_hd__o21ai_0
X_10522_ network.neuron_in213.counter\[3\] network.in_period\[213\]\[2\]
+ _00992_ net363 VSS VSS VDD VDD _07094_ sky130_fd_sc_hd__o22ai_1
X_10523_ network.neuron_in213.counter\[2\] _00992_ net365
+ VSS VSS VDD VDD _07095_ sky130_fd_sc_hd__nand3_1
X_10524_ network.in_period\[213\]\[2\] net365 _07095_ VSS
+ VSS VDD VDD _07096_ sky130_fd_sc_hd__o21ai_0
X_10525_ _07024_ _07094_ _07096_ VSS VSS VDD VDD _02917_ sky130_fd_sc_hd__a21oi_1
X_10526_ network.neuron_in214.counter\[3\] _01000_ VSS VSS
+ VDD VDD _07097_ sky130_fd_sc_hd__nand2b_1
X_10527_ _07097_ _07007_ VSS VSS VDD VDD _07098_ sky130_fd_sc_hd__nand2b_1
X_10528_ net365 _07098_ VSS VSS VDD VDD _07099_ sky130_fd_sc_hd__nand2_1
X_10529_ net653 _07099_ VSS VSS VDD VDD _07100_ sky130_fd_sc_hd__nand2_1
X_10530_ _01001_ _07099_ _07100_ VSS VSS VDD VDD _02920_ sky130_fd_sc_hd__o21ai_0
X_10531_ network.neuron_in251.counter\[0\] VSS VSS VDD VDD
+ _01109_ sky130_fd_sc_hd__inv_1
X_10532_ network.neuron_in214.counter\[0\] VSS VSS VDD VDD
+ _00998_ sky130_fd_sc_hd__inv_1
X_10533_ net640 _07099_ VSS VSS VDD VDD _07101_ sky130_fd_sc_hd__nand2_1
X_10534_ network.neuron_in214.counter\[0\] _07099_ _07101_
+ VSS VSS VDD VDD _02919_ sky130_fd_sc_hd__o21ai_0
X_10535_ net644 _07060_ VSS VSS VDD VDD _07102_ sky130_fd_sc_hd__nand2_1
X_10536_ _00304_ _07060_ _07102_ VSS VSS VDD VDD _02924_ sky130_fd_sc_hd__o21ai_0
X_10537_ network.neuron_in137.counter\[1\] VSS VSS VDD VDD
+ _00684_ sky130_fd_sc_hd__inv_1
X_10538_ network.neuron_in226.counter\[1\] VSS VSS VDD VDD
+ _00798_ sky130_fd_sc_hd__inv_1
X_10539_ network.neuron_in192.counter\[1\] VSS VSS VDD VDD
+ _01031_ sky130_fd_sc_hd__inv_1
X_10540_ network.neuron_in216.counter\[3\] _00938_ VSS VSS
+ VDD VDD _07103_ sky130_fd_sc_hd__nand2b_1
X_10541_ _07103_ _07028_ VSS VSS VDD VDD _07104_ sky130_fd_sc_hd__nand2b_1
X_10542_ net366 _07104_ VSS VSS VDD VDD _07105_ sky130_fd_sc_hd__nand2_1
X_10543_ net655 _07105_ VSS VSS VDD VDD _07106_ sky130_fd_sc_hd__nand2_1
X_10544_ _00939_ _07105_ _07106_ VSS VSS VDD VDD _02928_ sky130_fd_sc_hd__o21ai_0
X_10545_ network.neuron_in079.counter\[0\] VSS VSS VDD VDD
+ _00094_ sky130_fd_sc_hd__inv_1
X_10546_ network.neuron_in216.counter\[0\] VSS VSS VDD VDD
+ _00936_ sky130_fd_sc_hd__inv_1
X_10547_ net625 _07105_ VSS VSS VDD VDD _07107_ sky130_fd_sc_hd__nand2_1
X_10548_ network.neuron_in216.counter\[0\] _07105_ _07107_
+ VSS VSS VDD VDD _02927_ sky130_fd_sc_hd__o21ai_0
X_10549_ network.neuron_in217.counter\[2\] network.neuron_in217.counter\[3\]
+ VSS VSS VDD VDD _07108_ sky130_fd_sc_hd__nor2_1
X_10550_ _00948_ _07108_ VSS VSS VDD VDD _07109_ sky130_fd_sc_hd__nand2_1
X_10551_ net366 _07109_ VSS VSS VDD VDD _07110_ sky130_fd_sc_hd__nand2_1
X_10552_ net580 _07110_ VSS VSS VDD VDD _07111_ sky130_fd_sc_hd__nand2_1
X_10553_ _00949_ _07110_ _07111_ VSS VSS VDD VDD _02932_ sky130_fd_sc_hd__o21ai_0
X_10554_ network.neuron_in217.counter\[0\] VSS VSS VDD VDD
+ _00946_ sky130_fd_sc_hd__inv_1
X_10555_ net599 _07110_ VSS VSS VDD VDD _07112_ sky130_fd_sc_hd__nand2_1
X_10556_ network.neuron_in217.counter\[0\] _07110_ _07112_
+ VSS VSS VDD VDD _02931_ sky130_fd_sc_hd__o21ai_0
X_10557_ network.neuron_in229.counter\[2\] VSS VSS VDD VDD
+ _07113_ sky130_fd_sc_hd__inv_1
X_10558_ network.neuron_in229.counter\[3\] network.in_period\[229\]\[2\]
+ _00661_ net358 VSS VSS VDD VDD _07114_ sky130_fd_sc_hd__o22ai_1
X_10559_ network.neuron_in229.counter\[2\] _00661_ net381
+ VSS VSS VDD VDD _07115_ sky130_fd_sc_hd__nand3_1
X_10560_ network.in_period\[229\]\[2\] net381 _07115_ VSS
+ VSS VDD VDD _07116_ sky130_fd_sc_hd__o21ai_0
X_10561_ _07113_ _07114_ _07116_ VSS VSS VDD VDD _02981_ sky130_fd_sc_hd__a21oi_1
X_10562_ network.neuron_in121.counter\[0\] VSS VSS VDD VDD
+ _00293_ sky130_fd_sc_hd__inv_1
X_10563_ network.neuron_in224.counter\[2\] VSS VSS VDD VDD
+ _07117_ sky130_fd_sc_hd__inv_1
X_10564_ network.neuron_in224.counter\[3\] network.in_period\[224\]\[2\]
+ _01190_ net358 VSS VSS VDD VDD _07118_ sky130_fd_sc_hd__o22ai_1
X_10565_ network.neuron_in224.counter\[2\] _01190_ net388
+ VSS VSS VDD VDD _07119_ sky130_fd_sc_hd__nand3_1
X_10566_ network.in_period\[224\]\[2\] net388 _07119_ VSS
+ VSS VDD VDD _07120_ sky130_fd_sc_hd__o21ai_0
X_10567_ _07117_ _07118_ _07120_ VSS VSS VDD VDD _02961_ sky130_fd_sc_hd__a21oi_1
X_10568_ network.neuron_in228.counter\[0\] VSS VSS VDD VDD
+ _01018_ sky130_fd_sc_hd__inv_1
X_10569_ network.neuron_in228.counter\[3\] _01020_ VSS VSS
+ VDD VDD _07121_ sky130_fd_sc_hd__nand2b_1
X_10570_ network.neuron_in228.counter\[2\] VSS VSS VDD VDD
+ _07122_ sky130_fd_sc_hd__inv_1
X_10571_ _07121_ _07122_ VSS VSS VDD VDD _07123_ sky130_fd_sc_hd__nand2b_1
X_10572_ net388 _07123_ VSS VSS VDD VDD _07124_ sky130_fd_sc_hd__nand2_1
X_10573_ net531 _07124_ VSS VSS VDD VDD _07125_ sky130_fd_sc_hd__nand2_1
X_10574_ network.neuron_in228.counter\[0\] _07124_ _07125_
+ VSS VSS VDD VDD _02975_ sky130_fd_sc_hd__o21ai_0
X_10575_ network.neuron_in036.counter\[1\] VSS VSS VDD VDD
+ _00346_ sky130_fd_sc_hd__inv_1
X_10576_ network.neuron_in081.counter\[1\] VSS VSS VDD VDD
+ _00082_ sky130_fd_sc_hd__inv_1
X_10577_ network.neuron_in221.counter\[3\] _00897_ VSS VSS
+ VDD VDD _07126_ sky130_fd_sc_hd__nand2b_1
X_10578_ network.neuron_in221.counter\[2\] VSS VSS VDD VDD
+ _07127_ sky130_fd_sc_hd__inv_1
X_10579_ _07126_ _07127_ VSS VSS VDD VDD _07128_ sky130_fd_sc_hd__nand2b_1
X_10580_ net365 _07128_ VSS VSS VDD VDD _07129_ sky130_fd_sc_hd__nand2_1
X_10581_ net675 _07129_ VSS VSS VDD VDD _07130_ sky130_fd_sc_hd__nand2_1
X_10582_ _00898_ _07129_ _07130_ VSS VSS VDD VDD _02948_ sky130_fd_sc_hd__o21ai_0
X_10583_ network.neuron_in223.counter\[0\] VSS VSS VDD VDD
+ _00932_ sky130_fd_sc_hd__inv_1
X_10584_ network.neuron_in223.counter\[2\] VSS VSS VDD VDD
+ _07131_ sky130_fd_sc_hd__inv_1
X_10585_ _07131_ _00934_ VSS VSS VDD VDD _07132_ sky130_fd_sc_hd__nand2_1
X_10586_ network.neuron_in223.counter\[3\] _07132_ VSS VSS
+ VDD VDD _07133_ sky130_fd_sc_hd__or2_2
X_10587_ net366 _07133_ VSS VSS VDD VDD _07134_ sky130_fd_sc_hd__nand2_1
X_10588_ net678 _07134_ VSS VSS VDD VDD _07135_ sky130_fd_sc_hd__nand2_1
X_10589_ network.neuron_in223.counter\[0\] _07134_ _07135_
+ VSS VSS VDD VDD _02955_ sky130_fd_sc_hd__o21ai_0
X_10590_ network.neuron_in226.counter\[2\] net388 VSS VSS
+ VDD VDD _07136_ sky130_fd_sc_hd__nand2_1
X_10591_ network.neuron_in226.counter\[3\] network.in_period\[226\]\[2\]
+ _07136_ VSS VSS VDD VDD _07137_ sky130_fd_sc_hd__o21ai_0
X_10592_ _00799_ network.neuron_in226.counter\[2\] net358
+ VSS VSS VDD VDD _07138_ sky130_fd_sc_hd__or3_1
X_10593_ network.in_period\[226\]\[2\] net388 _07138_ VSS
+ VSS VDD VDD _07139_ sky130_fd_sc_hd__o21ai_0
X_10594_ _00799_ _07137_ _07139_ VSS VSS VDD VDD _02969_ sky130_fd_sc_hd__a21oi_1
X_10595_ net534 _07124_ VSS VSS VDD VDD _07140_ sky130_fd_sc_hd__nand2_1
X_10596_ _01021_ _07124_ _07140_ VSS VSS VDD VDD _02976_ sky130_fd_sc_hd__o21ai_0
X_10597_ network.neuron_in220.counter\[2\] VSS VSS VDD VDD
+ _07141_ sky130_fd_sc_hd__inv_1
X_10598_ network.neuron_in220.counter\[3\] network.in_period\[220\]\[2\]
+ net362 _01036_ VSS VSS VDD VDD _07142_ sky130_fd_sc_hd__o22ai_1
Xclkload22 clknet_leaf_4_clk_net VSS VSS VDD VDD _unconnected_44
+ sky130_fd_sc_hd__clkbuf_1
Xclkload21 clknet_leaf_3_clk_net VSS VSS VDD VDD _unconnected_45
+ sky130_fd_sc_hd__clkbuf_1
X_10601_ network.neuron_in220.counter\[2\] _01036_ net366
+ VSS VSS VDD VDD _07145_ sky130_fd_sc_hd__nand3_1
X_10602_ network.in_period\[220\]\[2\] net366 _07145_ VSS
+ VSS VDD VDD _07146_ sky130_fd_sc_hd__o21ai_0
X_10603_ _07141_ _07142_ _07146_ VSS VSS VDD VDD _02945_ sky130_fd_sc_hd__a21oi_1
X_10604_ network.neuron_in221.counter\[3\] network.in_period\[221\]\[2\]
+ _00897_ net363 VSS VSS VDD VDD _07147_ sky130_fd_sc_hd__o22ai_1
X_10605_ network.neuron_in221.counter\[2\] _00897_ net365
+ VSS VSS VDD VDD _07148_ sky130_fd_sc_hd__nand3_1
X_10606_ network.in_period\[221\]\[2\] net365 _07148_ VSS
+ VSS VDD VDD _07149_ sky130_fd_sc_hd__o21ai_0
X_10607_ _07127_ _07147_ _07149_ VSS VSS VDD VDD _02949_ sky130_fd_sc_hd__a21oi_1
X_10608_ network.neuron_in222.counter\[2\] network.neuron_in222.counter\[3\]
+ VSS VSS VDD VDD _07150_ sky130_fd_sc_hd__nor2_1
X_10609_ _00944_ _07150_ VSS VSS VDD VDD _07151_ sky130_fd_sc_hd__nand2_1
X_10610_ net366 _07151_ VSS VSS VDD VDD _07152_ sky130_fd_sc_hd__nand2_1
X_10611_ net672 _07152_ VSS VSS VDD VDD _07153_ sky130_fd_sc_hd__nand2_1
X_10612_ _00945_ _07152_ _07153_ VSS VSS VDD VDD _02952_ sky130_fd_sc_hd__o21ai_0
X_10613_ net635 _07134_ VSS VSS VDD VDD _07154_ sky130_fd_sc_hd__nand2_1
X_10614_ _00935_ _07134_ _07154_ VSS VSS VDD VDD _02956_ sky130_fd_sc_hd__o21ai_0
X_10615_ network.neuron_in225.counter\[2\] VSS VSS VDD VDD
+ _07155_ sky130_fd_sc_hd__inv_1
X_10616_ network.neuron_in225.counter\[3\] network.in_period\[225\]\[2\]
+ _00843_ net364 VSS VSS VDD VDD _07156_ sky130_fd_sc_hd__o22ai_1
X_10617_ network.neuron_in225.counter\[2\] _00843_ net388
+ VSS VSS VDD VDD _07157_ sky130_fd_sc_hd__nand3_1
X_10618_ network.in_period\[225\]\[2\] net388 _07157_ VSS
+ VSS VDD VDD _07158_ sky130_fd_sc_hd__o21ai_0
X_10619_ _07155_ _07156_ _07158_ VSS VSS VDD VDD _02965_ sky130_fd_sc_hd__a21oi_1
X_10620_ network.neuron_in082.counter\[0\] VSS VSS VDD VDD
+ _00057_ sky130_fd_sc_hd__inv_1
X_10621_ network.neuron_in229.counter\[1\] VSS VSS VDD VDD
+ _00660_ sky130_fd_sc_hd__inv_1
X_10622_ network.neuron_in147.counter\[1\] VSS VSS VDD VDD
+ _01199_ sky130_fd_sc_hd__inv_1
X_10623_ network.neuron_in225.counter\[0\] VSS VSS VDD VDD
+ _00841_ sky130_fd_sc_hd__inv_1
Xclkload20 clknet_leaf_2_clk_net VSS VSS VDD VDD _unconnected_46
+ sky130_fd_sc_hd__clkbuf_1
X_10625_ network.neuron_in225.counter\[3\] _00843_ VSS VSS
+ VDD VDD _07160_ sky130_fd_sc_hd__nand2b_1
X_10626_ _07160_ _07155_ VSS VSS VDD VDD _07161_ sky130_fd_sc_hd__nand2b_1
X_10627_ net388 _07161_ VSS VSS VDD VDD _07162_ sky130_fd_sc_hd__nand2_1
X_10628_ net553 _07162_ VSS VSS VDD VDD _07163_ sky130_fd_sc_hd__nand2_1
X_10629_ network.neuron_in225.counter\[0\] _07162_ _07163_
+ VSS VSS VDD VDD _02963_ sky130_fd_sc_hd__o21ai_0
X_10630_ network.neuron_in227.counter\[2\] VSS VSS VDD VDD
+ _07164_ sky130_fd_sc_hd__inv_1
X_10631_ network.neuron_in227.counter\[3\] network.in_period\[227\]\[2\]
+ _00930_ net364 VSS VSS VDD VDD _07165_ sky130_fd_sc_hd__o22ai_1
X_10632_ network.neuron_in227.counter\[2\] _00930_ net372
+ VSS VSS VDD VDD _07166_ sky130_fd_sc_hd__nand3_1
X_10633_ network.in_period\[227\]\[2\] net372 _07166_ VSS
+ VSS VDD VDD _07167_ sky130_fd_sc_hd__o21ai_0
X_10634_ _07164_ _07165_ _07167_ VSS VSS VDD VDD _02973_ sky130_fd_sc_hd__a21oi_1
X_10635_ network.neuron_in228.counter\[3\] network.in_period\[228\]\[2\]
+ _01020_ net358 VSS VSS VDD VDD _07168_ sky130_fd_sc_hd__o22ai_1
X_10636_ network.neuron_in228.counter\[2\] _01020_ net388
+ VSS VSS VDD VDD _07169_ sky130_fd_sc_hd__nand3_1
X_10637_ network.in_period\[228\]\[2\] net388 _07169_ VSS
+ VSS VDD VDD _07170_ sky130_fd_sc_hd__o21ai_0
X_10638_ _07122_ _07168_ _07170_ VSS VSS VDD VDD _02977_ sky130_fd_sc_hd__a21oi_1
X_10639_ _07003_ _00315_ VSS VSS VDD VDD _07171_ sky130_fd_sc_hd__nand2_1
X_10640_ network.neuron_in219.counter\[3\] _07171_ VSS VSS
+ VDD VDD _07172_ sky130_fd_sc_hd__or2_2
X_10641_ net366 _07172_ VSS VSS VDD VDD _07173_ sky130_fd_sc_hd__nand2_1
X_10642_ net743 _07173_ VSS VSS VDD VDD _07174_ sky130_fd_sc_hd__nand2_1
X_10643_ _00316_ _07173_ _07174_ VSS VSS VDD VDD _02940_ sky130_fd_sc_hd__o21ai_0
X_10644_ network.neuron_in024.counter\[0\] VSS VSS VDD VDD
+ _00393_ sky130_fd_sc_hd__inv_1
X_10645_ network.neuron_in090.counter\[0\] VSS VSS VDD VDD
+ _00595_ sky130_fd_sc_hd__inv_1
X_10646_ net698 _07173_ VSS VSS VDD VDD _07175_ sky130_fd_sc_hd__nand2_1
X_10647_ network.neuron_in219.counter\[0\] _07173_ _07175_
+ VSS VSS VDD VDD _02939_ sky130_fd_sc_hd__o21ai_0
X_10648_ _07141_ _01036_ VSS VSS VDD VDD _07176_ sky130_fd_sc_hd__nand2_1
X_10649_ network.neuron_in220.counter\[3\] _07176_ VSS VSS
+ VDD VDD _07177_ sky130_fd_sc_hd__or2_2
X_10650_ net366 _07177_ VSS VSS VDD VDD _07178_ sky130_fd_sc_hd__nand2_1
X_10651_ net724 _07178_ VSS VSS VDD VDD _07179_ sky130_fd_sc_hd__nand2_1
X_10652_ _01037_ _07178_ _07179_ VSS VSS VDD VDD _02944_ sky130_fd_sc_hd__o21ai_0
X_10653_ net657 _07178_ VSS VSS VDD VDD _07180_ sky130_fd_sc_hd__nand2_1
X_10654_ network.neuron_in220.counter\[0\] _07178_ _07180_
+ VSS VSS VDD VDD _02943_ sky130_fd_sc_hd__o21ai_0
X_10655_ network.neuron_in230.counter\[1\] VSS VSS VDD VDD
+ _00354_ sky130_fd_sc_hd__inv_1
X_10656_ network.neuron_in051.counter\[0\] VSS VSS VDD VDD
+ _00337_ sky130_fd_sc_hd__inv_1
X_10657_ network.neuron_in035.counter\[1\] VSS VSS VDD VDD
+ _00362_ sky130_fd_sc_hd__inv_1
X_10658_ network.neuron_in221.counter\[0\] VSS VSS VDD VDD
+ _00895_ sky130_fd_sc_hd__inv_1
X_10659_ net642 _07129_ VSS VSS VDD VDD _07181_ sky130_fd_sc_hd__nand2_1
X_10660_ network.neuron_in221.counter\[0\] _07129_ _07181_
+ VSS VSS VDD VDD _02947_ sky130_fd_sc_hd__o21ai_0
X_10661_ network.neuron_in222.counter\[2\] VSS VSS VDD VDD
+ _07182_ sky130_fd_sc_hd__inv_1
X_10662_ network.neuron_in222.counter\[3\] network.in_period\[222\]\[2\]
+ _00944_ net362 VSS VSS VDD VDD _07183_ sky130_fd_sc_hd__o22ai_1
X_10663_ network.neuron_in222.counter\[2\] _00944_ net366
+ VSS VSS VDD VDD _07184_ sky130_fd_sc_hd__nand3_1
X_10664_ network.in_period\[222\]\[2\] net366 _07184_ VSS
+ VSS VDD VDD _07185_ sky130_fd_sc_hd__o21ai_0
X_10665_ _07182_ _07183_ _07185_ VSS VSS VDD VDD _02953_ sky130_fd_sc_hd__a21oi_1
X_10666_ network.neuron_in222.counter\[0\] VSS VSS VDD VDD
+ _00942_ sky130_fd_sc_hd__inv_1
X_10667_ network.in_period\[222\]\[0\] _07152_ VSS VSS VDD
+ VDD _07186_ sky130_fd_sc_hd__nand2_1
X_10668_ network.neuron_in222.counter\[0\] _07152_ _07186_
+ VSS VSS VDD VDD _02951_ sky130_fd_sc_hd__o21ai_0
Xclkload19 clknet_leaf_1_clk_net VSS VSS VDD VDD _unconnected_47
+ sky130_fd_sc_hd__clkbuf_1
X_10670_ network.neuron_in223.counter\[3\] network.in_period\[223\]\[2\]
+ _00934_ net362 VSS VSS VDD VDD _07188_ sky130_fd_sc_hd__o22ai_1
X_10671_ network.neuron_in223.counter\[2\] _00934_ net366
+ VSS VSS VDD VDD _07189_ sky130_fd_sc_hd__nand3_1
X_10672_ network.in_period\[223\]\[2\] net366 _07189_ VSS
+ VSS VDD VDD _07190_ sky130_fd_sc_hd__o21ai_0
X_10673_ _07131_ _07188_ _07190_ VSS VSS VDD VDD _02957_ sky130_fd_sc_hd__a21oi_1
X_10674_ network.neuron_in224.counter\[3\] _01190_ VSS VSS
+ VDD VDD _07191_ sky130_fd_sc_hd__nand2b_1
X_10675_ _07191_ _07117_ VSS VSS VDD VDD _07192_ sky130_fd_sc_hd__nand2b_1
X_10676_ net388 _07192_ VSS VSS VDD VDD _07193_ sky130_fd_sc_hd__nand2_1
X_10677_ net527 _07193_ VSS VSS VDD VDD _07194_ sky130_fd_sc_hd__nand2_1
X_10678_ _01191_ _07193_ _07194_ VSS VSS VDD VDD _02960_ sky130_fd_sc_hd__o21ai_0
X_10679_ _00885_ network.neuron_in134.counter\[2\] VSS VSS
+ VDD VDD _07195_ sky130_fd_sc_hd__xnor2_1
Xclkload18 clknet_leaf_0_clk_net VSS VSS VDD VDD _unconnected_48
+ sky130_fd_sc_hd__clkbuf_1
X_10681_ network.neuron_in134.counter\[3\] _00885_ VSS VSS
+ VDD VDD _07197_ sky130_fd_sc_hd__nand2b_1
X_10682_ net381 _07197_ network.in_period\[134\]\[2\] VSS
+ VSS VDD VDD _07198_ sky130_fd_sc_hd__a21oi_1
X_10683_ net381 _07195_ _07198_ VSS VSS VDD VDD _02601_ sky130_fd_sc_hd__a21oi_1
X_10684_ network.neuron_in224.counter\[0\] VSS VSS VDD VDD
+ _01188_ sky130_fd_sc_hd__inv_1
X_10685_ net523 _07193_ VSS VSS VDD VDD _07199_ sky130_fd_sc_hd__nand2_1
X_10686_ network.neuron_in224.counter\[0\] _07193_ _07199_
+ VSS VSS VDD VDD _02959_ sky130_fd_sc_hd__o21ai_0
X_10687_ network.neuron_in029.counter\[1\] VSS VSS VDD VDD
+ _00350_ sky130_fd_sc_hd__inv_1
X_10688_ network.neuron_in171.counter\[1\] VSS VSS VDD VDD
+ _01027_ sky130_fd_sc_hd__inv_1
X_10689_ network.neuron_in134.counter\[2\] _07197_ VSS VSS
+ VDD VDD _07200_ sky130_fd_sc_hd__or2_2
X_10690_ net381 _07200_ VSS VSS VDD VDD _07201_ sky130_fd_sc_hd__nand2_1
X_10691_ network.in_period\[134\]\[1\] _07201_ VSS VSS VDD
+ VDD _07202_ sky130_fd_sc_hd__nand2_1
X_10692_ _00886_ _07201_ _07202_ VSS VSS VDD VDD _02600_ sky130_fd_sc_hd__o21ai_0
X_10693_ net539 _07162_ VSS VSS VDD VDD _07203_ sky130_fd_sc_hd__nand2_1
X_10694_ _00844_ _07162_ _07203_ VSS VSS VDD VDD _02964_ sky130_fd_sc_hd__o21ai_0
X_10695_ network.neuron_in226.counter\[3\] _00799_ VSS VSS
+ VDD VDD _07204_ sky130_fd_sc_hd__nand2b_1
X_10696_ network.neuron_in226.counter\[2\] _07204_ VSS VSS
+ VDD VDD _07205_ sky130_fd_sc_hd__or2_2
X_10697_ net388 _07205_ VSS VSS VDD VDD _07206_ sky130_fd_sc_hd__nand2_1
X_10698_ net520 _07206_ VSS VSS VDD VDD _07207_ sky130_fd_sc_hd__nand2_1
X_10699_ _00800_ _07206_ _07207_ VSS VSS VDD VDD _02968_ sky130_fd_sc_hd__o21ai_0
X_10700_ network.neuron_in226.counter\[0\] VSS VSS VDD VDD
+ _00797_ sky130_fd_sc_hd__inv_1
X_10701_ net533 _07206_ VSS VSS VDD VDD _07208_ sky130_fd_sc_hd__nand2_1
X_10702_ network.neuron_in226.counter\[0\] _07206_ _07208_
+ VSS VSS VDD VDD _02967_ sky130_fd_sc_hd__o21ai_0
X_10703_ network.neuron_in090.counter\[1\] VSS VSS VDD VDD
+ _00596_ sky130_fd_sc_hd__inv_1
X_10704_ network.neuron_in064.counter\[0\] VSS VSS VDD VDD
+ _00197_ sky130_fd_sc_hd__inv_1
X_10705_ network.neuron_in237.counter\[1\] VSS VSS VDD VDD
+ _00609_ sky130_fd_sc_hd__inv_1
X_10706_ network.neuron_in030.counter\[1\] VSS VSS VDD VDD
+ _00435_ sky130_fd_sc_hd__inv_1
X_10707_ network.neuron_in028.counter\[1\] VSS VSS VDD VDD
+ _00374_ sky130_fd_sc_hd__inv_1
X_10708_ network.neuron_in119.counter\[0\] VSS VSS VDD VDD
+ _00600_ sky130_fd_sc_hd__inv_1
X_10709_ network.neuron_in027.counter\[1\] VSS VSS VDD VDD
+ _00465_ sky130_fd_sc_hd__inv_1
X_10710_ network.neuron_in119.counter\[1\] VSS VSS VDD VDD
+ _00601_ sky130_fd_sc_hd__inv_1
X_10711_ network.neuron_in025.counter\[1\] VSS VSS VDD VDD
+ _00382_ sky130_fd_sc_hd__inv_1
X_10712_ network.neuron_in043.counter\[0\] VSS VSS VDD VDD
+ _00289_ sky130_fd_sc_hd__inv_1
X_10713_ network.neuron_in171.counter\[0\] VSS VSS VDD VDD
+ _01026_ sky130_fd_sc_hd__inv_1
X_10714_ network.neuron_in208.counter\[1\] VSS VSS VDD VDD
+ _00514_ sky130_fd_sc_hd__inv_1
X_10715_ network.neuron_in023.counter\[1\] VSS VSS VDD VDD
+ _00386_ sky130_fd_sc_hd__inv_1
X_10716_ network.neuron_in100.counter\[1\] VSS VSS VDD VDD
+ _00054_ sky130_fd_sc_hd__inv_1
X_10717_ network.neuron_in111.counter\[1\] VSS VSS VDD VDD
+ _00605_ sky130_fd_sc_hd__inv_1
X_10718_ network.neuron_in111.counter\[0\] VSS VSS VDD VDD
+ _00604_ sky130_fd_sc_hd__inv_1
X_10719_ network.neuron_in051.counter\[1\] VSS VSS VDD VDD
+ _00338_ sky130_fd_sc_hd__inv_1
X_10720_ network.neuron_in254.counter\[1\] VSS VSS VDD VDD
+ _00900_ sky130_fd_sc_hd__inv_1
X_10721_ network.neuron_in021.counter\[1\] VSS VSS VDD VDD
+ _00410_ sky130_fd_sc_hd__inv_1
X_10722_ network.neuron_in155.counter\[1\] VSS VSS VDD VDD
+ _01098_ sky130_fd_sc_hd__inv_1
X_10723_ network.neuron_in022.counter\[1\] VSS VSS VDD VDD
+ _00398_ sky130_fd_sc_hd__inv_1
X_10724_ network.neuron_in228.counter\[1\] VSS VSS VDD VDD
+ _01019_ sky130_fd_sc_hd__inv_1
X_10725_ network.neuron_in020.counter\[1\] VSS VSS VDD VDD
+ _00406_ sky130_fd_sc_hd__inv_1
X_10726_ network.neuron_in151.counter\[0\] VSS VSS VDD VDD
+ _00504_ sky130_fd_sc_hd__inv_1
X_10727_ network.neuron_hid1.IF0.ref_counter\[1\] VSS VSS
+ VDD VDD _01015_ sky130_fd_sc_hd__inv_1
X_10728_ network.neuron_in019.counter\[1\] VSS VSS VDD VDD
+ _00414_ sky130_fd_sc_hd__inv_1
X_10729_ network.neuron_in237.counter\[0\] VSS VSS VDD VDD
+ _00608_ sky130_fd_sc_hd__inv_1
X_10730_ network.neuron_in032.counter\[0\] VSS VSS VDD VDD
+ _01118_ sky130_fd_sc_hd__inv_1
X_10731_ network.neuron_in170.counter\[1\] VSS VSS VDD VDD
+ _01011_ sky130_fd_sc_hd__inv_1
X_10732_ network.neuron_in045.counter\[0\] VSS VSS VDD VDD
+ _00285_ sky130_fd_sc_hd__inv_1
X_10733_ network.neuron_in018.counter\[1\] VSS VSS VDD VDD
+ _00422_ sky130_fd_sc_hd__inv_1
X_10734_ network.neuron_in017.counter\[1\] VSS VSS VDD VDD
+ _00418_ sky130_fd_sc_hd__inv_1
X_10735_ network.neuron_in240.counter\[0\] VSS VSS VDD VDD
+ _00521_ sky130_fd_sc_hd__inv_1
X_10736_ network.neuron_in138.counter\[0\] VSS VSS VDD VDD
+ _00612_ sky130_fd_sc_hd__inv_1
X_10737_ network.neuron_in015.counter\[1\] VSS VSS VDD VDD
+ _00443_ sky130_fd_sc_hd__inv_1
X_10738_ network.neuron_in037.counter\[0\] VSS VSS VDD VDD
+ _00341_ sky130_fd_sc_hd__inv_1
X_10739_ network.neuron_in115.counter\[0\] VSS VSS VDD VDD
+ _01222_ sky130_fd_sc_hd__inv_1
X_10740_ network.neuron_in016.counter\[1\] VSS VSS VDD VDD
+ _00426_ sky130_fd_sc_hd__inv_1
X_10741_ network.neuron_in170.counter\[0\] VSS VSS VDD VDD
+ _01010_ sky130_fd_sc_hd__inv_1
X_10742_ network.neuron_in056.counter\[0\] VSS VSS VDD VDD
+ _00233_ sky130_fd_sc_hd__inv_1
X_10743_ network.neuron_in128.counter\[2\] _01046_ VSS VSS
+ VDD VDD _07209_ sky130_fd_sc_hd__nand2b_1
X_10744_ network.neuron_in128.counter\[3\] _07209_ VSS VSS
+ VDD VDD _07210_ sky130_fd_sc_hd__or2_2
X_10745_ net384 _07210_ VSS VSS VDD VDD _07211_ sky130_fd_sc_hd__nand2_1
X_10746_ net667 _07211_ VSS VSS VDD VDD _07212_ sky130_fd_sc_hd__nand2_1
X_10747_ _01047_ _07211_ _07212_ VSS VSS VDD VDD _02576_ sky130_fd_sc_hd__o21ai_0
X_10748_ network.neuron_in013.counter\[1\] VSS VSS VDD VDD
+ _00447_ sky130_fd_sc_hd__inv_1
X_10749_ network.in_period\[128\]\[0\] _07211_ VSS VSS VDD
+ VDD _07213_ sky130_fd_sc_hd__nand2_1
X_10750_ network.neuron_in128.counter\[0\] _07211_ _07213_
+ VSS VSS VDD VDD _02575_ sky130_fd_sc_hd__o21ai_0
X_10751_ network.neuron_in014.counter\[1\] VSS VSS VDD VDD
+ _00439_ sky130_fd_sc_hd__inv_1
X_10752_ network.neuron_in138.counter\[1\] VSS VSS VDD VDD
+ _00613_ sky130_fd_sc_hd__inv_1
X_10753_ network.neuron_in125.counter\[1\] VSS VSS VDD VDD
+ _00485_ sky130_fd_sc_hd__inv_1
X_10754_ network.neuron_in249.counter\[1\] VSS VSS VDD VDD
+ _01007_ sky130_fd_sc_hd__inv_1
X_10755_ network.neuron_in012.counter\[1\] VSS VSS VDD VDD
+ _00451_ sky130_fd_sc_hd__inv_1
X_10756_ network.neuron_in199.counter\[1\] VSS VSS VDD VDD
+ _01179_ sky130_fd_sc_hd__inv_1
X_10757_ network.neuron_in227.counter\[3\] _00930_ VSS VSS
+ VDD VDD _07214_ sky130_fd_sc_hd__nand2b_1
X_10758_ _07214_ _07164_ VSS VSS VDD VDD _07215_ sky130_fd_sc_hd__nand2b_1
X_10759_ net372 _07215_ VSS VSS VDD VDD _07216_ sky130_fd_sc_hd__nand2_1
X_10760_ net603 _07216_ VSS VSS VDD VDD _07217_ sky130_fd_sc_hd__nand2_1
X_10761_ _00931_ _07216_ _07217_ VSS VSS VDD VDD _02972_ sky130_fd_sc_hd__o21ai_0
Xclkload17 clknet_4_15_0_clk_net VSS VSS VDD VDD _unconnected_49
+ sky130_fd_sc_hd__clkinv_8
Xclkload16 clknet_4_14_0_clk_net VSS VSS VDD VDD _unconnected_50
+ sky130_fd_sc_hd__clkinv_16
X_10764_ network.neuron_in141.counter\[2\] net377 VSS VSS
+ VDD VDD _07220_ sky130_fd_sc_hd__nand2_1
X_10765_ network.in_period\[141\]\[2\] network.neuron_in141.counter\[3\]
+ _07220_ VSS VSS VDD VDD _07221_ sky130_fd_sc_hd__o21ai_0
X_10766_ _00158_ network.neuron_in141.counter\[2\] net360
+ VSS VSS VDD VDD _07222_ sky130_fd_sc_hd__or3_1
X_10767_ network.in_period\[141\]\[2\] net377 _07222_ VSS
+ VSS VDD VDD _07223_ sky130_fd_sc_hd__o21ai_0
X_10768_ _00158_ _07221_ _07223_ VSS VSS VDD VDD _02629_ sky130_fd_sc_hd__a21oi_1
X_10769_ network.neuron_in227.counter\[0\] VSS VSS VDD VDD
+ _00928_ sky130_fd_sc_hd__inv_1
X_10770_ net585 _07216_ VSS VSS VDD VDD _07224_ sky130_fd_sc_hd__nand2_1
X_10771_ network.neuron_in227.counter\[0\] _07216_ _07224_
+ VSS VSS VDD VDD _02971_ sky130_fd_sc_hd__o21ai_0
X_10772_ network.neuron_in034.counter\[1\] VSS VSS VDD VDD
+ _00358_ sky130_fd_sc_hd__inv_1
X_10773_ network.in_period\[141\]\[1\] _07081_ VSS VSS VDD
+ VDD _07225_ sky130_fd_sc_hd__nand2_1
X_10774_ _00159_ _07081_ _07225_ VSS VSS VDD VDD _02628_ sky130_fd_sc_hd__o21ai_0
X_10775_ network.neuron_in249.counter\[0\] VSS VSS VDD VDD
+ _01006_ sky130_fd_sc_hd__inv_1
X_10776_ network.neuron_in000.counter\[1\] VSS VSS VDD VDD
+ _00630_ sky130_fd_sc_hd__inv_1
X_10777_ network.neuron_in234.counter\[2\] net390 VSS VSS
+ VDD VDD _07226_ sky130_fd_sc_hd__nand2_1
X_10778_ network.neuron_in234.counter\[3\] network.in_period\[234\]\[2\]
+ _07226_ VSS VSS VDD VDD _07227_ sky130_fd_sc_hd__o21ai_0
Xclkload15 clknet_4_13_0_clk_net VSS VSS VDD VDD _unconnected_51
+ sky130_fd_sc_hd__clkinv_8
X_10780_ _00581_ network.neuron_in234.counter\[2\] net363
+ VSS VSS VDD VDD _07229_ sky130_fd_sc_hd__or3_1
X_10781_ network.in_period\[234\]\[2\] net390 _07229_ VSS
+ VSS VDD VDD _07230_ sky130_fd_sc_hd__o21ai_0
X_10782_ _00581_ _07227_ _07230_ VSS VSS VDD VDD _03001_ sky130_fd_sc_hd__a21oi_1
X_10783_ network.neuron_in011.counter\[1\] VSS VSS VDD VDD
+ _00455_ sky130_fd_sc_hd__inv_1
Xclkload14 clknet_4_12_0_clk_net VSS VSS VDD VDD _unconnected_52
+ sky130_fd_sc_hd__clkinv_8
X_10785_ network.neuron_in231.counter\[2\] network.neuron_in231.counter\[3\]
+ VSS VSS VDD VDD _07232_ sky130_fd_sc_hd__nor2_1
X_10786_ _00573_ _07232_ VSS VSS VDD VDD _07233_ sky130_fd_sc_hd__nand2_1
X_10787_ net387 _07233_ VSS VSS VDD VDD _07234_ sky130_fd_sc_hd__nand2_1
X_10788_ net561 _07234_ VSS VSS VDD VDD _07235_ sky130_fd_sc_hd__nand2_1
X_10789_ _00574_ _07234_ _07235_ VSS VSS VDD VDD _02988_ sky130_fd_sc_hd__o21ai_0
X_10790_ network.neuron_in005.counter\[0\] VSS VSS VDD VDD
+ _00616_ sky130_fd_sc_hd__inv_1
X_10791_ network.neuron_in076.counter\[0\] VSS VSS VDD VDD
+ _00111_ sky130_fd_sc_hd__inv_1
X_10792_ network.neuron_in233.counter\[0\] VSS VSS VDD VDD
+ _00801_ sky130_fd_sc_hd__inv_1
X_10793_ network.neuron_in233.counter\[3\] _00803_ VSS VSS
+ VDD VDD _07236_ sky130_fd_sc_hd__nand2b_1
X_10794_ network.neuron_in233.counter\[2\] VSS VSS VDD VDD
+ _07237_ sky130_fd_sc_hd__inv_1
X_10795_ _07236_ _07237_ VSS VSS VDD VDD _07238_ sky130_fd_sc_hd__nand2b_1
X_10796_ net372 _07238_ VSS VSS VDD VDD _07239_ sky130_fd_sc_hd__nand2_1
X_10797_ net664 _07239_ VSS VSS VDD VDD _07240_ sky130_fd_sc_hd__nand2_1
X_10798_ network.neuron_in233.counter\[0\] _07239_ _07240_
+ VSS VSS VDD VDD _02995_ sky130_fd_sc_hd__o21ai_0
Xclkload13 clknet_4_11_0_clk_net VSS VSS VDD VDD _unconnected_53
+ sky130_fd_sc_hd__inv_16
X_10800_ net393 net396 VSS VSS VDD VDD _07242_ sky130_fd_sc_hd__nor2_1
X_10801_ net391 _07242_ VSS VSS VDD VDD _07243_ sky130_fd_sc_hd__and2_1
Xclkload12 clknet_4_10_0_clk_net VSS VSS VDD VDD _unconnected_54
+ sky130_fd_sc_hd__clkbuf_16
X_10803_ network.neuron_hid0.ROM0.read_en net389 _07243_ VSS
+ VSS VDD VDD _07245_ sky130_fd_sc_hd__nand3_1
Xclkload11 clknet_4_9_0_clk_net VSS VSS VDD VDD _unconnected_55
+ sky130_fd_sc_hd__clkinv_8
Xclkload10 clknet_4_8_0_clk_net VSS VSS VDD VDD _unconnected_56
+ sky130_fd_sc_hd__inv_6
Xclkload9 clknet_4_7_0_clk_net VSS VSS VDD VDD _unconnected_57
+ sky130_fd_sc_hd__clkbuf_16
Xclkload8 clknet_4_6_0_clk_net VSS VSS VDD VDD _unconnected_58
+ sky130_fd_sc_hd__clkinv_8
Xclkload7 clknet_4_5_0_clk_net VSS VSS VDD VDD _unconnected_59
+ sky130_fd_sc_hd__inv_6
Xclkload6 clknet_4_4_0_clk_net VSS VSS VDD VDD _unconnected_60
+ sky130_fd_sc_hd__clkinv_8
Xclkload5 clknet_4_3_0_clk_net VSS VSS VDD VDD _unconnected_61
+ sky130_fd_sc_hd__inv_6
Xclkload4 clknet_4_2_0_clk_net VSS VSS VDD VDD _unconnected_62
+ sky130_fd_sc_hd__inv_6
Xclkload3 clknet_4_1_0_clk_net VSS VSS VDD VDD _unconnected_63
+ sky130_fd_sc_hd__inv_6
Xclkbuf_4_15_0_clk_net clknet_0_clk_net VSS VSS VDD VDD clknet_4_15_0_clk_net
+ sky130_fd_sc_hd__clkbuf_16
Xclkbuf_4_14_0_clk_net clknet_0_clk_net VSS VSS VDD VDD clknet_4_14_0_clk_net
+ sky130_fd_sc_hd__clkbuf_16
Xclkbuf_4_13_0_clk_net clknet_0_clk_net VSS VSS VDD VDD clknet_4_13_0_clk_net
+ sky130_fd_sc_hd__clkbuf_16
Xclkbuf_4_12_0_clk_net clknet_0_clk_net VSS VSS VDD VDD clknet_4_12_0_clk_net
+ sky130_fd_sc_hd__clkbuf_16
Xclkbuf_4_11_0_clk_net clknet_0_clk_net VSS VSS VDD VDD clknet_4_11_0_clk_net
+ sky130_fd_sc_hd__clkbuf_16
Xclkbuf_4_10_0_clk_net clknet_0_clk_net VSS VSS VDD VDD clknet_4_10_0_clk_net
+ sky130_fd_sc_hd__clkbuf_16
X_10819_ net411 net402 VSS VSS VDD VDD _07261_ sky130_fd_sc_hd__nor2b_2
Xclkbuf_4_9_0_clk_net clknet_0_clk_net VSS VSS VDD VDD clknet_4_9_0_clk_net
+ sky130_fd_sc_hd__clkbuf_16
Xclkbuf_4_8_0_clk_net clknet_0_clk_net VSS VSS VDD VDD clknet_4_8_0_clk_net
+ sky130_fd_sc_hd__clkbuf_16
X_10822_ net402 net411 VSS VSS VDD VDD _07264_ sky130_fd_sc_hd__nand2b_1
Xclkbuf_4_7_0_clk_net clknet_0_clk_net VSS VSS VDD VDD clknet_4_7_0_clk_net
+ sky130_fd_sc_hd__clkbuf_16
X_10824_ net397 net346 net345 VSS VSS VDD VDD _07266_ sky130_fd_sc_hd__o21ai_0
X_10825_ net406 net402 VSS VSS VDD VDD _07267_ sky130_fd_sc_hd__nand2b_1
Xclkbuf_4_6_0_clk_net clknet_0_clk_net VSS VSS VDD VDD clknet_4_6_0_clk_net
+ sky130_fd_sc_hd__clkbuf_16
X_10827_ net397 net344 VSS VSS VDD VDD _07269_ sky130_fd_sc_hd__nor2_1
X_10828_ net405 _07266_ _07269_ VSS VSS VDD VDD _07270_ sky130_fd_sc_hd__a21oi_1
X_10829_ net401 VSS VSS VDD VDD _07271_ sky130_fd_sc_hd__clkinv_1
Xclkbuf_4_5_0_clk_net clknet_0_clk_net VSS VSS VDD VDD clknet_4_5_0_clk_net
+ sky130_fd_sc_hd__clkbuf_16
Xclkbuf_4_4_0_clk_net clknet_0_clk_net VSS VSS VDD VDD clknet_4_4_0_clk_net
+ sky130_fd_sc_hd__clkbuf_16
X_10832_ net407 VSS VSS VDD VDD _07274_ sky130_fd_sc_hd__inv_1
Xclkbuf_4_3_0_clk_net clknet_0_clk_net VSS VSS VDD VDD clknet_4_3_0_clk_net
+ sky130_fd_sc_hd__clkbuf_16
X_10834_ net342 net341 VSS VSS VDD VDD _07276_ sky130_fd_sc_hd__nand2_1
Xclkbuf_4_2_0_clk_net clknet_0_clk_net VSS VSS VDD VDD clknet_4_2_0_clk_net
+ sky130_fd_sc_hd__clkbuf_16
X_10836_ network.neuron_hid0.ROM0.address\[3\] network.neuron_hid0.ROM0.address\[1\]
+ VSS VSS VDD VDD _07278_ sky130_fd_sc_hd__nor2b_2
Xclkbuf_4_1_0_clk_net clknet_0_clk_net VSS VSS VDD VDD clknet_4_1_0_clk_net
+ sky130_fd_sc_hd__clkbuf_16
X_10838_ net346 net340 VSS VSS VDD VDD _07280_ sky130_fd_sc_hd__nor2_1
X_10839_ net409 _07270_ _07276_ _07280_ VSS VSS VDD VDD _07281_
+ sky130_fd_sc_hd__o22a_1
X_10840_ network.neuron_hid0.ROM0.read_en net390 VSS VSS VDD
+ VDD _07282_ sky130_fd_sc_hd__nand2_2
X_10841_ net391 _07282_ VSS VSS VDD VDD _07283_ sky130_fd_sc_hd__or2_2
Xclkbuf_4_0_0_clk_net clknet_0_clk_net VSS VSS VDD VDD clknet_4_0_0_clk_net
+ sky130_fd_sc_hd__clkbuf_16
Xclkbuf_0_clk_net clk_net VSS VSS VDD VDD clknet_0_clk_net
+ sky130_fd_sc_hd__clkbuf_16
Xclkbuf_leaf_168_clk_net clknet_4_0_0_clk_net VSS VSS VDD
+ VDD clknet_leaf_168_clk_net sky130_fd_sc_hd__clkbuf_16
Xclkbuf_leaf_167_clk_net clknet_4_0_0_clk_net VSS VSS VDD
+ VDD clknet_leaf_167_clk_net sky130_fd_sc_hd__clkbuf_16
Xclkbuf_leaf_166_clk_net clknet_4_0_0_clk_net VSS VSS VDD
+ VDD clknet_leaf_166_clk_net sky130_fd_sc_hd__clkbuf_16
Xclkbuf_leaf_165_clk_net clknet_4_0_0_clk_net VSS VSS VDD
+ VDD clknet_leaf_165_clk_net sky130_fd_sc_hd__clkbuf_16
X_10848_ net395 VSS VSS VDD VDD _07290_ sky130_fd_sc_hd__inv_2
Xclkbuf_leaf_164_clk_net clknet_4_0_0_clk_net VSS VSS VDD
+ VDD clknet_leaf_164_clk_net sky130_fd_sc_hd__clkbuf_16
Xclkbuf_leaf_163_clk_net clknet_4_0_0_clk_net VSS VSS VDD
+ VDD clknet_leaf_163_clk_net sky130_fd_sc_hd__clkbuf_16
Xclkbuf_leaf_162_clk_net clknet_4_0_0_clk_net VSS VSS VDD
+ VDD clknet_leaf_162_clk_net sky130_fd_sc_hd__clkbuf_16
Xclkbuf_leaf_161_clk_net clknet_4_1_0_clk_net VSS VSS VDD
+ VDD clknet_leaf_161_clk_net sky130_fd_sc_hd__clkbuf_16
Xclkbuf_leaf_160_clk_net clknet_4_1_0_clk_net VSS VSS VDD
+ VDD clknet_leaf_160_clk_net sky130_fd_sc_hd__clkbuf_16
Xclkbuf_leaf_159_clk_net clknet_4_1_0_clk_net VSS VSS VDD
+ VDD clknet_leaf_159_clk_net sky130_fd_sc_hd__clkbuf_16
Xclkbuf_leaf_158_clk_net clknet_4_1_0_clk_net VSS VSS VDD
+ VDD clknet_leaf_158_clk_net sky130_fd_sc_hd__clkbuf_16
Xclkbuf_leaf_157_clk_net clknet_4_1_0_clk_net VSS VSS VDD
+ VDD clknet_leaf_157_clk_net sky130_fd_sc_hd__clkbuf_16
X_10857_ network.neuron_hid0.ROM0.address\[3\] network.neuron_hid0.ROM0.address\[1\]
+ VSS VSS VDD VDD _07299_ sky130_fd_sc_hd__nand2_1
Xclkbuf_leaf_156_clk_net clknet_4_1_0_clk_net VSS VSS VDD
+ VDD clknet_leaf_156_clk_net sky130_fd_sc_hd__clkbuf_16
X_10859_ net402 net408 VSS VSS VDD VDD _07301_ sky130_fd_sc_hd__nor2_1
Xclkbuf_leaf_155_clk_net clknet_4_1_0_clk_net VSS VSS VDD
+ VDD clknet_leaf_155_clk_net sky130_fd_sc_hd__clkbuf_16
X_10861_ net400 net338 net337 VSS VSS VDD VDD _07303_ sky130_fd_sc_hd__a21oi_1
Xclkbuf_leaf_154_clk_net clknet_4_1_0_clk_net VSS VSS VDD
+ VDD clknet_leaf_154_clk_net sky130_fd_sc_hd__clkbuf_16
Xclkbuf_leaf_153_clk_net clknet_4_1_0_clk_net VSS VSS VDD
+ VDD clknet_leaf_153_clk_net sky130_fd_sc_hd__clkbuf_16
X_10864_ net408 net346 VSS VSS VDD VDD _07306_ sky130_fd_sc_hd__nor2_1
Xclkbuf_leaf_152_clk_net clknet_4_1_0_clk_net VSS VSS VDD
+ VDD clknet_leaf_152_clk_net sky130_fd_sc_hd__clkbuf_16
Xclkbuf_leaf_151_clk_net clknet_4_1_0_clk_net VSS VSS VDD
+ VDD clknet_leaf_151_clk_net sky130_fd_sc_hd__clkbuf_16
X_10867_ net400 net402 net408 VSS VSS VDD VDD _07309_ sky130_fd_sc_hd__a21oi_1
X_10868_ network.neuron_hid0.ROM0.address\[0\] VSS VSS VDD
+ VDD _07310_ sky130_fd_sc_hd__inv_1
Xclkbuf_leaf_150_clk_net clknet_4_3_0_clk_net VSS VSS VDD
+ VDD clknet_leaf_150_clk_net sky130_fd_sc_hd__clkbuf_16
Xclkbuf_leaf_149_clk_net clknet_4_3_0_clk_net VSS VSS VDD
+ VDD clknet_leaf_149_clk_net sky130_fd_sc_hd__clkbuf_16
X_10871_ net400 _07306_ _07309_ net336 VSS VSS VDD VDD _07313_
+ sky130_fd_sc_hd__o22ai_1
X_10872_ net339 _07313_ VSS VSS VDD VDD _07314_ sky130_fd_sc_hd__nand2_1
Xclkbuf_leaf_148_clk_net clknet_4_3_0_clk_net VSS VSS VDD
+ VDD clknet_leaf_148_clk_net sky130_fd_sc_hd__clkbuf_16
X_10874_ net411 net402 net408 VSS VSS VDD VDD _07316_ sky130_fd_sc_hd__nand3_1
X_10875_ net339 net411 _07303_ _07314_ _07316_ VSS VSS VDD
+ VDD _07317_ sky130_fd_sc_hd__o311ai_0
X_10876_ net341 _07317_ VSS VSS VDD VDD _07318_ sky130_fd_sc_hd__nand2_1
Xclkbuf_leaf_147_clk_net clknet_4_3_0_clk_net VSS VSS VDD
+ VDD clknet_leaf_147_clk_net sky130_fd_sc_hd__clkbuf_16
Xclkbuf_leaf_146_clk_net clknet_4_3_0_clk_net VSS VSS VDD
+ VDD clknet_leaf_146_clk_net sky130_fd_sc_hd__clkbuf_16
Xclkbuf_leaf_145_clk_net clknet_4_6_0_clk_net VSS VSS VDD
+ VDD clknet_leaf_145_clk_net sky130_fd_sc_hd__clkbuf_16
Xclkbuf_leaf_144_clk_net clknet_4_6_0_clk_net VSS VSS VDD
+ VDD clknet_leaf_144_clk_net sky130_fd_sc_hd__clkbuf_16
Xclkbuf_leaf_143_clk_net clknet_4_6_0_clk_net VSS VSS VDD
+ VDD clknet_leaf_143_clk_net sky130_fd_sc_hd__clkbuf_16
Xclkbuf_leaf_142_clk_net clknet_4_6_0_clk_net VSS VSS VDD
+ VDD clknet_leaf_142_clk_net sky130_fd_sc_hd__clkbuf_16
X_10883_ net402 network.neuron_hid0.ROM0.address\[1\] VSS
+ VSS VDD VDD _07325_ sky130_fd_sc_hd__nand2b_1
Xclkbuf_leaf_141_clk_net clknet_4_6_0_clk_net VSS VSS VDD
+ VDD clknet_leaf_141_clk_net sky130_fd_sc_hd__clkbuf_16
Xclkbuf_leaf_140_clk_net clknet_4_6_0_clk_net VSS VSS VDD
+ VDD clknet_leaf_140_clk_net sky130_fd_sc_hd__clkbuf_16
Xclkbuf_leaf_139_clk_net clknet_4_4_0_clk_net VSS VSS VDD
+ VDD clknet_leaf_139_clk_net sky130_fd_sc_hd__clkbuf_16
Xclkbuf_leaf_138_clk_net clknet_4_4_0_clk_net VSS VSS VDD
+ VDD clknet_leaf_138_clk_net sky130_fd_sc_hd__clkbuf_16
X_10888_ net400 net402 VSS VSS VDD VDD _07330_ sky130_fd_sc_hd__nor2_1
X_10889_ net342 net410 VSS VSS VDD VDD _07331_ sky130_fd_sc_hd__nor2_1
X_10890_ _07330_ net307 VSS VSS VDD VDD _07332_ sky130_fd_sc_hd__nor2_1
Xclkbuf_leaf_137_clk_net clknet_4_4_0_clk_net VSS VSS VDD
+ VDD clknet_leaf_137_clk_net sky130_fd_sc_hd__clkbuf_16
Xclkbuf_leaf_136_clk_net clknet_4_4_0_clk_net VSS VSS VDD
+ VDD clknet_leaf_136_clk_net sky130_fd_sc_hd__clkbuf_16
Xclkbuf_leaf_135_clk_net clknet_4_4_0_clk_net VSS VSS VDD
+ VDD clknet_leaf_135_clk_net sky130_fd_sc_hd__clkbuf_16
Xclkbuf_leaf_134_clk_net clknet_4_4_0_clk_net VSS VSS VDD
+ VDD clknet_leaf_134_clk_net sky130_fd_sc_hd__clkbuf_16
X_10895_ network.neuron_hid0.ROM0.address\[1\] network.neuron_hid0.ROM0.address\[3\]
+ VSS VSS VDD VDD _07337_ sky130_fd_sc_hd__nand2b_2
Xclkbuf_leaf_133_clk_net clknet_4_4_0_clk_net VSS VSS VDD
+ VDD clknet_leaf_133_clk_net sky130_fd_sc_hd__clkbuf_16
Xclkbuf_leaf_132_clk_net clknet_4_4_0_clk_net VSS VSS VDD
+ VDD clknet_leaf_132_clk_net sky130_fd_sc_hd__clkbuf_16
X_10898_ net400 net335 _07332_ net395 net334 VSS VSS VDD VDD
+ _07340_ sky130_fd_sc_hd__o221ai_1
X_10899_ net342 net411 VSS VSS VDD VDD _07341_ sky130_fd_sc_hd__nand2_1
Xclkbuf_leaf_131_clk_net clknet_4_4_0_clk_net VSS VSS VDD
+ VDD clknet_leaf_131_clk_net sky130_fd_sc_hd__clkbuf_16
Xclkbuf_leaf_130_clk_net clknet_4_5_0_clk_net VSS VSS VDD
+ VDD clknet_leaf_130_clk_net sky130_fd_sc_hd__clkbuf_16
Xclkbuf_leaf_129_clk_net clknet_4_4_0_clk_net VSS VSS VDD
+ VDD clknet_leaf_129_clk_net sky130_fd_sc_hd__clkbuf_16
X_10903_ net395 net402 net409 VSS VSS VDD VDD _07345_ sky130_fd_sc_hd__a21oi_1
X_10904_ _07341_ _07345_ VSS VSS VDD VDD _07346_ sky130_fd_sc_hd__nor2_1
X_10905_ net404 _07340_ _07346_ VSS VSS VDD VDD _07347_ sky130_fd_sc_hd__a21oi_1
Xclkbuf_leaf_128_clk_net clknet_4_5_0_clk_net VSS VSS VDD
+ VDD clknet_leaf_128_clk_net sky130_fd_sc_hd__clkbuf_16
Xclkbuf_leaf_127_clk_net clknet_4_5_0_clk_net VSS VSS VDD
+ VDD clknet_leaf_127_clk_net sky130_fd_sc_hd__clkbuf_16
Xclkbuf_leaf_126_clk_net clknet_4_5_0_clk_net VSS VSS VDD
+ VDD clknet_leaf_126_clk_net sky130_fd_sc_hd__clkbuf_16
Xclkbuf_leaf_125_clk_net clknet_4_5_0_clk_net VSS VSS VDD
+ VDD clknet_leaf_125_clk_net sky130_fd_sc_hd__clkbuf_16
X_10910_ net404 net411 VSS VSS VDD VDD _07352_ sky130_fd_sc_hd__and2_1
Xclkbuf_leaf_124_clk_net clknet_4_5_0_clk_net VSS VSS VDD
+ VDD clknet_leaf_124_clk_net sky130_fd_sc_hd__clkbuf_16
X_10912_ net411 net408 VSS VSS VDD VDD _07354_ sky130_fd_sc_hd__nor2_2
Xclkbuf_leaf_123_clk_net clknet_4_5_0_clk_net VSS VSS VDD
+ VDD clknet_leaf_123_clk_net sky130_fd_sc_hd__clkbuf_16
Xclkbuf_leaf_122_clk_net clknet_4_5_0_clk_net VSS VSS VDD
+ VDD clknet_leaf_122_clk_net sky130_fd_sc_hd__clkbuf_16
X_10915_ net408 net333 net332 net342 VSS VSS VDD VDD _07357_
+ sky130_fd_sc_hd__a22oi_1
Xclkbuf_leaf_121_clk_net clknet_4_5_0_clk_net VSS VSS VDD
+ VDD clknet_leaf_121_clk_net sky130_fd_sc_hd__clkbuf_16
Xclkbuf_leaf_120_clk_net clknet_4_5_0_clk_net VSS VSS VDD
+ VDD clknet_leaf_120_clk_net sky130_fd_sc_hd__clkbuf_16
Xclkbuf_leaf_119_clk_net clknet_4_5_0_clk_net VSS VSS VDD
+ VDD clknet_leaf_119_clk_net sky130_fd_sc_hd__clkbuf_16
Xclkbuf_leaf_118_clk_net clknet_4_7_0_clk_net VSS VSS VDD
+ VDD clknet_leaf_118_clk_net sky130_fd_sc_hd__clkbuf_16
X_10920_ net394 net408 VSS VSS VDD VDD _07362_ sky130_fd_sc_hd__nor2_1
X_10921_ _07274_ network.neuron_hid0.ROM0.address\[0\] VSS
+ VSS VDD VDD _07363_ sky130_fd_sc_hd__nor2_1
X_10922_ net402 _07362_ net306 VSS VSS VDD VDD _07364_ sky130_fd_sc_hd__o21ai_0
X_10923_ net339 net402 _07357_ _07364_ VSS VSS VDD VDD _07365_
+ sky130_fd_sc_hd__o31ai_1
Xclkbuf_leaf_117_clk_net clknet_4_7_0_clk_net VSS VSS VDD
+ VDD clknet_leaf_117_clk_net sky130_fd_sc_hd__clkbuf_16
X_10925_ network.neuron_hid0.ROM0.address\[0\] net335 VSS
+ VSS VDD VDD _07367_ sky130_fd_sc_hd__nor2_1
X_10926_ net406 net402 VSS VSS VDD VDD _07368_ sky130_fd_sc_hd__and2_1
Xclkbuf_leaf_116_clk_net clknet_4_7_0_clk_net VSS VSS VDD
+ VDD clknet_leaf_116_clk_net sky130_fd_sc_hd__clkbuf_16
Xclkbuf_leaf_115_clk_net clknet_4_7_0_clk_net VSS VSS VDD
+ VDD clknet_leaf_115_clk_net sky130_fd_sc_hd__clkbuf_16
Xclkbuf_leaf_114_clk_net clknet_4_7_0_clk_net VSS VSS VDD
+ VDD clknet_leaf_114_clk_net sky130_fd_sc_hd__clkbuf_16
X_10930_ net305 _07368_ net394 VSS VSS VDD VDD _07372_ sky130_fd_sc_hd__o21ai_0
X_10931_ net411 net334 VSS VSS VDD VDD _07373_ sky130_fd_sc_hd__nor2_2
X_10932_ network.neuron_hid0.ROM0.address\[3\] net408 VSS
+ VSS VDD VDD _07374_ sky130_fd_sc_hd__and2_1
X_10933_ _07274_ _07374_ VSS VSS VDD VDD _07375_ sky130_fd_sc_hd__nand2_1
X_10934_ network.neuron_hid0.ROM0.address\[3\] net406 VSS
+ VSS VDD VDD _07376_ sky130_fd_sc_hd__nand2b_2
Xclkbuf_leaf_113_clk_net clknet_4_7_0_clk_net VSS VSS VDD
+ VDD clknet_leaf_113_clk_net sky130_fd_sc_hd__clkbuf_16
X_10936_ _07290_ network.neuron_hid0.ROM0.address\[0\] VSS
+ VSS VDD VDD _07378_ sky130_fd_sc_hd__nand2_1
X_10937_ net304 _07376_ _07378_ VSS VSS VDD VDD _07379_ sky130_fd_sc_hd__a21oi_1
X_10938_ _07373_ _07379_ VSS VSS VDD VDD _07380_ sky130_fd_sc_hd__nor2_1
X_10939_ net407 network.neuron_hid0.ROM0.address\[0\] VSS
+ VSS VDD VDD _07381_ sky130_fd_sc_hd__nand2b_1
Xclkbuf_leaf_112_clk_net clknet_4_7_0_clk_net VSS VSS VDD
+ VDD clknet_leaf_112_clk_net sky130_fd_sc_hd__clkbuf_16
Xclkbuf_leaf_111_clk_net clknet_4_7_0_clk_net VSS VSS VDD
+ VDD clknet_leaf_111_clk_net sky130_fd_sc_hd__clkbuf_16
X_10942_ net403 VSS VSS VDD VDD _07384_ sky130_fd_sc_hd__inv_1
X_10943_ net394 net329 VSS VSS VDD VDD _07385_ sky130_fd_sc_hd__nor2_1
Xclkbuf_leaf_110_clk_net clknet_4_7_0_clk_net VSS VSS VDD
+ VDD clknet_leaf_110_clk_net sky130_fd_sc_hd__clkbuf_16
X_10945_ net409 net410 VSS VSS VDD VDD _07387_ sky130_fd_sc_hd__nor2b_1
Xclkbuf_leaf_109_clk_net clknet_4_7_0_clk_net VSS VSS VDD
+ VDD clknet_leaf_109_clk_net sky130_fd_sc_hd__clkbuf_16
X_10947_ net410 net409 VSS VSS VDD VDD _07389_ sky130_fd_sc_hd__nor2b_2
X_10948_ _07387_ net327 VSS VSS VDD VDD _07390_ sky130_fd_sc_hd__nor2_1
X_10949_ network.neuron_hid0.ROM0.address\[1\] net403 VSS
+ VSS VDD VDD _07391_ sky130_fd_sc_hd__nor2b_2
Xclkbuf_leaf_108_clk_net clknet_4_7_0_clk_net VSS VSS VDD
+ VDD clknet_leaf_108_clk_net sky130_fd_sc_hd__clkbuf_16
X_10951_ net410 _07391_ VSS VSS VDD VDD _07393_ sky130_fd_sc_hd__nand2_1
X_10952_ net394 _07390_ _07393_ VSS VSS VDD VDD _07394_ sky130_fd_sc_hd__o21ai_0
Xclkbuf_leaf_107_clk_net clknet_4_7_0_clk_net VSS VSS VDD
+ VDD clknet_leaf_107_clk_net sky130_fd_sc_hd__clkbuf_16
X_10954_ net330 _07385_ _07394_ _07274_ net400 VSS VSS VDD
+ VDD _07396_ sky130_fd_sc_hd__a221oi_1
X_10955_ net400 _07372_ _07380_ _07396_ VSS VSS VDD VDD _07397_
+ sky130_fd_sc_hd__a31oi_1
X_10956_ net392 _07365_ _07397_ VSS VSS VDD VDD _07398_ sky130_fd_sc_hd__nor3_1
X_10957_ net392 _07318_ _07347_ _07398_ VSS VSS VDD VDD _07399_
+ sky130_fd_sc_hd__a31oi_1
X_10958_ net294 _07281_ _07283_ _07399_ VSS VSS VDD VDD _01505_
+ sky130_fd_sc_hd__o22ai_1
X_10959_ network.neuron_in230.counter\[2\] VSS VSS VDD VDD
+ _07400_ sky130_fd_sc_hd__inv_1
X_10960_ network.neuron_in230.counter\[3\] network.in_period\[230\]\[2\]
+ _00355_ net363 VSS VSS VDD VDD _07401_ sky130_fd_sc_hd__o22ai_1
X_10961_ network.neuron_in230.counter\[2\] _00355_ net390
+ VSS VSS VDD VDD _07402_ sky130_fd_sc_hd__nand3_1
X_10962_ network.in_period\[230\]\[2\] net390 _07402_ VSS
+ VSS VDD VDD _07403_ sky130_fd_sc_hd__o21ai_0
X_10963_ _07400_ _07401_ _07403_ VSS VSS VDD VDD _02985_ sky130_fd_sc_hd__a21oi_1
X_10964_ network.neuron_in244.counter\[1\] VSS VSS VDD VDD
+ _01003_ sky130_fd_sc_hd__inv_1
X_10965_ network.neuron_in083.counter\[1\] VSS VSS VDD VDD
+ _00062_ sky130_fd_sc_hd__inv_1
X_10966_ network.neuron_in026.counter\[1\] VSS VSS VDD VDD
+ _00469_ sky130_fd_sc_hd__inv_1
X_10967_ network.neuron_in231.counter\[2\] net387 VSS VSS
+ VDD VDD _07404_ sky130_fd_sc_hd__nand2_1
X_10968_ network.neuron_in231.counter\[3\] network.in_period\[231\]\[2\]
+ _07404_ VSS VSS VDD VDD _07405_ sky130_fd_sc_hd__o21ai_0
Xclkbuf_leaf_106_clk_net clknet_4_6_0_clk_net VSS VSS VDD
+ VDD clknet_leaf_106_clk_net sky130_fd_sc_hd__clkbuf_16
X_10970_ _00573_ network.neuron_in231.counter\[2\] net364
+ VSS VSS VDD VDD _07407_ sky130_fd_sc_hd__or3_1
X_10971_ network.in_period\[231\]\[2\] net387 _07407_ VSS
+ VSS VDD VDD _07408_ sky130_fd_sc_hd__o21ai_0
X_10972_ _00573_ _07405_ _07408_ VSS VSS VDD VDD _02989_ sky130_fd_sc_hd__a21oi_1
X_10973_ network.neuron_in232.counter\[2\] _01073_ VSS VSS
+ VDD VDD _07409_ sky130_fd_sc_hd__nand2b_1
X_10974_ network.neuron_in232.counter\[3\] _07409_ VSS VSS
+ VDD VDD _07410_ sky130_fd_sc_hd__or2_2
X_10975_ net387 _07410_ VSS VSS VDD VDD _07411_ sky130_fd_sc_hd__nand2_1
X_10976_ net630 _07411_ VSS VSS VDD VDD _07412_ sky130_fd_sc_hd__nand2_1
X_10977_ _01074_ _07411_ _07412_ VSS VSS VDD VDD _02992_ sky130_fd_sc_hd__o21ai_0
X_10978_ network.neuron_in010.counter\[1\] VSS VSS VDD VDD
+ _00477_ sky130_fd_sc_hd__inv_1
X_10979_ net620 _07239_ VSS VSS VDD VDD _07413_ sky130_fd_sc_hd__nand2_1
X_10980_ _00804_ _07239_ _07413_ VSS VSS VDD VDD _02996_ sky130_fd_sc_hd__o21ai_0
X_10981_ network.neuron_in234.counter\[2\] network.neuron_in234.counter\[3\]
+ _00581_ VSS VSS VDD VDD _07414_ sky130_fd_sc_hd__or3b_2
X_10982_ net390 _07414_ VSS VSS VDD VDD _07415_ sky130_fd_sc_hd__nand2_1
X_10983_ net479 _07415_ VSS VSS VDD VDD _07416_ sky130_fd_sc_hd__nand2_1
X_10984_ network.neuron_in234.counter\[0\] _07415_ _07416_
+ VSS VSS VDD VDD _02999_ sky130_fd_sc_hd__o21ai_0
X_10985_ network.neuron_in235.counter\[0\] VSS VSS VDD VDD
+ _00317_ sky130_fd_sc_hd__inv_1
X_10986_ network.neuron_in235.counter\[3\] _00319_ VSS VSS
+ VDD VDD _07417_ sky130_fd_sc_hd__nand2b_1
X_10987_ network.neuron_in235.counter\[2\] VSS VSS VDD VDD
+ _07418_ sky130_fd_sc_hd__inv_1
X_10988_ _07417_ _07418_ VSS VSS VDD VDD _07419_ sky130_fd_sc_hd__nand2b_1
X_10989_ net390 _07419_ VSS VSS VDD VDD _07420_ sky130_fd_sc_hd__nand2_1
X_10990_ net468 _07420_ VSS VSS VDD VDD _07421_ sky130_fd_sc_hd__nand2_1
X_10991_ network.neuron_in235.counter\[0\] _07420_ _07421_
+ VSS VSS VDD VDD _03003_ sky130_fd_sc_hd__o21ai_0
Xclkbuf_leaf_105_clk_net clknet_4_6_0_clk_net VSS VSS VDD
+ VDD clknet_leaf_105_clk_net sky130_fd_sc_hd__clkbuf_16
Xclkbuf_leaf_104_clk_net clknet_4_6_0_clk_net VSS VSS VDD
+ VDD clknet_leaf_104_clk_net sky130_fd_sc_hd__clkbuf_16
Xclkbuf_leaf_103_clk_net clknet_4_6_0_clk_net VSS VSS VDD
+ VDD clknet_leaf_103_clk_net sky130_fd_sc_hd__clkbuf_16
Xclkbuf_leaf_102_clk_net clknet_4_12_0_clk_net VSS VSS VDD
+ VDD clknet_leaf_102_clk_net sky130_fd_sc_hd__clkbuf_16
X_10996_ net405 net409 VSS VSS VDD VDD _07426_ sky130_fd_sc_hd__nor2b_2
X_10997_ net342 _07368_ _07426_ VSS VSS VDD VDD _07427_ sky130_fd_sc_hd__a21oi_1
X_10998_ network.neuron_hid0.ROM0.address\[3\] network.neuron_hid0.ROM0.address\[0\]
+ VSS VSS VDD VDD _07428_ sky130_fd_sc_hd__nor2b_2
Xclkbuf_leaf_101_clk_net clknet_4_12_0_clk_net VSS VSS VDD
+ VDD clknet_leaf_101_clk_net sky130_fd_sc_hd__clkbuf_16
X_11000_ network.neuron_hid0.ROM0.address\[1\] net410 VSS
+ VSS VDD VDD _07430_ sky130_fd_sc_hd__nand2b_1
Xclkbuf_leaf_100_clk_net clknet_4_12_0_clk_net VSS VSS VDD
+ VDD clknet_leaf_100_clk_net sky130_fd_sc_hd__clkbuf_16
Xclkbuf_leaf_99_clk_net clknet_4_12_0_clk_net VSS VSS VDD
+ VDD clknet_leaf_99_clk_net sky130_fd_sc_hd__clkbuf_16
X_11003_ net403 _07430_ net397 VSS VSS VDD VDD _07433_ sky130_fd_sc_hd__a21oi_1
X_11004_ net325 _07433_ net341 VSS VSS VDD VDD _07434_ sky130_fd_sc_hd__o21ai_0
Xclkbuf_leaf_98_clk_net clknet_4_12_0_clk_net VSS VSS VDD
+ VDD clknet_leaf_98_clk_net sky130_fd_sc_hd__clkbuf_16
X_11006_ net410 net337 VSS VSS VDD VDD _07436_ sky130_fd_sc_hd__nand2_1
X_11007_ net410 _07427_ _07434_ _07436_ VSS VSS VDD VDD _07437_
+ sky130_fd_sc_hd__o211ai_1
Xclkbuf_leaf_97_clk_net clknet_4_12_0_clk_net VSS VSS VDD
+ VDD clknet_leaf_97_clk_net sky130_fd_sc_hd__clkbuf_16
X_11009_ net411 net402 VSS VSS VDD VDD _07439_ sky130_fd_sc_hd__or2_2
Xclkbuf_leaf_96_clk_net clknet_4_12_0_clk_net VSS VSS VDD
+ VDD clknet_leaf_96_clk_net sky130_fd_sc_hd__clkbuf_16
X_11011_ net399 _07439_ net330 VSS VSS VDD VDD _07441_ sky130_fd_sc_hd__o21ai_0
Xclkbuf_leaf_95_clk_net clknet_4_13_0_clk_net VSS VSS VDD
+ VDD clknet_leaf_95_clk_net sky130_fd_sc_hd__clkbuf_16
Xclkbuf_leaf_94_clk_net clknet_4_13_0_clk_net VSS VSS VDD
+ VDD clknet_leaf_94_clk_net sky130_fd_sc_hd__clkbuf_16
X_11014_ net341 net329 VSS VSS VDD VDD _07444_ sky130_fd_sc_hd__nand2_1
X_11015_ net397 net333 VSS VSS VDD VDD _07445_ sky130_fd_sc_hd__nand2_1
X_11016_ net399 _07444_ _07445_ VSS VSS VDD VDD _07446_ sky130_fd_sc_hd__o21ai_0
X_11017_ net404 net400 VSS VSS VDD VDD _07447_ sky130_fd_sc_hd__nand2b_1
X_11018_ net409 _07447_ VSS VSS VDD VDD _07448_ sky130_fd_sc_hd__nand2_1
X_11019_ net409 net307 net333 _07448_ net403 VSS VSS VDD VDD
+ _07449_ sky130_fd_sc_hd__o311a_1
X_11020_ net409 _07441_ _07446_ _07449_ net339 VSS VSS VDD
+ VDD _07450_ sky130_fd_sc_hd__a2111oi_0
X_11021_ net411 net402 net404 VSS VSS VDD VDD _07451_ sky130_fd_sc_hd__nand3b_1
X_11022_ net330 _07451_ VSS VSS VDD VDD _07452_ sky130_fd_sc_hd__nand2_1
X_11023_ network.neuron_hid0.ROM0.address\[0\] net402 VSS
+ VSS VDD VDD _07453_ sky130_fd_sc_hd__nand2_2
Xclkbuf_leaf_93_clk_net clknet_4_13_0_clk_net VSS VSS VDD
+ VDD clknet_leaf_93_clk_net sky130_fd_sc_hd__clkbuf_16
X_11025_ net410 net403 VSS VSS VDD VDD _07455_ sky130_fd_sc_hd__nor2_2
X_11026_ _07274_ _07453_ net323 VSS VSS VDD VDD _07456_ sky130_fd_sc_hd__a21oi_1
X_11027_ net400 net411 VSS VSS VDD VDD _07457_ sky130_fd_sc_hd__nor2_1
X_11028_ net409 net400 VSS VSS VDD VDD _07458_ sky130_fd_sc_hd__nand2b_1
X_11029_ _07453_ _07458_ VSS VSS VDD VDD _07459_ sky130_fd_sc_hd__nor2_1
X_11030_ _07457_ _07459_ net404 VSS VSS VDD VDD _07460_ sky130_fd_sc_hd__o21ai_0
X_11031_ net409 _07456_ _07460_ VSS VSS VDD VDD _07461_ sky130_fd_sc_hd__o21ai_0
X_11032_ net409 _07452_ _07461_ net394 VSS VSS VDD VDD _07462_
+ sky130_fd_sc_hd__a211oi_1
Xclkbuf_leaf_92_clk_net clknet_4_13_0_clk_net VSS VSS VDD
+ VDD clknet_leaf_92_clk_net sky130_fd_sc_hd__clkbuf_16
Xclkbuf_leaf_91_clk_net clknet_4_13_0_clk_net VSS VSS VDD
+ VDD clknet_leaf_91_clk_net sky130_fd_sc_hd__clkbuf_16
Xclkbuf_leaf_90_clk_net clknet_4_13_0_clk_net VSS VSS VDD
+ VDD clknet_leaf_90_clk_net sky130_fd_sc_hd__clkbuf_16
Xclkbuf_leaf_89_clk_net clknet_4_13_0_clk_net VSS VSS VDD
+ VDD clknet_leaf_89_clk_net sky130_fd_sc_hd__clkbuf_16
Xclkbuf_leaf_88_clk_net clknet_4_13_0_clk_net VSS VSS VDD
+ VDD clknet_leaf_88_clk_net sky130_fd_sc_hd__clkbuf_16
X_11038_ net336 net408 VSS VSS VDD VDD _07468_ sky130_fd_sc_hd__nand2_1
X_11039_ _07468_ _07436_ net405 VSS VSS VDD VDD _07469_ sky130_fd_sc_hd__a21oi_1
X_11040_ net405 net346 _07469_ VSS VSS VDD VDD _07470_ sky130_fd_sc_hd__a21oi_1
X_11041_ net336 net326 VSS VSS VDD VDD _07471_ sky130_fd_sc_hd__nand2_1
X_11042_ net410 net340 VSS VSS VDD VDD _07472_ sky130_fd_sc_hd__nand2_1
X_11043_ _07471_ _07472_ VSS VSS VDD VDD _07473_ sky130_fd_sc_hd__nand2_1
X_11044_ net392 net339 VSS VSS VDD VDD _07474_ sky130_fd_sc_hd__nand2_1
Xclkbuf_leaf_87_clk_net clknet_4_13_0_clk_net VSS VSS VDD
+ VDD clknet_leaf_87_clk_net sky130_fd_sc_hd__clkbuf_16
X_11046_ net411 net409 VSS VSS VDD VDD _07476_ sky130_fd_sc_hd__and2_0
X_11047_ net399 net332 _07476_ VSS VSS VDD VDD _07477_ sky130_fd_sc_hd__a21oi_1
X_11048_ net341 _07477_ VSS VSS VDD VDD _07478_ sky130_fd_sc_hd__nor2_1
X_11049_ net399 _07473_ _07474_ _07478_ VSS VSS VDD VDD _07479_
+ sky130_fd_sc_hd__a211oi_1
X_11050_ net399 _07470_ _07479_ VSS VSS VDD VDD _07480_ sky130_fd_sc_hd__o21ai_0
X_11051_ net392 _07450_ _07462_ _07480_ VSS VSS VDD VDD _07481_
+ sky130_fd_sc_hd__o31ai_1
X_11052_ net392 net395 _07437_ _07481_ VSS VSS VDD VDD _07482_
+ sky130_fd_sc_hd__a31oi_1
X_11053_ net391 net347 VSS VSS VDD VDD _07483_ sky130_fd_sc_hd__nand2_1
X_11054_ _07282_ _07483_ VSS VSS VDD VDD _07484_ sky130_fd_sc_hd__nor2_2
Xclkbuf_leaf_86_clk_net clknet_4_15_0_clk_net VSS VSS VDD
+ VDD clknet_leaf_86_clk_net sky130_fd_sc_hd__clkbuf_16
Xclkbuf_leaf_85_clk_net clknet_4_15_0_clk_net VSS VSS VDD
+ VDD clknet_leaf_85_clk_net sky130_fd_sc_hd__clkbuf_16
Xclkbuf_leaf_84_clk_net clknet_4_13_0_clk_net VSS VSS VDD
+ VDD clknet_leaf_84_clk_net sky130_fd_sc_hd__clkbuf_16
Xclkbuf_leaf_83_clk_net clknet_4_15_0_clk_net VSS VSS VDD
+ VDD clknet_leaf_83_clk_net sky130_fd_sc_hd__clkbuf_16
X_11059_ net329 _07430_ VSS VSS VDD VDD _07489_ sky130_fd_sc_hd__nand2_1
Xclkbuf_leaf_82_clk_net clknet_4_15_0_clk_net VSS VSS VDD
+ VDD clknet_leaf_82_clk_net sky130_fd_sc_hd__clkbuf_16
Xclkbuf_leaf_81_clk_net clknet_4_15_0_clk_net VSS VSS VDD
+ VDD clknet_leaf_81_clk_net sky130_fd_sc_hd__clkbuf_16
X_11062_ net405 net403 VSS VSS VDD VDD _07492_ sky130_fd_sc_hd__nor2_1
X_11063_ net410 net321 VSS VSS VDD VDD _07493_ sky130_fd_sc_hd__nor2_1
X_11064_ net405 _07489_ _07493_ net409 VSS VSS VDD VDD _07494_
+ sky130_fd_sc_hd__a22oi_1
X_11065_ net406 net408 VSS VSS VDD VDD _07495_ sky130_fd_sc_hd__nand2b_1
X_11066_ net404 net332 VSS VSS VDD VDD _07496_ sky130_fd_sc_hd__nand2_1
X_11067_ _07495_ _07496_ VSS VSS VDD VDD _07497_ sky130_fd_sc_hd__nand2_1
X_11068_ net342 net403 VSS VSS VDD VDD _07498_ sky130_fd_sc_hd__nor2_2
X_11069_ _07497_ _07498_ VSS VSS VDD VDD _07499_ sky130_fd_sc_hd__nand2_1
X_11070_ net397 _07494_ _07499_ VSS VSS VDD VDD _07500_ sky130_fd_sc_hd__o21ai_0
X_11071_ net293 _07500_ VSS VSS VDD VDD _07501_ sky130_fd_sc_hd__nand2_1
X_11072_ _07283_ _07482_ _07501_ VSS VSS VDD VDD _01506_ sky130_fd_sc_hd__o21ai_0
Xclkbuf_leaf_80_clk_net clknet_4_15_0_clk_net VSS VSS VDD
+ VDD clknet_leaf_80_clk_net sky130_fd_sc_hd__clkbuf_16
X_11074_ network.neuron_in236.counter\[3\] _00371_ VSS VSS
+ VDD VDD _07503_ sky130_fd_sc_hd__nand2b_1
X_11075_ network.neuron_in236.counter\[2\] VSS VSS VDD VDD
+ _07504_ sky130_fd_sc_hd__inv_1
X_11076_ _07503_ _07504_ VSS VSS VDD VDD _07505_ sky130_fd_sc_hd__nand2b_1
X_11077_ net388 _07505_ VSS VSS VDD VDD _07506_ sky130_fd_sc_hd__nand2_1
X_11078_ net525 _07506_ VSS VSS VDD VDD _07507_ sky130_fd_sc_hd__nand2_1
X_11079_ network.neuron_in236.counter\[0\] _07506_ _07507_
+ VSS VSS VDD VDD _03007_ sky130_fd_sc_hd__o21ai_0
X_11080_ network.neuron_in229.counter\[3\] _00661_ VSS VSS
+ VDD VDD _07508_ sky130_fd_sc_hd__nand2b_1
X_11081_ _07508_ _07113_ VSS VSS VDD VDD _07509_ sky130_fd_sc_hd__nand2b_1
X_11082_ net381 _07509_ VSS VSS VDD VDD _07510_ sky130_fd_sc_hd__nand2_1
X_11083_ net576 _07510_ VSS VSS VDD VDD _07511_ sky130_fd_sc_hd__nand2_1
X_11084_ _00662_ _07510_ _07511_ VSS VSS VDD VDD _02980_ sky130_fd_sc_hd__o21ai_0
X_11085_ network.neuron_in229.counter\[0\] VSS VSS VDD VDD
+ _00659_ sky130_fd_sc_hd__inv_1
X_11086_ net567 _07510_ VSS VSS VDD VDD _07512_ sky130_fd_sc_hd__nand2_1
X_11087_ network.neuron_in229.counter\[0\] _07510_ _07512_
+ VSS VSS VDD VDD _02979_ sky130_fd_sc_hd__o21ai_0
X_11088_ network.neuron_in009.counter\[1\] VSS VSS VDD VDD
+ _00481_ sky130_fd_sc_hd__inv_1
X_11089_ network.neuron_in230.counter\[2\] network.neuron_in230.counter\[3\]
+ VSS VSS VDD VDD _07513_ sky130_fd_sc_hd__nor2_1
X_11090_ _00355_ _07513_ VSS VSS VDD VDD _07514_ sky130_fd_sc_hd__nand2_1
X_11091_ net390 _07514_ VSS VSS VDD VDD _07515_ sky130_fd_sc_hd__nand2_1
X_11092_ net472 _07515_ VSS VSS VDD VDD _07516_ sky130_fd_sc_hd__nand2_1
X_11093_ _00356_ _07515_ _07516_ VSS VSS VDD VDD _02984_ sky130_fd_sc_hd__o21ai_0
X_11094_ network.neuron_in044.counter\[0\] VSS VSS VDD VDD
+ _00281_ sky130_fd_sc_hd__inv_1
X_11095_ network.neuron_in244.counter\[0\] VSS VSS VDD VDD
+ _01002_ sky130_fd_sc_hd__inv_1
X_11096_ network.neuron_in156.counter\[2\] _01077_ VSS VSS
+ VDD VDD _07517_ sky130_fd_sc_hd__nand2b_1
X_11097_ network.neuron_in156.counter\[3\] _07517_ VSS VSS
+ VDD VDD _07518_ sky130_fd_sc_hd__or2_2
X_11098_ net381 _07518_ VSS VSS VDD VDD _07519_ sky130_fd_sc_hd__nand2_1
X_11099_ net778 _07519_ VSS VSS VDD VDD _07520_ sky130_fd_sc_hd__nand2_1
X_11100_ _01078_ _07519_ _07520_ VSS VSS VDD VDD _02688_ sky130_fd_sc_hd__o21ai_0
X_11101_ network.neuron_in005.counter\[1\] VSS VSS VDD VDD
+ _00617_ sky130_fd_sc_hd__inv_1
X_11102_ network.neuron_in008.counter\[1\] VSS VSS VDD VDD
+ _00489_ sky130_fd_sc_hd__inv_1
X_11103_ network.neuron_in230.counter\[0\] VSS VSS VDD VDD
+ _00353_ sky130_fd_sc_hd__inv_1
X_11104_ net478 _07515_ VSS VSS VDD VDD _07521_ sky130_fd_sc_hd__nand2_1
X_11105_ network.neuron_in230.counter\[0\] _07515_ _07521_
+ VSS VSS VDD VDD _02983_ sky130_fd_sc_hd__o21ai_0
X_11106_ net560 _07234_ VSS VSS VDD VDD _07522_ sky130_fd_sc_hd__nand2_1
X_11107_ network.neuron_in231.counter\[0\] _07234_ _07522_
+ VSS VSS VDD VDD _02987_ sky130_fd_sc_hd__o21ai_0
X_11108_ network.neuron_in232.counter\[2\] net387 VSS VSS
+ VDD VDD _07523_ sky130_fd_sc_hd__nand2_1
X_11109_ network.neuron_in232.counter\[3\] network.in_period\[232\]\[2\]
+ _07523_ VSS VSS VDD VDD _07524_ sky130_fd_sc_hd__o21ai_0
X_11110_ _01073_ network.neuron_in232.counter\[2\] net358
+ VSS VSS VDD VDD _07525_ sky130_fd_sc_hd__or3_1
X_11111_ network.in_period\[232\]\[2\] net387 _07525_ VSS
+ VSS VDD VDD _07526_ sky130_fd_sc_hd__o21ai_0
X_11112_ _01073_ _07524_ _07526_ VSS VSS VDD VDD _02993_ sky130_fd_sc_hd__a21oi_1
X_11113_ net598 _07411_ VSS VSS VDD VDD _07527_ sky130_fd_sc_hd__nand2_1
X_11114_ network.neuron_in232.counter\[0\] _07411_ _07527_
+ VSS VSS VDD VDD _02991_ sky130_fd_sc_hd__o21ai_0
X_11115_ network.neuron_in214.counter\[1\] VSS VSS VDD VDD
+ _00999_ sky130_fd_sc_hd__inv_1
X_11116_ network.neuron_in010.counter\[0\] VSS VSS VDD VDD
+ _00476_ sky130_fd_sc_hd__inv_1
X_11117_ network.neuron_in233.counter\[3\] network.in_period\[233\]\[2\]
+ _00803_ net364 VSS VSS VDD VDD _07528_ sky130_fd_sc_hd__o22ai_1
X_11118_ network.neuron_in233.counter\[2\] _00803_ net372
+ VSS VSS VDD VDD _07529_ sky130_fd_sc_hd__nand3_1
X_11119_ network.in_period\[233\]\[2\] net372 _07529_ VSS
+ VSS VDD VDD _07530_ sky130_fd_sc_hd__o21ai_0
X_11120_ _07237_ _07528_ _07530_ VSS VSS VDD VDD _02997_ sky130_fd_sc_hd__a21oi_1
X_11121_ net477 _07415_ VSS VSS VDD VDD _07531_ sky130_fd_sc_hd__nand2_1
X_11122_ _00582_ _07415_ _07531_ VSS VSS VDD VDD _03000_ sky130_fd_sc_hd__o21ai_0
X_11123_ network.neuron_in152.counter\[1\] VSS VSS VDD VDD
+ _00501_ sky130_fd_sc_hd__inv_1
X_11124_ network.neuron_in235.counter\[3\] network.in_period\[235\]\[2\]
+ _00319_ net363 VSS VSS VDD VDD _07532_ sky130_fd_sc_hd__o22ai_1
X_11125_ network.neuron_in235.counter\[2\] _00319_ net390
+ VSS VSS VDD VDD _07533_ sky130_fd_sc_hd__nand3_1
X_11126_ network.in_period\[235\]\[2\] net390 _07533_ VSS
+ VSS VDD VDD _07534_ sky130_fd_sc_hd__o21ai_0
X_11127_ _07418_ _07532_ _07534_ VSS VSS VDD VDD _03005_ sky130_fd_sc_hd__a21oi_1
X_11128_ network.neuron_in089.counter\[1\] VSS VSS VDD VDD
+ _01219_ sky130_fd_sc_hd__inv_1
X_11129_ net467 _07420_ VSS VSS VDD VDD _07535_ sky130_fd_sc_hd__nand2_1
X_11130_ _00320_ _07420_ _07535_ VSS VSS VDD VDD _03004_ sky130_fd_sc_hd__o21ai_0
Xclkbuf_leaf_79_clk_net clknet_4_15_0_clk_net VSS VSS VDD
+ VDD clknet_leaf_79_clk_net sky130_fd_sc_hd__clkbuf_16
X_11132_ net391 _07282_ VSS VSS VDD VDD _07537_ sky130_fd_sc_hd__nor2_4
Xclkbuf_leaf_78_clk_net clknet_4_15_0_clk_net VSS VSS VDD
+ VDD clknet_leaf_78_clk_net sky130_fd_sc_hd__clkbuf_16
Xclkbuf_leaf_77_clk_net clknet_4_15_0_clk_net VSS VSS VDD
+ VDD clknet_leaf_77_clk_net sky130_fd_sc_hd__clkbuf_16
Xclkbuf_leaf_76_clk_net clknet_4_14_0_clk_net VSS VSS VDD
+ VDD clknet_leaf_76_clk_net sky130_fd_sc_hd__clkbuf_16
X_11136_ net411 _07444_ net409 VSS VSS VDD VDD _07541_ sky130_fd_sc_hd__a21o_1
X_11137_ net407 network.neuron_hid0.ROM0.address\[0\] VSS
+ VSS VDD VDD _07542_ sky130_fd_sc_hd__nand2_1
X_11138_ net402 net320 VSS VSS VDD VDD _07543_ sky130_fd_sc_hd__nand2_1
X_11139_ net404 net411 VSS VSS VDD VDD _07544_ sky130_fd_sc_hd__nor2_2
X_11140_ net409 _07543_ net319 net326 net400 VSS VSS VDD VDD
+ _07545_ sky130_fd_sc_hd__a2111oi_0
X_11141_ net400 _07451_ _07541_ _07545_ VSS VSS VDD VDD _07546_
+ sky130_fd_sc_hd__a31oi_1
X_11142_ net341 net336 net340 VSS VSS VDD VDD _07547_ sky130_fd_sc_hd__nor3_1
X_11143_ net341 net338 net324 _07547_ VSS VSS VDD VDD _07548_
+ sky130_fd_sc_hd__a31oi_1
X_11144_ net395 net342 VSS VSS VDD VDD _07549_ sky130_fd_sc_hd__nor2_2
Xclkbuf_leaf_75_clk_net clknet_4_14_0_clk_net VSS VSS VDD
+ VDD clknet_leaf_75_clk_net sky130_fd_sc_hd__clkbuf_16
Xclkbuf_leaf_74_clk_net clknet_4_14_0_clk_net VSS VSS VDD
+ VDD clknet_leaf_74_clk_net sky130_fd_sc_hd__clkbuf_16
X_11147_ net404 net327 _07451_ _07472_ VSS VSS VDD VDD _07552_
+ sky130_fd_sc_hd__o211ai_1
X_11148_ net394 net401 VSS VSS VDD VDD _07553_ sky130_fd_sc_hd__nor2_1
X_11149_ net395 _07546_ _07548_ _07549_ _07552_ net318 VSS
+ VSS VDD VDD _07554_ sky130_fd_sc_hd__a222oi_1
X_11150_ net404 _07439_ VSS VSS VDD VDD _07555_ sky130_fd_sc_hd__nand2_1
X_11151_ net408 net407 VSS VSS VDD VDD _07556_ sky130_fd_sc_hd__nand2b_1
Xclkbuf_leaf_73_clk_net clknet_4_15_0_clk_net VSS VSS VDD
+ VDD clknet_leaf_73_clk_net sky130_fd_sc_hd__clkbuf_16
X_11153_ net345 net317 VSS VSS VDD VDD _07558_ sky130_fd_sc_hd__nor2_1
X_11154_ net341 net346 VSS VSS VDD VDD _07559_ sky130_fd_sc_hd__nand2_1
X_11155_ net318 _07559_ VSS VSS VDD VDD _07560_ sky130_fd_sc_hd__nand2_1
X_11156_ net409 _07555_ _07558_ _07560_ VSS VSS VDD VDD _07561_
+ sky130_fd_sc_hd__a211oi_1
X_11157_ net411 net408 net402 VSS VSS VDD VDD _07562_ sky130_fd_sc_hd__a21oi_2
X_11158_ net404 _07562_ VSS VSS VDD VDD _07563_ sky130_fd_sc_hd__nand2_1
X_11159_ net407 net408 VSS VSS VDD VDD _07564_ sky130_fd_sc_hd__nor2_1
X_11160_ _07274_ net338 VSS VSS VDD VDD _07565_ sky130_fd_sc_hd__nor2_1
X_11161_ net316 net303 net411 VSS VSS VDD VDD _07566_ sky130_fd_sc_hd__o21ai_0
X_11162_ net339 net401 VSS VSS VDD VDD _07567_ sky130_fd_sc_hd__nand2_1
X_11163_ _07563_ _07566_ _07567_ VSS VSS VDD VDD _07568_ sky130_fd_sc_hd__a21oi_1
X_11164_ net342 net408 VSS VSS VDD VDD _07569_ sky130_fd_sc_hd__nand2_1
X_11165_ net317 _07569_ net345 VSS VSS VDD VDD _07570_ sky130_fd_sc_hd__a21oi_1
X_11166_ network.neuron_hid0.ROM0.address\[0\] network.neuron_hid0.ROM0.address\[3\]
+ VSS VSS VDD VDD _07571_ sky130_fd_sc_hd__nand2b_1
X_11167_ net399 net409 VSS VSS VDD VDD _07572_ sky130_fd_sc_hd__nor2_2
X_11168_ _07571_ _07572_ net395 VSS VSS VDD VDD _07573_ sky130_fd_sc_hd__o21ai_0
X_11169_ net341 net345 _07569_ _07570_ _07573_ VSS VSS VDD
+ VDD _07574_ sky130_fd_sc_hd__a311oi_1
X_11170_ net392 _07561_ _07568_ _07574_ VSS VSS VDD VDD _07575_
+ sky130_fd_sc_hd__nor4_1
X_11171_ net392 _07554_ _07575_ VSS VSS VDD VDD _07576_ sky130_fd_sc_hd__a21oi_1
X_11172_ net334 _07468_ net341 VSS VSS VDD VDD _07577_ sky130_fd_sc_hd__a21oi_1
Xclkbuf_leaf_72_clk_net clknet_4_14_0_clk_net VSS VSS VDD
+ VDD clknet_leaf_72_clk_net sky130_fd_sc_hd__clkbuf_16
X_11174_ net321 _07577_ net342 VSS VSS VDD VDD _07579_ sky130_fd_sc_hd__o21a_1
X_11175_ _07390_ net321 _07579_ VSS VSS VDD VDD _07580_ sky130_fd_sc_hd__a21oi_1
X_11176_ _07537_ _07576_ _07580_ net294 VSS VSS VDD VDD _01507_
+ sky130_fd_sc_hd__o2bb2ai_1
X_11177_ net401 net406 VSS VSS VDD VDD _07581_ sky130_fd_sc_hd__nand2_1
Xclkbuf_leaf_71_clk_net clknet_4_14_0_clk_net VSS VSS VDD
+ VDD clknet_leaf_71_clk_net sky130_fd_sc_hd__clkbuf_16
X_11179_ net406 net334 VSS VSS VDD VDD _07583_ sky130_fd_sc_hd__nor2_1
X_11180_ net407 network.neuron_hid0.ROM0.address\[0\] network.neuron_hid0.ROM0.address\[3\]
+ VSS VSS VDD VDD _07584_ sky130_fd_sc_hd__or3_1
X_11181_ net336 _07384_ VSS VSS VDD VDD _07585_ sky130_fd_sc_hd__nor2_1
X_11182_ net407 net302 VSS VSS VDD VDD _07586_ sky130_fd_sc_hd__nand2_1
X_11183_ net336 net335 VSS VSS VDD VDD _07587_ sky130_fd_sc_hd__nor2_1
X_11184_ net338 net306 _07587_ net400 VSS VSS VDD VDD _07588_
+ sky130_fd_sc_hd__a211oi_1
X_11185_ net400 _07584_ _07586_ _07588_ VSS VSS VDD VDD _07589_
+ sky130_fd_sc_hd__a31oi_1
X_11186_ net402 net404 VSS VSS VDD VDD _07590_ sky130_fd_sc_hd__nor2b_1
X_11187_ net409 net315 net400 VSS VSS VDD VDD _07591_ sky130_fd_sc_hd__o21a_1
X_11188_ _07269_ _07591_ net336 VSS VSS VDD VDD _07592_ sky130_fd_sc_hd__o21ai_0
X_11189_ net325 _07572_ net341 VSS VSS VDD VDD _07593_ sky130_fd_sc_hd__o21ai_0
X_11190_ net395 net324 _07592_ _07593_ VSS VSS VDD VDD _07594_
+ sky130_fd_sc_hd__nand4_1
X_11191_ net394 _07583_ _07589_ _07594_ VSS VSS VDD VDD _07595_
+ sky130_fd_sc_hd__o31ai_1
X_11192_ _07390_ _07581_ _07595_ VSS VSS VDD VDD _07596_ sky130_fd_sc_hd__o21ai_0
X_11193_ _07316_ _07447_ VSS VSS VDD VDD _07597_ sky130_fd_sc_hd__nor2_1
X_11194_ net341 net324 VSS VSS VDD VDD _07598_ sky130_fd_sc_hd__nor2_2
X_11195_ network.neuron_hid0.ROM0.address\[0\] net408 VSS
+ VSS VDD VDD _07599_ sky130_fd_sc_hd__nand2_1
Xclkbuf_leaf_70_clk_net clknet_4_14_0_clk_net VSS VSS VDD
+ VDD clknet_leaf_70_clk_net sky130_fd_sc_hd__clkbuf_16
X_11197_ net342 _07599_ net406 VSS VSS VDD VDD _07601_ sky130_fd_sc_hd__a21oi_1
X_11198_ _07598_ _07601_ net402 VSS VSS VDD VDD _07602_ sky130_fd_sc_hd__o21ai_0
X_11199_ net406 _07439_ VSS VSS VDD VDD _07603_ sky130_fd_sc_hd__nor2_1
X_11200_ net400 net408 _07453_ _07603_ VSS VSS VDD VDD _07604_
+ sky130_fd_sc_hd__a31oi_1
X_11201_ net400 _07562_ VSS VSS VDD VDD _07605_ sky130_fd_sc_hd__nand2_1
X_11202_ net400 net323 _07605_ VSS VSS VDD VDD _07606_ sky130_fd_sc_hd__o21ai_0
X_11203_ _07274_ _07310_ VSS VSS VDD VDD _07607_ sky130_fd_sc_hd__nand2_2
X_11204_ net400 _07607_ VSS VSS VDD VDD _07608_ sky130_fd_sc_hd__nand2_1
Xclkbuf_leaf_69_clk_net clknet_4_14_0_clk_net VSS VSS VDD
+ VDD clknet_leaf_69_clk_net sky130_fd_sc_hd__clkbuf_16
X_11206_ net406 _07606_ _07608_ net326 net394 VSS VSS VDD
+ VDD _07610_ sky130_fd_sc_hd__a221oi_1
X_11207_ net394 _07602_ _07604_ _07610_ VSS VSS VDD VDD _07611_
+ sky130_fd_sc_hd__a31oi_1
X_11208_ net393 _07597_ _07611_ VSS VSS VDD VDD _07612_ sky130_fd_sc_hd__nor3_1
X_11209_ net392 _07596_ _07612_ VSS VSS VDD VDD _07613_ sky130_fd_sc_hd__a21oi_1
Xclkbuf_leaf_68_clk_net clknet_4_14_0_clk_net VSS VSS VDD
+ VDD clknet_leaf_68_clk_net sky130_fd_sc_hd__clkbuf_16
X_11211_ net401 net402 VSS VSS VDD VDD _07615_ sky130_fd_sc_hd__nor2b_1
X_11212_ net401 net337 _07615_ VSS VSS VDD VDD _07616_ sky130_fd_sc_hd__a21oi_1
X_11213_ net326 _07587_ VSS VSS VDD VDD _07617_ sky130_fd_sc_hd__nor2_1
Xclkbuf_leaf_67_clk_net clknet_4_12_0_clk_net VSS VSS VDD
+ VDD clknet_leaf_67_clk_net sky130_fd_sc_hd__clkbuf_16
X_11215_ net411 _07616_ _07617_ net401 VSS VSS VDD VDD _07619_
+ sky130_fd_sc_hd__o22ai_1
Xclkbuf_leaf_66_clk_net clknet_4_12_0_clk_net VSS VSS VDD
+ VDD clknet_leaf_66_clk_net sky130_fd_sc_hd__clkbuf_16
X_11217_ net410 network.neuron_hid0.ROM0.address\[1\] VSS
+ VSS VDD VDD _07621_ sky130_fd_sc_hd__or2_2
Xclkbuf_leaf_65_clk_net clknet_4_12_0_clk_net VSS VSS VDD
+ VDD clknet_leaf_65_clk_net sky130_fd_sc_hd__clkbuf_16
X_11219_ net399 _07621_ _07572_ VSS VSS VDD VDD _07623_ sky130_fd_sc_hd__a21oi_1
Xclkbuf_leaf_64_clk_net clknet_4_9_0_clk_net VSS VSS VDD VDD
+ clknet_leaf_64_clk_net sky130_fd_sc_hd__clkbuf_16
X_11221_ _07341_ net338 _07623_ net403 net341 VSS VSS VDD
+ VDD _07625_ sky130_fd_sc_hd__o221ai_1
X_11222_ net341 _07619_ _07625_ VSS VSS VDD VDD _07626_ sky130_fd_sc_hd__o21ai_0
X_11223_ _07537_ _07613_ _07626_ net294 VSS VSS VDD VDD _01508_
+ sky130_fd_sc_hd__o2bb2ai_1
X_11224_ network.neuron_in105.counter\[1\] VSS VSS VDD VDD
+ _00497_ sky130_fd_sc_hd__inv_1
X_11225_ network.neuron_in236.counter\[3\] network.in_period\[236\]\[2\]
+ _00371_ net358 VSS VSS VDD VDD _07627_ sky130_fd_sc_hd__o22ai_1
Xclkbuf_leaf_63_clk_net clknet_4_9_0_clk_net VSS VSS VDD VDD
+ clknet_leaf_63_clk_net sky130_fd_sc_hd__clkbuf_16
X_11227_ network.neuron_in236.counter\[2\] _00371_ net388
+ VSS VSS VDD VDD _07629_ sky130_fd_sc_hd__nand3_1
X_11228_ network.in_period\[236\]\[2\] net388 _07629_ VSS
+ VSS VDD VDD _07630_ sky130_fd_sc_hd__o21ai_0
X_11229_ _07504_ _07627_ _07630_ VSS VSS VDD VDD _03009_ sky130_fd_sc_hd__a21oi_1
X_11230_ net528 _07506_ VSS VSS VDD VDD _07631_ sky130_fd_sc_hd__nand2_1
X_11231_ _00372_ _07506_ _07631_ VSS VSS VDD VDD _03008_ sky130_fd_sc_hd__o21ai_0
X_11232_ network.neuron_in241.counter\[2\] VSS VSS VDD VDD
+ _07632_ sky130_fd_sc_hd__inv_1
X_11233_ network.in_period\[241\]\[2\] network.neuron_in241.counter\[3\]
+ _00543_ net361 VSS VSS VDD VDD _07633_ sky130_fd_sc_hd__o22ai_1
X_11234_ network.neuron_in241.counter\[2\] _00543_ net381
+ VSS VSS VDD VDD _07634_ sky130_fd_sc_hd__nand3_1
X_11235_ network.in_period\[241\]\[2\] net381 _07634_ VSS
+ VSS VDD VDD _07635_ sky130_fd_sc_hd__o21ai_0
X_11236_ _07632_ _07633_ _07635_ VSS VSS VDD VDD _03029_ sky130_fd_sc_hd__a21oi_1
X_11237_ network.neuron_in206.counter\[1\] VSS VSS VDD VDD
+ _00995_ sky130_fd_sc_hd__inv_1
X_11238_ network.neuron_in237.counter\[3\] _00610_ VSS VSS
+ VDD VDD _07636_ sky130_fd_sc_hd__nand2b_1
X_11239_ network.neuron_in237.counter\[2\] VSS VSS VDD VDD
+ _07637_ sky130_fd_sc_hd__inv_1
X_11240_ _07636_ _07637_ VSS VSS VDD VDD _07638_ sky130_fd_sc_hd__nand2b_1
X_11241_ net388 _07638_ VSS VSS VDD VDD _07639_ sky130_fd_sc_hd__nand2_1
X_11242_ net532 _07639_ VSS VSS VDD VDD _07640_ sky130_fd_sc_hd__nand2_1
X_11243_ _00611_ _07639_ _07640_ VSS VSS VDD VDD _03012_ sky130_fd_sc_hd__o21ai_0
X_11244_ network.neuron_in238.counter\[3\] _00926_ VSS VSS
+ VDD VDD _07641_ sky130_fd_sc_hd__nand2b_1
X_11245_ network.neuron_in238.counter\[2\] VSS VSS VDD VDD
+ _07642_ sky130_fd_sc_hd__inv_1
X_11246_ _07641_ _07642_ VSS VSS VDD VDD _07643_ sky130_fd_sc_hd__nand2b_1
X_11247_ net390 _07643_ VSS VSS VDD VDD _07644_ sky130_fd_sc_hd__nand2_1
X_11248_ net466 _07644_ VSS VSS VDD VDD _07645_ sky130_fd_sc_hd__nand2_1
X_11249_ _00927_ _07644_ _07645_ VSS VSS VDD VDD _03016_ sky130_fd_sc_hd__o21ai_0
X_11250_ network.neuron_in144.counter\[1\] VSS VSS VDD VDD
+ _00666_ sky130_fd_sc_hd__inv_1
X_11251_ network.neuron_in149.counter\[1\] VSS VSS VDD VDD
+ _00526_ sky130_fd_sc_hd__inv_1
X_11252_ network.neuron_in239.counter\[2\] VSS VSS VDD VDD
+ _07646_ sky130_fd_sc_hd__inv_1
X_11253_ _07646_ _00511_ VSS VSS VDD VDD _07647_ sky130_fd_sc_hd__nand2_1
X_11254_ network.neuron_in239.counter\[3\] _07647_ VSS VSS
+ VDD VDD _07648_ sky130_fd_sc_hd__or2_2
X_11255_ net390 _07648_ VSS VSS VDD VDD _07649_ sky130_fd_sc_hd__nand2_1
X_11256_ net465 _07649_ VSS VSS VDD VDD _07650_ sky130_fd_sc_hd__nand2_1
X_11257_ _00512_ _07649_ _07650_ VSS VSS VDD VDD _03020_ sky130_fd_sc_hd__o21ai_0
X_11258_ network.neuron_in240.counter\[2\] VSS VSS VDD VDD
+ _07651_ sky130_fd_sc_hd__inv_1
X_11259_ _07651_ _00523_ VSS VSS VDD VDD _07652_ sky130_fd_sc_hd__nand2_1
X_11260_ network.neuron_in240.counter\[3\] _07652_ VSS VSS
+ VDD VDD _07653_ sky130_fd_sc_hd__or2_2
X_11261_ net380 _07653_ VSS VSS VDD VDD _07654_ sky130_fd_sc_hd__nand2_1
X_11262_ network.in_period\[240\]\[1\] _07654_ VSS VSS VDD
+ VDD _07655_ sky130_fd_sc_hd__nand2_1
X_11263_ _00524_ _07654_ _07655_ VSS VSS VDD VDD _03024_ sky130_fd_sc_hd__o21ai_0
X_11264_ network.neuron_in158.counter\[0\] VSS VSS VDD VDD
+ _00669_ sky130_fd_sc_hd__inv_1
X_11265_ network.neuron_in241.counter\[1\] VSS VSS VDD VDD
+ _00542_ sky130_fd_sc_hd__inv_1
X_11266_ network.neuron_in029.counter\[0\] VSS VSS VDD VDD
+ _00349_ sky130_fd_sc_hd__inv_1
X_11267_ network.neuron_in134.counter\[0\] VSS VSS VDD VDD
+ _00883_ sky130_fd_sc_hd__inv_1
X_11268_ network.in_period\[134\]\[0\] _07201_ VSS VSS VDD
+ VDD _07656_ sky130_fd_sc_hd__nand2_1
X_11269_ network.neuron_in134.counter\[0\] _07201_ _07656_
+ VSS VSS VDD VDD _02599_ sky130_fd_sc_hd__o21ai_0
X_11270_ network.neuron_in237.counter\[3\] network.in_period\[237\]\[2\]
+ net359 _00610_ VSS VSS VDD VDD _07657_ sky130_fd_sc_hd__o22ai_1
X_11271_ network.neuron_in237.counter\[2\] _00610_ net388
+ VSS VSS VDD VDD _07658_ sky130_fd_sc_hd__nand3_1
X_11272_ network.in_period\[237\]\[2\] net388 _07658_ VSS
+ VSS VDD VDD _07659_ sky130_fd_sc_hd__o21ai_0
X_11273_ _07637_ _07657_ _07659_ VSS VSS VDD VDD _03013_ sky130_fd_sc_hd__a21oi_1
X_11274_ net547 _07639_ VSS VSS VDD VDD _07660_ sky130_fd_sc_hd__nand2_1
X_11275_ network.neuron_in237.counter\[0\] _07639_ _07660_
+ VSS VSS VDD VDD _03011_ sky130_fd_sc_hd__o21ai_0
X_11276_ network.neuron_in135.counter\[2\] VSS VSS VDD VDD
+ _07661_ sky130_fd_sc_hd__inv_1
X_11277_ network.neuron_in135.counter\[3\] network.in_period\[135\]\[2\]
+ _00738_ net357 VSS VSS VDD VDD _07662_ sky130_fd_sc_hd__o22ai_1
X_11278_ network.neuron_in135.counter\[2\] _00738_ net384
+ VSS VSS VDD VDD _07663_ sky130_fd_sc_hd__nand3_1
X_11279_ network.in_period\[135\]\[2\] net384 _07663_ VSS
+ VSS VDD VDD _07664_ sky130_fd_sc_hd__o21ai_0
X_11280_ _07661_ _07662_ _07664_ VSS VSS VDD VDD _02605_ sky130_fd_sc_hd__a21oi_1
X_11281_ network.neuron_in238.counter\[3\] network.in_period\[238\]\[2\]
+ _00926_ net363 VSS VSS VDD VDD _07665_ sky130_fd_sc_hd__o22ai_1
X_11282_ network.neuron_in238.counter\[2\] _00926_ net390
+ VSS VSS VDD VDD _07666_ sky130_fd_sc_hd__nand3_1
X_11283_ network.in_period\[238\]\[2\] net390 _07666_ VSS
+ VSS VDD VDD _07667_ sky130_fd_sc_hd__o21ai_0
X_11284_ _07642_ _07665_ _07667_ VSS VSS VDD VDD _03017_ sky130_fd_sc_hd__a21oi_1
X_11285_ network.neuron_in238.counter\[0\] VSS VSS VDD VDD
+ _00924_ sky130_fd_sc_hd__inv_1
X_11286_ net470 _07644_ VSS VSS VDD VDD _07668_ sky130_fd_sc_hd__nand2_1
X_11287_ network.neuron_in238.counter\[0\] _07644_ _07668_
+ VSS VSS VDD VDD _03015_ sky130_fd_sc_hd__o21ai_0
X_11288_ network.neuron_in004.counter\[0\] VSS VSS VDD VDD
+ _00620_ sky130_fd_sc_hd__inv_1
X_11289_ network.neuron_in239.counter\[3\] network.in_period\[239\]\[2\]
+ _00511_ net363 VSS VSS VDD VDD _07669_ sky130_fd_sc_hd__o22ai_1
X_11290_ network.neuron_in239.counter\[2\] _00511_ net390
+ VSS VSS VDD VDD _07670_ sky130_fd_sc_hd__nand3_1
X_11291_ network.in_period\[239\]\[2\] net390 _07670_ VSS
+ VSS VDD VDD _07671_ sky130_fd_sc_hd__o21ai_0
X_11292_ _07646_ _07669_ _07671_ VSS VSS VDD VDD _03021_ sky130_fd_sc_hd__a21oi_1
X_11293_ network.neuron_in239.counter\[0\] VSS VSS VDD VDD
+ _00509_ sky130_fd_sc_hd__inv_1
X_11294_ net469 _07649_ VSS VSS VDD VDD _07672_ sky130_fd_sc_hd__nand2_1
X_11295_ network.neuron_in239.counter\[0\] _07649_ _07672_
+ VSS VSS VDD VDD _03019_ sky130_fd_sc_hd__o21ai_0
X_11296_ network.neuron_in007.counter\[1\] VSS VSS VDD VDD
+ _00538_ sky130_fd_sc_hd__inv_1
X_11297_ network.neuron_in240.counter\[3\] network.in_period\[240\]\[2\]
+ _00523_ net361 VSS VSS VDD VDD _07673_ sky130_fd_sc_hd__o22ai_1
Xclkbuf_leaf_62_clk_net clknet_4_9_0_clk_net VSS VSS VDD VDD
+ clknet_leaf_62_clk_net sky130_fd_sc_hd__clkbuf_16
X_11299_ network.neuron_in240.counter\[2\] _00523_ net379
+ VSS VSS VDD VDD _07675_ sky130_fd_sc_hd__nand3_1
X_11300_ network.in_period\[240\]\[2\] net379 _07675_ VSS
+ VSS VDD VDD _07676_ sky130_fd_sc_hd__o21ai_0
X_11301_ _07651_ _07673_ _07676_ VSS VSS VDD VDD _03025_ sky130_fd_sc_hd__a21oi_1
X_11302_ network.in_period\[240\]\[0\] _07654_ VSS VSS VDD
+ VDD _07677_ sky130_fd_sc_hd__nand2_1
X_11303_ network.neuron_in240.counter\[0\] _07654_ _07677_
+ VSS VSS VDD VDD _03023_ sky130_fd_sc_hd__o21ai_0
X_11304_ network.neuron_in242.counter\[2\] _00379_ VSS VSS
+ VDD VDD _07678_ sky130_fd_sc_hd__xnor2_1
X_11305_ network.neuron_in242.counter\[2\] network.neuron_in242.counter\[3\]
+ VSS VSS VDD VDD _07679_ sky130_fd_sc_hd__nor2_1
X_11306_ net359 _07679_ VSS VSS VDD VDD _07680_ sky130_fd_sc_hd__nor2_1
X_11307_ network.in_period\[242\]\[2\] _07680_ VSS VSS VDD
+ VDD _07681_ sky130_fd_sc_hd__nor2_1
X_11308_ net381 _07678_ _07681_ VSS VSS VDD VDD _03033_ sky130_fd_sc_hd__a21oi_1
X_11309_ network.neuron_in148.counter\[1\] VSS VSS VDD VDD
+ _00534_ sky130_fd_sc_hd__inv_1
X_11310_ network.neuron_in058.counter\[0\] VSS VSS VDD VDD
+ _00225_ sky130_fd_sc_hd__inv_1
X_11311_ network.neuron_in118.counter\[1\] VSS VSS VDD VDD
+ _00107_ sky130_fd_sc_hd__inv_1
X_11312_ network.neuron_in243.counter\[2\] network.neuron_in243.counter\[3\]
+ VSS VSS VDD VDD _07682_ sky130_fd_sc_hd__nor2_1
X_11313_ net363 _07682_ VSS VSS VDD VDD _07683_ sky130_fd_sc_hd__nor2_1
X_11314_ network.neuron_in243.counter\[2\] _00913_ VSS VSS
+ VDD VDD _07684_ sky130_fd_sc_hd__xnor2_1
X_11315_ network.in_period\[243\]\[2\] _07683_ _07684_ net380
+ VSS VSS VDD VDD _03037_ sky130_fd_sc_hd__a2bb2oi_1
X_11316_ network.neuron_in243.counter\[0\] VSS VSS VDD VDD
+ _00911_ sky130_fd_sc_hd__inv_1
X_11317_ _00913_ _07682_ VSS VSS VDD VDD _07685_ sky130_fd_sc_hd__nand2_1
X_11318_ net380 _07685_ VSS VSS VDD VDD _07686_ sky130_fd_sc_hd__nand2_1
X_11319_ net549 _07686_ VSS VSS VDD VDD _07687_ sky130_fd_sc_hd__nand2_1
X_11320_ network.neuron_in243.counter\[0\] _07686_ _07687_
+ VSS VSS VDD VDD _03035_ sky130_fd_sc_hd__o21ai_0
X_11321_ network.neuron_in142.counter\[1\] VSS VSS VDD VDD
+ _00556_ sky130_fd_sc_hd__inv_1
X_11322_ network.neuron_in248.counter\[0\] VSS VSS VDD VDD
+ _00559_ sky130_fd_sc_hd__inv_1
X_11323_ network.neuron_in244.counter\[2\] VSS VSS VDD VDD
+ _07688_ sky130_fd_sc_hd__inv_1
X_11324_ network.in_period\[244\]\[2\] network.neuron_in244.counter\[3\]
+ net361 _01004_ VSS VSS VDD VDD _07689_ sky130_fd_sc_hd__o22ai_1
X_11325_ network.neuron_in244.counter\[2\] _01004_ net388
+ VSS VSS VDD VDD _07690_ sky130_fd_sc_hd__nand3_1
X_11326_ network.in_period\[244\]\[2\] net388 _07690_ VSS
+ VSS VDD VDD _07691_ sky130_fd_sc_hd__o21ai_0
X_11327_ _07688_ _07689_ _07691_ VSS VSS VDD VDD _03041_ sky130_fd_sc_hd__a21oi_1
X_11328_ network.neuron_in097.counter\[1\] VSS VSS VDD VDD
+ _00074_ sky130_fd_sc_hd__inv_1
X_11329_ network.neuron_in245.counter\[2\] VSS VSS VDD VDD
+ _07692_ sky130_fd_sc_hd__inv_1
Xclkbuf_leaf_61_clk_net clknet_4_9_0_clk_net VSS VSS VDD VDD
+ clknet_leaf_61_clk_net sky130_fd_sc_hd__clkbuf_16
X_11331_ network.in_period\[245\]\[2\] network.neuron_in245.counter\[3\]
+ _00697_ net361 VSS VSS VDD VDD _07694_ sky130_fd_sc_hd__o22ai_1
X_11332_ network.neuron_in245.counter\[2\] _00697_ net379
+ VSS VSS VDD VDD _07695_ sky130_fd_sc_hd__nand3_1
X_11333_ network.in_period\[245\]\[2\] net379 _07695_ VSS
+ VSS VDD VDD _07696_ sky130_fd_sc_hd__o21ai_0
X_11334_ _07692_ _07694_ _07696_ VSS VSS VDD VDD _03045_ sky130_fd_sc_hd__a21oi_1
X_11335_ network.neuron_in241.counter\[3\] _00543_ VSS VSS
+ VDD VDD _07697_ sky130_fd_sc_hd__nand2b_1
X_11336_ _07697_ _07632_ VSS VSS VDD VDD _07698_ sky130_fd_sc_hd__nand2b_1
X_11337_ net381 _07698_ VSS VSS VDD VDD _07699_ sky130_fd_sc_hd__nand2_1
X_11338_ network.in_period\[241\]\[1\] _07699_ VSS VSS VDD
+ VDD _07700_ sky130_fd_sc_hd__nand2_1
X_11339_ _00544_ _07699_ _07700_ VSS VSS VDD VDD _03028_ sky130_fd_sc_hd__o21ai_0
X_11340_ network.neuron_in098.counter\[1\] VSS VSS VDD VDD
+ _00720_ sky130_fd_sc_hd__inv_1
X_11341_ network.neuron_in241.counter\[0\] VSS VSS VDD VDD
+ _00541_ sky130_fd_sc_hd__inv_1
X_11342_ network.in_period\[241\]\[0\] _07699_ VSS VSS VDD
+ VDD _07701_ sky130_fd_sc_hd__nand2_1
X_11343_ network.neuron_in241.counter\[0\] _07699_ _07701_
+ VSS VSS VDD VDD _03027_ sky130_fd_sc_hd__o21ai_0
X_11344_ network.neuron_in151.counter\[1\] VSS VSS VDD VDD
+ _00505_ sky130_fd_sc_hd__inv_1
X_11345_ network.neuron_in242.counter\[3\] _00379_ VSS VSS
+ VDD VDD _07702_ sky130_fd_sc_hd__nand2b_1
X_11346_ network.neuron_in242.counter\[2\] _07702_ VSS VSS
+ VDD VDD _07703_ sky130_fd_sc_hd__or2_2
X_11347_ net381 _07703_ VSS VSS VDD VDD _07704_ sky130_fd_sc_hd__nand2_1
X_11348_ network.in_period\[242\]\[1\] _07704_ VSS VSS VDD
+ VDD _07705_ sky130_fd_sc_hd__nand2_1
X_11349_ _00380_ _07704_ _07705_ VSS VSS VDD VDD _03032_ sky130_fd_sc_hd__o21ai_0
X_11350_ network.neuron_in242.counter\[0\] VSS VSS VDD VDD
+ _00377_ sky130_fd_sc_hd__inv_1
X_11351_ network.in_period\[242\]\[0\] _07704_ VSS VSS VDD
+ VDD _07706_ sky130_fd_sc_hd__nand2_1
X_11352_ network.neuron_in242.counter\[0\] _07704_ _07706_
+ VSS VSS VDD VDD _03031_ sky130_fd_sc_hd__o21ai_0
X_11353_ network.neuron_in150.counter\[1\] VSS VSS VDD VDD
+ _00518_ sky130_fd_sc_hd__inv_1
X_11354_ network.neuron_in075.counter\[0\] VSS VSS VDD VDD
+ _00123_ sky130_fd_sc_hd__inv_1
Xclkbuf_leaf_60_clk_net clknet_4_9_0_clk_net VSS VSS VDD VDD
+ clknet_leaf_60_clk_net sky130_fd_sc_hd__clkbuf_16
X_11356_ network.neuron_in177.counter\[3\] _00589_ VSS VSS
+ VDD VDD _07708_ sky130_fd_sc_hd__nand2b_1
X_11357_ network.neuron_in177.counter\[2\] VSS VSS VDD VDD
+ _07709_ sky130_fd_sc_hd__inv_1
X_11358_ _07708_ _07709_ VSS VSS VDD VDD _07710_ sky130_fd_sc_hd__nand2b_1
X_11359_ net379 _07710_ VSS VSS VDD VDD _07711_ sky130_fd_sc_hd__nand2_1
X_11360_ net636 _07711_ VSS VSS VDD VDD _07712_ sky130_fd_sc_hd__nand2_1
X_11361_ network.neuron_in177.counter\[0\] _07711_ _07712_
+ VSS VSS VDD VDD _02771_ sky130_fd_sc_hd__o21ai_0
X_11362_ network.neuron_in172.counter\[3\] _01050_ VSS VSS
+ VDD VDD _07713_ sky130_fd_sc_hd__nand2b_1
X_11363_ network.neuron_in172.counter\[2\] VSS VSS VDD VDD
+ _07714_ sky130_fd_sc_hd__inv_1
X_11364_ _07713_ _07714_ VSS VSS VDD VDD _07715_ sky130_fd_sc_hd__nand2b_1
X_11365_ net378 _07715_ VSS VSS VDD VDD _07716_ sky130_fd_sc_hd__nand2_1
X_11366_ network.in_period\[172\]\[1\] _07716_ VSS VSS VDD
+ VDD _07717_ sky130_fd_sc_hd__nand2_1
X_11367_ _01051_ _07716_ _07717_ VSS VSS VDD VDD _02752_ sky130_fd_sc_hd__o21ai_0
X_11368_ net649 _07711_ VSS VSS VDD VDD _07718_ sky130_fd_sc_hd__nand2_1
X_11369_ _00590_ _07711_ _07718_ VSS VSS VDD VDD _02772_ sky130_fd_sc_hd__o21ai_0
X_11370_ network.neuron_in169.counter\[0\] VSS VSS VDD VDD
+ _00978_ sky130_fd_sc_hd__inv_1
X_11371_ network.neuron_in169.counter\[3\] _00980_ VSS VSS
+ VDD VDD _07719_ sky130_fd_sc_hd__nand2b_1
X_11372_ network.neuron_in169.counter\[2\] VSS VSS VDD VDD
+ _07720_ sky130_fd_sc_hd__inv_1
X_11373_ _07719_ _07720_ VSS VSS VDD VDD _07721_ sky130_fd_sc_hd__nand2b_1
X_11374_ net380 _07721_ VSS VSS VDD VDD _07722_ sky130_fd_sc_hd__nand2_1
X_11375_ network.in_period\[169\]\[0\] _07722_ VSS VSS VDD
+ VDD _07723_ sky130_fd_sc_hd__nand2_1
X_11376_ network.neuron_in169.counter\[0\] _07722_ _07723_
+ VSS VSS VDD VDD _02739_ sky130_fd_sc_hd__o21ai_0
X_11377_ network.neuron_in172.counter\[3\] network.in_period\[172\]\[2\]
+ net360 _01050_ VSS VSS VDD VDD _07724_ sky130_fd_sc_hd__o22ai_1
X_11378_ network.neuron_in172.counter\[2\] _01050_ net378
+ VSS VSS VDD VDD _07725_ sky130_fd_sc_hd__nand3_1
X_11379_ network.in_period\[172\]\[2\] net378 _07725_ VSS
+ VSS VDD VDD _07726_ sky130_fd_sc_hd__o21ai_0
X_11380_ _07714_ _07724_ _07726_ VSS VSS VDD VDD _02753_ sky130_fd_sc_hd__a21oi_1
X_11381_ network.neuron_in174.counter\[0\] VSS VSS VDD VDD
+ _00907_ sky130_fd_sc_hd__inv_1
X_11382_ network.neuron_in174.counter\[3\] _00909_ VSS VSS
+ VDD VDD _07727_ sky130_fd_sc_hd__nand2b_1
X_11383_ network.neuron_in174.counter\[2\] VSS VSS VDD VDD
+ _07728_ sky130_fd_sc_hd__inv_1
X_11384_ _07727_ _07728_ VSS VSS VDD VDD _07729_ sky130_fd_sc_hd__nand2b_1
X_11385_ net378 _07729_ VSS VSS VDD VDD _07730_ sky130_fd_sc_hd__nand2_1
X_11386_ network.in_period\[174\]\[0\] _07730_ VSS VSS VDD
+ VDD _07731_ sky130_fd_sc_hd__nand2_1
X_11387_ network.neuron_in174.counter\[0\] _07730_ _07731_
+ VSS VSS VDD VDD _02759_ sky130_fd_sc_hd__o21ai_0
X_11388_ network.neuron_in177.counter\[3\] network.in_period\[177\]\[2\]
+ net362 _00589_ VSS VSS VDD VDD _07732_ sky130_fd_sc_hd__o22ai_1
Xclkbuf_leaf_59_clk_net clknet_4_11_0_clk_net VSS VSS VDD
+ VDD clknet_leaf_59_clk_net sky130_fd_sc_hd__clkbuf_16
X_11390_ network.neuron_in177.counter\[2\] _00589_ net379
+ VSS VSS VDD VDD _07734_ sky130_fd_sc_hd__nand3_1
X_11391_ network.in_period\[177\]\[2\] net379 _07734_ VSS
+ VSS VDD VDD _07735_ sky130_fd_sc_hd__o21ai_0
X_11392_ _07709_ _07732_ _07735_ VSS VSS VDD VDD _02773_ sky130_fd_sc_hd__a21oi_1
X_11393_ network.neuron_in168.counter\[3\] _00952_ VSS VSS
+ VDD VDD _07736_ sky130_fd_sc_hd__nand2b_1
X_11394_ network.neuron_in168.counter\[2\] VSS VSS VDD VDD
+ _07737_ sky130_fd_sc_hd__inv_1
X_11395_ _07736_ _07737_ VSS VSS VDD VDD _07738_ sky130_fd_sc_hd__nand2b_1
X_11396_ net380 _07738_ VSS VSS VDD VDD _07739_ sky130_fd_sc_hd__nand2_1
X_11397_ network.in_period\[168\]\[1\] _07739_ VSS VSS VDD
+ VDD _07740_ sky130_fd_sc_hd__nand2_1
X_11398_ _00953_ _07739_ _07740_ VSS VSS VDD VDD _02736_ sky130_fd_sc_hd__o21ai_0
X_11399_ network.in_period\[169\]\[1\] _07722_ VSS VSS VDD
+ VDD _07741_ sky130_fd_sc_hd__nand2_1
X_11400_ _00981_ _07722_ _07741_ VSS VSS VDD VDD _02740_ sky130_fd_sc_hd__o21ai_0
X_11401_ network.neuron_in170.counter\[3\] network.neuron_in170.counter\[2\]
+ VSS VSS VDD VDD _07742_ sky130_fd_sc_hd__nor2_1
X_11402_ _01012_ _07742_ VSS VSS VDD VDD _07743_ sky130_fd_sc_hd__nand2_1
X_11403_ net380 _07743_ VSS VSS VDD VDD _07744_ sky130_fd_sc_hd__nand2_1
X_11404_ net609 _07744_ VSS VSS VDD VDD _07745_ sky130_fd_sc_hd__nand2_1
X_11405_ network.neuron_in170.counter\[0\] _07744_ _07745_
+ VSS VSS VDD VDD _02743_ sky130_fd_sc_hd__o21ai_0
X_11406_ network.neuron_in171.counter\[3\] _01028_ VSS VSS
+ VDD VDD _07746_ sky130_fd_sc_hd__nand2b_1
X_11407_ network.neuron_in171.counter\[2\] VSS VSS VDD VDD
+ _07747_ sky130_fd_sc_hd__inv_1
X_11408_ _07746_ _07747_ VSS VSS VDD VDD _07748_ sky130_fd_sc_hd__nand2b_1
X_11409_ net380 _07748_ VSS VSS VDD VDD _07749_ sky130_fd_sc_hd__nand2_1
X_11410_ network.in_period\[171\]\[0\] _07749_ VSS VSS VDD
+ VDD _07750_ sky130_fd_sc_hd__nand2_1
X_11411_ network.neuron_in171.counter\[0\] _07749_ _07750_
+ VSS VSS VDD VDD _02747_ sky130_fd_sc_hd__o21ai_0
X_11412_ network.neuron_in173.counter\[2\] network.neuron_in173.counter\[3\]
+ VSS VSS VDD VDD _07751_ sky130_fd_sc_hd__nor2_1
X_11413_ _00188_ _07751_ VSS VSS VDD VDD _07752_ sky130_fd_sc_hd__nand2_1
X_11414_ net378 _07752_ VSS VSS VDD VDD _07753_ sky130_fd_sc_hd__nand2_1
X_11415_ network.in_period\[173\]\[1\] _07753_ VSS VSS VDD
+ VDD _07754_ sky130_fd_sc_hd__nand2_1
X_11416_ _00189_ _07753_ _07754_ VSS VSS VDD VDD _02756_ sky130_fd_sc_hd__o21ai_0
X_11417_ network.in_period\[174\]\[1\] _07730_ VSS VSS VDD
+ VDD _07755_ sky130_fd_sc_hd__nand2_1
X_11418_ _00910_ _07730_ _07755_ VSS VSS VDD VDD _02760_ sky130_fd_sc_hd__o21ai_0
X_11419_ network.neuron_in175.counter\[0\] VSS VSS VDD VDD
+ _00805_ sky130_fd_sc_hd__inv_1
X_11420_ network.neuron_in175.counter\[3\] _00807_ VSS VSS
+ VDD VDD _07756_ sky130_fd_sc_hd__nand2b_1
X_11421_ network.neuron_in175.counter\[2\] VSS VSS VDD VDD
+ _07757_ sky130_fd_sc_hd__inv_1
X_11422_ _07756_ _07757_ VSS VSS VDD VDD _07758_ sky130_fd_sc_hd__nand2b_1
X_11423_ net378 _07758_ VSS VSS VDD VDD _07759_ sky130_fd_sc_hd__nand2_1
X_11424_ network.in_period\[175\]\[0\] _07759_ VSS VSS VDD
+ VDD _07760_ sky130_fd_sc_hd__nand2_1
X_11425_ network.neuron_in175.counter\[0\] _07759_ _07760_
+ VSS VSS VDD VDD _02763_ sky130_fd_sc_hd__o21ai_0
X_11426_ network.neuron_in176.counter\[0\] VSS VSS VDD VDD
+ _00727_ sky130_fd_sc_hd__inv_1
X_11427_ network.neuron_in176.counter\[3\] _00729_ VSS VSS
+ VDD VDD _07761_ sky130_fd_sc_hd__nand2b_1
X_11428_ network.neuron_in176.counter\[2\] VSS VSS VDD VDD
+ _07762_ sky130_fd_sc_hd__inv_1
X_11429_ _07761_ _07762_ VSS VSS VDD VDD _07763_ sky130_fd_sc_hd__nand2b_1
X_11430_ net366 _07763_ VSS VSS VDD VDD _07764_ sky130_fd_sc_hd__nand2_1
X_11431_ net627 _07764_ VSS VSS VDD VDD _07765_ sky130_fd_sc_hd__nand2_1
X_11432_ network.neuron_in176.counter\[0\] _07764_ _07765_
+ VSS VSS VDD VDD _02767_ sky130_fd_sc_hd__o21ai_0
X_11433_ network.neuron_in167.counter\[0\] VSS VSS VDD VDD
+ _00920_ sky130_fd_sc_hd__inv_1
X_11434_ network.neuron_in167.counter\[3\] _00922_ VSS VSS
+ VDD VDD _07766_ sky130_fd_sc_hd__nand2b_1
X_11435_ network.neuron_in167.counter\[2\] VSS VSS VDD VDD
+ _07767_ sky130_fd_sc_hd__inv_1
X_11436_ _07766_ _07767_ VSS VSS VDD VDD _07768_ sky130_fd_sc_hd__nand2b_1
X_11437_ net378 _07768_ VSS VSS VDD VDD _07769_ sky130_fd_sc_hd__nand2_1
X_11438_ net764 _07769_ VSS VSS VDD VDD _07770_ sky130_fd_sc_hd__nand2_1
X_11439_ network.neuron_in167.counter\[0\] _07769_ _07770_
+ VSS VSS VDD VDD _02731_ sky130_fd_sc_hd__o21ai_0
X_11440_ network.neuron_in168.counter\[3\] network.in_period\[168\]\[2\]
+ _00952_ net360 VSS VSS VDD VDD _07771_ sky130_fd_sc_hd__o22ai_1
X_11441_ network.neuron_in168.counter\[2\] _00952_ net380
+ VSS VSS VDD VDD _07772_ sky130_fd_sc_hd__nand3_1
X_11442_ network.in_period\[168\]\[2\] net380 _07772_ VSS
+ VSS VDD VDD _07773_ sky130_fd_sc_hd__o21ai_0
X_11443_ _07737_ _07771_ _07773_ VSS VSS VDD VDD _02737_ sky130_fd_sc_hd__a21oi_1
X_11444_ network.neuron_in168.counter\[0\] VSS VSS VDD VDD
+ _00950_ sky130_fd_sc_hd__inv_1
X_11445_ network.in_period\[168\]\[0\] _07739_ VSS VSS VDD
+ VDD _07774_ sky130_fd_sc_hd__nand2_1
X_11446_ network.neuron_in168.counter\[0\] _07739_ _07774_
+ VSS VSS VDD VDD _02735_ sky130_fd_sc_hd__o21ai_0
X_11447_ network.neuron_in169.counter\[3\] network.in_period\[169\]\[2\]
+ _00980_ net360 VSS VSS VDD VDD _07775_ sky130_fd_sc_hd__o22ai_1
X_11448_ network.neuron_in169.counter\[2\] _00980_ net380
+ VSS VSS VDD VDD _07776_ sky130_fd_sc_hd__nand3_1
X_11449_ network.in_period\[169\]\[2\] net380 _07776_ VSS
+ VSS VDD VDD _07777_ sky130_fd_sc_hd__o21ai_0
X_11450_ _07720_ _07775_ _07777_ VSS VSS VDD VDD _02741_ sky130_fd_sc_hd__a21oi_1
X_11451_ network.neuron_in170.counter\[2\] net380 VSS VSS
+ VDD VDD _07778_ sky130_fd_sc_hd__nand2_1
X_11452_ network.in_period\[170\]\[2\] network.neuron_in170.counter\[3\]
+ _07778_ VSS VSS VDD VDD _07779_ sky130_fd_sc_hd__o21ai_0
X_11453_ _01012_ network.neuron_in170.counter\[2\] net360
+ VSS VSS VDD VDD _07780_ sky130_fd_sc_hd__or3_1
X_11454_ network.in_period\[170\]\[2\] net380 _07780_ VSS
+ VSS VDD VDD _07781_ sky130_fd_sc_hd__o21ai_0
X_11455_ _01012_ _07779_ _07781_ VSS VSS VDD VDD _02745_ sky130_fd_sc_hd__a21oi_1
X_11456_ net613 _07744_ VSS VSS VDD VDD _07782_ sky130_fd_sc_hd__nand2_1
X_11457_ _01013_ _07744_ _07782_ VSS VSS VDD VDD _02744_ sky130_fd_sc_hd__o21ai_0
X_11458_ network.neuron_in171.counter\[3\] network.in_period\[171\]\[2\]
+ net360 _01028_ VSS VSS VDD VDD _07783_ sky130_fd_sc_hd__o22ai_1
X_11459_ network.neuron_in171.counter\[2\] _01028_ net380
+ VSS VSS VDD VDD _07784_ sky130_fd_sc_hd__nand3_1
X_11460_ network.in_period\[171\]\[2\] net380 _07784_ VSS
+ VSS VDD VDD _07785_ sky130_fd_sc_hd__o21ai_0
X_11461_ _07747_ _07783_ _07785_ VSS VSS VDD VDD _02749_ sky130_fd_sc_hd__a21oi_1
X_11462_ net579 _07749_ VSS VSS VDD VDD _07786_ sky130_fd_sc_hd__nand2_1
X_11463_ _01029_ _07749_ _07786_ VSS VSS VDD VDD _02748_ sky130_fd_sc_hd__o21ai_0
X_11464_ network.in_period\[172\]\[0\] _07716_ VSS VSS VDD
+ VDD _07787_ sky130_fd_sc_hd__nand2_1
X_11465_ network.neuron_in172.counter\[0\] _07716_ _07787_
+ VSS VSS VDD VDD _02751_ sky130_fd_sc_hd__o21ai_0
X_11466_ net360 _07751_ VSS VSS VDD VDD _07788_ sky130_fd_sc_hd__nor2_1
X_11467_ network.neuron_in173.counter\[2\] _00188_ VSS VSS
+ VDD VDD _07789_ sky130_fd_sc_hd__xnor2_1
X_11468_ network.in_period\[173\]\[2\] _07788_ _07789_ net378
+ VSS VSS VDD VDD _02757_ sky130_fd_sc_hd__a2bb2oi_1
X_11469_ network.neuron_in173.counter\[0\] VSS VSS VDD VDD
+ _00186_ sky130_fd_sc_hd__inv_1
X_11470_ network.in_period\[173\]\[0\] _07753_ VSS VSS VDD
+ VDD _07790_ sky130_fd_sc_hd__nand2_1
X_11471_ network.neuron_in173.counter\[0\] _07753_ _07790_
+ VSS VSS VDD VDD _02755_ sky130_fd_sc_hd__o21ai_0
X_11472_ network.neuron_in174.counter\[3\] network.in_period\[174\]\[2\]
+ _00909_ net360 VSS VSS VDD VDD _07791_ sky130_fd_sc_hd__o22ai_1
X_11473_ network.neuron_in174.counter\[2\] _00909_ net378
+ VSS VSS VDD VDD _07792_ sky130_fd_sc_hd__nand3_1
X_11474_ network.in_period\[174\]\[2\] net378 _07792_ VSS
+ VSS VDD VDD _07793_ sky130_fd_sc_hd__o21ai_0
X_11475_ _07728_ _07791_ _07793_ VSS VSS VDD VDD _02761_ sky130_fd_sc_hd__a21oi_1
X_11476_ network.neuron_in175.counter\[3\] network.in_period\[175\]\[2\]
+ _00807_ net360 VSS VSS VDD VDD _07794_ sky130_fd_sc_hd__o22ai_1
Xclkbuf_leaf_58_clk_net clknet_4_11_0_clk_net VSS VSS VDD
+ VDD clknet_leaf_58_clk_net sky130_fd_sc_hd__clkbuf_16
X_11478_ network.neuron_in175.counter\[2\] _00807_ net378
+ VSS VSS VDD VDD _07796_ sky130_fd_sc_hd__nand3_1
X_11479_ network.in_period\[175\]\[2\] net378 _07796_ VSS
+ VSS VDD VDD _07797_ sky130_fd_sc_hd__o21ai_0
X_11480_ _07757_ _07794_ _07797_ VSS VSS VDD VDD _02765_ sky130_fd_sc_hd__a21oi_1
X_11481_ network.in_period\[175\]\[1\] _07759_ VSS VSS VDD
+ VDD _07798_ sky130_fd_sc_hd__nand2_1
X_11482_ _00808_ _07759_ _07798_ VSS VSS VDD VDD _02764_ sky130_fd_sc_hd__o21ai_0
X_11483_ network.neuron_in176.counter\[3\] network.in_period\[176\]\[2\]
+ _00729_ net362 VSS VSS VDD VDD _07799_ sky130_fd_sc_hd__o22ai_1
X_11484_ network.neuron_in176.counter\[2\] _00729_ net366
+ VSS VSS VDD VDD _07800_ sky130_fd_sc_hd__nand3_1
X_11485_ network.in_period\[176\]\[2\] net366 _07800_ VSS
+ VSS VDD VDD _07801_ sky130_fd_sc_hd__o21ai_0
X_11486_ _07762_ _07799_ _07801_ VSS VSS VDD VDD _02769_ sky130_fd_sc_hd__a21oi_1
X_11487_ net654 _07764_ VSS VSS VDD VDD _07802_ sky130_fd_sc_hd__nand2_1
X_11488_ _00730_ _07764_ _07802_ VSS VSS VDD VDD _02768_ sky130_fd_sc_hd__o21ai_0
X_11489_ network.neuron_in028.counter\[0\] VSS VSS VDD VDD
+ _00373_ sky130_fd_sc_hd__inv_1
X_11490_ network.neuron_in028.counter\[2\] VSS VSS VDD VDD
+ _07803_ sky130_fd_sc_hd__inv_1
X_11491_ _07803_ _00375_ VSS VSS VDD VDD _07804_ sky130_fd_sc_hd__nand2_1
X_11492_ network.neuron_in028.counter\[3\] _07804_ VSS VSS
+ VDD VDD _07805_ sky130_fd_sc_hd__or2_2
X_11493_ net373 _07805_ VSS VSS VDD VDD _07806_ sky130_fd_sc_hd__nand2_1
X_11494_ net730 _07806_ VSS VSS VDD VDD _07807_ sky130_fd_sc_hd__nand2_1
X_11495_ network.neuron_in028.counter\[0\] _07806_ _07807_
+ VSS VSS VDD VDD _02175_ sky130_fd_sc_hd__o21ai_0
X_11496_ net807 _07806_ VSS VSS VDD VDD _07808_ sky130_fd_sc_hd__nand2_1
X_11497_ _00376_ _07806_ _07808_ VSS VSS VDD VDD _02176_ sky130_fd_sc_hd__o21ai_0
X_11498_ network.neuron_in029.counter\[2\] VSS VSS VDD VDD
+ _07809_ sky130_fd_sc_hd__inv_1
X_11499_ network.in_period\[29\]\[2\] network.neuron_in029.counter\[3\]
+ net352 _00351_ VSS VSS VDD VDD _07810_ sky130_fd_sc_hd__o22ai_1
X_11500_ network.neuron_in029.counter\[2\] _00351_ net370
+ VSS VSS VDD VDD _07811_ sky130_fd_sc_hd__nand3_1
X_11501_ network.in_period\[29\]\[2\] net370 _07811_ VSS VSS
+ VDD VDD _07812_ sky130_fd_sc_hd__o21ai_0
X_11502_ _07809_ _07810_ _07812_ VSS VSS VDD VDD _02181_ sky130_fd_sc_hd__a21oi_1
X_11503_ network.in_period\[28\]\[2\] network.neuron_in028.counter\[3\]
+ _00375_ net352 VSS VSS VDD VDD _07813_ sky130_fd_sc_hd__o22ai_1
X_11504_ network.neuron_in028.counter\[2\] _00375_ net373
+ VSS VSS VDD VDD _07814_ sky130_fd_sc_hd__nand3_1
X_11505_ network.in_period\[28\]\[2\] net373 _07814_ VSS VSS
+ VDD VDD _07815_ sky130_fd_sc_hd__o21ai_0
X_11506_ _07803_ _07813_ _07815_ VSS VSS VDD VDD _02177_ sky130_fd_sc_hd__a21oi_1
Xclkbuf_leaf_57_clk_net clknet_4_11_0_clk_net VSS VSS VDD
+ VDD clknet_leaf_57_clk_net sky130_fd_sc_hd__clkbuf_16
X_11508_ network.neuron_in029.counter\[3\] _00351_ VSS VSS
+ VDD VDD _07817_ sky130_fd_sc_hd__nand2b_1
X_11509_ _07817_ _07809_ VSS VSS VDD VDD _07818_ sky130_fd_sc_hd__nand2b_1
X_11510_ net370 _07818_ VSS VSS VDD VDD _07819_ sky130_fd_sc_hd__nand2_1
X_11511_ net695 _07819_ VSS VSS VDD VDD _07820_ sky130_fd_sc_hd__nand2_1
X_11512_ _00352_ _07819_ _07820_ VSS VSS VDD VDD _02180_ sky130_fd_sc_hd__o21ai_0
X_11513_ net786 _07819_ VSS VSS VDD VDD _07821_ sky130_fd_sc_hd__nand2_1
X_11514_ network.neuron_in029.counter\[0\] _07819_ _07821_
+ VSS VSS VDD VDD _02179_ sky130_fd_sc_hd__o21ai_0
X_11515_ network.neuron_in125.counter\[0\] VSS VSS VDD VDD
+ _00484_ sky130_fd_sc_hd__inv_1
X_11516_ network.neuron_in091.counter\[0\] VSS VSS VDD VDD
+ _00135_ sky130_fd_sc_hd__inv_1
X_11517_ net545 _07686_ VSS VSS VDD VDD _07822_ sky130_fd_sc_hd__nand2_1
X_11518_ _00914_ _07686_ _07822_ VSS VSS VDD VDD _03036_ sky130_fd_sc_hd__o21ai_0
X_11519_ network.neuron_in046.counter\[0\] VSS VSS VDD VDD
+ _00277_ sky130_fd_sc_hd__inv_1
X_11520_ network.neuron_in140.counter\[2\] _01081_ VSS VSS
+ VDD VDD _07823_ sky130_fd_sc_hd__nand2b_1
X_11521_ network.neuron_in140.counter\[3\] _07823_ VSS VSS
+ VDD VDD _07824_ sky130_fd_sc_hd__or2_2
X_11522_ net377 _07824_ VSS VSS VDD VDD _07825_ sky130_fd_sc_hd__nand2_1
X_11523_ network.in_period\[140\]\[0\] _07825_ VSS VSS VDD
+ VDD _07826_ sky130_fd_sc_hd__nand2_1
X_11524_ network.neuron_in140.counter\[0\] _07825_ _07826_
+ VSS VSS VDD VDD _02623_ sky130_fd_sc_hd__o21ai_0
X_11525_ network.neuron_in060.counter\[0\] VSS VSS VDD VDD
+ _00209_ sky130_fd_sc_hd__inv_1
X_11526_ network.neuron_in154.counter\[3\] _01166_ VSS VSS
+ VDD VDD _07827_ sky130_fd_sc_hd__nand2b_1
X_11527_ network.neuron_in154.counter\[2\] VSS VSS VDD VDD
+ _07828_ sky130_fd_sc_hd__inv_1
X_11528_ _07827_ _07828_ VSS VSS VDD VDD _07829_ sky130_fd_sc_hd__nand2b_1
X_11529_ net387 _07829_ VSS VSS VDD VDD _07830_ sky130_fd_sc_hd__nand2_1
X_11530_ net734 _07830_ VSS VSS VDD VDD _07831_ sky130_fd_sc_hd__nand2_1
X_11531_ _01167_ _07830_ _07831_ VSS VSS VDD VDD _02680_ sky130_fd_sc_hd__o21ai_0
X_11532_ network.neuron_in178.counter\[1\] VSS VSS VDD VDD
+ _00270_ sky130_fd_sc_hd__inv_1
X_11533_ network.neuron_in091.counter\[1\] VSS VSS VDD VDD
+ _00136_ sky130_fd_sc_hd__inv_1
X_11534_ network.neuron_in084.counter\[1\] VSS VSS VDD VDD
+ _00050_ sky130_fd_sc_hd__inv_1
X_11535_ network.neuron_in169.counter\[1\] VSS VSS VDD VDD
+ _00979_ sky130_fd_sc_hd__inv_1
X_11536_ network.neuron_in153.counter\[1\] VSS VSS VDD VDD
+ _00493_ sky130_fd_sc_hd__inv_1
X_11537_ network.neuron_in149.counter\[0\] VSS VSS VDD VDD
+ _00525_ sky130_fd_sc_hd__inv_1
X_11538_ network.neuron_in143.counter\[1\] VSS VSS VDD VDD
+ _00716_ sky130_fd_sc_hd__inv_1
X_11539_ network.neuron_in009.counter\[0\] VSS VSS VDD VDD
+ _00480_ sky130_fd_sc_hd__inv_1
X_11540_ network.neuron_in089.counter\[0\] VSS VSS VDD VDD
+ _01218_ sky130_fd_sc_hd__inv_1
X_11541_ network.neuron_in244.counter\[3\] _01004_ VSS VSS
+ VDD VDD _07832_ sky130_fd_sc_hd__nand2b_1
X_11542_ _07832_ _07688_ VSS VSS VDD VDD _07833_ sky130_fd_sc_hd__nand2b_1
X_11543_ net388 _07833_ VSS VSS VDD VDD _07834_ sky130_fd_sc_hd__nand2_1
X_11544_ network.in_period\[244\]\[1\] _07834_ VSS VSS VDD
+ VDD _07835_ sky130_fd_sc_hd__nand2_1
X_11545_ _01005_ _07834_ _07835_ VSS VSS VDD VDD _03040_ sky130_fd_sc_hd__o21ai_0
X_11546_ network.in_period\[244\]\[0\] _07834_ VSS VSS VDD
+ VDD _07836_ sky130_fd_sc_hd__nand2_1
X_11547_ network.neuron_in244.counter\[0\] _07834_ _07836_
+ VSS VSS VDD VDD _03039_ sky130_fd_sc_hd__o21ai_0
X_11548_ network.neuron_in145.counter\[1\] VSS VSS VDD VDD
+ _00642_ sky130_fd_sc_hd__inv_1
X_11549_ network.neuron_in085.counter\[1\] VSS VSS VDD VDD
+ _00043_ sky130_fd_sc_hd__inv_1
X_11550_ net406 _07599_ _07621_ VSS VSS VDD VDD _07837_ sky130_fd_sc_hd__o21ai_0
X_11551_ _07571_ _07376_ net400 VSS VSS VDD VDD _07838_ sky130_fd_sc_hd__a21oi_1
X_11552_ net400 _07837_ _07838_ _07583_ VSS VSS VDD VDD _07839_
+ sky130_fd_sc_hd__a211oi_1
X_11553_ net408 _07330_ net326 net400 VSS VSS VDD VDD _07840_
+ sky130_fd_sc_hd__a22oi_1
X_11554_ net401 net408 VSS VSS VDD VDD _07841_ sky130_fd_sc_hd__nand2_1
X_11555_ net404 net338 VSS VSS VDD VDD _07842_ sky130_fd_sc_hd__nor2_1
X_11556_ net315 _07841_ net411 _07842_ VSS VSS VDD VDD _07843_
+ sky130_fd_sc_hd__a211oi_1
Xclkbuf_leaf_56_clk_net clknet_4_11_0_clk_net VSS VSS VDD
+ VDD clknet_leaf_56_clk_net sky130_fd_sc_hd__clkbuf_16
X_11558_ net402 _07569_ net320 VSS VSS VDD VDD _07845_ sky130_fd_sc_hd__a21oi_1
X_11559_ _07843_ _07845_ net394 VSS VSS VDD VDD _07846_ sky130_fd_sc_hd__o21ai_0
X_11560_ net394 _07839_ _07840_ net406 _07846_ VSS VSS VDD
+ VDD _07847_ sky130_fd_sc_hd__o221ai_1
Xclkbuf_leaf_55_clk_net clknet_4_11_0_clk_net VSS VSS VDD
+ VDD clknet_leaf_55_clk_net sky130_fd_sc_hd__clkbuf_16
X_11562_ net339 net316 net333 VSS VSS VDD VDD _07849_ sky130_fd_sc_hd__a21oi_1
X_11563_ net400 net336 VSS VSS VDD VDD _07850_ sky130_fd_sc_hd__nor2_1
X_11564_ net407 net301 net394 VSS VSS VDD VDD _07851_ sky130_fd_sc_hd__o21ai_0
X_11565_ net401 _07849_ _07851_ VSS VSS VDD VDD _07852_ sky130_fd_sc_hd__o21ai_0
X_11566_ net323 _07385_ _07274_ VSS VSS VDD VDD _07853_ sky130_fd_sc_hd__o21ai_0
X_11567_ net407 net325 VSS VSS VDD VDD _07854_ sky130_fd_sc_hd__nand2_1
X_11568_ _07264_ _07571_ VSS VSS VDD VDD _07855_ sky130_fd_sc_hd__nand2_1
X_11569_ network.neuron_hid0.ROM0.address\[0\] net407 VSS
+ VSS VDD VDD _07856_ sky130_fd_sc_hd__nand2b_1
X_11570_ net394 _07856_ VSS VSS VDD VDD _07857_ sky130_fd_sc_hd__nor2_1
X_11571_ net394 _07855_ _07857_ net408 VSS VSS VDD VDD _07858_
+ sky130_fd_sc_hd__a211oi_1
X_11572_ net408 _07853_ _07854_ _07858_ VSS VSS VDD VDD _07859_
+ sky130_fd_sc_hd__a31oi_1
X_11573_ net335 net330 VSS VSS VDD VDD _07860_ sky130_fd_sc_hd__nor2_1
X_11574_ net334 _07857_ _07860_ VSS VSS VDD VDD _07861_ sky130_fd_sc_hd__a21oi_1
X_11575_ net401 _07861_ VSS VSS VDD VDD _07862_ sky130_fd_sc_hd__nor2_1
X_11576_ network.neuron_hid0.ROM0.address\[3\] _07852_ _07859_
+ net401 _07862_ VSS VSS VDD VDD _07863_ sky130_fd_sc_hd__a221oi_1
X_11577_ _07847_ _07863_ net393 VSS VSS VDD VDD _07864_ sky130_fd_sc_hd__mux2i_1
X_11578_ net335 net334 VSS VSS VDD VDD _07865_ sky130_fd_sc_hd__nand2_1
X_11579_ net400 net408 VSS VSS VDD VDD _07866_ sky130_fd_sc_hd__or2_2
Xclkbuf_leaf_54_clk_net clknet_4_11_0_clk_net VSS VSS VDD
+ VDD clknet_leaf_54_clk_net sky130_fd_sc_hd__clkbuf_16
X_11581_ net336 net340 VSS VSS VDD VDD _07868_ sky130_fd_sc_hd__nand2_1
X_11582_ _07866_ _07868_ net405 VSS VSS VDD VDD _07869_ sky130_fd_sc_hd__a21oi_1
X_11583_ net402 network.neuron_hid0.ROM0.address\[1\] VSS
+ VSS VDD VDD _07870_ sky130_fd_sc_hd__or2_2
Xclkbuf_leaf_53_clk_net clknet_4_11_0_clk_net VSS VSS VDD
+ VDD clknet_leaf_53_clk_net sky130_fd_sc_hd__clkbuf_16
X_11585_ net336 _07870_ VSS VSS VDD VDD _07872_ sky130_fd_sc_hd__nor2_2
X_11586_ net322 _07865_ _07869_ _07872_ VSS VSS VDD VDD _07873_
+ sky130_fd_sc_hd__a211oi_1
X_11587_ net391 _07864_ _07873_ _07483_ VSS VSS VDD VDD _07874_
+ sky130_fd_sc_hd__o22ai_1
X_11588_ _07282_ _07874_ VSS VSS VDD VDD _01509_ sky130_fd_sc_hd__nor2b_1
X_11589_ net407 net408 VSS VSS VDD VDD _07875_ sky130_fd_sc_hd__nand2_1
X_11590_ net302 net314 net305 VSS VSS VDD VDD _07876_ sky130_fd_sc_hd__a21oi_1
Xclkbuf_leaf_52_clk_net clknet_4_11_0_clk_net VSS VSS VDD
+ VDD clknet_leaf_52_clk_net sky130_fd_sc_hd__clkbuf_16
X_11592_ net395 _07870_ VSS VSS VDD VDD _07878_ sky130_fd_sc_hd__nor2_1
X_11593_ net394 net331 _07878_ VSS VSS VDD VDD _07879_ sky130_fd_sc_hd__a21oi_1
X_11594_ net411 _07879_ _07393_ VSS VSS VDD VDD _07880_ sky130_fd_sc_hd__o21ai_0
Xclkbuf_leaf_51_clk_net clknet_4_11_0_clk_net VSS VSS VDD
+ VDD clknet_leaf_51_clk_net sky130_fd_sc_hd__clkbuf_16
X_11596_ net334 _07868_ VSS VSS VDD VDD _07882_ sky130_fd_sc_hd__nand2_1
X_11597_ network.neuron_hid0.ROM0.address\[0\] net335 _07882_
+ net394 VSS VSS VDD VDD _07883_ sky130_fd_sc_hd__a211oi_1
X_11598_ net394 _07870_ _07599_ _07883_ net407 VSS VSS VDD
+ VDD _07884_ sky130_fd_sc_hd__a311oi_1
X_11599_ net339 net401 VSS VSS VDD VDD _07885_ sky130_fd_sc_hd__nor2_1
X_11600_ _07549_ net300 VSS VSS VDD VDD _07886_ sky130_fd_sc_hd__nor2_1
X_11601_ net407 _07880_ _07884_ _07886_ VSS VSS VDD VDD _07887_
+ sky130_fd_sc_hd__a211oi_1
X_11602_ net395 net399 VSS VSS VDD VDD _07888_ sky130_fd_sc_hd__nand2_1
X_11603_ net407 _07621_ VSS VSS VDD VDD _07889_ sky130_fd_sc_hd__nor2_1
X_11604_ _07577_ _07888_ _07889_ VSS VSS VDD VDD _07890_ sky130_fd_sc_hd__nor3_1
Xclkbuf_leaf_50_clk_net clknet_4_10_0_clk_net VSS VSS VDD
+ VDD clknet_leaf_50_clk_net sky130_fd_sc_hd__clkbuf_16
Xclkbuf_leaf_49_clk_net clknet_4_10_0_clk_net VSS VSS VDD
+ VDD clknet_leaf_49_clk_net sky130_fd_sc_hd__clkbuf_16
X_11607_ net318 _07876_ _07887_ _07890_ net393 VSS VSS VDD
+ VDD _07893_ sky130_fd_sc_hd__a2111oi_0
X_11608_ _07274_ net408 _07855_ VSS VSS VDD VDD _07894_ sky130_fd_sc_hd__nand3_1
X_11609_ net302 net317 _07894_ VSS VSS VDD VDD _07895_ sky130_fd_sc_hd__o21ai_0
X_11610_ net341 net302 _07363_ net408 VSS VSS VDD VDD _07896_
+ sky130_fd_sc_hd__a22oi_1
X_11611_ net405 _07455_ VSS VSS VDD VDD _07897_ sky130_fd_sc_hd__nand2_1
X_11612_ net401 _07896_ _07897_ VSS VSS VDD VDD _07898_ sky130_fd_sc_hd__o21ai_0
X_11613_ net401 _07895_ _07898_ VSS VSS VDD VDD _07899_ sky130_fd_sc_hd__a21oi_1
X_11614_ net408 net404 VSS VSS VDD VDD _07900_ sky130_fd_sc_hd__nor2b_1
X_11615_ _07426_ net313 VSS VSS VDD VDD _07901_ sky130_fd_sc_hd__nor2_1
X_11616_ net336 _07901_ VSS VSS VDD VDD _07902_ sky130_fd_sc_hd__nor2_1
X_11617_ _07373_ _07902_ net300 VSS VSS VDD VDD _07903_ sky130_fd_sc_hd__o21ai_0
X_11618_ _07428_ _07363_ net408 VSS VSS VDD VDD _07904_ sky130_fd_sc_hd__o21ai_0
X_11619_ net410 network.neuron_hid0.ROM0.address\[3\] network.neuron_hid0.ROM0.address\[1\]
+ VSS VSS VDD VDD _07905_ sky130_fd_sc_hd__or3_1
Xclkbuf_leaf_48_clk_net clknet_4_10_0_clk_net VSS VSS VDD
+ VDD clknet_leaf_48_clk_net sky130_fd_sc_hd__clkbuf_16
X_11621_ net395 net401 _07904_ _07905_ VSS VSS VDD VDD _07907_
+ sky130_fd_sc_hd__nand4_1
X_11622_ net395 _07899_ _07903_ _07907_ net393 VSS VSS VDD
+ VDD _07908_ sky130_fd_sc_hd__o2111ai_1
X_11623_ _07537_ _07908_ VSS VSS VDD VDD _07909_ sky130_fd_sc_hd__nand2_1
X_11624_ net404 net336 VSS VSS VDD VDD _07910_ sky130_fd_sc_hd__nor2_1
Xclkbuf_leaf_47_clk_net clknet_4_10_0_clk_net VSS VSS VDD
+ VDD clknet_leaf_47_clk_net sky130_fd_sc_hd__clkbuf_16
X_11626_ net400 net306 net299 _07598_ _07608_ VSS VSS VDD
+ VDD _07912_ sky130_fd_sc_hd__o32ai_1
X_11627_ network.neuron_hid0.ROM0.address\[0\] net331 _07889_
+ VSS VSS VDD VDD _07913_ sky130_fd_sc_hd__a21oi_1
X_11628_ network.neuron_hid0.ROM0.address\[3\] _07912_ _07913_
+ net401 VSS VSS VDD VDD _07914_ sky130_fd_sc_hd__o22ai_1
X_11629_ _07484_ _07914_ VSS VSS VDD VDD _07915_ sky130_fd_sc_hd__nand2_1
X_11630_ _07893_ _07909_ _07915_ VSS VSS VDD VDD _01510_ sky130_fd_sc_hd__o21ai_0
X_11631_ _07599_ _07905_ VSS VSS VDD VDD _07916_ sky130_fd_sc_hd__nand2_1
Xclkbuf_leaf_46_clk_net clknet_4_10_0_clk_net VSS VSS VDD
+ VDD clknet_leaf_46_clk_net sky130_fd_sc_hd__clkbuf_16
X_11633_ net401 _07905_ net341 VSS VSS VDD VDD _07918_ sky130_fd_sc_hd__a21oi_1
X_11634_ net343 _07916_ _07918_ _07860_ VSS VSS VDD VDD _07919_
+ sky130_fd_sc_hd__a211oi_1
X_11635_ _07495_ net317 VSS VSS VDD VDD _07920_ sky130_fd_sc_hd__nand2_1
X_11636_ net405 network.neuron_hid0.ROM0.address\[1\] VSS
+ VSS VDD VDD _07921_ sky130_fd_sc_hd__or2_2
Xclkbuf_leaf_45_clk_net clknet_4_10_0_clk_net VSS VSS VDD
+ VDD clknet_leaf_45_clk_net sky130_fd_sc_hd__clkbuf_16
X_11638_ net399 _07921_ net410 VSS VSS VDD VDD _07923_ sky130_fd_sc_hd__o21ai_0
X_11639_ net399 _07920_ _07923_ VSS VSS VDD VDD _07924_ sky130_fd_sc_hd__a21oi_1
Xclkbuf_leaf_44_clk_net clknet_4_10_0_clk_net VSS VSS VDD
+ VDD clknet_leaf_44_clk_net sky130_fd_sc_hd__clkbuf_16
X_11641_ _07276_ _07299_ _07924_ net403 _07496_ VSS VSS VDD
+ VDD _07926_ sky130_fd_sc_hd__o221ai_1
X_11642_ _07376_ net330 VSS VSS VDD VDD _07927_ sky130_fd_sc_hd__nand2_1
X_11643_ net397 _07927_ net320 VSS VSS VDD VDD _07928_ sky130_fd_sc_hd__o21ai_0
X_11644_ net409 _07928_ VSS VSS VDD VDD _07929_ sky130_fd_sc_hd__nor2_1
X_11645_ net409 net330 _07897_ _07929_ VSS VSS VDD VDD _07930_
+ sky130_fd_sc_hd__a31oi_1
X_11646_ net399 net344 net317 _07930_ _07474_ VSS VSS VDD
+ VDD _07931_ sky130_fd_sc_hd__a311oi_1
X_11647_ net400 net406 VSS VSS VDD VDD _07932_ sky130_fd_sc_hd__nand2b_1
X_11648_ net411 net394 VSS VSS VDD VDD _07933_ sky130_fd_sc_hd__nor2b_1
X_11649_ net406 _07458_ _07378_ VSS VSS VDD VDD _07934_ sky130_fd_sc_hd__a21oi_1
X_11650_ net401 net316 _07932_ _07933_ _07934_ VSS VSS VDD
+ VDD _07935_ sky130_fd_sc_hd__a221o_1
X_11651_ net394 _07274_ VSS VSS VDD VDD _07936_ sky130_fd_sc_hd__nand2_1
X_11652_ net400 net336 VSS VSS VDD VDD _07937_ sky130_fd_sc_hd__nand2_1
X_11653_ _07875_ _07936_ _07937_ VSS VSS VDD VDD _07938_ sky130_fd_sc_hd__a21oi_1
X_11654_ net408 _07368_ VSS VSS VDD VDD _07939_ sky130_fd_sc_hd__nor2_1
X_11655_ net339 net406 net338 VSS VSS VDD VDD _07940_ sky130_fd_sc_hd__a21oi_1
X_11656_ net394 _07939_ _07940_ VSS VSS VDD VDD _07941_ sky130_fd_sc_hd__a21oi_1
X_11657_ net342 _07941_ VSS VSS VDD VDD _07942_ sky130_fd_sc_hd__nand2_1
X_11658_ network.neuron_hid0.ROM0.address\[3\] net408 net406
+ VSS VSS VDD VDD _07943_ sky130_fd_sc_hd__nand3b_1
X_11659_ _07921_ _07943_ network.neuron_hid0.ROM0.address\[0\]
+ VSS VSS VDD VDD _07944_ sky130_fd_sc_hd__a21oi_1
X_11660_ net406 net326 VSS VSS VDD VDD _07945_ sky130_fd_sc_hd__nand2_1
X_11661_ _07495_ _07945_ _07378_ VSS VSS VDD VDD _07946_ sky130_fd_sc_hd__a21oi_1
X_11662_ _07942_ _07944_ _07946_ VSS VSS VDD VDD _07947_ sky130_fd_sc_hd__nor3_1
X_11663_ net402 _07935_ _07938_ _07947_ net393 VSS VSS VDD
+ VDD _07948_ sky130_fd_sc_hd__a2111oi_2
X_11664_ net392 net395 _07926_ _07931_ _07948_ VSS VSS VDD
+ VDD _07949_ sky130_fd_sc_hd__a311oi_1
X_11665_ net294 _07919_ _07949_ _07283_ VSS VSS VDD VDD _01511_
+ sky130_fd_sc_hd__o22ai_1
X_11666_ net398 _07299_ _07870_ VSS VSS VDD VDD _07950_ sky130_fd_sc_hd__o21ai_0
X_11667_ _07439_ _07921_ net398 VSS VSS VDD VDD _07951_ sky130_fd_sc_hd__a21oi_1
X_11668_ net410 _07950_ _07951_ VSS VSS VDD VDD _07952_ sky130_fd_sc_hd__a21oi_1
X_11669_ _07483_ _07952_ VSS VSS VDD VDD _07953_ sky130_fd_sc_hd__nor2_1
X_11670_ net325 net346 VSS VSS VDD VDD _07954_ sky130_fd_sc_hd__nor2_1
X_11671_ net338 _07378_ _07954_ net339 VSS VSS VDD VDD _07955_
+ sky130_fd_sc_hd__o22ai_1
X_11672_ net339 net340 net326 VSS VSS VDD VDD _07956_ sky130_fd_sc_hd__a21oi_1
X_11673_ _07870_ _07341_ _07956_ net410 VSS VSS VDD VDD _07957_
+ sky130_fd_sc_hd__o22ai_1
X_11674_ net398 _07955_ _07957_ VSS VSS VDD VDD _07958_ sky130_fd_sc_hd__a21oi_1
X_11675_ net398 network.neuron_hid0.ROM0.address\[1\] VSS
+ VSS VDD VDD _07959_ sky130_fd_sc_hd__nor2b_1
X_11676_ net337 _07959_ VSS VSS VDD VDD _07960_ sky130_fd_sc_hd__nor2_1
X_11677_ net339 net336 VSS VSS VDD VDD _07961_ sky130_fd_sc_hd__nand2_1
X_11678_ net334 _07888_ _07960_ _07961_ VSS VSS VDD VDD _07962_
+ sky130_fd_sc_hd__o22ai_1
X_11679_ net411 net337 net395 VSS VSS VDD VDD _07963_ sky130_fd_sc_hd__o21ai_0
X_11680_ _07453_ _07963_ net399 VSS VSS VDD VDD _07964_ sky130_fd_sc_hd__a21oi_1
X_11681_ net406 _07962_ _07964_ VSS VSS VDD VDD _07965_ sky130_fd_sc_hd__nor3_1
X_11682_ net406 _07958_ _07965_ VSS VSS VDD VDD _07966_ sky130_fd_sc_hd__a21oi_1
X_11683_ net302 net300 _07966_ VSS VSS VDD VDD _07967_ sky130_fd_sc_hd__a21oi_1
X_11684_ net394 net411 VSS VSS VDD VDD _07968_ sky130_fd_sc_hd__nand2_1
X_11685_ net398 _07865_ _07968_ VSS VSS VDD VDD _07969_ sky130_fd_sc_hd__nor3_1
X_11686_ _07621_ _07378_ VSS VSS VDD VDD _07970_ sky130_fd_sc_hd__nand2_1
X_11687_ net408 _07933_ net401 VSS VSS VDD VDD _07971_ sky130_fd_sc_hd__o21ai_0
X_11688_ _07468_ _07971_ net402 VSS VSS VDD VDD _07972_ sky130_fd_sc_hd__a21oi_1
X_11689_ _07615_ _07970_ _07972_ VSS VSS VDD VDD _07973_ sky130_fd_sc_hd__a21oi_1
X_11690_ net398 net403 VSS VSS VDD VDD _07974_ sky130_fd_sc_hd__nand2_1
X_11691_ net398 _07870_ _07974_ net396 VSS VSS VDD VDD _07975_
+ sky130_fd_sc_hd__o22ai_1
X_11692_ net394 _07309_ VSS VSS VDD VDD _07976_ sky130_fd_sc_hd__and2_1
X_11693_ net339 _07616_ _07976_ net411 VSS VSS VDD VDD _07977_
+ sky130_fd_sc_hd__a211oi_1
X_11694_ net411 _07975_ _07977_ net404 VSS VSS VDD VDD _07978_
+ sky130_fd_sc_hd__a211oi_1
X_11695_ net404 _07973_ _07978_ VSS VSS VDD VDD _07979_ sky130_fd_sc_hd__a21oi_1
X_11696_ net392 _07969_ _07979_ VSS VSS VDD VDD _07980_ sky130_fd_sc_hd__nor3_1
X_11697_ net392 _07967_ _07980_ net391 VSS VSS VDD VDD _07981_
+ sky130_fd_sc_hd__a211oi_1
X_11698_ _07953_ _07981_ _07282_ VSS VSS VDD VDD _01512_ sky130_fd_sc_hd__o21ba_2
X_11699_ net398 net405 VSS VSS VDD VDD _07982_ sky130_fd_sc_hd__nor2b_1
Xclkbuf_leaf_43_clk_net clknet_4_10_0_clk_net VSS VSS VDD
+ VDD clknet_leaf_43_clk_net sky130_fd_sc_hd__clkbuf_16
X_11701_ net402 _07921_ VSS VSS VDD VDD _07984_ sky130_fd_sc_hd__nand2_1
X_11702_ _07870_ _07581_ _07984_ net400 VSS VSS VDD VDD _07985_
+ sky130_fd_sc_hd__o22ai_1
X_11703_ net404 net402 VSS VSS VDD VDD _07986_ sky130_fd_sc_hd__nor2b_1
X_11704_ net408 _07986_ net400 VSS VSS VDD VDD _07987_ sky130_fd_sc_hd__o21ai_0
X_11705_ _07866_ _07987_ net336 VSS VSS VDD VDD _07988_ sky130_fd_sc_hd__a21oi_1
X_11706_ net336 _07985_ _07988_ VSS VSS VDD VDD _07989_ sky130_fd_sc_hd__a21oi_1
X_11707_ _07276_ _07870_ _07989_ VSS VSS VDD VDD _07990_ sky130_fd_sc_hd__o21ai_0
X_11708_ net400 _07368_ VSS VSS VDD VDD _07991_ sky130_fd_sc_hd__nand2_1
X_11709_ net399 net403 _07544_ _07991_ VSS VSS VDD VDD _07992_
+ sky130_fd_sc_hd__o31ai_1
X_11710_ net409 _07992_ VSS VSS VDD VDD _07993_ sky130_fd_sc_hd__nand2_1
X_11711_ net346 _07872_ net397 VSS VSS VDD VDD _07994_ sky130_fd_sc_hd__o21ai_0
Xclkbuf_leaf_42_clk_net clknet_4_10_0_clk_net VSS VSS VDD
+ VDD clknet_leaf_42_clk_net sky130_fd_sc_hd__clkbuf_16
X_11713_ net403 _07544_ _07572_ VSS VSS VDD VDD _07996_ sky130_fd_sc_hd__o21ai_0
X_11714_ _07993_ _07994_ _07996_ net396 VSS VSS VDD VDD _07997_
+ sky130_fd_sc_hd__a31oi_1
X_11715_ net325 net312 _07990_ net396 _07997_ VSS VSS VDD
+ VDD _07998_ sky130_fd_sc_hd__a221oi_1
X_11716_ net398 net410 VSS VSS VDD VDD _07999_ sky130_fd_sc_hd__nand2_1
X_11717_ net407 net408 VSS VSS VDD VDD _08000_ sky130_fd_sc_hd__and2_1
Xclkbuf_leaf_41_clk_net clknet_4_10_0_clk_net VSS VSS VDD
+ VDD clknet_leaf_41_clk_net sky130_fd_sc_hd__clkbuf_16
X_11719_ net403 _08000_ VSS VSS VDD VDD _08002_ sky130_fd_sc_hd__nor2_1
X_11720_ net303 _08002_ VSS VSS VDD VDD _08003_ sky130_fd_sc_hd__nor2_1
X_11721_ _07476_ net313 net399 VSS VSS VDD VDD _08004_ sky130_fd_sc_hd__o21ai_0
X_11722_ net409 _07954_ _08004_ VSS VSS VDD VDD _08005_ sky130_fd_sc_hd__o21ai_0
X_11723_ net398 net346 net328 VSS VSS VDD VDD _08006_ sky130_fd_sc_hd__nor3_1
X_11724_ net398 net335 _08006_ net405 VSS VSS VDD VDD _08007_
+ sky130_fd_sc_hd__a211oi_1
X_11725_ net397 net344 _07943_ VSS VSS VDD VDD _08008_ sky130_fd_sc_hd__nand3_1
X_11726_ net397 net321 net303 _08008_ VSS VSS VDD VDD _08009_
+ sky130_fd_sc_hd__o31ai_1
X_11727_ net405 net335 VSS VSS VDD VDD _08010_ sky130_fd_sc_hd__nor2_1
X_11728_ _07598_ _08010_ _07271_ VSS VSS VDD VDD _08011_ sky130_fd_sc_hd__o21ai_0
X_11729_ net410 _08009_ _08011_ net396 VSS VSS VDD VDD _08012_
+ sky130_fd_sc_hd__o211ai_1
X_11730_ net396 _08005_ _08007_ _08012_ VSS VSS VDD VDD _08013_
+ sky130_fd_sc_hd__o31ai_1
X_11731_ _07999_ _08003_ _08013_ VSS VSS VDD VDD _08014_ sky130_fd_sc_hd__o21ai_0
X_11732_ _07998_ _08014_ net392 VSS VSS VDD VDD _08015_ sky130_fd_sc_hd__mux2i_1
X_11733_ net398 _07599_ VSS VSS VDD VDD _08016_ sky130_fd_sc_hd__nor2_1
X_11734_ net409 net330 net342 VSS VSS VDD VDD _08017_ sky130_fd_sc_hd__a21oi_1
X_11735_ _08016_ _08017_ net329 VSS VSS VDD VDD _08018_ sky130_fd_sc_hd__o21ai_0
X_11736_ net341 net325 _07866_ _08018_ VSS VSS VDD VDD _08019_
+ sky130_fd_sc_hd__o31ai_1
X_11737_ _07537_ _08015_ _08019_ net293 VSS VSS VDD VDD _01513_
+ sky130_fd_sc_hd__a22o_1
X_11738_ net399 _07426_ VSS VSS VDD VDD _08020_ sky130_fd_sc_hd__nand2_1
X_11739_ net411 _07866_ net340 VSS VSS VDD VDD _08021_ sky130_fd_sc_hd__a21oi_1
X_11740_ net403 net332 VSS VSS VDD VDD _08022_ sky130_fd_sc_hd__nor2_1
X_11741_ _07373_ _08022_ net399 VSS VSS VDD VDD _08023_ sky130_fd_sc_hd__o21ai_0
X_11742_ net405 _08021_ _08023_ VSS VSS VDD VDD _08024_ sky130_fd_sc_hd__o21ai_0
X_11743_ net395 _07562_ _07385_ VSS VSS VDD VDD _08025_ sky130_fd_sc_hd__a21oi_1
X_11744_ net404 net345 _07471_ VSS VSS VDD VDD _08026_ sky130_fd_sc_hd__o21ai_0
X_11745_ net339 _08026_ net303 VSS VSS VDD VDD _08027_ sky130_fd_sc_hd__a21oi_1
X_11746_ net341 _08025_ _08027_ VSS VSS VDD VDD _08028_ sky130_fd_sc_hd__o21ai_0
X_11747_ net399 _07476_ VSS VSS VDD VDD _08029_ sky130_fd_sc_hd__nand2_1
Xclkbuf_leaf_40_clk_net clknet_4_10_0_clk_net VSS VSS VDD
+ VDD clknet_leaf_40_clk_net sky130_fd_sc_hd__clkbuf_16
X_11749_ _07496_ _08029_ net395 VSS VSS VDD VDD _08031_ sky130_fd_sc_hd__a21oi_1
X_11750_ net395 _08024_ _08028_ net342 _08031_ VSS VSS VDD
+ VDD _08032_ sky130_fd_sc_hd__a221oi_1
X_11751_ _07555_ _07584_ net399 VSS VSS VDD VDD _08033_ sky130_fd_sc_hd__a21oi_1
X_11752_ net299 _08000_ net399 VSS VSS VDD VDD _08034_ sky130_fd_sc_hd__o21ai_0
X_11753_ net404 _07870_ _07453_ _08034_ VSS VSS VDD VDD _08035_
+ sky130_fd_sc_hd__o211ai_1
X_11754_ _08033_ _08035_ net395 VSS VSS VDD VDD _08036_ sky130_fd_sc_hd__o21ai_0
X_11755_ net404 net335 net317 VSS VSS VDD VDD _08037_ sky130_fd_sc_hd__o21ai_0
X_11756_ _07472_ _07559_ net399 VSS VSS VDD VDD _08038_ sky130_fd_sc_hd__a21oi_1
X_11757_ net336 _08037_ _08038_ VSS VSS VDD VDD _08039_ sky130_fd_sc_hd__a21oi_1
X_11758_ net395 _08039_ net299 net337 VSS VSS VDD VDD _08040_
+ sky130_fd_sc_hd__a2bb2oi_1
X_11759_ _07585_ _07572_ _08036_ _08040_ net392 VSS VSS VDD
+ VDD _08041_ sky130_fd_sc_hd__a221oi_1
X_11760_ net392 _08020_ _08032_ _08041_ VSS VSS VDD VDD _08042_
+ sky130_fd_sc_hd__a31oi_1
X_11761_ net403 _07607_ net409 VSS VSS VDD VDD _08043_ sky130_fd_sc_hd__a21oi_1
X_11762_ net410 net331 _08043_ VSS VSS VDD VDD _08044_ sky130_fd_sc_hd__a21oi_1
X_11763_ _07872_ _07959_ net405 VSS VSS VDD VDD _08045_ sky130_fd_sc_hd__o21ai_0
X_11764_ net397 _08044_ _08045_ VSS VSS VDD VDD _08046_ sky130_fd_sc_hd__o21ai_0
X_11765_ _07537_ _08042_ _08046_ net293 VSS VSS VDD VDD _01514_
+ sky130_fd_sc_hd__a22o_1
X_11766_ net343 net336 VSS VSS VDD VDD _08047_ sky130_fd_sc_hd__nand2_1
X_11767_ net405 net337 VSS VSS VDD VDD _08048_ sky130_fd_sc_hd__nor2_1
X_11768_ net341 _07476_ net313 VSS VSS VDD VDD _08049_ sky130_fd_sc_hd__a21oi_1
X_11769_ _08047_ _08048_ _08049_ net403 VSS VSS VDD VDD _08050_
+ sky130_fd_sc_hd__o22ai_1
X_11770_ _07243_ _08050_ VSS VSS VDD VDD _08051_ sky130_fd_sc_hd__nand2_1
X_11771_ net397 net405 VSS VSS VDD VDD _08052_ sky130_fd_sc_hd__nor2_2
X_11772_ net395 _07621_ _07453_ VSS VSS VDD VDD _08053_ sky130_fd_sc_hd__o21ai_0
X_11773_ net397 _07920_ _07375_ VSS VSS VDD VDD _08054_ sky130_fd_sc_hd__o21ai_0
X_11774_ net399 _07856_ net330 VSS VSS VDD VDD _08055_ sky130_fd_sc_hd__nand3_1
X_11775_ net341 _07389_ VSS VSS VDD VDD _08056_ sky130_fd_sc_hd__nand2_1
X_11776_ _08055_ _08056_ net403 VSS VSS VDD VDD _08057_ sky130_fd_sc_hd__a21oi_1
X_11777_ net326 net322 _08054_ net410 _08057_ VSS VSS VDD
+ VDD _08058_ sky130_fd_sc_hd__a221oi_1
X_11778_ net395 _08058_ VSS VSS VDD VDD _08059_ sky130_fd_sc_hd__nand2_1
X_11779_ _07430_ _07468_ VSS VSS VDD VDD _08060_ sky130_fd_sc_hd__nand2_1
X_11780_ net397 _07389_ _08060_ net405 VSS VSS VDD VDD _08061_
+ sky130_fd_sc_hd__a22oi_1
X_11781_ net323 _07458_ _08061_ net403 net339 VSS VSS VDD
+ VDD _08062_ sky130_fd_sc_hd__o221ai_1
X_11782_ _08052_ _08053_ _08059_ _08062_ VSS VSS VDD VDD _08063_
+ sky130_fd_sc_hd__a22o_1
X_11783_ _07498_ _07544_ net339 VSS VSS VDD VDD _08064_ sky130_fd_sc_hd__o21ai_0
X_11784_ _07897_ _08064_ VSS VSS VDD VDD _08065_ sky130_fd_sc_hd__nand2_1
X_11785_ _07393_ _07567_ VSS VSS VDD VDD _08066_ sky130_fd_sc_hd__nor2_1
X_11786_ net345 _07549_ _07373_ VSS VSS VDD VDD _08067_ sky130_fd_sc_hd__a21oi_1
X_11787_ net339 net411 net337 _07842_ VSS VSS VDD VDD _08068_
+ sky130_fd_sc_hd__a31oi_1
X_11788_ net341 _08067_ _08068_ net400 VSS VSS VDD VDD _08069_
+ sky130_fd_sc_hd__o22ai_1
X_11789_ net392 _08066_ _08069_ VSS VSS VDD VDD _08070_ sky130_fd_sc_hd__or3_1
X_11790_ net409 _08065_ _08070_ VSS VSS VDD VDD _08071_ sky130_fd_sc_hd__a21oi_1
X_11791_ net342 _07376_ VSS VSS VDD VDD _08072_ sky130_fd_sc_hd__nand2_1
X_11792_ net342 net299 _08072_ VSS VSS VDD VDD _08073_ sky130_fd_sc_hd__o21ai_0
X_11793_ net320 _07444_ net342 VSS VSS VDD VDD _08074_ sky130_fd_sc_hd__a21oi_1
X_11794_ net409 _07544_ _08074_ VSS VSS VDD VDD _08075_ sky130_fd_sc_hd__nor3_1
X_11795_ net409 _08073_ _08075_ VSS VSS VDD VDD _08076_ sky130_fd_sc_hd__a21oi_1
X_11796_ _07269_ _08076_ net395 VSS VSS VDD VDD _08077_ sky130_fd_sc_hd__o21ai_0
X_11797_ net392 _08063_ _08071_ _08077_ net391 VSS VSS VDD
+ VDD _08078_ sky130_fd_sc_hd__a221o_1
Xclkbuf_leaf_39_clk_net clknet_4_10_0_clk_net VSS VSS VDD
+ VDD clknet_leaf_39_clk_net sky130_fd_sc_hd__clkbuf_16
X_11799_ _08051_ _08078_ _07282_ VSS VSS VDD VDD _01515_ sky130_fd_sc_hd__a21oi_1
X_11800_ net397 _07468_ _07430_ VSS VSS VDD VDD _08080_ sky130_fd_sc_hd__o21ai_0
X_11801_ net317 _08056_ VSS VSS VDD VDD _08081_ sky130_fd_sc_hd__nand2_1
X_11802_ net405 _08080_ _08081_ net397 VSS VSS VDD VDD _08082_
+ sky130_fd_sc_hd__a22oi_1
X_11803_ net331 net333 net319 net335 VSS VSS VDD VDD _08083_
+ sky130_fd_sc_hd__a22oi_1
X_11804_ net403 _08082_ _08083_ net397 VSS VSS VDD VDD _08084_
+ sky130_fd_sc_hd__o22ai_1
X_11805_ net293 _08084_ VSS VSS VDD VDD _08085_ sky130_fd_sc_hd__nand2_1
X_11806_ net394 net407 VSS VSS VDD VDD _08086_ sky130_fd_sc_hd__nor2_1
X_11807_ net346 net311 VSS VSS VDD VDD _08087_ sky130_fd_sc_hd__nor2_1
X_11808_ net395 net325 VSS VSS VDD VDD _08088_ sky130_fd_sc_hd__nor2_1
X_11809_ net346 _08088_ net404 VSS VSS VDD VDD _08089_ sky130_fd_sc_hd__o21ai_0
X_11810_ net409 _08087_ _08089_ VSS VSS VDD VDD _08090_ sky130_fd_sc_hd__o21ai_0
X_11811_ net397 net331 VSS VSS VDD VDD _08091_ sky130_fd_sc_hd__nand2_1
X_11812_ net343 _07865_ _08091_ VSS VSS VDD VDD _08092_ sky130_fd_sc_hd__a21boi_0
X_11813_ _07495_ _07498_ VSS VSS VDD VDD _08093_ sky130_fd_sc_hd__nand2_1
X_11814_ net405 _08092_ _08093_ VSS VSS VDD VDD _08094_ sky130_fd_sc_hd__o21ai_0
X_11815_ net331 net323 net343 VSS VSS VDD VDD _08095_ sky130_fd_sc_hd__o21ai_0
X_11816_ _07458_ _08095_ net341 VSS VSS VDD VDD _08096_ sky130_fd_sc_hd__a21oi_1
X_11817_ net410 _08094_ _08096_ VSS VSS VDD VDD _08097_ sky130_fd_sc_hd__a21o_1
X_11818_ net344 _07376_ VSS VSS VDD VDD _08098_ sky130_fd_sc_hd__nand2_1
X_11819_ net407 _07571_ VSS VSS VDD VDD _08099_ sky130_fd_sc_hd__nor2_1
X_11820_ _07959_ _08098_ _08099_ VSS VSS VDD VDD _08100_ sky130_fd_sc_hd__a21oi_1
X_11821_ _07299_ _08047_ _08100_ net396 VSS VSS VDD VDD _08101_
+ sky130_fd_sc_hd__o22ai_1
X_11822_ net398 _08090_ _08097_ net396 _08101_ VSS VSS VDD
+ VDD _08102_ sky130_fd_sc_hd__a221oi_1
X_11823_ net408 net333 _07385_ VSS VSS VDD VDD _08103_ sky130_fd_sc_hd__o21ai_0
X_11824_ net340 net333 VSS VSS VDD VDD _08104_ sky130_fd_sc_hd__nand2_1
X_11825_ net407 _07453_ _07376_ net394 VSS VSS VDD VDD _08105_
+ sky130_fd_sc_hd__o22ai_1
X_11826_ net394 _07882_ _08105_ net401 VSS VSS VDD VDD _08106_
+ sky130_fd_sc_hd__a211oi_1
X_11827_ net401 _08103_ _08104_ _08106_ VSS VSS VDD VDD _08107_
+ sky130_fd_sc_hd__a31oi_1
X_11828_ net395 net404 VSS VSS VDD VDD _08108_ sky130_fd_sc_hd__nand2_1
X_11829_ network.neuron_hid0.ROM0.address\[0\] net338 VSS
+ VSS VDD VDD _08109_ sky130_fd_sc_hd__nor2_4
X_11830_ _07878_ _08109_ net341 VSS VSS VDD VDD _08110_ sky130_fd_sc_hd__o21ai_0
X_11831_ _07368_ net324 net318 VSS VSS VDD VDD _08111_ sky130_fd_sc_hd__nand3_1
X_11832_ _07471_ _08108_ _08110_ _08111_ net392 VSS VSS VDD
+ VDD _08112_ sky130_fd_sc_hd__o2111ai_1
X_11833_ net392 _08102_ _08107_ _08112_ _07537_ VSS VSS VDD
+ VDD _08113_ sky130_fd_sc_hd__o221ai_1
X_11834_ _08085_ _08113_ VSS VSS VDD VDD _01516_ sky130_fd_sc_hd__nand2_1
X_11835_ network.neuron_in245.counter\[3\] _00697_ VSS VSS
+ VDD VDD _08114_ sky130_fd_sc_hd__nand2b_1
X_11836_ _08114_ _07692_ VSS VSS VDD VDD _08115_ sky130_fd_sc_hd__nand2b_1
X_11837_ net379 _08115_ VSS VSS VDD VDD _08116_ sky130_fd_sc_hd__nand2_1
X_11838_ net611 _08116_ VSS VSS VDD VDD _08117_ sky130_fd_sc_hd__nand2_1
X_11839_ _00698_ _08116_ _08117_ VSS VSS VDD VDD _03044_ sky130_fd_sc_hd__o21ai_0
X_11840_ network.neuron_in245.counter\[0\] VSS VSS VDD VDD
+ _00695_ sky130_fd_sc_hd__inv_1
X_11841_ net616 _08116_ VSS VSS VDD VDD _08118_ sky130_fd_sc_hd__nand2_1
X_11842_ network.neuron_in245.counter\[0\] _08116_ _08118_
+ VSS VSS VDD VDD _03043_ sky130_fd_sc_hd__o21ai_0
X_11843_ network.neuron_in155.counter\[0\] VSS VSS VDD VDD
+ _01097_ sky130_fd_sc_hd__inv_1
X_11844_ network.neuron_in004.counter\[1\] VSS VSS VDD VDD
+ _00621_ sky130_fd_sc_hd__inv_1
X_11845_ network.in_period\[156\]\[0\] _07519_ VSS VSS VDD
+ VDD _08119_ sky130_fd_sc_hd__nand2_1
X_11846_ network.neuron_in156.counter\[0\] _07519_ _08119_
+ VSS VSS VDD VDD _02687_ sky130_fd_sc_hd__o21ai_0
X_11847_ network.neuron_in104.counter\[1\] VSS VSS VDD VDD
+ _00530_ sky130_fd_sc_hd__inv_1
X_11848_ _07661_ _00738_ VSS VSS VDD VDD _08120_ sky130_fd_sc_hd__nand2_1
X_11849_ network.neuron_in135.counter\[3\] _08120_ VSS VSS
+ VDD VDD _08121_ sky130_fd_sc_hd__or2_2
X_11850_ net384 _08121_ VSS VSS VDD VDD _08122_ sky130_fd_sc_hd__nand2_1
X_11851_ network.in_period\[135\]\[1\] _08122_ VSS VSS VDD
+ VDD _08123_ sky130_fd_sc_hd__nand2_1
X_11852_ _00739_ _08122_ _08123_ VSS VSS VDD VDD _02604_ sky130_fd_sc_hd__o21ai_0
X_11853_ network.neuron_in135.counter\[0\] VSS VSS VDD VDD
+ _00736_ sky130_fd_sc_hd__inv_1
X_11854_ network.in_period\[135\]\[0\] _08122_ VSS VSS VDD
+ VDD _08124_ sky130_fd_sc_hd__nand2_1
X_11855_ network.neuron_in135.counter\[0\] _08122_ _08124_
+ VSS VSS VDD VDD _02603_ sky130_fd_sc_hd__o21ai_0
X_11856_ network.neuron_in250.counter\[2\] VSS VSS VDD VDD
+ _08125_ sky130_fd_sc_hd__inv_1
X_11857_ network.neuron_in250.counter\[3\] network.in_period\[250\]\[2\]
+ _00905_ net361 VSS VSS VDD VDD _08126_ sky130_fd_sc_hd__o22ai_1
X_11858_ network.neuron_in250.counter\[2\] _00905_ net380
+ VSS VSS VDD VDD _08127_ sky130_fd_sc_hd__nand3_1
X_11859_ network.in_period\[250\]\[2\] net380 _08127_ VSS
+ VSS VDD VDD _08128_ sky130_fd_sc_hd__o21ai_0
X_11860_ _08125_ _08126_ _08128_ VSS VSS VDD VDD _03065_ sky130_fd_sc_hd__a21oi_1
X_11861_ network.neuron_in246.counter\[0\] VSS VSS VDD VDD
+ _00874_ sky130_fd_sc_hd__inv_1
X_11862_ network.neuron_in246.counter\[2\] network.neuron_in246.counter\[3\]
+ VSS VSS VDD VDD _08129_ sky130_fd_sc_hd__nor2_1
X_11863_ _00876_ _08129_ VSS VSS VDD VDD _08130_ sky130_fd_sc_hd__nand2_1
X_11864_ net380 _08130_ VSS VSS VDD VDD _08131_ sky130_fd_sc_hd__nand2_1
X_11865_ net588 _08131_ VSS VSS VDD VDD _08132_ sky130_fd_sc_hd__nand2_1
X_11866_ network.neuron_in246.counter\[0\] _08131_ _08132_
+ VSS VSS VDD VDD _03047_ sky130_fd_sc_hd__o21ai_0
X_11867_ network.neuron_in247.counter\[0\] VSS VSS VDD VDD
+ _00891_ sky130_fd_sc_hd__inv_1
X_11868_ network.neuron_in247.counter\[3\] _00893_ VSS VSS
+ VDD VDD _08133_ sky130_fd_sc_hd__nand2b_1
X_11869_ network.neuron_in247.counter\[2\] _08133_ VSS VSS
+ VDD VDD _08134_ sky130_fd_sc_hd__or2_2
X_11870_ net380 _08134_ VSS VSS VDD VDD _08135_ sky130_fd_sc_hd__nand2_1
X_11871_ network.in_period\[247\]\[0\] _08135_ VSS VSS VDD
+ VDD _08136_ sky130_fd_sc_hd__nand2_1
X_11872_ network.neuron_in247.counter\[0\] _08135_ _08136_
+ VSS VSS VDD VDD _03051_ sky130_fd_sc_hd__o21ai_0
X_11873_ network.neuron_in248.counter\[2\] _00561_ VSS VSS
+ VDD VDD _08137_ sky130_fd_sc_hd__nand2b_1
X_11874_ network.neuron_in248.counter\[3\] _08137_ VSS VSS
+ VDD VDD _08138_ sky130_fd_sc_hd__or2_2
X_11875_ net388 _08138_ VSS VSS VDD VDD _08139_ sky130_fd_sc_hd__nand2_1
X_11876_ net536 _08139_ VSS VSS VDD VDD _08140_ sky130_fd_sc_hd__nand2_1
X_11877_ network.neuron_in248.counter\[0\] _08139_ _08140_
+ VSS VSS VDD VDD _03055_ sky130_fd_sc_hd__o21ai_0
X_11878_ network.neuron_in189.counter\[1\] VSS VSS VDD VDD
+ _00975_ sky130_fd_sc_hd__inv_1
X_11879_ network.neuron_in249.counter\[2\] network.neuron_in249.counter\[3\]
+ VSS VSS VDD VDD _08141_ sky130_fd_sc_hd__nor2_1
X_11880_ _01008_ _08141_ VSS VSS VDD VDD _08142_ sky130_fd_sc_hd__nand2_1
X_11881_ net388 _08142_ VSS VSS VDD VDD _08143_ sky130_fd_sc_hd__nand2_1
X_11882_ network.in_period\[249\]\[0\] _08143_ VSS VSS VDD
+ VDD _08144_ sky130_fd_sc_hd__nand2_1
X_11883_ network.neuron_in249.counter\[0\] _08143_ _08144_
+ VSS VSS VDD VDD _03059_ sky130_fd_sc_hd__o21ai_0
X_11884_ network.neuron_in251.counter\[2\] net380 VSS VSS
+ VDD VDD _08145_ sky130_fd_sc_hd__nand2_1
X_11885_ network.neuron_in251.counter\[3\] network.in_period\[251\]\[2\]
+ _08145_ VSS VSS VDD VDD _08146_ sky130_fd_sc_hd__o21ai_0
X_11886_ _01111_ network.neuron_in251.counter\[2\] net361
+ VSS VSS VDD VDD _08147_ sky130_fd_sc_hd__or3_1
X_11887_ network.in_period\[251\]\[2\] net380 _08147_ VSS
+ VSS VDD VDD _08148_ sky130_fd_sc_hd__o21ai_0
X_11888_ _01111_ _08146_ _08148_ VSS VSS VDD VDD _03069_ sky130_fd_sc_hd__a21oi_1
X_11889_ network.neuron_in003.counter\[1\] VSS VSS VDD VDD
+ _00626_ sky130_fd_sc_hd__inv_1
X_11890_ network.neuron_in021.counter\[0\] VSS VSS VDD VDD
+ _00409_ sky130_fd_sc_hd__inv_1
X_11891_ network.neuron_in003.counter\[0\] VSS VSS VDD VDD
+ _00625_ sky130_fd_sc_hd__inv_1
X_11892_ network.neuron_in151.counter\[2\] net387 VSS VSS
+ VDD VDD _08149_ sky130_fd_sc_hd__nand2_1
X_11893_ network.in_period\[151\]\[2\] network.neuron_in151.counter\[3\]
+ _08149_ VSS VSS VDD VDD _08150_ sky130_fd_sc_hd__o21ai_0
X_11894_ _00506_ network.neuron_in151.counter\[2\] net348
+ VSS VSS VDD VDD _08151_ sky130_fd_sc_hd__or3_1
X_11895_ network.in_period\[151\]\[2\] net387 _08151_ VSS
+ VSS VDD VDD _08152_ sky130_fd_sc_hd__o21ai_0
X_11896_ _00506_ _08150_ _08152_ VSS VSS VDD VDD _02669_ sky130_fd_sc_hd__a21oi_1
X_11897_ network.in_period\[136\]\[2\] network.neuron_in136.counter\[3\]
+ _01115_ net358 VSS VSS VDD VDD _08153_ sky130_fd_sc_hd__o22ai_1
Xclkbuf_leaf_38_clk_net clknet_4_8_0_clk_net VSS VSS VDD VDD
+ clknet_leaf_38_clk_net sky130_fd_sc_hd__clkbuf_16
X_11899_ network.neuron_in136.counter\[2\] _01115_ net384
+ VSS VSS VDD VDD _08155_ sky130_fd_sc_hd__nand3_1
X_11900_ network.in_period\[136\]\[2\] net384 _08155_ VSS
+ VSS VDD VDD _08156_ sky130_fd_sc_hd__o21ai_0
X_11901_ _06681_ _08153_ _08156_ VSS VSS VDD VDD _02609_ sky130_fd_sc_hd__a21oi_1
X_11902_ network.neuron_in188.counter\[1\] VSS VSS VDD VDD
+ _00230_ sky130_fd_sc_hd__inv_1
X_11903_ network.neuron_in246.counter\[2\] VSS VSS VDD VDD
+ _08157_ sky130_fd_sc_hd__inv_1
X_11904_ network.in_period\[246\]\[2\] network.neuron_in246.counter\[3\]
+ _00876_ net361 VSS VSS VDD VDD _08158_ sky130_fd_sc_hd__o22ai_1
X_11905_ network.neuron_in246.counter\[2\] _00876_ net380
+ VSS VSS VDD VDD _08159_ sky130_fd_sc_hd__nand3_1
X_11906_ network.in_period\[246\]\[2\] net380 _08159_ VSS
+ VSS VDD VDD _08160_ sky130_fd_sc_hd__o21ai_0
X_11907_ _08157_ _08158_ _08160_ VSS VSS VDD VDD _03049_ sky130_fd_sc_hd__a21oi_1
X_11908_ net400 net330 VSS VSS VDD VDD _08161_ sky130_fd_sc_hd__nor2_1
X_11909_ _07276_ _07621_ net395 VSS VSS VDD VDD _08162_ sky130_fd_sc_hd__a21oi_1
X_11910_ _08161_ _08162_ net329 VSS VSS VDD VDD _08163_ sky130_fd_sc_hd__o21ai_0
X_11911_ net338 net299 net324 _07936_ VSS VSS VDD VDD _08164_
+ sky130_fd_sc_hd__o22ai_1
X_11912_ net335 _07856_ net394 VSS VSS VDD VDD _08165_ sky130_fd_sc_hd__a21oi_1
X_11913_ _07968_ _07984_ VSS VSS VDD VDD _08166_ sky130_fd_sc_hd__nor2_1
X_11914_ net402 net317 net411 VSS VSS VDD VDD _08167_ sky130_fd_sc_hd__a21oi_1
X_11915_ net342 _08165_ _08166_ _08167_ VSS VSS VDD VDD _08168_
+ sky130_fd_sc_hd__or4_1
X_11916_ net400 _08164_ _08168_ VSS VSS VDD VDD _08169_ sky130_fd_sc_hd__o21ai_0
X_11917_ net399 _07901_ net330 VSS VSS VDD VDD _08170_ sky130_fd_sc_hd__o21ai_0
X_11918_ net339 _08170_ VSS VSS VDD VDD _08171_ sky130_fd_sc_hd__nand2_1
X_11919_ _07426_ _07888_ _08171_ VSS VSS VDD VDD _08172_ sky130_fd_sc_hd__o21ai_0
X_11920_ net313 _07549_ net300 net340 VSS VSS VDD VDD _08173_
+ sky130_fd_sc_hd__a22oi_1
X_11921_ net397 net314 VSS VSS VDD VDD _08174_ sky130_fd_sc_hd__nor2_1
X_11922_ net395 _07458_ VSS VSS VDD VDD _08175_ sky130_fd_sc_hd__nand2_1
X_11923_ _08052_ net315 net409 VSS VSS VDD VDD _08176_ sky130_fd_sc_hd__o21ai_0
X_11924_ net339 _08176_ VSS VSS VDD VDD _08177_ sky130_fd_sc_hd__nand2_1
X_11925_ _08174_ _08175_ _08177_ net410 VSS VSS VDD VDD _08178_
+ sky130_fd_sc_hd__o211ai_1
X_11926_ net410 _08173_ _08178_ VSS VSS VDD VDD _08179_ sky130_fd_sc_hd__o21ai_0
X_11927_ net403 _08172_ _08179_ net392 VSS VSS VDD VDD _08180_
+ sky130_fd_sc_hd__a211oi_1
X_11928_ net392 _08163_ _08169_ _08180_ VSS VSS VDD VDD _08181_
+ sky130_fd_sc_hd__a31oi_1
X_11929_ net342 _07562_ net293 VSS VSS VDD VDD _08182_ sky130_fd_sc_hd__o21ai_0
X_11930_ net409 _07330_ net410 VSS VSS VDD VDD _08183_ sky130_fd_sc_hd__o21ai_0
X_11931_ net403 _08060_ net405 VSS VSS VDD VDD _08184_ sky130_fd_sc_hd__a21oi_1
X_11932_ net405 net335 _08183_ _08184_ VSS VSS VDD VDD _08185_
+ sky130_fd_sc_hd__a31oi_1
X_11933_ _07283_ _08181_ _08182_ _08185_ VSS VSS VDD VDD _01517_
+ sky130_fd_sc_hd__o22ai_1
X_11934_ net342 _07902_ VSS VSS VDD VDD _08186_ sky130_fd_sc_hd__nor2_1
X_11935_ net404 net324 net327 net399 VSS VSS VDD VDD _08187_
+ sky130_fd_sc_hd__a211oi_1
X_11936_ net326 net299 net327 net404 VSS VSS VDD VDD _08188_
+ sky130_fd_sc_hd__a22oi_1
X_11937_ net402 _08186_ _08187_ _08188_ net399 VSS VSS VDD
+ VDD _08189_ sky130_fd_sc_hd__o32ai_1
X_11938_ net404 net337 _07986_ VSS VSS VDD VDD _08190_ sky130_fd_sc_hd__a21oi_1
X_11939_ _07986_ _07362_ net400 VSS VSS VDD VDD _08191_ sky130_fd_sc_hd__o21ai_0
X_11940_ net402 _08086_ VSS VSS VDD VDD _08192_ sky130_fd_sc_hd__nor2_1
X_11941_ net339 _07376_ _08192_ net400 VSS VSS VDD VDD _08193_
+ sky130_fd_sc_hd__o22ai_1
X_11942_ net408 _08193_ VSS VSS VDD VDD _08194_ sky130_fd_sc_hd__nand2_1
X_11943_ net394 _08190_ _08191_ _08194_ VSS VSS VDD VDD _08195_
+ sky130_fd_sc_hd__o211ai_1
X_11944_ net400 net313 _07269_ VSS VSS VDD VDD _08196_ sky130_fd_sc_hd__a21oi_1
X_11945_ _07866_ _08192_ _08196_ net339 _07991_ VSS VSS VDD
+ VDD _08197_ sky130_fd_sc_hd__o221ai_1
X_11946_ net407 net408 network.neuron_hid0.ROM0.address\[3\]
+ VSS VSS VDD VDD _08198_ sky130_fd_sc_hd__or3b_2
X_11947_ net336 _08197_ _07888_ _08198_ VSS VSS VDD VDD _08199_
+ sky130_fd_sc_hd__o2bb2ai_1
X_11948_ net411 _08195_ _08199_ VSS VSS VDD VDD _08200_ sky130_fd_sc_hd__a21oi_1
X_11949_ net340 _07368_ net399 VSS VSS VDD VDD _08201_ sky130_fd_sc_hd__o21ai_0
X_11950_ _07276_ net334 _08201_ VSS VSS VDD VDD _08202_ sky130_fd_sc_hd__o21ai_0
X_11951_ net342 net314 net316 VSS VSS VDD VDD _08203_ sky130_fd_sc_hd__a21oi_1
X_11952_ net338 _07932_ _08203_ net402 net411 VSS VSS VDD
+ VDD _08204_ sky130_fd_sc_hd__o221ai_1
X_11953_ net411 _08202_ _08204_ VSS VSS VDD VDD _08205_ sky130_fd_sc_hd__o21ai_0
X_11954_ net393 net395 VSS VSS VDD VDD _08206_ sky130_fd_sc_hd__nand2_1
X_11955_ net411 net326 net335 VSS VSS VDD VDD _08207_ sky130_fd_sc_hd__o21ai_0
X_11956_ net341 _08207_ net305 VSS VSS VDD VDD _08208_ sky130_fd_sc_hd__a21oi_1
X_11957_ net395 net393 VSS VSS VDD VDD _08209_ sky130_fd_sc_hd__nor2b_1
X_11958_ net338 _07581_ _08209_ VSS VSS VDD VDD _08210_ sky130_fd_sc_hd__o21ai_0
X_11959_ net411 _07569_ _08098_ _08210_ VSS VSS VDD VDD _08211_
+ sky130_fd_sc_hd__a31oi_1
X_11960_ net399 _08208_ _08211_ VSS VSS VDD VDD _08212_ sky130_fd_sc_hd__o21ai_0
X_11961_ net393 _08200_ _08205_ _08206_ _08212_ VSS VSS VDD
+ VDD _08213_ sky130_fd_sc_hd__o221ai_1
X_11962_ net293 _08189_ _08213_ _07537_ VSS VSS VDD VDD _01518_
+ sky130_fd_sc_hd__a22o_1
X_11963_ net407 net324 _07961_ net338 VSS VSS VDD VDD _08214_
+ sky130_fd_sc_hd__o22ai_1
X_11964_ _08020_ net317 net411 VSS VSS VDD VDD _08215_ sky130_fd_sc_hd__a21oi_1
X_11965_ net409 net320 net399 VSS VSS VDD VDD _08216_ sky130_fd_sc_hd__a21oi_1
X_11966_ net402 _08215_ _08216_ VSS VSS VDD VDD _08217_ sky130_fd_sc_hd__nor3_1
X_11967_ net411 _07866_ _07901_ net399 net329 VSS VSS VDD
+ VDD _08218_ sky130_fd_sc_hd__a221oi_1
X_11968_ _08217_ _08218_ VSS VSS VDD VDD _08219_ sky130_fd_sc_hd__nor2_1
X_11969_ net406 _07354_ _07945_ VSS VSS VDD VDD _08220_ sky130_fd_sc_hd__o21ai_0
X_11970_ net342 _08220_ _07587_ VSS VSS VDD VDD _08221_ sky130_fd_sc_hd__a21oi_1
X_11971_ net394 _08221_ VSS VSS VDD VDD _08222_ sky130_fd_sc_hd__nor2_1
X_11972_ net401 _08214_ _08219_ net394 _08222_ VSS VSS VDD
+ VDD _08223_ sky130_fd_sc_hd__a221oi_1
X_11973_ net391 net392 _08223_ VSS VSS VDD VDD _08224_ sky130_fd_sc_hd__or3_1
X_11974_ net402 _07430_ net406 VSS VSS VDD VDD _08225_ sky130_fd_sc_hd__a21oi_1
X_11975_ net406 net335 _07393_ _08225_ net398 VSS VSS VDD
+ VDD _08226_ sky130_fd_sc_hd__a311o_1
X_11976_ net335 _07607_ _08226_ VSS VSS VDD VDD _08227_ sky130_fd_sc_hd__o21ai_0
X_11977_ net398 net337 _07982_ VSS VSS VDD VDD _08228_ sky130_fd_sc_hd__a21oi_1
X_11978_ net343 net344 _08228_ net396 VSS VSS VDD VDD _08229_
+ sky130_fd_sc_hd__o22ai_1
X_11979_ net391 net392 VSS VSS VDD VDD _08230_ sky130_fd_sc_hd__nand2b_1
X_11980_ net394 net329 _07581_ _07921_ net401 VSS VSS VDD
+ VDD _08231_ sky130_fd_sc_hd__o32a_1
X_11981_ net395 net408 VSS VSS VDD VDD _08232_ sky130_fd_sc_hd__nor2b_1
X_11982_ net315 _08232_ _07583_ VSS VSS VDD VDD _08233_ sky130_fd_sc_hd__a21oi_1
X_11983_ net411 _08231_ _08233_ net401 VSS VSS VDD VDD _08234_
+ sky130_fd_sc_hd__o22ai_1
X_11984_ net410 net340 net343 VSS VSS VDD VDD _08235_ sky130_fd_sc_hd__o21ai_0
X_11985_ net334 _08235_ net341 VSS VSS VDD VDD _08236_ sky130_fd_sc_hd__a21oi_1
X_11986_ net401 net320 _08099_ _08236_ net339 VSS VSS VDD
+ VDD _08237_ sky130_fd_sc_hd__a2111oi_0
X_11987_ net410 _08229_ _08230_ _08234_ _08237_ VSS VSS VDD
+ VDD _08238_ sky130_fd_sc_hd__a2111oi_0
X_11988_ _07243_ _08227_ _08238_ VSS VSS VDD VDD _08239_ sky130_fd_sc_hd__a21oi_1
X_11989_ _08224_ _08239_ _07282_ VSS VSS VDD VDD _01519_ sky130_fd_sc_hd__a21oi_1
X_11990_ net400 _07453_ _07468_ VSS VSS VDD VDD _08240_ sky130_fd_sc_hd__o21ai_0
X_11991_ net402 _07457_ net408 VSS VSS VDD VDD _08241_ sky130_fd_sc_hd__o21ai_0
X_11992_ _07866_ _07854_ _08241_ VSS VSS VDD VDD _08242_ sky130_fd_sc_hd__o21ai_0
X_11993_ _07274_ _08240_ _08242_ VSS VSS VDD VDD _08243_ sky130_fd_sc_hd__a21oi_1
X_11994_ net408 _07453_ VSS VSS VDD VDD _08244_ sky130_fd_sc_hd__nand2_1
X_11995_ net406 _08244_ VSS VSS VDD VDD _08245_ sky130_fd_sc_hd__nand2_1
X_11996_ net300 _07894_ _07905_ _08245_ VSS VSS VDD VDD _08246_
+ sky130_fd_sc_hd__nand4_1
X_11997_ net394 _08243_ _08246_ net393 VSS VSS VDD VDD _08247_
+ sky130_fd_sc_hd__o211ai_1
X_11998_ net342 net408 _07439_ _07306_ net345 VSS VSS VDD
+ VDD _08248_ sky130_fd_sc_hd__a32oi_1
X_11999_ net406 _08248_ VSS VSS VDD VDD _08249_ sky130_fd_sc_hd__nor2_1
X_12000_ net400 _07543_ VSS VSS VDD VDD _08250_ sky130_fd_sc_hd__nand2_1
X_12001_ _07274_ net402 _07390_ _08250_ net394 VSS VSS VDD
+ VDD _08251_ sky130_fd_sc_hd__o311ai_0
X_12002_ net394 _07444_ _07856_ net408 VSS VSS VDD VDD _08252_
+ sky130_fd_sc_hd__o211ai_1
X_12003_ net408 _08105_ _08252_ VSS VSS VDD VDD _08253_ sky130_fd_sc_hd__o21ai_0
X_12004_ net299 net303 net394 VSS VSS VDD VDD _08254_ sky130_fd_sc_hd__o21ai_0
X_12005_ _07986_ _07961_ _08253_ _08254_ net400 VSS VSS VDD
+ VDD _08255_ sky130_fd_sc_hd__o2111ai_1
X_12006_ net299 _08232_ VSS VSS VDD VDD _08256_ sky130_fd_sc_hd__nand2_1
X_12007_ _07496_ _08256_ VSS VSS VDD VDD _08257_ sky130_fd_sc_hd__nand2_1
X_12008_ _07587_ net318 _07615_ _08257_ net393 VSS VSS VDD
+ VDD _08258_ sky130_fd_sc_hd__a221oi_1
X_12009_ _08249_ _08251_ _08255_ _08258_ VSS VSS VDD VDD _08259_
+ sky130_fd_sc_hd__o211ai_1
X_12010_ net345 _07559_ net408 VSS VSS VDD VDD _08260_ sky130_fd_sc_hd__a21oi_1
X_12011_ _07387_ _08109_ net404 VSS VSS VDD VDD _08261_ sky130_fd_sc_hd__o21ai_0
X_12012_ _08260_ _07888_ net392 _08261_ VSS VSS VDD VDD _08262_
+ sky130_fd_sc_hd__nor4bb_1
X_12013_ _08247_ _08259_ _08262_ VSS VSS VDD VDD _08263_ sky130_fd_sc_hd__a21oi_1
X_12014_ net343 net299 _08055_ VSS VSS VDD VDD _08264_ sky130_fd_sc_hd__a21boi_0
X_12015_ _07599_ _07932_ _08264_ net409 VSS VSS VDD VDD _08265_
+ sky130_fd_sc_hd__o22ai_1
X_12016_ net343 net346 _07920_ _08265_ net329 VSS VSS VDD
+ VDD _08266_ sky130_fd_sc_hd__a32oi_1
X_12017_ _07283_ _08263_ _08266_ net294 VSS VSS VDD VDD _01520_
+ sky130_fd_sc_hd__o22ai_1
X_12018_ network.neuron_in150.counter\[2\] network.neuron_in150.counter\[3\]
+ VSS VSS VDD VDD _08267_ sky130_fd_sc_hd__nor2_1
X_12019_ _00519_ _08267_ VSS VSS VDD VDD _08268_ sky130_fd_sc_hd__nand2_1
X_12020_ net387 _08268_ VSS VSS VDD VDD _08269_ sky130_fd_sc_hd__nand2_1
X_12021_ net558 _08269_ VSS VSS VDD VDD _08270_ sky130_fd_sc_hd__nand2_1
X_12022_ _00520_ _08269_ _08270_ VSS VSS VDD VDD _02664_ sky130_fd_sc_hd__o21ai_0
X_12023_ net587 _08131_ VSS VSS VDD VDD _08271_ sky130_fd_sc_hd__nand2_1
X_12024_ _00877_ _08131_ _08271_ VSS VSS VDD VDD _03048_ sky130_fd_sc_hd__o21ai_0
X_12025_ net564 _08269_ VSS VSS VDD VDD _08272_ sky130_fd_sc_hd__nand2_1
X_12026_ network.neuron_in150.counter\[0\] _08269_ _08272_
+ VSS VSS VDD VDD _02663_ sky130_fd_sc_hd__o21ai_0
X_12027_ network.neuron_in053.counter\[0\] VSS VSS VDD VDD
+ _00253_ sky130_fd_sc_hd__inv_1
X_12028_ network.neuron_in247.counter\[2\] _00893_ VSS VSS
+ VDD VDD _08273_ sky130_fd_sc_hd__xnor2_1
X_12029_ network.neuron_in247.counter\[2\] network.neuron_in247.counter\[3\]
+ VSS VSS VDD VDD _08274_ sky130_fd_sc_hd__nor2_1
X_12030_ net361 _08274_ VSS VSS VDD VDD _08275_ sky130_fd_sc_hd__nor2_1
X_12031_ network.in_period\[247\]\[2\] _08275_ VSS VSS VDD
+ VDD _08276_ sky130_fd_sc_hd__nor2_1
X_12032_ net380 _08273_ _08276_ VSS VSS VDD VDD _03053_ sky130_fd_sc_hd__a21oi_1
X_12033_ network.in_period\[247\]\[1\] _08135_ VSS VSS VDD
+ VDD _08277_ sky130_fd_sc_hd__nand2_1
X_12034_ _00894_ _08135_ _08277_ VSS VSS VDD VDD _03052_ sky130_fd_sc_hd__o21ai_0
X_12035_ network.neuron_in248.counter\[2\] net388 VSS VSS
+ VDD VDD _08278_ sky130_fd_sc_hd__nand2_1
X_12036_ network.neuron_in248.counter\[3\] network.in_period\[248\]\[2\]
+ _08278_ VSS VSS VDD VDD _08279_ sky130_fd_sc_hd__o21ai_0
X_12037_ _00561_ network.neuron_in248.counter\[2\] net359
+ VSS VSS VDD VDD _08280_ sky130_fd_sc_hd__or3_1
X_12038_ network.in_period\[248\]\[2\] net388 _08280_ VSS
+ VSS VDD VDD _08281_ sky130_fd_sc_hd__o21ai_0
X_12039_ _00561_ _08279_ _08281_ VSS VSS VDD VDD _03057_ sky130_fd_sc_hd__a21oi_1
X_12040_ net529 _08139_ VSS VSS VDD VDD _08282_ sky130_fd_sc_hd__nand2_1
X_12041_ _00562_ _08139_ _08282_ VSS VSS VDD VDD _03056_ sky130_fd_sc_hd__o21ai_0
X_12042_ network.neuron_in249.counter\[2\] net388 VSS VSS
+ VDD VDD _08283_ sky130_fd_sc_hd__nand2_1
X_12043_ network.neuron_in249.counter\[3\] network.in_period\[249\]\[2\]
+ _08283_ VSS VSS VDD VDD _08284_ sky130_fd_sc_hd__o21ai_0
Xclkbuf_leaf_37_clk_net clknet_4_8_0_clk_net VSS VSS VDD VDD
+ clknet_leaf_37_clk_net sky130_fd_sc_hd__clkbuf_16
X_12045_ _01008_ network.neuron_in249.counter\[2\] net359
+ VSS VSS VDD VDD _08286_ sky130_fd_sc_hd__or3_1
X_12046_ network.in_period\[249\]\[2\] net388 _08286_ VSS
+ VSS VDD VDD _08287_ sky130_fd_sc_hd__o21ai_0
X_12047_ _01008_ _08284_ _08287_ VSS VSS VDD VDD _03061_ sky130_fd_sc_hd__a21oi_1
X_12048_ network.in_period\[249\]\[1\] _08143_ VSS VSS VDD
+ VDD _08288_ sky130_fd_sc_hd__nand2_1
X_12049_ _01009_ _08143_ _08288_ VSS VSS VDD VDD _03060_ sky130_fd_sc_hd__o21ai_0
X_12050_ network.neuron_in250.counter\[3\] _00905_ VSS VSS
+ VDD VDD _08289_ sky130_fd_sc_hd__nand2b_1
X_12051_ _08289_ _08125_ VSS VSS VDD VDD _08290_ sky130_fd_sc_hd__nand2b_1
X_12052_ net380 _08290_ VSS VSS VDD VDD _08291_ sky130_fd_sc_hd__nand2_1
X_12053_ net552 _08291_ VSS VSS VDD VDD _08292_ sky130_fd_sc_hd__nand2_1
X_12054_ _00906_ _08291_ _08292_ VSS VSS VDD VDD _03064_ sky130_fd_sc_hd__o21ai_0
X_12055_ network.neuron_in250.counter\[0\] VSS VSS VDD VDD
+ _00903_ sky130_fd_sc_hd__inv_1
X_12056_ net541 _08291_ VSS VSS VDD VDD _08293_ sky130_fd_sc_hd__nand2_1
X_12057_ network.neuron_in250.counter\[0\] _08291_ _08293_
+ VSS VSS VDD VDD _03063_ sky130_fd_sc_hd__o21ai_0
X_12058_ network.neuron_in251.counter\[2\] network.neuron_in251.counter\[3\]
+ VSS VSS VDD VDD _08294_ sky130_fd_sc_hd__nor2_1
X_12059_ _01111_ _08294_ VSS VSS VDD VDD _08295_ sky130_fd_sc_hd__nand2_1
X_12060_ net380 _08295_ VSS VSS VDD VDD _08296_ sky130_fd_sc_hd__nand2_1
X_12061_ network.in_period\[251\]\[1\] _08296_ VSS VSS VDD
+ VDD _08297_ sky130_fd_sc_hd__nand2_1
X_12062_ _01112_ _08296_ _08297_ VSS VSS VDD VDD _03068_ sky130_fd_sc_hd__o21ai_0
X_12063_ net641 _08296_ VSS VSS VDD VDD _08298_ sky130_fd_sc_hd__nand2_1
X_12064_ network.neuron_in251.counter\[0\] _08296_ _08298_
+ VSS VSS VDD VDD _03067_ sky130_fd_sc_hd__o21ai_0
X_12065_ network.neuron_in252.counter\[0\] VSS VSS VDD VDD
+ _01101_ sky130_fd_sc_hd__inv_1
X_12066_ network.neuron_in252.counter\[2\] VSS VSS VDD VDD
+ _08299_ sky130_fd_sc_hd__inv_1
X_12067_ _08299_ _01103_ VSS VSS VDD VDD _08300_ sky130_fd_sc_hd__nand2_1
X_12068_ network.neuron_in252.counter\[3\] _08300_ VSS VSS
+ VDD VDD _08301_ sky130_fd_sc_hd__or2_2
X_12069_ net379 _08301_ VSS VSS VDD VDD _08302_ sky130_fd_sc_hd__nand2_1
X_12070_ net619 _08302_ VSS VSS VDD VDD _08303_ sky130_fd_sc_hd__nand2_1
X_12071_ network.neuron_in252.counter\[0\] _08302_ _08303_
+ VSS VSS VDD VDD _03071_ sky130_fd_sc_hd__o21ai_0
X_12072_ network.neuron_in253.counter\[2\] network.neuron_in253.counter\[3\]
+ VSS VSS VDD VDD _08304_ sky130_fd_sc_hd__nor2_1
X_12073_ _00755_ _08304_ VSS VSS VDD VDD _08305_ sky130_fd_sc_hd__nand2_1
X_12074_ net379 _08305_ VSS VSS VDD VDD _08306_ sky130_fd_sc_hd__nand2_1
X_12075_ net679 _08306_ VSS VSS VDD VDD _08307_ sky130_fd_sc_hd__nand2_1
X_12076_ _00756_ _08306_ _08307_ VSS VSS VDD VDD _03076_ sky130_fd_sc_hd__o21ai_0
X_12077_ network.neuron_in254.counter\[0\] VSS VSS VDD VDD
+ _00899_ sky130_fd_sc_hd__inv_1
Xclkbuf_leaf_36_clk_net clknet_4_8_0_clk_net VSS VSS VDD VDD
+ clknet_leaf_36_clk_net sky130_fd_sc_hd__clkbuf_16
X_12079_ network.neuron_in254.counter\[2\] network.neuron_in254.counter\[3\]
+ VSS VSS VDD VDD _08309_ sky130_fd_sc_hd__nor2_1
X_12080_ _00901_ _08309_ VSS VSS VDD VDD _08310_ sky130_fd_sc_hd__nand2_1
X_12081_ net379 _08310_ VSS VSS VDD VDD _08311_ sky130_fd_sc_hd__nand2_1
X_12082_ network.in_period\[254\]\[0\] _08311_ VSS VSS VDD
+ VDD _08312_ sky130_fd_sc_hd__nand2_1
X_12083_ network.neuron_in254.counter\[0\] _08311_ _08312_
+ VSS VSS VDD VDD _03079_ sky130_fd_sc_hd__o21ai_0
Xclkbuf_leaf_35_clk_net clknet_4_8_0_clk_net VSS VSS VDD VDD
+ clknet_leaf_35_clk_net sky130_fd_sc_hd__clkbuf_16
X_12085_ network.neuron_in255.counter\[2\] _01040_ VSS VSS
+ VDD VDD _08314_ sky130_fd_sc_hd__nand2b_1
X_12086_ network.neuron_in255.counter\[3\] _08314_ VSS VSS
+ VDD VDD _08315_ sky130_fd_sc_hd__or2_2
X_12087_ net380 _08315_ VSS VSS VDD VDD _08316_ sky130_fd_sc_hd__nand2_1
X_12088_ net812 _08316_ VSS VSS VDD VDD _08317_ sky130_fd_sc_hd__nand2_1
X_12089_ network.neuron_in255.counter\[0\] _08316_ _08317_
+ VSS VSS VDD VDD _03083_ sky130_fd_sc_hd__o21ai_0
X_12090_ network.neuron_in252.counter\[3\] network.in_period\[252\]\[2\]
+ net362 _01103_ VSS VSS VDD VDD _08318_ sky130_fd_sc_hd__o22ai_1
X_12091_ network.neuron_in252.counter\[2\] _01103_ net379
+ VSS VSS VDD VDD _08319_ sky130_fd_sc_hd__nand3_1
X_12092_ network.in_period\[252\]\[2\] net379 _08319_ VSS
+ VSS VDD VDD _08320_ sky130_fd_sc_hd__o21ai_0
X_12093_ _08299_ _08318_ _08320_ VSS VSS VDD VDD _03073_ sky130_fd_sc_hd__a21oi_1
X_12094_ net633 _08302_ VSS VSS VDD VDD _08321_ sky130_fd_sc_hd__nand2_1
X_12095_ _01104_ _08302_ _08321_ VSS VSS VDD VDD _03072_ sky130_fd_sc_hd__o21ai_0
X_12096_ network.neuron_in253.counter\[2\] VSS VSS VDD VDD
+ _08322_ sky130_fd_sc_hd__inv_1
Xclkbuf_leaf_34_clk_net clknet_4_8_0_clk_net VSS VSS VDD VDD
+ clknet_leaf_34_clk_net sky130_fd_sc_hd__clkbuf_16
X_12098_ network.neuron_in253.counter\[3\] network.in_period\[253\]\[2\]
+ _00755_ net362 VSS VSS VDD VDD _08324_ sky130_fd_sc_hd__o22ai_1
X_12099_ network.neuron_in253.counter\[2\] _00755_ net379
+ VSS VSS VDD VDD _08325_ sky130_fd_sc_hd__nand3_1
X_12100_ network.in_period\[253\]\[2\] net379 _08325_ VSS
+ VSS VDD VDD _08326_ sky130_fd_sc_hd__o21ai_0
X_12101_ _08322_ _08324_ _08326_ VSS VSS VDD VDD _03077_ sky130_fd_sc_hd__a21oi_1
X_12102_ network.neuron_in253.counter\[0\] VSS VSS VDD VDD
+ _00753_ sky130_fd_sc_hd__inv_1
X_12103_ net705 _08306_ VSS VSS VDD VDD _08327_ sky130_fd_sc_hd__nand2_1
X_12104_ network.neuron_in253.counter\[0\] _08306_ _08327_
+ VSS VSS VDD VDD _03075_ sky130_fd_sc_hd__o21ai_0
X_12105_ network.neuron_in254.counter\[2\] VSS VSS VDD VDD
+ _08328_ sky130_fd_sc_hd__inv_1
X_12106_ network.neuron_in254.counter\[3\] network.in_period\[254\]\[2\]
+ _00901_ net360 VSS VSS VDD VDD _08329_ sky130_fd_sc_hd__o22ai_1
X_12107_ network.neuron_in254.counter\[2\] _00901_ net379
+ VSS VSS VDD VDD _08330_ sky130_fd_sc_hd__nand3_1
X_12108_ network.in_period\[254\]\[2\] net379 _08330_ VSS
+ VSS VDD VDD _08331_ sky130_fd_sc_hd__o21ai_0
X_12109_ _08328_ _08329_ _08331_ VSS VSS VDD VDD _03081_ sky130_fd_sc_hd__a21oi_1
X_12110_ net805 _08311_ VSS VSS VDD VDD _08332_ sky130_fd_sc_hd__nand2_1
X_12111_ _00902_ _08311_ _08332_ VSS VSS VDD VDD _03080_ sky130_fd_sc_hd__o21ai_0
X_12112_ network.neuron_in196.counter\[1\] VSS VSS VDD VDD
+ _00971_ sky130_fd_sc_hd__inv_1
X_12113_ network.neuron_in255.counter\[2\] net380 VSS VSS
+ VDD VDD _08333_ sky130_fd_sc_hd__nand2_1
X_12114_ network.neuron_in255.counter\[3\] network.in_period\[255\]\[2\]
+ _08333_ VSS VSS VDD VDD _08334_ sky130_fd_sc_hd__o21ai_0
X_12115_ _01040_ network.neuron_in255.counter\[2\] net361
+ VSS VSS VDD VDD _08335_ sky130_fd_sc_hd__or3_1
X_12116_ network.in_period\[255\]\[2\] net380 _08335_ VSS
+ VSS VDD VDD _08336_ sky130_fd_sc_hd__o21ai_0
X_12117_ _01040_ _08334_ _08336_ VSS VSS VDD VDD _03085_ sky130_fd_sc_hd__a21oi_1
X_12118_ network.in_period\[255\]\[1\] _08316_ VSS VSS VDD
+ VDD _08337_ sky130_fd_sc_hd__nand2_1
X_12119_ _01041_ _08316_ _08337_ VSS VSS VDD VDD _03084_ sky130_fd_sc_hd__o21ai_0
X_12120_ network.neuron_in178.counter\[0\] VSS VSS VDD VDD
+ _00269_ sky130_fd_sc_hd__inv_1
X_12121_ network.neuron_in139.counter\[3\] _01095_ VSS VSS
+ VDD VDD _08338_ sky130_fd_sc_hd__nand2b_1
X_12122_ network.neuron_in139.counter\[2\] VSS VSS VDD VDD
+ _08339_ sky130_fd_sc_hd__inv_1
X_12123_ _08338_ _08339_ VSS VSS VDD VDD _08340_ sky130_fd_sc_hd__nand2b_1
X_12124_ net377 _08340_ VSS VSS VDD VDD _08341_ sky130_fd_sc_hd__nand2_1
X_12125_ net643 _08341_ VSS VSS VDD VDD _08342_ sky130_fd_sc_hd__nand2_1
X_12126_ _01096_ _08341_ _08342_ VSS VSS VDD VDD _02620_ sky130_fd_sc_hd__o21ai_0
X_12127_ network.neuron_in159.counter\[1\] VSS VSS VDD VDD
+ _00638_ sky130_fd_sc_hd__inv_1
Xclkbuf_leaf_33_clk_net clknet_4_8_0_clk_net VSS VSS VDD VDD
+ clknet_leaf_33_clk_net sky130_fd_sc_hd__clkbuf_16
X_12129_ network.neuron_in149.counter\[2\] net387 VSS VSS
+ VDD VDD _08344_ sky130_fd_sc_hd__nand2_1
X_12130_ network.in_period\[149\]\[2\] network.neuron_in149.counter\[3\]
+ _08344_ VSS VSS VDD VDD _08345_ sky130_fd_sc_hd__o21ai_0
X_12131_ _00527_ network.neuron_in149.counter\[2\] net357
+ VSS VSS VDD VDD _08346_ sky130_fd_sc_hd__or3_1
X_12132_ network.in_period\[149\]\[2\] net387 _08346_ VSS
+ VSS VDD VDD _08347_ sky130_fd_sc_hd__o21ai_0
X_12133_ _00527_ _08345_ _08347_ VSS VSS VDD VDD _02661_ sky130_fd_sc_hd__a21oi_1
X_12134_ network.neuron_in193.counter\[1\] VSS VSS VDD VDD
+ _00250_ sky130_fd_sc_hd__inv_1
X_12135_ network.neuron_in032.counter\[1\] VSS VSS VDD VDD
+ _01119_ sky130_fd_sc_hd__inv_1
X_12136_ network.neuron_in186.counter\[1\] VSS VSS VDD VDD
+ _00766_ sky130_fd_sc_hd__inv_1
X_12137_ network.neuron_in154.counter\[0\] VSS VSS VDD VDD
+ _01164_ sky130_fd_sc_hd__inv_1
X_12138_ network.neuron_in158.counter\[1\] VSS VSS VDD VDD
+ _00670_ sky130_fd_sc_hd__inv_1
X_12139_ network.neuron_in123.counter\[0\] VSS VSS VDD VDD
+ _00205_ sky130_fd_sc_hd__inv_1
X_12140_ network.neuron_in200.counter\[1\] VSS VSS VDD VDD
+ _00967_ sky130_fd_sc_hd__inv_1
X_12141_ network.neuron_in071.counter\[0\] VSS VSS VDD VDD
+ _00139_ sky130_fd_sc_hd__inv_1
X_12142_ network.neuron_in080.counter\[0\] VSS VSS VDD VDD
+ _00086_ sky130_fd_sc_hd__inv_1
Xclkbuf_leaf_32_clk_net clknet_4_8_0_clk_net VSS VSS VDD VDD
+ clknet_leaf_32_clk_net sky130_fd_sc_hd__clkbuf_16
X_12144_ network.neuron_out0.ROM0.address\[1\] network.neuron_out0.ROM0.read_en
+ net389 VSS VSS VDD VDD _08349_ sky130_fd_sc_hd__nand3_1
X_12145_ _08349_ VSS VSS VDD VDD _01521_ sky130_fd_sc_hd__inv_1
Xclkbuf_leaf_31_clk_net clknet_4_8_0_clk_net VSS VSS VDD VDD
+ clknet_leaf_31_clk_net sky130_fd_sc_hd__clkbuf_16
Xclkbuf_leaf_30_clk_net clknet_4_8_0_clk_net VSS VSS VDD VDD
+ clknet_leaf_30_clk_net sky130_fd_sc_hd__clkbuf_16
Xclkbuf_leaf_29_clk_net clknet_4_8_0_clk_net VSS VSS VDD VDD
+ clknet_leaf_29_clk_net sky130_fd_sc_hd__clkbuf_16
X_12149_ network.neuron_out0.ROM0.address\[2\] network.neuron_out0.ROM0.address\[0\]
+ VSS VSS VDD VDD _08353_ sky130_fd_sc_hd__nand2_1
X_12150_ network.neuron_out0.ROM0.read_en net389 _08353_ VSS
+ VSS VDD VDD _08354_ sky130_fd_sc_hd__nand3_1
X_12151_ network.neuron_out0.ROM0.address\[1\] _08354_ VSS
+ VSS VDD VDD _01522_ sky130_fd_sc_hd__nor2_1
X_12152_ network.neuron_out0.ROM0.address\[0\] VSS VSS VDD
+ VDD _08355_ sky130_fd_sc_hd__inv_1
X_12153_ network.neuron_out0.ROM0.address\[2\] _08355_ VSS
+ VSS VDD VDD _08356_ sky130_fd_sc_hd__nor2_1
X_12154_ network.neuron_out0.ROM0.address\[0\] network.neuron_out0.ROM0.address\[2\]
+ VSS VSS VDD VDD _08357_ sky130_fd_sc_hd__nor2b_1
X_12155_ network.neuron_out0.ROM0.address\[1\] _08356_ _08357_
+ VSS VSS VDD VDD _08358_ sky130_fd_sc_hd__nor3_1
X_12156_ network.neuron_out0.ROM0.read_en net389 VSS VSS VDD
+ VDD _08359_ sky130_fd_sc_hd__nand2_1
Xclkbuf_leaf_28_clk_net clknet_4_8_0_clk_net VSS VSS VDD VDD
+ clknet_leaf_28_clk_net sky130_fd_sc_hd__clkbuf_16
X_12158_ network.neuron_out0.ROM0.address\[1\] _08356_ _08358_
+ _08359_ VSS VSS VDD VDD _01523_ sky130_fd_sc_hd__a211oi_1
Xclkbuf_leaf_27_clk_net clknet_4_9_0_clk_net VSS VSS VDD VDD
+ clknet_leaf_27_clk_net sky130_fd_sc_hd__clkbuf_16
X_12160_ network.neuron_out0.ROM0.address\[1\] _08355_ VSS
+ VSS VDD VDD _08362_ sky130_fd_sc_hd__nor2_1
X_12161_ _08362_ network.neuron_out0.ROM0.address\[2\] VSS
+ VSS VDD VDD _08363_ sky130_fd_sc_hd__nor2b_1
X_12162_ _08359_ _08363_ VSS VSS VDD VDD _01524_ sky130_fd_sc_hd__nor2_1
X_12163_ network.neuron_out0.ROM0.address\[2\] network.neuron_out0.ROM0.address\[1\]
+ VSS VSS VDD VDD _08364_ sky130_fd_sc_hd__nand2b_1
X_12164_ network.neuron_out0.ROM0.address\[2\] network.neuron_out0.ROM0.address\[0\]
+ VSS VSS VDD VDD _08365_ sky130_fd_sc_hd__nor2_1
X_12165_ network.neuron_out0.ROM0.address\[1\] _08365_ VSS
+ VSS VDD VDD _08366_ sky130_fd_sc_hd__or2_2
X_12166_ _08364_ _08366_ _08359_ VSS VSS VDD VDD _01525_ sky130_fd_sc_hd__a21oi_1
X_12167_ network.neuron_out0.ROM0.address\[2\] _08355_ VSS
+ VSS VDD VDD _08367_ sky130_fd_sc_hd__nand2_1
X_12168_ network.neuron_out0.ROM0.address\[1\] _08367_ _08364_
+ VSS VSS VDD VDD _08368_ sky130_fd_sc_hd__o21ai_0
X_12169_ _08359_ _08368_ VSS VSS VDD VDD _01526_ sky130_fd_sc_hd__nor2b_1
X_12170_ network.neuron_out0.ROM0.address\[1\] _08367_ _08356_
+ VSS VSS VDD VDD _08369_ sky130_fd_sc_hd__a21oi_1
X_12171_ _08359_ _08369_ VSS VSS VDD VDD _01527_ sky130_fd_sc_hd__nor2_1
X_12172_ network.neuron_out0.ROM0.address\[2\] network.neuron_out0.ROM0.address\[0\]
+ VSS VSS VDD VDD _08370_ sky130_fd_sc_hd__nand2b_1
X_12173_ network.neuron_out0.ROM0.address\[1\] _08357_ VSS
+ VSS VDD VDD _08371_ sky130_fd_sc_hd__nand2_1
X_12174_ network.neuron_out0.ROM0.address\[1\] _08370_ _08371_
+ VSS VSS VDD VDD _08372_ sky130_fd_sc_hd__o21ai_0
X_12175_ _08359_ _08372_ VSS VSS VDD VDD _01528_ sky130_fd_sc_hd__nor2_1
X_12176_ network.neuron_out0.ROM0.address\[1\] _08353_ _08365_
+ VSS VSS VDD VDD _08373_ sky130_fd_sc_hd__a21oi_1
X_12177_ _08359_ _08373_ VSS VSS VDD VDD _01529_ sky130_fd_sc_hd__nor2_1
X_12178_ network.neuron_out0.ROM0.address\[1\] _08370_ _08359_
+ VSS VSS VDD VDD _01530_ sky130_fd_sc_hd__a21oi_1
X_12179_ network.neuron_out0.ROM0.address\[1\] network.neuron_out0.ROM0.address\[2\]
+ VSS VSS VDD VDD _08374_ sky130_fd_sc_hd__nor2_1
X_12180_ network.neuron_out0.ROM0.address\[1\] _08357_ _08374_
+ VSS VSS VDD VDD _08375_ sky130_fd_sc_hd__a21oi_1
X_12181_ _08359_ _08375_ VSS VSS VDD VDD _01531_ sky130_fd_sc_hd__nor2_1
X_12182_ _08359_ _08372_ VSS VSS VDD VDD _01532_ sky130_fd_sc_hd__nor2b_1
X_12183_ network.neuron_out0.ROM0.address\[1\] _08365_ _08362_
+ _08359_ VSS VSS VDD VDD _01533_ sky130_fd_sc_hd__a211oi_1
X_12184_ network.neuron_out0.ROM0.address\[0\] _08349_ VSS
+ VSS VDD VDD _01534_ sky130_fd_sc_hd__nor2_1
X_12185_ _08356_ _08357_ VSS VSS VDD VDD _08376_ sky130_fd_sc_hd__nor2_1
X_12186_ network.neuron_out0.ROM0.address\[1\] network.neuron_out0.ROM0.address\[2\]
+ network.neuron_out0.ROM0.address\[0\] VSS VSS VDD VDD _08377_
+ sky130_fd_sc_hd__nand3_1
X_12187_ network.neuron_out0.ROM0.address\[1\] _08376_ _08377_
+ VSS VSS VDD VDD _08378_ sky130_fd_sc_hd__o21a_1
X_12188_ _08359_ _08378_ VSS VSS VDD VDD _01535_ sky130_fd_sc_hd__nor2_1
X_12189_ _08353_ _08364_ _08359_ VSS VSS VDD VDD _01536_ sky130_fd_sc_hd__a21oi_1
X_12190_ _08354_ _08374_ VSS VSS VDD VDD _01537_ sky130_fd_sc_hd__nor2_1
X_12191_ network.neuron_out0.ROM0.address\[1\] network.neuron_out0.ROM0.address\[0\]
+ VSS VSS VDD VDD _08379_ sky130_fd_sc_hd__nor2_1
X_12192_ _08354_ _08379_ VSS VSS VDD VDD _01538_ sky130_fd_sc_hd__nor2_1
X_12193_ network.neuron_out0.ROM0.address\[2\] network.neuron_out0.ROM0.address\[0\]
+ network.neuron_out0.ROM0.address\[1\] VSS VSS VDD VDD _08380_
+ sky130_fd_sc_hd__a21oi_1
X_12194_ network.neuron_out0.ROM0.address\[1\] _08376_ _08380_
+ _08359_ VSS VSS VDD VDD _01539_ sky130_fd_sc_hd__a211oi_1
X_12195_ network.neuron_in047.counter\[0\] VSS VSS VDD VDD
+ _00273_ sky130_fd_sc_hd__inv_1
X_12196_ net403 _07921_ net397 VSS VSS VDD VDD _08381_ sky130_fd_sc_hd__a21oi_1
X_12197_ net321 _08381_ net410 VSS VSS VDD VDD _08382_ sky130_fd_sc_hd__o21ai_0
X_12198_ _07571_ _08000_ net347 VSS VSS VDD VDD _08383_ sky130_fd_sc_hd__o21ai_0
X_12199_ _07341_ _07937_ _08000_ _08383_ VSS VSS VDD VDD _08384_
+ sky130_fd_sc_hd__a31oi_1
X_12200_ _08052_ net331 VSS VSS VDD VDD _08385_ sky130_fd_sc_hd__nor2_1
X_12201_ _07426_ _07878_ net398 VSS VSS VDD VDD _08386_ sky130_fd_sc_hd__o21ai_0
X_12202_ net396 _08385_ _08386_ net304 VSS VSS VDD VDD _08387_
+ sky130_fd_sc_hd__o211ai_1
X_12203_ net402 _07621_ net398 VSS VSS VDD VDD _08388_ sky130_fd_sc_hd__a21oi_1
X_12204_ net343 _07453_ _07905_ VSS VSS VDD VDD _08389_ sky130_fd_sc_hd__o21ai_0
X_12205_ _08388_ _08389_ net396 VSS VSS VDD VDD _08390_ sky130_fd_sc_hd__o21ai_0
X_12206_ _07956_ _07999_ _08390_ VSS VSS VDD VDD _08391_ sky130_fd_sc_hd__o21ai_0
X_12207_ net325 net311 net343 VSS VSS VDD VDD _08392_ sky130_fd_sc_hd__o21ai_0
X_12208_ net341 net325 _08392_ VSS VSS VDD VDD _08393_ sky130_fd_sc_hd__a21boi_0
X_12209_ network.neuron_hid0.ROM0.address\[1\] _08393_ net392
+ VSS VSS VDD VDD _08394_ sky130_fd_sc_hd__o21ai_0
X_12210_ net336 _08387_ _08391_ net406 _08394_ VSS VSS VDD
+ VDD _08395_ sky130_fd_sc_hd__a221oi_1
X_12211_ _08382_ _08384_ _08395_ VSS VSS VDD VDD _08396_ sky130_fd_sc_hd__a21oi_1
X_12212_ _07430_ _07607_ net342 VSS VSS VDD VDD _08397_ sky130_fd_sc_hd__a21oi_1
X_12213_ _08161_ _08397_ VSS VSS VDD VDD _08398_ sky130_fd_sc_hd__nor2_1
X_12214_ net405 net410 net337 VSS VSS VDD VDD _08399_ sky130_fd_sc_hd__nor3_1
X_12215_ net331 net333 _08399_ VSS VSS VDD VDD _08400_ sky130_fd_sc_hd__a21oi_1
X_12216_ net403 _08398_ _08400_ net397 VSS VSS VDD VDD _08401_
+ sky130_fd_sc_hd__o22ai_1
X_12217_ net403 _07572_ net341 VSS VSS VDD VDD _08402_ sky130_fd_sc_hd__o21ai_0
X_12218_ _08091_ _08402_ net410 VSS VSS VDD VDD _08403_ sky130_fd_sc_hd__a21oi_1
X_12219_ net391 net392 net339 VSS VSS VDD VDD _08404_ sky130_fd_sc_hd__or3_1
X_12220_ net397 net320 VSS VSS VDD VDD _08405_ sky130_fd_sc_hd__nor2_1
X_12221_ net397 _07927_ _08405_ VSS VSS VDD VDD _08406_ sky130_fd_sc_hd__a21oi_1
X_12222_ net342 net409 _07607_ net333 VSS VSS VDD VDD _08407_
+ sky130_fd_sc_hd__a31oi_1
X_12223_ net409 _08406_ _08407_ net403 VSS VSS VDD VDD _08408_
+ sky130_fd_sc_hd__o22ai_1
X_12224_ _08403_ _08404_ _08408_ VSS VSS VDD VDD _08409_ sky130_fd_sc_hd__nor3_1
X_12225_ _07243_ _08401_ _08409_ VSS VSS VDD VDD _08410_ sky130_fd_sc_hd__a21oi_1
X_12226_ net391 _08396_ _08410_ VSS VSS VDD VDD _08411_ sky130_fd_sc_hd__o21ai_0
X_12227_ _07282_ _08411_ VSS VSS VDD VDD _01540_ sky130_fd_sc_hd__nor2b_1
X_12228_ net399 _07453_ net301 VSS VSS VDD VDD _08412_ sky130_fd_sc_hd__a21oi_1
X_12229_ net399 _07444_ _08412_ net341 VSS VSS VDD VDD _08413_
+ sky130_fd_sc_hd__o22ai_1
X_12230_ _07439_ _07393_ VSS VSS VDD VDD _08414_ sky130_fd_sc_hd__nand2_1
X_12231_ net326 net299 _08413_ net409 net399 _08414_ VSS VSS
+ VDD VDD _08415_ sky130_fd_sc_hd__a222oi_1
X_12232_ _07474_ _08415_ VSS VSS VDD VDD _08416_ sky130_fd_sc_hd__nor2_1
X_12233_ _07870_ net314 _07999_ VSS VSS VDD VDD _08417_ sky130_fd_sc_hd__a21oi_1
X_12234_ _07330_ net317 _07426_ VSS VSS VDD VDD _08418_ sky130_fd_sc_hd__a21oi_1
X_12235_ net307 _08161_ net403 VSS VSS VDD VDD _08419_ sky130_fd_sc_hd__o21ai_0
X_12236_ net410 _08418_ _08419_ VSS VSS VDD VDD _08420_ sky130_fd_sc_hd__o21ai_0
X_12237_ _08417_ _08420_ net396 VSS VSS VDD VDD _08421_ sky130_fd_sc_hd__o21ai_0
X_12238_ net330 _07496_ VSS VSS VDD VDD _08422_ sky130_fd_sc_hd__nand2_1
X_12239_ net330 _07615_ _08422_ net400 _07587_ VSS VSS VDD
+ VDD _08423_ sky130_fd_sc_hd__a221o_1
X_12240_ _08052_ net328 _08423_ net339 VSS VSS VDD VDD _08424_
+ sky130_fd_sc_hd__a22oi_1
X_12241_ _08421_ _08424_ net392 VSS VSS VDD VDD _08425_ sky130_fd_sc_hd__a21oi_1
X_12242_ _08416_ _08425_ net391 VSS VSS VDD VDD _08426_ sky130_fd_sc_hd__o21bai_1
X_12243_ net403 net409 net410 VSS VSS VDD VDD _08427_ sky130_fd_sc_hd__o21ai_0
X_12244_ _07621_ _08427_ net405 VSS VSS VDD VDD _08428_ sky130_fd_sc_hd__a21oi_1
X_12245_ net405 _07389_ _08428_ VSS VSS VDD VDD _08429_ sky130_fd_sc_hd__a21oi_1
X_12246_ net397 _07497_ _08405_ VSS VSS VDD VDD _08430_ sky130_fd_sc_hd__a21oi_1
X_12247_ net397 _08429_ _08430_ net403 VSS VSS VDD VDD _08431_
+ sky130_fd_sc_hd__o22ai_1
X_12248_ net397 net409 net325 VSS VSS VDD VDD _08432_ sky130_fd_sc_hd__nor3_1
X_12249_ net397 _07439_ _08432_ VSS VSS VDD VDD _08433_ sky130_fd_sc_hd__a21oi_1
X_12250_ net391 net392 VSS VSS VDD VDD _08434_ sky130_fd_sc_hd__nor2b_1
X_12251_ net345 net312 _07373_ VSS VSS VDD VDD _08435_ sky130_fd_sc_hd__a21oi_1
X_12252_ net320 _07865_ _08434_ _08435_ net396 VSS VSS VDD
+ VDD _08436_ sky130_fd_sc_hd__o2111ai_1
X_12253_ net341 _08433_ _08436_ VSS VSS VDD VDD _08437_ sky130_fd_sc_hd__a21oi_1
X_12254_ _07243_ _08431_ _08437_ VSS VSS VDD VDD _08438_ sky130_fd_sc_hd__a21oi_1
X_12255_ _08426_ _08438_ _07282_ VSS VSS VDD VDD _01541_ sky130_fd_sc_hd__a21oi_1
X_12256_ net404 net324 VSS VSS VDD VDD _08439_ sky130_fd_sc_hd__nor2_1
X_12257_ net404 _07390_ _08439_ net323 VSS VSS VDD VDD _08440_
+ sky130_fd_sc_hd__a211oi_1
X_12258_ net405 _08022_ _07472_ VSS VSS VDD VDD _08441_ sky130_fd_sc_hd__o21ai_0
X_12259_ net410 net326 _08441_ net397 _08404_ VSS VSS VDD
+ VDD _08442_ sky130_fd_sc_hd__a221oi_1
X_12260_ net397 _08440_ _08442_ VSS VSS VDD VDD _08443_ sky130_fd_sc_hd__o21ai_0
X_12261_ net405 _07299_ VSS VSS VDD VDD _08444_ sky130_fd_sc_hd__nand2_1
X_12262_ _07559_ _07943_ net342 VSS VSS VDD VDD _08445_ sky130_fd_sc_hd__a21oi_1
X_12263_ net322 net304 _08444_ _08445_ VSS VSS VDD VDD _08446_
+ sky130_fd_sc_hd__a31oi_1
X_12264_ net397 net315 VSS VSS VDD VDD _08447_ sky130_fd_sc_hd__nand2_1
X_12265_ net397 _07495_ _08447_ VSS VSS VDD VDD _08448_ sky130_fd_sc_hd__o21ai_0
X_12266_ net391 net392 net396 VSS VSS VDD VDD _08449_ sky130_fd_sc_hd__or3_1
X_12267_ net410 _08448_ _08449_ VSS VSS VDD VDD _08450_ sky130_fd_sc_hd__a21oi_1
X_12268_ _08446_ _08450_ VSS VSS VDD VDD _08451_ sky130_fd_sc_hd__nand2_1
X_12269_ net317 _07954_ net397 VSS VSS VDD VDD _08452_ sky130_fd_sc_hd__a21oi_1
X_12270_ net335 _07341_ net405 VSS VSS VDD VDD _08453_ sky130_fd_sc_hd__a21oi_1
X_12271_ _08452_ _08453_ _07243_ VSS VSS VDD VDD _08454_ sky130_fd_sc_hd__o21ai_0
X_12272_ net409 net322 _07448_ _08405_ VSS VSS VDD VDD _08455_
+ sky130_fd_sc_hd__o22ai_1
X_12273_ net397 _07453_ VSS VSS VDD VDD _08456_ sky130_fd_sc_hd__nor2_1
X_12274_ net410 net334 net342 VSS VSS VDD VDD _08457_ sky130_fd_sc_hd__a21oi_1
X_12275_ _08456_ _08457_ net341 VSS VSS VDD VDD _08458_ sky130_fd_sc_hd__o21ai_0
X_12276_ net403 _08455_ _08458_ VSS VSS VDD VDD _08459_ sky130_fd_sc_hd__o21ai_0
X_12277_ net400 _07936_ VSS VSS VDD VDD _08460_ sky130_fd_sc_hd__nor2_1
X_12278_ net400 net326 _08460_ VSS VSS VDD VDD _08461_ sky130_fd_sc_hd__a21oi_1
X_12279_ net395 net409 _07607_ _07558_ VSS VSS VDD VDD _08462_
+ sky130_fd_sc_hd__a31oi_1
X_12280_ net411 _08461_ _08462_ net342 VSS VSS VDD VDD _08463_
+ sky130_fd_sc_hd__o22ai_1
X_12281_ _07393_ _08108_ VSS VSS VDD VDD _08464_ sky130_fd_sc_hd__nand2_1
X_12282_ net342 _07489_ _08464_ VSS VSS VDD VDD _08465_ sky130_fd_sc_hd__and3_1
X_12283_ net339 _08459_ _08463_ _08465_ _08230_ VSS VSS VDD
+ VDD _08466_ sky130_fd_sc_hd__a2111o_1
X_12284_ _08443_ _08451_ _08454_ _08466_ _07282_ VSS VSS VDD
+ VDD _01542_ sky130_fd_sc_hd__a41oi_1
X_12285_ network.neuron_out0.ROM0.address\[1\] _08357_ _08358_
+ VSS VSS VDD VDD _08467_ sky130_fd_sc_hd__a21oi_1
X_12286_ _08359_ _08467_ VSS VSS VDD VDD _01543_ sky130_fd_sc_hd__nor2_1
X_12287_ _08359_ _08366_ VSS VSS VDD VDD _01544_ sky130_fd_sc_hd__nor2_1
X_12288_ _08359_ _08374_ _08377_ VSS VSS VDD VDD _01545_ sky130_fd_sc_hd__nor3b_1
X_12289_ _08355_ _08359_ VSS VSS VDD VDD _01546_ sky130_fd_sc_hd__nor2_1
X_12290_ network.neuron_out0.ROM0.address\[1\] network.neuron_out0.ROM0.address\[2\]
+ VSS VSS VDD VDD _08468_ sky130_fd_sc_hd__nand2b_1
X_12291_ _08355_ _08468_ _08359_ VSS VSS VDD VDD _01547_ sky130_fd_sc_hd__a21oi_1
X_12292_ net331 net319 net315 net400 VSS VSS VDD VDD _08469_
+ sky130_fd_sc_hd__a211oi_1
X_12293_ net400 _07472_ _08261_ _08469_ VSS VSS VDD VDD _08470_
+ sky130_fd_sc_hd__a31oi_1
X_12294_ net399 net319 net315 VSS VSS VDD VDD _08471_ sky130_fd_sc_hd__a21oi_1
X_12295_ net399 net319 _08471_ VSS VSS VDD VDD _08472_ sky130_fd_sc_hd__o21ai_0
X_12296_ _07476_ net323 _07447_ _07897_ _07393_ VSS VSS VDD
+ VDD _08473_ sky130_fd_sc_hd__o311ai_0
X_12297_ net409 _08472_ _08473_ VSS VSS VDD VDD _08474_ sky130_fd_sc_hd__a21oi_1
X_12298_ net339 _08474_ VSS VSS VDD VDD _08475_ sky130_fd_sc_hd__nand2_1
X_12299_ net339 _08470_ _08475_ VSS VSS VDD VDD _08476_ sky130_fd_sc_hd__o21ai_0
X_12300_ _08000_ _07583_ net301 VSS VSS VDD VDD _08477_ sky130_fd_sc_hd__o21ai_0
X_12301_ net394 net402 VSS VSS VDD VDD _08478_ sky130_fd_sc_hd__nor2_1
X_12302_ net330 _08478_ net408 net306 VSS VSS VDD VDD _08479_
+ sky130_fd_sc_hd__a211o_1
X_12303_ net394 net334 _07599_ VSS VSS VDD VDD _08480_ sky130_fd_sc_hd__nand3_1
X_12304_ net394 net327 _08480_ VSS VSS VDD VDD _08481_ sky130_fd_sc_hd__o21ai_0
X_12305_ _07453_ _08481_ net406 VSS VSS VDD VDD _08482_ sky130_fd_sc_hd__a21oi_1
X_12306_ _08244_ _08479_ _08482_ VSS VSS VDD VDD _08483_ sky130_fd_sc_hd__a21oi_1
X_12307_ net346 net333 net408 VSS VSS VDD VDD _08484_ sky130_fd_sc_hd__o21ai_0
X_12308_ _07496_ _08484_ net342 VSS VSS VDD VDD _08485_ sky130_fd_sc_hd__a21oi_1
X_12309_ net337 net299 _08485_ VSS VSS VDD VDD _08486_ sky130_fd_sc_hd__a21oi_1
X_12310_ net411 _07368_ net408 VSS VSS VDD VDD _08487_ sky130_fd_sc_hd__o21ai_0
X_12311_ net337 net319 _07888_ VSS VSS VDD VDD _08488_ sky130_fd_sc_hd__a21oi_1
X_12312_ _07586_ _08487_ _08488_ net392 VSS VSS VDD VDD _08489_
+ sky130_fd_sc_hd__a31oi_1
X_12313_ net394 _08486_ _08489_ VSS VSS VDD VDD _08490_ sky130_fd_sc_hd__o21ai_0
X_12314_ net342 _08483_ _08490_ VSS VSS VDD VDD _08491_ sky130_fd_sc_hd__a21oi_1
X_12315_ net392 _08476_ _08477_ _08491_ VSS VSS VDD VDD _08492_
+ sky130_fd_sc_hd__a31oi_1
X_12316_ net410 _07444_ net314 _07389_ VSS VSS VDD VDD _08493_
+ sky130_fd_sc_hd__a31oi_1
X_12317_ net397 _08493_ _07499_ VSS VSS VDD VDD _08494_ sky130_fd_sc_hd__o21ai_0
X_12318_ _07537_ _08492_ _08494_ net293 VSS VSS VDD VDD _01548_
+ sky130_fd_sc_hd__a22o_1
X_12319_ network.neuron_in000.counter\[2\] VSS VSS VDD VDD
+ _08495_ sky130_fd_sc_hd__inv_1
X_12320_ network.neuron_in000.counter\[3\] network.in_period\[0\]\[2\]
+ _00631_ net351 VSS VSS VDD VDD _08496_ sky130_fd_sc_hd__o22ai_1
X_12321_ network.neuron_in000.counter\[2\] _00631_ net368
+ VSS VSS VDD VDD _08497_ sky130_fd_sc_hd__nand3_1
X_12322_ network.in_period\[0\]\[2\] net368 _08497_ VSS VSS
+ VDD VDD _08498_ sky130_fd_sc_hd__o21ai_0
X_12323_ _08495_ _08496_ _08498_ VSS VSS VDD VDD _02065_ sky130_fd_sc_hd__a21oi_1
X_12324_ network.cnt_main.counter\[1\] VSS VSS VDD VDD _00634_
+ sky130_fd_sc_hd__inv_1
X_12325_ network.neuron_in088.counter\[1\] VSS VSS VDD VDD
+ _01215_ sky130_fd_sc_hd__inv_1
X_12326_ network.neuron_in003.counter\[3\] _00627_ VSS VSS
+ VDD VDD _08499_ sky130_fd_sc_hd__nand2b_1
X_12327_ network.neuron_in003.counter\[2\] VSS VSS VDD VDD
+ _08500_ sky130_fd_sc_hd__inv_1
X_12328_ _08499_ _08500_ VSS VSS VDD VDD _08501_ sky130_fd_sc_hd__nand2b_1
X_12329_ net368 _08501_ VSS VSS VDD VDD _08502_ sky130_fd_sc_hd__nand2_1
X_12330_ network.in_period\[3\]\[1\] _08502_ VSS VSS VDD VDD
+ _08503_ sky130_fd_sc_hd__nand2_1
X_12331_ _00628_ _08502_ _08503_ VSS VSS VDD VDD _02076_ sky130_fd_sc_hd__o21ai_0
X_12332_ network.neuron_in001.counter\[2\] VSS VSS VDD VDD
+ _08504_ sky130_fd_sc_hd__inv_1
X_12333_ network.neuron_in001.counter\[3\] network.in_period\[1\]\[2\]
+ net351 _00569_ VSS VSS VDD VDD _08505_ sky130_fd_sc_hd__o22ai_1
X_12334_ network.neuron_in001.counter\[2\] _00569_ net368
+ VSS VSS VDD VDD _08506_ sky130_fd_sc_hd__nand3_1
X_12335_ network.in_period\[1\]\[2\] net368 _08506_ VSS VSS
+ VDD VDD _08507_ sky130_fd_sc_hd__o21ai_0
X_12336_ _08504_ _08505_ _08507_ VSS VSS VDD VDD _02069_ sky130_fd_sc_hd__a21oi_1
X_12337_ network.neuron_in128.counter\[2\] net384 VSS VSS
+ VDD VDD _08508_ sky130_fd_sc_hd__nand2_1
X_12338_ network.in_period\[128\]\[2\] network.neuron_in128.counter\[3\]
+ _08508_ VSS VSS VDD VDD _08509_ sky130_fd_sc_hd__o21ai_0
Xclkbuf_leaf_26_clk_net clknet_4_9_0_clk_net VSS VSS VDD VDD
+ clknet_leaf_26_clk_net sky130_fd_sc_hd__clkbuf_16
X_12340_ _01046_ network.neuron_in128.counter\[2\] net357
+ VSS VSS VDD VDD _08511_ sky130_fd_sc_hd__or3_1
X_12341_ network.in_period\[128\]\[2\] net384 _08511_ VSS
+ VSS VDD VDD _08512_ sky130_fd_sc_hd__o21ai_0
X_12342_ _01046_ _08509_ _08512_ VSS VSS VDD VDD _02577_ sky130_fd_sc_hd__a21oi_1
X_12343_ network.neuron_in084.counter\[0\] VSS VSS VDD VDD
+ _00049_ sky130_fd_sc_hd__inv_1
X_12344_ network.neuron_in120.counter\[1\] VSS VSS VDD VDD
+ _00963_ sky130_fd_sc_hd__inv_1
X_12345_ network.in_period\[133\]\[1\] _07037_ VSS VSS VDD
+ VDD _08513_ sky130_fd_sc_hd__nand2_1
X_12346_ _00475_ _07037_ _08513_ VSS VSS VDD VDD _02596_ sky130_fd_sc_hd__o21ai_0
X_12347_ network.neuron_in106.counter\[1\] VSS VSS VDD VDD
+ _00649_ sky130_fd_sc_hd__inv_1
X_12348_ network.neuron_in002.counter\[3\] _00759_ VSS VSS
+ VDD VDD _08514_ sky130_fd_sc_hd__nand2b_1
X_12349_ network.neuron_in002.counter\[2\] VSS VSS VDD VDD
+ _08515_ sky130_fd_sc_hd__inv_1
X_12350_ _08514_ _08515_ VSS VSS VDD VDD _08516_ sky130_fd_sc_hd__nand2b_1
X_12351_ net368 _08516_ VSS VSS VDD VDD _08517_ sky130_fd_sc_hd__nand2_1
X_12352_ network.in_period\[2\]\[1\] _08517_ VSS VSS VDD VDD
+ _08518_ sky130_fd_sc_hd__nand2_1
X_12353_ _00760_ _08517_ _08518_ VSS VSS VDD VDD _02072_ sky130_fd_sc_hd__o21ai_0
X_12354_ _08495_ _00631_ VSS VSS VDD VDD _08519_ sky130_fd_sc_hd__nand2_1
X_12355_ network.neuron_in000.counter\[3\] _08519_ VSS VSS
+ VDD VDD _08520_ sky130_fd_sc_hd__or2_2
X_12356_ net368 _08520_ VSS VSS VDD VDD _08521_ sky130_fd_sc_hd__nand2_1
X_12357_ network.in_period\[0\]\[1\] _08521_ VSS VSS VDD VDD
+ _08522_ sky130_fd_sc_hd__nand2_1
X_12358_ _00632_ _08521_ _08522_ VSS VSS VDD VDD _02064_ sky130_fd_sc_hd__o21ai_0
X_12359_ network.neuron_in000.counter\[0\] VSS VSS VDD VDD
+ _00629_ sky130_fd_sc_hd__inv_1
X_12360_ network.in_period\[0\]\[0\] _08521_ VSS VSS VDD VDD
+ _08523_ sky130_fd_sc_hd__nand2_1
X_12361_ network.neuron_in000.counter\[0\] _08521_ _08523_
+ VSS VSS VDD VDD _02063_ sky130_fd_sc_hd__o21ai_0
X_12362_ _08504_ _00569_ VSS VSS VDD VDD _08524_ sky130_fd_sc_hd__nand2_1
X_12363_ network.neuron_in001.counter\[3\] _08524_ VSS VSS
+ VDD VDD _08525_ sky130_fd_sc_hd__or2_2
X_12364_ net368 _08525_ VSS VSS VDD VDD _08526_ sky130_fd_sc_hd__nand2_1
X_12365_ network.in_period\[1\]\[1\] _08526_ VSS VSS VDD VDD
+ _08527_ sky130_fd_sc_hd__nand2_1
X_12366_ _00570_ _08526_ _08527_ VSS VSS VDD VDD _02068_ sky130_fd_sc_hd__o21ai_0
X_12367_ network.in_period\[1\]\[0\] _08526_ VSS VSS VDD VDD
+ _08528_ sky130_fd_sc_hd__nand2_1
X_12368_ network.neuron_in001.counter\[0\] _08526_ _08528_
+ VSS VSS VDD VDD _02067_ sky130_fd_sc_hd__o21ai_0
Xclkbuf_leaf_25_clk_net clknet_4_9_0_clk_net VSS VSS VDD VDD
+ clknet_leaf_25_clk_net sky130_fd_sc_hd__clkbuf_16
X_12370_ network.neuron_in002.counter\[3\] network.in_period\[2\]\[2\]
+ net351 _00759_ VSS VSS VDD VDD _08530_ sky130_fd_sc_hd__o22ai_1
X_12371_ network.neuron_in002.counter\[2\] _00759_ net368
+ VSS VSS VDD VDD _08531_ sky130_fd_sc_hd__nand3_1
X_12372_ network.in_period\[2\]\[2\] net368 _08531_ VSS VSS
+ VDD VDD _08532_ sky130_fd_sc_hd__o21ai_0
X_12373_ _08515_ _08530_ _08532_ VSS VSS VDD VDD _02073_ sky130_fd_sc_hd__a21oi_1
X_12374_ network.neuron_in002.counter\[0\] VSS VSS VDD VDD
+ _00757_ sky130_fd_sc_hd__inv_1
X_12375_ network.in_period\[2\]\[0\] _08517_ VSS VSS VDD VDD
+ _08533_ sky130_fd_sc_hd__nand2_1
X_12376_ network.neuron_in002.counter\[0\] _08517_ _08533_
+ VSS VSS VDD VDD _02071_ sky130_fd_sc_hd__o21ai_0
X_12377_ network.in_period\[3\]\[2\] network.neuron_in003.counter\[3\]
+ net351 _00627_ VSS VSS VDD VDD _08534_ sky130_fd_sc_hd__o22ai_1
Xclkbuf_leaf_24_clk_net clknet_4_9_0_clk_net VSS VSS VDD VDD
+ clknet_leaf_24_clk_net sky130_fd_sc_hd__clkbuf_16
X_12379_ network.neuron_in003.counter\[2\] _00627_ net368
+ VSS VSS VDD VDD _08536_ sky130_fd_sc_hd__nand3_1
X_12380_ network.in_period\[3\]\[2\] net368 _08536_ VSS VSS
+ VDD VDD _08537_ sky130_fd_sc_hd__o21ai_0
X_12381_ _08500_ _08534_ _08537_ VSS VSS VDD VDD _02077_ sky130_fd_sc_hd__a21oi_1
X_12382_ network.neuron_in004.counter\[2\] VSS VSS VDD VDD
+ _08538_ sky130_fd_sc_hd__inv_1
X_12383_ _08538_ _00622_ VSS VSS VDD VDD _08539_ sky130_fd_sc_hd__nand2_1
X_12384_ network.neuron_in004.counter\[3\] _08539_ VSS VSS
+ VDD VDD _08540_ sky130_fd_sc_hd__or2_2
X_12385_ net368 _08540_ VSS VSS VDD VDD _08541_ sky130_fd_sc_hd__nand2_1
X_12386_ net773 _08541_ VSS VSS VDD VDD _08542_ sky130_fd_sc_hd__nand2_1
X_12387_ _00623_ _08541_ _08542_ VSS VSS VDD VDD _02080_ sky130_fd_sc_hd__o21ai_0
X_12388_ network.neuron_in005.counter\[2\] net368 VSS VSS
+ VDD VDD _08543_ sky130_fd_sc_hd__nand2_1
X_12389_ network.neuron_in005.counter\[3\] network.in_period\[5\]\[2\]
+ _08543_ VSS VSS VDD VDD _08544_ sky130_fd_sc_hd__o21ai_0
X_12390_ _00618_ network.neuron_in005.counter\[2\] net351
+ VSS VSS VDD VDD _08545_ sky130_fd_sc_hd__or3_1
X_12391_ network.in_period\[5\]\[2\] net368 _08545_ VSS VSS
+ VDD VDD _08546_ sky130_fd_sc_hd__o21ai_0
X_12392_ _00618_ _08544_ _08546_ VSS VSS VDD VDD _02085_ sky130_fd_sc_hd__a21oi_1
X_12393_ network.neuron_in006.counter\[0\] VSS VSS VDD VDD
+ _00699_ sky130_fd_sc_hd__inv_1
X_12394_ network.neuron_in006.counter\[2\] network.neuron_in006.counter\[3\]
+ VSS VSS VDD VDD _08547_ sky130_fd_sc_hd__nor2_1
X_12395_ _00701_ _08547_ VSS VSS VDD VDD _08548_ sky130_fd_sc_hd__nand2_1
X_12396_ net368 _08548_ VSS VSS VDD VDD _08549_ sky130_fd_sc_hd__nand2_1
X_12397_ net735 _08549_ VSS VSS VDD VDD _08550_ sky130_fd_sc_hd__nand2_1
X_12398_ network.neuron_in006.counter\[0\] _08549_ _08550_
+ VSS VSS VDD VDD _02087_ sky130_fd_sc_hd__o21ai_0
X_12399_ network.in_period\[3\]\[0\] _08502_ VSS VSS VDD VDD
+ _08551_ sky130_fd_sc_hd__nand2_1
X_12400_ network.neuron_in003.counter\[0\] _08502_ _08551_
+ VSS VSS VDD VDD _02075_ sky130_fd_sc_hd__o21ai_0
X_12401_ network.neuron_in004.counter\[3\] network.in_period\[4\]\[2\]
+ net351 _00622_ VSS VSS VDD VDD _08552_ sky130_fd_sc_hd__o22ai_1
X_12402_ network.neuron_in004.counter\[2\] _00622_ net368
+ VSS VSS VDD VDD _08553_ sky130_fd_sc_hd__nand3_1
X_12403_ network.in_period\[4\]\[2\] net368 _08553_ VSS VSS
+ VDD VDD _08554_ sky130_fd_sc_hd__o21ai_0
X_12404_ _08538_ _08552_ _08554_ VSS VSS VDD VDD _02081_ sky130_fd_sc_hd__a21oi_1
X_12405_ network.in_period\[4\]\[0\] _08541_ VSS VSS VDD VDD
+ _08555_ sky130_fd_sc_hd__nand2_1
X_12406_ network.neuron_in004.counter\[0\] _08541_ _08555_
+ VSS VSS VDD VDD _02079_ sky130_fd_sc_hd__o21ai_0
X_12407_ network.neuron_in005.counter\[2\] network.neuron_in005.counter\[3\]
+ VSS VSS VDD VDD _08556_ sky130_fd_sc_hd__nor2_1
X_12408_ _00618_ _08556_ VSS VSS VDD VDD _08557_ sky130_fd_sc_hd__nand2_1
X_12409_ net368 _08557_ VSS VSS VDD VDD _08558_ sky130_fd_sc_hd__nand2_1
X_12410_ network.in_period\[5\]\[1\] _08558_ VSS VSS VDD VDD
+ _08559_ sky130_fd_sc_hd__nand2_1
X_12411_ _00619_ _08558_ _08559_ VSS VSS VDD VDD _02084_ sky130_fd_sc_hd__o21ai_0
X_12412_ network.neuron_in006.counter\[1\] VSS VSS VDD VDD
+ _00700_ sky130_fd_sc_hd__inv_1
X_12413_ network.in_period\[5\]\[0\] _08558_ VSS VSS VDD VDD
+ _08560_ sky130_fd_sc_hd__nand2_1
X_12414_ network.neuron_in005.counter\[0\] _08558_ _08560_
+ VSS VSS VDD VDD _02083_ sky130_fd_sc_hd__o21ai_0
X_12415_ network.neuron_in006.counter\[2\] VSS VSS VDD VDD
+ _08561_ sky130_fd_sc_hd__inv_1
X_12416_ network.neuron_in006.counter\[3\] network.in_period\[6\]\[2\]
+ _00701_ net351 VSS VSS VDD VDD _08562_ sky130_fd_sc_hd__o22ai_1
Xclkbuf_leaf_23_clk_net clknet_4_9_0_clk_net VSS VSS VDD VDD
+ clknet_leaf_23_clk_net sky130_fd_sc_hd__clkbuf_16
X_12418_ network.neuron_in006.counter\[2\] _00701_ net368
+ VSS VSS VDD VDD _08564_ sky130_fd_sc_hd__nand3_1
X_12419_ network.in_period\[6\]\[2\] net368 _08564_ VSS VSS
+ VDD VDD _08565_ sky130_fd_sc_hd__o21ai_0
X_12420_ _08561_ _08562_ _08565_ VSS VSS VDD VDD _02089_ sky130_fd_sc_hd__a21oi_1
X_12421_ network.in_period\[6\]\[1\] _08549_ VSS VSS VDD VDD
+ _08566_ sky130_fd_sc_hd__nand2_1
X_12422_ _00702_ _08549_ _08566_ VSS VSS VDD VDD _02088_ sky130_fd_sc_hd__o21ai_0
X_12423_ network.neuron_in157.counter\[1\] VSS VSS VDD VDD
+ _00690_ sky130_fd_sc_hd__inv_1
X_12424_ network.neuron_in007.counter\[2\] VSS VSS VDD VDD
+ _08567_ sky130_fd_sc_hd__inv_1
X_12425_ network.neuron_in007.counter\[3\] network.in_period\[7\]\[2\]
+ net351 _00539_ VSS VSS VDD VDD _08568_ sky130_fd_sc_hd__o22ai_1
X_12426_ network.neuron_in007.counter\[2\] _00539_ net369
+ VSS VSS VDD VDD _08569_ sky130_fd_sc_hd__nand3_1
X_12427_ network.in_period\[7\]\[2\] net369 _08569_ VSS VSS
+ VDD VDD _08570_ sky130_fd_sc_hd__o21ai_0
X_12428_ _08567_ _08568_ _08570_ VSS VSS VDD VDD _02093_ sky130_fd_sc_hd__a21oi_1
X_12429_ _08567_ _00539_ VSS VSS VDD VDD _08571_ sky130_fd_sc_hd__nand2_1
X_12430_ network.neuron_in007.counter\[3\] _08571_ VSS VSS
+ VDD VDD _08572_ sky130_fd_sc_hd__or2_2
X_12431_ net369 _08572_ VSS VSS VDD VDD _08573_ sky130_fd_sc_hd__nand2_1
X_12432_ net779 _08573_ VSS VSS VDD VDD _08574_ sky130_fd_sc_hd__nand2_1
X_12433_ _00540_ _08573_ _08574_ VSS VSS VDD VDD _02092_ sky130_fd_sc_hd__o21ai_0
X_12434_ network.neuron_in007.counter\[0\] VSS VSS VDD VDD
+ _00537_ sky130_fd_sc_hd__inv_1
X_12435_ network.in_period\[7\]\[0\] _08573_ VSS VSS VDD VDD
+ _08575_ sky130_fd_sc_hd__nand2_1
X_12436_ network.neuron_in007.counter\[0\] _08573_ _08575_
+ VSS VSS VDD VDD _02091_ sky130_fd_sc_hd__o21ai_0
X_12437_ network.neuron_in008.counter\[0\] VSS VSS VDD VDD
+ _00488_ sky130_fd_sc_hd__inv_1
X_12438_ network.neuron_in008.counter\[3\] _00490_ VSS VSS
+ VDD VDD _08576_ sky130_fd_sc_hd__nand2b_1
X_12439_ network.neuron_in008.counter\[2\] VSS VSS VDD VDD
+ _08577_ sky130_fd_sc_hd__inv_1
X_12440_ _08576_ _08577_ VSS VSS VDD VDD _08578_ sky130_fd_sc_hd__nand2b_1
X_12441_ net369 _08578_ VSS VSS VDD VDD _08579_ sky130_fd_sc_hd__nand2_1
X_12442_ network.in_period\[8\]\[0\] _08579_ VSS VSS VDD VDD
+ _08580_ sky130_fd_sc_hd__nand2_1
X_12443_ network.neuron_in008.counter\[0\] _08579_ _08580_
+ VSS VSS VDD VDD _02095_ sky130_fd_sc_hd__o21ai_0
X_12444_ network.neuron_in008.counter\[3\] network.in_period\[8\]\[2\]
+ _00490_ net350 VSS VSS VDD VDD _08581_ sky130_fd_sc_hd__o22ai_1
X_12445_ network.neuron_in008.counter\[2\] _00490_ net369
+ VSS VSS VDD VDD _08582_ sky130_fd_sc_hd__nand3_1
X_12446_ network.in_period\[8\]\[2\] net369 _08582_ VSS VSS
+ VDD VDD _08583_ sky130_fd_sc_hd__o21ai_0
X_12447_ _08577_ _08581_ _08583_ VSS VSS VDD VDD _02097_ sky130_fd_sc_hd__a21oi_1
X_12448_ network.in_period\[8\]\[1\] _08579_ VSS VSS VDD VDD
+ _08584_ sky130_fd_sc_hd__nand2_1
X_12449_ _00491_ _08579_ _08584_ VSS VSS VDD VDD _02096_ sky130_fd_sc_hd__o21ai_0
X_12450_ loaded\[0\] VSS VSS VDD VDD _00190_ sky130_fd_sc_hd__inv_1
X_12451_ network.neuron_in133.counter\[1\] VSS VSS VDD VDD
+ _00473_ sky130_fd_sc_hd__inv_1
X_12452_ network.neuron_out4.IF0.membrane_potential\[1\] network.neuron_out4.IF0.membrane_potential\[0\]
+ network.neuron_out4.IF0.membrane_potential\[3\] network.neuron_out4.IF0.membrane_potential\[2\]
+ VSS VSS VDD VDD _08585_ sky130_fd_sc_hd__nor4_1
X_12453_ network.neuron_out4.IF0.membrane_potential\[6\] network.neuron_out4.IF0.membrane_potential\[5\]
+ network.neuron_out4.IF0.membrane_potential\[4\] VSS VSS VDD
+ VDD _08586_ sky130_fd_sc_hd__nand3_1
X_12454_ network.neuron_out4.IF0.membrane_potential\[9\] network.neuron_out4.IF0.membrane_potential\[7\]
+ network.neuron_out4.IF0.membrane_potential\[10\] network.neuron_out4.IF0.membrane_potential\[8\]
+ VSS VSS VDD VDD _08587_ sky130_fd_sc_hd__nor4_1
X_12455_ _08585_ _08586_ _08587_ VSS VSS VDD VDD _08588_ sky130_fd_sc_hd__o21ai_0
X_12456_ network.neuron_out5.IF0.membrane_potential\[2\] network.neuron_out5.IF0.membrane_potential\[0\]
+ network.neuron_out5.IF0.membrane_potential\[3\] network.neuron_out5.IF0.membrane_potential\[1\]
+ VSS VSS VDD VDD _08589_ sky130_fd_sc_hd__nor4_1
X_12457_ network.neuron_out5.IF0.membrane_potential\[6\] network.neuron_out5.IF0.membrane_potential\[5\]
+ network.neuron_out5.IF0.membrane_potential\[4\] VSS VSS VDD
+ VDD _08590_ sky130_fd_sc_hd__nand3_1
X_12458_ network.neuron_out5.IF0.membrane_potential\[7\] network.neuron_out5.IF0.membrane_potential\[10\]
+ network.neuron_out5.IF0.membrane_potential\[8\] network.neuron_out5.IF0.membrane_potential\[9\]
+ VSS VSS VDD VDD _08591_ sky130_fd_sc_hd__nor4_1
X_12459_ _08589_ _08590_ _08591_ VSS VSS VDD VDD _08592_ sky130_fd_sc_hd__o21ai_0
X_12460_ _08588_ _08592_ VSS VSS VDD VDD _08593_ sky130_fd_sc_hd__nor2_1
X_12461_ network.neuron_out0.IF0.membrane_potential\[2\] network.neuron_out0.IF0.membrane_potential\[0\]
+ network.neuron_out0.IF0.membrane_potential\[1\] network.neuron_out0.IF0.membrane_potential\[3\]
+ VSS VSS VDD VDD _08594_ sky130_fd_sc_hd__nor4_1
X_12462_ network.neuron_out0.IF0.membrane_potential\[6\] network.neuron_out0.IF0.membrane_potential\[5\]
+ network.neuron_out0.IF0.membrane_potential\[4\] VSS VSS VDD
+ VDD _08595_ sky130_fd_sc_hd__nand3_1
X_12463_ network.neuron_out0.IF0.membrane_potential\[7\] network.neuron_out0.IF0.membrane_potential\[8\]
+ network.neuron_out0.IF0.membrane_potential\[9\] network.neuron_out0.IF0.membrane_potential\[10\]
+ VSS VSS VDD VDD _08596_ sky130_fd_sc_hd__nor4_1
X_12464_ _08594_ _08595_ _08596_ VSS VSS VDD VDD _08597_ sky130_fd_sc_hd__o21ai_0
X_12465_ network.neuron_out1.IF0.membrane_potential\[2\] network.neuron_out1.IF0.membrane_potential\[1\]
+ network.neuron_out1.IF0.membrane_potential\[3\] network.neuron_out1.IF0.membrane_potential\[0\]
+ VSS VSS VDD VDD _08598_ sky130_fd_sc_hd__nor4_1
X_12466_ network.neuron_out1.IF0.membrane_potential\[6\] network.neuron_out1.IF0.membrane_potential\[5\]
+ network.neuron_out1.IF0.membrane_potential\[4\] VSS VSS VDD
+ VDD _08599_ sky130_fd_sc_hd__nand3_1
X_12467_ network.neuron_out1.IF0.membrane_potential\[7\] network.neuron_out1.IF0.membrane_potential\[9\]
+ network.neuron_out1.IF0.membrane_potential\[8\] network.neuron_out1.IF0.membrane_potential\[10\]
+ VSS VSS VDD VDD _08600_ sky130_fd_sc_hd__nor4_1
X_12468_ _08598_ _08599_ _08600_ VSS VSS VDD VDD _08601_ sky130_fd_sc_hd__o21ai_0
X_12469_ net298 _08601_ VSS VSS VDD VDD _08602_ sky130_fd_sc_hd__nor2_1
X_12470_ network.neuron_out2.IF0.membrane_potential\[1\] network.neuron_out2.IF0.membrane_potential\[3\]
+ network.neuron_out2.IF0.membrane_potential\[0\] network.neuron_out2.IF0.membrane_potential\[2\]
+ VSS VSS VDD VDD _08603_ sky130_fd_sc_hd__nor4_1
X_12471_ network.neuron_out2.IF0.membrane_potential\[5\] network.neuron_out2.IF0.membrane_potential\[6\]
+ network.neuron_out2.IF0.membrane_potential\[4\] VSS VSS VDD
+ VDD _08604_ sky130_fd_sc_hd__nand3_1
X_12472_ network.neuron_out2.IF0.membrane_potential\[8\] network.neuron_out2.IF0.membrane_potential\[7\]
+ network.neuron_out2.IF0.membrane_potential\[9\] network.neuron_out2.IF0.membrane_potential\[10\]
+ VSS VSS VDD VDD _08605_ sky130_fd_sc_hd__nor4_1
X_12473_ _08603_ _08604_ _08605_ VSS VSS VDD VDD _08606_ sky130_fd_sc_hd__o21ai_0
X_12474_ network.neuron_out3.IF0.membrane_potential\[3\] network.neuron_out3.IF0.membrane_potential\[2\]
+ network.neuron_out3.IF0.membrane_potential\[1\] network.neuron_out3.IF0.membrane_potential\[0\]
+ VSS VSS VDD VDD _08607_ sky130_fd_sc_hd__nor4_1
X_12475_ network.neuron_out3.IF0.membrane_potential\[6\] network.neuron_out3.IF0.membrane_potential\[5\]
+ network.neuron_out3.IF0.membrane_potential\[4\] VSS VSS VDD
+ VDD _08608_ sky130_fd_sc_hd__nand3_1
X_12476_ network.neuron_out3.IF0.membrane_potential\[8\] network.neuron_out3.IF0.membrane_potential\[7\]
+ network.neuron_out3.IF0.membrane_potential\[9\] network.neuron_out3.IF0.membrane_potential\[10\]
+ VSS VSS VDD VDD _08609_ sky130_fd_sc_hd__nor4_1
X_12477_ _08607_ _08608_ _08609_ VSS VSS VDD VDD _08610_ sky130_fd_sc_hd__o21ai_0
X_12478_ _00117_ VSS VSS VDD VDD _08611_ sky130_fd_sc_hd__inv_1
X_12479_ network.arbit.counter\[3\] network.arbit.counter\[2\]
+ _08611_ VSS VSS VDD VDD _08612_ sky130_fd_sc_hd__nor3_1
X_12480_ _08606_ net297 _08612_ VSS VSS VDD VDD _08613_ sky130_fd_sc_hd__nor3_1
X_12481_ _08593_ _08602_ _08613_ VSS VSS VDD VDD _08614_ sky130_fd_sc_hd__and3_1
X_12482_ _06644_ state\[0\] VSS VSS VDD VDD _08615_ sky130_fd_sc_hd__nor2_1
X_12483_ _08614_ net310 VSS VSS VDD VDD _08616_ sky130_fd_sc_hd__nand2b_1
X_12484_ _08606_ net297 VSS VSS VDD VDD _08617_ sky130_fd_sc_hd__nor2_1
X_12485_ _08588_ _08592_ VSS VSS VDD VDD _08618_ sky130_fd_sc_hd__nand2b_1
X_12486_ _08617_ _08618_ _08601_ VSS VSS VDD VDD _08619_ sky130_fd_sc_hd__a21oi_1
X_12487_ net298 _08616_ _08619_ VSS VSS VDD VDD _08620_ sky130_fd_sc_hd__nor3_1
X_12488_ net462 _08616_ _08620_ net447 VSS VSS VDD VDD _01549_
+ sky130_fd_sc_hd__a211o_1
X_12489_ net30 net31 VSS VSS VDD VDD _08621_ sky130_fd_sc_hd__nand2_1
Xclkbuf_leaf_22_clk_net clknet_4_3_0_clk_net VSS VSS VDD VDD
+ clknet_leaf_22_clk_net sky130_fd_sc_hd__clkbuf_16
X_12491_ net28 VSS VSS VDD VDD _08623_ sky130_fd_sc_hd__inv_1
X_12492_ net36 net37 net38 net39 VSS VSS VDD VDD _08624_ sky130_fd_sc_hd__and4_1
X_12493_ net40 net41 net42 _08624_ VSS VSS VDD VDD _08625_
+ sky130_fd_sc_hd__nand4_1
X_12494_ _08623_ _08625_ VSS VSS VDD VDD _08626_ sky130_fd_sc_hd__nor2_1
X_12495_ net35 net29 _00652_ _08626_ VSS VSS VDD VDD _08627_
+ sky130_fd_sc_hd__nand4_1
X_12496_ _08621_ _08627_ net310 VSS VSS VDD VDD _08628_ sky130_fd_sc_hd__o21ai_0
Xclkbuf_leaf_21_clk_net clknet_4_3_0_clk_net VSS VSS VDD VDD
+ clknet_leaf_21_clk_net sky130_fd_sc_hd__clkbuf_16
X_12498_ loaded\[2\] loaded\[3\] VSS VSS VDD VDD _08630_ sky130_fd_sc_hd__nor2_2
X_12499_ _00192_ _08630_ VSS VSS VDD VDD _08631_ sky130_fd_sc_hd__nand2_8
Xclkbuf_leaf_20_clk_net clknet_4_3_0_clk_net VSS VSS VDD VDD
+ clknet_leaf_20_clk_net sky130_fd_sc_hd__clkbuf_16
Xclkbuf_leaf_19_clk_net clknet_4_3_0_clk_net VSS VSS VDD VDD
+ clknet_leaf_19_clk_net sky130_fd_sc_hd__clkbuf_16
Xclkbuf_leaf_18_clk_net clknet_4_3_0_clk_net VSS VSS VDD VDD
+ clknet_leaf_18_clk_net sky130_fd_sc_hd__clkbuf_16
X_12503_ net413 loaded\[7\] VSS VSS VDD VDD _08635_ sky130_fd_sc_hd__nor2_1
X_12504_ loaded\[4\] net412 loaded\[8\] VSS VSS VDD VDD _08636_
+ sky130_fd_sc_hd__nand3b_1
X_12505_ loaded\[5\] _08631_ _08636_ VSS VSS VDD VDD net43
+ sky130_fd_sc_hd__nor3_1
X_12506_ net444 net43 VSS VSS VDD VDD _08637_ sky130_fd_sc_hd__nand2_1
X_12507_ _06644_ _08637_ state\[0\] VSS VSS VDD VDD _08638_
+ sky130_fd_sc_hd__a21oi_2
Xclkbuf_leaf_17_clk_net clknet_4_3_0_clk_net VSS VSS VDD VDD
+ clknet_leaf_17_clk_net sky130_fd_sc_hd__clkbuf_16
Xclkbuf_leaf_16_clk_net clknet_4_2_0_clk_net VSS VSS VDD VDD
+ clknet_leaf_16_clk_net sky130_fd_sc_hd__clkbuf_16
X_12510_ _06611_ _08621_ _08627_ VSS VSS VDD VDD _08641_ sky130_fd_sc_hd__nor3_1
X_12511_ net32 _08641_ VSS VSS VDD VDD _08642_ sky130_fd_sc_hd__nor2_1
Xclkbuf_leaf_15_clk_net clknet_4_2_0_clk_net VSS VSS VDD VDD
+ clknet_leaf_15_clk_net sky130_fd_sc_hd__clkbuf_16
X_12513_ net32 _08628_ _08638_ _08642_ net447 VSS VSS VDD
+ VDD _01550_ sky130_fd_sc_hd__a311oi_1
Xclkbuf_leaf_14_clk_net clknet_4_2_0_clk_net VSS VSS VDD VDD
+ clknet_leaf_14_clk_net sky130_fd_sc_hd__clkbuf_16
X_12515_ net27 net34 net35 VSS VSS VDD VDD _08645_ sky130_fd_sc_hd__and3_1
X_12516_ net29 net30 _08626_ _08645_ VSS VSS VDD VDD _08646_
+ sky130_fd_sc_hd__and4_1
X_12517_ _06611_ _08646_ _08638_ VSS VSS VDD VDD _08647_ sky130_fd_sc_hd__o21ai_0
Xclkbuf_leaf_13_clk_net clknet_4_2_0_clk_net VSS VSS VDD VDD
+ clknet_leaf_13_clk_net sky130_fd_sc_hd__clkbuf_16
X_12519_ net310 _08646_ VSS VSS VDD VDD _08649_ sky130_fd_sc_hd__nand2_1
X_12520_ net31 _08649_ VSS VSS VDD VDD _08650_ sky130_fd_sc_hd__nor2_1
X_12521_ net31 _08647_ _08650_ VSS VSS VDD VDD _08651_ sky130_fd_sc_hd__a21oi_1
X_12522_ net447 _08651_ VSS VSS VDD VDD _01551_ sky130_fd_sc_hd__nor2_1
X_12523_ net35 _00652_ VSS VSS VDD VDD _08652_ sky130_fd_sc_hd__nand2_1
X_12524_ net29 _08626_ VSS VSS VDD VDD _08653_ sky130_fd_sc_hd__nand2_1
X_12525_ _08652_ _08653_ VSS VSS VDD VDD _08654_ sky130_fd_sc_hd__nor2_1
X_12526_ _06611_ _08654_ _08638_ VSS VSS VDD VDD _08655_ sky130_fd_sc_hd__o21ai_0
X_12527_ net30 _06611_ _08627_ VSS VSS VDD VDD _08656_ sky130_fd_sc_hd__nor3_1
X_12528_ net30 _08655_ _08656_ VSS VSS VDD VDD _08657_ sky130_fd_sc_hd__a21oi_1
X_12529_ net447 _08657_ VSS VSS VDD VDD _01552_ sky130_fd_sc_hd__nor2_1
X_12530_ _06644_ _08637_ state\[0\] VSS VSS VDD VDD _08658_
+ sky130_fd_sc_hd__a21o_1
X_12531_ state\[0\] net29 VSS VSS VDD VDD _08659_ sky130_fd_sc_hd__nor2_1
X_12532_ _08626_ _08645_ VSS VSS VDD VDD _08660_ sky130_fd_sc_hd__nand2_1
X_12533_ _08659_ net29 _08660_ VSS VSS VDD VDD _08661_ sky130_fd_sc_hd__mux2_2
X_12534_ net29 _08658_ _08661_ state\[1\] VSS VSS VDD VDD
+ _08662_ sky130_fd_sc_hd__a22oi_1
X_12535_ net447 _08662_ VSS VSS VDD VDD _01553_ sky130_fd_sc_hd__nor2_1
X_12536_ _08625_ _08652_ net310 VSS VSS VDD VDD _08663_ sky130_fd_sc_hd__o21ai_0
X_12537_ _06611_ _08625_ _08652_ VSS VSS VDD VDD _08664_ sky130_fd_sc_hd__nor3_1
X_12538_ net28 _08664_ VSS VSS VDD VDD _08665_ sky130_fd_sc_hd__nor2_1
X_12539_ net28 _08638_ _08663_ _08665_ net447 VSS VSS VDD
+ VDD _01554_ sky130_fd_sc_hd__a311oi_1
X_12540_ net40 _08624_ VSS VSS VDD VDD _08666_ sky130_fd_sc_hd__and2_1
X_12541_ net41 _08666_ _08645_ VSS VSS VDD VDD _08667_ sky130_fd_sc_hd__nand3_1
X_12542_ net310 _08667_ VSS VSS VDD VDD _08668_ sky130_fd_sc_hd__nand2_1
X_12543_ net27 net34 net35 VSS VSS VDD VDD _08669_ sky130_fd_sc_hd__nand3_1
X_12544_ _06611_ _08669_ VSS VSS VDD VDD _08670_ sky130_fd_sc_hd__nor2_1
X_12545_ net41 _08666_ _08670_ net42 VSS VSS VDD VDD _08671_
+ sky130_fd_sc_hd__a31oi_1
X_12546_ net42 _08638_ _08668_ _08671_ net447 VSS VSS VDD
+ VDD _01555_ sky130_fd_sc_hd__a311oi_1
X_12547_ net40 _08624_ VSS VSS VDD VDD _08672_ sky130_fd_sc_hd__nand2_1
X_12548_ _08672_ _08652_ net310 VSS VSS VDD VDD _08673_ sky130_fd_sc_hd__o21ai_0
X_12549_ _06611_ _08652_ VSS VSS VDD VDD _08674_ sky130_fd_sc_hd__nor2_1
X_12550_ _08666_ _08674_ net41 VSS VSS VDD VDD _08675_ sky130_fd_sc_hd__a21oi_1
X_12551_ net41 _08638_ _08673_ _08675_ net447 VSS VSS VDD
+ VDD _01556_ sky130_fd_sc_hd__a311oi_1
X_12552_ _08624_ _08645_ VSS VSS VDD VDD _08676_ sky130_fd_sc_hd__nand2_1
X_12553_ net310 _08676_ VSS VSS VDD VDD _08677_ sky130_fd_sc_hd__nand2_1
X_12554_ _08624_ _08670_ net40 VSS VSS VDD VDD _08678_ sky130_fd_sc_hd__a21oi_1
X_12555_ net40 _08638_ _08677_ _08678_ net447 VSS VSS VDD
+ VDD _01557_ sky130_fd_sc_hd__a311oi_1
X_12556_ net36 net37 net38 VSS VSS VDD VDD _08679_ sky130_fd_sc_hd__and3_1
X_12557_ net35 _00652_ _08679_ VSS VSS VDD VDD _08680_ sky130_fd_sc_hd__nand3_1
X_12558_ net310 _08680_ VSS VSS VDD VDD _08681_ sky130_fd_sc_hd__nand2_1
X_12559_ _08679_ _08674_ net39 VSS VSS VDD VDD _08682_ sky130_fd_sc_hd__a21oi_1
X_12560_ net39 _08638_ _08681_ _08682_ net447 VSS VSS VDD
+ VDD _01558_ sky130_fd_sc_hd__a311oi_1
X_12561_ net36 net37 _08645_ VSS VSS VDD VDD _08683_ sky130_fd_sc_hd__nand3_1
X_12562_ net310 _08683_ VSS VSS VDD VDD _08684_ sky130_fd_sc_hd__nand2_1
X_12563_ net36 net37 _08670_ net38 VSS VSS VDD VDD _08685_
+ sky130_fd_sc_hd__a31oi_1
X_12564_ net38 _08638_ _08684_ _08685_ net447 VSS VSS VDD
+ VDD _01559_ sky130_fd_sc_hd__a311oi_1
X_12565_ net35 net36 _00652_ _06611_ VSS VSS VDD VDD _08686_
+ sky130_fd_sc_hd__a31oi_1
X_12566_ _08658_ _08686_ net37 VSS VSS VDD VDD _08687_ sky130_fd_sc_hd__o21ai_0
X_12567_ net37 _08674_ net36 VSS VSS VDD VDD _08688_ sky130_fd_sc_hd__nand3b_1
X_12568_ _08687_ _08688_ net447 VSS VSS VDD VDD _01560_ sky130_fd_sc_hd__a21oi_1
X_12569_ net310 _08669_ VSS VSS VDD VDD _08689_ sky130_fd_sc_hd__nand2_1
X_12570_ net36 _08670_ VSS VSS VDD VDD _08690_ sky130_fd_sc_hd__nor2_1
X_12571_ net36 _08638_ _08689_ _08690_ net447 VSS VSS VDD
+ VDD _01561_ sky130_fd_sc_hd__a311oi_1
X_12572_ _00652_ _06611_ _08638_ VSS VSS VDD VDD _08691_ sky130_fd_sc_hd__o21ai_0
X_12573_ _00652_ net310 VSS VSS VDD VDD _08692_ sky130_fd_sc_hd__nand2_1
X_12574_ net35 _08692_ VSS VSS VDD VDD _08693_ sky130_fd_sc_hd__nor2_1
X_12575_ net35 _08691_ _08693_ VSS VSS VDD VDD _08694_ sky130_fd_sc_hd__a21oi_1
X_12576_ net447 _08694_ VSS VSS VDD VDD _01562_ sky130_fd_sc_hd__nor2_1
X_12577_ _00653_ net310 _08658_ net34 VSS VSS VDD VDD _08695_
+ sky130_fd_sc_hd__a22oi_1
X_12578_ net447 _08695_ VSS VSS VDD VDD _01563_ sky130_fd_sc_hd__nor2_1
X_12579_ net27 net310 VSS VSS VDD VDD _08696_ sky130_fd_sc_hd__nor2_1
X_12580_ net27 _08638_ _08696_ net447 VSS VSS VDD VDD _01564_
+ sky130_fd_sc_hd__a211oi_1
X_12581_ net310 _08614_ VSS VSS VDD VDD _08697_ sky130_fd_sc_hd__nand2_1
X_12582_ state\[1\] _08697_ VSS VSS VDD VDD _08698_ sky130_fd_sc_hd__nand2_1
X_12583_ net23 _08698_ VSS VSS VDD VDD _08699_ sky130_fd_sc_hd__nand2b_1
X_12584_ state\[1\] state\[0\] net23 VSS VSS VDD VDD icg_net.en
+ sky130_fd_sc_hd__or3_1
X_12585_ loaded\[8\] icg_net.en VSS VSS VDD VDD net44 sky130_fd_sc_hd__nor2_1
X_12586_ net22 net44 VSS VSS VDD VDD _08700_ sky130_fd_sc_hd__nand2_1
X_12587_ _08700_ VSS VSS VDD VDD icg_load.en sky130_fd_sc_hd__inv_1
X_12588_ state\[1\] icg_load.en VSS VSS VDD VDD _08701_ sky130_fd_sc_hd__nor2_1
X_12589_ _08615_ _08593_ _08602_ _08613_ _08701_ VSS VSS VDD
+ VDD _08702_ sky130_fd_sc_hd__a41oi_2
X_12590_ loaded\[0\] loaded\[1\] _08702_ VSS VSS VDD VDD _08703_
+ sky130_fd_sc_hd__and3_1
X_12591_ loaded\[2\] loaded\[3\] VSS VSS VDD VDD _08704_ sky130_fd_sc_hd__and2_2
X_12592_ loaded\[4\] loaded\[5\] _08704_ VSS VSS VDD VDD _08705_
+ sky130_fd_sc_hd__and3_1
X_12593_ net413 _08703_ _08705_ VSS VSS VDD VDD _08706_ sky130_fd_sc_hd__nand3_1
X_12594_ loaded\[7\] _08706_ VSS VSS VDD VDD _08707_ sky130_fd_sc_hd__xor2_1
X_12595_ _08699_ _08707_ VSS VSS VDD VDD _01565_ sky130_fd_sc_hd__nor2_1
X_12596_ loaded\[2\] loaded\[3\] _00196_ VSS VSS VDD VDD _08708_
+ sky130_fd_sc_hd__and3_1
X_12597_ loaded\[4\] loaded\[5\] _08702_ _08708_ VSS VSS VDD
+ VDD _08709_ sky130_fd_sc_hd__nand4_1
X_12598_ net413 _08709_ VSS VSS VDD VDD _08710_ sky130_fd_sc_hd__xor2_1
X_12599_ _08699_ _08710_ VSS VSS VDD VDD _01566_ sky130_fd_sc_hd__nor2_1
X_12600_ loaded\[4\] _08703_ _08704_ VSS VSS VDD VDD _08711_
+ sky130_fd_sc_hd__nand3_1
X_12601_ loaded\[5\] _08711_ VSS VSS VDD VDD _08712_ sky130_fd_sc_hd__xor2_1
X_12602_ _08699_ _08712_ VSS VSS VDD VDD _01567_ sky130_fd_sc_hd__nor2_1
X_12603_ _08702_ _08708_ VSS VSS VDD VDD _08713_ sky130_fd_sc_hd__nand2_1
X_12604_ loaded\[4\] _08713_ VSS VSS VDD VDD _08714_ sky130_fd_sc_hd__xor2_1
X_12605_ _08699_ _08714_ VSS VSS VDD VDD _01568_ sky130_fd_sc_hd__nor2_1
X_12606_ loaded\[2\] _08703_ VSS VSS VDD VDD _08715_ sky130_fd_sc_hd__nand2_1
X_12607_ loaded\[3\] _08715_ VSS VSS VDD VDD _08716_ sky130_fd_sc_hd__xor2_1
X_12608_ _08699_ _08716_ VSS VSS VDD VDD _01569_ sky130_fd_sc_hd__nor2_1
X_12609_ _00196_ _08702_ VSS VSS VDD VDD _08717_ sky130_fd_sc_hd__nand2_1
X_12610_ loaded\[2\] _08717_ VSS VSS VDD VDD _08718_ sky130_fd_sc_hd__xor2_1
X_12611_ _08699_ _08718_ VSS VSS VDD VDD _01570_ sky130_fd_sc_hd__nor2_1
X_12612_ state\[1\] state\[0\] VSS VSS VDD VDD _08719_ sky130_fd_sc_hd__nor2_1
X_12613_ loaded\[1\] VSS VSS VDD VDD _00191_ sky130_fd_sc_hd__inv_1
X_12614_ _00191_ _08702_ VSS VSS VDD VDD _08720_ sky130_fd_sc_hd__nor2_1
X_12615_ _00193_ _08719_ _08702_ _08720_ VSS VSS VDD VDD _08721_
+ sky130_fd_sc_hd__a31oi_1
X_12616_ net447 _08721_ VSS VSS VDD VDD _01571_ sky130_fd_sc_hd__nor2_1
X_12617_ state\[1\] state\[0\] loaded\[0\] VSS VSS VDD VDD
+ _08722_ sky130_fd_sc_hd__nor3_1
X_12618_ _00190_ _08702_ VSS VSS VDD VDD _08723_ sky130_fd_sc_hd__nor2_1
X_12619_ _08702_ _08722_ _08723_ VSS VSS VDD VDD _08724_ sky130_fd_sc_hd__a21oi_1
X_12620_ net447 _08724_ VSS VSS VDD VDD _01572_ sky130_fd_sc_hd__nor2_1
X_12621_ _08637_ net448 VSS VSS VDD VDD _01573_ sky130_fd_sc_hd__nor2_1
X_12622_ network.cnt_main.counter\[3\] network.cnt_main.counter\[4\]
+ network.cnt_main.counter\[5\] network.cnt_main.counter\[2\]
+ VSS VSS VDD VDD _08725_ sky130_fd_sc_hd__nor4_1
X_12623_ network.cnt_main.counter\[8\] network.cnt_main.counter\[9\]
+ network.cnt_main.counter\[7\] network.cnt_main.counter\[6\]
+ VSS VSS VDD VDD _08726_ sky130_fd_sc_hd__nor4_1
X_12624_ _00635_ _08725_ _08726_ VSS VSS VDD VDD _08727_ sky130_fd_sc_hd__nand3_1
X_12625_ network.cnt_main.counter\[11\] network.cnt_main.counter\[10\]
+ network.cnt_main.counter\[12\] VSS VSS VDD VDD _08728_ sky130_fd_sc_hd__or3_1
X_12626_ network.cnt_main.counter\[13\] _08727_ _08728_ VSS
+ VSS VDD VDD _08729_ sky130_fd_sc_hd__or3_2
Xclkbuf_leaf_12_clk_net clknet_4_2_0_clk_net VSS VSS VDD VDD
+ clknet_leaf_12_clk_net sky130_fd_sc_hd__clkbuf_16
Xclkbuf_leaf_11_clk_net clknet_4_2_0_clk_net VSS VSS VDD VDD
+ clknet_leaf_11_clk_net sky130_fd_sc_hd__clkbuf_16
X_12629_ _08611_ _08729_ VSS VSS VDD VDD _08732_ sky130_fd_sc_hd__nor2_1
X_12630_ network.arbit.counter\[2\] _08732_ VSS VSS VDD VDD
+ _08733_ sky130_fd_sc_hd__xnor2_1
X_12631_ net389 _08733_ VSS VSS VDD VDD _01574_ sky130_fd_sc_hd__nand2_1
Xclkbuf_leaf_10_clk_net clknet_4_2_0_clk_net VSS VSS VDD VDD
+ clknet_leaf_10_clk_net sky130_fd_sc_hd__clkbuf_16
Xclkbuf_leaf_9_clk_net clknet_4_2_0_clk_net VSS VSS VDD VDD
+ clknet_leaf_9_clk_net sky130_fd_sc_hd__clkbuf_16
X_12634_ _00118_ _08729_ VSS VSS VDD VDD _08736_ sky130_fd_sc_hd__nor2_1
X_12635_ network.arbit.counter\[1\] _08729_ _08736_ VSS VSS
+ VDD VDD _08737_ sky130_fd_sc_hd__a21oi_1
X_12636_ _06645_ _08737_ VSS VSS VDD VDD _01575_ sky130_fd_sc_hd__nor2_1
X_12637_ _00115_ _08729_ VSS VSS VDD VDD _08738_ sky130_fd_sc_hd__xnor2_1
X_12638_ _06645_ _08738_ VSS VSS VDD VDD _01576_ sky130_fd_sc_hd__nor2_1
X_12639_ _00781_ network.neuron_out5.IF0.membrane_potential\[7\]
+ VSS VSS VDD VDD _08739_ sky130_fd_sc_hd__nor2_1
X_12640_ _00023_ _00128_ _00127_ VSS VSS VDD VDD _08740_ sky130_fd_sc_hd__a21o_1
X_12641_ _00165_ _08740_ _00164_ VSS VSS VDD VDD _08741_ sky130_fd_sc_hd__a21o_1
X_12642_ _00655_ _08741_ _00654_ VSS VSS VDD VDD _08742_ sky130_fd_sc_hd__a21o_1
X_12643_ _01068_ _08742_ _01067_ VSS VSS VDD VDD _08743_ sky130_fd_sc_hd__a21oi_1
X_12644_ _08743_ _00664_ VSS VSS VDD VDD _08744_ sky130_fd_sc_hd__nor2b_1
X_12645_ _00663_ _08744_ _00782_ VSS VSS VDD VDD _08745_ sky130_fd_sc_hd__o21ai_0
X_12646_ _06645_ _08592_ VSS VSS VDD VDD _08746_ sky130_fd_sc_hd__or2_2
Xclkbuf_leaf_8_clk_net clknet_4_2_0_clk_net VSS VSS VDD VDD
+ clknet_leaf_8_clk_net sky130_fd_sc_hd__clkbuf_16
X_12648_ _08739_ _08745_ _08746_ VSS VSS VDD VDD _01577_ sky130_fd_sc_hd__a21oi_1
X_12649_ _00024_ _00165_ _00164_ VSS VSS VDD VDD _08748_ sky130_fd_sc_hd__a21o_1
X_12650_ _00655_ _08748_ _00654_ VSS VSS VDD VDD _08749_ sky130_fd_sc_hd__a21o_1
X_12651_ _01068_ _08749_ _01067_ VSS VSS VDD VDD _08750_ sky130_fd_sc_hd__a21o_1
X_12652_ _00664_ _08750_ _00663_ VSS VSS VDD VDD _08751_ sky130_fd_sc_hd__a21oi_1
X_12653_ _00782_ _08751_ VSS VSS VDD VDD _08752_ sky130_fd_sc_hd__xor2_1
X_12654_ _08746_ _08752_ VSS VSS VDD VDD _01578_ sky130_fd_sc_hd__nor2_1
X_12655_ _00664_ _08743_ VSS VSS VDD VDD _08753_ sky130_fd_sc_hd__nor2b_1
X_12656_ _08746_ _08744_ _08753_ VSS VSS VDD VDD _01579_ sky130_fd_sc_hd__nor3_1
X_12657_ _01068_ _08749_ VSS VSS VDD VDD _08754_ sky130_fd_sc_hd__xnor2_1
X_12658_ _08746_ _08754_ VSS VSS VDD VDD _01580_ sky130_fd_sc_hd__nor2_1
X_12659_ _00655_ _08741_ VSS VSS VDD VDD _08755_ sky130_fd_sc_hd__xnor2_1
X_12660_ _08746_ _08755_ VSS VSS VDD VDD _01581_ sky130_fd_sc_hd__nor2_1
X_12661_ _00024_ _00165_ VSS VSS VDD VDD _08756_ sky130_fd_sc_hd__xnor2_1
X_12662_ _08746_ _08756_ VSS VSS VDD VDD _01582_ sky130_fd_sc_hd__nor2_1
X_12663_ _00025_ VSS VSS VDD VDD _08757_ sky130_fd_sc_hd__inv_1
X_12664_ _08757_ _08746_ VSS VSS VDD VDD _01583_ sky130_fd_sc_hd__nor2_1
X_12665_ _00110_ VSS VSS VDD VDD _08758_ sky130_fd_sc_hd__inv_1
X_12666_ _08758_ _08746_ VSS VSS VDD VDD _01584_ sky130_fd_sc_hd__nor2_1
X_12667_ _06645_ _08588_ VSS VSS VDD VDD _08759_ sky130_fd_sc_hd__or2_2
Xplace391 _06612_ VSS VSS VDD VDD net390 sky130_fd_sc_hd__buf_4
X_12669_ _00031_ _00682_ _00681_ VSS VSS VDD VDD _08761_ sky130_fd_sc_hd__a21o_1
X_12670_ _00177_ _08761_ _00176_ VSS VSS VDD VDD _08762_ sky130_fd_sc_hd__a21oi_1
X_12671_ _08762_ _00865_ VSS VSS VDD VDD _08763_ sky130_fd_sc_hd__nor2b_1
X_12672_ _00864_ _08763_ _00854_ VSS VSS VDD VDD _08764_ sky130_fd_sc_hd__o21ai_0
X_12673_ _00853_ _08764_ VSS VSS VDD VDD _08765_ sky130_fd_sc_hd__nand2b_1
X_12674_ network.neuron_out4.IF0.membrane_potential\[6\] network.neuron_out4.IF0.membrane_potential\[5\]
+ _08765_ net482 VSS VSS VDD VDD _08766_ sky130_fd_sc_hd__a31oi_1
X_12675_ _08759_ _08766_ VSS VSS VDD VDD _01585_ sky130_fd_sc_hd__nor2_1
X_12676_ _00032_ _00177_ _00176_ VSS VSS VDD VDD _08767_ sky130_fd_sc_hd__a21o_1
X_12677_ _00865_ _08767_ _00864_ VSS VSS VDD VDD _08768_ sky130_fd_sc_hd__a21oi_1
X_12678_ _08768_ _00854_ VSS VSS VDD VDD _08769_ sky130_fd_sc_hd__nor2b_1
X_12679_ _00853_ _08769_ network.neuron_out4.IF0.membrane_potential\[5\]
+ VSS VSS VDD VDD _08770_ sky130_fd_sc_hd__o21ai_0
X_12680_ network.neuron_out4.IF0.membrane_potential\[6\] _08770_
+ VSS VSS VDD VDD _08771_ sky130_fd_sc_hd__xor2_1
X_12681_ _08759_ _08771_ VSS VSS VDD VDD _01586_ sky130_fd_sc_hd__nor2_1
X_12682_ network.neuron_out4.IF0.membrane_potential\[5\] _08765_
+ VSS VSS VDD VDD _08772_ sky130_fd_sc_hd__xnor2_1
X_12683_ _08759_ _08772_ VSS VSS VDD VDD _01587_ sky130_fd_sc_hd__nor2_1
X_12684_ _00854_ _08768_ VSS VSS VDD VDD _08773_ sky130_fd_sc_hd__nor2b_1
X_12685_ _08759_ _08769_ _08773_ VSS VSS VDD VDD _01588_ sky130_fd_sc_hd__nor3_1
X_12686_ _00865_ _08762_ VSS VSS VDD VDD _08774_ sky130_fd_sc_hd__nor2b_1
X_12687_ _08759_ _08763_ _08774_ VSS VSS VDD VDD _01589_ sky130_fd_sc_hd__nor3_1
X_12688_ _00032_ _00177_ VSS VSS VDD VDD _08775_ sky130_fd_sc_hd__xnor2_1
X_12689_ _08759_ _08775_ VSS VSS VDD VDD _01590_ sky130_fd_sc_hd__nor2_1
X_12690_ _00033_ VSS VSS VDD VDD _08776_ sky130_fd_sc_hd__inv_1
X_12691_ _08776_ _08759_ VSS VSS VDD VDD _01591_ sky130_fd_sc_hd__nor2_1
X_12692_ _00647_ VSS VSS VDD VDD _08777_ sky130_fd_sc_hd__inv_1
X_12693_ _08777_ _08759_ VSS VSS VDD VDD _01592_ sky130_fd_sc_hd__nor2_1
X_12694_ _06645_ net297 VSS VSS VDD VDD _08778_ sky130_fd_sc_hd__or2_2
Xplace390 net390 VSS VSS VDD VDD net389 sky130_fd_sc_hd__buf_4
X_12696_ _00392_ _00018_ _00391_ VSS VSS VDD VDD _08780_ sky130_fd_sc_hd__a21o_1
X_12697_ _00941_ _08780_ _00940_ VSS VSS VDD VDD _08781_ sky130_fd_sc_hd__a21oi_1
X_12698_ _08781_ _01123_ VSS VSS VDD VDD _08782_ sky130_fd_sc_hd__nor2b_1
X_12699_ _01122_ _08782_ _01057_ VSS VSS VDD VDD _08783_ sky130_fd_sc_hd__o21ai_0
X_12700_ _01056_ _08783_ VSS VSS VDD VDD _08784_ sky130_fd_sc_hd__nand2b_1
X_12701_ network.neuron_out3.IF0.membrane_potential\[6\] network.neuron_out3.IF0.membrane_potential\[5\]
+ _08784_ net483 VSS VSS VDD VDD _08785_ sky130_fd_sc_hd__a31oi_1
X_12702_ _08778_ _08785_ VSS VSS VDD VDD _01593_ sky130_fd_sc_hd__nor2_1
X_12703_ _00941_ _00019_ _00940_ VSS VSS VDD VDD _08786_ sky130_fd_sc_hd__a21o_1
X_12704_ _01123_ _08786_ _01122_ VSS VSS VDD VDD _08787_ sky130_fd_sc_hd__a21oi_1
X_12705_ _08787_ _01057_ VSS VSS VDD VDD _08788_ sky130_fd_sc_hd__nor2b_1
X_12706_ _01056_ _08788_ network.neuron_out3.IF0.membrane_potential\[5\]
+ VSS VSS VDD VDD _08789_ sky130_fd_sc_hd__o21ai_0
X_12707_ network.neuron_out3.IF0.membrane_potential\[6\] _08789_
+ VSS VSS VDD VDD _08790_ sky130_fd_sc_hd__xor2_1
X_12708_ _08778_ _08790_ VSS VSS VDD VDD _01594_ sky130_fd_sc_hd__nor2_1
X_12709_ network.neuron_out3.IF0.membrane_potential\[5\] _08784_
+ VSS VSS VDD VDD _08791_ sky130_fd_sc_hd__xnor2_1
X_12710_ _08778_ _08791_ VSS VSS VDD VDD _01595_ sky130_fd_sc_hd__nor2_1
X_12711_ _01057_ _08787_ VSS VSS VDD VDD _08792_ sky130_fd_sc_hd__nor2b_1
X_12712_ _08778_ _08788_ _08792_ VSS VSS VDD VDD _01596_ sky130_fd_sc_hd__nor3_1
X_12713_ _01123_ _08781_ VSS VSS VDD VDD _08793_ sky130_fd_sc_hd__nor2b_1
X_12714_ _08778_ _08782_ _08793_ VSS VSS VDD VDD _01597_ sky130_fd_sc_hd__nor3_1
X_12715_ _00941_ _00019_ VSS VSS VDD VDD _08794_ sky130_fd_sc_hd__xnor2_1
X_12716_ _08778_ _08794_ VSS VSS VDD VDD _01598_ sky130_fd_sc_hd__nor2_1
X_12717_ _00020_ VSS VSS VDD VDD _08795_ sky130_fd_sc_hd__inv_1
X_12718_ _08795_ _08778_ VSS VSS VDD VDD _01599_ sky130_fd_sc_hd__nor2_1
X_12719_ _00147_ VSS VSS VDD VDD _08796_ sky130_fd_sc_hd__inv_1
X_12720_ _08796_ _08778_ VSS VSS VDD VDD _01600_ sky130_fd_sc_hd__nor2_1
X_12721_ _06645_ _08606_ VSS VSS VDD VDD _08797_ sky130_fd_sc_hd__or2_2
Xplace389 net390 VSS VSS VDD VDD net388 sky130_fd_sc_hd__buf_4
X_12723_ _00013_ _00624_ _00919_ VSS VSS VDD VDD _08799_ sky130_fd_sc_hd__a21o_1
X_12724_ _00181_ _08799_ _00180_ VSS VSS VDD VDD _08800_ sky130_fd_sc_hd__a21oi_1
X_12725_ _08800_ _01159_ VSS VSS VDD VDD _08801_ sky130_fd_sc_hd__nor2b_1
X_12726_ _01158_ _08801_ _00048_ VSS VSS VDD VDD _08802_ sky130_fd_sc_hd__o21ai_0
X_12727_ _00047_ _08802_ VSS VSS VDD VDD _08803_ sky130_fd_sc_hd__nand2b_1
X_12728_ network.neuron_out2.IF0.membrane_potential\[5\] network.neuron_out2.IF0.membrane_potential\[6\]
+ _08803_ net484 VSS VSS VDD VDD _08804_ sky130_fd_sc_hd__a31oi_1
X_12729_ _08797_ _08804_ VSS VSS VDD VDD _01601_ sky130_fd_sc_hd__nor2_1
X_12730_ _00014_ _00181_ _00180_ VSS VSS VDD VDD _08805_ sky130_fd_sc_hd__a21o_1
X_12731_ _01159_ _08805_ _01158_ VSS VSS VDD VDD _08806_ sky130_fd_sc_hd__a21oi_1
X_12732_ _08806_ _00048_ VSS VSS VDD VDD _08807_ sky130_fd_sc_hd__nor2b_1
X_12733_ _00047_ _08807_ network.neuron_out2.IF0.membrane_potential\[5\]
+ VSS VSS VDD VDD _08808_ sky130_fd_sc_hd__o21ai_0
X_12734_ network.neuron_out2.IF0.membrane_potential\[6\] _08808_
+ VSS VSS VDD VDD _08809_ sky130_fd_sc_hd__xor2_1
X_12735_ _08797_ _08809_ VSS VSS VDD VDD _01602_ sky130_fd_sc_hd__nor2_1
X_12736_ network.neuron_out2.IF0.membrane_potential\[5\] _08803_
+ VSS VSS VDD VDD _08810_ sky130_fd_sc_hd__xnor2_1
X_12737_ _08797_ _08810_ VSS VSS VDD VDD _01603_ sky130_fd_sc_hd__nor2_1
X_12738_ _00048_ _08806_ VSS VSS VDD VDD _08811_ sky130_fd_sc_hd__nor2b_1
X_12739_ _08797_ _08807_ _08811_ VSS VSS VDD VDD _01604_ sky130_fd_sc_hd__nor3_1
X_12740_ _01159_ _08800_ VSS VSS VDD VDD _08812_ sky130_fd_sc_hd__nor2b_1
X_12741_ _08797_ _08801_ _08812_ VSS VSS VDD VDD _01605_ sky130_fd_sc_hd__nor3_1
X_12742_ _00014_ _00181_ VSS VSS VDD VDD _08813_ sky130_fd_sc_hd__xnor2_1
X_12743_ _08797_ _08813_ VSS VSS VDD VDD _01606_ sky130_fd_sc_hd__nor2_1
X_12744_ _00015_ VSS VSS VDD VDD _08814_ sky130_fd_sc_hd__inv_1
X_12745_ _08814_ _08797_ VSS VSS VDD VDD _01607_ sky130_fd_sc_hd__nor2_1
X_12746_ _00658_ VSS VSS VDD VDD _08815_ sky130_fd_sc_hd__inv_1
X_12747_ _08815_ _08797_ VSS VSS VDD VDD _01608_ sky130_fd_sc_hd__nor2_1
X_12748_ _06645_ _08601_ VSS VSS VDD VDD _08816_ sky130_fd_sc_hd__or2_2
Xplace388 net388 VSS VSS VDD VDD net387 sky130_fd_sc_hd__buf_4
X_12750_ _00008_ _00171_ _00170_ VSS VSS VDD VDD _08818_ sky130_fd_sc_hd__a21o_1
X_12751_ _01055_ _08818_ _01054_ VSS VSS VDD VDD _08819_ sky130_fd_sc_hd__a21oi_1
X_12752_ _08819_ _00657_ VSS VSS VDD VDD _08820_ sky130_fd_sc_hd__nor2b_1
X_12753_ _00656_ _08820_ _00869_ VSS VSS VDD VDD _08821_ sky130_fd_sc_hd__o21ai_0
X_12754_ _00868_ _08821_ VSS VSS VDD VDD _08822_ sky130_fd_sc_hd__nand2b_1
X_12755_ network.neuron_out1.IF0.membrane_potential\[6\] network.neuron_out1.IF0.membrane_potential\[5\]
+ _08822_ network.neuron_out1.IF0.membrane_potential\[7\] VSS
+ VSS VDD VDD _08823_ sky130_fd_sc_hd__a31oi_1
X_12756_ _08816_ _08823_ VSS VSS VDD VDD _01609_ sky130_fd_sc_hd__nor2_1
X_12757_ _00009_ _01055_ _01054_ VSS VSS VDD VDD _08824_ sky130_fd_sc_hd__a21o_1
X_12758_ _00657_ _08824_ _00656_ VSS VSS VDD VDD _08825_ sky130_fd_sc_hd__a21oi_1
X_12759_ _08825_ _00869_ VSS VSS VDD VDD _08826_ sky130_fd_sc_hd__nor2b_1
X_12760_ _00868_ _08826_ network.neuron_out1.IF0.membrane_potential\[5\]
+ VSS VSS VDD VDD _08827_ sky130_fd_sc_hd__o21ai_0
X_12761_ network.neuron_out1.IF0.membrane_potential\[6\] _08827_
+ VSS VSS VDD VDD _08828_ sky130_fd_sc_hd__xor2_1
X_12762_ _08816_ _08828_ VSS VSS VDD VDD _01610_ sky130_fd_sc_hd__nor2_1
X_12763_ network.neuron_out1.IF0.membrane_potential\[5\] _08822_
+ VSS VSS VDD VDD _08829_ sky130_fd_sc_hd__xnor2_1
X_12764_ _08816_ _08829_ VSS VSS VDD VDD _01611_ sky130_fd_sc_hd__nor2_1
X_12765_ _00869_ _08825_ VSS VSS VDD VDD _08830_ sky130_fd_sc_hd__nor2b_1
X_12766_ _08816_ _08826_ _08830_ VSS VSS VDD VDD _01612_ sky130_fd_sc_hd__nor3_1
X_12767_ _00657_ _08819_ VSS VSS VDD VDD _08831_ sky130_fd_sc_hd__nor2b_1
X_12768_ _08816_ _08820_ _08831_ VSS VSS VDD VDD _01613_ sky130_fd_sc_hd__nor3_1
X_12769_ _00009_ _01055_ VSS VSS VDD VDD _08832_ sky130_fd_sc_hd__xnor2_1
X_12770_ _08816_ _08832_ VSS VSS VDD VDD _01614_ sky130_fd_sc_hd__nor2_1
X_12771_ _00010_ VSS VSS VDD VDD _08833_ sky130_fd_sc_hd__inv_1
X_12772_ _08833_ _08816_ VSS VSS VDD VDD _01615_ sky130_fd_sc_hd__nor2_1
X_12773_ _00744_ VSS VSS VDD VDD _08834_ sky130_fd_sc_hd__inv_1
X_12774_ _08834_ _08816_ VSS VSS VDD VDD _01616_ sky130_fd_sc_hd__nor2_1
X_12775_ net485 VSS VSS VDD VDD _08835_ sky130_fd_sc_hd__inv_1
X_12776_ _01137_ VSS VSS VDD VDD _08836_ sky130_fd_sc_hd__inv_1
X_12777_ _00028_ _01117_ _01226_ VSS VSS VDD VDD _08837_ sky130_fd_sc_hd__a21o_1
X_12778_ _01065_ _08837_ _01064_ VSS VSS VDD VDD _08838_ sky130_fd_sc_hd__a21oi_1
X_12779_ _08836_ _08838_ _01136_ VSS VSS VDD VDD _08839_ sky130_fd_sc_hd__o21bai_1
X_12780_ _00688_ _08839_ _00687_ VSS VSS VDD VDD _08840_ sky130_fd_sc_hd__a21oi_1
X_12781_ _08840_ _00867_ VSS VSS VDD VDD _08841_ sky130_fd_sc_hd__nor2b_1
X_12782_ _00866_ _08841_ network.neuron_out0.IF0.membrane_potential\[6\]
+ VSS VSS VDD VDD _08842_ sky130_fd_sc_hd__o21ai_0
X_12783_ _06645_ net298 VSS VSS VDD VDD _08843_ sky130_fd_sc_hd__or2_2
Xplace387 net387 VSS VSS VDD VDD net386 sky130_fd_sc_hd__buf_4
X_12785_ _08835_ _08842_ _08843_ VSS VSS VDD VDD _01617_ sky130_fd_sc_hd__a21oi_1
X_12786_ _01065_ _00029_ _01064_ VSS VSS VDD VDD _08845_ sky130_fd_sc_hd__a21oi_1
X_12787_ _08836_ _08845_ _01136_ VSS VSS VDD VDD _08846_ sky130_fd_sc_hd__o21bai_1
X_12788_ _00688_ _08846_ _00687_ VSS VSS VDD VDD _08847_ sky130_fd_sc_hd__a21o_1
X_12789_ _00867_ _08847_ _00866_ VSS VSS VDD VDD _08848_ sky130_fd_sc_hd__a21oi_1
X_12790_ network.neuron_out0.IF0.membrane_potential\[6\] _08848_
+ VSS VSS VDD VDD _08849_ sky130_fd_sc_hd__xor2_1
X_12791_ _08843_ _08849_ VSS VSS VDD VDD _01618_ sky130_fd_sc_hd__nor2_1
X_12792_ _00867_ _08840_ VSS VSS VDD VDD _08850_ sky130_fd_sc_hd__nor2b_1
X_12793_ _08843_ _08841_ _08850_ VSS VSS VDD VDD _01619_ sky130_fd_sc_hd__nor3_1
X_12794_ _00688_ _08846_ VSS VSS VDD VDD _08851_ sky130_fd_sc_hd__xnor2_1
X_12795_ _08843_ _08851_ VSS VSS VDD VDD _01620_ sky130_fd_sc_hd__nor2_1
X_12796_ _08836_ _08838_ VSS VSS VDD VDD _08852_ sky130_fd_sc_hd__xnor2_1
X_12797_ _08843_ _08852_ VSS VSS VDD VDD _01621_ sky130_fd_sc_hd__nor2_1
X_12798_ _01065_ _00029_ VSS VSS VDD VDD _08853_ sky130_fd_sc_hd__xnor2_1
X_12799_ _08843_ _08853_ VSS VSS VDD VDD _01622_ sky130_fd_sc_hd__nor2_1
X_12800_ _00030_ VSS VSS VDD VDD _08854_ sky130_fd_sc_hd__inv_1
X_12801_ _08854_ _08843_ VSS VSS VDD VDD _01623_ sky130_fd_sc_hd__nor2_1
X_12802_ _01025_ VSS VSS VDD VDD _08855_ sky130_fd_sc_hd__inv_1
X_12803_ _08855_ _08843_ VSS VSS VDD VDD _01624_ sky130_fd_sc_hd__nor2_1
X_12804_ network.hid_spk7 network.hid_spk6 network.hid_spk5
+ network.hid_spk4 VSS VSS VDD VDD _08856_ sky130_fd_sc_hd__nor4_1
X_12805_ network.hid_spk3 network.hid_spk2 VSS VSS VDD VDD
+ _08857_ sky130_fd_sc_hd__nor2_1
X_12806_ network.hid_spk1 network.hid_spk0 VSS VSS VDD VDD
+ _08858_ sky130_fd_sc_hd__nor2_1
X_12807_ _08857_ _08858_ VSS VSS VDD VDD _08859_ sky130_fd_sc_hd__nand2_1
X_12808_ _06645_ _08856_ _08859_ VSS VSS VDD VDD _01940_ sky130_fd_sc_hd__nor3_1
Xplace386 net386 VSS VSS VDD VDD net385 sky130_fd_sc_hd__buf_4
Xplace385 net387 VSS VSS VDD VDD net384 sky130_fd_sc_hd__buf_4
X_12811_ network.hid_spk3 network.hid_spk2 network.hid_spk1
+ VSS VSS VDD VDD _08862_ sky130_fd_sc_hd__nor3_1
X_12812_ network.hid_spk0 _06645_ _08862_ VSS VSS VDD VDD
+ _08863_ sky130_fd_sc_hd__nor3_1
X_12813_ _01940_ _08863_ VSS VSS VDD VDD _08864_ sky130_fd_sc_hd__nor2_1
X_12814_ network.hid_spk5 network.hid_spk4 _08859_ VSS VSS
+ VDD VDD _08865_ sky130_fd_sc_hd__or3_1
X_12815_ network.hid_spk7 network.hid_spk6 VSS VSS VDD VDD
+ _08866_ sky130_fd_sc_hd__nor2_1
X_12816_ network.hid_spk1 network.hid_spk0 _08857_ _08865_
+ _08866_ VSS VSS VDD VDD _08867_ sky130_fd_sc_hd__o32a_1
X_12817_ _08864_ _08867_ VSS VSS VDD VDD _01625_ sky130_fd_sc_hd__nor2_1
X_12818_ network.hid_spk6 _08865_ VSS VSS VDD VDD _08868_
+ sky130_fd_sc_hd__nor2_1
X_12819_ network.hid_spk4 VSS VSS VDD VDD _08869_ sky130_fd_sc_hd__inv_1
X_12820_ network.hid_spk5 _08869_ network.hid_spk3 VSS VSS
+ VDD VDD _08870_ sky130_fd_sc_hd__a21oi_1
X_12821_ network.hid_spk2 _08870_ VSS VSS VDD VDD _08871_
+ sky130_fd_sc_hd__nor2_1
X_12822_ network.hid_spk1 _08871_ VSS VSS VDD VDD _08872_
+ sky130_fd_sc_hd__nor2_1
X_12823_ network.hid_spk0 _08872_ VSS VSS VDD VDD _08873_
+ sky130_fd_sc_hd__nor2_1
X_12824_ network.hid_spk7 _08868_ _08873_ VSS VSS VDD VDD
+ _08874_ sky130_fd_sc_hd__a21oi_1
X_12825_ _08864_ _08874_ VSS VSS VDD VDD _01626_ sky130_fd_sc_hd__nor2_1
X_12826_ network.neuron_hid7.IF0.membrane_potential\[4\] network.neuron_hid7.IF0.membrane_potential\[2\]
+ network.neuron_hid7.IF0.membrane_potential\[3\] network.neuron_hid7.IF0.membrane_potential\[5\]
+ VSS VSS VDD VDD _08875_ sky130_fd_sc_hd__or4_1
X_12827_ network.neuron_hid7.IF0.membrane_potential\[0\] network.neuron_hid7.IF0.membrane_potential\[1\]
+ _08875_ network.neuron_hid7.IF0.membrane_potential\[6\] VSS
+ VSS VDD VDD _08876_ sky130_fd_sc_hd__o31a_1
X_12828_ network.neuron_hid7.IF0.membrane_potential\[7\] _08876_
+ network.neuron_hid7.IF0.membrane_potential\[8\] VSS VSS VDD
+ VDD _08877_ sky130_fd_sc_hd__o21a_1
X_12829_ network.neuron_hid7.IF0.membrane_potential\[9\] network.neuron_hid7.IF0.membrane_potential\[10\]
+ _08877_ _01126_ VSS VSS VDD VDD _08878_ sky130_fd_sc_hd__o31ai_1
X_12830_ net389 _08878_ VSS VSS VDD VDD _08879_ sky130_fd_sc_hd__nand2_1
Xplace384 net387 VSS VSS VDD VDD net383 sky130_fd_sc_hd__buf_4
X_12832_ _01126_ _08729_ VSS VSS VDD VDD _08881_ sky130_fd_sc_hd__nor2_1
X_12833_ network.neuron_hid7.IF0.ref_counter\[0\] _08881_
+ VSS VSS VDD VDD _08882_ sky130_fd_sc_hd__xnor2_1
X_12834_ _08879_ _08882_ VSS VSS VDD VDD _01627_ sky130_fd_sc_hd__nor2_1
X_12835_ _00694_ VSS VSS VDD VDD _08883_ sky130_fd_sc_hd__inv_1
X_12836_ _00774_ VSS VSS VDD VDD _08884_ sky130_fd_sc_hd__inv_1
X_12837_ _00006_ _00508_ _00882_ VSS VSS VDD VDD _08885_ sky130_fd_sc_hd__a21o_1
X_12838_ _00130_ _08885_ _00129_ VSS VSS VDD VDD _08886_ sky130_fd_sc_hd__a21oi_1
X_12839_ _08884_ _08886_ _00773_ VSS VSS VDD VDD _08887_ sky130_fd_sc_hd__o21bai_1
X_12840_ _01043_ _08887_ _01042_ VSS VSS VDD VDD _08888_ sky130_fd_sc_hd__a21oi_1
X_12841_ _08883_ _08888_ _00693_ VSS VSS VDD VDD _08889_ sky130_fd_sc_hd__o21bai_1
X_12842_ network.neuron_hid7.IF0.membrane_potential\[8\] _00179_
+ _01130_ VSS VSS VDD VDD _08890_ sky130_fd_sc_hd__nand3_1
X_12843_ _00178_ network.neuron_hid7.IF0.membrane_potential\[8\]
+ VSS VSS VDD VDD _08891_ sky130_fd_sc_hd__nand2_1
X_12844_ _08890_ _08891_ VSS VSS VDD VDD _08892_ sky130_fd_sc_hd__nand2_1
X_12845_ network.neuron_hid7.IF0.membrane_potential\[8\] _00179_
+ _01131_ _08889_ _08892_ VSS VSS VDD VDD _08893_ sky130_fd_sc_hd__a41oi_1
X_12846_ network.neuron_hid7.IF0.membrane_potential\[9\] _08893_
+ VSS VSS VDD VDD _08894_ sky130_fd_sc_hd__xor2_1
X_12847_ _08879_ _08894_ VSS VSS VDD VDD _01628_ sky130_fd_sc_hd__nor2_1
X_12848_ _01043_ VSS VSS VDD VDD _08895_ sky130_fd_sc_hd__inv_1
X_12849_ _00130_ _00007_ _00129_ VSS VSS VDD VDD _08896_ sky130_fd_sc_hd__a21o_1
X_12850_ _00774_ _08896_ _00773_ VSS VSS VDD VDD _08897_ sky130_fd_sc_hd__a21oi_1
X_12851_ _08895_ _08897_ _01042_ VSS VSS VDD VDD _08898_ sky130_fd_sc_hd__o21bai_1
X_12852_ _00694_ _08898_ _00693_ VSS VSS VDD VDD _08899_ sky130_fd_sc_hd__a21oi_1
X_12853_ _00179_ _01131_ VSS VSS VDD VDD _08900_ sky130_fd_sc_hd__nand2_1
X_12854_ _00179_ _01130_ _00178_ VSS VSS VDD VDD _08901_ sky130_fd_sc_hd__a21oi_1
X_12855_ _08899_ _08900_ _08901_ VSS VSS VDD VDD _08902_ sky130_fd_sc_hd__o21ai_0
X_12856_ network.neuron_hid7.IF0.membrane_potential\[8\] _08902_
+ VSS VSS VDD VDD _08903_ sky130_fd_sc_hd__xnor2_1
X_12857_ _08879_ _08903_ VSS VSS VDD VDD _01629_ sky130_fd_sc_hd__nor2_1
X_12858_ _01131_ _08889_ _01130_ VSS VSS VDD VDD _08904_ sky130_fd_sc_hd__a21oi_1
X_12859_ _00179_ _08904_ VSS VSS VDD VDD _08905_ sky130_fd_sc_hd__xor2_1
X_12860_ _08879_ _08905_ VSS VSS VDD VDD _01630_ sky130_fd_sc_hd__nor2_1
X_12861_ _01131_ _08899_ VSS VSS VDD VDD _08906_ sky130_fd_sc_hd__xor2_1
X_12862_ _08879_ _08906_ VSS VSS VDD VDD _01631_ sky130_fd_sc_hd__nor2_1
X_12863_ _08883_ _08888_ VSS VSS VDD VDD _08907_ sky130_fd_sc_hd__xnor2_1
X_12864_ _08879_ _08907_ VSS VSS VDD VDD _01632_ sky130_fd_sc_hd__nor2_1
X_12865_ _08895_ _08897_ VSS VSS VDD VDD _08908_ sky130_fd_sc_hd__xnor2_1
X_12866_ _08879_ _08908_ VSS VSS VDD VDD _01633_ sky130_fd_sc_hd__nor2_1
X_12867_ _08884_ _08886_ VSS VSS VDD VDD _08909_ sky130_fd_sc_hd__xnor2_1
X_12868_ _08879_ _08909_ VSS VSS VDD VDD _01634_ sky130_fd_sc_hd__nor2_1
X_12869_ _00130_ _00007_ VSS VSS VDD VDD _08910_ sky130_fd_sc_hd__xnor2_1
X_12870_ _08879_ _08910_ VSS VSS VDD VDD _01635_ sky130_fd_sc_hd__nor2_1
Xplace383 net383 VSS VSS VDD VDD net382 sky130_fd_sc_hd__buf_4
X_12872_ network.neuron_hid7.IF0.add_out\[1\] net389 _08878_
+ VSS VSS VDD VDD _01636_ sky130_fd_sc_hd__and3_1
Xplace382 net388 VSS VSS VDD VDD net381 sky130_fd_sc_hd__buf_4
X_12874_ network.neuron_hid7.IF0.add_out\[0\] net389 _08878_
+ VSS VSS VDD VDD _01637_ sky130_fd_sc_hd__and3_1
X_12875_ network.neuron_hid6.IF0.membrane_potential\[5\] network.neuron_hid6.IF0.membrane_potential\[3\]
+ network.neuron_hid6.IF0.membrane_potential\[1\] network.neuron_hid6.IF0.membrane_potential\[0\]
+ VSS VSS VDD VDD _08913_ sky130_fd_sc_hd__or4_1
X_12876_ network.neuron_hid6.IF0.membrane_potential\[2\] network.neuron_hid6.IF0.membrane_potential\[4\]
+ _08913_ network.neuron_hid6.IF0.membrane_potential\[6\] VSS
+ VSS VDD VDD _08914_ sky130_fd_sc_hd__o31a_1
X_12877_ network.neuron_hid6.IF0.membrane_potential\[7\] _08914_
+ network.neuron_hid6.IF0.membrane_potential\[8\] VSS VSS VDD
+ VDD _08915_ sky130_fd_sc_hd__o21a_1
X_12878_ network.neuron_hid6.IF0.membrane_potential\[10\]
+ network.neuron_hid6.IF0.membrane_potential\[9\] _08915_ _00734_
+ VSS VSS VDD VDD _08916_ sky130_fd_sc_hd__o31ai_1
X_12879_ net389 _08916_ VSS VSS VDD VDD _08917_ sky130_fd_sc_hd__nand2_1
Xplace365 _06645_ VSS VSS VDD VDD net364 sky130_fd_sc_hd__buf_4
X_12881_ _00734_ _08729_ VSS VSS VDD VDD _08919_ sky130_fd_sc_hd__nor2_1
X_12882_ network.neuron_hid6.IF0.ref_counter\[0\] _08919_
+ VSS VSS VDD VDD _08920_ sky130_fd_sc_hd__xnor2_1
X_12883_ _08917_ _08920_ VSS VSS VDD VDD _01638_ sky130_fd_sc_hd__nor2_1
X_12884_ _00002_ _00085_ _00859_ VSS VSS VDD VDD _08921_ sky130_fd_sc_hd__a21o_1
X_12885_ _01070_ _08921_ _01069_ VSS VSS VDD VDD _08922_ sky130_fd_sc_hd__a21o_1
X_12886_ _00390_ _08922_ _00389_ VSS VSS VDD VDD _08923_ sky130_fd_sc_hd__a21o_1
X_12887_ _00856_ _08923_ _00855_ VSS VSS VDD VDD _08924_ sky130_fd_sc_hd__a21oi_1
X_12888_ network.neuron_hid6.IF0.membrane_potential\[5\] network.neuron_hid6.IF0.membrane_potential\[7\]
+ network.neuron_hid6.IF0.membrane_potential\[6\] network.neuron_hid6.IF0.membrane_potential\[8\]
+ VSS VSS VDD VDD _08925_ sky130_fd_sc_hd__nand4_1
X_12889_ _08924_ _08925_ network.neuron_hid6.IF0.membrane_potential\[9\]
+ VSS VSS VDD VDD _08926_ sky130_fd_sc_hd__o21ai_0
X_12890_ network.neuron_hid6.IF0.membrane_potential\[9\] _08924_
+ _08925_ VSS VSS VDD VDD _08927_ sky130_fd_sc_hd__or3_1
X_12891_ _08926_ _08927_ _08917_ VSS VSS VDD VDD _01639_ sky130_fd_sc_hd__a21oi_1
X_12892_ _01070_ _00003_ _01069_ VSS VSS VDD VDD _08928_ sky130_fd_sc_hd__a21o_1
X_12893_ _00390_ _08928_ _00389_ VSS VSS VDD VDD _08929_ sky130_fd_sc_hd__a21oi_1
X_12894_ _08929_ VSS VSS VDD VDD _08930_ sky130_fd_sc_hd__inv_1
X_12895_ _00856_ _08930_ _00855_ VSS VSS VDD VDD _08931_ sky130_fd_sc_hd__a21oi_1
X_12896_ network.neuron_hid6.IF0.membrane_potential\[5\] network.neuron_hid6.IF0.membrane_potential\[6\]
+ VSS VSS VDD VDD _08932_ sky130_fd_sc_hd__nand2_1
X_12897_ _08931_ _08932_ network.neuron_hid6.IF0.membrane_potential\[7\]
+ VSS VSS VDD VDD _08933_ sky130_fd_sc_hd__nor3b_1
X_12898_ network.neuron_hid6.IF0.membrane_potential\[8\] _08933_
+ VSS VSS VDD VDD _08934_ sky130_fd_sc_hd__xnor2_1
X_12899_ _08917_ _08934_ VSS VSS VDD VDD _01640_ sky130_fd_sc_hd__nor2_1
X_12900_ _08924_ _08932_ network.neuron_hid6.IF0.membrane_potential\[7\]
+ VSS VSS VDD VDD _08935_ sky130_fd_sc_hd__o21ai_0
X_12901_ network.neuron_hid6.IF0.membrane_potential\[7\] _08924_
+ _08932_ VSS VSS VDD VDD _08936_ sky130_fd_sc_hd__or3_1
X_12902_ _08935_ _08936_ _08917_ VSS VSS VDD VDD _01641_ sky130_fd_sc_hd__a21oi_1
X_12903_ _08931_ network.neuron_hid6.IF0.membrane_potential\[5\]
+ VSS VSS VDD VDD _08937_ sky130_fd_sc_hd__nor2b_1
X_12904_ network.neuron_hid6.IF0.membrane_potential\[6\] _08937_
+ VSS VSS VDD VDD _08938_ sky130_fd_sc_hd__xnor2_1
X_12905_ _08917_ _08938_ VSS VSS VDD VDD _01642_ sky130_fd_sc_hd__nor2_1
X_12906_ network.neuron_hid6.IF0.membrane_potential\[5\] _08924_
+ VSS VSS VDD VDD _08939_ sky130_fd_sc_hd__xor2_1
X_12907_ _08917_ _08939_ VSS VSS VDD VDD _01643_ sky130_fd_sc_hd__nor2_1
X_12908_ _00856_ _08929_ VSS VSS VDD VDD _08940_ sky130_fd_sc_hd__xor2_1
X_12909_ _08917_ _08940_ VSS VSS VDD VDD _01644_ sky130_fd_sc_hd__nor2_1
X_12910_ _00390_ _08922_ VSS VSS VDD VDD _08941_ sky130_fd_sc_hd__xnor2_1
X_12911_ _08917_ _08941_ VSS VSS VDD VDD _01645_ sky130_fd_sc_hd__nor2_1
X_12912_ _01070_ _00003_ VSS VSS VDD VDD _08942_ sky130_fd_sc_hd__xnor2_1
X_12913_ _08917_ _08942_ VSS VSS VDD VDD _01646_ sky130_fd_sc_hd__nor2_1
X_12914_ network.neuron_hid6.IF0.add_out\[1\] net389 _08916_
+ VSS VSS VDD VDD _01647_ sky130_fd_sc_hd__and3_1
X_12915_ network.neuron_hid6.IF0.add_out\[0\] net389 _08916_
+ VSS VSS VDD VDD _01648_ sky130_fd_sc_hd__and3_1
X_12916_ network.neuron_hid5.IF0.membrane_potential\[5\] network.neuron_hid5.IF0.membrane_potential\[2\]
+ network.neuron_hid5.IF0.membrane_potential\[1\] network.neuron_hid5.IF0.membrane_potential\[0\]
+ VSS VSS VDD VDD _08943_ sky130_fd_sc_hd__or4_1
X_12917_ network.neuron_hid5.IF0.membrane_potential\[3\] network.neuron_hid5.IF0.membrane_potential\[4\]
+ _08943_ network.neuron_hid5.IF0.membrane_potential\[6\] VSS
+ VSS VDD VDD _08944_ sky130_fd_sc_hd__o31a_1
X_12918_ network.neuron_hid5.IF0.membrane_potential\[7\] _08944_
+ network.neuron_hid5.IF0.membrane_potential\[8\] VSS VSS VDD
+ VDD _08945_ sky130_fd_sc_hd__o21a_1
X_12919_ network.neuron_hid5.IF0.membrane_potential\[9\] network.neuron_hid5.IF0.membrane_potential\[10\]
+ _08945_ _00917_ VSS VSS VDD VDD _08946_ sky130_fd_sc_hd__o31ai_2
X_12920_ net389 _08946_ VSS VSS VDD VDD _08947_ sky130_fd_sc_hd__nand2_1
Xplace364 net364 VSS VSS VDD VDD net363 sky130_fd_sc_hd__buf_4
X_12922_ _00917_ _08729_ VSS VSS VDD VDD _08949_ sky130_fd_sc_hd__nor2_1
X_12923_ network.neuron_hid5.IF0.ref_counter\[0\] _08949_
+ VSS VSS VDD VDD _08950_ sky130_fd_sc_hd__xnor2_1
X_12924_ _08947_ _08950_ VSS VSS VDD VDD _01649_ sky130_fd_sc_hd__nor2_1
X_12925_ _00046_ _00000_ _01066_ VSS VSS VDD VDD _08951_ sky130_fd_sc_hd__a21o_1
X_12926_ _00146_ _08951_ _00145_ VSS VSS VDD VDD _08952_ sky130_fd_sc_hd__a21o_1
X_12927_ _00144_ _08952_ _00143_ VSS VSS VDD VDD _08953_ sky130_fd_sc_hd__a21o_1
X_12928_ _00646_ _08953_ _00645_ VSS VSS VDD VDD _08954_ sky130_fd_sc_hd__a21oi_1
X_12929_ network.neuron_hid5.IF0.membrane_potential\[7\] network.neuron_hid5.IF0.membrane_potential\[6\]
+ network.neuron_hid5.IF0.membrane_potential\[5\] network.neuron_hid5.IF0.membrane_potential\[8\]
+ VSS VSS VDD VDD _08955_ sky130_fd_sc_hd__nand4_1
X_12930_ _08954_ _08955_ network.neuron_hid5.IF0.membrane_potential\[9\]
+ VSS VSS VDD VDD _08956_ sky130_fd_sc_hd__o21ai_0
X_12931_ network.neuron_hid5.IF0.membrane_potential\[9\] _08954_
+ _08955_ VSS VSS VDD VDD _08957_ sky130_fd_sc_hd__or3_1
X_12932_ _08956_ _08957_ _08947_ VSS VSS VDD VDD _01650_ sky130_fd_sc_hd__a21oi_1
X_12933_ _00146_ _00001_ _00145_ VSS VSS VDD VDD _08958_ sky130_fd_sc_hd__a21o_1
X_12934_ _00144_ _08958_ _00143_ VSS VSS VDD VDD _08959_ sky130_fd_sc_hd__a21oi_1
X_12935_ _08959_ VSS VSS VDD VDD _08960_ sky130_fd_sc_hd__inv_1
X_12936_ _00646_ _08960_ _00645_ VSS VSS VDD VDD _08961_ sky130_fd_sc_hd__a21oi_1
X_12937_ network.neuron_hid5.IF0.membrane_potential\[6\] network.neuron_hid5.IF0.membrane_potential\[5\]
+ VSS VSS VDD VDD _08962_ sky130_fd_sc_hd__nand2_1
X_12938_ _08961_ _08962_ network.neuron_hid5.IF0.membrane_potential\[7\]
+ VSS VSS VDD VDD _08963_ sky130_fd_sc_hd__nor3b_1
X_12939_ network.neuron_hid5.IF0.membrane_potential\[8\] _08963_
+ VSS VSS VDD VDD _08964_ sky130_fd_sc_hd__xnor2_1
X_12940_ _08947_ _08964_ VSS VSS VDD VDD _01651_ sky130_fd_sc_hd__nor2_1
X_12941_ _08954_ _08962_ network.neuron_hid5.IF0.membrane_potential\[7\]
+ VSS VSS VDD VDD _08965_ sky130_fd_sc_hd__o21ai_0
X_12942_ network.neuron_hid5.IF0.membrane_potential\[7\] _08954_
+ _08962_ VSS VSS VDD VDD _08966_ sky130_fd_sc_hd__or3_1
X_12943_ _08965_ _08966_ _08947_ VSS VSS VDD VDD _01652_ sky130_fd_sc_hd__a21oi_1
X_12944_ _08961_ network.neuron_hid5.IF0.membrane_potential\[5\]
+ VSS VSS VDD VDD _08967_ sky130_fd_sc_hd__nor2b_1
X_12945_ network.neuron_hid5.IF0.membrane_potential\[6\] _08967_
+ VSS VSS VDD VDD _08968_ sky130_fd_sc_hd__xnor2_1
X_12946_ _08947_ _08968_ VSS VSS VDD VDD _01653_ sky130_fd_sc_hd__nor2_1
X_12947_ network.neuron_hid5.IF0.membrane_potential\[5\] _08954_
+ VSS VSS VDD VDD _08969_ sky130_fd_sc_hd__xor2_1
X_12948_ _08947_ _08969_ VSS VSS VDD VDD _01654_ sky130_fd_sc_hd__nor2_1
X_12949_ _00646_ _08959_ VSS VSS VDD VDD _08970_ sky130_fd_sc_hd__xor2_1
X_12950_ _08947_ _08970_ VSS VSS VDD VDD _01655_ sky130_fd_sc_hd__nor2_1
X_12951_ _00144_ _08952_ VSS VSS VDD VDD _08971_ sky130_fd_sc_hd__xnor2_1
X_12952_ _08947_ _08971_ VSS VSS VDD VDD _01656_ sky130_fd_sc_hd__nor2_1
X_12953_ _00146_ _00001_ VSS VSS VDD VDD _08972_ sky130_fd_sc_hd__xnor2_1
X_12954_ _08947_ _08972_ VSS VSS VDD VDD _01657_ sky130_fd_sc_hd__nor2_1
X_12955_ network.neuron_hid5.IF0.add_out\[1\] net389 _08946_
+ VSS VSS VDD VDD _01658_ sky130_fd_sc_hd__and3_1
X_12956_ network.neuron_hid5.IF0.add_out\[0\] net389 _08946_
+ VSS VSS VDD VDD _01659_ sky130_fd_sc_hd__and3_1
Xplace363 net363 VSS VSS VDD VDD net362 sky130_fd_sc_hd__buf_4
X_12958_ network.neuron_hid4.IF0.membrane_potential\[5\] network.neuron_hid4.IF0.membrane_potential\[0\]
+ network.neuron_hid4.IF0.membrane_potential\[3\] network.neuron_hid4.IF0.membrane_potential\[4\]
+ VSS VSS VDD VDD _08974_ sky130_fd_sc_hd__or4_1
X_12959_ network.neuron_hid4.IF0.membrane_potential\[1\] network.neuron_hid4.IF0.membrane_potential\[2\]
+ _08974_ network.neuron_hid4.IF0.membrane_potential\[6\] VSS
+ VSS VDD VDD _08975_ sky130_fd_sc_hd__o31a_1
X_12960_ network.neuron_hid4.IF0.membrane_potential\[7\] _08975_
+ network.neuron_hid4.IF0.membrane_potential\[8\] VSS VSS VDD
+ VDD _08976_ sky130_fd_sc_hd__o21a_1
X_12961_ network.neuron_hid4.IF0.membrane_potential\[9\] network.neuron_hid4.IF0.membrane_potential\[10\]
+ _08976_ _01134_ VSS VSS VDD VDD _08977_ sky130_fd_sc_hd__o31ai_1
X_12962_ net389 _08977_ VSS VSS VDD VDD _08978_ sky130_fd_sc_hd__nand2_1
Xplace362 net363 VSS VSS VDD VDD net361 sky130_fd_sc_hd__buf_4
X_12964_ _01134_ _08729_ VSS VSS VDD VDD _08980_ sky130_fd_sc_hd__nor2_1
X_12965_ network.neuron_hid4.IF0.ref_counter\[0\] _08980_
+ VSS VSS VDD VDD _08981_ sky130_fd_sc_hd__xnor2_1
X_12966_ _08978_ _08981_ VSS VSS VDD VDD _01660_ sky130_fd_sc_hd__nor2_1
X_12967_ _00016_ _00708_ _00731_ VSS VSS VDD VDD _08982_ sky130_fd_sc_hd__a21o_1
X_12968_ _00066_ _08982_ _00065_ VSS VSS VDD VDD _08983_ sky130_fd_sc_hd__a21o_1
X_12969_ _01169_ _08983_ _01168_ VSS VSS VDD VDD _08984_ sky130_fd_sc_hd__a21o_1
X_12970_ _00068_ _08984_ _00067_ VSS VSS VDD VDD _08985_ sky130_fd_sc_hd__a21oi_1
X_12971_ network.neuron_hid4.IF0.membrane_potential\[6\] network.neuron_hid4.IF0.membrane_potential\[7\]
+ network.neuron_hid4.IF0.membrane_potential\[5\] network.neuron_hid4.IF0.membrane_potential\[8\]
+ VSS VSS VDD VDD _08986_ sky130_fd_sc_hd__nand4_1
X_12972_ _08985_ _08986_ network.neuron_hid4.IF0.membrane_potential\[9\]
+ VSS VSS VDD VDD _08987_ sky130_fd_sc_hd__o21ai_0
X_12973_ network.neuron_hid4.IF0.membrane_potential\[9\] _08985_
+ _08986_ VSS VSS VDD VDD _08988_ sky130_fd_sc_hd__or3_1
X_12974_ _08987_ _08988_ _08978_ VSS VSS VDD VDD _01661_ sky130_fd_sc_hd__a21oi_1
X_12975_ _00017_ _00066_ _00065_ VSS VSS VDD VDD _08989_ sky130_fd_sc_hd__a21o_1
X_12976_ _01169_ _08989_ _01168_ VSS VSS VDD VDD _08990_ sky130_fd_sc_hd__a21oi_1
X_12977_ _08990_ VSS VSS VDD VDD _08991_ sky130_fd_sc_hd__inv_1
X_12978_ _00068_ _08991_ _00067_ VSS VSS VDD VDD _08992_ sky130_fd_sc_hd__a21oi_1
X_12979_ network.neuron_hid4.IF0.membrane_potential\[6\] network.neuron_hid4.IF0.membrane_potential\[5\]
+ VSS VSS VDD VDD _08993_ sky130_fd_sc_hd__nand2_1
X_12980_ _08992_ _08993_ network.neuron_hid4.IF0.membrane_potential\[7\]
+ VSS VSS VDD VDD _08994_ sky130_fd_sc_hd__nor3b_1
X_12981_ network.neuron_hid4.IF0.membrane_potential\[8\] _08994_
+ VSS VSS VDD VDD _08995_ sky130_fd_sc_hd__xnor2_1
X_12982_ _08978_ _08995_ VSS VSS VDD VDD _01662_ sky130_fd_sc_hd__nor2_1
X_12983_ _08985_ _08993_ network.neuron_hid4.IF0.membrane_potential\[7\]
+ VSS VSS VDD VDD _08996_ sky130_fd_sc_hd__o21ai_0
X_12984_ network.neuron_hid4.IF0.membrane_potential\[7\] _08985_
+ _08993_ VSS VSS VDD VDD _08997_ sky130_fd_sc_hd__or3_1
X_12985_ _08996_ _08997_ _08978_ VSS VSS VDD VDD _01663_ sky130_fd_sc_hd__a21oi_1
X_12986_ _08992_ network.neuron_hid4.IF0.membrane_potential\[5\]
+ VSS VSS VDD VDD _08998_ sky130_fd_sc_hd__nor2b_1
X_12987_ network.neuron_hid4.IF0.membrane_potential\[6\] _08998_
+ VSS VSS VDD VDD _08999_ sky130_fd_sc_hd__xnor2_1
X_12988_ _08978_ _08999_ VSS VSS VDD VDD _01664_ sky130_fd_sc_hd__nor2_1
X_12989_ network.neuron_hid4.IF0.membrane_potential\[5\] _08985_
+ VSS VSS VDD VDD _09000_ sky130_fd_sc_hd__xor2_1
X_12990_ _08978_ _09000_ VSS VSS VDD VDD _01665_ sky130_fd_sc_hd__nor2_1
X_12991_ _00068_ _08990_ VSS VSS VDD VDD _09001_ sky130_fd_sc_hd__xor2_1
X_12992_ _08978_ _09001_ VSS VSS VDD VDD _01666_ sky130_fd_sc_hd__nor2_1
X_12993_ _01169_ _08983_ VSS VSS VDD VDD _09002_ sky130_fd_sc_hd__xnor2_1
X_12994_ _08978_ _09002_ VSS VSS VDD VDD _01667_ sky130_fd_sc_hd__nor2_1
X_12995_ _00017_ _00066_ VSS VSS VDD VDD _09003_ sky130_fd_sc_hd__xnor2_1
X_12996_ _08978_ _09003_ VSS VSS VDD VDD _01668_ sky130_fd_sc_hd__nor2_1
X_12997_ network.neuron_hid4.IF0.add_out\[1\] net389 _08977_
+ VSS VSS VDD VDD _01669_ sky130_fd_sc_hd__and3_1
X_12998_ network.neuron_hid4.IF0.add_out\[0\] net389 _08977_
+ VSS VSS VDD VDD _01670_ sky130_fd_sc_hd__and3_1
X_12999_ network.neuron_hid3.IF0.membrane_potential\[4\] network.neuron_hid3.IF0.membrane_potential\[2\]
+ network.neuron_hid3.IF0.membrane_potential\[5\] network.neuron_hid3.IF0.membrane_potential\[3\]
+ VSS VSS VDD VDD _09004_ sky130_fd_sc_hd__or4_1
X_13000_ network.neuron_hid3.IF0.membrane_potential\[0\] network.neuron_hid3.IF0.membrane_potential\[1\]
+ _09004_ network.neuron_hid3.IF0.membrane_potential\[6\] VSS
+ VSS VDD VDD _09005_ sky130_fd_sc_hd__o31a_1
X_13001_ network.neuron_hid3.IF0.membrane_potential\[7\] _09005_
+ network.neuron_hid3.IF0.membrane_potential\[8\] VSS VSS VDD
+ VDD _09006_ sky130_fd_sc_hd__o21a_1
X_13002_ network.neuron_hid3.IF0.membrane_potential\[9\] network.neuron_hid3.IF0.membrane_potential\[10\]
+ _09006_ _00880_ VSS VSS VDD VDD _09007_ sky130_fd_sc_hd__o31ai_1
X_13003_ net389 _09007_ VSS VSS VDD VDD _09008_ sky130_fd_sc_hd__nand2_1
Xplace361 net361 VSS VSS VDD VDD net360 sky130_fd_sc_hd__buf_4
X_13005_ _00880_ _08729_ VSS VSS VDD VDD _09010_ sky130_fd_sc_hd__nor2_1
X_13006_ network.neuron_hid3.IF0.ref_counter\[0\] _09010_
+ VSS VSS VDD VDD _09011_ sky130_fd_sc_hd__xnor2_1
X_13007_ _09008_ _09011_ VSS VSS VDD VDD _01671_ sky130_fd_sc_hd__nor2_1
X_13008_ _00714_ VSS VSS VDD VDD _09012_ sky130_fd_sc_hd__inv_1
X_13009_ _01053_ VSS VSS VDD VDD _09013_ sky130_fd_sc_hd__inv_1
X_13010_ _00599_ _00011_ _01024_ VSS VSS VDD VDD _09014_ sky130_fd_sc_hd__a21o_1
X_13011_ _01129_ _09014_ _01128_ VSS VSS VDD VDD _09015_ sky130_fd_sc_hd__a21oi_1
X_13012_ _09013_ _09015_ _01052_ VSS VSS VDD VDD _09016_ sky130_fd_sc_hd__o21bai_1
X_13013_ _01063_ _09016_ _01062_ VSS VSS VDD VDD _09017_ sky130_fd_sc_hd__a21oi_1
X_13014_ _09012_ _09017_ _00713_ VSS VSS VDD VDD _09018_ sky130_fd_sc_hd__o21bai_1
X_13015_ network.neuron_hid3.IF0.membrane_potential\[8\] _00546_
+ _01022_ VSS VSS VDD VDD _09019_ sky130_fd_sc_hd__nand3_1
X_13016_ network.neuron_hid3.IF0.membrane_potential\[8\] _00545_
+ VSS VSS VDD VDD _09020_ sky130_fd_sc_hd__nand2_1
X_13017_ _09019_ _09020_ VSS VSS VDD VDD _09021_ sky130_fd_sc_hd__nand2_1
X_13018_ network.neuron_hid3.IF0.membrane_potential\[8\] _00546_
+ _01023_ _09018_ _09021_ VSS VSS VDD VDD _09022_ sky130_fd_sc_hd__a41oi_1
X_13019_ network.neuron_hid3.IF0.membrane_potential\[9\] _09022_
+ VSS VSS VDD VDD _09023_ sky130_fd_sc_hd__xor2_1
X_13020_ _09008_ _09023_ VSS VSS VDD VDD _01672_ sky130_fd_sc_hd__nor2_1
X_13021_ _01063_ VSS VSS VDD VDD _09024_ sky130_fd_sc_hd__inv_1
X_13022_ _00012_ _01129_ _01128_ VSS VSS VDD VDD _09025_ sky130_fd_sc_hd__a21o_1
X_13023_ _01053_ _09025_ _01052_ VSS VSS VDD VDD _09026_ sky130_fd_sc_hd__a21oi_1
X_13024_ _09024_ _09026_ _01062_ VSS VSS VDD VDD _09027_ sky130_fd_sc_hd__o21bai_1
X_13025_ _00714_ _09027_ _00713_ VSS VSS VDD VDD _09028_ sky130_fd_sc_hd__a21oi_1
X_13026_ _00546_ _01023_ VSS VSS VDD VDD _09029_ sky130_fd_sc_hd__nand2_1
X_13027_ _00546_ _01022_ _00545_ VSS VSS VDD VDD _09030_ sky130_fd_sc_hd__a21oi_1
X_13028_ _09028_ _09029_ _09030_ VSS VSS VDD VDD _09031_ sky130_fd_sc_hd__o21ai_0
X_13029_ network.neuron_hid3.IF0.membrane_potential\[8\] _09031_
+ VSS VSS VDD VDD _09032_ sky130_fd_sc_hd__xnor2_1
X_13030_ _09008_ _09032_ VSS VSS VDD VDD _01673_ sky130_fd_sc_hd__nor2_1
X_13031_ _01023_ _09018_ _01022_ VSS VSS VDD VDD _09033_ sky130_fd_sc_hd__a21oi_1
X_13032_ _00546_ _09033_ VSS VSS VDD VDD _09034_ sky130_fd_sc_hd__xor2_1
X_13033_ _09008_ _09034_ VSS VSS VDD VDD _01674_ sky130_fd_sc_hd__nor2_1
X_13034_ _01023_ _09028_ VSS VSS VDD VDD _09035_ sky130_fd_sc_hd__xor2_1
X_13035_ _09008_ _09035_ VSS VSS VDD VDD _01675_ sky130_fd_sc_hd__nor2_1
X_13036_ _09012_ _09017_ VSS VSS VDD VDD _09036_ sky130_fd_sc_hd__xnor2_1
X_13037_ _09008_ _09036_ VSS VSS VDD VDD _01676_ sky130_fd_sc_hd__nor2_1
X_13038_ _09024_ _09026_ VSS VSS VDD VDD _09037_ sky130_fd_sc_hd__xnor2_1
X_13039_ _09008_ _09037_ VSS VSS VDD VDD _01677_ sky130_fd_sc_hd__nor2_1
X_13040_ _09013_ _09015_ VSS VSS VDD VDD _09038_ sky130_fd_sc_hd__xnor2_1
X_13041_ _09008_ _09038_ VSS VSS VDD VDD _01678_ sky130_fd_sc_hd__nor2_1
X_13042_ _00012_ _01129_ VSS VSS VDD VDD _09039_ sky130_fd_sc_hd__xnor2_1
X_13043_ _09008_ _09039_ VSS VSS VDD VDD _01679_ sky130_fd_sc_hd__nor2_1
X_13044_ network.neuron_hid3.IF0.add_out\[1\] net389 _09007_
+ VSS VSS VDD VDD _01680_ sky130_fd_sc_hd__and3_1
X_13045_ network.neuron_hid3.IF0.add_out\[0\] net389 _09007_
+ VSS VSS VDD VDD _01681_ sky130_fd_sc_hd__and3_1
X_13046_ network.neuron_hid2.IF0.membrane_potential\[1\] network.neuron_hid2.IF0.membrane_potential\[3\]
+ network.neuron_hid2.IF0.membrane_potential\[4\] network.neuron_hid2.IF0.membrane_potential\[0\]
+ VSS VSS VDD VDD _09040_ sky130_fd_sc_hd__or4_1
X_13047_ network.neuron_hid2.IF0.membrane_potential\[2\] network.neuron_hid2.IF0.membrane_potential\[5\]
+ _09040_ network.neuron_hid2.IF0.membrane_potential\[6\] VSS
+ VSS VDD VDD _09041_ sky130_fd_sc_hd__o31a_1
X_13048_ network.neuron_hid2.IF0.membrane_potential\[7\] _09041_
+ network.neuron_hid2.IF0.membrane_potential\[8\] VSS VSS VDD
+ VDD _09042_ sky130_fd_sc_hd__o21a_1
X_13049_ network.neuron_hid2.IF0.membrane_potential\[9\] network.neuron_hid2.IF0.membrane_potential\[10\]
+ _09042_ _00785_ VSS VSS VDD VDD _09043_ sky130_fd_sc_hd__o31ai_1
X_13050_ net389 _09043_ VSS VSS VDD VDD _09044_ sky130_fd_sc_hd__nand2_1
Xplace360 net364 VSS VSS VDD VDD net359 sky130_fd_sc_hd__buf_4
X_13052_ _00785_ _08729_ VSS VSS VDD VDD _09046_ sky130_fd_sc_hd__nor2_1
X_13053_ network.neuron_hid2.IF0.ref_counter\[0\] _09046_
+ VSS VSS VDD VDD _09047_ sky130_fd_sc_hd__xnor2_1
X_13054_ _09044_ _09047_ VSS VSS VDD VDD _01682_ sky130_fd_sc_hd__nor2_1
X_13055_ _00780_ VSS VSS VDD VDD _09048_ sky130_fd_sc_hd__inv_1
X_13056_ _01244_ VSS VSS VDD VDD _09049_ sky130_fd_sc_hd__inv_1
X_13057_ _00712_ _00021_ _00711_ VSS VSS VDD VDD _09050_ sky130_fd_sc_hd__a21o_1
X_13058_ _01242_ _09050_ _01241_ VSS VSS VDD VDD _09051_ sky130_fd_sc_hd__a21oi_1
X_13059_ _09049_ _09051_ _01243_ VSS VSS VDD VDD _09052_ sky130_fd_sc_hd__o21bai_1
X_13060_ _01240_ _09052_ _01239_ VSS VSS VDD VDD _09053_ sky130_fd_sc_hd__a21oi_1
X_13061_ _09048_ _09053_ _00779_ VSS VSS VDD VDD _09054_ sky130_fd_sc_hd__o21bai_1
X_13062_ network.neuron_hid2.IF0.membrane_potential\[8\] _00709_
+ VSS VSS VDD VDD _09055_ sky130_fd_sc_hd__nand2_1
X_13063_ network.neuron_hid2.IF0.membrane_potential\[8\] _00710_
+ _01208_ VSS VSS VDD VDD _09056_ sky130_fd_sc_hd__nand3_1
X_13064_ _09055_ _09056_ VSS VSS VDD VDD _09057_ sky130_fd_sc_hd__nand2_1
X_13065_ network.neuron_hid2.IF0.membrane_potential\[8\] _00710_
+ _01209_ _09054_ _09057_ VSS VSS VDD VDD _09058_ sky130_fd_sc_hd__a41oi_1
X_13066_ network.neuron_hid2.IF0.membrane_potential\[9\] _09058_
+ VSS VSS VDD VDD _09059_ sky130_fd_sc_hd__xor2_1
X_13067_ _09044_ _09059_ VSS VSS VDD VDD _01683_ sky130_fd_sc_hd__nor2_1
X_13068_ _01240_ VSS VSS VDD VDD _09060_ sky130_fd_sc_hd__inv_1
X_13069_ _01242_ _00022_ _01241_ VSS VSS VDD VDD _09061_ sky130_fd_sc_hd__a21o_1
X_13070_ _01244_ _09061_ _01243_ VSS VSS VDD VDD _09062_ sky130_fd_sc_hd__a21oi_1
X_13071_ _09060_ _09062_ _01239_ VSS VSS VDD VDD _09063_ sky130_fd_sc_hd__o21bai_1
X_13072_ _00780_ _09063_ _00779_ VSS VSS VDD VDD _09064_ sky130_fd_sc_hd__a21oi_1
X_13073_ _00710_ _01209_ VSS VSS VDD VDD _09065_ sky130_fd_sc_hd__nand2_1
X_13074_ _00710_ _01208_ _00709_ VSS VSS VDD VDD _09066_ sky130_fd_sc_hd__a21oi_1
X_13075_ _09064_ _09065_ _09066_ VSS VSS VDD VDD _09067_ sky130_fd_sc_hd__o21ai_0
X_13076_ network.neuron_hid2.IF0.membrane_potential\[8\] _09067_
+ VSS VSS VDD VDD _09068_ sky130_fd_sc_hd__xnor2_1
X_13077_ _09044_ _09068_ VSS VSS VDD VDD _01684_ sky130_fd_sc_hd__nor2_1
X_13078_ _01209_ _09054_ _01208_ VSS VSS VDD VDD _09069_ sky130_fd_sc_hd__a21oi_1
X_13079_ _00710_ _09069_ VSS VSS VDD VDD _09070_ sky130_fd_sc_hd__xor2_1
X_13080_ _09044_ _09070_ VSS VSS VDD VDD _01685_ sky130_fd_sc_hd__nor2_1
X_13081_ _01209_ _09064_ VSS VSS VDD VDD _09071_ sky130_fd_sc_hd__xor2_1
X_13082_ _09044_ _09071_ VSS VSS VDD VDD _01686_ sky130_fd_sc_hd__nor2_1
X_13083_ _09048_ _09053_ VSS VSS VDD VDD _09072_ sky130_fd_sc_hd__xnor2_1
X_13084_ _09044_ _09072_ VSS VSS VDD VDD _01687_ sky130_fd_sc_hd__nor2_1
X_13085_ _09060_ _09062_ VSS VSS VDD VDD _09073_ sky130_fd_sc_hd__xnor2_1
X_13086_ _09044_ _09073_ VSS VSS VDD VDD _01688_ sky130_fd_sc_hd__nor2_1
X_13087_ _09049_ _09051_ VSS VSS VDD VDD _09074_ sky130_fd_sc_hd__xnor2_1
X_13088_ _09044_ _09074_ VSS VSS VDD VDD _01689_ sky130_fd_sc_hd__nor2_1
X_13089_ _01242_ _00022_ VSS VSS VDD VDD _09075_ sky130_fd_sc_hd__xnor2_1
X_13090_ _09044_ _09075_ VSS VSS VDD VDD _01690_ sky130_fd_sc_hd__nor2_1
X_13091_ network.neuron_hid2.IF0.add_out\[1\] net389 _09043_
+ VSS VSS VDD VDD _01691_ sky130_fd_sc_hd__and3_1
X_13092_ network.neuron_hid2.IF0.add_out\[0\] net389 _09043_
+ VSS VSS VDD VDD _01692_ sky130_fd_sc_hd__and3_1
X_13093_ network.neuron_hid1.IF0.membrane_potential\[3\] network.neuron_hid1.IF0.membrane_potential\[5\]
+ network.neuron_hid1.IF0.membrane_potential\[4\] network.neuron_hid1.IF0.membrane_potential\[1\]
+ VSS VSS VDD VDD _09076_ sky130_fd_sc_hd__or4_1
X_13094_ network.neuron_hid1.IF0.membrane_potential\[2\] network.neuron_hid1.IF0.membrane_potential\[0\]
+ _09076_ network.neuron_hid1.IF0.membrane_potential\[6\] VSS
+ VSS VDD VDD _09077_ sky130_fd_sc_hd__o31a_1
X_13095_ network.neuron_hid1.IF0.membrane_potential\[7\] _09077_
+ network.neuron_hid1.IF0.membrane_potential\[8\] VSS VSS VDD
+ VDD _09078_ sky130_fd_sc_hd__o21a_1
X_13096_ network.neuron_hid1.IF0.membrane_potential\[10\]
+ network.neuron_hid1.IF0.membrane_potential\[9\] _09078_ _01016_
+ VSS VSS VDD VDD _09079_ sky130_fd_sc_hd__o31ai_1
X_13097_ net389 _09079_ VSS VSS VDD VDD _09080_ sky130_fd_sc_hd__nand2_1
Xplace359 net359 VSS VSS VDD VDD net358 sky130_fd_sc_hd__buf_4
X_13099_ _01016_ _08729_ VSS VSS VDD VDD _09082_ sky130_fd_sc_hd__nor2_1
X_13100_ network.neuron_hid1.IF0.ref_counter\[0\] _09082_
+ VSS VSS VDD VDD _09083_ sky130_fd_sc_hd__xnor2_1
X_13101_ _09080_ _09083_ VSS VSS VDD VDD _01693_ sky130_fd_sc_hd__nor2_1
X_13102_ _00026_ _00796_ _00795_ VSS VSS VDD VDD _09084_ sky130_fd_sc_hd__a21o_1
X_13103_ _01197_ _09084_ _01196_ VSS VSS VDD VDD _09085_ sky130_fd_sc_hd__a21o_1
X_13104_ _00463_ _09085_ _00462_ VSS VSS VDD VDD _09086_ sky130_fd_sc_hd__a21o_1
X_13105_ _01207_ _09086_ _01206_ VSS VSS VDD VDD _09087_ sky130_fd_sc_hd__a21oi_1
X_13106_ network.neuron_hid1.IF0.membrane_potential\[5\] network.neuron_hid1.IF0.membrane_potential\[7\]
+ network.neuron_hid1.IF0.membrane_potential\[6\] network.neuron_hid1.IF0.membrane_potential\[8\]
+ VSS VSS VDD VDD _09088_ sky130_fd_sc_hd__nand4_1
X_13107_ _09087_ _09088_ network.neuron_hid1.IF0.membrane_potential\[9\]
+ VSS VSS VDD VDD _09089_ sky130_fd_sc_hd__o21ai_0
X_13108_ network.neuron_hid1.IF0.membrane_potential\[9\] _09087_
+ _09088_ VSS VSS VDD VDD _09090_ sky130_fd_sc_hd__or3_1
X_13109_ _09089_ _09090_ _09080_ VSS VSS VDD VDD _01694_ sky130_fd_sc_hd__a21oi_1
X_13110_ _00027_ _01197_ _01196_ VSS VSS VDD VDD _09091_ sky130_fd_sc_hd__a21o_1
X_13111_ _00463_ _09091_ _00462_ VSS VSS VDD VDD _09092_ sky130_fd_sc_hd__a21oi_1
X_13112_ _09092_ VSS VSS VDD VDD _09093_ sky130_fd_sc_hd__inv_1
X_13113_ _01207_ _09093_ _01206_ VSS VSS VDD VDD _09094_ sky130_fd_sc_hd__a21oi_1
X_13114_ network.neuron_hid1.IF0.membrane_potential\[5\] network.neuron_hid1.IF0.membrane_potential\[6\]
+ VSS VSS VDD VDD _09095_ sky130_fd_sc_hd__nand2_1
X_13115_ _09094_ _09095_ network.neuron_hid1.IF0.membrane_potential\[7\]
+ VSS VSS VDD VDD _09096_ sky130_fd_sc_hd__nor3b_1
X_13116_ network.neuron_hid1.IF0.membrane_potential\[8\] _09096_
+ VSS VSS VDD VDD _09097_ sky130_fd_sc_hd__xnor2_1
X_13117_ _09080_ _09097_ VSS VSS VDD VDD _01695_ sky130_fd_sc_hd__nor2_1
X_13118_ _09087_ _09095_ network.neuron_hid1.IF0.membrane_potential\[7\]
+ VSS VSS VDD VDD _09098_ sky130_fd_sc_hd__o21ai_0
X_13119_ network.neuron_hid1.IF0.membrane_potential\[7\] _09087_
+ _09095_ VSS VSS VDD VDD _09099_ sky130_fd_sc_hd__or3_1
X_13120_ _09098_ _09099_ _09080_ VSS VSS VDD VDD _01696_ sky130_fd_sc_hd__a21oi_1
X_13121_ _09094_ network.neuron_hid1.IF0.membrane_potential\[5\]
+ VSS VSS VDD VDD _09100_ sky130_fd_sc_hd__nor2b_1
X_13122_ network.neuron_hid1.IF0.membrane_potential\[6\] _09100_
+ VSS VSS VDD VDD _09101_ sky130_fd_sc_hd__xnor2_1
X_13123_ _09080_ _09101_ VSS VSS VDD VDD _01697_ sky130_fd_sc_hd__nor2_1
X_13124_ network.neuron_hid1.IF0.membrane_potential\[5\] _09087_
+ VSS VSS VDD VDD _09102_ sky130_fd_sc_hd__xor2_1
X_13125_ _09080_ _09102_ VSS VSS VDD VDD _01698_ sky130_fd_sc_hd__nor2_1
X_13126_ _01207_ _09092_ VSS VSS VDD VDD _09103_ sky130_fd_sc_hd__xor2_1
X_13127_ _09080_ _09103_ VSS VSS VDD VDD _01699_ sky130_fd_sc_hd__nor2_1
X_13128_ _00463_ _09085_ VSS VSS VDD VDD _09104_ sky130_fd_sc_hd__xnor2_1
X_13129_ _09080_ _09104_ VSS VSS VDD VDD _01700_ sky130_fd_sc_hd__nor2_1
X_13130_ _00027_ _01197_ VSS VSS VDD VDD _09105_ sky130_fd_sc_hd__xnor2_1
X_13131_ _09080_ _09105_ VSS VSS VDD VDD _01701_ sky130_fd_sc_hd__nor2_1
X_13132_ network.neuron_hid1.IF0.add_out\[1\] net389 _09079_
+ VSS VSS VDD VDD _01702_ sky130_fd_sc_hd__and3_1
X_13133_ network.neuron_hid1.IF0.add_out\[0\] net389 _09079_
+ VSS VSS VDD VDD _01703_ sky130_fd_sc_hd__and3_1
X_13134_ net487 net376 VSS VSS VDD VDD _01704_ sky130_fd_sc_hd__and2_1
X_13135_ net597 net371 VSS VSS VDD VDD _01705_ sky130_fd_sc_hd__and2_1
X_13136_ network.ctrl_addr\[4\] net371 VSS VSS VDD VDD _01706_
+ sky130_fd_sc_hd__and2_1
X_13137_ net491 net376 VSS VSS VDD VDD _01707_ sky130_fd_sc_hd__and2_1
X_13138_ net499 net376 VSS VSS VDD VDD _01708_ sky130_fd_sc_hd__and2_1
X_13139_ net497 net376 VSS VSS VDD VDD _01709_ sky130_fd_sc_hd__and2_1
X_13140_ net594 net371 VSS VSS VDD VDD _01710_ sky130_fd_sc_hd__and2_1
X_13141_ network.neuron_hid0.IF0.membrane_potential\[5\] network.neuron_hid0.IF0.membrane_potential\[3\]
+ network.neuron_hid0.IF0.membrane_potential\[0\] network.neuron_hid0.IF0.membrane_potential\[4\]
+ VSS VSS VDD VDD _09106_ sky130_fd_sc_hd__or4_1
X_13142_ network.neuron_hid0.IF0.membrane_potential\[1\] network.neuron_hid0.IF0.membrane_potential\[2\]
+ _09106_ network.neuron_hid0.IF0.membrane_potential\[6\] VSS
+ VSS VDD VDD _09107_ sky130_fd_sc_hd__o31a_1
X_13143_ network.neuron_hid0.IF0.membrane_potential\[7\] _09107_
+ network.neuron_hid0.IF0.membrane_potential\[8\] VSS VSS VDD
+ VDD _09108_ sky130_fd_sc_hd__o21a_1
X_13144_ network.neuron_hid0.IF0.membrane_potential\[9\] network.neuron_hid0.IF0.membrane_potential\[10\]
+ _09108_ _00679_ VSS VSS VDD VDD _09109_ sky130_fd_sc_hd__o31ai_2
X_13145_ net389 _09109_ VSS VSS VDD VDD _09110_ sky130_fd_sc_hd__nand2_1
Xplace358 net358 VSS VSS VDD VDD net357 sky130_fd_sc_hd__buf_4
X_13147_ _00679_ _08729_ VSS VSS VDD VDD _09112_ sky130_fd_sc_hd__nor2_1
X_13148_ network.neuron_hid0.IF0.ref_counter\[0\] _09112_
+ VSS VSS VDD VDD _09113_ sky130_fd_sc_hd__xnor2_1
X_13149_ _09110_ _09113_ VSS VSS VDD VDD _01711_ sky130_fd_sc_hd__nor2_1
X_13150_ _00004_ _00429_ _00703_ VSS VSS VDD VDD _09114_ sky130_fd_sc_hd__a21o_1
X_13151_ _01187_ _09114_ _01186_ VSS VSS VDD VDD _09115_ sky130_fd_sc_hd__a21o_1
X_13152_ _01084_ _09115_ _01083_ VSS VSS VDD VDD _09116_ sky130_fd_sc_hd__a21o_1
X_13153_ _00858_ _09116_ _00857_ VSS VSS VDD VDD _09117_ sky130_fd_sc_hd__a21oi_1
X_13154_ network.neuron_hid0.IF0.membrane_potential\[5\] network.neuron_hid0.IF0.membrane_potential\[8\]
+ network.neuron_hid0.IF0.membrane_potential\[7\] network.neuron_hid0.IF0.membrane_potential\[6\]
+ VSS VSS VDD VDD _09118_ sky130_fd_sc_hd__nand4_1
X_13155_ _09117_ _09118_ network.neuron_hid0.IF0.membrane_potential\[9\]
+ VSS VSS VDD VDD _09119_ sky130_fd_sc_hd__o21ai_0
X_13156_ network.neuron_hid0.IF0.membrane_potential\[9\] _09117_
+ _09118_ VSS VSS VDD VDD _09120_ sky130_fd_sc_hd__or3_1
X_13157_ _09119_ _09120_ _09110_ VSS VSS VDD VDD _01712_ sky130_fd_sc_hd__a21oi_1
X_13158_ _00005_ _01187_ _01186_ VSS VSS VDD VDD _09121_ sky130_fd_sc_hd__a21o_1
X_13159_ _01084_ _09121_ _01083_ VSS VSS VDD VDD _09122_ sky130_fd_sc_hd__a21oi_1
X_13160_ _09122_ VSS VSS VDD VDD _09123_ sky130_fd_sc_hd__inv_1
X_13161_ _00858_ _09123_ _00857_ VSS VSS VDD VDD _09124_ sky130_fd_sc_hd__a21oi_1
X_13162_ network.neuron_hid0.IF0.membrane_potential\[5\] network.neuron_hid0.IF0.membrane_potential\[6\]
+ VSS VSS VDD VDD _09125_ sky130_fd_sc_hd__nand2_1
X_13163_ _09124_ _09125_ network.neuron_hid0.IF0.membrane_potential\[7\]
+ VSS VSS VDD VDD _09126_ sky130_fd_sc_hd__nor3b_1
X_13164_ network.neuron_hid0.IF0.membrane_potential\[8\] _09126_
+ VSS VSS VDD VDD _09127_ sky130_fd_sc_hd__xnor2_1
X_13165_ _09110_ _09127_ VSS VSS VDD VDD _01713_ sky130_fd_sc_hd__nor2_1
X_13166_ _09117_ _09125_ network.neuron_hid0.IF0.membrane_potential\[7\]
+ VSS VSS VDD VDD _09128_ sky130_fd_sc_hd__o21ai_0
X_13167_ network.neuron_hid0.IF0.membrane_potential\[7\] _09117_
+ _09125_ VSS VSS VDD VDD _09129_ sky130_fd_sc_hd__or3_1
X_13168_ _09128_ _09129_ _09110_ VSS VSS VDD VDD _01714_ sky130_fd_sc_hd__a21oi_1
X_13169_ _09124_ network.neuron_hid0.IF0.membrane_potential\[5\]
+ VSS VSS VDD VDD _09130_ sky130_fd_sc_hd__nor2b_1
X_13170_ network.neuron_hid0.IF0.membrane_potential\[6\] _09130_
+ VSS VSS VDD VDD _09131_ sky130_fd_sc_hd__xnor2_1
X_13171_ _09110_ _09131_ VSS VSS VDD VDD _01715_ sky130_fd_sc_hd__nor2_1
X_13172_ network.neuron_hid0.IF0.membrane_potential\[5\] _09117_
+ VSS VSS VDD VDD _09132_ sky130_fd_sc_hd__xor2_1
X_13173_ _09110_ _09132_ VSS VSS VDD VDD _01716_ sky130_fd_sc_hd__nor2_1
X_13174_ _00858_ _09122_ VSS VSS VDD VDD _09133_ sky130_fd_sc_hd__xor2_1
X_13175_ _09110_ _09133_ VSS VSS VDD VDD _01717_ sky130_fd_sc_hd__nor2_1
X_13176_ _01084_ _09115_ VSS VSS VDD VDD _09134_ sky130_fd_sc_hd__xnor2_1
X_13177_ _09110_ _09134_ VSS VSS VDD VDD _01718_ sky130_fd_sc_hd__nor2_1
X_13178_ _00005_ _01187_ VSS VSS VDD VDD _09135_ sky130_fd_sc_hd__xnor2_1
X_13179_ _09110_ _09135_ VSS VSS VDD VDD _01719_ sky130_fd_sc_hd__nor2_1
X_13180_ network.neuron_hid0.IF0.add_out\[1\] net389 _09109_
+ VSS VSS VDD VDD _01720_ sky130_fd_sc_hd__and3_1
X_13181_ network.neuron_hid0.IF0.add_out\[0\] net389 _09109_
+ VSS VSS VDD VDD _01721_ sky130_fd_sc_hd__and3_1
X_13182_ network.in_spk08_03 network.in_spk09_03 network.in_spk10_03
+ network.in_spk11_03 VSS VSS VDD VDD _09136_ sky130_fd_sc_hd__nor4_4
X_13183_ network.in_spk12_03 network.in_spk13_03 network.in_spk14_03
+ network.in_spk15_03 VSS VSS VDD VDD _09137_ sky130_fd_sc_hd__nor4_2
Xplace357 net358 VSS VSS VDD VDD net356 sky130_fd_sc_hd__buf_4
X_13185_ network.in_spk04_03 network.in_spk05_03 network.in_spk06_03
+ network.in_spk07_03 VSS VSS VDD VDD _09139_ sky130_fd_sc_hd__nor4_2
X_13186_ network.in_spk00_03 network.in_spk01_03 network.in_spk02_03
+ network.in_spk03_03 VSS VSS VDD VDD _09140_ sky130_fd_sc_hd__nor4_2
X_13187_ _09136_ _09137_ _09139_ _09140_ VSS VSS VDD VDD _09141_
+ sky130_fd_sc_hd__nand4_2
X_13188_ network.in_spk08_00 network.in_spk09_00 network.in_spk10_00
+ network.in_spk11_00 VSS VSS VDD VDD _09142_ sky130_fd_sc_hd__nor4_2
X_13189_ network.in_spk12_00 network.in_spk13_00 network.in_spk14_00
+ network.in_spk15_00 VSS VSS VDD VDD _09143_ sky130_fd_sc_hd__nor4_2
X_13190_ network.in_spk00_00 network.in_spk01_00 network.in_spk02_00
+ network.in_spk03_00 VSS VSS VDD VDD _09144_ sky130_fd_sc_hd__nor4_4
X_13191_ network.in_spk04_00 network.in_spk05_00 network.in_spk06_00
+ network.in_spk07_00 VSS VSS VDD VDD _09145_ sky130_fd_sc_hd__nor4_4
X_13192_ _09142_ _09143_ _09144_ _09145_ VSS VSS VDD VDD _09146_
+ sky130_fd_sc_hd__nand4_4
X_13193_ network.in_spk08_01 network.in_spk09_01 network.in_spk10_01
+ network.in_spk11_01 VSS VSS VDD VDD _09147_ sky130_fd_sc_hd__nor4_4
X_13194_ network.in_spk12_01 network.in_spk13_01 network.in_spk14_01
+ network.in_spk15_01 VSS VSS VDD VDD _09148_ sky130_fd_sc_hd__nor4_2
X_13195_ network.in_spk00_01 network.in_spk01_01 network.in_spk02_01
+ network.in_spk03_01 VSS VSS VDD VDD _09149_ sky130_fd_sc_hd__nor4_1
X_13196_ network.in_spk04_01 network.in_spk05_01 network.in_spk06_01
+ network.in_spk07_01 VSS VSS VDD VDD _09150_ sky130_fd_sc_hd__nor4_1
X_13197_ _09147_ _09148_ _09149_ _09150_ VSS VSS VDD VDD _09151_
+ sky130_fd_sc_hd__nand4_1
X_13198_ network.in_spk00_02 network.in_spk01_02 network.in_spk02_02
+ network.in_spk03_02 VSS VSS VDD VDD _09152_ sky130_fd_sc_hd__nor4_4
X_13199_ network.in_spk04_02 network.in_spk05_02 network.in_spk06_02
+ network.in_spk07_02 VSS VSS VDD VDD _09153_ sky130_fd_sc_hd__nor4_2
X_13200_ network.in_spk08_02 network.in_spk09_02 network.in_spk10_02
+ network.in_spk11_02 VSS VSS VDD VDD _09154_ sky130_fd_sc_hd__nor4_2
X_13201_ network.in_spk12_02 network.in_spk13_02 network.in_spk14_02
+ network.in_spk15_02 VSS VSS VDD VDD _09155_ sky130_fd_sc_hd__nor4_1
X_13202_ _09152_ _09153_ _09154_ _09155_ VSS VSS VDD VDD _09156_
+ sky130_fd_sc_hd__nand4_2
X_13203_ _09141_ _09146_ _09151_ _09156_ VSS VSS VDD VDD _09157_
+ sky130_fd_sc_hd__nor4_2
Xplace356 net364 VSS VSS VDD VDD net355 sky130_fd_sc_hd__buf_4
Xplace355 net355 VSS VSS VDD VDD net354 sky130_fd_sc_hd__buf_4
X_13206_ network.in_spk00_04 network.in_spk01_04 network.in_spk02_04
+ network.in_spk03_04 VSS VSS VDD VDD _09160_ sky130_fd_sc_hd__nor4_2
X_13207_ network.in_spk04_04 network.in_spk05_04 network.in_spk06_04
+ network.in_spk07_04 VSS VSS VDD VDD _09161_ sky130_fd_sc_hd__nor4_2
X_13208_ network.in_spk08_04 network.in_spk09_04 network.in_spk10_04
+ network.in_spk11_04 VSS VSS VDD VDD _09162_ sky130_fd_sc_hd__nor4_1
X_13209_ network.in_spk12_04 network.in_spk13_04 network.in_spk14_04
+ network.in_spk15_04 VSS VSS VDD VDD _09163_ sky130_fd_sc_hd__nor4_1
X_13210_ _09160_ _09161_ _09162_ _09163_ VSS VSS VDD VDD _09164_
+ sky130_fd_sc_hd__and4_1
Xplace354 net354 VSS VSS VDD VDD net353 sky130_fd_sc_hd__buf_4
X_13212_ network.in_spk00_05 network.in_spk01_05 network.in_spk02_05
+ network.in_spk03_05 VSS VSS VDD VDD _09166_ sky130_fd_sc_hd__nor4_2
Xplace353 net353 VSS VSS VDD VDD net352 sky130_fd_sc_hd__buf_4
X_13214_ network.in_spk04_05 network.in_spk05_05 network.in_spk06_05
+ network.in_spk07_05 VSS VSS VDD VDD _09168_ sky130_fd_sc_hd__nor4_1
Xplace352 net354 VSS VSS VDD VDD net351 sky130_fd_sc_hd__buf_4
X_13216_ network.in_spk08_05 network.in_spk09_05 network.in_spk10_05
+ network.in_spk11_05 VSS VSS VDD VDD _09170_ sky130_fd_sc_hd__nor4_1
Xplace351 net351 VSS VSS VDD VDD net350 sky130_fd_sc_hd__buf_4
X_13218_ network.in_spk12_05 network.in_spk13_05 network.in_spk14_05
+ network.in_spk15_05 VSS VSS VDD VDD _09172_ sky130_fd_sc_hd__nor4_1
X_13219_ _09166_ _09168_ _09170_ _09172_ VSS VSS VDD VDD _09173_
+ sky130_fd_sc_hd__and4_1
X_13220_ network.in_spk08_06 network.in_spk09_06 network.in_spk10_06
+ network.in_spk11_06 VSS VSS VDD VDD _09174_ sky130_fd_sc_hd__or4_1
X_13221_ network.in_spk12_06 network.in_spk13_06 network.in_spk14_06
+ network.in_spk15_06 VSS VSS VDD VDD _09175_ sky130_fd_sc_hd__or4_1
Xplace350 net355 VSS VSS VDD VDD net349 sky130_fd_sc_hd__buf_4
X_13223_ network.in_spk02_06 network.in_spk03_06 network.in_spk00_06
+ network.in_spk01_06 VSS VSS VDD VDD _09177_ sky130_fd_sc_hd__or4_1
X_13224_ network.in_spk04_06 network.in_spk05_06 network.in_spk06_06
+ network.in_spk07_06 VSS VSS VDD VDD _09178_ sky130_fd_sc_hd__or4_1
X_13225_ _09174_ _09175_ _09177_ _09178_ VSS VSS VDD VDD _09179_
+ sky130_fd_sc_hd__nor4_4
X_13226_ network.in_spk08_07 network.in_spk09_07 network.in_spk10_07
+ network.in_spk11_07 VSS VSS VDD VDD _09180_ sky130_fd_sc_hd__or4_1
X_13227_ network.in_spk12_07 network.in_spk13_07 network.in_spk14_07
+ network.in_spk15_07 VSS VSS VDD VDD _09181_ sky130_fd_sc_hd__or4_1
X_13228_ network.in_spk00_07 network.in_spk01_07 network.in_spk02_07
+ network.in_spk03_07 VSS VSS VDD VDD _09182_ sky130_fd_sc_hd__or4_1
Xplace349 net364 VSS VSS VDD VDD net348 sky130_fd_sc_hd__buf_4
X_13230_ network.in_spk04_07 network.in_spk05_07 network.in_spk06_07
+ network.in_spk07_07 VSS VSS VDD VDD _09184_ sky130_fd_sc_hd__or4_1
X_13231_ _09180_ _09181_ _09182_ _09184_ VSS VSS VDD VDD _09185_
+ sky130_fd_sc_hd__nor4_1
X_13232_ _09164_ _09173_ _09179_ _09185_ VSS VSS VDD VDD _09186_
+ sky130_fd_sc_hd__nand4_1
X_13233_ net292 net291 VSS VSS VDD VDD _09187_ sky130_fd_sc_hd__nand2_1
X_13234_ _09141_ _09146_ _09151_ _09156_ VSS VSS VDD VDD _09188_
+ sky130_fd_sc_hd__or4_4
X_13235_ _09188_ net291 VSS VSS VDD VDD _09189_ sky130_fd_sc_hd__nor2_1
Xplace347 _07261_ VSS VSS VDD VDD net346 sky130_fd_sc_hd__buf_4
X_13237_ network.in_spk00_13 network.in_spk01_13 network.in_spk02_13
+ network.in_spk03_13 VSS VSS VDD VDD _09191_ sky130_fd_sc_hd__nor4_1
X_13238_ network.in_spk04_13 network.in_spk05_13 network.in_spk06_13
+ network.in_spk07_13 VSS VSS VDD VDD _09192_ sky130_fd_sc_hd__nor4_2
X_13239_ _09191_ _09192_ VSS VSS VDD VDD _09193_ sky130_fd_sc_hd__nand2_1
X_13240_ network.in_spk08_13 network.in_spk09_13 network.in_spk10_13
+ network.in_spk11_13 VSS VSS VDD VDD _09194_ sky130_fd_sc_hd__nor4_1
X_13241_ network.in_spk12_13 network.in_spk13_13 network.in_spk14_13
+ network.in_spk15_13 VSS VSS VDD VDD _09195_ sky130_fd_sc_hd__nor4_1
X_13242_ _09194_ _09195_ VSS VSS VDD VDD _09196_ sky130_fd_sc_hd__nand2_1
X_13243_ _09193_ _09196_ VSS VSS VDD VDD _09197_ sky130_fd_sc_hd__nor2_1
X_13244_ network.in_spk08_08 network.in_spk09_08 network.in_spk10_08
+ network.in_spk11_08 VSS VSS VDD VDD _09198_ sky130_fd_sc_hd__or4_1
X_13245_ network.in_spk12_08 network.in_spk13_08 network.in_spk14_08
+ network.in_spk15_08 VSS VSS VDD VDD _09199_ sky130_fd_sc_hd__or4_1
X_13246_ network.in_spk00_08 network.in_spk01_08 network.in_spk02_08
+ network.in_spk03_08 VSS VSS VDD VDD _09200_ sky130_fd_sc_hd__or4_1
Xplace346 _07264_ VSS VSS VDD VDD net345 sky130_fd_sc_hd__buf_4
X_13248_ network.in_spk04_08 network.in_spk05_08 network.in_spk06_08
+ network.in_spk07_08 VSS VSS VDD VDD _09202_ sky130_fd_sc_hd__or4_1
X_13249_ _09198_ _09199_ _09200_ _09202_ VSS VSS VDD VDD _09203_
+ sky130_fd_sc_hd__nor4_2
X_13250_ network.in_spk08_09 network.in_spk09_09 network.in_spk10_09
+ network.in_spk11_09 VSS VSS VDD VDD _09204_ sky130_fd_sc_hd__nor4_1
X_13251_ network.in_spk12_09 network.in_spk13_09 network.in_spk14_09
+ network.in_spk15_09 VSS VSS VDD VDD _09205_ sky130_fd_sc_hd__nor4_1
X_13252_ network.in_spk00_09 network.in_spk01_09 network.in_spk02_09
+ network.in_spk03_09 VSS VSS VDD VDD _09206_ sky130_fd_sc_hd__nor4_1
X_13253_ network.in_spk04_09 network.in_spk05_09 network.in_spk06_09
+ network.in_spk07_09 VSS VSS VDD VDD _09207_ sky130_fd_sc_hd__nor4_1
X_13254_ _09204_ _09205_ _09206_ _09207_ VSS VSS VDD VDD _09208_
+ sky130_fd_sc_hd__and4_1
X_13255_ net296 _09208_ VSS VSS VDD VDD _09209_ sky130_fd_sc_hd__nand2_1
X_13256_ network.in_spk08_10 network.in_spk09_10 network.in_spk10_10
+ network.in_spk11_10 VSS VSS VDD VDD _09210_ sky130_fd_sc_hd__nor4_1
X_13257_ network.in_spk12_10 network.in_spk13_10 network.in_spk14_10
+ network.in_spk15_10 VSS VSS VDD VDD _09211_ sky130_fd_sc_hd__nor4_1
X_13258_ network.in_spk00_10 network.in_spk01_10 network.in_spk02_10
+ network.in_spk03_10 VSS VSS VDD VDD _09212_ sky130_fd_sc_hd__nor4_1
X_13259_ network.in_spk04_10 network.in_spk05_10 network.in_spk06_10
+ network.in_spk07_10 VSS VSS VDD VDD _09213_ sky130_fd_sc_hd__nor4_1
X_13260_ net309 _09211_ _09212_ _09213_ VSS VSS VDD VDD _09214_
+ sky130_fd_sc_hd__nand4_1
X_13261_ network.in_spk00_11 network.in_spk01_11 VSS VSS VDD
+ VDD _09215_ sky130_fd_sc_hd__nor2_1
X_13262_ network.in_spk02_11 network.in_spk03_11 VSS VSS VDD
+ VDD _09216_ sky130_fd_sc_hd__nor2_1
X_13263_ network.in_spk04_11 network.in_spk05_11 network.in_spk06_11
+ network.in_spk07_11 VSS VSS VDD VDD _09217_ sky130_fd_sc_hd__nor4_1
X_13264_ _09215_ _09216_ _09217_ VSS VSS VDD VDD _09218_ sky130_fd_sc_hd__and3_1
X_13265_ network.in_spk08_11 network.in_spk09_11 network.in_spk10_11
+ network.in_spk11_11 VSS VSS VDD VDD _09219_ sky130_fd_sc_hd__nor4_1
X_13266_ network.in_spk12_11 network.in_spk13_11 VSS VSS VDD
+ VDD _09220_ sky130_fd_sc_hd__nor2_1
X_13267_ network.in_spk14_11 network.in_spk15_11 VSS VSS VDD
+ VDD _09221_ sky130_fd_sc_hd__nor2_1
X_13268_ _09219_ _09220_ _09221_ VSS VSS VDD VDD _09222_ sky130_fd_sc_hd__and3_1
X_13269_ _09214_ _09218_ _09222_ VSS VSS VDD VDD _09223_ sky130_fd_sc_hd__nand3b_1
X_13270_ _09209_ _09223_ VSS VSS VDD VDD _09224_ sky130_fd_sc_hd__nor2_1
X_13271_ network.in_spk00_12 network.in_spk01_12 network.in_spk02_12
+ network.in_spk03_12 VSS VSS VDD VDD _09225_ sky130_fd_sc_hd__nor4_1
X_13272_ network.in_spk04_12 network.in_spk05_12 network.in_spk06_12
+ network.in_spk07_12 VSS VSS VDD VDD _09226_ sky130_fd_sc_hd__nor4_1
X_13273_ network.in_spk11_12 network.in_spk12_12 network.in_spk13_12
+ network.in_spk14_12 VSS VSS VDD VDD _09227_ sky130_fd_sc_hd__or4_1
X_13274_ network.in_spk08_12 network.in_spk09_12 network.in_spk10_12
+ VSS VSS VDD VDD _09228_ sky130_fd_sc_hd__or3_1
X_13275_ network.in_spk15_12 _09227_ _09228_ VSS VSS VDD VDD
+ _09229_ sky130_fd_sc_hd__nor3_1
X_13276_ _09225_ _09226_ _09229_ VSS VSS VDD VDD _09230_ sky130_fd_sc_hd__nand3_1
X_13277_ network.in_spk14_14 network.in_spk13_14 network.in_spk12_14
+ VSS VSS VDD VDD _09231_ sky130_fd_sc_hd__or3_1
Xplace344 _07271_ VSS VSS VDD VDD net343 sky130_fd_sc_hd__buf_4
X_13279_ network.in_spk02_14 network.in_spk03_14 network.in_spk00_14
+ network.in_spk01_14 VSS VSS VDD VDD _09233_ sky130_fd_sc_hd__nor4_1
X_13280_ network.in_spk04_14 network.in_spk05_14 network.in_spk06_14
+ network.in_spk07_14 VSS VSS VDD VDD _09234_ sky130_fd_sc_hd__nor4_1
X_13281_ network.in_spk10_14 network.in_spk09_14 network.in_spk08_14
+ network.in_spk11_14 VSS VSS VDD VDD _09235_ sky130_fd_sc_hd__nor4_1
X_13282_ _09233_ _09234_ _09235_ VSS VSS VDD VDD _09236_ sky130_fd_sc_hd__nand3_1
X_13283_ network.in_spk15_14 _09231_ _09236_ VSS VSS VDD VDD
+ _09237_ sky130_fd_sc_hd__nor3_1
X_13284_ _09230_ _09237_ VSS VSS VDD VDD _09238_ sky130_fd_sc_hd__nor2_1
X_13285_ net287 _09197_ _09224_ _09238_ VSS VSS VDD VDD _09239_
+ sky130_fd_sc_hd__nand4_1
X_13286_ _09225_ _09226_ VSS VSS VDD VDD _09240_ sky130_fd_sc_hd__nand2_1
X_13287_ _09240_ _09228_ VSS VSS VDD VDD _09241_ sky130_fd_sc_hd__or2_2
X_13288_ network.in_spk15_12 _09227_ _09241_ VSS VSS VDD VDD
+ _09242_ sky130_fd_sc_hd__nor3_1
X_13289_ _09188_ net291 _09209_ _09223_ VSS VSS VDD VDD _09243_
+ sky130_fd_sc_hd__nor4_1
Xplace340 _07290_ VSS VSS VDD VDD net339 sky130_fd_sc_hd__buf_4
X_13291_ network.in_spk03_15 network.in_spk02_15 network.in_spk01_15
+ network.in_spk00_15 VSS VSS VDD VDD _09245_ sky130_fd_sc_hd__or4_1
X_13292_ network.in_spk06_15 network.in_spk05_15 network.in_spk04_15
+ VSS VSS VDD VDD _09246_ sky130_fd_sc_hd__or3_1
X_13293_ network.in_spk07_15 _09245_ _09246_ VSS VSS VDD VDD
+ _09247_ sky130_fd_sc_hd__nor3_1
X_13294_ network.in_spk11_15 network.in_spk10_15 network.in_spk09_15
+ network.in_spk08_15 VSS VSS VDD VDD _09248_ sky130_fd_sc_hd__or4_1
X_13295_ network.in_spk14_15 network.in_spk13_15 network.in_spk12_15
+ VSS VSS VDD VDD _09249_ sky130_fd_sc_hd__or3_1
X_13296_ network.in_spk15_15 _09248_ _09249_ VSS VSS VDD VDD
+ _09250_ sky130_fd_sc_hd__nor3_1
X_13297_ _09191_ _09192_ _09194_ _09195_ VSS VSS VDD VDD _09251_
+ sky130_fd_sc_hd__nand4_1
X_13298_ _09247_ _09250_ _09251_ VSS VSS VDD VDD _09252_ sky130_fd_sc_hd__a21oi_1
X_13299_ _09242_ _09237_ net286 _09252_ VSS VSS VDD VDD _09253_
+ sky130_fd_sc_hd__nand4_1
X_13300_ net287 _09224_ _09230_ VSS VSS VDD VDD _09254_ sky130_fd_sc_hd__nand3_1
X_13301_ net287 _09251_ _09224_ _09242_ VSS VSS VDD VDD _09255_
+ sky130_fd_sc_hd__nand4_1
X_13302_ _09239_ _09253_ _09254_ _09255_ VSS VSS VDD VDD _09256_
+ sky130_fd_sc_hd__and4_1
X_13303_ _09187_ _09256_ net358 VSS VSS VDD VDD _01722_ sky130_fd_sc_hd__a21oi_1
X_13304_ _09188_ net291 _09209_ _09223_ VSS VSS VDD VDD _09257_
+ sky130_fd_sc_hd__or4_1
Xplace338 _07301_ VSS VSS VDD VDD net337 sky130_fd_sc_hd__buf_4
X_13306_ _09237_ _09252_ VSS VSS VDD VDD _09259_ sky130_fd_sc_hd__nand2_1
X_13307_ _09230_ _09257_ _09259_ VSS VSS VDD VDD _09260_ sky130_fd_sc_hd__or3_1
X_13308_ _09251_ _09230_ _09237_ _09257_ VSS VSS VDD VDD _09261_
+ sky130_fd_sc_hd__or4_1
Xplace337 _07310_ VSS VSS VDD VDD net336 sky130_fd_sc_hd__buf_4
X_13310_ _09160_ _09161_ _09162_ _09163_ VSS VSS VDD VDD _09263_
+ sky130_fd_sc_hd__nand4_1
X_13311_ _09166_ _09168_ _09170_ _09172_ VSS VSS VDD VDD _09264_
+ sky130_fd_sc_hd__nand4_1
X_13312_ _09179_ _09185_ _09263_ _09264_ VSS VSS VDD VDD _09265_
+ sky130_fd_sc_hd__a211oi_2
X_13313_ _09146_ _09151_ VSS VSS VDD VDD _09266_ sky130_fd_sc_hd__nor2_1
X_13314_ _09141_ _09156_ _09265_ net290 VSS VSS VDD VDD _09267_
+ sky130_fd_sc_hd__o31ai_4
X_13315_ _09198_ _09199_ _09200_ _09202_ VSS VSS VDD VDD _09268_
+ sky130_fd_sc_hd__or4_1
X_13316_ _09204_ _09205_ VSS VSS VDD VDD _09269_ sky130_fd_sc_hd__nand2_1
X_13317_ _09206_ _09207_ VSS VSS VDD VDD _09270_ sky130_fd_sc_hd__nand2_1
X_13318_ _09268_ _09269_ _09270_ VSS VSS VDD VDD _09271_ sky130_fd_sc_hd__nor3_2
X_13319_ net287 _09271_ _09214_ VSS VSS VDD VDD _09272_ sky130_fd_sc_hd__nand3_1
X_13320_ _09261_ _09267_ _09272_ VSS VSS VDD VDD _09273_ sky130_fd_sc_hd__and3_1
X_13321_ _09174_ _09175_ _09177_ _09178_ VSS VSS VDD VDD _09274_
+ sky130_fd_sc_hd__or4_1
X_13322_ _09180_ _09181_ _09182_ _09184_ VSS VSS VDD VDD _09275_
+ sky130_fd_sc_hd__or4_1
X_13323_ _09263_ _09264_ _09274_ _09275_ VSS VSS VDD VDD _09276_
+ sky130_fd_sc_hd__nor4_2
X_13324_ _09218_ _09222_ _09214_ VSS VSS VDD VDD _09277_ sky130_fd_sc_hd__a21oi_1
X_13325_ net292 net289 _09271_ _09277_ VSS VSS VDD VDD _09278_
+ sky130_fd_sc_hd__nand4_1
Xplace336 _07325_ VSS VSS VDD VDD net335 sky130_fd_sc_hd__buf_4
X_13327_ net286 _09256_ net359 VSS VSS VDD VDD _09280_ sky130_fd_sc_hd__a21o_1
X_13328_ _09260_ _09273_ net285 _09280_ VSS VSS VDD VDD _01723_
+ sky130_fd_sc_hd__a31oi_1
X_13329_ _09197_ _09230_ _09257_ VSS VSS VDD VDD _09281_ sky130_fd_sc_hd__nor3_1
X_13330_ net292 net289 net296 VSS VSS VDD VDD _09282_ sky130_fd_sc_hd__nand3_1
X_13331_ _09208_ _09282_ VSS VSS VDD VDD _09283_ sky130_fd_sc_hd__nor2_1
X_13332_ _09263_ _09173_ VSS VSS VDD VDD _09284_ sky130_fd_sc_hd__nor2_1
X_13333_ net292 _09284_ VSS VSS VDD VDD _09285_ sky130_fd_sc_hd__nand2_1
X_13334_ _09146_ _09151_ VSS VSS VDD VDD _09286_ sky130_fd_sc_hd__nor2b_1
X_13335_ _09146_ _09151_ _09156_ _09141_ VSS VSS VDD VDD _09287_
+ sky130_fd_sc_hd__nor4b_1
X_13336_ _09286_ _09287_ VSS VSS VDD VDD _09288_ sky130_fd_sc_hd__nor2_1
X_13337_ _09263_ _09264_ VSS VSS VDD VDD _09289_ sky130_fd_sc_hd__nor2_1
X_13338_ net292 _09289_ _09179_ _09275_ VSS VSS VDD VDD _09290_
+ sky130_fd_sc_hd__nand4_1
X_13339_ _09285_ _09288_ _09290_ VSS VSS VDD VDD _09291_ sky130_fd_sc_hd__nand3_1
X_13340_ net284 _09283_ _09291_ VSS VSS VDD VDD _09292_ sky130_fd_sc_hd__nor3_1
X_13341_ _09260_ net285 _09292_ _09280_ VSS VSS VDD VDD _01724_
+ sky130_fd_sc_hd__a31oi_1
X_13342_ _09144_ _09145_ VSS VSS VDD VDD _09293_ sky130_fd_sc_hd__nand2_1
X_13343_ network.in_spk00_01 network.in_spk01_01 VSS VSS VDD
+ VDD _09294_ sky130_fd_sc_hd__nor2_1
X_13344_ network.in_spk02_01 network.in_spk03_01 VSS VSS VDD
+ VDD _09295_ sky130_fd_sc_hd__nor2_1
X_13345_ _09294_ _09295_ VSS VSS VDD VDD _09296_ sky130_fd_sc_hd__nand2_1
X_13346_ network.in_spk04_01 network.in_spk05_01 network.in_spk06_01
+ network.in_spk07_01 VSS VSS VDD VDD _09297_ sky130_fd_sc_hd__or4_1
X_13347_ _09296_ _09297_ VSS VSS VDD VDD _09298_ sky130_fd_sc_hd__nor2_1
X_13348_ _09152_ _09153_ VSS VSS VDD VDD _09299_ sky130_fd_sc_hd__nand2_1
X_13349_ _09136_ _09137_ VSS VSS VDD VDD _09300_ sky130_fd_sc_hd__nand2_1
X_13350_ network.in_spk02_03 network.in_spk03_03 VSS VSS VDD
+ VDD _09301_ sky130_fd_sc_hd__nor2_1
X_13351_ network.in_spk04_03 network.in_spk05_03 network.in_spk06_03
+ network.in_spk07_03 VSS VSS VDD VDD _09302_ sky130_fd_sc_hd__or4_1
X_13352_ network.in_spk00_03 network.in_spk01_03 _09302_ VSS
+ VSS VDD VDD _09303_ sky130_fd_sc_hd__nor3_1
X_13353_ _09154_ _09155_ VSS VSS VDD VDD _09304_ sky130_fd_sc_hd__nand2_1
X_13354_ _09300_ _09301_ _09303_ _09304_ VSS VSS VDD VDD _09305_
+ sky130_fd_sc_hd__a31oi_1
X_13355_ _09147_ _09148_ VSS VSS VDD VDD _09306_ sky130_fd_sc_hd__nand2_1
X_13356_ _09299_ _09305_ _09306_ VSS VSS VDD VDD _09307_ sky130_fd_sc_hd__o21bai_1
X_13357_ _09142_ _09143_ VSS VSS VDD VDD _09308_ sky130_fd_sc_hd__nand2_1
X_13358_ _09298_ _09307_ _09308_ VSS VSS VDD VDD _09309_ sky130_fd_sc_hd__a21oi_1
X_13359_ _09293_ _09309_ VSS VSS VDD VDD _09310_ sky130_fd_sc_hd__nor2_2
X_13360_ net292 _09160_ _09161_ VSS VSS VDD VDD _09311_ sky130_fd_sc_hd__nand3_1
X_13361_ _09174_ _09175_ VSS VSS VDD VDD _09312_ sky130_fd_sc_hd__nor2_1
X_13362_ network.in_spk02_06 network.in_spk03_06 network.in_spk00_06
+ network.in_spk01_06 VSS VSS VDD VDD _09313_ sky130_fd_sc_hd__nor4_1
X_13363_ network.in_spk04_06 network.in_spk05_06 network.in_spk06_06
+ network.in_spk07_06 VSS VSS VDD VDD _09314_ sky130_fd_sc_hd__nor4_1
X_13364_ _09313_ _09314_ VSS VSS VDD VDD _09315_ sky130_fd_sc_hd__nand2_1
X_13365_ _09264_ _09312_ _09315_ _09163_ _09162_ VSS VSS VDD
+ VDD _09316_ sky130_fd_sc_hd__o311a_1
X_13366_ net292 _09166_ _09168_ _09284_ VSS VSS VDD VDD _09317_
+ sky130_fd_sc_hd__nand4_1
X_13367_ _09200_ _09202_ VSS VSS VDD VDD _09318_ sky130_fd_sc_hd__nor2_1
X_13368_ _09198_ _09199_ _09318_ net287 VSS VSS VDD VDD _09319_
+ sky130_fd_sc_hd__o211ai_2
X_13369_ _09311_ _09316_ _09317_ _09319_ VSS VSS VDD VDD _09320_
+ sky130_fd_sc_hd__o211ai_1
X_13370_ net309 _09211_ VSS VSS VDD VDD _09321_ sky130_fd_sc_hd__nand2_1
X_13371_ _09212_ _09213_ VSS VSS VDD VDD _09322_ sky130_fd_sc_hd__and2_1
X_13372_ _09188_ net291 _09268_ VSS VSS VDD VDD _09323_ sky130_fd_sc_hd__nor3_1
X_13373_ _09208_ _09321_ _09322_ _09323_ VSS VSS VDD VDD _09324_
+ sky130_fd_sc_hd__nand4_1
X_13374_ _09222_ net285 _09218_ VSS VSS VDD VDD _09325_ sky130_fd_sc_hd__or3b_1
X_13375_ network.in_spk00_09 network.in_spk01_09 VSS VSS VDD
+ VDD _09326_ sky130_fd_sc_hd__nor2_1
X_13376_ network.in_spk02_09 network.in_spk03_09 VSS VSS VDD
+ VDD _09327_ sky130_fd_sc_hd__nor2_1
X_13377_ _09326_ _09327_ VSS VSS VDD VDD _09328_ sky130_fd_sc_hd__nand2_1
X_13378_ network.in_spk04_09 network.in_spk05_09 network.in_spk06_09
+ VSS VSS VDD VDD _09329_ sky130_fd_sc_hd__or3_1
X_13379_ network.in_spk07_09 _09329_ VSS VSS VDD VDD _09330_
+ sky130_fd_sc_hd__or2_2
X_13380_ _09328_ _09330_ VSS VSS VDD VDD _09331_ sky130_fd_sc_hd__nor2_1
X_13381_ _09269_ _09331_ _09323_ VSS VSS VDD VDD _09332_ sky130_fd_sc_hd__nand3_1
X_13382_ _09180_ _09181_ VSS VSS VDD VDD _09333_ sky130_fd_sc_hd__nor2_1
X_13383_ network.in_spk04_07 network.in_spk05_07 network.in_spk06_07
+ network.in_spk07_07 VSS VSS VDD VDD _09334_ sky130_fd_sc_hd__nor4_1
X_13384_ _09182_ _09334_ VSS VSS VDD VDD _09335_ sky130_fd_sc_hd__nand2b_1
X_13385_ _09333_ _09335_ _09290_ VSS VSS VDD VDD _09336_ sky130_fd_sc_hd__or3_1
X_13386_ _09324_ _09325_ _09332_ _09336_ VSS VSS VDD VDD _09337_
+ sky130_fd_sc_hd__nand4_1
X_13387_ _09240_ _09229_ _09257_ VSS VSS VDD VDD _09338_ sky130_fd_sc_hd__or3_1
X_13388_ _09310_ _09320_ _09337_ _09338_ VSS VSS VDD VDD _09339_
+ sky130_fd_sc_hd__nor4b_2
X_13389_ _09230_ _09257_ _09259_ VSS VSS VDD VDD _09340_ sky130_fd_sc_hd__nor3_2
X_13390_ _09247_ _09340_ VSS VSS VDD VDD _09341_ sky130_fd_sc_hd__nand2_1
X_13391_ _09191_ _09192_ VSS VSS VDD VDD _09342_ sky130_fd_sc_hd__and2_1
X_13392_ _09342_ _09196_ net284 VSS VSS VDD VDD _09343_ sky130_fd_sc_hd__nand3_1
X_13393_ network.in_spk04_14 network.in_spk05_14 VSS VSS VDD
+ VDD _09344_ sky130_fd_sc_hd__nor2_1
X_13394_ network.in_spk06_14 _09233_ _09344_ VSS VSS VDD VDD
+ _09345_ sky130_fd_sc_hd__nand3b_1
X_13395_ network.in_spk07_14 _09345_ VSS VSS VDD VDD _09346_
+ sky130_fd_sc_hd__nor2_1
X_13396_ _09251_ _09230_ _09237_ _09257_ VSS VSS VDD VDD _09347_
+ sky130_fd_sc_hd__nor4_1
X_13397_ _09346_ _09347_ VSS VSS VDD VDD _09348_ sky130_fd_sc_hd__nand2_1
X_13398_ _09339_ _09341_ _09343_ _09348_ _09280_ VSS VSS VDD
+ VDD _01725_ sky130_fd_sc_hd__a41oi_1
X_13399_ network.in_spk15_15 _09249_ VSS VSS VDD VDD _09349_
+ sky130_fd_sc_hd__nor2_1
X_13400_ network.in_spk07_15 _09246_ VSS VSS VDD VDD _09350_
+ sky130_fd_sc_hd__nor2_1
X_13401_ _09248_ _09349_ _09350_ VSS VSS VDD VDD _09351_ sky130_fd_sc_hd__o21a_1
X_13402_ network.in_spk03_15 network.in_spk02_15 network.in_spk01_15
+ network.in_spk00_15 VSS VSS VDD VDD _09352_ sky130_fd_sc_hd__nor4_1
X_13403_ _09352_ _09340_ VSS VSS VDD VDD _09353_ sky130_fd_sc_hd__nand2_1
X_13404_ _09233_ _09347_ VSS VSS VDD VDD _09354_ sky130_fd_sc_hd__nand2_1
X_13405_ network.in_spk15_14 _09231_ _09235_ VSS VSS VDD VDD
+ _09355_ sky130_fd_sc_hd__o21ai_0
X_13406_ _09234_ _09355_ VSS VSS VDD VDD _09356_ sky130_fd_sc_hd__and2_1
X_13407_ net292 _09289_ VSS VSS VDD VDD _09357_ sky130_fd_sc_hd__nand2_1
X_13408_ network.in_spk10_06 network.in_spk11_06 VSS VSS VDD
+ VDD _09358_ sky130_fd_sc_hd__nor2_1
X_13409_ network.in_spk08_06 network.in_spk09_06 VSS VSS VDD
+ VDD _09359_ sky130_fd_sc_hd__nor2_1
X_13410_ _09358_ _09359_ _09175_ _09178_ VSS VSS VDD VDD _09360_
+ sky130_fd_sc_hd__a31oi_1
X_13411_ _09308_ _09293_ VSS VSS VDD VDD _09361_ sky130_fd_sc_hd__nor2_1
X_13412_ network.in_spk08_02 network.in_spk09_02 network.in_spk10_02
+ network.in_spk11_02 VSS VSS VDD VDD _09362_ sky130_fd_sc_hd__or4_1
X_13413_ _09362_ _09155_ _09153_ VSS VSS VDD VDD _09363_ sky130_fd_sc_hd__o21ai_1
X_13414_ network.in_spk08_01 network.in_spk09_01 network.in_spk10_01
+ network.in_spk11_01 VSS VSS VDD VDD _09364_ sky130_fd_sc_hd__or4_1
X_13415_ _09364_ _09148_ _09150_ VSS VSS VDD VDD _09365_ sky130_fd_sc_hd__o21ai_0
X_13416_ _09147_ _09152_ _09363_ _09365_ VSS VSS VDD VDD _09366_
+ sky130_fd_sc_hd__a31o_2
X_13417_ network.in_spk10_00 network.in_spk11_00 VSS VSS VDD
+ VDD _09367_ sky130_fd_sc_hd__nor2_1
X_13418_ network.in_spk08_00 network.in_spk09_00 VSS VSS VDD
+ VDD _09368_ sky130_fd_sc_hd__nor2_1
X_13419_ _09367_ _09368_ VSS VSS VDD VDD _09369_ sky130_fd_sc_hd__nand2_1
X_13420_ _09369_ _09143_ _09145_ VSS VSS VDD VDD _09370_ sky130_fd_sc_hd__o21ai_0
X_13421_ _09361_ _09149_ _09366_ _09370_ _09144_ VSS VSS VDD
+ VDD _09371_ sky130_fd_sc_hd__a32oi_1
X_13422_ network.in_spk08_05 network.in_spk09_05 network.in_spk10_05
+ VSS VSS VDD VDD _09372_ sky130_fd_sc_hd__nor3_1
X_13423_ network.in_spk11_05 _09372_ VSS VSS VDD VDD _09373_
+ sky130_fd_sc_hd__nand2b_1
X_13424_ _09373_ _09172_ _09168_ VSS VSS VDD VDD _09374_ sky130_fd_sc_hd__o21ai_0
X_13425_ net292 _09166_ _09284_ _09374_ VSS VSS VDD VDD _09375_
+ sky130_fd_sc_hd__nand4_1
X_13426_ _09177_ _09357_ _09360_ net441 _09375_ VSS VSS VDD
+ VDD _09376_ sky130_fd_sc_hd__o311ai_2
X_13427_ net292 _09160_ _09263_ VSS VSS VDD VDD _09377_ sky130_fd_sc_hd__nand3_1
X_13428_ network.in_spk12_04 network.in_spk13_04 network.in_spk14_04
+ VSS VSS VDD VDD _09378_ sky130_fd_sc_hd__nor3_1
X_13429_ network.in_spk15_04 _09378_ VSS VSS VDD VDD _09379_
+ sky130_fd_sc_hd__nand2b_1
X_13430_ _09162_ _09379_ _09161_ VSS VSS VDD VDD _09380_ sky130_fd_sc_hd__a21boi_0
X_13431_ _09137_ _09136_ VSS VSS VDD VDD _09381_ sky130_fd_sc_hd__and2b_1
X_13432_ _09302_ _09381_ VSS VSS VDD VDD _09382_ sky130_fd_sc_hd__nor2_1
X_13433_ network.in_spk00_03 network.in_spk01_03 VSS VSS VDD
+ VDD _09383_ sky130_fd_sc_hd__nor2_1
X_13434_ _09301_ _09383_ _09287_ VSS VSS VDD VDD _09384_ sky130_fd_sc_hd__nand3_1
X_13435_ _09377_ _09380_ _09382_ _09384_ VSS VSS VDD VDD _09385_
+ sky130_fd_sc_hd__o22ai_1
X_13436_ network.in_spk08_09 network.in_spk09_09 network.in_spk10_09
+ VSS VSS VDD VDD _09386_ sky130_fd_sc_hd__or3_1
X_13437_ network.in_spk11_09 _09386_ _09205_ VSS VSS VDD VDD
+ _09387_ sky130_fd_sc_hd__nor3_1
X_13438_ _09330_ _09387_ _09206_ VSS VSS VDD VDD _09388_ sky130_fd_sc_hd__o21ai_0
X_13439_ network.in_spk11_07 VSS VSS VDD VDD _09389_ sky130_fd_sc_hd__inv_1
X_13440_ network.in_spk08_07 network.in_spk09_07 network.in_spk10_07
+ VSS VSS VDD VDD _09390_ sky130_fd_sc_hd__nor3_1
X_13441_ _09389_ _09390_ _09181_ _09184_ VSS VSS VDD VDD _09391_
+ sky130_fd_sc_hd__a31oi_1
X_13442_ _09333_ _09334_ _09182_ VSS VSS VDD VDD _09392_ sky130_fd_sc_hd__a21oi_1
X_13443_ net292 _09289_ _09179_ _09392_ VSS VSS VDD VDD _09393_
+ sky130_fd_sc_hd__nand4_1
X_13444_ _09282_ _09388_ _09391_ _09393_ VSS VSS VDD VDD _09394_
+ sky130_fd_sc_hd__o22ai_1
X_13445_ net292 net289 VSS VSS VDD VDD _09395_ sky130_fd_sc_hd__nand2_1
X_13446_ network.in_spk08_08 network.in_spk09_08 network.in_spk10_08
+ network.in_spk11_08 VSS VSS VDD VDD _09396_ sky130_fd_sc_hd__nor4_1
X_13447_ _09396_ _09199_ _09202_ VSS VSS VDD VDD _09397_ sky130_fd_sc_hd__a21oi_1
X_13448_ _09395_ _09200_ net296 _09397_ VSS VSS VDD VDD _09398_
+ sky130_fd_sc_hd__nor4_2
X_13449_ _09376_ _09385_ _09394_ _09398_ VSS VSS VDD VDD _09399_
+ sky130_fd_sc_hd__nor4_1
X_13450_ _09351_ _09353_ _09354_ _09356_ net276 VSS VSS VDD
+ VDD _09400_ sky130_fd_sc_hd__o221a_2
X_13451_ _09195_ _09194_ VSS VSS VDD VDD _09401_ sky130_fd_sc_hd__nand2b_1
X_13452_ network.in_spk00_13 network.in_spk01_13 network.in_spk02_13
+ network.in_spk03_13 VSS VSS VDD VDD _09402_ sky130_fd_sc_hd__or4_1
Xplace335 _07337_ VSS VSS VDD VDD net334 sky130_fd_sc_hd__buf_4
X_13454_ _09192_ _09401_ _09402_ VSS VSS VDD VDD _09404_ sky130_fd_sc_hd__a21oi_1
X_13455_ _09219_ _09217_ VSS VSS VDD VDD _09405_ sky130_fd_sc_hd__nor2b_1
X_13456_ network.in_spk00_11 net285 network.in_spk01_11 _09216_
+ VSS VSS VDD VDD _09406_ sky130_fd_sc_hd__or4b_1
X_13457_ _09405_ _09406_ VSS VSS VDD VDD _09407_ sky130_fd_sc_hd__nor2_1
X_13458_ network.in_spk11_12 _09228_ VSS VSS VDD VDD _09408_
+ sky130_fd_sc_hd__or2_2
X_13459_ _09225_ _09230_ net286 VSS VSS VDD VDD _09409_ sky130_fd_sc_hd__nand3_1
X_13460_ _09226_ _09408_ _09409_ VSS VSS VDD VDD _09410_ sky130_fd_sc_hd__a21oi_1
X_13461_ _09211_ net309 VSS VSS VDD VDD _09411_ sky130_fd_sc_hd__nand2b_1
X_13462_ net292 net289 _09271_ _09214_ VSS VSS VDD VDD _09412_
+ sky130_fd_sc_hd__and4_1
X_13463_ _09212_ _09412_ VSS VSS VDD VDD _09413_ sky130_fd_sc_hd__nand2_1
X_13464_ _09213_ _09411_ _09413_ VSS VSS VDD VDD _09414_ sky130_fd_sc_hd__a21oi_1
X_13465_ net284 _09404_ _09407_ _09410_ _09414_ VSS VSS VDD
+ VDD _09415_ sky130_fd_sc_hd__a2111oi_0
X_13466_ _09400_ _09415_ _09280_ VSS VSS VDD VDD _01726_ sky130_fd_sc_hd__a21oi_1
X_13467_ _09230_ net286 VSS VSS VDD VDD _09416_ sky130_fd_sc_hd__nand2_1
X_13468_ network.in_spk14_12 VSS VSS VDD VDD _09417_ sky130_fd_sc_hd__inv_1
X_13469_ network.in_spk11_12 network.in_spk12_12 network.in_spk13_12
+ VSS VSS VDD VDD _09418_ sky130_fd_sc_hd__nor3_1
X_13470_ _09417_ network.in_spk15_12 _09418_ network.in_spk11_12
+ VSS VSS VDD VDD _09419_ sky130_fd_sc_hd__a31oi_1
X_13471_ _09241_ _09419_ VSS VSS VDD VDD _09420_ sky130_fd_sc_hd__nor2_1
X_13472_ network.in_spk06_12 network.in_spk07_12 VSS VSS VDD
+ VDD _09421_ sky130_fd_sc_hd__nor2_1
X_13473_ network.in_spk04_12 network.in_spk05_12 _09421_ VSS
+ VSS VDD VDD _09422_ sky130_fd_sc_hd__nor3_1
X_13474_ network.in_spk02_12 network.in_spk03_12 _09422_ VSS
+ VSS VDD VDD _09423_ sky130_fd_sc_hd__nor3_1
X_13475_ network.in_spk00_12 network.in_spk01_12 _09423_ VSS
+ VSS VDD VDD _09424_ sky130_fd_sc_hd__nor3_1
X_13476_ network.in_spk14_12 _09418_ network.in_spk10_12 VSS
+ VSS VDD VDD _09425_ sky130_fd_sc_hd__a21oi_1
X_13477_ network.in_spk08_12 network.in_spk09_12 _09240_ _09425_
+ VSS VSS VDD VDD _09426_ sky130_fd_sc_hd__nor4_1
X_13478_ _09420_ _09424_ _09426_ VSS VSS VDD VDD _09427_ sky130_fd_sc_hd__nor3_1
X_13479_ net309 _09322_ VSS VSS VDD VDD _09428_ sky130_fd_sc_hd__nand2_1
X_13480_ network.in_spk12_10 network.in_spk13_10 _09428_ VSS
+ VSS VDD VDD _09429_ sky130_fd_sc_hd__nor3_1
X_13481_ network.in_spk04_10 network.in_spk05_10 VSS VSS VDD
+ VDD _09430_ sky130_fd_sc_hd__nor2_1
X_13482_ network.in_spk08_10 network.in_spk09_10 VSS VSS VDD
+ VDD _09431_ sky130_fd_sc_hd__nor2_1
X_13483_ network.in_spk10_10 _09431_ network.in_spk06_10 network.in_spk07_10
+ VSS VSS VDD VDD _09432_ sky130_fd_sc_hd__a211o_1
X_13484_ _09430_ _09432_ network.in_spk02_10 network.in_spk03_10
+ VSS VSS VDD VDD _09433_ sky130_fd_sc_hd__a211oi_1
X_13485_ network.in_spk00_10 network.in_spk01_10 _09433_ VSS
+ VSS VDD VDD _09434_ sky130_fd_sc_hd__nor3_1
X_13486_ network.in_spk08_10 network.in_spk09_10 network.in_spk10_10
+ VSS VSS VDD VDD _09435_ sky130_fd_sc_hd__or3_1
X_13487_ network.in_spk12_10 network.in_spk13_10 network.in_spk14_10
+ VSS VSS VDD VDD _09436_ sky130_fd_sc_hd__nor3_1
X_13488_ network.in_spk15_10 _09436_ network.in_spk11_10 VSS
+ VSS VDD VDD _09437_ sky130_fd_sc_hd__a21oi_1
X_13489_ _09435_ _09437_ _09322_ VSS VSS VDD VDD _09438_ sky130_fd_sc_hd__nor3b_1
X_13490_ network.in_spk14_10 _09429_ _09434_ _09438_ VSS VSS
+ VDD VDD _09439_ sky130_fd_sc_hd__a211oi_1
X_13491_ network.in_spk01_10 network.in_spk02_10 network.in_spk03_10
+ VSS VSS VDD VDD _09440_ sky130_fd_sc_hd__nor3_1
X_13492_ net309 _09211_ _09213_ _09440_ network.in_spk00_10
+ VSS VSS VDD VDD _09441_ sky130_fd_sc_hd__a41oi_1
X_13493_ net287 _09271_ _09441_ VSS VSS VDD VDD _09442_ sky130_fd_sc_hd__nand3_1
X_13494_ network.in_spk04_11 network.in_spk05_11 VSS VSS VDD
+ VDD _09443_ sky130_fd_sc_hd__or2_2
X_13495_ network.in_spk10_11 network.in_spk11_11 VSS VSS VDD
+ VDD _09444_ sky130_fd_sc_hd__nor2_1
X_13496_ network.in_spk14_11 network.in_spk15_11 _09220_ VSS
+ VSS VDD VDD _09445_ sky130_fd_sc_hd__o21ai_0
X_13497_ _09444_ _09445_ network.in_spk08_11 network.in_spk09_11
+ VSS VSS VDD VDD _09446_ sky130_fd_sc_hd__a211oi_1
X_13498_ network.in_spk06_11 network.in_spk07_11 _09446_ VSS
+ VSS VDD VDD _09447_ sky130_fd_sc_hd__nor3_1
X_13499_ _09443_ _09447_ _09216_ VSS VSS VDD VDD _09448_ sky130_fd_sc_hd__o21ai_0
X_13500_ network.in_spk00_11 network.in_spk01_11 net285 VSS
+ VSS VDD VDD _09449_ sky130_fd_sc_hd__nor3_1
X_13501_ _09439_ _09442_ _09448_ _09449_ VSS VSS VDD VDD _09450_
+ sky130_fd_sc_hd__a2bb2oi_1
X_13502_ network.in_spk12_09 network.in_spk13_09 VSS VSS VDD
+ VDD _09451_ sky130_fd_sc_hd__nor2_1
X_13503_ network.in_spk11_09 _09386_ _09270_ VSS VSS VDD VDD
+ _09452_ sky130_fd_sc_hd__nor3_1
X_13504_ network.in_spk14_09 _09451_ _09452_ VSS VSS VDD VDD
+ _09453_ sky130_fd_sc_hd__nand3_1
X_13505_ network.in_spk08_09 network.in_spk09_09 VSS VSS VDD
+ VDD _09454_ sky130_fd_sc_hd__nor2_1
X_13506_ network.in_spk06_09 network.in_spk07_09 VSS VSS VDD
+ VDD _09455_ sky130_fd_sc_hd__nor2_1
X_13507_ network.in_spk04_09 network.in_spk05_09 _09455_ VSS
+ VSS VDD VDD _09456_ sky130_fd_sc_hd__nor3_1
X_13508_ network.in_spk02_09 network.in_spk03_09 _09456_ _09326_
+ VSS VSS VDD VDD _09457_ sky130_fd_sc_hd__o31a_1
X_13509_ network.in_spk12_09 network.in_spk13_09 network.in_spk14_09
+ VSS VSS VDD VDD _09458_ sky130_fd_sc_hd__nor3_1
X_13510_ network.in_spk15_09 _09458_ network.in_spk11_09 VSS
+ VSS VDD VDD _09459_ sky130_fd_sc_hd__a21oi_1
X_13511_ _09386_ _09270_ _09459_ VSS VSS VDD VDD _09460_ sky130_fd_sc_hd__nor3_1
X_13512_ network.in_spk10_09 _09454_ _09331_ _09457_ _09460_
+ VSS VSS VDD VDD _09461_ sky130_fd_sc_hd__a311oi_1
X_13513_ network.in_spk01_09 network.in_spk02_09 network.in_spk03_09
+ _09330_ VSS VSS VDD VDD _09462_ sky130_fd_sc_hd__nor4_1
X_13514_ _09204_ _09205_ _09462_ network.in_spk00_09 VSS VSS
+ VDD VDD _09463_ sky130_fd_sc_hd__a31oi_1
X_13515_ _09323_ _09463_ VSS VSS VDD VDD _09464_ sky130_fd_sc_hd__nand2_1
X_13516_ _09453_ _09461_ _09464_ VSS VSS VDD VDD _09465_ sky130_fd_sc_hd__a21o_1
X_13517_ network.in_spk04_05 network.in_spk05_05 VSS VSS VDD
+ VDD _09466_ sky130_fd_sc_hd__nor2_1
X_13518_ network.in_spk06_05 _09466_ network.in_spk02_05 network.in_spk03_05
+ VSS VSS VDD VDD _09467_ sky130_fd_sc_hd__a211oi_1
X_13519_ network.in_spk00_05 network.in_spk01_05 _09467_ VSS
+ VSS VDD VDD _09468_ sky130_fd_sc_hd__nor3_1
X_13520_ _09166_ _09168_ VSS VSS VDD VDD _09469_ sky130_fd_sc_hd__nand2_1
X_13521_ network.in_spk12_05 network.in_spk13_05 VSS VSS VDD
+ VDD _09470_ sky130_fd_sc_hd__nor2_1
X_13522_ network.in_spk08_05 network.in_spk09_05 VSS VSS VDD
+ VDD _09471_ sky130_fd_sc_hd__nor2_1
X_13523_ network.in_spk14_05 _09170_ _09470_ _09471_ network.in_spk10_05
+ VSS VSS VDD VDD _09472_ sky130_fd_sc_hd__a32oi_1
X_13524_ _09469_ _09472_ VSS VSS VDD VDD _09473_ sky130_fd_sc_hd__nor2_1
X_13525_ network.in_spk12_05 network.in_spk13_05 network.in_spk14_05
+ VSS VSS VDD VDD _09474_ sky130_fd_sc_hd__nor3_1
X_13526_ network.in_spk15_05 _09474_ network.in_spk07_05 network.in_spk11_05
+ VSS VSS VDD VDD _09475_ sky130_fd_sc_hd__a211oi_1
X_13527_ network.in_spk04_05 network.in_spk05_05 network.in_spk06_05
+ VSS VSS VDD VDD _09476_ sky130_fd_sc_hd__nor3_1
X_13528_ network.in_spk07_05 _09372_ _09476_ _09166_ VSS VSS
+ VDD VDD _09477_ sky130_fd_sc_hd__o211ai_1
X_13529_ _09475_ _09477_ VSS VSS VDD VDD _09478_ sky130_fd_sc_hd__nor2_1
X_13530_ _09468_ _09473_ _09478_ VSS VSS VDD VDD _09479_ sky130_fd_sc_hd__nor3_1
X_13531_ network.in_spk00_05 _09285_ _09479_ VSS VSS VDD VDD
+ _09480_ sky130_fd_sc_hd__nor3_1
X_13532_ network.in_spk12_04 network.in_spk13_04 VSS VSS VDD
+ VDD _09481_ sky130_fd_sc_hd__nor2_1
X_13533_ _09160_ _09161_ _09162_ VSS VSS VDD VDD _09482_ sky130_fd_sc_hd__and3_1
X_13534_ network.in_spk15_04 _09378_ network.in_spk10_04 network.in_spk11_04
+ VSS VSS VDD VDD _09483_ sky130_fd_sc_hd__a211oi_1
X_13535_ network.in_spk08_04 network.in_spk09_04 VSS VSS VDD
+ VDD _09484_ sky130_fd_sc_hd__nor2_1
X_13536_ _09160_ _09161_ _09484_ VSS VSS VDD VDD _09485_ sky130_fd_sc_hd__nand3_1
X_13537_ network.in_spk06_04 network.in_spk07_04 VSS VSS VDD
+ VDD _09486_ sky130_fd_sc_hd__nor2_1
X_13538_ network.in_spk02_04 network.in_spk03_04 VSS VSS VDD
+ VDD _09487_ sky130_fd_sc_hd__nor2_1
X_13539_ network.in_spk04_04 network.in_spk05_04 _09486_ _09487_
+ VSS VSS VDD VDD _09488_ sky130_fd_sc_hd__o31a_1
X_13540_ _09483_ _09485_ _09488_ network.in_spk01_04 VSS VSS
+ VDD VDD _09489_ sky130_fd_sc_hd__o22ai_1
X_13541_ network.in_spk14_04 _09481_ _09482_ _09489_ VSS VSS
+ VDD VDD _09490_ sky130_fd_sc_hd__a31oi_1
X_13542_ _09299_ _09304_ VSS VSS VDD VDD _09491_ sky130_fd_sc_hd__nor2_1
X_13543_ network.in_spk00_04 _09141_ _09164_ VSS VSS VDD VDD
+ _09492_ sky130_fd_sc_hd__nor3_1
X_13544_ net290 _09491_ _09492_ VSS VSS VDD VDD _09493_ sky130_fd_sc_hd__nand3_1
X_13545_ network.in_spk14_01 network.in_spk15_01 VSS VSS VDD
+ VDD _09494_ sky130_fd_sc_hd__nor2_1
X_13546_ network.in_spk06_01 network.in_spk07_01 network.in_spk10_01
+ network.in_spk11_01 VSS VSS VDD VDD _09495_ sky130_fd_sc_hd__nor4_1
X_13547_ network.in_spk12_01 network.in_spk13_01 _09494_ _09495_
+ VSS VSS VDD VDD _09496_ sky130_fd_sc_hd__o31a_1
X_13548_ network.in_spk08_01 network.in_spk09_01 VSS VSS VDD
+ VDD _09497_ sky130_fd_sc_hd__nor2_1
X_13549_ network.in_spk06_01 network.in_spk07_01 _09497_ VSS
+ VSS VDD VDD _09498_ sky130_fd_sc_hd__nor3_1
X_13550_ network.in_spk04_01 network.in_spk05_01 _09496_ _09498_
+ _09295_ VSS VSS VDD VDD _09499_ sky130_fd_sc_hd__o41ai_1
X_13551_ network.in_spk00_00 network.in_spk01_00 VSS VSS VDD
+ VDD _09500_ sky130_fd_sc_hd__nor2_1
X_13552_ network.in_spk06_00 network.in_spk07_00 VSS VSS VDD
+ VDD _09501_ sky130_fd_sc_hd__nor2_1
X_13553_ network.in_spk02_00 network.in_spk03_00 VSS VSS VDD
+ VDD _09502_ sky130_fd_sc_hd__nor2_1
X_13554_ network.in_spk04_00 network.in_spk05_00 _09501_ _09502_
+ VSS VSS VDD VDD _09503_ sky130_fd_sc_hd__o31ai_1
X_13555_ _09368_ _09144_ _09145_ VSS VSS VDD VDD _09504_ sky130_fd_sc_hd__nand3_1
X_13556_ network.in_spk14_00 network.in_spk15_00 VSS VSS VDD
+ VDD _09505_ sky130_fd_sc_hd__nor2_1
X_13557_ network.in_spk12_00 network.in_spk13_00 _09505_ _09367_
+ VSS VSS VDD VDD _09506_ sky130_fd_sc_hd__o31a_1
X_13558_ _09500_ _09503_ _09504_ _09506_ VSS VSS VDD VDD _09507_
+ sky130_fd_sc_hd__o2bb2ai_1
X_13559_ _09294_ _09286_ _09499_ _09507_ VSS VSS VDD VDD _09508_
+ sky130_fd_sc_hd__a31oi_1
X_13560_ network.in_spk00_03 VSS VSS VDD VDD _09509_ sky130_fd_sc_hd__inv_1
X_13561_ network.in_spk08_03 network.in_spk09_03 VSS VSS VDD
+ VDD _09510_ sky130_fd_sc_hd__nor2_1
X_13562_ network.in_spk14_03 network.in_spk15_03 VSS VSS VDD
+ VDD _09511_ sky130_fd_sc_hd__nor2_1
X_13563_ network.in_spk10_03 network.in_spk11_03 VSS VSS VDD
+ VDD _09512_ sky130_fd_sc_hd__nor2_1
X_13564_ network.in_spk12_03 network.in_spk13_03 _09511_ _09512_
+ VSS VSS VDD VDD _09513_ sky130_fd_sc_hd__o31ai_1
X_13565_ network.in_spk06_03 network.in_spk07_03 VSS VSS VDD
+ VDD _09514_ sky130_fd_sc_hd__nor2_1
X_13566_ network.in_spk04_03 network.in_spk05_03 _09514_ _09301_
+ VSS VSS VDD VDD _09515_ sky130_fd_sc_hd__o31ai_1
X_13567_ _09510_ _09303_ _09513_ _09515_ _09383_ VSS VSS VDD
+ VDD _09516_ sky130_fd_sc_hd__a32o_1
X_13568_ _09509_ _09287_ _09516_ VSS VSS VDD VDD _09517_ sky130_fd_sc_hd__nand3_1
X_13569_ network.in_spk02_02 network.in_spk03_02 VSS VSS VDD
+ VDD _09518_ sky130_fd_sc_hd__nor2_1
X_13570_ network.in_spk04_02 network.in_spk05_02 VSS VSS VDD
+ VDD _09519_ sky130_fd_sc_hd__nor2_1
X_13571_ network.in_spk06_02 network.in_spk07_02 _09519_ VSS
+ VSS VDD VDD _09520_ sky130_fd_sc_hd__o21ai_0
X_13572_ _09518_ _09520_ network.in_spk01_02 VSS VSS VDD VDD
+ _09521_ sky130_fd_sc_hd__a21oi_1
X_13573_ network.in_spk10_02 network.in_spk11_02 VSS VSS VDD
+ VDD _09522_ sky130_fd_sc_hd__nor2_1
X_13574_ network.in_spk12_02 network.in_spk13_02 VSS VSS VDD
+ VDD _09523_ sky130_fd_sc_hd__nor2_1
X_13575_ network.in_spk14_02 network.in_spk15_02 _09523_ VSS
+ VSS VDD VDD _09524_ sky130_fd_sc_hd__o21ai_0
X_13576_ _09522_ _09524_ network.in_spk08_02 network.in_spk09_02
+ _09299_ VSS VSS VDD VDD _09525_ sky130_fd_sc_hd__a2111oi_0
X_13577_ network.in_spk00_02 VSS VSS VDD VDD _09526_ sky130_fd_sc_hd__inv_1
X_13578_ _09521_ _09525_ _09526_ net290 _09156_ VSS VSS VDD
+ VDD _09527_ sky130_fd_sc_hd__o2111ai_1
X_13579_ _09490_ _09493_ _09508_ _09517_ _09527_ VSS VSS VDD
+ VDD _09528_ sky130_fd_sc_hd__o2111ai_1
X_13580_ network.in_spk14_08 network.in_spk15_08 VSS VSS VDD
+ VDD _09529_ sky130_fd_sc_hd__nor2_1
X_13581_ network.in_spk12_08 network.in_spk13_08 _09529_ VSS
+ VSS VDD VDD _09530_ sky130_fd_sc_hd__nor3_1
X_13582_ network.in_spk08_08 network.in_spk09_08 VSS VSS VDD
+ VDD _09531_ sky130_fd_sc_hd__nor2_1
X_13583_ network.in_spk10_08 network.in_spk11_08 _09530_ _09318_
+ _09531_ VSS VSS VDD VDD _09532_ sky130_fd_sc_hd__o311ai_0
X_13584_ network.in_spk06_08 network.in_spk07_08 VSS VSS VDD
+ VDD _09533_ sky130_fd_sc_hd__nor2_1
X_13585_ network.in_spk04_08 network.in_spk05_08 _09533_ VSS
+ VSS VDD VDD _09534_ sky130_fd_sc_hd__nor3_1
X_13586_ network.in_spk00_08 network.in_spk01_08 VSS VSS VDD
+ VDD _09535_ sky130_fd_sc_hd__nor2_1
X_13587_ network.in_spk02_08 network.in_spk03_08 _09534_ _09535_
+ VSS VSS VDD VDD _09536_ sky130_fd_sc_hd__o31ai_1
X_13588_ network.in_spk12_08 network.in_spk13_08 VSS VSS VDD
+ VDD _09537_ sky130_fd_sc_hd__nor2_1
X_13589_ network.in_spk01_08 network.in_spk02_08 network.in_spk03_08
+ _09202_ VSS VSS VDD VDD _09538_ sky130_fd_sc_hd__nor4_1
X_13590_ _09396_ _09537_ _09529_ _09538_ network.in_spk00_08
+ VSS VSS VDD VDD _09539_ sky130_fd_sc_hd__a41oi_1
X_13591_ net292 net289 _09539_ VSS VSS VDD VDD _09540_ sky130_fd_sc_hd__nand3_1
X_13592_ _09532_ _09536_ _09540_ VSS VSS VDD VDD _09541_ sky130_fd_sc_hd__a21oi_1
X_13593_ net292 _09289_ _09274_ VSS VSS VDD VDD _09542_ sky130_fd_sc_hd__nand3_1
X_13594_ network.in_spk01_06 VSS VSS VDD VDD _09543_ sky130_fd_sc_hd__inv_1
X_13595_ network.in_spk02_06 network.in_spk03_06 VSS VSS VDD
+ VDD _09544_ sky130_fd_sc_hd__nor2_1
X_13596_ _09543_ _09312_ _09544_ _09314_ network.in_spk00_06
+ VSS VSS VDD VDD _09545_ sky130_fd_sc_hd__a41o_1
X_13597_ network.in_spk08_06 _09177_ _09178_ VSS VSS VDD VDD
+ _09546_ sky130_fd_sc_hd__or3_1
X_13598_ network.in_spk09_06 _09546_ VSS VSS VDD VDD _09547_
+ sky130_fd_sc_hd__nor2_1
X_13599_ network.in_spk14_06 network.in_spk15_06 VSS VSS VDD
+ VDD _09548_ sky130_fd_sc_hd__nor2_1
X_13600_ network.in_spk12_06 network.in_spk13_06 _09548_ _09358_
+ VSS VSS VDD VDD _09549_ sky130_fd_sc_hd__o31ai_1
X_13601_ network.in_spk04_06 network.in_spk05_06 VSS VSS VDD
+ VDD _09550_ sky130_fd_sc_hd__nor2_1
X_13602_ network.in_spk06_06 network.in_spk07_06 _09550_ VSS
+ VSS VDD VDD _09551_ sky130_fd_sc_hd__o21ai_0
X_13603_ _09544_ _09551_ network.in_spk00_06 network.in_spk01_06
+ VSS VSS VDD VDD _09552_ sky130_fd_sc_hd__a211oi_1
X_13604_ _09547_ _09549_ _09552_ VSS VSS VDD VDD _09553_ sky130_fd_sc_hd__a21oi_1
X_13605_ network.in_spk04_07 network.in_spk05_07 VSS VSS VDD
+ VDD _09554_ sky130_fd_sc_hd__nor2_1
X_13606_ network.in_spk10_07 network.in_spk11_07 VSS VSS VDD
+ VDD _09555_ sky130_fd_sc_hd__nor2_1
X_13607_ network.in_spk06_07 network.in_spk07_07 VSS VSS VDD
+ VDD _09556_ sky130_fd_sc_hd__nor2_1
X_13608_ network.in_spk08_07 network.in_spk09_07 _09555_ _09556_
+ VSS VSS VDD VDD _09557_ sky130_fd_sc_hd__o31ai_1
X_13609_ _09554_ _09557_ network.in_spk02_07 network.in_spk03_07
+ VSS VSS VDD VDD _09558_ sky130_fd_sc_hd__a211oi_1
X_13610_ network.in_spk12_07 network.in_spk13_07 VSS VSS VDD
+ VDD _09559_ sky130_fd_sc_hd__nor2_1
X_13611_ _09180_ _09182_ _09184_ VSS VSS VDD VDD _09560_ sky130_fd_sc_hd__nor3_1
X_13612_ network.in_spk14_07 network.in_spk15_07 _09559_ _09560_
+ VSS VSS VDD VDD _09561_ sky130_fd_sc_hd__o211ai_1
X_13613_ network.in_spk00_07 network.in_spk01_07 _09558_ _09561_
+ VSS VSS VDD VDD _09562_ sky130_fd_sc_hd__o31a_1
X_13614_ network.in_spk01_07 network.in_spk02_07 network.in_spk03_07
+ _09184_ VSS VSS VDD VDD _09563_ sky130_fd_sc_hd__nor4_1
X_13615_ _09333_ _09563_ network.in_spk00_07 VSS VSS VDD VDD
+ _09564_ sky130_fd_sc_hd__a21oi_1
X_13616_ net292 _09289_ _09179_ _09564_ VSS VSS VDD VDD _09565_
+ sky130_fd_sc_hd__nand4_1
X_13617_ _09542_ _09545_ _09553_ _09562_ _09565_ VSS VSS VDD
+ VDD _09566_ sky130_fd_sc_hd__o32ai_1
X_13618_ _09480_ _09528_ _09541_ _09566_ VSS VSS VDD VDD _09567_
+ sky130_fd_sc_hd__nor4_1
X_13619_ _09416_ _09427_ _09450_ _09465_ net275 VSS VSS VDD
+ VDD _09568_ sky130_fd_sc_hd__o2111a_1
X_13620_ network.in_spk13_15 network.in_spk12_15 VSS VSS VDD
+ VDD _09569_ sky130_fd_sc_hd__nor2_1
X_13621_ _09352_ _09350_ VSS VSS VDD VDD _09570_ sky130_fd_sc_hd__nand2_1
X_13622_ _09570_ _09248_ VSS VSS VDD VDD _09571_ sky130_fd_sc_hd__nor2_1
X_13623_ network.in_spk05_15 network.in_spk04_15 VSS VSS VDD
+ VDD _09572_ sky130_fd_sc_hd__nor2_1
X_13624_ network.in_spk06_15 _09572_ network.in_spk02_15 network.in_spk03_15
+ VSS VSS VDD VDD _09573_ sky130_fd_sc_hd__a211oi_1
X_13625_ network.in_spk09_15 network.in_spk08_15 VSS VSS VDD
+ VDD _09574_ sky130_fd_sc_hd__nor2_1
X_13626_ network.in_spk10_15 _09574_ VSS VSS VDD VDD _09575_
+ sky130_fd_sc_hd__nand2_1
X_13627_ network.in_spk01_15 network.in_spk00_15 _09573_ _09575_
+ _09570_ VSS VSS VDD VDD _09576_ sky130_fd_sc_hd__o32ai_1
X_13628_ network.in_spk10_15 network.in_spk09_15 network.in_spk08_15
+ VSS VSS VDD VDD _09577_ sky130_fd_sc_hd__nor3_1
X_13629_ network.in_spk15_15 VSS VSS VDD VDD _09578_ sky130_fd_sc_hd__inv_1
X_13630_ _09578_ _09249_ network.in_spk11_15 VSS VSS VDD VDD
+ _09579_ sky130_fd_sc_hd__o21bai_1
X_13631_ _09577_ _09579_ network.in_spk07_15 VSS VSS VDD VDD
+ _09580_ sky130_fd_sc_hd__a21oi_1
X_13632_ _09245_ _09246_ _09580_ VSS VSS VDD VDD _09581_ sky130_fd_sc_hd__nor3_1
X_13633_ network.in_spk14_15 _09569_ _09571_ _09576_ _09581_
+ VSS VSS VDD VDD _09582_ sky130_fd_sc_hd__a311o_1
X_13634_ network.in_spk03_15 network.in_spk02_15 network.in_spk01_15
+ VSS VSS VDD VDD _09583_ sky130_fd_sc_hd__nor3_1
X_13635_ _09350_ _09250_ _09583_ network.in_spk00_15 VSS VSS
+ VDD VDD _09584_ sky130_fd_sc_hd__a31oi_1
X_13636_ _09251_ _09242_ net286 VSS VSS VDD VDD _09585_ sky130_fd_sc_hd__nand3_1
X_13637_ network.in_spk08_13 network.in_spk09_13 VSS VSS VDD
+ VDD _09586_ sky130_fd_sc_hd__nor2_1
X_13638_ _09193_ _09586_ VSS VSS VDD VDD _09587_ sky130_fd_sc_hd__nor2_1
X_13639_ network.in_spk01_13 VSS VSS VDD VDD _09588_ sky130_fd_sc_hd__inv_1
X_13640_ network.in_spk10_13 network.in_spk11_13 _09192_ _09586_
+ VSS VSS VDD VDD _09589_ sky130_fd_sc_hd__o211a_1
X_13641_ network.in_spk02_13 network.in_spk03_13 _09589_ VSS
+ VSS VDD VDD _09590_ sky130_fd_sc_hd__nor3_1
X_13642_ _09588_ _09590_ network.in_spk00_13 VSS VSS VDD VDD
+ _09591_ sky130_fd_sc_hd__a21oi_1
X_13643_ _09404_ _09587_ _09591_ VSS VSS VDD VDD _09592_ sky130_fd_sc_hd__nor3_1
X_13644_ network.in_spk12_13 network.in_spk13_13 network.in_spk14_13
+ VSS VSS VDD VDD _09593_ sky130_fd_sc_hd__nor3_1
X_13645_ _09191_ _09192_ _09194_ VSS VSS VDD VDD _09594_ sky130_fd_sc_hd__and3_1
X_13646_ network.in_spk04_13 network.in_spk05_13 network.in_spk06_13
+ _09402_ VSS VSS VDD VDD _09595_ sky130_fd_sc_hd__nor4_1
X_13647_ network.in_spk15_13 _09593_ _09594_ _09595_ network.in_spk07_13
+ VSS VSS VDD VDD _09596_ sky130_fd_sc_hd__a32oi_1
X_13648_ network.in_spk12_13 network.in_spk13_13 VSS VSS VDD
+ VDD _09597_ sky130_fd_sc_hd__nor2_1
X_13649_ network.in_spk04_13 network.in_spk05_13 _09402_ VSS
+ VSS VDD VDD _09598_ sky130_fd_sc_hd__nor3_1
X_13650_ network.in_spk14_13 _09597_ _09594_ _09598_ network.in_spk06_13
+ VSS VSS VDD VDD _09599_ sky130_fd_sc_hd__a32oi_1
X_13651_ network.in_spk00_13 network.in_spk01_13 _09590_ _09596_
+ _09599_ VSS VSS VDD VDD _09600_ sky130_fd_sc_hd__o311a_1
X_13652_ _09585_ _09592_ _09600_ VSS VSS VDD VDD _09601_ sky130_fd_sc_hd__nor3_1
X_13653_ _09233_ _09234_ VSS VSS VDD VDD _09602_ sky130_fd_sc_hd__nand2_1
X_13654_ network.in_spk09_14 network.in_spk08_14 _09602_ VSS
+ VSS VDD VDD _09603_ sky130_fd_sc_hd__nor3_1
X_13655_ network.in_spk14_14 network.in_spk13_14 network.in_spk12_14
+ VSS VSS VDD VDD _09604_ sky130_fd_sc_hd__nor3_1
X_13656_ network.in_spk15_14 _09604_ network.in_spk11_14 network.in_spk07_14
+ VSS VSS VDD VDD _09605_ sky130_fd_sc_hd__a211oi_1
X_13657_ network.in_spk10_14 network.in_spk09_14 network.in_spk08_14
+ VSS VSS VDD VDD _09606_ sky130_fd_sc_hd__nor3_1
X_13658_ network.in_spk07_14 _09606_ VSS VSS VDD VDD _09607_
+ sky130_fd_sc_hd__nor2_1
X_13659_ _09345_ _09605_ _09607_ VSS VSS VDD VDD _09608_ sky130_fd_sc_hd__nor3_1
X_13660_ network.in_spk13_14 network.in_spk12_14 _09236_ network.in_spk14_14
+ VSS VSS VDD VDD _09609_ sky130_fd_sc_hd__nor4b_1
X_13661_ network.in_spk06_14 _09344_ network.in_spk03_14 network.in_spk02_14
+ VSS VSS VDD VDD _09610_ sky130_fd_sc_hd__a211oi_1
X_13662_ network.in_spk00_14 network.in_spk01_14 _09610_ VSS
+ VSS VDD VDD _09611_ sky130_fd_sc_hd__nor3_1
X_13663_ network.in_spk10_14 _09603_ _09608_ _09609_ _09611_
+ VSS VSS VDD VDD _09612_ sky130_fd_sc_hd__a2111oi_0
X_13664_ network.in_spk00_14 _09261_ _09612_ VSS VSS VDD VDD
+ _09613_ sky130_fd_sc_hd__nor3_1
X_13665_ _09340_ _09582_ _09584_ _09601_ _09613_ VSS VSS VDD
+ VDD _09614_ sky130_fd_sc_hd__a311oi_1
X_13666_ _09568_ _09614_ _09280_ VSS VSS VDD VDD _01727_ sky130_fd_sc_hd__a21oi_1
X_13667_ network.in_spk00_05 _09285_ VSS VSS VDD VDD _09615_
+ sky130_fd_sc_hd__or2_2
X_13668_ network.in_spk03_05 VSS VSS VDD VDD _09616_ sky130_fd_sc_hd__inv_1
X_13669_ network.in_spk04_05 network.in_spk05_05 VSS VSS VDD
+ VDD _09617_ sky130_fd_sc_hd__nand2b_1
X_13670_ _09616_ _09617_ network.in_spk02_05 VSS VSS VDD VDD
+ _09618_ sky130_fd_sc_hd__a21oi_1
X_13671_ network.in_spk01_05 _09618_ VSS VSS VDD VDD _09619_
+ sky130_fd_sc_hd__nor2_1
X_13672_ network.in_spk12_05 VSS VSS VDD VDD _09620_ sky130_fd_sc_hd__inv_1
X_13673_ network.in_spk08_05 VSS VSS VDD VDD _09621_ sky130_fd_sc_hd__inv_1
X_13674_ _09620_ network.in_spk13_05 _09170_ network.in_spk09_05
+ _09621_ VSS VSS VDD VDD _09622_ sky130_fd_sc_hd__a32oi_1
X_13675_ network.in_spk00_05 _09619_ _09622_ _09469_ VSS VSS
+ VDD VDD _09623_ sky130_fd_sc_hd__o22ai_1
X_13676_ _09478_ _09623_ VSS VSS VDD VDD _09624_ sky130_fd_sc_hd__nor2_1
X_13677_ network.in_spk14_04 VSS VSS VDD VDD _09625_ sky130_fd_sc_hd__inv_1
X_13678_ _09625_ network.in_spk15_04 network.in_spk13_04 VSS
+ VSS VDD VDD _09626_ sky130_fd_sc_hd__a21oi_1
X_13679_ network.in_spk12_04 _09626_ VSS VSS VDD VDD _09627_
+ sky130_fd_sc_hd__nor2_1
X_13680_ network.in_spk08_04 VSS VSS VDD VDD _09628_ sky130_fd_sc_hd__inv_1
X_13681_ network.in_spk08_04 network.in_spk10_04 VSS VSS VDD
+ VDD _09629_ sky130_fd_sc_hd__nor2_1
X_13682_ _09628_ network.in_spk09_04 network.in_spk11_04 _09629_
+ network.in_spk07_04 VSS VSS VDD VDD _09630_ sky130_fd_sc_hd__a221oi_1
X_13683_ network.in_spk04_04 network.in_spk06_04 _09630_ VSS
+ VSS VDD VDD _09631_ sky130_fd_sc_hd__or3_1
X_13684_ network.in_spk04_04 VSS VSS VDD VDD _09632_ sky130_fd_sc_hd__inv_1
X_13685_ _09632_ network.in_spk05_04 network.in_spk03_04 VSS
+ VSS VDD VDD _09633_ sky130_fd_sc_hd__a21oi_1
X_13686_ _09631_ _09633_ network.in_spk02_04 VSS VSS VDD VDD
+ _09634_ sky130_fd_sc_hd__a21oi_1
X_13687_ _09482_ _09627_ _09634_ network.in_spk01_04 VSS VSS
+ VDD VDD _09635_ sky130_fd_sc_hd__a211oi_1
X_13688_ _09526_ net290 _09156_ VSS VSS VDD VDD _09636_ sky130_fd_sc_hd__nand3_1
X_13689_ network.in_spk14_02 network.in_spk15_02 VSS VSS VDD
+ VDD _09637_ sky130_fd_sc_hd__nor2b_1
X_13690_ network.in_spk10_02 network.in_spk12_02 VSS VSS VDD
+ VDD _09638_ sky130_fd_sc_hd__nor2_1
X_13691_ network.in_spk13_02 _09637_ _09638_ VSS VSS VDD VDD
+ _09639_ sky130_fd_sc_hd__o21ai_0
X_13692_ network.in_spk10_02 VSS VSS VDD VDD _09640_ sky130_fd_sc_hd__inv_1
X_13693_ _09640_ network.in_spk11_02 network.in_spk09_02 VSS
+ VSS VDD VDD _09641_ sky130_fd_sc_hd__a21oi_1
X_13694_ _09639_ _09641_ network.in_spk08_02 _09299_ VSS VSS
+ VDD VDD _09642_ sky130_fd_sc_hd__a211oi_1
X_13695_ network.in_spk04_02 VSS VSS VDD VDD _09643_ sky130_fd_sc_hd__inv_1
X_13696_ network.in_spk04_02 network.in_spk06_02 VSS VSS VDD
+ VDD _09644_ sky130_fd_sc_hd__nor2_1
X_13697_ _09643_ network.in_spk05_02 network.in_spk07_02 _09644_
+ network.in_spk03_02 VSS VSS VDD VDD _09645_ sky130_fd_sc_hd__a221oi_1
X_13698_ network.in_spk02_02 _09645_ VSS VSS VDD VDD _09646_
+ sky130_fd_sc_hd__nor2_1
X_13699_ network.in_spk01_02 _09642_ _09646_ VSS VSS VDD VDD
+ _09647_ sky130_fd_sc_hd__nor3_1
X_13700_ network.in_spk14_01 network.in_spk15_01 VSS VSS VDD
+ VDD _09648_ sky130_fd_sc_hd__nor2b_1
X_13701_ network.in_spk10_01 network.in_spk12_01 VSS VSS VDD
+ VDD _09649_ sky130_fd_sc_hd__nor2_1
X_13702_ network.in_spk13_01 _09648_ _09649_ VSS VSS VDD VDD
+ _09650_ sky130_fd_sc_hd__o21ai_0
X_13703_ network.in_spk10_01 VSS VSS VDD VDD _09651_ sky130_fd_sc_hd__inv_1
X_13704_ _09651_ network.in_spk11_01 network.in_spk09_01 VSS
+ VSS VDD VDD _09652_ sky130_fd_sc_hd__a21oi_1
X_13705_ _09650_ _09652_ network.in_spk08_01 _09296_ _09297_
+ VSS VSS VDD VDD _09653_ sky130_fd_sc_hd__a2111oi_0
X_13706_ network.in_spk03_01 VSS VSS VDD VDD _09654_ sky130_fd_sc_hd__inv_1
X_13707_ network.in_spk06_01 network.in_spk07_01 VSS VSS VDD
+ VDD _09655_ sky130_fd_sc_hd__nor2b_1
X_13708_ network.in_spk05_01 _09655_ network.in_spk04_01 VSS
+ VSS VDD VDD _09656_ sky130_fd_sc_hd__o21bai_1
X_13709_ _09654_ _09656_ network.in_spk02_01 VSS VSS VDD VDD
+ _09657_ sky130_fd_sc_hd__a21oi_1
X_13710_ network.in_spk01_01 network.in_spk02_01 network.in_spk03_01
+ _09297_ VSS VSS VDD VDD _09658_ sky130_fd_sc_hd__nor4_1
X_13711_ _09147_ _09148_ _09658_ _09146_ network.in_spk00_01
+ VSS VSS VDD VDD _09659_ sky130_fd_sc_hd__a311oi_1
X_13712_ network.in_spk01_01 _09653_ _09657_ _09659_ VSS VSS
+ VDD VDD _09660_ sky130_fd_sc_hd__o31ai_2
X_13713_ network.in_spk00_00 VSS VSS VDD VDD _09661_ sky130_fd_sc_hd__inv_1
X_13714_ network.in_spk04_00 VSS VSS VDD VDD _09662_ sky130_fd_sc_hd__inv_1
X_13715_ _09662_ network.in_spk05_00 network.in_spk03_00 VSS
+ VSS VDD VDD _09663_ sky130_fd_sc_hd__a21oi_1
X_13716_ network.in_spk02_00 _09663_ network.in_spk01_00 VSS
+ VSS VDD VDD _09664_ sky130_fd_sc_hd__o21bai_1
X_13717_ network.in_spk10_00 VSS VSS VDD VDD _09665_ sky130_fd_sc_hd__inv_1
X_13718_ _09665_ network.in_spk11_00 network.in_spk09_00 VSS
+ VSS VDD VDD _09666_ sky130_fd_sc_hd__a21oi_1
X_13719_ network.in_spk08_00 _09666_ network.in_spk07_00 VSS
+ VSS VDD VDD _09667_ sky130_fd_sc_hd__o21bai_1
X_13720_ _09500_ _09502_ VSS VSS VDD VDD _09668_ sky130_fd_sc_hd__nand2_1
X_13721_ network.in_spk04_00 network.in_spk05_00 network.in_spk06_00
+ _09668_ VSS VSS VDD VDD _09669_ sky130_fd_sc_hd__nor4_1
X_13722_ _09142_ _09144_ _09145_ VSS VSS VDD VDD _09670_ sky130_fd_sc_hd__nand3_1
X_13723_ network.in_spk14_00 VSS VSS VDD VDD _09671_ sky130_fd_sc_hd__inv_1
X_13724_ _09671_ network.in_spk15_00 network.in_spk13_00 VSS
+ VSS VDD VDD _09672_ sky130_fd_sc_hd__a21oi_1
X_13725_ network.in_spk12_00 _09670_ _09672_ VSS VSS VDD VDD
+ _09673_ sky130_fd_sc_hd__nor3_1
X_13726_ _09661_ _09664_ _09667_ _09669_ _09673_ VSS VSS VDD
+ VDD _09674_ sky130_fd_sc_hd__a221oi_1
X_13727_ _09636_ _09647_ _09660_ _09674_ VSS VSS VDD VDD _09675_
+ sky130_fd_sc_hd__o211a_1
X_13728_ _09615_ _09624_ _09635_ _09493_ _09675_ VSS VSS VDD
+ VDD _09676_ sky130_fd_sc_hd__o221a_2
X_13729_ _09139_ _09140_ VSS VSS VDD VDD _09677_ sky130_fd_sc_hd__nand2_1
X_13730_ network.in_spk14_03 network.in_spk15_03 VSS VSS VDD
+ VDD _09678_ sky130_fd_sc_hd__nor2b_1
X_13731_ network.in_spk13_03 _09678_ _09136_ VSS VSS VDD VDD
+ _09679_ sky130_fd_sc_hd__o21ai_0
X_13732_ network.in_spk12_03 _09677_ _09679_ VSS VSS VDD VDD
+ _09680_ sky130_fd_sc_hd__nor3_1
X_13733_ network.in_spk04_03 VSS VSS VDD VDD _09681_ sky130_fd_sc_hd__inv_1
X_13734_ network.in_spk10_03 VSS VSS VDD VDD _09682_ sky130_fd_sc_hd__inv_1
X_13735_ _09682_ network.in_spk11_03 network.in_spk09_03 VSS
+ VSS VDD VDD _09683_ sky130_fd_sc_hd__a21oi_1
X_13736_ network.in_spk08_03 _09683_ network.in_spk07_03 VSS
+ VSS VDD VDD _09684_ sky130_fd_sc_hd__o21bai_1
X_13737_ network.in_spk04_03 network.in_spk06_03 VSS VSS VDD
+ VDD _09685_ sky130_fd_sc_hd__nor2_1
X_13738_ _09681_ network.in_spk05_03 _09684_ _09685_ network.in_spk03_03
+ VSS VSS VDD VDD _09686_ sky130_fd_sc_hd__a221oi_1
X_13739_ network.in_spk02_03 _09686_ network.in_spk01_03 VSS
+ VSS VDD VDD _03343_ sky130_fd_sc_hd__o21bai_1
X_13740_ _09680_ _03343_ _09509_ _09287_ VSS VSS VDD VDD _03344_
+ sky130_fd_sc_hd__o211ai_1
X_13741_ network.in_spk04_07 VSS VSS VDD VDD _03345_ sky130_fd_sc_hd__inv_1
X_13742_ _03345_ network.in_spk05_07 network.in_spk03_07 VSS
+ VSS VDD VDD _03346_ sky130_fd_sc_hd__a21oi_1
X_13743_ network.in_spk02_07 _03346_ VSS VSS VDD VDD _03347_
+ sky130_fd_sc_hd__nor2_1
X_13744_ network.in_spk01_07 _03347_ VSS VSS VDD VDD _03348_
+ sky130_fd_sc_hd__nor2_1
X_13745_ network.in_spk04_07 network.in_spk05_07 network.in_spk06_07
+ _09182_ VSS VSS VDD VDD _03349_ sky130_fd_sc_hd__or4_1
X_13746_ network.in_spk11_07 _09390_ network.in_spk07_07 VSS
+ VSS VDD VDD _03350_ sky130_fd_sc_hd__a21oi_1
X_13747_ network.in_spk00_07 _03348_ _03349_ _03350_ VSS VSS
+ VDD VDD _03351_ sky130_fd_sc_hd__o22ai_1
X_13748_ network.in_spk14_07 VSS VSS VDD VDD _03352_ sky130_fd_sc_hd__inv_1
X_13749_ _03352_ network.in_spk15_07 network.in_spk13_07 VSS
+ VSS VDD VDD _03353_ sky130_fd_sc_hd__a21oi_1
X_13750_ network.in_spk09_07 VSS VSS VDD VDD _03354_ sky130_fd_sc_hd__inv_1
X_13751_ network.in_spk12_07 _09180_ _03353_ _03354_ network.in_spk08_07
+ VSS VSS VDD VDD _03355_ sky130_fd_sc_hd__o32a_1
X_13752_ _09335_ _03355_ VSS VSS VDD VDD _03356_ sky130_fd_sc_hd__nor2_1
X_13753_ _03351_ _03356_ _09565_ VSS VSS VDD VDD _03357_ sky130_fd_sc_hd__o21bai_1
X_13754_ _09542_ _09545_ VSS VSS VDD VDD _03358_ sky130_fd_sc_hd__nor2_1
X_13755_ network.in_spk10_06 VSS VSS VDD VDD _03359_ sky130_fd_sc_hd__inv_1
X_13756_ network.in_spk14_06 VSS VSS VDD VDD _03360_ sky130_fd_sc_hd__inv_1
X_13757_ _03360_ network.in_spk15_06 network.in_spk13_06 VSS
+ VSS VDD VDD _03361_ sky130_fd_sc_hd__a21oi_1
X_13758_ network.in_spk12_06 _03361_ network.in_spk11_06 VSS
+ VSS VDD VDD _03362_ sky130_fd_sc_hd__o21bai_1
X_13759_ _03359_ _03362_ network.in_spk09_06 VSS VSS VDD VDD
+ _03363_ sky130_fd_sc_hd__a21oi_1
X_13760_ network.in_spk04_06 network.in_spk05_06 network.in_spk06_06
+ VSS VSS VDD VDD _03364_ sky130_fd_sc_hd__nor3_1
X_13761_ network.in_spk04_06 network.in_spk05_06 VSS VSS VDD
+ VDD _03365_ sky130_fd_sc_hd__nor2b_1
X_13762_ network.in_spk03_06 _03365_ network.in_spk02_06 VSS
+ VSS VDD VDD _03366_ sky130_fd_sc_hd__o21bai_1
X_13763_ _09543_ _03366_ network.in_spk00_06 VSS VSS VDD VDD
+ _03367_ sky130_fd_sc_hd__a21oi_1
X_13764_ network.in_spk07_06 _09313_ _03364_ _03367_ VSS VSS
+ VDD VDD _03368_ sky130_fd_sc_hd__a31oi_1
X_13765_ _09546_ _03363_ _03368_ VSS VSS VDD VDD _03369_ sky130_fd_sc_hd__o21ai_0
X_13766_ _09396_ _09318_ VSS VSS VDD VDD _03370_ sky130_fd_sc_hd__nand2_1
X_13767_ network.in_spk14_08 VSS VSS VDD VDD _03371_ sky130_fd_sc_hd__inv_1
X_13768_ _03371_ network.in_spk15_08 network.in_spk13_08 VSS
+ VSS VDD VDD _03372_ sky130_fd_sc_hd__a21oi_1
X_13769_ network.in_spk12_08 _03370_ _03372_ VSS VSS VDD VDD
+ _03373_ sky130_fd_sc_hd__or3_1
X_13770_ network.in_spk10_08 VSS VSS VDD VDD _03374_ sky130_fd_sc_hd__inv_1
X_13771_ _03374_ network.in_spk11_08 network.in_spk09_08 VSS
+ VSS VDD VDD _03375_ sky130_fd_sc_hd__a21oi_1
X_13772_ network.in_spk08_08 _03375_ VSS VSS VDD VDD _03376_
+ sky130_fd_sc_hd__nor2_1
X_13773_ network.in_spk04_08 network.in_spk05_08 network.in_spk06_08
+ _09200_ VSS VSS VDD VDD _03377_ sky130_fd_sc_hd__nor4_1
X_13774_ network.in_spk07_08 _03376_ _03377_ VSS VSS VDD VDD
+ _03378_ sky130_fd_sc_hd__o21ai_0
X_13775_ network.in_spk04_08 VSS VSS VDD VDD _03379_ sky130_fd_sc_hd__inv_1
X_13776_ _03379_ network.in_spk05_08 network.in_spk03_08 VSS
+ VSS VDD VDD _03380_ sky130_fd_sc_hd__a21oi_1
X_13777_ network.in_spk02_08 _03380_ VSS VSS VDD VDD _03381_
+ sky130_fd_sc_hd__nor2_1
X_13778_ network.in_spk01_08 _03381_ VSS VSS VDD VDD _03382_
+ sky130_fd_sc_hd__nor2_1
X_13779_ _03373_ _03378_ _03382_ _09540_ VSS VSS VDD VDD _03383_
+ sky130_fd_sc_hd__a31oi_2
X_13780_ _03358_ _03369_ _03383_ VSS VSS VDD VDD _03384_ sky130_fd_sc_hd__a21oi_1
X_13781_ _09676_ _03344_ _03357_ _03384_ VSS VSS VDD VDD _03385_
+ sky130_fd_sc_hd__and4_1
X_13782_ _09218_ _09219_ VSS VSS VDD VDD _03386_ sky130_fd_sc_hd__nand2_1
X_13783_ network.in_spk14_11 VSS VSS VDD VDD _03387_ sky130_fd_sc_hd__inv_1
X_13784_ _03387_ network.in_spk15_11 network.in_spk13_11 VSS
+ VSS VDD VDD _03388_ sky130_fd_sc_hd__a21oi_1
X_13785_ network.in_spk12_11 _03386_ _03388_ VSS VSS VDD VDD
+ _03389_ sky130_fd_sc_hd__nor3_1
X_13786_ _09215_ _09216_ VSS VSS VDD VDD _03390_ sky130_fd_sc_hd__nand2_1
X_13787_ network.in_spk09_11 VSS VSS VDD VDD _03391_ sky130_fd_sc_hd__inv_1
X_13788_ network.in_spk10_11 network.in_spk11_11 VSS VSS VDD
+ VDD _03392_ sky130_fd_sc_hd__nand2b_1
X_13789_ _03391_ _03392_ network.in_spk08_11 VSS VSS VDD VDD
+ _03393_ sky130_fd_sc_hd__a21oi_1
X_13790_ network.in_spk07_11 _03393_ VSS VSS VDD VDD _03394_
+ sky130_fd_sc_hd__nor2_1
X_13791_ network.in_spk06_11 _03390_ _09443_ _03394_ VSS VSS
+ VDD VDD _03395_ sky130_fd_sc_hd__nor4_1
X_13792_ network.in_spk04_11 VSS VSS VDD VDD _03396_ sky130_fd_sc_hd__inv_1
X_13793_ _03396_ network.in_spk05_11 network.in_spk03_11 VSS
+ VSS VDD VDD _03397_ sky130_fd_sc_hd__a21oi_1
X_13794_ network.in_spk02_11 _03397_ VSS VSS VDD VDD _03398_
+ sky130_fd_sc_hd__nor2_1
X_13795_ network.in_spk01_11 _03389_ _03395_ _03398_ VSS VSS
+ VDD VDD _03399_ sky130_fd_sc_hd__nor4_2
X_13796_ network.in_spk12_09 network.in_spk13_09 VSS VSS VDD
+ VDD _03400_ sky130_fd_sc_hd__nor2b_1
X_13797_ network.in_spk08_09 VSS VSS VDD VDD _03401_ sky130_fd_sc_hd__inv_1
X_13798_ _03401_ network.in_spk09_09 network.in_spk07_09 VSS
+ VSS VDD VDD _03402_ sky130_fd_sc_hd__a21oi_1
X_13799_ network.in_spk03_09 VSS VSS VDD VDD _03403_ sky130_fd_sc_hd__inv_1
X_13800_ network.in_spk04_09 network.in_spk05_09 VSS VSS VDD
+ VDD _03404_ sky130_fd_sc_hd__nand2b_1
X_13801_ _03403_ _03404_ network.in_spk02_09 VSS VSS VDD VDD
+ _03405_ sky130_fd_sc_hd__a21oi_1
X_13802_ network.in_spk01_09 _03405_ VSS VSS VDD VDD _03406_
+ sky130_fd_sc_hd__nor2_1
X_13803_ _09328_ _09329_ _03402_ _03406_ network.in_spk00_09
+ VSS VSS VDD VDD _03407_ sky130_fd_sc_hd__o32ai_1
X_13804_ _09452_ _03400_ _03407_ _09460_ VSS VSS VDD VDD _03408_
+ sky130_fd_sc_hd__a211oi_1
X_13805_ net287 net296 _09463_ VSS VSS VDD VDD _03409_ sky130_fd_sc_hd__nand3_1
X_13806_ network.in_spk00_11 net285 _03399_ _03408_ _03409_
+ VSS VSS VDD VDD _03410_ sky130_fd_sc_hd__o32ai_1
X_13807_ network.in_spk12_13 VSS VSS VDD VDD _03411_ sky130_fd_sc_hd__inv_1
X_13808_ _03411_ network.in_spk13_13 network.in_spk11_13 VSS
+ VSS VDD VDD _03412_ sky130_fd_sc_hd__a21oi_1
X_13809_ network.in_spk10_13 _03412_ VSS VSS VDD VDD _03413_
+ sky130_fd_sc_hd__nor2_1
X_13810_ network.in_spk09_13 _03413_ VSS VSS VDD VDD _03414_
+ sky130_fd_sc_hd__nor2_1
X_13811_ network.in_spk04_13 VSS VSS VDD VDD _03415_ sky130_fd_sc_hd__inv_1
X_13812_ _03415_ network.in_spk05_13 network.in_spk03_13 VSS
+ VSS VDD VDD _03416_ sky130_fd_sc_hd__a21oi_1
X_13813_ network.in_spk02_13 _03416_ VSS VSS VDD VDD _03417_
+ sky130_fd_sc_hd__nor2_1
X_13814_ network.in_spk01_13 _03417_ VSS VSS VDD VDD _03418_
+ sky130_fd_sc_hd__nor2_1
X_13815_ network.in_spk08_13 _09193_ _03414_ _03418_ network.in_spk00_13
+ VSS VSS VDD VDD _03419_ sky130_fd_sc_hd__o32a_1
X_13816_ _09596_ _03419_ _09255_ _09592_ VSS VSS VDD VDD _03420_
+ sky130_fd_sc_hd__a211oi_1
X_13817_ network.in_spk02_12 VSS VSS VDD VDD _03421_ sky130_fd_sc_hd__inv_1
X_13818_ network.in_spk06_12 VSS VSS VDD VDD _03422_ sky130_fd_sc_hd__inv_1
X_13819_ _03422_ network.in_spk07_12 network.in_spk05_12 VSS
+ VSS VDD VDD _03423_ sky130_fd_sc_hd__a21oi_1
X_13820_ network.in_spk04_12 _03423_ network.in_spk03_12 VSS
+ VSS VDD VDD _03424_ sky130_fd_sc_hd__o21bai_1
X_13821_ _03421_ _03424_ network.in_spk01_12 VSS VSS VDD VDD
+ _03425_ sky130_fd_sc_hd__a21oi_1
X_13822_ network.in_spk10_12 network.in_spk11_12 network.in_spk12_12
+ network.in_spk13_12 VSS VSS VDD VDD _03426_ sky130_fd_sc_hd__nor4b_1
X_13823_ network.in_spk09_12 _03426_ VSS VSS VDD VDD _03427_
+ sky130_fd_sc_hd__nor2_1
X_13824_ network.in_spk08_12 _09240_ _03427_ _09419_ _09241_
+ VSS VSS VDD VDD _03428_ sky130_fd_sc_hd__o32a_1
X_13825_ network.in_spk00_12 _03425_ _03428_ VSS VSS VDD VDD
+ _03429_ sky130_fd_sc_hd__o21a_1
X_13826_ _09428_ network.in_spk12_10 network.in_spk13_10 VSS
+ VSS VDD VDD _03430_ sky130_fd_sc_hd__nor3b_1
X_13827_ network.in_spk03_10 VSS VSS VDD VDD _03431_ sky130_fd_sc_hd__inv_1
X_13828_ network.in_spk04_10 network.in_spk05_10 VSS VSS VDD
+ VDD _03432_ sky130_fd_sc_hd__nand2b_1
X_13829_ _03431_ _03432_ network.in_spk02_10 VSS VSS VDD VDD
+ _03433_ sky130_fd_sc_hd__a21oi_1
X_13830_ network.in_spk01_10 _03433_ VSS VSS VDD VDD _03434_
+ sky130_fd_sc_hd__nor2_1
X_13831_ network.in_spk08_10 VSS VSS VDD VDD _03435_ sky130_fd_sc_hd__inv_1
X_13832_ _03435_ network.in_spk09_10 network.in_spk07_10 VSS
+ VSS VDD VDD _03436_ sky130_fd_sc_hd__a21oi_1
X_13833_ network.in_spk06_10 _09212_ _09430_ VSS VSS VDD VDD
+ _03437_ sky130_fd_sc_hd__nand3b_1
X_13834_ network.in_spk00_10 _03434_ _03436_ _03437_ VSS VSS
+ VDD VDD _03438_ sky130_fd_sc_hd__o22ai_1
X_13835_ _09438_ _03430_ _03438_ VSS VSS VDD VDD _03439_ sky130_fd_sc_hd__nor3_1
X_13836_ net287 _09271_ _09441_ VSS VSS VDD VDD _03440_ sky130_fd_sc_hd__nand3_1
X_13837_ _09254_ _03429_ _03439_ _03440_ VSS VSS VDD VDD _03441_
+ sky130_fd_sc_hd__o22ai_1
X_13838_ network.in_spk08_14 _09602_ VSS VSS VDD VDD _03442_
+ sky130_fd_sc_hd__nor2_1
X_13839_ network.in_spk04_14 VSS VSS VDD VDD _03443_ sky130_fd_sc_hd__inv_1
X_13840_ _03443_ network.in_spk05_14 network.in_spk03_14 VSS
+ VSS VDD VDD _03444_ sky130_fd_sc_hd__a21oi_1
X_13841_ network.in_spk02_14 _03444_ network.in_spk01_14 VSS
+ VSS VDD VDD _03445_ sky130_fd_sc_hd__o21bai_1
X_13842_ network.in_spk12_14 _09236_ network.in_spk13_14 VSS
+ VSS VDD VDD _03446_ sky130_fd_sc_hd__nor3b_1
X_13843_ network.in_spk09_14 _03442_ _03445_ _03446_ _09608_
+ VSS VSS VDD VDD _03447_ sky130_fd_sc_hd__a2111oi_0
X_13844_ network.in_spk12_15 VSS VSS VDD VDD _03448_ sky130_fd_sc_hd__inv_1
X_13845_ network.in_spk09_15 VSS VSS VDD VDD _03449_ sky130_fd_sc_hd__inv_1
X_13846_ network.in_spk03_15 VSS VSS VDD VDD _03450_ sky130_fd_sc_hd__inv_1
X_13847_ network.in_spk04_15 network.in_spk05_15 VSS VSS VDD
+ VDD _03451_ sky130_fd_sc_hd__nand2b_1
X_13848_ _03450_ _03451_ network.in_spk02_15 VSS VSS VDD VDD
+ _03452_ sky130_fd_sc_hd__a21oi_1
X_13849_ network.in_spk01_15 _03452_ VSS VSS VDD VDD _03453_
+ sky130_fd_sc_hd__nor2_1
X_13850_ _03449_ network.in_spk08_15 _09570_ _03453_ network.in_spk00_15
+ VSS VSS VDD VDD _03454_ sky130_fd_sc_hd__o32ai_1
X_13851_ network.in_spk13_15 _03448_ _09571_ _03454_ _09581_
+ VSS VSS VDD VDD _03455_ sky130_fd_sc_hd__a311oi_1
X_13852_ network.in_spk00_14 _09239_ _03447_ _03455_ _09253_
+ VSS VSS VDD VDD _03456_ sky130_fd_sc_hd__o32ai_1
X_13853_ _03410_ _03420_ _03441_ _03456_ VSS VSS VDD VDD _03457_
+ sky130_fd_sc_hd__nor4_2
X_13854_ _03385_ _03457_ _09280_ VSS VSS VDD VDD _01728_ sky130_fd_sc_hd__a21oi_1
X_13855_ network.neuron_hid7.IF0.ref_counter\[1\] VSS VSS
+ VDD VDD _01125_ sky130_fd_sc_hd__inv_1
X_13856_ network.neuron_in009.counter\[2\] net369 VSS VSS
+ VDD VDD _03458_ sky130_fd_sc_hd__nand2_1
X_13857_ network.neuron_in009.counter\[3\] network.in_period\[9\]\[2\]
+ _03458_ VSS VSS VDD VDD _03459_ sky130_fd_sc_hd__o21ai_0
X_13858_ _00482_ network.neuron_in009.counter\[2\] net350
+ VSS VSS VDD VDD _03460_ sky130_fd_sc_hd__or3_1
X_13859_ network.in_period\[9\]\[2\] net369 _03460_ VSS VSS
+ VDD VDD _03461_ sky130_fd_sc_hd__o21ai_0
X_13860_ _00482_ _03459_ _03461_ VSS VSS VDD VDD _02101_ sky130_fd_sc_hd__a21oi_1
X_13861_ network.neuron_in009.counter\[2\] network.neuron_in009.counter\[3\]
+ VSS VSS VDD VDD _03462_ sky130_fd_sc_hd__nor2_1
X_13862_ _00482_ _03462_ VSS VSS VDD VDD _03463_ sky130_fd_sc_hd__nand2_1
X_13863_ net369 _03463_ VSS VSS VDD VDD _03464_ sky130_fd_sc_hd__nand2_1
X_13864_ network.in_period\[9\]\[1\] _03464_ VSS VSS VDD VDD
+ _03465_ sky130_fd_sc_hd__nand2_1
X_13865_ _00483_ _03464_ _03465_ VSS VSS VDD VDD _02100_ sky130_fd_sc_hd__o21ai_0
X_13866_ network.in_period\[9\]\[0\] _03464_ VSS VSS VDD VDD
+ _03466_ sky130_fd_sc_hd__nand2_1
X_13867_ network.neuron_in009.counter\[0\] _03464_ _03466_
+ VSS VSS VDD VDD _02099_ sky130_fd_sc_hd__o21ai_0
X_13868_ network.neuron_in010.counter\[2\] VSS VSS VDD VDD
+ _03467_ sky130_fd_sc_hd__inv_1
X_13869_ network.in_period\[10\]\[2\] network.neuron_in010.counter\[3\]
+ net350 _00478_ VSS VSS VDD VDD _03468_ sky130_fd_sc_hd__o22ai_1
X_13870_ network.neuron_in010.counter\[2\] _00478_ net369
+ VSS VSS VDD VDD _03469_ sky130_fd_sc_hd__nand3_1
X_13871_ network.in_period\[10\]\[2\] net369 _03469_ VSS VSS
+ VDD VDD _03470_ sky130_fd_sc_hd__o21ai_0
X_13872_ _03467_ _03468_ _03470_ VSS VSS VDD VDD _02105_ sky130_fd_sc_hd__a21oi_1
X_13873_ network.neuron_in010.counter\[3\] _00478_ VSS VSS
+ VDD VDD _03471_ sky130_fd_sc_hd__nand2b_1
X_13874_ _03471_ _03467_ VSS VSS VDD VDD _03472_ sky130_fd_sc_hd__nand2b_1
X_13875_ net369 _03472_ VSS VSS VDD VDD _03473_ sky130_fd_sc_hd__nand2_1
X_13876_ network.in_period\[10\]\[1\] _03473_ VSS VSS VDD
+ VDD _03474_ sky130_fd_sc_hd__nand2_1
X_13877_ _00479_ _03473_ _03474_ VSS VSS VDD VDD _02104_ sky130_fd_sc_hd__o21ai_0
X_13878_ network.in_period\[10\]\[0\] _03473_ VSS VSS VDD
+ VDD _03475_ sky130_fd_sc_hd__nand2_1
X_13879_ network.neuron_in010.counter\[0\] _03473_ _03475_
+ VSS VSS VDD VDD _02103_ sky130_fd_sc_hd__o21ai_0
X_13880_ network.neuron_in120.counter\[0\] VSS VSS VDD VDD
+ _00962_ sky130_fd_sc_hd__inv_1
X_13881_ network.in_period\[140\]\[1\] _07825_ VSS VSS VDD
+ VDD _03476_ sky130_fd_sc_hd__nand2_1
X_13882_ _01082_ _07825_ _03476_ VSS VSS VDD VDD _02624_ sky130_fd_sc_hd__o21ai_0
X_13883_ network.neuron_in011.counter\[2\] net369 VSS VSS
+ VDD VDD _03477_ sky130_fd_sc_hd__nand2_1
X_13884_ network.in_period\[11\]\[2\] network.neuron_in011.counter\[3\]
+ _03477_ VSS VSS VDD VDD _03478_ sky130_fd_sc_hd__o21ai_0
X_13885_ _00456_ network.neuron_in011.counter\[2\] net350
+ VSS VSS VDD VDD _03479_ sky130_fd_sc_hd__or3_1
X_13886_ network.in_period\[11\]\[2\] net369 _03479_ VSS VSS
+ VDD VDD _03480_ sky130_fd_sc_hd__o21ai_0
X_13887_ _00456_ _03478_ _03480_ VSS VSS VDD VDD _02109_ sky130_fd_sc_hd__a21oi_1
Xplace334 _07352_ VSS VSS VDD VDD net333 sky130_fd_sc_hd__buf_4
X_13889_ network.neuron_in011.counter\[2\] _00456_ VSS VSS
+ VDD VDD _03482_ sky130_fd_sc_hd__nand2b_1
X_13890_ network.neuron_in011.counter\[3\] _03482_ VSS VSS
+ VDD VDD _03483_ sky130_fd_sc_hd__or2_2
X_13891_ net369 _03483_ VSS VSS VDD VDD _03484_ sky130_fd_sc_hd__nand2_1
X_13892_ network.in_period\[11\]\[1\] _03484_ VSS VSS VDD
+ VDD _03485_ sky130_fd_sc_hd__nand2_1
X_13893_ _00457_ _03484_ _03485_ VSS VSS VDD VDD _02108_ sky130_fd_sc_hd__o21ai_0
X_13894_ network.neuron_in011.counter\[0\] VSS VSS VDD VDD
+ _00454_ sky130_fd_sc_hd__inv_1
X_13895_ network.in_period\[11\]\[0\] _03484_ VSS VSS VDD
+ VDD _03486_ sky130_fd_sc_hd__nand2_1
X_13896_ network.neuron_in011.counter\[0\] _03484_ _03486_
+ VSS VSS VDD VDD _02107_ sky130_fd_sc_hd__o21ai_0
X_13897_ network.neuron_in049.counter\[0\] VSS VSS VDD VDD
+ _00261_ sky130_fd_sc_hd__inv_1
X_13898_ network.neuron_in012.counter\[2\] net368 VSS VSS
+ VDD VDD _03487_ sky130_fd_sc_hd__nand2_1
X_13899_ network.in_period\[12\]\[2\] network.neuron_in012.counter\[3\]
+ _03487_ VSS VSS VDD VDD _03488_ sky130_fd_sc_hd__o21ai_0
X_13900_ _00452_ network.neuron_in012.counter\[2\] net351
+ VSS VSS VDD VDD _03489_ sky130_fd_sc_hd__or3_1
X_13901_ network.in_period\[12\]\[2\] net368 _03489_ VSS VSS
+ VDD VDD _03490_ sky130_fd_sc_hd__o21ai_0
X_13902_ _00452_ _03488_ _03490_ VSS VSS VDD VDD _02113_ sky130_fd_sc_hd__a21oi_1
X_13903_ network.neuron_in012.counter\[2\] _00452_ VSS VSS
+ VDD VDD _03491_ sky130_fd_sc_hd__nand2b_1
X_13904_ network.neuron_in012.counter\[3\] _03491_ VSS VSS
+ VDD VDD _03492_ sky130_fd_sc_hd__or2_2
X_13905_ net368 _03492_ VSS VSS VDD VDD _03493_ sky130_fd_sc_hd__nand2_1
X_13906_ network.in_period\[12\]\[1\] _03493_ VSS VSS VDD
+ VDD _03494_ sky130_fd_sc_hd__nand2_1
X_13907_ _00453_ _03493_ _03494_ VSS VSS VDD VDD _02112_ sky130_fd_sc_hd__o21ai_0
X_13908_ network.neuron_in012.counter\[0\] VSS VSS VDD VDD
+ _00450_ sky130_fd_sc_hd__inv_1
X_13909_ network.in_period\[12\]\[0\] _03493_ VSS VSS VDD
+ VDD _03495_ sky130_fd_sc_hd__nand2_1
X_13910_ network.neuron_in012.counter\[0\] _03493_ _03495_
+ VSS VSS VDD VDD _02111_ sky130_fd_sc_hd__o21ai_0
X_13911_ network.neuron_in013.counter\[2\] VSS VSS VDD VDD
+ _03496_ sky130_fd_sc_hd__inv_1
X_13912_ network.in_period\[13\]\[2\] network.neuron_in013.counter\[3\]
+ _00448_ net351 VSS VSS VDD VDD _03497_ sky130_fd_sc_hd__o22ai_1
Xplace333 _07354_ VSS VSS VDD VDD net332 sky130_fd_sc_hd__buf_4
X_13914_ network.neuron_in013.counter\[2\] _00448_ net368
+ VSS VSS VDD VDD _03499_ sky130_fd_sc_hd__nand3_1
X_13915_ network.in_period\[13\]\[2\] net368 _03499_ VSS VSS
+ VDD VDD _03500_ sky130_fd_sc_hd__o21ai_0
X_13916_ _03496_ _03497_ _03500_ VSS VSS VDD VDD _02117_ sky130_fd_sc_hd__a21oi_1
X_13917_ network.neuron_in137.counter\[2\] network.neuron_in137.counter\[3\]
+ VSS VSS VDD VDD _03501_ sky130_fd_sc_hd__nor2_1
X_13918_ _00685_ _03501_ VSS VSS VDD VDD _03502_ sky130_fd_sc_hd__nand2_1
X_13919_ net377 _03502_ VSS VSS VDD VDD _03503_ sky130_fd_sc_hd__nand2_1
X_13920_ net661 _03503_ VSS VSS VDD VDD _03504_ sky130_fd_sc_hd__nand2_1
X_13921_ _00686_ _03503_ _03504_ VSS VSS VDD VDD _02612_ sky130_fd_sc_hd__o21ai_0
X_13922_ network.neuron_in205.counter\[1\] VSS VSS VDD VDD
+ _00959_ sky130_fd_sc_hd__inv_1
X_13923_ net358 _03501_ VSS VSS VDD VDD _03505_ sky130_fd_sc_hd__nor2_1
X_13924_ network.neuron_in137.counter\[2\] _00685_ VSS VSS
+ VDD VDD _03506_ sky130_fd_sc_hd__xnor2_1
X_13925_ network.in_period\[137\]\[2\] _03505_ _03506_ net377
+ VSS VSS VDD VDD _02613_ sky130_fd_sc_hd__a2bb2oi_1
X_13926_ network.neuron_in014.counter\[0\] VSS VSS VDD VDD
+ _00438_ sky130_fd_sc_hd__inv_1
X_13927_ network.neuron_in014.counter\[3\] _00440_ VSS VSS
+ VDD VDD _03507_ sky130_fd_sc_hd__nand2b_1
X_13928_ network.neuron_in014.counter\[2\] _03507_ VSS VSS
+ VDD VDD _03508_ sky130_fd_sc_hd__or2_2
X_13929_ net368 _03508_ VSS VSS VDD VDD _03509_ sky130_fd_sc_hd__nand2_1
X_13930_ net787 _03509_ VSS VSS VDD VDD _03510_ sky130_fd_sc_hd__nand2_1
X_13931_ network.neuron_in014.counter\[0\] _03509_ _03510_
+ VSS VSS VDD VDD _02119_ sky130_fd_sc_hd__o21ai_0
X_13932_ network.neuron_in013.counter\[2\] network.neuron_in013.counter\[3\]
+ VSS VSS VDD VDD _03511_ sky130_fd_sc_hd__nor2_1
X_13933_ _00448_ _03511_ VSS VSS VDD VDD _03512_ sky130_fd_sc_hd__nand2_1
X_13934_ net368 _03512_ VSS VSS VDD VDD _03513_ sky130_fd_sc_hd__nand2_1
X_13935_ network.in_period\[13\]\[1\] _03513_ VSS VSS VDD
+ VDD _03514_ sky130_fd_sc_hd__nand2_1
X_13936_ _00449_ _03513_ _03514_ VSS VSS VDD VDD _02116_ sky130_fd_sc_hd__o21ai_0
X_13937_ network.neuron_in013.counter\[0\] VSS VSS VDD VDD
+ _00446_ sky130_fd_sc_hd__inv_1
X_13938_ network.in_period\[13\]\[0\] _03513_ VSS VSS VDD
+ VDD _03515_ sky130_fd_sc_hd__nand2_1
X_13939_ network.neuron_in013.counter\[0\] _03513_ _03515_
+ VSS VSS VDD VDD _02115_ sky130_fd_sc_hd__o21ai_0
X_13940_ network.neuron_in014.counter\[2\] net368 VSS VSS
+ VDD VDD _03516_ sky130_fd_sc_hd__nand2_1
X_13941_ network.in_period\[14\]\[2\] network.neuron_in014.counter\[3\]
+ _03516_ VSS VSS VDD VDD _03517_ sky130_fd_sc_hd__o21ai_0
X_13942_ _00440_ network.neuron_in014.counter\[2\] net351
+ VSS VSS VDD VDD _03518_ sky130_fd_sc_hd__or3_1
X_13943_ network.in_period\[14\]\[2\] net368 _03518_ VSS VSS
+ VDD VDD _03519_ sky130_fd_sc_hd__o21ai_0
X_13944_ _00440_ _03517_ _03519_ VSS VSS VDD VDD _02121_ sky130_fd_sc_hd__a21oi_1
X_13945_ network.in_period\[14\]\[1\] _03509_ VSS VSS VDD
+ VDD _03520_ sky130_fd_sc_hd__nand2_1
X_13946_ _00441_ _03509_ _03520_ VSS VSS VDD VDD _02120_ sky130_fd_sc_hd__o21ai_0
X_13947_ network.neuron_in057.counter\[0\] VSS VSS VDD VDD
+ _00237_ sky130_fd_sc_hd__inv_1
X_13948_ network.neuron_in139.counter\[3\] network.in_period\[139\]\[2\]
+ _01095_ net358 VSS VSS VDD VDD _03521_ sky130_fd_sc_hd__o22ai_1
X_13949_ network.neuron_in139.counter\[2\] _01095_ net377
+ VSS VSS VDD VDD _03522_ sky130_fd_sc_hd__nand3_1
X_13950_ network.in_period\[139\]\[2\] net377 _03522_ VSS
+ VSS VDD VDD _03523_ sky130_fd_sc_hd__o21ai_0
X_13951_ _08339_ _03521_ _03523_ VSS VSS VDD VDD _02621_ sky130_fd_sc_hd__a21oi_1
X_13952_ network.neuron_in048.counter\[0\] VSS VSS VDD VDD
+ _00265_ sky130_fd_sc_hd__inv_1
X_13953_ network.neuron_in099.counter\[1\] VSS VSS VDD VDD
+ _00705_ sky130_fd_sc_hd__inv_1
X_13954_ network.neuron_in015.counter\[2\] VSS VSS VDD VDD
+ _03524_ sky130_fd_sc_hd__inv_1
X_13955_ network.in_period\[15\]\[2\] network.neuron_in015.counter\[3\]
+ _00444_ net351 VSS VSS VDD VDD _03525_ sky130_fd_sc_hd__o22ai_1
X_13956_ network.neuron_in015.counter\[2\] _00444_ net368
+ VSS VSS VDD VDD _03526_ sky130_fd_sc_hd__nand3_1
X_13957_ network.in_period\[15\]\[2\] net368 _03526_ VSS VSS
+ VDD VDD _03527_ sky130_fd_sc_hd__o21ai_0
X_13958_ _03524_ _03525_ _03527_ VSS VSS VDD VDD _02125_ sky130_fd_sc_hd__a21oi_1
X_13959_ _03524_ _00444_ VSS VSS VDD VDD _03528_ sky130_fd_sc_hd__nand2_1
X_13960_ network.neuron_in015.counter\[3\] _03528_ VSS VSS
+ VDD VDD _03529_ sky130_fd_sc_hd__or2_2
X_13961_ net368 _03529_ VSS VSS VDD VDD _03530_ sky130_fd_sc_hd__nand2_1
X_13962_ network.in_period\[15\]\[1\] _03530_ VSS VSS VDD
+ VDD _03531_ sky130_fd_sc_hd__nand2_1
X_13963_ _00445_ _03530_ _03531_ VSS VSS VDD VDD _02124_ sky130_fd_sc_hd__o21ai_0
X_13964_ network.neuron_in015.counter\[0\] VSS VSS VDD VDD
+ _00442_ sky130_fd_sc_hd__inv_1
X_13965_ network.in_period\[15\]\[0\] _03530_ VSS VSS VDD
+ VDD _03532_ sky130_fd_sc_hd__nand2_1
X_13966_ network.neuron_in015.counter\[0\] _03530_ _03532_
+ VSS VSS VDD VDD _02123_ sky130_fd_sc_hd__o21ai_0
X_13967_ network.neuron_in100.counter\[0\] VSS VSS VDD VDD
+ _00053_ sky130_fd_sc_hd__inv_1
X_13968_ network.neuron_in138.counter\[3\] _00614_ VSS VSS
+ VDD VDD _03533_ sky130_fd_sc_hd__nand2b_1
X_13969_ network.neuron_in138.counter\[2\] VSS VSS VDD VDD
+ _03534_ sky130_fd_sc_hd__inv_1
X_13970_ _03533_ _03534_ VSS VSS VDD VDD _03535_ sky130_fd_sc_hd__nand2b_1
X_13971_ net377 _03535_ VSS VSS VDD VDD _03536_ sky130_fd_sc_hd__nand2_1
X_13972_ net699 _03536_ VSS VSS VDD VDD _03537_ sky130_fd_sc_hd__nand2_1
X_13973_ _00615_ _03536_ _03537_ VSS VSS VDD VDD _02616_ sky130_fd_sc_hd__o21ai_0
X_13974_ net666 _03536_ VSS VSS VDD VDD _03538_ sky130_fd_sc_hd__nand2_1
X_13975_ network.neuron_in138.counter\[0\] _03536_ _03538_
+ VSS VSS VDD VDD _02615_ sky130_fd_sc_hd__o21ai_0
X_13976_ network.neuron_in017.counter\[2\] VSS VSS VDD VDD
+ _03539_ sky130_fd_sc_hd__inv_1
X_13977_ network.in_period\[17\]\[2\] network.neuron_in017.counter\[3\]
+ _00419_ net350 VSS VSS VDD VDD _03540_ sky130_fd_sc_hd__o22ai_1
X_13978_ network.neuron_in017.counter\[2\] _00419_ net369
+ VSS VSS VDD VDD _03541_ sky130_fd_sc_hd__nand3_1
X_13979_ network.in_period\[17\]\[2\] net369 _03541_ VSS VSS
+ VDD VDD _03542_ sky130_fd_sc_hd__o21ai_0
X_13980_ _03539_ _03540_ _03542_ VSS VSS VDD VDD _02133_ sky130_fd_sc_hd__a21oi_1
X_13981_ network.neuron_in017.counter\[3\] _00419_ VSS VSS
+ VDD VDD _03543_ sky130_fd_sc_hd__nand2b_1
X_13982_ _03543_ _03539_ VSS VSS VDD VDD _03544_ sky130_fd_sc_hd__nand2b_1
X_13983_ net369 _03544_ VSS VSS VDD VDD _03545_ sky130_fd_sc_hd__nand2_1
X_13984_ network.in_period\[17\]\[1\] _03545_ VSS VSS VDD
+ VDD _03546_ sky130_fd_sc_hd__nand2_1
X_13985_ _00420_ _03545_ _03546_ VSS VSS VDD VDD _02132_ sky130_fd_sc_hd__o21ai_0
X_13986_ network.neuron_in017.counter\[0\] VSS VSS VDD VDD
+ _00417_ sky130_fd_sc_hd__inv_1
X_13987_ network.in_period\[17\]\[0\] _03545_ VSS VSS VDD
+ VDD _03547_ sky130_fd_sc_hd__nand2_1
X_13988_ network.neuron_in017.counter\[0\] _03545_ _03547_
+ VSS VSS VDD VDD _02131_ sky130_fd_sc_hd__o21ai_0
X_13989_ network.neuron_in016.counter\[2\] net369 VSS VSS
+ VDD VDD _03548_ sky130_fd_sc_hd__nand2_1
X_13990_ network.in_period\[16\]\[2\] network.neuron_in016.counter\[3\]
+ _03548_ VSS VSS VDD VDD _03549_ sky130_fd_sc_hd__o21ai_0
X_13991_ _00427_ network.neuron_in016.counter\[2\] net350
+ VSS VSS VDD VDD _03550_ sky130_fd_sc_hd__or3_1
X_13992_ network.in_period\[16\]\[2\] net369 _03550_ VSS VSS
+ VDD VDD _03551_ sky130_fd_sc_hd__o21ai_0
X_13993_ _00427_ _03549_ _03551_ VSS VSS VDD VDD _02129_ sky130_fd_sc_hd__a21oi_1
X_13994_ network.neuron_in016.counter\[2\] _00427_ VSS VSS
+ VDD VDD _03552_ sky130_fd_sc_hd__nand2b_1
X_13995_ network.neuron_in016.counter\[3\] _03552_ VSS VSS
+ VDD VDD _03553_ sky130_fd_sc_hd__or2_2
X_13996_ net369 _03553_ VSS VSS VDD VDD _03554_ sky130_fd_sc_hd__nand2_1
X_13997_ network.in_period\[16\]\[1\] _03554_ VSS VSS VDD
+ VDD _03555_ sky130_fd_sc_hd__nand2_1
X_13998_ _00428_ _03554_ _03555_ VSS VSS VDD VDD _02128_ sky130_fd_sc_hd__o21ai_0
X_13999_ network.neuron_in016.counter\[0\] VSS VSS VDD VDD
+ _00425_ sky130_fd_sc_hd__inv_1
X_14000_ network.in_period\[16\]\[0\] _03554_ VSS VSS VDD
+ VDD _03556_ sky130_fd_sc_hd__nand2_1
X_14001_ network.neuron_in016.counter\[0\] _03554_ _03556_
+ VSS VSS VDD VDD _02127_ sky130_fd_sc_hd__o21ai_0
X_14002_ network.neuron_in211.counter\[1\] VSS VSS VDD VDD
+ _00955_ sky130_fd_sc_hd__inv_1
X_14003_ network.neuron_in181.counter\[1\] VSS VSS VDD VDD
+ _00846_ sky130_fd_sc_hd__inv_1
X_14004_ network.neuron_in018.counter\[2\] net369 VSS VSS
+ VDD VDD _03557_ sky130_fd_sc_hd__nand2_1
X_14005_ network.in_period\[18\]\[2\] network.neuron_in018.counter\[3\]
+ _03557_ VSS VSS VDD VDD _03558_ sky130_fd_sc_hd__o21ai_0
X_14006_ _00423_ network.neuron_in018.counter\[2\] net350
+ VSS VSS VDD VDD _03559_ sky130_fd_sc_hd__or3_1
X_14007_ network.in_period\[18\]\[2\] net369 _03559_ VSS VSS
+ VDD VDD _03560_ sky130_fd_sc_hd__o21ai_0
X_14008_ _00423_ _03558_ _03560_ VSS VSS VDD VDD _02137_ sky130_fd_sc_hd__a21oi_1
X_14009_ network.neuron_in018.counter\[3\] _00423_ VSS VSS
+ VDD VDD _03561_ sky130_fd_sc_hd__nand2b_1
X_14010_ network.neuron_in018.counter\[2\] _03561_ VSS VSS
+ VDD VDD _03562_ sky130_fd_sc_hd__or2_2
X_14011_ net369 _03562_ VSS VSS VDD VDD _03563_ sky130_fd_sc_hd__nand2_1
X_14012_ network.in_period\[18\]\[1\] _03563_ VSS VSS VDD
+ VDD _03564_ sky130_fd_sc_hd__nand2_1
X_14013_ _00424_ _03563_ _03564_ VSS VSS VDD VDD _02136_ sky130_fd_sc_hd__o21ai_0
X_14014_ network.neuron_in018.counter\[0\] VSS VSS VDD VDD
+ _00421_ sky130_fd_sc_hd__inv_1
X_14015_ network.in_period\[18\]\[0\] _03563_ VSS VSS VDD
+ VDD _03565_ sky130_fd_sc_hd__nand2_1
X_14016_ network.neuron_in018.counter\[0\] _03563_ _03565_
+ VSS VSS VDD VDD _02135_ sky130_fd_sc_hd__o21ai_0
X_14017_ network.neuron_in019.counter\[2\] VSS VSS VDD VDD
+ _03566_ sky130_fd_sc_hd__inv_1
X_14018_ network.in_period\[19\]\[2\] network.neuron_in019.counter\[3\]
+ _00415_ net350 VSS VSS VDD VDD _03567_ sky130_fd_sc_hd__o22ai_1
X_14019_ network.neuron_in019.counter\[2\] _00415_ net369
+ VSS VSS VDD VDD _03568_ sky130_fd_sc_hd__nand3_1
X_14020_ network.in_period\[19\]\[2\] net369 _03568_ VSS VSS
+ VDD VDD _03569_ sky130_fd_sc_hd__o21ai_0
X_14021_ _03566_ _03567_ _03569_ VSS VSS VDD VDD _02141_ sky130_fd_sc_hd__a21oi_1
X_14022_ network.neuron_in085.counter\[0\] VSS VSS VDD VDD
+ _00042_ sky130_fd_sc_hd__inv_1
X_14023_ _03566_ _00415_ VSS VSS VDD VDD _03570_ sky130_fd_sc_hd__nand2_1
X_14024_ network.neuron_in019.counter\[3\] _03570_ VSS VSS
+ VDD VDD _03571_ sky130_fd_sc_hd__or2_2
X_14025_ net369 _03571_ VSS VSS VDD VDD _03572_ sky130_fd_sc_hd__nand2_1
X_14026_ network.in_period\[19\]\[1\] _03572_ VSS VSS VDD
+ VDD _03573_ sky130_fd_sc_hd__nand2_1
X_14027_ _00416_ _03572_ _03573_ VSS VSS VDD VDD _02140_ sky130_fd_sc_hd__o21ai_0
X_14028_ network.in_period\[19\]\[0\] _03572_ VSS VSS VDD
+ VDD _03574_ sky130_fd_sc_hd__nand2_1
X_14029_ network.neuron_in019.counter\[0\] _03572_ _03574_
+ VSS VSS VDD VDD _02139_ sky130_fd_sc_hd__o21ai_0
X_14030_ network.neuron_in168.counter\[1\] VSS VSS VDD VDD
+ _00951_ sky130_fd_sc_hd__inv_1
X_14031_ network.neuron_in020.counter\[2\] VSS VSS VDD VDD
+ _03575_ sky130_fd_sc_hd__inv_1
Xplace332 _07374_ VSS VSS VDD VDD net331 sky130_fd_sc_hd__buf_4
X_14033_ network.in_period\[20\]\[2\] network.neuron_in020.counter\[3\]
+ _00407_ net352 VSS VSS VDD VDD _03577_ sky130_fd_sc_hd__o22ai_1
X_14034_ network.neuron_in020.counter\[2\] _00407_ net370
+ VSS VSS VDD VDD _03578_ sky130_fd_sc_hd__nand3_1
X_14035_ network.in_period\[20\]\[2\] net370 _03578_ VSS VSS
+ VDD VDD _03579_ sky130_fd_sc_hd__o21ai_0
X_14036_ _03575_ _03577_ _03579_ VSS VSS VDD VDD _02145_ sky130_fd_sc_hd__a21oi_1
X_14037_ network.neuron_in020.counter\[3\] _00407_ VSS VSS
+ VDD VDD _03580_ sky130_fd_sc_hd__nand2b_1
X_14038_ _03580_ _03575_ VSS VSS VDD VDD _03581_ sky130_fd_sc_hd__nand2b_1
X_14039_ net370 _03581_ VSS VSS VDD VDD _03582_ sky130_fd_sc_hd__nand2_1
X_14040_ network.in_period\[20\]\[1\] _03582_ VSS VSS VDD
+ VDD _03583_ sky130_fd_sc_hd__nand2_1
X_14041_ _00408_ _03582_ _03583_ VSS VSS VDD VDD _02144_ sky130_fd_sc_hd__o21ai_0
X_14042_ network.neuron_in020.counter\[0\] VSS VSS VDD VDD
+ _00405_ sky130_fd_sc_hd__inv_1
X_14043_ network.in_period\[20\]\[0\] _03582_ VSS VSS VDD
+ VDD _03584_ sky130_fd_sc_hd__nand2_1
X_14044_ network.neuron_in020.counter\[0\] _03582_ _03584_
+ VSS VSS VDD VDD _02143_ sky130_fd_sc_hd__o21ai_0
X_14045_ network.neuron_in021.counter\[2\] VSS VSS VDD VDD
+ _03585_ sky130_fd_sc_hd__inv_1
X_14046_ network.neuron_in021.counter\[3\] network.in_period\[21\]\[2\]
+ _00411_ net352 VSS VSS VDD VDD _03586_ sky130_fd_sc_hd__o22ai_1
Xplace331 _07381_ VSS VSS VDD VDD net330 sky130_fd_sc_hd__buf_4
X_14048_ network.neuron_in021.counter\[2\] _00411_ net370
+ VSS VSS VDD VDD _03588_ sky130_fd_sc_hd__nand3_1
X_14049_ network.in_period\[21\]\[2\] net370 _03588_ VSS VSS
+ VDD VDD _03589_ sky130_fd_sc_hd__o21ai_0
X_14050_ _03585_ _03586_ _03589_ VSS VSS VDD VDD _02149_ sky130_fd_sc_hd__a21oi_1
X_14051_ network.neuron_in092.counter\[1\] VSS VSS VDD VDD
+ _01228_ sky130_fd_sc_hd__inv_1
X_14052_ network.neuron_in021.counter\[2\] network.neuron_in021.counter\[3\]
+ VSS VSS VDD VDD _03590_ sky130_fd_sc_hd__nor2_1
X_14053_ _00411_ _03590_ VSS VSS VDD VDD _03591_ sky130_fd_sc_hd__nand2_1
X_14054_ net370 _03591_ VSS VSS VDD VDD _03592_ sky130_fd_sc_hd__nand2_1
X_14055_ net803 _03592_ VSS VSS VDD VDD _03593_ sky130_fd_sc_hd__nand2_1
X_14056_ _00412_ _03592_ _03593_ VSS VSS VDD VDD _02148_ sky130_fd_sc_hd__o21ai_0
X_14057_ net711 _03592_ VSS VSS VDD VDD _03594_ sky130_fd_sc_hd__nand2_1
X_14058_ network.neuron_in021.counter\[0\] _03592_ _03594_
+ VSS VSS VDD VDD _02147_ sky130_fd_sc_hd__o21ai_0
X_14059_ network.neuron_in022.counter\[2\] VSS VSS VDD VDD
+ _03595_ sky130_fd_sc_hd__inv_1
X_14060_ network.in_period\[22\]\[2\] network.neuron_in022.counter\[3\]
+ net350 _00399_ VSS VSS VDD VDD _03596_ sky130_fd_sc_hd__o22ai_1
Xplace330 _07384_ VSS VSS VDD VDD net329 sky130_fd_sc_hd__buf_4
X_14062_ network.neuron_in022.counter\[2\] _00399_ net370
+ VSS VSS VDD VDD _03598_ sky130_fd_sc_hd__nand3_1
X_14063_ network.in_period\[22\]\[2\] net370 _03598_ VSS VSS
+ VDD VDD _03599_ sky130_fd_sc_hd__o21ai_0
X_14064_ _03595_ _03596_ _03599_ VSS VSS VDD VDD _02153_ sky130_fd_sc_hd__a21oi_1
X_14065_ network.neuron_in022.counter\[3\] VSS VSS VDD VDD
+ _03600_ sky130_fd_sc_hd__inv_1
X_14066_ _03595_ _00399_ _03600_ VSS VSS VDD VDD _03601_ sky130_fd_sc_hd__nand3_1
X_14067_ net370 _03601_ VSS VSS VDD VDD _03602_ sky130_fd_sc_hd__nand2_1
X_14068_ network.in_period\[22\]\[1\] _03602_ VSS VSS VDD
+ VDD _03603_ sky130_fd_sc_hd__nand2_1
X_14069_ _00400_ _03602_ _03603_ VSS VSS VDD VDD _02152_ sky130_fd_sc_hd__o21ai_0
X_14070_ network.neuron_in022.counter\[0\] VSS VSS VDD VDD
+ _00397_ sky130_fd_sc_hd__inv_1
X_14071_ network.in_period\[22\]\[0\] _03602_ VSS VSS VDD
+ VDD _03604_ sky130_fd_sc_hd__nand2_1
X_14072_ network.neuron_in022.counter\[0\] _03602_ _03604_
+ VSS VSS VDD VDD _02151_ sky130_fd_sc_hd__o21ai_0
X_14073_ network.neuron_in023.counter\[2\] VSS VSS VDD VDD
+ _03605_ sky130_fd_sc_hd__inv_1
X_14074_ network.in_period\[23\]\[2\] network.neuron_in023.counter\[3\]
+ _00387_ net352 VSS VSS VDD VDD _03606_ sky130_fd_sc_hd__o22ai_1
X_14075_ network.neuron_in023.counter\[2\] _00387_ net370
+ VSS VSS VDD VDD _03607_ sky130_fd_sc_hd__nand3_1
X_14076_ network.in_period\[23\]\[2\] net370 _03607_ VSS VSS
+ VDD VDD _03608_ sky130_fd_sc_hd__o21ai_0
X_14077_ _03605_ _03606_ _03608_ VSS VSS VDD VDD _02157_ sky130_fd_sc_hd__a21oi_1
Xplace326 _07428_ VSS VSS VDD VDD net325 sky130_fd_sc_hd__buf_4
X_14079_ _03605_ _00387_ VSS VSS VDD VDD _03610_ sky130_fd_sc_hd__nand2_1
X_14080_ network.neuron_in023.counter\[3\] _03610_ VSS VSS
+ VDD VDD _03611_ sky130_fd_sc_hd__or2_2
X_14081_ net370 _03611_ VSS VSS VDD VDD _03612_ sky130_fd_sc_hd__nand2_1
X_14082_ network.in_period\[23\]\[1\] _03612_ VSS VSS VDD
+ VDD _03613_ sky130_fd_sc_hd__nand2_1
X_14083_ _00388_ _03612_ _03613_ VSS VSS VDD VDD _02156_ sky130_fd_sc_hd__o21ai_0
X_14084_ network.neuron_in023.counter\[0\] VSS VSS VDD VDD
+ _00385_ sky130_fd_sc_hd__inv_1
X_14085_ network.in_period\[23\]\[0\] _03612_ VSS VSS VDD
+ VDD _03614_ sky130_fd_sc_hd__nand2_1
X_14086_ network.neuron_in023.counter\[0\] _03612_ _03614_
+ VSS VSS VDD VDD _02155_ sky130_fd_sc_hd__o21ai_0
X_14087_ network.neuron_in024.counter\[2\] VSS VSS VDD VDD
+ _03615_ sky130_fd_sc_hd__inv_1
X_14088_ network.in_period\[24\]\[2\] network.neuron_in024.counter\[3\]
+ _00395_ net352 VSS VSS VDD VDD _03616_ sky130_fd_sc_hd__o22ai_1
X_14089_ network.neuron_in024.counter\[2\] _00395_ net373
+ VSS VSS VDD VDD _03617_ sky130_fd_sc_hd__nand3_1
X_14090_ network.in_period\[24\]\[2\] net373 _03617_ VSS VSS
+ VDD VDD _03618_ sky130_fd_sc_hd__o21ai_0
X_14091_ _03615_ _03616_ _03618_ VSS VSS VDD VDD _02161_ sky130_fd_sc_hd__a21oi_1
X_14092_ _03615_ _00395_ VSS VSS VDD VDD _03619_ sky130_fd_sc_hd__nand2_1
X_14093_ network.neuron_in024.counter\[3\] _03619_ VSS VSS
+ VDD VDD _03620_ sky130_fd_sc_hd__or2_2
X_14094_ net373 _03620_ VSS VSS VDD VDD _03621_ sky130_fd_sc_hd__nand2_1
X_14095_ network.in_period\[24\]\[1\] _03621_ VSS VSS VDD
+ VDD _03622_ sky130_fd_sc_hd__nand2_1
X_14096_ _00396_ _03621_ _03622_ VSS VSS VDD VDD _02160_ sky130_fd_sc_hd__o21ai_0
X_14097_ network.in_period\[24\]\[0\] _03621_ VSS VSS VDD
+ VDD _03623_ sky130_fd_sc_hd__nand2_1
X_14098_ network.neuron_in024.counter\[0\] _03621_ _03623_
+ VSS VSS VDD VDD _02159_ sky130_fd_sc_hd__o21ai_0
X_14099_ network.neuron_in130.counter\[0\] VSS VSS VDD VDD
+ _00458_ sky130_fd_sc_hd__inv_1
X_14100_ network.neuron_in130.counter\[3\] _00460_ VSS VSS
+ VDD VDD _03624_ sky130_fd_sc_hd__nand2b_1
X_14101_ network.neuron_in130.counter\[2\] VSS VSS VDD VDD
+ _03625_ sky130_fd_sc_hd__inv_1
X_14102_ _03624_ _03625_ VSS VSS VDD VDD _03626_ sky130_fd_sc_hd__nand2b_1
X_14103_ net377 _03626_ VSS VSS VDD VDD _03627_ sky130_fd_sc_hd__nand2_1
X_14104_ net746 _03627_ VSS VSS VDD VDD _03628_ sky130_fd_sc_hd__nand2_1
X_14105_ network.neuron_in130.counter\[0\] _03627_ _03628_
+ VSS VSS VDD VDD _02583_ sky130_fd_sc_hd__o21ai_0
X_14106_ network.neuron_in131.counter\[2\] net384 VSS VSS
+ VDD VDD _03629_ sky130_fd_sc_hd__nand2_1
X_14107_ network.in_period\[131\]\[2\] network.neuron_in131.counter\[3\]
+ _03629_ VSS VSS VDD VDD _03630_ sky130_fd_sc_hd__o21ai_0
X_14108_ _01162_ network.neuron_in131.counter\[2\] net357
+ VSS VSS VDD VDD _03631_ sky130_fd_sc_hd__or3_1
X_14109_ network.in_period\[131\]\[2\] net384 _03631_ VSS
+ VSS VDD VDD _03632_ sky130_fd_sc_hd__o21ai_0
X_14110_ _01162_ _03630_ _03632_ VSS VSS VDD VDD _02589_ sky130_fd_sc_hd__a21oi_1
X_14111_ network.neuron_in030.counter\[0\] VSS VSS VDD VDD
+ _00434_ sky130_fd_sc_hd__inv_1
X_14112_ network.neuron_in030.counter\[3\] _00436_ VSS VSS
+ VDD VDD _03633_ sky130_fd_sc_hd__nand2b_1
X_14113_ network.neuron_in030.counter\[2\] VSS VSS VDD VDD
+ _03634_ sky130_fd_sc_hd__inv_1
X_14114_ _03633_ _03634_ VSS VSS VDD VDD _03635_ sky130_fd_sc_hd__nand2b_1
X_14115_ net369 _03635_ VSS VSS VDD VDD _03636_ sky130_fd_sc_hd__nand2_1
X_14116_ network.in_period\[30\]\[0\] _03636_ VSS VSS VDD
+ VDD _03637_ sky130_fd_sc_hd__nand2_1
X_14117_ network.neuron_in030.counter\[0\] _03636_ _03637_
+ VSS VSS VDD VDD _02183_ sky130_fd_sc_hd__o21ai_0
X_14118_ network.in_period\[30\]\[1\] _03636_ VSS VSS VDD
+ VDD _03638_ sky130_fd_sc_hd__nand2_1
X_14119_ _00437_ _03636_ _03638_ VSS VSS VDD VDD _02184_ sky130_fd_sc_hd__o21ai_0
X_14120_ network.neuron_in025.counter\[0\] VSS VSS VDD VDD
+ _00381_ sky130_fd_sc_hd__inv_1
X_14121_ network.neuron_in025.counter\[3\] _00383_ VSS VSS
+ VDD VDD _03639_ sky130_fd_sc_hd__nand2b_1
X_14122_ network.neuron_in025.counter\[2\] _03639_ VSS VSS
+ VDD VDD _03640_ sky130_fd_sc_hd__or2_2
X_14123_ net373 _03640_ VSS VSS VDD VDD _03641_ sky130_fd_sc_hd__nand2_1
X_14124_ network.in_period\[25\]\[0\] _03641_ VSS VSS VDD
+ VDD _03642_ sky130_fd_sc_hd__nand2_1
X_14125_ network.neuron_in025.counter\[0\] _03641_ _03642_
+ VSS VSS VDD VDD _02163_ sky130_fd_sc_hd__o21ai_0
X_14126_ network.neuron_in153.counter\[0\] VSS VSS VDD VDD
+ _00492_ sky130_fd_sc_hd__inv_1
X_14127_ network.neuron_in026.counter\[2\] VSS VSS VDD VDD
+ _03643_ sky130_fd_sc_hd__inv_1
X_14128_ network.neuron_in026.counter\[3\] network.in_period\[26\]\[2\]
+ net352 _00470_ VSS VSS VDD VDD _03644_ sky130_fd_sc_hd__o22ai_1
X_14129_ network.neuron_in026.counter\[2\] _00470_ net370
+ VSS VSS VDD VDD _03645_ sky130_fd_sc_hd__nand3_1
X_14130_ network.in_period\[26\]\[2\] net370 _03645_ VSS VSS
+ VDD VDD _03646_ sky130_fd_sc_hd__o21ai_0
X_14131_ _03643_ _03644_ _03646_ VSS VSS VDD VDD _02169_ sky130_fd_sc_hd__a21oi_1
X_14132_ network.in_period\[30\]\[2\] network.neuron_in030.counter\[3\]
+ _00436_ net350 VSS VSS VDD VDD _03647_ sky130_fd_sc_hd__o22ai_1
X_14133_ network.neuron_in030.counter\[2\] _00436_ net369
+ VSS VSS VDD VDD _03648_ sky130_fd_sc_hd__nand3_1
X_14134_ network.in_period\[30\]\[2\] net369 _03648_ VSS VSS
+ VDD VDD _03649_ sky130_fd_sc_hd__o21ai_0
X_14135_ _03634_ _03647_ _03649_ VSS VSS VDD VDD _02185_ sky130_fd_sc_hd__a21oi_1
Xplace324 _07455_ VSS VSS VDD VDD net323 sky130_fd_sc_hd__buf_4
X_14137_ network.neuron_in025.counter\[2\] net373 VSS VSS
+ VDD VDD _03651_ sky130_fd_sc_hd__nand2_1
X_14138_ network.neuron_in025.counter\[3\] network.in_period\[25\]\[2\]
+ _03651_ VSS VSS VDD VDD _03652_ sky130_fd_sc_hd__o21ai_0
X_14139_ _00383_ network.neuron_in025.counter\[2\] net352
+ VSS VSS VDD VDD _03653_ sky130_fd_sc_hd__or3_1
X_14140_ network.in_period\[25\]\[2\] net373 _03653_ VSS VSS
+ VDD VDD _03654_ sky130_fd_sc_hd__o21ai_0
X_14141_ _00383_ _03652_ _03654_ VSS VSS VDD VDD _02165_ sky130_fd_sc_hd__a21oi_1
X_14142_ network.in_period\[25\]\[1\] _03641_ VSS VSS VDD
+ VDD _03655_ sky130_fd_sc_hd__nand2_1
X_14143_ _00384_ _03641_ _03655_ VSS VSS VDD VDD _02164_ sky130_fd_sc_hd__o21ai_0
X_14144_ network.neuron_in187.counter\[1\] VSS VSS VDD VDD
+ _00741_ sky130_fd_sc_hd__inv_1
X_14145_ network.neuron_in026.counter\[3\] _00470_ VSS VSS
+ VDD VDD _03656_ sky130_fd_sc_hd__nand2b_1
X_14146_ _03656_ _03643_ VSS VSS VDD VDD _03657_ sky130_fd_sc_hd__nand2b_1
X_14147_ net370 _03657_ VSS VSS VDD VDD _03658_ sky130_fd_sc_hd__nand2_1
X_14148_ net768 _03658_ VSS VSS VDD VDD _03659_ sky130_fd_sc_hd__nand2_1
X_14149_ _00471_ _03658_ _03659_ VSS VSS VDD VDD _02168_ sky130_fd_sc_hd__o21ai_0
X_14150_ network.neuron_in026.counter\[0\] VSS VSS VDD VDD
+ _00468_ sky130_fd_sc_hd__inv_1
X_14151_ net774 _03658_ VSS VSS VDD VDD _03660_ sky130_fd_sc_hd__nand2_1
X_14152_ network.neuron_in026.counter\[0\] _03658_ _03660_
+ VSS VSS VDD VDD _02167_ sky130_fd_sc_hd__o21ai_0
X_14153_ network.neuron_in242.counter\[1\] VSS VSS VDD VDD
+ _00378_ sky130_fd_sc_hd__inv_1
X_14154_ network.neuron_in031.counter\[0\] VSS VSS VDD VDD
+ _01202_ sky130_fd_sc_hd__inv_1
X_14155_ network.neuron_in031.counter\[3\] _01204_ VSS VSS
+ VDD VDD _03661_ sky130_fd_sc_hd__nand2b_1
X_14156_ network.neuron_in031.counter\[2\] VSS VSS VDD VDD
+ _03662_ sky130_fd_sc_hd__inv_1
X_14157_ _03661_ _03662_ VSS VSS VDD VDD _03663_ sky130_fd_sc_hd__nand2b_1
X_14158_ net370 _03663_ VSS VSS VDD VDD _03664_ sky130_fd_sc_hd__nand2_1
X_14159_ network.in_period\[31\]\[0\] _03664_ VSS VSS VDD
+ VDD _03665_ sky130_fd_sc_hd__nand2_1
X_14160_ network.neuron_in031.counter\[0\] _03664_ _03665_
+ VSS VSS VDD VDD _02187_ sky130_fd_sc_hd__o21ai_0
X_14161_ network.neuron_in032.counter\[2\] _01120_ VSS VSS
+ VDD VDD _03666_ sky130_fd_sc_hd__nand2b_1
X_14162_ network.neuron_in032.counter\[3\] _03666_ VSS VSS
+ VDD VDD _03667_ sky130_fd_sc_hd__or2_2
X_14163_ net371 _03667_ VSS VSS VDD VDD _03668_ sky130_fd_sc_hd__nand2_1
X_14164_ network.in_period\[32\]\[0\] _03668_ VSS VSS VDD
+ VDD _03669_ sky130_fd_sc_hd__nand2_1
X_14165_ network.neuron_in032.counter\[0\] _03668_ _03669_
+ VSS VSS VDD VDD _02191_ sky130_fd_sc_hd__o21ai_0
X_14166_ network.neuron_in095.counter\[0\] VSS VSS VDD VDD
+ _01245_ sky130_fd_sc_hd__inv_1
X_14167_ network.neuron_in031.counter\[3\] network.in_period\[31\]\[2\]
+ _01204_ net352 VSS VSS VDD VDD _03670_ sky130_fd_sc_hd__o22ai_1
X_14168_ network.neuron_in031.counter\[2\] _01204_ net370
+ VSS VSS VDD VDD _03671_ sky130_fd_sc_hd__nand3_1
X_14169_ network.in_period\[31\]\[2\] net370 _03671_ VSS VSS
+ VDD VDD _03672_ sky130_fd_sc_hd__o21ai_0
X_14170_ _03662_ _03670_ _03672_ VSS VSS VDD VDD _02189_ sky130_fd_sc_hd__a21oi_1
X_14171_ net738 _03664_ VSS VSS VDD VDD _03673_ sky130_fd_sc_hd__nand2_1
X_14172_ _01205_ _03664_ _03673_ VSS VSS VDD VDD _02188_ sky130_fd_sc_hd__o21ai_0
X_14173_ network.neuron_in002.counter\[1\] VSS VSS VDD VDD
+ _00758_ sky130_fd_sc_hd__inv_1
X_14174_ network.neuron_in032.counter\[2\] net371 VSS VSS
+ VDD VDD _03674_ sky130_fd_sc_hd__nand2_1
X_14175_ network.in_period\[32\]\[2\] network.neuron_in032.counter\[3\]
+ _03674_ VSS VSS VDD VDD _03675_ sky130_fd_sc_hd__o21ai_0
Xplace323 _07457_ VSS VSS VDD VDD net322 sky130_fd_sc_hd__buf_4
X_14177_ _01120_ network.neuron_in032.counter\[2\] net354
+ VSS VSS VDD VDD _03677_ sky130_fd_sc_hd__or3_1
X_14178_ network.in_period\[32\]\[2\] net371 _03677_ VSS VSS
+ VDD VDD _03678_ sky130_fd_sc_hd__o21ai_0
X_14179_ _01120_ _03675_ _03678_ VSS VSS VDD VDD _02193_ sky130_fd_sc_hd__a21oi_1
X_14180_ network.in_period\[32\]\[1\] _03668_ VSS VSS VDD
+ VDD _03679_ sky130_fd_sc_hd__nand2_1
X_14181_ _01121_ _03668_ _03679_ VSS VSS VDD VDD _02192_ sky130_fd_sc_hd__o21ai_0
X_14182_ network.neuron_in137.counter\[0\] VSS VSS VDD VDD
+ _00683_ sky130_fd_sc_hd__inv_1
X_14183_ net688 _03503_ VSS VSS VDD VDD _03680_ sky130_fd_sc_hd__nand2_1
X_14184_ network.neuron_in137.counter\[0\] _03503_ _03680_
+ VSS VSS VDD VDD _02611_ sky130_fd_sc_hd__o21ai_0
X_14185_ network.neuron_in034.counter\[0\] VSS VSS VDD VDD
+ _00357_ sky130_fd_sc_hd__inv_1
X_14186_ network.neuron_in034.counter\[3\] _00359_ VSS VSS
+ VDD VDD _03681_ sky130_fd_sc_hd__nand2b_1
X_14187_ network.neuron_in034.counter\[2\] VSS VSS VDD VDD
+ _03682_ sky130_fd_sc_hd__inv_1
X_14188_ _03681_ _03682_ VSS VSS VDD VDD _03683_ sky130_fd_sc_hd__nand2b_1
X_14189_ net368 _03683_ VSS VSS VDD VDD _03684_ sky130_fd_sc_hd__nand2_1
X_14190_ network.in_period\[34\]\[0\] _03684_ VSS VSS VDD
+ VDD _03685_ sky130_fd_sc_hd__nand2_1
X_14191_ network.neuron_in034.counter\[0\] _03684_ _03685_
+ VSS VSS VDD VDD _02199_ sky130_fd_sc_hd__o21ai_0
X_14192_ network.neuron_in131.counter\[2\] _01162_ VSS VSS
+ VDD VDD _03686_ sky130_fd_sc_hd__nand2b_1
X_14193_ network.neuron_in131.counter\[3\] _03686_ VSS VSS
+ VDD VDD _03687_ sky130_fd_sc_hd__or2_2
X_14194_ net384 _03687_ VSS VSS VDD VDD _03688_ sky130_fd_sc_hd__nand2_1
X_14195_ net612 _03688_ VSS VSS VDD VDD _03689_ sky130_fd_sc_hd__nand2_1
X_14196_ _01163_ _03688_ _03689_ VSS VSS VDD VDD _02588_ sky130_fd_sc_hd__o21ai_0
X_14197_ network.neuron_in138.counter\[3\] network.in_period\[138\]\[2\]
+ net360 _00614_ VSS VSS VDD VDD _03690_ sky130_fd_sc_hd__o22ai_1
X_14198_ network.neuron_in138.counter\[2\] _00614_ net377
+ VSS VSS VDD VDD _03691_ sky130_fd_sc_hd__nand3_1
X_14199_ network.in_period\[138\]\[2\] net377 _03691_ VSS
+ VSS VDD VDD _03692_ sky130_fd_sc_hd__o21ai_0
X_14200_ _03534_ _03690_ _03692_ VSS VSS VDD VDD _02617_ sky130_fd_sc_hd__a21oi_1
X_14201_ network.in_period\[34\]\[1\] _03684_ VSS VSS VDD
+ VDD _03693_ sky130_fd_sc_hd__nand2_1
X_14202_ _00360_ _03684_ _03693_ VSS VSS VDD VDD _02200_ sky130_fd_sc_hd__o21ai_0
X_14203_ network.arbit.counter\[1\] VSS VSS VDD VDD _00116_
+ sky130_fd_sc_hd__inv_1
X_14204_ network.neuron_in035.counter\[0\] VSS VSS VDD VDD
+ _00361_ sky130_fd_sc_hd__inv_1
Xplace322 _07492_ VSS VSS VDD VDD net321 sky130_fd_sc_hd__buf_4
X_14206_ network.neuron_in035.counter\[3\] _00363_ VSS VSS
+ VDD VDD _03695_ sky130_fd_sc_hd__nand2b_1
X_14207_ network.neuron_in035.counter\[2\] VSS VSS VDD VDD
+ _03696_ sky130_fd_sc_hd__inv_1
X_14208_ _03695_ _03696_ VSS VSS VDD VDD _03697_ sky130_fd_sc_hd__nand2b_1
X_14209_ net371 _03697_ VSS VSS VDD VDD _03698_ sky130_fd_sc_hd__nand2_1
X_14210_ network.in_period\[35\]\[0\] _03698_ VSS VSS VDD
+ VDD _03699_ sky130_fd_sc_hd__nand2_1
X_14211_ network.neuron_in035.counter\[0\] _03698_ _03699_
+ VSS VSS VDD VDD _02203_ sky130_fd_sc_hd__o21ai_0
X_14212_ network.neuron_in033.counter\[3\] _00577_ VSS VSS
+ VDD VDD _03700_ sky130_fd_sc_hd__nand2b_1
X_14213_ network.neuron_in033.counter\[2\] VSS VSS VDD VDD
+ _03701_ sky130_fd_sc_hd__inv_1
X_14214_ _03700_ _03701_ VSS VSS VDD VDD _03702_ sky130_fd_sc_hd__nand2b_1
X_14215_ net372 _03702_ VSS VSS VDD VDD _03703_ sky130_fd_sc_hd__nand2_1
X_14216_ network.in_period\[33\]\[0\] _03703_ VSS VSS VDD
+ VDD _03704_ sky130_fd_sc_hd__nand2_1
X_14217_ network.neuron_in033.counter\[0\] _03703_ _03704_
+ VSS VSS VDD VDD _02195_ sky130_fd_sc_hd__o21ai_0
X_14218_ network.neuron_in131.counter\[0\] VSS VSS VDD VDD
+ _01160_ sky130_fd_sc_hd__inv_1
X_14219_ net658 _03688_ VSS VSS VDD VDD _03705_ sky130_fd_sc_hd__nand2_1
X_14220_ network.neuron_in131.counter\[0\] _03688_ _03705_
+ VSS VSS VDD VDD _02587_ sky130_fd_sc_hd__o21ai_0
X_14221_ network.neuron_in034.counter\[3\] network.in_period\[34\]\[2\]
+ _00359_ net351 VSS VSS VDD VDD _03706_ sky130_fd_sc_hd__o22ai_1
Xplace320 _07544_ VSS VSS VDD VDD net319 sky130_fd_sc_hd__buf_4
Xplace319 _07553_ VSS VSS VDD VDD net318 sky130_fd_sc_hd__buf_4
X_14224_ network.neuron_in034.counter\[2\] _00359_ net368
+ VSS VSS VDD VDD _03709_ sky130_fd_sc_hd__nand3_1
X_14225_ network.in_period\[34\]\[2\] net368 _03709_ VSS VSS
+ VDD VDD _03710_ sky130_fd_sc_hd__o21ai_0
X_14226_ _03682_ _03706_ _03710_ VSS VSS VDD VDD _02201_ sky130_fd_sc_hd__a21oi_1
X_14227_ network.neuron_in202.counter\[1\] VSS VSS VDD VDD
+ _00674_ sky130_fd_sc_hd__inv_1
X_14228_ network.neuron_in132.counter\[2\] VSS VSS VDD VDD
+ _03711_ sky130_fd_sc_hd__inv_1
X_14229_ network.neuron_in132.counter\[3\] network.in_period\[132\]\[2\]
+ _00432_ net357 VSS VSS VDD VDD _03712_ sky130_fd_sc_hd__o22ai_1
X_14230_ network.neuron_in132.counter\[2\] _00432_ net384
+ VSS VSS VDD VDD _03713_ sky130_fd_sc_hd__nand3_1
X_14231_ network.in_period\[132\]\[2\] net384 _03713_ VSS
+ VSS VDD VDD _03714_ sky130_fd_sc_hd__o21ai_0
X_14232_ _03711_ _03712_ _03714_ VSS VSS VDD VDD _02593_ sky130_fd_sc_hd__a21oi_1
X_14233_ network.in_period\[35\]\[1\] _03698_ VSS VSS VDD
+ VDD _03715_ sky130_fd_sc_hd__nand2_1
X_14234_ _00364_ _03698_ _03715_ VSS VSS VDD VDD _02204_ sky130_fd_sc_hd__o21ai_0
X_14235_ network.neuron_in033.counter\[3\] network.in_period\[33\]\[2\]
+ net355 _00577_ VSS VSS VDD VDD _03716_ sky130_fd_sc_hd__o22ai_1
Xplace318 _07556_ VSS VSS VDD VDD net317 sky130_fd_sc_hd__buf_4
X_14237_ network.neuron_in033.counter\[2\] _00577_ net372
+ VSS VSS VDD VDD _03718_ sky130_fd_sc_hd__nand3_1
X_14238_ network.in_period\[33\]\[2\] net372 _03718_ VSS VSS
+ VDD VDD _03719_ sky130_fd_sc_hd__o21ai_0
X_14239_ _03701_ _03716_ _03719_ VSS VSS VDD VDD _02197_ sky130_fd_sc_hd__a21oi_1
X_14240_ network.in_period\[33\]\[1\] _03703_ VSS VSS VDD
+ VDD _03720_ sky130_fd_sc_hd__nand2_1
X_14241_ _00578_ _03703_ _03720_ VSS VSS VDD VDD _02196_ sky130_fd_sc_hd__o21ai_0
X_14242_ network.neuron_in106.counter\[0\] VSS VSS VDD VDD
+ _00648_ sky130_fd_sc_hd__inv_1
X_14243_ network.neuron_in035.counter\[3\] network.in_period\[35\]\[2\]
+ _00363_ net350 VSS VSS VDD VDD _03721_ sky130_fd_sc_hd__o22ai_1
X_14244_ network.neuron_in035.counter\[2\] _00363_ net371
+ VSS VSS VDD VDD _03722_ sky130_fd_sc_hd__nand3_1
X_14245_ network.in_period\[35\]\[2\] net371 _03722_ VSS VSS
+ VDD VDD _03723_ sky130_fd_sc_hd__o21ai_0
X_14246_ _03696_ _03721_ _03723_ VSS VSS VDD VDD _02205_ sky130_fd_sc_hd__a21oi_1
X_14247_ network.neuron_in039.counter\[0\] VSS VSS VDD VDD
+ _00325_ sky130_fd_sc_hd__inv_1
X_14248_ network.neuron_in039.counter\[3\] _00327_ VSS VSS
+ VDD VDD _03724_ sky130_fd_sc_hd__nand2b_1
X_14249_ network.neuron_in039.counter\[2\] _03724_ VSS VSS
+ VDD VDD _03725_ sky130_fd_sc_hd__or2_2
X_14250_ net375 _03725_ VSS VSS VDD VDD _03726_ sky130_fd_sc_hd__nand2_1
X_14251_ network.in_period\[39\]\[0\] _03726_ VSS VSS VDD
+ VDD _03727_ sky130_fd_sc_hd__nand2_1
X_14252_ network.neuron_in039.counter\[0\] _03726_ _03727_
+ VSS VSS VDD VDD _02219_ sky130_fd_sc_hd__o21ai_0
X_14253_ network.neuron_in037.counter\[3\] _00343_ VSS VSS
+ VDD VDD _03728_ sky130_fd_sc_hd__nand2b_1
X_14254_ network.neuron_in037.counter\[2\] VSS VSS VDD VDD
+ _03729_ sky130_fd_sc_hd__inv_1
X_14255_ _03728_ _03729_ VSS VSS VDD VDD _03730_ sky130_fd_sc_hd__nand2b_1
X_14256_ net371 _03730_ VSS VSS VDD VDD _03731_ sky130_fd_sc_hd__nand2_1
X_14257_ network.in_period\[37\]\[1\] _03731_ VSS VSS VDD
+ VDD _03732_ sky130_fd_sc_hd__nand2_1
X_14258_ _00344_ _03731_ _03732_ VSS VSS VDD VDD _02212_ sky130_fd_sc_hd__o21ai_0
X_14259_ network.in_period\[39\]\[1\] _03726_ VSS VSS VDD
+ VDD _03733_ sky130_fd_sc_hd__nand2_1
X_14260_ _00328_ _03726_ _03733_ VSS VSS VDD VDD _02220_ sky130_fd_sc_hd__o21ai_0
X_14261_ network.neuron_in036.counter\[2\] VSS VSS VDD VDD
+ _03734_ sky130_fd_sc_hd__inv_1
X_14262_ network.in_period\[36\]\[2\] network.neuron_in036.counter\[3\]
+ net354 _00347_ VSS VSS VDD VDD _03735_ sky130_fd_sc_hd__o22ai_1
X_14263_ network.neuron_in036.counter\[2\] _00347_ net371
+ VSS VSS VDD VDD _03736_ sky130_fd_sc_hd__nand3_1
X_14264_ network.in_period\[36\]\[2\] net371 _03736_ VSS VSS
+ VDD VDD _03737_ sky130_fd_sc_hd__o21ai_0
X_14265_ _03734_ _03735_ _03737_ VSS VSS VDD VDD _02209_ sky130_fd_sc_hd__a21oi_1
Xplace317 _07564_ VSS VSS VDD VDD net316 sky130_fd_sc_hd__buf_4
X_14267_ network.neuron_in037.counter\[3\] network.in_period\[37\]\[2\]
+ net351 _00343_ VSS VSS VDD VDD _03739_ sky130_fd_sc_hd__o22ai_1
X_14268_ network.neuron_in037.counter\[2\] _00343_ net371
+ VSS VSS VDD VDD _03740_ sky130_fd_sc_hd__nand3_1
X_14269_ network.in_period\[37\]\[2\] net371 _03740_ VSS VSS
+ VDD VDD _03741_ sky130_fd_sc_hd__o21ai_0
X_14270_ _03729_ _03739_ _03741_ VSS VSS VDD VDD _02213_ sky130_fd_sc_hd__a21oi_1
X_14271_ network.neuron_in038.counter\[3\] _00331_ VSS VSS
+ VDD VDD _03742_ sky130_fd_sc_hd__nand2b_1
X_14272_ network.neuron_in038.counter\[2\] VSS VSS VDD VDD
+ _03743_ sky130_fd_sc_hd__inv_1
X_14273_ _03742_ _03743_ VSS VSS VDD VDD _03744_ sky130_fd_sc_hd__nand2b_1
X_14274_ net371 _03744_ VSS VSS VDD VDD _03745_ sky130_fd_sc_hd__nand2_1
X_14275_ net577 _03745_ VSS VSS VDD VDD _03746_ sky130_fd_sc_hd__nand2_1
X_14276_ _00332_ _03745_ _03746_ VSS VSS VDD VDD _02216_ sky130_fd_sc_hd__o21ai_0
X_14277_ network.neuron_in039.counter\[2\] net375 VSS VSS
+ VDD VDD _03747_ sky130_fd_sc_hd__nand2_1
X_14278_ network.neuron_in039.counter\[3\] network.in_period\[39\]\[2\]
+ _03747_ VSS VSS VDD VDD _03748_ sky130_fd_sc_hd__o21ai_0
X_14279_ _00327_ network.neuron_in039.counter\[2\] net355
+ VSS VSS VDD VDD _03749_ sky130_fd_sc_hd__or3_1
X_14280_ network.in_period\[39\]\[2\] net375 _03749_ VSS VSS
+ VDD VDD _03750_ sky130_fd_sc_hd__o21ai_0
X_14281_ _00327_ _03748_ _03750_ VSS VSS VDD VDD _02221_ sky130_fd_sc_hd__a21oi_1
Xplace316 _07590_ VSS VSS VDD VDD net315 sky130_fd_sc_hd__buf_4
X_14283_ net389 _08729_ VSS VSS VDD VDD _03752_ sky130_fd_sc_hd__nand2_1
X_14284_ network.cnt_main.counter\[11\] network.cnt_main.counter\[10\]
+ _08727_ VSS VSS VDD VDD _03753_ sky130_fd_sc_hd__nor3_1
X_14285_ network.cnt_main.counter\[12\] _03753_ VSS VSS VDD
+ VDD _03754_ sky130_fd_sc_hd__xnor2_1
X_14286_ _03752_ _03754_ VSS VSS VDD VDD _01729_ sky130_fd_sc_hd__nor2_1
X_14287_ _06612_ _08729_ VSS VSS VDD VDD _03755_ sky130_fd_sc_hd__and2_1
Xplace284 _03755_ VSS VSS VDD VDD net283 sky130_fd_sc_hd__buf_4
Xplace283 net283 VSS VSS VDD VDD net282 sky130_fd_sc_hd__buf_4
Xplace282 net283 VSS VSS VDD VDD net281 sky130_fd_sc_hd__buf_4
X_14291_ network.cnt_main.counter\[1\] network.cnt_main.counter\[0\]
+ VSS VSS VDD VDD _03759_ sky130_fd_sc_hd__nor2_1
X_14292_ _08725_ _08726_ _03759_ VSS VSS VDD VDD _03760_ sky130_fd_sc_hd__nand3_1
X_14293_ network.cnt_main.counter\[10\] _03760_ VSS VSS VDD
+ VDD _03761_ sky130_fd_sc_hd__nor2_1
X_14294_ network.cnt_main.counter\[11\] _03761_ VSS VSS VDD
+ VDD _03762_ sky130_fd_sc_hd__xnor2_1
X_14295_ net279 _03762_ VSS VSS VDD VDD _01730_ sky130_fd_sc_hd__nand2_1
X_14296_ network.cnt_main.counter\[10\] _08727_ VSS VSS VDD
+ VDD _03763_ sky130_fd_sc_hd__xor2_1
X_14297_ _03752_ _03763_ VSS VSS VDD VDD _01731_ sky130_fd_sc_hd__nor2_1
X_14298_ _08725_ _03759_ VSS VSS VDD VDD _03764_ sky130_fd_sc_hd__nand2_1
X_14299_ network.cnt_main.counter\[8\] network.cnt_main.counter\[7\]
+ network.cnt_main.counter\[6\] _03764_ net595 VSS VSS VDD VDD
+ _03765_ sky130_fd_sc_hd__o41ai_1
X_14300_ _03760_ _03765_ _03752_ VSS VSS VDD VDD _01732_ sky130_fd_sc_hd__a21oi_1
X_14301_ _00635_ _08725_ VSS VSS VDD VDD _03766_ sky130_fd_sc_hd__nand2_1
X_14302_ network.cnt_main.counter\[7\] network.cnt_main.counter\[6\]
+ _03766_ VSS VSS VDD VDD _03767_ sky130_fd_sc_hd__nor3_1
X_14303_ network.cnt_main.counter\[8\] _03767_ VSS VSS VDD
+ VDD _03768_ sky130_fd_sc_hd__xnor2_1
X_14304_ net279 _03768_ VSS VSS VDD VDD _01733_ sky130_fd_sc_hd__nand2_1
X_14305_ network.cnt_main.counter\[6\] _03764_ VSS VSS VDD
+ VDD _03769_ sky130_fd_sc_hd__nor2_1
X_14306_ network.cnt_main.counter\[7\] _03769_ VSS VSS VDD
+ VDD _03770_ sky130_fd_sc_hd__xnor2_1
X_14307_ net279 _03770_ VSS VSS VDD VDD _01734_ sky130_fd_sc_hd__nand2_1
X_14308_ network.cnt_main.counter\[6\] _03766_ VSS VSS VDD
+ VDD _03771_ sky130_fd_sc_hd__xor2_1
X_14309_ net279 _03771_ VSS VSS VDD VDD _01735_ sky130_fd_sc_hd__nand2_1
X_14310_ network.cnt_main.counter\[3\] network.cnt_main.counter\[2\]
+ VSS VSS VDD VDD _03772_ sky130_fd_sc_hd__nor2_1
X_14311_ _03772_ _03759_ VSS VSS VDD VDD _03773_ sky130_fd_sc_hd__nand2_1
X_14312_ network.cnt_main.counter\[4\] _03773_ net591 VSS
+ VSS VDD VDD _03774_ sky130_fd_sc_hd__o21ai_0
X_14313_ _03764_ _03774_ _03752_ VSS VSS VDD VDD _01736_ sky130_fd_sc_hd__a21oi_1
X_14314_ _00635_ _03772_ VSS VSS VDD VDD _03775_ sky130_fd_sc_hd__nand2_1
X_14315_ network.cnt_main.counter\[4\] _03775_ VSS VSS VDD
+ VDD _03776_ sky130_fd_sc_hd__xor2_1
X_14316_ _03752_ _03776_ VSS VSS VDD VDD _01737_ sky130_fd_sc_hd__nor2_1
X_14317_ network.cnt_main.counter\[2\] network.cnt_main.counter\[1\]
+ network.cnt_main.counter\[0\] network.cnt_main.counter\[3\]
+ VSS VSS VDD VDD _03777_ sky130_fd_sc_hd__o31ai_1
X_14318_ _03773_ _03777_ _03752_ VSS VSS VDD VDD _01738_ sky130_fd_sc_hd__a21oi_1
X_14319_ _00635_ network.cnt_main.counter\[2\] VSS VSS VDD
+ VDD _03778_ sky130_fd_sc_hd__xnor2_1
X_14320_ net279 _03778_ VSS VSS VDD VDD _01739_ sky130_fd_sc_hd__nand2_1
X_14321_ _00636_ _03752_ VSS VSS VDD VDD _01740_ sky130_fd_sc_hd__nor2_1
X_14322_ network.cnt_main.counter\[0\] VSS VSS VDD VDD _00633_
+ sky130_fd_sc_hd__inv_1
X_14323_ net575 _03752_ VSS VSS VDD VDD _01741_ sky130_fd_sc_hd__nor2_1
X_14324_ network.neuron_in217.counter\[1\] VSS VSS VDD VDD
+ _00947_ sky130_fd_sc_hd__inv_1
X_14325_ network.neuron_in038.counter\[3\] network.in_period\[38\]\[2\]
+ net354 _00331_ VSS VSS VDD VDD _03779_ sky130_fd_sc_hd__o22ai_1
X_14326_ network.neuron_in038.counter\[2\] _00331_ net371
+ VSS VSS VDD VDD _03780_ sky130_fd_sc_hd__nand3_1
X_14327_ network.in_period\[38\]\[2\] net371 _03780_ VSS VSS
+ VDD VDD _03781_ sky130_fd_sc_hd__o21ai_0
X_14328_ _03743_ _03779_ _03781_ VSS VSS VDD VDD _02217_ sky130_fd_sc_hd__a21oi_1
X_14329_ net716 _06953_ VSS VSS VDD VDD _03782_ sky130_fd_sc_hd__nand2_1
X_14330_ _00536_ _06953_ _03782_ VSS VSS VDD VDD _02656_ sky130_fd_sc_hd__o21ai_0
X_14331_ net753 _06639_ VSS VSS VDD VDD _03783_ sky130_fd_sc_hd__nand2_1
X_14332_ network.neuron_in162.counter\[0\] _06639_ _03783_
+ VSS VSS VDD VDD _02711_ sky130_fd_sc_hd__o21ai_0
X_14333_ network.neuron_in163.counter\[2\] VSS VSS VDD VDD
+ _03784_ sky130_fd_sc_hd__inv_1
X_14334_ network.neuron_in163.counter\[3\] network.in_period\[163\]\[2\]
+ _00819_ net360 VSS VSS VDD VDD _03785_ sky130_fd_sc_hd__o22ai_1
X_14335_ network.neuron_in163.counter\[2\] _00819_ net378
+ VSS VSS VDD VDD _03786_ sky130_fd_sc_hd__nand3_1
X_14336_ network.in_period\[163\]\[2\] net378 _03786_ VSS
+ VSS VDD VDD _03787_ sky130_fd_sc_hd__o21ai_0
X_14337_ _03784_ _03785_ _03787_ VSS VSS VDD VDD _02717_ sky130_fd_sc_hd__a21oi_1
X_14338_ network.neuron_in036.counter\[3\] _00347_ VSS VSS
+ VDD VDD _03788_ sky130_fd_sc_hd__nand2b_1
X_14339_ _03788_ _03734_ VSS VSS VDD VDD _03789_ sky130_fd_sc_hd__nand2b_1
X_14340_ net371 _03789_ VSS VSS VDD VDD _03790_ sky130_fd_sc_hd__nand2_1
X_14341_ network.in_period\[36\]\[1\] _03790_ VSS VSS VDD
+ VDD _03791_ sky130_fd_sc_hd__nand2_1
X_14342_ _00348_ _03790_ _03791_ VSS VSS VDD VDD _02208_ sky130_fd_sc_hd__o21ai_0
X_14343_ network.neuron_in163.counter\[3\] _00819_ VSS VSS
+ VDD VDD _03792_ sky130_fd_sc_hd__nand2b_1
X_14344_ _03792_ _03784_ VSS VSS VDD VDD _03793_ sky130_fd_sc_hd__nand2b_1
X_14345_ net378 _03793_ VSS VSS VDD VDD _03794_ sky130_fd_sc_hd__nand2_1
X_14346_ network.in_period\[163\]\[1\] _03794_ VSS VSS VDD
+ VDD _03795_ sky130_fd_sc_hd__nand2_1
X_14347_ _00820_ _03794_ _03795_ VSS VSS VDD VDD _02716_ sky130_fd_sc_hd__o21ai_0
X_14348_ network.neuron_in036.counter\[0\] VSS VSS VDD VDD
+ _00345_ sky130_fd_sc_hd__inv_1
X_14349_ network.in_period\[36\]\[0\] _03790_ VSS VSS VDD
+ VDD _03796_ sky130_fd_sc_hd__nand2_1
X_14350_ network.neuron_in036.counter\[0\] _03790_ _03796_
+ VSS VSS VDD VDD _02207_ sky130_fd_sc_hd__o21ai_0
X_14351_ network.neuron_in163.counter\[0\] VSS VSS VDD VDD
+ _00817_ sky130_fd_sc_hd__inv_1
X_14352_ network.in_period\[163\]\[0\] _03794_ VSS VSS VDD
+ VDD _03797_ sky130_fd_sc_hd__nand2_1
X_14353_ network.neuron_in163.counter\[0\] _03794_ _03797_
+ VSS VSS VDD VDD _02715_ sky130_fd_sc_hd__o21ai_0
X_14354_ network.neuron_in161.counter\[1\] VSS VSS VDD VDD
+ _00776_ sky130_fd_sc_hd__inv_1
X_14355_ network.neuron_in164.counter\[2\] VSS VSS VDD VDD
+ _03798_ sky130_fd_sc_hd__inv_1
Xplace281 net283 VSS VSS VDD VDD net280 sky130_fd_sc_hd__buf_6
X_14357_ network.neuron_in164.counter\[3\] network.in_period\[164\]\[2\]
+ _00862_ net360 VSS VSS VDD VDD _03800_ sky130_fd_sc_hd__o22ai_1
X_14358_ network.neuron_in164.counter\[2\] _00862_ net378
+ VSS VSS VDD VDD _03801_ sky130_fd_sc_hd__nand3_1
X_14359_ network.in_period\[164\]\[2\] net378 _03801_ VSS
+ VSS VDD VDD _03802_ sky130_fd_sc_hd__o21ai_0
X_14360_ _03798_ _03800_ _03802_ VSS VSS VDD VDD _02721_ sky130_fd_sc_hd__a21oi_1
X_14361_ network.in_period\[37\]\[0\] _03731_ VSS VSS VDD
+ VDD _03803_ sky130_fd_sc_hd__nand2_1
X_14362_ network.neuron_in037.counter\[0\] _03731_ _03803_
+ VSS VSS VDD VDD _02211_ sky130_fd_sc_hd__o21ai_0
X_14363_ network.neuron_in164.counter\[3\] _00862_ VSS VSS
+ VDD VDD _03804_ sky130_fd_sc_hd__nand2b_1
X_14364_ _03804_ _03798_ VSS VSS VDD VDD _03805_ sky130_fd_sc_hd__nand2b_1
X_14365_ net378 _03805_ VSS VSS VDD VDD _03806_ sky130_fd_sc_hd__nand2_1
X_14366_ network.in_period\[164\]\[1\] _03806_ VSS VSS VDD
+ VDD _03807_ sky130_fd_sc_hd__nand2_1
X_14367_ _00863_ _03806_ _03807_ VSS VSS VDD VDD _02720_ sky130_fd_sc_hd__o21ai_0
X_14368_ network.neuron_in164.counter\[0\] VSS VSS VDD VDD
+ _00860_ sky130_fd_sc_hd__inv_1
X_14369_ network.in_period\[164\]\[0\] _03806_ VSS VSS VDD
+ VDD _03808_ sky130_fd_sc_hd__nand2_1
X_14370_ network.neuron_in164.counter\[0\] _03806_ _03808_
+ VSS VSS VDD VDD _02719_ sky130_fd_sc_hd__o21ai_0
X_14371_ network.neuron_in165.counter\[2\] VSS VSS VDD VDD
+ _03809_ sky130_fd_sc_hd__inv_1
X_14372_ network.in_period\[165\]\[2\] network.neuron_in165.counter\[3\]
+ _00872_ net360 VSS VSS VDD VDD _03810_ sky130_fd_sc_hd__o22ai_1
Xplace280 _03755_ VSS VSS VDD VDD net279 sky130_fd_sc_hd__buf_4
X_14374_ network.neuron_in165.counter\[2\] _00872_ net378
+ VSS VSS VDD VDD _03812_ sky130_fd_sc_hd__nand3_1
X_14375_ network.in_period\[165\]\[2\] net378 _03812_ VSS
+ VSS VDD VDD _03813_ sky130_fd_sc_hd__o21ai_0
X_14376_ _03809_ _03810_ _03813_ VSS VSS VDD VDD _02725_ sky130_fd_sc_hd__a21oi_1
X_14377_ network.neuron_in165.counter\[3\] _00872_ VSS VSS
+ VDD VDD _03814_ sky130_fd_sc_hd__nand2b_1
X_14378_ _03814_ _03809_ VSS VSS VDD VDD _03815_ sky130_fd_sc_hd__nand2b_1
X_14379_ net378 _03815_ VSS VSS VDD VDD _03816_ sky130_fd_sc_hd__nand2_1
X_14380_ net747 _03816_ VSS VSS VDD VDD _03817_ sky130_fd_sc_hd__nand2_1
X_14381_ _00873_ _03816_ _03817_ VSS VSS VDD VDD _02724_ sky130_fd_sc_hd__o21ai_0
X_14382_ network.neuron_in038.counter\[0\] VSS VSS VDD VDD
+ _00329_ sky130_fd_sc_hd__inv_1
X_14383_ net572 _03745_ VSS VSS VDD VDD _03818_ sky130_fd_sc_hd__nand2_1
X_14384_ network.neuron_in038.counter\[0\] _03745_ _03818_
+ VSS VSS VDD VDD _02215_ sky130_fd_sc_hd__o21ai_0
X_14385_ network.neuron_in165.counter\[0\] VSS VSS VDD VDD
+ _00870_ sky130_fd_sc_hd__inv_1
X_14386_ network.in_period\[165\]\[0\] _03816_ VSS VSS VDD
+ VDD _03819_ sky130_fd_sc_hd__nand2_1
X_14387_ network.neuron_in165.counter\[0\] _03816_ _03819_
+ VSS VSS VDD VDD _02723_ sky130_fd_sc_hd__o21ai_0
X_14388_ network.neuron_in166.counter\[2\] VSS VSS VDD VDD
+ _03820_ sky130_fd_sc_hd__inv_1
X_14389_ network.neuron_in166.counter\[3\] network.in_period\[166\]\[2\]
+ _00889_ net360 VSS VSS VDD VDD _03821_ sky130_fd_sc_hd__o22ai_1
X_14390_ network.neuron_in166.counter\[2\] _00889_ net378
+ VSS VSS VDD VDD _03822_ sky130_fd_sc_hd__nand3_1
X_14391_ network.in_period\[166\]\[2\] net378 _03822_ VSS
+ VSS VDD VDD _03823_ sky130_fd_sc_hd__o21ai_0
X_14392_ _03820_ _03821_ _03823_ VSS VSS VDD VDD _02729_ sky130_fd_sc_hd__a21oi_1
X_14393_ network.neuron_in088.counter\[0\] VSS VSS VDD VDD
+ _01214_ sky130_fd_sc_hd__inv_1
X_14394_ network.neuron_in166.counter\[3\] _00889_ VSS VSS
+ VDD VDD _03824_ sky130_fd_sc_hd__nand2b_1
X_14395_ _03824_ _03820_ VSS VSS VDD VDD _03825_ sky130_fd_sc_hd__nand2b_1
X_14396_ net378 _03825_ VSS VSS VDD VDD _03826_ sky130_fd_sc_hd__nand2_1
X_14397_ network.in_period\[166\]\[1\] _03826_ VSS VSS VDD
+ VDD _03827_ sky130_fd_sc_hd__nand2_1
X_14398_ _00890_ _03826_ _03827_ VSS VSS VDD VDD _02728_ sky130_fd_sc_hd__o21ai_0
X_14399_ network.neuron_in166.counter\[0\] VSS VSS VDD VDD
+ _00887_ sky130_fd_sc_hd__inv_1
X_14400_ network.in_period\[166\]\[0\] _03826_ VSS VSS VDD
+ VDD _03828_ sky130_fd_sc_hd__nand2_1
X_14401_ network.neuron_in166.counter\[0\] _03826_ _03828_
+ VSS VSS VDD VDD _02727_ sky130_fd_sc_hd__o21ai_0
X_14402_ network.neuron_in167.counter\[3\] network.in_period\[167\]\[2\]
+ _00922_ net360 VSS VSS VDD VDD _03829_ sky130_fd_sc_hd__o22ai_1
X_14403_ network.neuron_in167.counter\[2\] _00922_ net379
+ VSS VSS VDD VDD _03830_ sky130_fd_sc_hd__nand3_1
X_14404_ network.in_period\[167\]\[2\] net378 _03830_ VSS
+ VSS VDD VDD _03831_ sky130_fd_sc_hd__o21ai_0
X_14405_ _07767_ _03829_ _03831_ VSS VSS VDD VDD _02733_ sky130_fd_sc_hd__a21oi_1
X_14406_ network.neuron_in041.counter\[2\] net371 VSS VSS
+ VDD VDD _03832_ sky130_fd_sc_hd__nand2_1
X_14407_ network.neuron_in041.counter\[3\] network.in_period\[41\]\[2\]
+ _03832_ VSS VSS VDD VDD _03833_ sky130_fd_sc_hd__o21ai_0
X_14408_ _00311_ network.neuron_in041.counter\[2\] net354
+ VSS VSS VDD VDD _03834_ sky130_fd_sc_hd__or3_1
X_14409_ network.in_period\[41\]\[2\] net371 _03834_ VSS VSS
+ VDD VDD _03835_ sky130_fd_sc_hd__o21ai_0
X_14410_ _00311_ _03833_ _03835_ VSS VSS VDD VDD _02229_ sky130_fd_sc_hd__a21oi_1
X_14411_ network.neuron_in042.counter\[2\] network.neuron_in042.counter\[3\]
+ VSS VSS VDD VDD _03836_ sky130_fd_sc_hd__nor2_1
X_14412_ _00307_ _03836_ VSS VSS VDD VDD _03837_ sky130_fd_sc_hd__nand2_1
X_14413_ net371 _03837_ VSS VSS VDD VDD _03838_ sky130_fd_sc_hd__nand2_1
X_14414_ network.in_period\[42\]\[0\] _03838_ VSS VSS VDD
+ VDD _03839_ sky130_fd_sc_hd__nand2_1
X_14415_ network.neuron_in042.counter\[0\] _03838_ _03839_
+ VSS VSS VDD VDD _02231_ sky130_fd_sc_hd__o21ai_0
X_14416_ network.neuron_in222.counter\[1\] VSS VSS VDD VDD
+ _00943_ sky130_fd_sc_hd__inv_1
X_14417_ network.in_period\[167\]\[1\] _07769_ VSS VSS VDD
+ VDD _03840_ sky130_fd_sc_hd__nand2_1
X_14418_ _00923_ _07769_ _03840_ VSS VSS VDD VDD _02732_ sky130_fd_sc_hd__o21ai_0
X_14419_ network.neuron_in040.counter\[2\] VSS VSS VDD VDD
+ _03841_ sky130_fd_sc_hd__inv_1
X_14420_ network.in_period\[40\]\[2\] network.neuron_in040.counter\[3\]
+ _00323_ net355 VSS VSS VDD VDD _03842_ sky130_fd_sc_hd__o22ai_1
Xplace279 net279 VSS VSS VDD VDD net278 sky130_fd_sc_hd__buf_6
X_14422_ network.neuron_in040.counter\[2\] _00323_ net375
+ VSS VSS VDD VDD _03844_ sky130_fd_sc_hd__nand3_1
X_14423_ network.in_period\[40\]\[2\] net375 _03844_ VSS VSS
+ VDD VDD _03845_ sky130_fd_sc_hd__o21ai_0
X_14424_ _03841_ _03842_ _03845_ VSS VSS VDD VDD _02225_ sky130_fd_sc_hd__a21oi_1
X_14425_ network.neuron_in195.counter\[1\] VSS VSS VDD VDD
+ _00822_ sky130_fd_sc_hd__inv_1
X_14426_ network.neuron_in132.counter\[0\] VSS VSS VDD VDD
+ _00430_ sky130_fd_sc_hd__inv_1
X_14427_ network.neuron_in216.counter\[1\] VSS VSS VDD VDD
+ _00937_ sky130_fd_sc_hd__inv_1
X_14428_ network.neuron_in113.counter\[0\] VSS VSS VDD VDD
+ _01089_ sky130_fd_sc_hd__inv_1
X_14429_ network.neuron_in140.counter\[2\] net377 VSS VSS
+ VDD VDD _03846_ sky130_fd_sc_hd__nand2_1
X_14430_ network.neuron_in140.counter\[3\] network.in_period\[140\]\[2\]
+ _03846_ VSS VSS VDD VDD _03847_ sky130_fd_sc_hd__o21ai_0
X_14431_ _01081_ network.neuron_in140.counter\[2\] net360
+ VSS VSS VDD VDD _03848_ sky130_fd_sc_hd__or3_1
X_14432_ network.in_period\[140\]\[2\] net377 _03848_ VSS
+ VSS VDD VDD _03849_ sky130_fd_sc_hd__o21ai_0
X_14433_ _01081_ _03847_ _03849_ VSS VSS VDD VDD _02625_ sky130_fd_sc_hd__a21oi_1
X_14434_ network.neuron_in243.counter\[1\] VSS VSS VDD VDD
+ _00912_ sky130_fd_sc_hd__inv_1
X_14435_ network.neuron_in223.counter\[1\] VSS VSS VDD VDD
+ _00933_ sky130_fd_sc_hd__inv_1
X_14436_ network.neuron_in238.counter\[1\] VSS VSS VDD VDD
+ _00925_ sky130_fd_sc_hd__inv_1
X_14437_ network.neuron_in096.counter\[1\] VSS VSS VDD VDD
+ _01211_ sky130_fd_sc_hd__inv_1
X_14438_ network.neuron_in227.counter\[1\] VSS VSS VDD VDD
+ _00929_ sky130_fd_sc_hd__inv_1
X_14439_ network.neuron_in163.counter\[1\] VSS VSS VDD VDD
+ _00818_ sky130_fd_sc_hd__inv_1
X_14440_ network.neuron_in182.counter\[1\] VSS VSS VDD VDD
+ _00838_ sky130_fd_sc_hd__inv_1
X_14441_ network.neuron_in147.counter\[0\] VSS VSS VDD VDD
+ _01198_ sky130_fd_sc_hd__inv_1
Xplace278 net278 VSS VSS VDD VDD net277 sky130_fd_sc_hd__buf_6
X_14443_ network.neuron_in147.counter\[3\] _01200_ VSS VSS
+ VDD VDD _03851_ sky130_fd_sc_hd__nand2b_1
X_14444_ network.neuron_in147.counter\[2\] VSS VSS VDD VDD
+ _03852_ sky130_fd_sc_hd__inv_1
X_14445_ _03851_ _03852_ VSS VSS VDD VDD _03853_ sky130_fd_sc_hd__nand2b_1
X_14446_ net381 _03853_ VSS VSS VDD VDD _03854_ sky130_fd_sc_hd__nand2_1
X_14447_ net586 _03854_ VSS VSS VDD VDD _03855_ sky130_fd_sc_hd__nand2_1
X_14448_ network.neuron_in147.counter\[0\] _03854_ _03855_
+ VSS VSS VDD VDD _02651_ sky130_fd_sc_hd__o21ai_0
X_14449_ network.neuron_in235.counter\[1\] VSS VSS VDD VDD
+ _00318_ sky130_fd_sc_hd__inv_1
X_14450_ network.neuron_in201.counter\[1\] VSS VSS VDD VDD
+ _01151_ sky130_fd_sc_hd__inv_1
X_14451_ network.neuron_in225.counter\[1\] VSS VSS VDD VDD
+ _00842_ sky130_fd_sc_hd__inv_1
X_14452_ network.neuron_in253.counter\[1\] VSS VSS VDD VDD
+ _00754_ sky130_fd_sc_hd__inv_1
X_14453_ network.neuron_in167.counter\[1\] VSS VSS VDD VDD
+ _00921_ sky130_fd_sc_hd__inv_1
X_14454_ network.neuron_in124.counter\[0\] VSS VSS VDD VDD
+ _00365_ sky130_fd_sc_hd__inv_1
X_14455_ network.neuron_in175.counter\[1\] VSS VSS VDD VDD
+ _00806_ sky130_fd_sc_hd__inv_1
X_14456_ network.neuron_in104.counter\[0\] VSS VSS VDD VDD
+ _00529_ sky130_fd_sc_hd__inv_1
X_14457_ network.neuron_in164.counter\[1\] VSS VSS VDD VDD
+ _00861_ sky130_fd_sc_hd__inv_1
X_14458_ network.neuron_hid2.IF0.ref_counter\[1\] VSS VSS
+ VDD VDD _00784_ sky130_fd_sc_hd__inv_1
X_14459_ network.neuron_in112.counter\[0\] VSS VSS VDD VDD
+ _00745_ sky130_fd_sc_hd__inv_1
X_14460_ network.in_period\[42\]\[1\] _03838_ VSS VSS VDD
+ VDD _03856_ sky130_fd_sc_hd__nand2_1
X_14461_ _00308_ _03838_ _03856_ VSS VSS VDD VDD _02232_ sky130_fd_sc_hd__o21ai_0
X_14462_ network.neuron_in185.counter\[1\] VSS VSS VDD VDD
+ _00762_ sky130_fd_sc_hd__inv_1
X_14463_ network.neuron_in129.counter\[1\] VSS VSS VDD VDD
+ _00402_ sky130_fd_sc_hd__inv_1
X_14464_ network.neuron_in136.counter\[1\] VSS VSS VDD VDD
+ _01114_ sky130_fd_sc_hd__inv_1
X_14465_ network.neuron_hid5.IF0.ref_counter\[1\] VSS VSS
+ VDD VDD _00916_ sky130_fd_sc_hd__inv_1
X_14466_ network.neuron_in130.counter\[1\] VSS VSS VDD VDD
+ _00459_ sky130_fd_sc_hd__inv_1
X_14467_ network.neuron_in027.counter\[0\] VSS VSS VDD VDD
+ _00464_ sky130_fd_sc_hd__inv_1
X_14468_ network.neuron_in126.counter\[0\] VSS VSS VDD VDD
+ _00723_ sky130_fd_sc_hd__inv_1
X_14469_ network.neuron_in165.counter\[1\] VSS VSS VDD VDD
+ _00871_ sky130_fd_sc_hd__inv_1
X_14470_ net702 _06963_ VSS VSS VDD VDD _03857_ sky130_fd_sc_hd__nand2_1
X_14471_ network.neuron_in157.counter\[0\] _06963_ _03857_
+ VSS VSS VDD VDD _02691_ sky130_fd_sc_hd__o21ai_0
X_14472_ network.in_period\[154\]\[2\] network.neuron_in154.counter\[3\]
+ _01166_ net348 VSS VSS VDD VDD _03858_ sky130_fd_sc_hd__o22ai_1
X_14473_ network.neuron_in154.counter\[2\] _01166_ net387
+ VSS VSS VDD VDD _03859_ sky130_fd_sc_hd__nand3_1
X_14474_ network.in_period\[154\]\[2\] net387 _03859_ VSS
+ VSS VDD VDD _03860_ sky130_fd_sc_hd__o21ai_0
X_14475_ _07828_ _03858_ _03860_ VSS VSS VDD VDD _02681_ sky130_fd_sc_hd__a21oi_1
X_14476_ network.neuron_in087.counter\[1\] VSS VSS VDD VDD
+ _00035_ sky130_fd_sc_hd__inv_1
X_14477_ network.neuron_in166.counter\[1\] VSS VSS VDD VDD
+ _00888_ sky130_fd_sc_hd__inv_1
X_14478_ _03841_ _00323_ VSS VSS VDD VDD _03861_ sky130_fd_sc_hd__nand2_1
X_14479_ network.neuron_in040.counter\[3\] _03861_ VSS VSS
+ VDD VDD _03862_ sky130_fd_sc_hd__or2_2
X_14480_ net375 _03862_ VSS VSS VDD VDD _03863_ sky130_fd_sc_hd__nand2_1
X_14481_ network.in_period\[40\]\[1\] _03863_ VSS VSS VDD
+ VDD _03864_ sky130_fd_sc_hd__nand2_1
X_14482_ _00324_ _03863_ _03864_ VSS VSS VDD VDD _02224_ sky130_fd_sc_hd__o21ai_0
X_14483_ network.neuron_in093.counter\[1\] VSS VSS VDD VDD
+ _01232_ sky130_fd_sc_hd__inv_1
X_14484_ network.neuron_in094.counter\[0\] VSS VSS VDD VDD
+ _01235_ sky130_fd_sc_hd__inv_1
X_14485_ network.neuron_in110.counter\[0\] VSS VSS VDD VDD
+ _00547_ sky130_fd_sc_hd__inv_1
X_14486_ network.neuron_in250.counter\[1\] VSS VSS VDD VDD
+ _00904_ sky130_fd_sc_hd__inv_1
X_14487_ network.neuron_in132.counter\[1\] VSS VSS VDD VDD
+ _00431_ sky130_fd_sc_hd__inv_1
X_14488_ network.neuron_in095.counter\[1\] VSS VSS VDD VDD
+ _01246_ sky130_fd_sc_hd__inv_1
X_14489_ network.neuron_in246.counter\[1\] VSS VSS VDD VDD
+ _00875_ sky130_fd_sc_hd__inv_1
X_14490_ network.neuron_in040.counter\[0\] VSS VSS VDD VDD
+ _00321_ sky130_fd_sc_hd__inv_1
X_14491_ network.in_period\[40\]\[0\] _03863_ VSS VSS VDD
+ VDD _03865_ sky130_fd_sc_hd__nand2_1
X_14492_ network.neuron_in040.counter\[0\] _03863_ _03865_
+ VSS VSS VDD VDD _02223_ sky130_fd_sc_hd__o21ai_0
X_14493_ network.neuron_in096.counter\[0\] VSS VSS VDD VDD
+ _01210_ sky130_fd_sc_hd__inv_1
X_14494_ network.neuron_in221.counter\[1\] VSS VSS VDD VDD
+ _00896_ sky130_fd_sc_hd__inv_1
X_14495_ network.neuron_in145.counter\[0\] VSS VSS VDD VDD
+ _00641_ sky130_fd_sc_hd__inv_1
X_14496_ network.neuron_in146.counter\[2\] net387 VSS VSS
+ VDD VDD _03866_ sky130_fd_sc_hd__nand2_1
X_14497_ network.neuron_in146.counter\[3\] network.in_period\[146\]\[2\]
+ _03866_ VSS VSS VDD VDD _03867_ sky130_fd_sc_hd__o21ai_0
X_14498_ _00299_ network.neuron_in146.counter\[2\] net348
+ VSS VSS VDD VDD _03868_ sky130_fd_sc_hd__or3_1
X_14499_ network.in_period\[146\]\[2\] net387 _03868_ VSS
+ VSS VDD VDD _03869_ sky130_fd_sc_hd__o21ai_0
X_14500_ _00299_ _03867_ _03869_ VSS VSS VDD VDD _02649_ sky130_fd_sc_hd__a21oi_1
X_14501_ network.neuron_in207.counter\[1\] VSS VSS VDD VDD
+ _00814_ sky130_fd_sc_hd__inv_1
X_14502_ network.neuron_in086.counter\[1\] VSS VSS VDD VDD
+ _00039_ sky130_fd_sc_hd__inv_1
X_14503_ network.neuron_in147.counter\[3\] network.in_period\[147\]\[2\]
+ _01200_ net358 VSS VSS VDD VDD _03870_ sky130_fd_sc_hd__o22ai_1
X_14504_ network.neuron_in147.counter\[2\] _01200_ net381
+ VSS VSS VDD VDD _03871_ sky130_fd_sc_hd__nand3_1
X_14505_ network.in_period\[147\]\[2\] net381 _03871_ VSS
+ VSS VDD VDD _03872_ sky130_fd_sc_hd__o21ai_0
X_14506_ _03852_ _03870_ _03872_ VSS VSS VDD VDD _02653_ sky130_fd_sc_hd__a21oi_1
X_14507_ net570 _03854_ VSS VSS VDD VDD _03873_ sky130_fd_sc_hd__nand2_1
X_14508_ _01201_ _03854_ _03873_ VSS VSS VDD VDD _02652_ sky130_fd_sc_hd__o21ai_0
X_14509_ network.neuron_in145.counter\[3\] _00643_ VSS VSS
+ VDD VDD _03874_ sky130_fd_sc_hd__nand2b_1
X_14510_ network.neuron_in145.counter\[2\] VSS VSS VDD VDD
+ _03875_ sky130_fd_sc_hd__inv_1
X_14511_ _03874_ _03875_ VSS VSS VDD VDD _03876_ sky130_fd_sc_hd__nand2b_1
X_14512_ net383 _03876_ VSS VSS VDD VDD _03877_ sky130_fd_sc_hd__nand2_1
X_14513_ net659 _03877_ VSS VSS VDD VDD _03878_ sky130_fd_sc_hd__nand2_1
X_14514_ network.neuron_in145.counter\[0\] _03877_ _03878_
+ VSS VSS VDD VDD _02643_ sky130_fd_sc_hd__o21ai_0
X_14515_ network.neuron_in180.counter\[1\] VSS VSS VDD VDD
+ _00850_ sky130_fd_sc_hd__inv_1
X_14516_ network.neuron_in247.counter\[1\] VSS VSS VDD VDD
+ _00892_ sky130_fd_sc_hd__inv_1
X_14517_ network.neuron_in209.counter\[1\] VSS VSS VDD VDD
+ _00810_ sky130_fd_sc_hd__inv_1
X_14518_ network.neuron_in055.counter\[0\] VSS VSS VDD VDD
+ _00241_ sky130_fd_sc_hd__inv_1
X_14519_ network.neuron_in094.counter\[1\] VSS VSS VDD VDD
+ _01236_ sky130_fd_sc_hd__inv_1
X_14520_ network.neuron_in087.counter\[0\] VSS VSS VDD VDD
+ _00034_ sky130_fd_sc_hd__inv_1
X_14521_ network.neuron_in154.counter\[1\] VSS VSS VDD VDD
+ _01165_ sky130_fd_sc_hd__inv_1
X_14522_ network.neuron_in031.counter\[1\] VSS VSS VDD VDD
+ _01203_ sky130_fd_sc_hd__inv_1
X_14523_ network.neuron_hid3.IF0.ref_counter\[1\] VSS VSS
+ VDD VDD _00879_ sky130_fd_sc_hd__inv_1
X_14524_ network.neuron_in086.counter\[0\] VSS VSS VDD VDD
+ _00038_ sky130_fd_sc_hd__inv_1
X_14525_ network.neuron_in041.counter\[2\] network.neuron_in041.counter\[3\]
+ VSS VSS VDD VDD _03879_ sky130_fd_sc_hd__nor2_1
X_14526_ _00311_ _03879_ VSS VSS VDD VDD _03880_ sky130_fd_sc_hd__nand2_1
X_14527_ net371 _03880_ VSS VSS VDD VDD _03881_ sky130_fd_sc_hd__nand2_1
X_14528_ network.in_period\[41\]\[1\] _03881_ VSS VSS VDD
+ VDD _03882_ sky130_fd_sc_hd__nand2_1
X_14529_ _00312_ _03881_ _03882_ VSS VSS VDD VDD _02228_ sky130_fd_sc_hd__o21ai_0
X_14530_ network.neuron_in107.counter\[0\] VSS VSS VDD VDD
+ _00749_ sky130_fd_sc_hd__inv_1
X_14531_ net756 _03881_ VSS VSS VDD VDD _03883_ sky130_fd_sc_hd__nand2_1
X_14532_ network.neuron_in041.counter\[0\] _03881_ _03883_
+ VSS VSS VDD VDD _02227_ sky130_fd_sc_hd__o21ai_0
X_14533_ network.neuron_in042.counter\[2\] net369 VSS VSS
+ VDD VDD _03884_ sky130_fd_sc_hd__nand2_1
X_14534_ network.neuron_in042.counter\[3\] network.in_period\[42\]\[2\]
+ _03884_ VSS VSS VDD VDD _03885_ sky130_fd_sc_hd__o21ai_0
X_14535_ _00307_ network.neuron_in042.counter\[2\] net350
+ VSS VSS VDD VDD _03886_ sky130_fd_sc_hd__or3_1
X_14536_ network.in_period\[42\]\[2\] net369 _03886_ VSS VSS
+ VDD VDD _03887_ sky130_fd_sc_hd__o21ai_0
X_14537_ _00307_ _03885_ _03887_ VSS VSS VDD VDD _02233_ sky130_fd_sc_hd__a21oi_1
X_14538_ network.neuron_in108.counter\[0\] VSS VSS VDD VDD
+ _01154_ sky130_fd_sc_hd__inv_1
X_14539_ network.neuron_in116.counter\[1\] VSS VSS VDD VDD
+ _00091_ sky130_fd_sc_hd__inv_1
X_14540_ network.neuron_in099.counter\[0\] VSS VSS VDD VDD
+ _00704_ sky130_fd_sc_hd__inv_1
X_14541_ network.neuron_in131.counter\[1\] VSS VSS VDD VDD
+ _01161_ sky130_fd_sc_hd__inv_1
X_14542_ network.neuron_in043.counter\[2\] VSS VSS VDD VDD
+ _03888_ sky130_fd_sc_hd__inv_1
X_14543_ network.neuron_in043.counter\[3\] network.in_period\[43\]\[2\]
+ net354 _00291_ VSS VSS VDD VDD _03889_ sky130_fd_sc_hd__o22ai_1
Xplace276 _09567_ VSS VSS VDD VDD net275 sky130_fd_sc_hd__buf_4
X_14545_ network.neuron_in043.counter\[2\] _00291_ net375
+ VSS VSS VDD VDD _03891_ sky130_fd_sc_hd__nand3_1
X_14546_ network.in_period\[43\]\[2\] net375 _03891_ VSS VSS
+ VDD VDD _03892_ sky130_fd_sc_hd__o21ai_0
X_14547_ _03888_ _03889_ _03892_ VSS VSS VDD VDD _02237_ sky130_fd_sc_hd__a21oi_1
X_14548_ net301 _07385_ _07498_ _07968_ VSS VSS VDD VDD _03893_
+ sky130_fd_sc_hd__a22oi_1
X_14549_ _07495_ _03893_ net393 VSS VSS VDD VDD _03894_ sky130_fd_sc_hd__o21bai_1
X_14550_ _07559_ _07854_ VSS VSS VDD VDD _03895_ sky130_fd_sc_hd__nand2_1
X_14551_ _07567_ _07586_ _07886_ _03895_ VSS VSS VDD VDD _03896_
+ sky130_fd_sc_hd__a2bb2oi_1
X_14552_ net408 _03896_ VSS VSS VDD VDD _03897_ sky130_fd_sc_hd__nor2_1
X_14553_ net398 net410 network.neuron_hid0.ROM0.address\[1\]
+ VSS VSS VDD VDD _03898_ sky130_fd_sc_hd__o21ai_0
X_14554_ _07999_ _03898_ VSS VSS VDD VDD _03899_ sky130_fd_sc_hd__nand2_1
X_14555_ net323 _07959_ _03899_ net402 VSS VSS VDD VDD _03900_
+ sky130_fd_sc_hd__a22oi_1
X_14556_ net398 net325 net322 net402 VSS VSS VDD VDD _03901_
+ sky130_fd_sc_hd__a22oi_1
X_14557_ net406 _03900_ _03901_ net317 VSS VSS VDD VDD _03902_
+ sky130_fd_sc_hd__o22ai_1
X_14558_ net339 _03902_ VSS VSS VDD VDD _03903_ sky130_fd_sc_hd__nand2_1
X_14559_ net396 net398 net407 _08109_ VSS VSS VDD VDD _03904_
+ sky130_fd_sc_hd__nand4_1
X_14560_ net392 _03903_ _03904_ _07283_ VSS VSS VDD VDD _03905_
+ sky130_fd_sc_hd__a31oi_1
X_14561_ _03894_ _03897_ _03905_ VSS VSS VDD VDD _03906_ sky130_fd_sc_hd__o21ai_0
X_14562_ net402 _07856_ net330 VSS VSS VDD VDD _03907_ sky130_fd_sc_hd__nand3_1
X_14563_ net402 net319 _03907_ _07484_ _07959_ VSS VSS VDD
+ VDD _03908_ sky130_fd_sc_hd__o2111ai_1
X_14564_ _03906_ _03908_ VSS VSS VDD VDD _01742_ sky130_fd_sc_hd__nand2_1
X_14565_ net405 net328 VSS VSS VDD VDD _03909_ sky130_fd_sc_hd__nand2_1
X_14566_ net392 net339 VSS VSS VDD VDD _03910_ sky130_fd_sc_hd__nor2_1
X_14567_ _07498_ _03910_ VSS VSS VDD VDD _03911_ sky130_fd_sc_hd__nand2_1
X_14568_ _03909_ _03911_ VSS VSS VDD VDD _03912_ sky130_fd_sc_hd__nor2_1
X_14569_ net401 net334 _07943_ VSS VSS VDD VDD _03913_ sky130_fd_sc_hd__nand3_1
X_14570_ net401 net313 _03913_ VSS VSS VDD VDD _03914_ sky130_fd_sc_hd__o21ai_0
X_14571_ _07875_ _08198_ net401 VSS VSS VDD VDD _03915_ sky130_fd_sc_hd__a21oi_1
X_14572_ net303 _03915_ network.neuron_hid0.ROM0.address\[0\]
+ VSS VSS VDD VDD _03916_ sky130_fd_sc_hd__o21ai_0
X_14573_ network.neuron_hid0.ROM0.address\[0\] _03914_ _03916_
+ VSS VSS VDD VDD _03917_ sky130_fd_sc_hd__o21ai_0
X_14574_ net399 net332 net318 _07476_ VSS VSS VDD VDD _03918_
+ sky130_fd_sc_hd__a22oi_1
X_14575_ net395 _03917_ _03918_ net344 VSS VSS VDD VDD _03919_
+ sky130_fd_sc_hd__o2bb2ai_1
X_14576_ net399 _07621_ _08098_ _07586_ _07841_ VSS VSS VDD
+ VDD _03920_ sky130_fd_sc_hd__o32ai_1
X_14577_ net392 _03919_ _03920_ _03910_ VSS VSS VDD VDD _03921_
+ sky130_fd_sc_hd__a22o_1
X_14578_ _03912_ _03921_ _07537_ VSS VSS VDD VDD _03922_ sky130_fd_sc_hd__o21ai_0
X_14579_ _07436_ _08056_ net343 VSS VSS VDD VDD _03923_ sky130_fd_sc_hd__a21o_1
X_14580_ _07276_ _07471_ _07854_ _03923_ VSS VSS VDD VDD _03924_
+ sky130_fd_sc_hd__o211ai_1
X_14581_ net402 net294 _07276_ _07390_ VSS VSS VDD VDD _03925_
+ sky130_fd_sc_hd__nor4_1
X_14582_ net347 _07537_ _03924_ _03925_ VSS VSS VDD VDD _03926_
+ sky130_fd_sc_hd__a31oi_1
X_14583_ _03922_ _03926_ VSS VSS VDD VDD _01743_ sky130_fd_sc_hd__nand2_1
X_14584_ net343 net405 VSS VSS VDD VDD _03927_ sky130_fd_sc_hd__nor2_1
X_14585_ net328 _03927_ net312 net327 VSS VSS VDD VDD _03928_
+ sky130_fd_sc_hd__a22oi_1
X_14586_ net336 _07870_ net341 VSS VSS VDD VDD _03929_ sky130_fd_sc_hd__a21oi_1
X_14587_ _07872_ _03929_ VSS VSS VDD VDD _03930_ sky130_fd_sc_hd__nor2_1
X_14588_ network.neuron_hid0.ROM0.address\[1\] _03927_ net302
+ VSS VSS VDD VDD _03931_ sky130_fd_sc_hd__o21ai_0
X_14589_ net398 _03930_ _03931_ VSS VSS VDD VDD _03932_ sky130_fd_sc_hd__o21ai_0
X_14590_ net338 _07447_ VSS VSS VDD VDD _03933_ sky130_fd_sc_hd__nor2_1
X_14591_ _08198_ _07943_ net401 VSS VSS VDD VDD _03934_ sky130_fd_sc_hd__a21oi_1
X_14592_ _03933_ _03934_ network.neuron_hid0.ROM0.address\[0\]
+ VSS VSS VDD VDD _03935_ sky130_fd_sc_hd__o21ai_0
X_14593_ net335 net334 net407 VSS VSS VDD VDD _03936_ sky130_fd_sc_hd__a21oi_1
X_14594_ net303 _03936_ net307 VSS VSS VDD VDD _03937_ sky130_fd_sc_hd__o21ai_0
X_14595_ _03935_ _03937_ _08206_ VSS VSS VDD VDD _03938_ sky130_fd_sc_hd__a21oi_1
X_14596_ _08209_ _03932_ _03938_ VSS VSS VDD VDD _03939_ sky130_fd_sc_hd__a21oi_1
X_14597_ net403 _07483_ _03928_ _03939_ net391 VSS VSS VDD
+ VDD _03940_ sky130_fd_sc_hd__o32ai_1
X_14598_ net316 _08174_ net403 VSS VSS VDD VDD _03941_ sky130_fd_sc_hd__o21ai_0
X_14599_ _07865_ net312 _08048_ net397 net410 VSS VSS VDD
+ VDD _03942_ sky130_fd_sc_hd__a221oi_1
X_14600_ net410 _03941_ _03942_ _08404_ VSS VSS VDD VDD _03943_
+ sky130_fd_sc_hd__a211oi_1
X_14601_ _03940_ _03943_ VSS VSS VDD VDD _03944_ sky130_fd_sc_hd__nor2_1
X_14602_ net336 _08449_ VSS VSS VDD VDD _03945_ sky130_fd_sc_hd__nor2_1
X_14603_ net398 net409 net405 VSS VSS VDD VDD _03946_ sky130_fd_sc_hd__a21oi_1
X_14604_ _07276_ _07299_ _03946_ net403 VSS VSS VDD VDD _03947_
+ sky130_fd_sc_hd__o22ai_1
X_14605_ _03945_ _03947_ VSS VSS VDD VDD _03948_ sky130_fd_sc_hd__nand2_1
X_14606_ _03944_ _03948_ _07282_ VSS VSS VDD VDD _01744_ sky130_fd_sc_hd__a21oi_1
X_14607_ net342 net320 VSS VSS VDD VDD _03949_ sky130_fd_sc_hd__nor2_1
X_14608_ _07453_ _07584_ net399 VSS VSS VDD VDD _03950_ sky130_fd_sc_hd__a21oi_1
X_14609_ _03949_ _03950_ net409 VSS VSS VDD VDD _03951_ sky130_fd_sc_hd__o21ai_0
X_14610_ net346 net312 VSS VSS VDD VDD _03952_ sky130_fd_sc_hd__nand2_1
X_14611_ net411 net402 net404 VSS VSS VDD VDD _03953_ sky130_fd_sc_hd__nor3b_1
X_14612_ _07986_ _03953_ net400 VSS VSS VDD VDD _03954_ sky130_fd_sc_hd__o21ai_0
X_14613_ _03952_ _03954_ net409 VSS VSS VDD VDD _03955_ sky130_fd_sc_hd__a21o_1
X_14614_ _07571_ _07447_ _03951_ _03955_ VSS VSS VDD VDD _03956_
+ sky130_fd_sc_hd__o211ai_1
X_14615_ network.neuron_hid0.ROM0.address\[1\] _08047_ net402
+ VSS VSS VDD VDD _03957_ sky130_fd_sc_hd__a21oi_1
X_14616_ net396 net405 _07621_ _07999_ VSS VSS VDD VDD _03958_
+ sky130_fd_sc_hd__nand4_1
X_14617_ _03957_ _03958_ net392 VSS VSS VDD VDD _03959_ sky130_fd_sc_hd__o21ai_0
X_14618_ net339 _03956_ _03959_ VSS VSS VDD VDD _03960_ sky130_fd_sc_hd__a21oi_1
X_14619_ net396 net336 _07870_ VSS VSS VDD VDD _03961_ sky130_fd_sc_hd__nand3_1
X_14620_ _07436_ _03961_ net341 VSS VSS VDD VDD _03962_ sky130_fd_sc_hd__a21oi_1
X_14621_ _07473_ net311 _03962_ VSS VSS VDD VDD _03963_ sky130_fd_sc_hd__a21oi_1
X_14622_ _07870_ net320 _07841_ _07607_ VSS VSS VDD VDD _03964_
+ sky130_fd_sc_hd__o22ai_1
X_14623_ net396 _03964_ net392 VSS VSS VDD VDD _03965_ sky130_fd_sc_hd__a21oi_1
X_14624_ net396 _07542_ VSS VSS VDD VDD _03966_ sky130_fd_sc_hd__nor2_1
X_14625_ net319 _03966_ net398 net340 VSS VSS VDD VDD _03967_
+ sky130_fd_sc_hd__o211ai_1
X_14626_ net398 _03963_ _03965_ _03967_ VSS VSS VDD VDD _03968_
+ sky130_fd_sc_hd__o211ai_1
X_14627_ _07537_ _03968_ VSS VSS VDD VDD _03969_ sky130_fd_sc_hd__nand2_1
X_14628_ net334 _07607_ VSS VSS VDD VDD _03970_ sky130_fd_sc_hd__nor2_1
X_14629_ net406 network.neuron_hid0.ROM0.address\[1\] _07855_
+ _03970_ VSS VSS VDD VDD _03971_ sky130_fd_sc_hd__a31oi_1
X_14630_ _07872_ _03927_ VSS VSS VDD VDD _03972_ sky130_fd_sc_hd__nand2_1
X_14631_ net398 _03971_ _03972_ VSS VSS VDD VDD _03973_ sky130_fd_sc_hd__o21ai_0
X_14632_ _07484_ _03973_ VSS VSS VDD VDD _03974_ sky130_fd_sc_hd__nand2_1
X_14633_ _03960_ _03969_ _03974_ VSS VSS VDD VDD _01745_ sky130_fd_sc_hd__o21ai_0
X_14634_ _07559_ _07854_ net300 _07549_ net408 VSS VSS VDD
+ VDD _03975_ sky130_fd_sc_hd__a2111oi_0
X_14635_ _03894_ _03975_ _03905_ VSS VSS VDD VDD _03976_ sky130_fd_sc_hd__o21ai_0
X_14636_ _03908_ _03976_ VSS VSS VDD VDD _01746_ sky130_fd_sc_hd__nand2_1
X_14637_ _07986_ _07458_ _07376_ VSS VSS VDD VDD _03977_ sky130_fd_sc_hd__o21ai_0
X_14638_ net401 net334 _07841_ VSS VSS VDD VDD _03978_ sky130_fd_sc_hd__o21ai_0
X_14639_ network.neuron_hid0.ROM0.address\[0\] _03977_ _03978_
+ net319 VSS VSS VDD VDD _03979_ sky130_fd_sc_hd__a22o_1
X_14640_ net347 _07537_ _03979_ _03925_ VSS VSS VDD VDD _03980_
+ sky130_fd_sc_hd__a31oi_1
X_14641_ _03922_ _03980_ VSS VSS VDD VDD _01747_ sky130_fd_sc_hd__nand2_1
X_14642_ net343 net344 _07376_ VSS VSS VDD VDD _03981_ sky130_fd_sc_hd__nand3_1
X_14643_ _07921_ _08091_ _03945_ _03981_ VSS VSS VDD VDD _03982_
+ sky130_fd_sc_hd__nand4_1
X_14644_ _03944_ _03982_ _07282_ VSS VSS VDD VDD _01748_ sky130_fd_sc_hd__a21oi_1
X_14645_ net398 _07870_ VSS VSS VDD VDD _03983_ sky130_fd_sc_hd__nor2_1
X_14646_ net398 _07865_ _03983_ VSS VSS VDD VDD _03984_ sky130_fd_sc_hd__a21oi_1
X_14647_ net340 net307 _07473_ net343 VSS VSS VDD VDD _03985_
+ sky130_fd_sc_hd__a22oi_1
X_14648_ net320 _03984_ _03985_ net406 VSS VSS VDD VDD _03986_
+ sky130_fd_sc_hd__o22ai_1
X_14649_ _03909_ _08056_ _03911_ VSS VSS VDD VDD _03987_ sky130_fd_sc_hd__a21oi_1
X_14650_ net343 net344 _07932_ VSS VSS VDD VDD _03988_ sky130_fd_sc_hd__o21ai_0
X_14651_ net343 _07368_ _03988_ net409 VSS VSS VDD VDD _03989_
+ sky130_fd_sc_hd__a22oi_1
X_14652_ _07866_ _07854_ _03989_ net410 VSS VSS VDD VDD _03990_
+ sky130_fd_sc_hd__o22ai_1
X_14653_ net396 _03990_ VSS VSS VDD VDD _03991_ sky130_fd_sc_hd__nand2_1
X_14654_ _07299_ _08427_ _07905_ net397 VSS VSS VDD VDD _03992_
+ sky130_fd_sc_hd__a31oi_1
X_14655_ net398 net327 _03992_ VSS VSS VDD VDD _03993_ sky130_fd_sc_hd__a21oi_1
X_14656_ net341 _03993_ net396 VSS VSS VDD VDD _03994_ sky130_fd_sc_hd__o21ai_0
X_14657_ net396 _03956_ _03994_ net392 VSS VSS VDD VDD _03995_
+ sky130_fd_sc_hd__o211ai_1
X_14658_ net392 _03991_ _03995_ VSS VSS VDD VDD _03996_ sky130_fd_sc_hd__o21ai_0
X_14659_ net347 _03986_ _03987_ _03996_ VSS VSS VDD VDD _03997_
+ sky130_fd_sc_hd__a211oi_1
X_14660_ _07283_ _03997_ _03974_ VSS VSS VDD VDD _01749_ sky130_fd_sc_hd__o21ai_0
X_14661_ _03921_ _03987_ _07537_ VSS VSS VDD VDD _03998_ sky130_fd_sc_hd__o21ai_0
X_14662_ _03980_ _03998_ VSS VSS VDD VDD _01750_ sky130_fd_sc_hd__nand2_1
X_14663_ _07598_ _08010_ net397 VSS VSS VDD VDD _03999_ sky130_fd_sc_hd__o21ai_0
X_14664_ _07276_ _07299_ _07376_ VSS VSS VDD VDD _04000_ sky130_fd_sc_hd__o21ai_0
X_14665_ net410 _04000_ VSS VSS VDD VDD _04001_ sky130_fd_sc_hd__nand2_1
X_14666_ _03999_ _04001_ _08449_ VSS VSS VDD VDD _04002_ sky130_fd_sc_hd__a21oi_1
X_14667_ net307 net328 net341 VSS VSS VDD VDD _04003_ sky130_fd_sc_hd__o21ai_0
X_14668_ _08060_ _07932_ _04003_ VSS VSS VDD VDD _04004_ sky130_fd_sc_hd__o21ai_0
X_14669_ net305 net312 _04004_ net403 VSS VSS VDD VDD _04005_
+ sky130_fd_sc_hd__a22oi_1
X_14670_ _08404_ _04005_ VSS VSS VDD VDD _04006_ sky130_fd_sc_hd__nor2_1
X_14671_ _03940_ _04002_ _04006_ VSS VSS VDD VDD _04007_ sky130_fd_sc_hd__nor3_1
X_14672_ _07282_ _04007_ VSS VSS VDD VDD _01751_ sky130_fd_sc_hd__nor2_1
X_14673_ net398 net316 net314 VSS VSS VDD VDD _04008_ sky130_fd_sc_hd__o21ai_0
X_14674_ net397 _07607_ _07445_ VSS VSS VDD VDD _04009_ sky130_fd_sc_hd__o21ai_0
X_14675_ net325 _04008_ _04009_ net326 VSS VSS VDD VDD _04010_
+ sky130_fd_sc_hd__a22o_1
X_14676_ net347 _04010_ _03996_ _03912_ VSS VSS VDD VDD _04011_
+ sky130_fd_sc_hd__a211oi_1
X_14677_ net341 _07954_ _07584_ VSS VSS VDD VDD _04012_ sky130_fd_sc_hd__o21ai_0
X_14678_ network.neuron_hid0.ROM0.address\[1\] _04012_ _03970_
+ VSS VSS VDD VDD _04013_ sky130_fd_sc_hd__a21oi_1
X_14679_ net398 _04013_ _03972_ VSS VSS VDD VDD _04014_ sky130_fd_sc_hd__o21ai_0
X_14680_ _07484_ _04014_ VSS VSS VDD VDD _04015_ sky130_fd_sc_hd__nand2_1
X_14681_ _07283_ _04011_ _04015_ VSS VSS VDD VDD _01752_ sky130_fd_sc_hd__o21ai_0
X_14682_ network.neuron_in132.counter\[3\] _00432_ VSS VSS
+ VDD VDD _04016_ sky130_fd_sc_hd__nand2b_1
X_14683_ _04016_ _03711_ VSS VSS VDD VDD _04017_ sky130_fd_sc_hd__nand2b_1
X_14684_ net384 _04017_ VSS VSS VDD VDD _04018_ sky130_fd_sc_hd__nand2_1
X_14685_ net741 _04018_ VSS VSS VDD VDD _04019_ sky130_fd_sc_hd__nand2_1
X_14686_ _00433_ _04018_ _04019_ VSS VSS VDD VDD _02592_ sky130_fd_sc_hd__o21ai_0
X_14687_ net701 _04018_ VSS VSS VDD VDD _04020_ sky130_fd_sc_hd__nand2_1
X_14688_ network.neuron_in132.counter\[0\] _04018_ _04020_
+ VSS VSS VDD VDD _02591_ sky130_fd_sc_hd__o21ai_0
X_14689_ loaded\[3\] loaded\[2\] VSS VSS VDD VDD _04021_ sky130_fd_sc_hd__nor2b_4
X_14690_ _00192_ _04021_ VSS VSS VDD VDD _04022_ sky130_fd_sc_hd__nand2_8
Xplace348 _07242_ VSS VSS VDD VDD net347 sky130_fd_sc_hd__buf_4
X_14692_ loaded\[4\] loaded\[5\] icg_load.en VSS VSS VDD VDD
+ _04024_ sky130_fd_sc_hd__and3_2
X_14693_ net413 loaded\[7\] VSS VSS VDD VDD _04025_ sky130_fd_sc_hd__nor2b_2
X_14694_ _04024_ _04025_ VSS VSS VDD VDD _04026_ sky130_fd_sc_hd__nand2_2
Xplace342 _07274_ VSS VSS VDD VDD net341 sky130_fd_sc_hd__buf_4
X_14696_ _04022_ _04026_ VSS VSS VDD VDD _03176_ sky130_fd_sc_hd__nor2_1
X_14697_ _00196_ _08704_ VSS VSS VDD VDD _04028_ sky130_fd_sc_hd__nand2_8
Xclkbuf_leaf_7_clk_net clknet_4_2_0_clk_net VSS VSS VDD VDD
+ clknet_leaf_7_clk_net sky130_fd_sc_hd__clkbuf_16
X_14699_ _08700_ loaded\[4\] loaded\[5\] VSS VSS VDD VDD _04030_
+ sky130_fd_sc_hd__nor3b_4
X_14700_ _04025_ _04030_ VSS VSS VDD VDD _04031_ sky130_fd_sc_hd__nand2_2
Xclkbuf_leaf_6_clk_net clknet_4_2_0_clk_net VSS VSS VDD VDD
+ clknet_leaf_6_clk_net sky130_fd_sc_hd__clkbuf_16
X_14702_ _04028_ _04031_ VSS VSS VDD VDD _03170_ sky130_fd_sc_hd__nor2_1
X_14703_ loaded\[2\] loaded\[3\] VSS VSS VDD VDD _04033_ sky130_fd_sc_hd__nor2b_4
X_14704_ _00192_ _04033_ VSS VSS VDD VDD _04034_ sky130_fd_sc_hd__nand2_8
Xplace393 net393 VSS VSS VDD VDD net392 sky130_fd_sc_hd__buf_4
X_14706_ _04026_ _04034_ VSS VSS VDD VDD _03180_ sky130_fd_sc_hd__nor2_1
X_14707_ _00194_ _08704_ VSS VSS VDD VDD _04036_ sky130_fd_sc_hd__nand2_8
Xplace392 network.neuron_hid0.ROM0.address\[7\] VSS VSS VDD
+ VDD net391 sky130_fd_sc_hd__buf_4
X_14709_ _04031_ _04036_ VSS VSS VDD VDD _03169_ sky130_fd_sc_hd__nor2_1
X_14710_ _00196_ _08630_ VSS VSS VDD VDD _04038_ sky130_fd_sc_hd__nand2_2
Xclkbuf_leaf_5_clk_net clknet_4_0_0_clk_net VSS VSS VDD VDD
+ clknet_leaf_5_clk_net sky130_fd_sc_hd__clkbuf_16
X_14712_ _04026_ net308 VSS VSS VDD VDD _03174_ sky130_fd_sc_hd__nor2_1
X_14713_ _00195_ _08704_ VSS VSS VDD VDD _04040_ sky130_fd_sc_hd__nand2_8
Xplace421 net452 VSS VSS VDD VDD net420 sky130_fd_sc_hd__buf_4
X_14715_ _04031_ _04040_ VSS VSS VDD VDD _03168_ sky130_fd_sc_hd__nor2_1
X_14716_ net412 net442 VSS VSS VDD VDD _04042_ sky130_fd_sc_hd__nand2_2
Xplace394 network.neuron_hid0.ROM0.address\[6\] VSS VSS VDD
+ VDD net393 sky130_fd_sc_hd__buf_4
X_14718_ net308 _04042_ VSS VSS VDD VDD _03271_ sky130_fd_sc_hd__nor2_1
X_14719_ _07868_ _07999_ net341 VSS VSS VDD VDD _04044_ sky130_fd_sc_hd__a21oi_1
X_14720_ net325 net319 _07572_ VSS VSS VDD VDD _04045_ sky130_fd_sc_hd__o21ai_0
X_14721_ net403 net327 net397 VSS VSS VDD VDD _04046_ sky130_fd_sc_hd__o21ai_0
X_14722_ _07299_ net330 _04045_ _04046_ VSS VSS VDD VDD _04047_
+ sky130_fd_sc_hd__o211ai_1
X_14723_ network.neuron_hid0.ROM0.address\[1\] _07954_ _07854_
+ VSS VSS VDD VDD _04048_ sky130_fd_sc_hd__o21ai_0
X_14724_ net392 net396 net343 _04048_ _07283_ VSS VSS VDD
+ VDD _04049_ sky130_fd_sc_hd__a41o_1
X_14725_ net394 net411 _07362_ VSS VSS VDD VDD _04050_ sky130_fd_sc_hd__a21oi_1
X_14726_ net404 _04050_ VSS VSS VDD VDD _04051_ sky130_fd_sc_hd__nor2_1
X_14727_ net409 _07352_ VSS VSS VDD VDD _04052_ sky130_fd_sc_hd__nand2_1
X_14728_ _04052_ _07621_ net394 VSS VSS VDD VDD _04053_ sky130_fd_sc_hd__a21oi_1
X_14729_ _04051_ _04053_ net402 VSS VSS VDD VDD _04054_ sky130_fd_sc_hd__o21ai_0
X_14730_ net404 _08088_ _07897_ VSS VSS VDD VDD _04055_ sky130_fd_sc_hd__o21ai_0
X_14731_ net394 _08167_ _04055_ net408 _07558_ VSS VSS VDD
+ VDD _04056_ sky130_fd_sc_hd__a221oi_1
X_14732_ _04054_ _04056_ VSS VSS VDD VDD _04057_ sky130_fd_sc_hd__nand2_1
X_14733_ _07274_ _07599_ _07354_ VSS VSS VDD VDD _04058_ sky130_fd_sc_hd__a21oi_1
X_14734_ net402 _04058_ net304 VSS VSS VDD VDD _04059_ sky130_fd_sc_hd__o21ai_0
X_14735_ net400 _04057_ _04059_ net318 VSS VSS VDD VDD _04060_
+ sky130_fd_sc_hd__a22oi_1
X_14736_ net305 _08439_ net394 VSS VSS VDD VDD _04061_ sky130_fd_sc_hd__o21ai_0
X_14737_ net394 _07562_ net334 VSS VSS VDD VDD _04062_ sky130_fd_sc_hd__o21ai_0
X_14738_ _07274_ _04062_ VSS VSS VDD VDD _04063_ sky130_fd_sc_hd__nand2_1
X_14739_ _07316_ _04061_ _04063_ net342 VSS VSS VDD VDD _04064_
+ sky130_fd_sc_hd__a31oi_1
X_14740_ net401 net334 VSS VSS VDD VDD _04065_ sky130_fd_sc_hd__nor2_1
X_14741_ net339 _07841_ _04065_ VSS VSS VDD VDD _04066_ sky130_fd_sc_hd__a21oi_1
X_14742_ net401 net335 net334 net394 VSS VSS VDD VDD _04067_
+ sky130_fd_sc_hd__o22ai_1
X_14743_ net346 _08478_ VSS VSS VDD VDD _04068_ sky130_fd_sc_hd__nor2_1
X_14744_ net326 _07968_ _04068_ net401 net406 VSS VSS VDD
+ VDD _04069_ sky130_fd_sc_hd__o221ai_1
X_14745_ net407 _04067_ _04069_ VSS VSS VDD VDD _04070_ sky130_fd_sc_hd__o21ai_0
X_14746_ network.neuron_hid0.ROM0.address\[0\] _04066_ _04070_
+ VSS VSS VDD VDD _04071_ sky130_fd_sc_hd__o21ai_0
X_14747_ net393 _04064_ _04071_ VSS VSS VDD VDD _04072_ sky130_fd_sc_hd__nor3_1
X_14748_ net393 _04060_ _04072_ VSS VSS VDD VDD _04073_ sky130_fd_sc_hd__a21oi_1
X_14749_ net294 _04044_ _04047_ _04049_ _04073_ VSS VSS VDD
+ VDD _01753_ sky130_fd_sc_hd__o32ai_1
X_14750_ _07282_ _07974_ _03909_ _08449_ VSS VSS VDD VDD _01754_
+ sky130_fd_sc_hd__nor4_1
X_14751_ net413 loaded\[7\] _04030_ VSS VSS VDD VDD _04074_
+ sky130_fd_sc_hd__nand3_2
Xplace420 net420 VSS VSS VDD VDD net419 sky130_fd_sc_hd__buf_4
X_14753_ _04034_ _04074_ VSS VSS VDD VDD _03234_ sky130_fd_sc_hd__nor2_1
X_14754_ loaded\[5\] _08700_ loaded\[4\] VSS VSS VDD VDD _04076_
+ sky130_fd_sc_hd__nor3b_2
X_14755_ net413 loaded\[7\] net288 VSS VSS VDD VDD _04077_
+ sky130_fd_sc_hd__nand3_2
Xplace402 network.neuron_hid0.ROM0.address\[4\] VSS VSS VDD
+ VDD net401 sky130_fd_sc_hd__buf_4
X_14757_ _04028_ _04077_ VSS VSS VDD VDD _03224_ sky130_fd_sc_hd__nor2_1
X_14758_ _04040_ _04077_ VSS VSS VDD VDD _03222_ sky130_fd_sc_hd__nor2_1
X_14759_ _00196_ _04033_ VSS VSS VDD VDD _04079_ sky130_fd_sc_hd__nand2_8
Xplace401 net401 VSS VSS VDD VDD net400 sky130_fd_sc_hd__buf_4
X_14761_ _04077_ _04079_ VSS VSS VDD VDD _03219_ sky130_fd_sc_hd__nor2_1
X_14762_ _00196_ _04021_ VSS VSS VDD VDD _04081_ sky130_fd_sc_hd__nand2_8
Xplace397 network.neuron_hid0.ROM0.address\[5\] VSS VSS VDD
+ VDD net396 sky130_fd_sc_hd__buf_4
X_14764_ _04042_ _04081_ VSS VSS VDD VDD _03275_ sky130_fd_sc_hd__nor2_1
X_14765_ _00195_ _04033_ VSS VSS VDD VDD _04083_ sky130_fd_sc_hd__nand2_8
Xplace396 net396 VSS VSS VDD VDD net395 sky130_fd_sc_hd__buf_4
X_14767_ _04077_ _04083_ VSS VSS VDD VDD _03217_ sky130_fd_sc_hd__nor2_1
X_14768_ _00194_ _04021_ VSS VSS VDD VDD _04085_ sky130_fd_sc_hd__nand2_8
Xplace381 net390 VSS VSS VDD VDD net380 sky130_fd_sc_hd__buf_4
X_14770_ _04042_ _04085_ VSS VSS VDD VDD _03274_ sky130_fd_sc_hd__nor2_1
X_14771_ loaded\[4\] loaded\[5\] _08700_ VSS VSS VDD VDD _04087_
+ sky130_fd_sc_hd__nor3_4
X_14772_ net413 loaded\[7\] _04087_ VSS VSS VDD VDD _04088_
+ sky130_fd_sc_hd__nand3_2
Xplace377 net390 VSS VSS VDD VDD net376 sky130_fd_sc_hd__buf_4
X_14774_ _04028_ _04088_ VSS VSS VDD VDD _03206_ sky130_fd_sc_hd__nor2_1
X_14775_ _00195_ _04021_ VSS VSS VDD VDD _04090_ sky130_fd_sc_hd__nand2_8
Xplace369 net371 VSS VSS VDD VDD net368 sky130_fd_sc_hd__buf_4
X_14777_ _04042_ _04090_ VSS VSS VDD VDD _03273_ sky130_fd_sc_hd__nor2_1
X_14778_ _04083_ _04088_ VSS VSS VDD VDD _03200_ sky130_fd_sc_hd__nor2_1
X_14779_ _04034_ _04088_ VSS VSS VDD VDD _03199_ sky130_fd_sc_hd__nor2_1
X_14780_ _04022_ _04088_ VSS VSS VDD VDD _03193_ sky130_fd_sc_hd__nor2_1
X_14781_ net308 _04088_ VSS VSS VDD VDD _03192_ sky130_fd_sc_hd__nor2_1
X_14782_ _04026_ _04040_ VSS VSS VDD VDD _03185_ sky130_fd_sc_hd__nor2_1
X_14783_ _04031_ _04085_ VSS VSS VDD VDD _03160_ sky130_fd_sc_hd__nor2_1
Xplace367 net367 VSS VSS VDD VDD net366 sky130_fd_sc_hd__buf_4
X_14785_ _08631_ _04031_ VSS VSS VDD VDD _03154_ sky130_fd_sc_hd__nor2_1
X_14786_ _00192_ _08704_ VSS VSS VDD VDD _04093_ sky130_fd_sc_hd__nand2_8
Xplace366 net367 VSS VSS VDD VDD net365 sky130_fd_sc_hd__buf_4
X_14788_ _04025_ net288 VSS VSS VDD VDD _04095_ sky130_fd_sc_hd__nand2_2
Xplace368 net390 VSS VSS VDD VDD net367 sky130_fd_sc_hd__buf_4
X_14790_ _04093_ _04095_ VSS VSS VDD VDD _03149_ sky130_fd_sc_hd__nor2_1
X_14791_ _04028_ _04074_ VSS VSS VDD VDD _03241_ sky130_fd_sc_hd__nor2_1
X_14792_ _04083_ _04095_ VSS VSS VDD VDD _03146_ sky130_fd_sc_hd__nor2_1
X_14793_ _04025_ _04087_ VSS VSS VDD VDD _04097_ sky130_fd_sc_hd__nand2_2
Xplace376 net376 VSS VSS VDD VDD net375 sky130_fd_sc_hd__buf_4
X_14795_ net308 _04097_ VSS VSS VDD VDD _03122_ sky130_fd_sc_hd__nor2_1
X_14796_ _00194_ _08630_ VSS VSS VDD VDD _04099_ sky130_fd_sc_hd__nand2_8
Xplace375 net375 VSS VSS VDD VDD net374 sky130_fd_sc_hd__buf_4
X_14798_ _04097_ _04099_ VSS VSS VDD VDD _03121_ sky130_fd_sc_hd__nor2_1
X_14799_ _00195_ _08630_ VSS VSS VDD VDD _04101_ sky130_fd_sc_hd__nand2_1
Xplace374 net374 VSS VSS VDD VDD net373 sky130_fd_sc_hd__buf_4
X_14801_ _04097_ net295 VSS VSS VDD VDD _03119_ sky130_fd_sc_hd__nor2_1
X_14802_ _08631_ _04097_ VSS VSS VDD VDD _03118_ sky130_fd_sc_hd__nor2_1
X_14803_ net413 loaded\[7\] _04024_ VSS VSS VDD VDD _04103_
+ sky130_fd_sc_hd__nand3_2
Xplace373 net375 VSS VSS VDD VDD net372 sky130_fd_sc_hd__buf_4
X_14805_ _04028_ _04103_ VSS VSS VDD VDD _03259_ sky130_fd_sc_hd__nor2_1
X_14806_ loaded\[7\] net413 VSS VSS VDD VDD _04105_ sky130_fd_sc_hd__nor2b_2
X_14807_ _04024_ _04105_ VSS VSS VDD VDD _04106_ sky130_fd_sc_hd__nand2_2
Xplace372 net376 VSS VSS VDD VDD net371 sky130_fd_sc_hd__buf_4
X_14809_ _04028_ _04106_ VSS VSS VDD VDD _03117_ sky130_fd_sc_hd__nor2_1
X_14810_ _04036_ _04106_ VSS VSS VDD VDD _03116_ sky130_fd_sc_hd__nor2_1
X_14811_ _04093_ _04106_ VSS VSS VDD VDD _03114_ sky130_fd_sc_hd__nor2_1
X_14812_ _04079_ _04106_ VSS VSS VDD VDD _03113_ sky130_fd_sc_hd__nor2_1
X_14813_ _00194_ _04033_ VSS VSS VDD VDD _04108_ sky130_fd_sc_hd__nand2_8
Xplace371 net371 VSS VSS VDD VDD net370 sky130_fd_sc_hd__buf_4
X_14815_ _04106_ _04108_ VSS VSS VDD VDD _03112_ sky130_fd_sc_hd__nor2_1
X_14816_ _04083_ _04106_ VSS VSS VDD VDD _03111_ sky130_fd_sc_hd__nor2_1
X_14817_ _04034_ _04106_ VSS VSS VDD VDD _03110_ sky130_fd_sc_hd__nor2_1
X_14818_ _04081_ _04106_ VSS VSS VDD VDD _03108_ sky130_fd_sc_hd__nor2_1
X_14819_ _04085_ _04106_ VSS VSS VDD VDD _03107_ sky130_fd_sc_hd__nor2_1
X_14820_ _04090_ _04106_ VSS VSS VDD VDD _03106_ sky130_fd_sc_hd__nor2_1
X_14821_ _04022_ _04106_ VSS VSS VDD VDD _03105_ sky130_fd_sc_hd__nor2_1
X_14822_ net308 _04106_ VSS VSS VDD VDD _03104_ sky130_fd_sc_hd__nor2_1
X_14823_ _04099_ _04106_ VSS VSS VDD VDD _03103_ sky130_fd_sc_hd__nor2_1
X_14824_ network.neuron_in044.counter\[2\] VSS VSS VDD VDD
+ _04110_ sky130_fd_sc_hd__inv_1
X_14825_ network.neuron_in044.counter\[3\] network.in_period\[44\]\[2\]
+ net355 _00283_ VSS VSS VDD VDD _04111_ sky130_fd_sc_hd__o22ai_1
X_14826_ network.neuron_in044.counter\[2\] _00283_ net372
+ VSS VSS VDD VDD _04112_ sky130_fd_sc_hd__nand3_1
X_14827_ network.in_period\[44\]\[2\] net372 _04112_ VSS VSS
+ VDD VDD _04113_ sky130_fd_sc_hd__o21ai_0
X_14828_ _04110_ _04111_ _04113_ VSS VSS VDD VDD _02241_ sky130_fd_sc_hd__a21oi_1
X_14829_ net295 _04106_ VSS VSS VDD VDD _03102_ sky130_fd_sc_hd__nor2_1
X_14830_ _04074_ _04083_ VSS VSS VDD VDD _03235_ sky130_fd_sc_hd__nor2_1
X_14831_ _04074_ _04090_ VSS VSS VDD VDD _03230_ sky130_fd_sc_hd__nor2_1
X_14832_ _04077_ _04081_ VSS VSS VDD VDD _03215_ sky130_fd_sc_hd__nor2_1
X_14833_ _04077_ _04085_ VSS VSS VDD VDD _03214_ sky130_fd_sc_hd__nor2_1
X_14834_ _08631_ _04077_ VSS VSS VDD VDD _03207_ sky130_fd_sc_hd__nor2_1
X_14835_ _04085_ _04088_ VSS VSS VDD VDD _03195_ sky130_fd_sc_hd__nor2_1
X_14836_ _04088_ _04090_ VSS VSS VDD VDD _03194_ sky130_fd_sc_hd__nor2_1
X_14837_ _04026_ _04036_ VSS VSS VDD VDD _03187_ sky130_fd_sc_hd__nor2_1
X_14838_ _04081_ _04103_ VSS VSS VDD VDD _03250_ sky130_fd_sc_hd__nor2_1
X_14839_ _04095_ _04108_ VSS VSS VDD VDD _03147_ sky130_fd_sc_hd__nor2_1
X_14840_ _04036_ _04074_ VSS VSS VDD VDD _03240_ sky130_fd_sc_hd__nor2_1
X_14841_ _04081_ _04095_ VSS VSS VDD VDD _03144_ sky130_fd_sc_hd__nor2_1
Xplace370 net371 VSS VSS VDD VDD net369 sky130_fd_sc_hd__buf_4
X_14843_ network.neuron_in045.counter\[2\] VSS VSS VDD VDD
+ _04115_ sky130_fd_sc_hd__inv_1
X_14844_ network.neuron_in045.counter\[3\] VSS VSS VDD VDD
+ _04116_ sky130_fd_sc_hd__inv_1
X_14845_ _04115_ _00287_ _04116_ VSS VSS VDD VDD _04117_ sky130_fd_sc_hd__nand3_1
X_14846_ net375 _04117_ VSS VSS VDD VDD _04118_ sky130_fd_sc_hd__nand2_1
X_14847_ network.in_period\[45\]\[1\] _04118_ VSS VSS VDD
+ VDD _04119_ sky130_fd_sc_hd__nand2_1
X_14848_ _00288_ _04118_ _04119_ VSS VSS VDD VDD _02244_ sky130_fd_sc_hd__o21ai_0
X_14849_ network.neuron_in046.counter\[2\] VSS VSS VDD VDD
+ _04120_ sky130_fd_sc_hd__inv_1
X_14850_ network.neuron_in046.counter\[3\] VSS VSS VDD VDD
+ _04121_ sky130_fd_sc_hd__inv_1
X_14851_ _04120_ _00279_ _04121_ VSS VSS VDD VDD _04122_ sky130_fd_sc_hd__nand3_1
X_14852_ net372 _04122_ VSS VSS VDD VDD _04123_ sky130_fd_sc_hd__nand2_1
X_14853_ net637 _04123_ VSS VSS VDD VDD _04124_ sky130_fd_sc_hd__nand2_1
X_14854_ network.neuron_in046.counter\[0\] _04123_ _04124_
+ VSS VSS VDD VDD _02247_ sky130_fd_sc_hd__o21ai_0
X_14855_ _03888_ _00291_ VSS VSS VDD VDD _04125_ sky130_fd_sc_hd__nand2_1
X_14856_ network.neuron_in043.counter\[3\] _04125_ VSS VSS
+ VDD VDD _04126_ sky130_fd_sc_hd__or2_2
X_14857_ net375 _04126_ VSS VSS VDD VDD _04127_ sky130_fd_sc_hd__nand2_1
X_14858_ network.in_period\[43\]\[1\] _04127_ VSS VSS VDD
+ VDD _04128_ sky130_fd_sc_hd__nand2_1
X_14859_ _00292_ _04127_ _04128_ VSS VSS VDD VDD _02236_ sky130_fd_sc_hd__o21ai_0
X_14860_ network.in_period\[43\]\[0\] _04127_ VSS VSS VDD
+ VDD _04129_ sky130_fd_sc_hd__nand2_1
X_14861_ network.neuron_in043.counter\[0\] _04127_ _04129_
+ VSS VSS VDD VDD _02235_ sky130_fd_sc_hd__o21ai_0
X_14862_ _04110_ _00283_ VSS VSS VDD VDD _04130_ sky130_fd_sc_hd__nand2_1
X_14863_ network.neuron_in044.counter\[3\] _04130_ VSS VSS
+ VDD VDD _04131_ sky130_fd_sc_hd__or2_2
X_14864_ net375 _04131_ VSS VSS VDD VDD _04132_ sky130_fd_sc_hd__nand2_1
X_14865_ net769 _04132_ VSS VSS VDD VDD _04133_ sky130_fd_sc_hd__nand2_1
X_14866_ _00284_ _04132_ _04133_ VSS VSS VDD VDD _02240_ sky130_fd_sc_hd__o21ai_0
X_14867_ net740 _04132_ VSS VSS VDD VDD _04134_ sky130_fd_sc_hd__nand2_1
X_14868_ network.neuron_in044.counter\[0\] _04132_ _04134_
+ VSS VSS VDD VDD _02239_ sky130_fd_sc_hd__o21ai_0
X_14869_ network.neuron_in045.counter\[3\] network.in_period\[45\]\[2\]
+ net354 _00287_ VSS VSS VDD VDD _04135_ sky130_fd_sc_hd__o22ai_1
X_14870_ network.neuron_in045.counter\[2\] _00287_ net375
+ VSS VSS VDD VDD _04136_ sky130_fd_sc_hd__nand3_1
X_14871_ network.in_period\[45\]\[2\] net375 _04136_ VSS VSS
+ VDD VDD _04137_ sky130_fd_sc_hd__o21ai_0
X_14872_ _04115_ _04135_ _04137_ VSS VSS VDD VDD _02245_ sky130_fd_sc_hd__a21oi_1
X_14873_ network.in_period\[45\]\[0\] _04118_ VSS VSS VDD
+ VDD _04138_ sky130_fd_sc_hd__nand2_1
X_14874_ network.neuron_in045.counter\[0\] _04118_ _04138_
+ VSS VSS VDD VDD _02243_ sky130_fd_sc_hd__o21ai_0
X_14875_ network.neuron_in046.counter\[3\] network.in_period\[46\]\[2\]
+ net355 _00279_ VSS VSS VDD VDD _04139_ sky130_fd_sc_hd__o22ai_1
X_14876_ network.neuron_in046.counter\[2\] _00279_ net372
+ VSS VSS VDD VDD _04140_ sky130_fd_sc_hd__nand3_1
X_14877_ network.in_period\[46\]\[2\] net372 _04140_ VSS VSS
+ VDD VDD _04141_ sky130_fd_sc_hd__o21ai_0
X_14878_ _04120_ _04139_ _04141_ VSS VSS VDD VDD _02249_ sky130_fd_sc_hd__a21oi_1
X_14879_ net690 _04123_ VSS VSS VDD VDD _04142_ sky130_fd_sc_hd__nand2_1
X_14880_ _00280_ _04123_ _04142_ VSS VSS VDD VDD _02248_ sky130_fd_sc_hd__o21ai_0
X_14881_ network.neuron_in050.counter\[2\] VSS VSS VDD VDD
+ _04143_ sky130_fd_sc_hd__inv_1
X_14882_ network.neuron_in050.counter\[3\] network.in_period\[50\]\[2\]
+ net353 _00335_ VSS VSS VDD VDD _04144_ sky130_fd_sc_hd__o22ai_1
X_14883_ network.neuron_in050.counter\[2\] _00335_ net371
+ VSS VSS VDD VDD _04145_ sky130_fd_sc_hd__nand3_1
X_14884_ network.in_period\[50\]\[2\] net371 _04145_ VSS VSS
+ VDD VDD _04146_ sky130_fd_sc_hd__o21ai_0
X_14885_ _04143_ _04144_ _04146_ VSS VSS VDD VDD _02265_ sky130_fd_sc_hd__a21oi_1
X_14886_ network.neuron_in049.counter\[2\] VSS VSS VDD VDD
+ _04147_ sky130_fd_sc_hd__inv_1
X_14887_ _04147_ _00263_ VSS VSS VDD VDD _04148_ sky130_fd_sc_hd__nand2_1
X_14888_ network.neuron_in049.counter\[3\] _04148_ VSS VSS
+ VDD VDD _04149_ sky130_fd_sc_hd__or2_2
X_14889_ net374 _04149_ VSS VSS VDD VDD _04150_ sky130_fd_sc_hd__nand2_1
X_14890_ network.in_period\[49\]\[0\] _04150_ VSS VSS VDD
+ VDD _04151_ sky130_fd_sc_hd__nand2_1
X_14891_ network.neuron_in049.counter\[0\] _04150_ _04151_
+ VSS VSS VDD VDD _02259_ sky130_fd_sc_hd__o21ai_0
X_14892_ network.neuron_in052.counter\[2\] VSS VSS VDD VDD
+ _04152_ sky130_fd_sc_hd__inv_1
X_14893_ network.neuron_in052.counter\[3\] network.in_period\[52\]\[2\]
+ net352 _00259_ VSS VSS VDD VDD _04153_ sky130_fd_sc_hd__o22ai_1
X_14894_ network.neuron_in052.counter\[2\] _00259_ net370
+ VSS VSS VDD VDD _04154_ sky130_fd_sc_hd__nand3_1
X_14895_ network.in_period\[52\]\[2\] net370 _04154_ VSS VSS
+ VDD VDD _04155_ sky130_fd_sc_hd__o21ai_0
X_14896_ _04152_ _04153_ _04155_ VSS VSS VDD VDD _02273_ sky130_fd_sc_hd__a21oi_1
X_14897_ network.neuron_in047.counter\[3\] _00275_ VSS VSS
+ VDD VDD _04156_ sky130_fd_sc_hd__nand2b_1
X_14898_ network.neuron_in047.counter\[2\] VSS VSS VDD VDD
+ _04157_ sky130_fd_sc_hd__inv_1
X_14899_ _04156_ _04157_ VSS VSS VDD VDD _04158_ sky130_fd_sc_hd__nand2b_1
X_14900_ net372 _04158_ VSS VSS VDD VDD _04159_ sky130_fd_sc_hd__nand2_1
X_14901_ network.in_period\[47\]\[1\] _04159_ VSS VSS VDD
+ VDD _04160_ sky130_fd_sc_hd__nand2_1
X_14902_ _00276_ _04159_ _04160_ VSS VSS VDD VDD _02252_ sky130_fd_sc_hd__o21ai_0
X_14903_ network.neuron_in048.counter\[2\] VSS VSS VDD VDD
+ _04161_ sky130_fd_sc_hd__inv_1
X_14904_ _04161_ _00267_ VSS VSS VDD VDD _04162_ sky130_fd_sc_hd__nand2_1
X_14905_ network.neuron_in048.counter\[3\] _04162_ VSS VSS
+ VDD VDD _04163_ sky130_fd_sc_hd__or2_2
X_14906_ net373 _04163_ VSS VSS VDD VDD _04164_ sky130_fd_sc_hd__nand2_1
X_14907_ network.in_period\[48\]\[1\] _04164_ VSS VSS VDD
+ VDD _04165_ sky130_fd_sc_hd__nand2_1
X_14908_ _00268_ _04164_ _04165_ VSS VSS VDD VDD _02256_ sky130_fd_sc_hd__o21ai_0
X_14909_ network.in_period\[49\]\[1\] _04150_ VSS VSS VDD
+ VDD _04166_ sky130_fd_sc_hd__nand2_1
X_14910_ _00264_ _04150_ _04166_ VSS VSS VDD VDD _02260_ sky130_fd_sc_hd__o21ai_0
X_14911_ network.neuron_in050.counter\[3\] VSS VSS VDD VDD
+ _04167_ sky130_fd_sc_hd__inv_1
X_14912_ _04143_ _00335_ _04167_ VSS VSS VDD VDD _04168_ sky130_fd_sc_hd__nand3_1
X_14913_ net371 _04168_ VSS VSS VDD VDD _04169_ sky130_fd_sc_hd__nand2_1
X_14914_ net704 _04169_ VSS VSS VDD VDD _04170_ sky130_fd_sc_hd__nand2_1
X_14915_ network.neuron_in050.counter\[0\] _04169_ _04170_
+ VSS VSS VDD VDD _02263_ sky130_fd_sc_hd__o21ai_0
X_14916_ network.neuron_in051.counter\[2\] VSS VSS VDD VDD
+ _04171_ sky130_fd_sc_hd__inv_1
X_14917_ _04171_ _00339_ VSS VSS VDD VDD _04172_ sky130_fd_sc_hd__nand2_1
X_14918_ network.neuron_in051.counter\[3\] _04172_ VSS VSS
+ VDD VDD _04173_ sky130_fd_sc_hd__or2_2
X_14919_ net371 _04173_ VSS VSS VDD VDD _04174_ sky130_fd_sc_hd__nand2_1
X_14920_ network.in_period\[51\]\[0\] _04174_ VSS VSS VDD
+ VDD _04175_ sky130_fd_sc_hd__nand2_1
X_14921_ network.neuron_in051.counter\[0\] _04174_ _04175_
+ VSS VSS VDD VDD _02267_ sky130_fd_sc_hd__o21ai_0
X_14922_ net442 _04105_ VSS VSS VDD VDD _04176_ sky130_fd_sc_hd__nand2_2
Xplace380 net380 VSS VSS VDD VDD net379 sky130_fd_sc_hd__buf_4
X_14924_ net295 _04176_ VSS VSS VDD VDD _03339_ sky130_fd_sc_hd__nor2_1
X_14925_ network.in_period\[144\]\[0\] _06940_ VSS VSS VDD
+ VDD _04178_ sky130_fd_sc_hd__nand2_1
X_14926_ network.neuron_in144.counter\[0\] _06940_ _04178_
+ VSS VSS VDD VDD _02639_ sky130_fd_sc_hd__o21ai_0
X_14927_ net412 _04024_ VSS VSS VDD VDD _04179_ sky130_fd_sc_hd__nand2_2
Xplace315 _07875_ VSS VSS VDD VDD net314 sky130_fd_sc_hd__buf_4
X_14929_ _04022_ _04179_ VSS VSS VDD VDD _03290_ sky130_fd_sc_hd__nor2_1
X_14930_ _04036_ _04042_ VSS VSS VDD VDD _03283_ sky130_fd_sc_hd__nor2_1
X_14931_ _04022_ _04042_ VSS VSS VDD VDD _03272_ sky130_fd_sc_hd__nor2_1
X_14932_ network.neuron_in047.counter\[3\] network.in_period\[47\]\[2\]
+ net355 _00275_ VSS VSS VDD VDD _04181_ sky130_fd_sc_hd__o22ai_1
X_14933_ network.neuron_in047.counter\[2\] _00275_ net372
+ VSS VSS VDD VDD _04182_ sky130_fd_sc_hd__nand3_1
X_14934_ network.in_period\[47\]\[2\] net372 _04182_ VSS VSS
+ VDD VDD _04183_ sky130_fd_sc_hd__o21ai_0
X_14935_ _04157_ _04181_ _04183_ VSS VSS VDD VDD _02253_ sky130_fd_sc_hd__a21oi_1
X_14936_ net405 net345 _07331_ VSS VSS VDD VDD _04184_ sky130_fd_sc_hd__a21oi_1
X_14937_ net342 net321 _04184_ net409 _07472_ VSS VSS VDD
+ VDD _04185_ sky130_fd_sc_hd__o221ai_1
X_14938_ _07389_ _07598_ net398 VSS VSS VDD VDD _04186_ sky130_fd_sc_hd__o21ai_0
X_14939_ net398 net320 _07921_ VSS VSS VDD VDD _04187_ sky130_fd_sc_hd__nand3_1
X_14940_ net333 net316 net343 VSS VSS VDD VDD _04188_ sky130_fd_sc_hd__o21ai_0
X_14941_ net329 _04187_ _04188_ VSS VSS VDD VDD _04189_ sky130_fd_sc_hd__nand3_1
X_14942_ _07889_ _08016_ net403 VSS VSS VDD VDD _04190_ sky130_fd_sc_hd__o21ai_0
X_14943_ _03910_ _04186_ _04189_ _04190_ VSS VSS VDD VDD _04191_
+ sky130_fd_sc_hd__nand4_1
X_14944_ net404 net324 _07468_ VSS VSS VDD VDD _04192_ sky130_fd_sc_hd__o21ai_0
X_14945_ net404 _07458_ _04192_ net399 VSS VSS VDD VDD _04193_
+ sky130_fd_sc_hd__a22oi_1
X_14946_ net337 net319 _08006_ VSS VSS VDD VDD _04194_ sky130_fd_sc_hd__a21oi_1
X_14947_ net329 _04193_ _04194_ VSS VSS VDD VDD _04195_ sky130_fd_sc_hd__o21ai_0
X_14948_ _08052_ net332 net333 VSS VSS VDD VDD _04196_ sky130_fd_sc_hd__a21oi_1
X_14949_ net340 _04065_ _07607_ VSS VSS VDD VDD _04197_ sky130_fd_sc_hd__o21ai_0
X_14950_ _08099_ _08000_ net399 VSS VSS VDD VDD _04198_ sky130_fd_sc_hd__o21ai_0
X_14951_ net402 _04196_ _04197_ _04198_ VSS VSS VDD VDD _04199_
+ sky130_fd_sc_hd__o211ai_1
X_14952_ net302 _07367_ net398 VSS VSS VDD VDD _04200_ sky130_fd_sc_hd__o21ai_0
X_14953_ net338 _08047_ net324 _04200_ VSS VSS VDD VDD _04201_
+ sky130_fd_sc_hd__o211ai_1
X_14954_ net343 _07856_ VSS VSS VDD VDD _04202_ sky130_fd_sc_hd__nand2_1
X_14955_ net330 _04202_ net402 VSS VSS VDD VDD _04203_ sky130_fd_sc_hd__a21oi_1
X_14956_ net406 _04201_ _04203_ _08206_ _07889_ VSS VSS VDD
+ VDD _04204_ sky130_fd_sc_hd__a2111oi_0
X_14957_ _08209_ _04195_ _04199_ net347 _04204_ VSS VSS VDD
+ VDD _04205_ sky130_fd_sc_hd__a221oi_1
X_14958_ _07537_ _04191_ _04205_ VSS VSS VDD VDD _04206_ sky130_fd_sc_hd__nand3_1
X_14959_ net294 _04185_ _04206_ VSS VSS VDD VDD _01755_ sky130_fd_sc_hd__o21ai_0
X_14960_ network.in_period\[47\]\[0\] _04159_ VSS VSS VDD
+ VDD _04207_ sky130_fd_sc_hd__nand2_1
X_14961_ network.neuron_in047.counter\[0\] _04159_ _04207_
+ VSS VSS VDD VDD _02251_ sky130_fd_sc_hd__o21ai_0
X_14962_ _04042_ net295 VSS VSS VDD VDD _03269_ sky130_fd_sc_hd__nor2_1
X_14963_ _08631_ _04042_ VSS VSS VDD VDD _03268_ sky130_fd_sc_hd__nor2_1
X_14964_ net412 net288 VSS VSS VDD VDD _04208_ sky130_fd_sc_hd__nand2_2
Xplace314 _07900_ VSS VSS VDD VDD net313 sky130_fd_sc_hd__buf_4
X_14966_ _04028_ _04208_ VSS VSS VDD VDD _03267_ sky130_fd_sc_hd__nor2_1
X_14967_ network.neuron_in048.counter\[3\] network.in_period\[48\]\[2\]
+ net352 _00267_ VSS VSS VDD VDD _04210_ sky130_fd_sc_hd__o22ai_1
Xplace306 _07367_ VSS VSS VDD VDD net305 sky130_fd_sc_hd__buf_4
X_14969_ network.neuron_in048.counter\[2\] _00267_ net373
+ VSS VSS VDD VDD _04212_ sky130_fd_sc_hd__nand3_1
X_14970_ network.in_period\[48\]\[2\] net373 _04212_ VSS VSS
+ VDD VDD _04213_ sky130_fd_sc_hd__o21ai_0
X_14971_ _04161_ _04210_ _04213_ VSS VSS VDD VDD _02257_ sky130_fd_sc_hd__a21oi_1
X_14972_ _04036_ _04208_ VSS VSS VDD VDD _03266_ sky130_fd_sc_hd__nor2_1
X_14973_ network.in_period\[48\]\[0\] _04164_ VSS VSS VDD
+ VDD _04214_ sky130_fd_sc_hd__nand2_1
X_14974_ network.neuron_in048.counter\[0\] _04164_ _04214_
+ VSS VSS VDD VDD _02255_ sky130_fd_sc_hd__o21ai_0
X_14975_ _04040_ _04208_ VSS VSS VDD VDD _03264_ sky130_fd_sc_hd__nor2_1
Xplace285 _09281_ VSS VSS VDD VDD net284 sky130_fd_sc_hd__buf_4
X_14977_ network.neuron_in049.counter\[3\] network.in_period\[49\]\[2\]
+ net352 _00263_ VSS VSS VDD VDD _04216_ sky130_fd_sc_hd__o22ai_1
X_14978_ network.neuron_in049.counter\[2\] _00263_ net374
+ VSS VSS VDD VDD _04217_ sky130_fd_sc_hd__nand3_1
X_14979_ network.in_period\[49\]\[2\] net374 _04217_ VSS VSS
+ VDD VDD _04218_ sky130_fd_sc_hd__o21ai_0
X_14980_ _04147_ _04216_ _04218_ VSS VSS VDD VDD _02261_ sky130_fd_sc_hd__a21oi_1
X_14981_ _04093_ _04208_ VSS VSS VDD VDD _03263_ sky130_fd_sc_hd__nor2_1
X_14982_ network.in_period\[50\]\[1\] _04169_ VSS VSS VDD
+ VDD _04219_ sky130_fd_sc_hd__nand2_1
X_14983_ _00336_ _04169_ _04219_ VSS VSS VDD VDD _02264_ sky130_fd_sc_hd__o21ai_0
X_14984_ _04079_ _04208_ VSS VSS VDD VDD _03262_ sky130_fd_sc_hd__nor2_1
X_14985_ _04108_ _04208_ VSS VSS VDD VDD _03261_ sky130_fd_sc_hd__nor2_1
X_14986_ _04083_ _04208_ VSS VSS VDD VDD _03260_ sky130_fd_sc_hd__nor2_1
X_14987_ network.neuron_in051.counter\[3\] network.in_period\[51\]\[2\]
+ _00339_ net350 VSS VSS VDD VDD _04220_ sky130_fd_sc_hd__o22ai_1
X_14988_ network.neuron_in051.counter\[2\] _00339_ net369
+ VSS VSS VDD VDD _04221_ sky130_fd_sc_hd__nand3_1
X_14989_ network.in_period\[51\]\[2\] net369 _04221_ VSS VSS
+ VDD VDD _04222_ sky130_fd_sc_hd__o21ai_0
X_14990_ _04171_ _04220_ _04222_ VSS VSS VDD VDD _02269_ sky130_fd_sc_hd__a21oi_1
X_14991_ network.in_period\[51\]\[1\] _04174_ VSS VSS VDD
+ VDD _04223_ sky130_fd_sc_hd__nand2_1
X_14992_ _00340_ _04174_ _04223_ VSS VSS VDD VDD _02268_ sky130_fd_sc_hd__o21ai_0
X_14993_ _04081_ _04208_ VSS VSS VDD VDD _03242_ sky130_fd_sc_hd__nor2_1
Xplace310 _09210_ VSS VSS VDD VDD net309 sky130_fd_sc_hd__buf_4
X_14995_ _04152_ _00259_ VSS VSS VDD VDD _04225_ sky130_fd_sc_hd__nand2_1
X_14996_ network.neuron_in052.counter\[3\] _04225_ VSS VSS
+ VDD VDD _04226_ sky130_fd_sc_hd__or2_2
X_14997_ net370 _04226_ VSS VSS VDD VDD _04227_ sky130_fd_sc_hd__nand2_1
X_14998_ net766 _04227_ VSS VSS VDD VDD _04228_ sky130_fd_sc_hd__nand2_1
X_14999_ _00260_ _04227_ _04228_ VSS VSS VDD VDD _02272_ sky130_fd_sc_hd__o21ai_0
X_15000_ _04085_ _04208_ VSS VSS VDD VDD _03231_ sky130_fd_sc_hd__nor2_1
X_15001_ network.in_period\[52\]\[0\] _04227_ VSS VSS VDD
+ VDD _04229_ sky130_fd_sc_hd__nand2_1
X_15002_ network.neuron_in052.counter\[0\] _04227_ _04229_
+ VSS VSS VDD VDD _02271_ sky130_fd_sc_hd__o21ai_0
X_15003_ _04090_ _04208_ VSS VSS VDD VDD _03220_ sky130_fd_sc_hd__nor2_1
X_15004_ _04022_ _04208_ VSS VSS VDD VDD _03209_ sky130_fd_sc_hd__nor2_1
X_15005_ net308 _04208_ VSS VSS VDD VDD _03197_ sky130_fd_sc_hd__nor2_1
X_15006_ net295 _04208_ VSS VSS VDD VDD _03175_ sky130_fd_sc_hd__nor2_1
X_15007_ network.neuron_in057.counter\[3\] _00239_ VSS VSS
+ VDD VDD _04230_ sky130_fd_sc_hd__nand2b_1
X_15008_ network.neuron_in057.counter\[2\] VSS VSS VDD VDD
+ _04231_ sky130_fd_sc_hd__inv_1
X_15009_ _04230_ _04231_ VSS VSS VDD VDD _04232_ sky130_fd_sc_hd__nand2b_1
X_15010_ net371 _04232_ VSS VSS VDD VDD _04233_ sky130_fd_sc_hd__nand2_1
X_15011_ network.in_period\[57\]\[1\] _04233_ VSS VSS VDD
+ VDD _04234_ sky130_fd_sc_hd__nand2_1
X_15012_ _00240_ _04233_ _04234_ VSS VSS VDD VDD _02292_ sky130_fd_sc_hd__o21ai_0
X_15013_ _08631_ _04106_ VSS VSS VDD VDD _03101_ sky130_fd_sc_hd__nor2_1
X_15014_ _04028_ _04176_ VSS VSS VDD VDD _03100_ sky130_fd_sc_hd__nor2_1
X_15015_ net412 _04087_ VSS VSS VDD VDD _04235_ sky130_fd_sc_hd__nand2_2
Xplace307 _07363_ VSS VSS VDD VDD net306 sky130_fd_sc_hd__buf_4
X_15017_ _04081_ _04235_ VSS VSS VDD VDD _03320_ sky130_fd_sc_hd__nor2_1
X_15018_ _04036_ _04176_ VSS VSS VDD VDD _03099_ sky130_fd_sc_hd__nor2_1
X_15019_ network.neuron_in057.counter\[3\] network.in_period\[57\]\[2\]
+ net350 _00239_ VSS VSS VDD VDD _04237_ sky130_fd_sc_hd__o22ai_1
Xplace308 _07331_ VSS VSS VDD VDD net307 sky130_fd_sc_hd__buf_4
X_15021_ network.neuron_in057.counter\[2\] _00239_ net371
+ VSS VSS VDD VDD _04239_ sky130_fd_sc_hd__nand3_1
X_15022_ network.in_period\[57\]\[2\] net371 _04239_ VSS VSS
+ VDD VDD _04240_ sky130_fd_sc_hd__o21ai_0
X_15023_ _04231_ _04237_ _04240_ VSS VSS VDD VDD _02293_ sky130_fd_sc_hd__a21oi_1
X_15024_ net308 _04235_ VSS VSS VDD VDD _03276_ sky130_fd_sc_hd__nor2_1
X_15025_ network.neuron_in054.counter\[2\] VSS VSS VDD VDD
+ _04241_ sky130_fd_sc_hd__inv_1
X_15026_ network.neuron_in054.counter\[3\] network.in_period\[54\]\[2\]
+ net350 _00247_ VSS VSS VDD VDD _04242_ sky130_fd_sc_hd__o22ai_1
X_15027_ network.neuron_in054.counter\[2\] _00247_ net371
+ VSS VSS VDD VDD _04243_ sky130_fd_sc_hd__nand3_1
X_15028_ network.in_period\[54\]\[2\] net371 _04243_ VSS VSS
+ VDD VDD _04244_ sky130_fd_sc_hd__o21ai_0
X_15029_ _04241_ _04242_ _04244_ VSS VSS VDD VDD _02281_ sky130_fd_sc_hd__a21oi_1
X_15030_ _04040_ _04176_ VSS VSS VDD VDD _03097_ sky130_fd_sc_hd__nor2_1
X_15031_ _04040_ _04103_ VSS VSS VDD VDD _03257_ sky130_fd_sc_hd__nor2_1
X_15032_ net295 _04235_ VSS VSS VDD VDD _03198_ sky130_fd_sc_hd__nor2_1
X_15033_ network.neuron_in080.counter\[1\] VSS VSS VDD VDD
+ _00087_ sky130_fd_sc_hd__inv_1
X_15034_ _04079_ _04176_ VSS VSS VDD VDD _03095_ sky130_fd_sc_hd__nor2_1
X_15035_ _08631_ _04235_ VSS VSS VDD VDD _03087_ sky130_fd_sc_hd__nor2_1
X_15036_ network.neuron_in053.counter\[3\] _00255_ VSS VSS
+ VDD VDD _04245_ sky130_fd_sc_hd__nand2b_1
X_15037_ network.neuron_in053.counter\[2\] VSS VSS VDD VDD
+ _04246_ sky130_fd_sc_hd__inv_1
X_15038_ _04245_ _04246_ VSS VSS VDD VDD _04247_ sky130_fd_sc_hd__nand2b_1
X_15039_ net370 _04247_ VSS VSS VDD VDD _04248_ sky130_fd_sc_hd__nand2_1
X_15040_ network.in_period\[53\]\[0\] _04248_ VSS VSS VDD
+ VDD _04249_ sky130_fd_sc_hd__nand2_1
X_15041_ network.neuron_in053.counter\[0\] _04248_ _04249_
+ VSS VSS VDD VDD _02275_ sky130_fd_sc_hd__o21ai_0
X_15042_ network.neuron_in133.counter\[3\] network.in_period\[133\]\[2\]
+ _00474_ net358 VSS VSS VDD VDD _04250_ sky130_fd_sc_hd__o22ai_1
X_15043_ network.neuron_in133.counter\[2\] _00474_ net381
+ VSS VSS VDD VDD _04251_ sky130_fd_sc_hd__nand3_1
X_15044_ network.in_period\[133\]\[2\] net381 _04251_ VSS
+ VSS VDD VDD _04252_ sky130_fd_sc_hd__o21ai_0
X_15045_ _07035_ _04250_ _04252_ VSS VSS VDD VDD _02597_ sky130_fd_sc_hd__a21oi_1
X_15046_ network.neuron_in055.counter\[3\] _00243_ VSS VSS
+ VDD VDD _04253_ sky130_fd_sc_hd__nand2b_1
X_15047_ network.neuron_in055.counter\[2\] VSS VSS VDD VDD
+ _04254_ sky130_fd_sc_hd__inv_1
X_15048_ _04253_ _04254_ VSS VSS VDD VDD _04255_ sky130_fd_sc_hd__nand2b_1
X_15049_ net370 _04255_ VSS VSS VDD VDD _04256_ sky130_fd_sc_hd__nand2_1
X_15050_ network.in_period\[55\]\[0\] _04256_ VSS VSS VDD
+ VDD _04257_ sky130_fd_sc_hd__nand2_1
X_15051_ network.neuron_in055.counter\[0\] _04256_ _04257_
+ VSS VSS VDD VDD _02283_ sky130_fd_sc_hd__o21ai_0
X_15052_ network.neuron_in056.counter\[2\] VSS VSS VDD VDD
+ _04258_ sky130_fd_sc_hd__inv_1
X_15053_ _04258_ _00235_ VSS VSS VDD VDD _04259_ sky130_fd_sc_hd__nand2_1
X_15054_ network.neuron_in056.counter\[3\] _04259_ VSS VSS
+ VDD VDD _04260_ sky130_fd_sc_hd__or2_2
X_15055_ net374 _04260_ VSS VSS VDD VDD _04261_ sky130_fd_sc_hd__nand2_1
X_15056_ network.in_period\[56\]\[0\] _04261_ VSS VSS VDD
+ VDD _04262_ sky130_fd_sc_hd__nand2_1
X_15057_ network.neuron_in056.counter\[0\] _04261_ _04262_
+ VSS VSS VDD VDD _02287_ sky130_fd_sc_hd__o21ai_0
X_15058_ network.neuron_in053.counter\[3\] network.in_period\[53\]\[2\]
+ net352 _00255_ VSS VSS VDD VDD _04263_ sky130_fd_sc_hd__o22ai_1
X_15059_ network.neuron_in053.counter\[2\] _00255_ net370
+ VSS VSS VDD VDD _04264_ sky130_fd_sc_hd__nand3_1
X_15060_ network.in_period\[53\]\[2\] net370 _04264_ VSS VSS
+ VDD VDD _04265_ sky130_fd_sc_hd__o21ai_0
X_15061_ _04246_ _04263_ _04265_ VSS VSS VDD VDD _02277_ sky130_fd_sc_hd__a21oi_1
X_15062_ network.in_period\[53\]\[1\] _04248_ VSS VSS VDD
+ VDD _04266_ sky130_fd_sc_hd__nand2_1
X_15063_ _00256_ _04248_ _04266_ VSS VSS VDD VDD _02276_ sky130_fd_sc_hd__o21ai_0
X_15064_ _04241_ _00247_ VSS VSS VDD VDD _04267_ sky130_fd_sc_hd__nand2_1
X_15065_ network.neuron_in054.counter\[3\] _04267_ VSS VSS
+ VDD VDD _04268_ sky130_fd_sc_hd__or2_2
X_15066_ net371 _04268_ VSS VSS VDD VDD _04269_ sky130_fd_sc_hd__nand2_1
X_15067_ network.in_period\[54\]\[1\] _04269_ VSS VSS VDD
+ VDD _04270_ sky130_fd_sc_hd__nand2_1
X_15068_ _00248_ _04269_ _04270_ VSS VSS VDD VDD _02280_ sky130_fd_sc_hd__o21ai_0
X_15069_ network.neuron_in054.counter\[0\] VSS VSS VDD VDD
+ _00245_ sky130_fd_sc_hd__inv_1
X_15070_ network.in_period\[54\]\[0\] _04269_ VSS VSS VDD
+ VDD _04271_ sky130_fd_sc_hd__nand2_1
X_15071_ network.neuron_in054.counter\[0\] _04269_ _04271_
+ VSS VSS VDD VDD _02279_ sky130_fd_sc_hd__o21ai_0
X_15072_ network.neuron_in055.counter\[3\] network.in_period\[55\]\[2\]
+ _00243_ net353 VSS VSS VDD VDD _04272_ sky130_fd_sc_hd__o22ai_1
X_15073_ network.neuron_in055.counter\[2\] _00243_ net370
+ VSS VSS VDD VDD _04273_ sky130_fd_sc_hd__nand3_1
X_15074_ network.in_period\[55\]\[2\] net370 _04273_ VSS VSS
+ VDD VDD _04274_ sky130_fd_sc_hd__o21ai_0
X_15075_ _04254_ _04272_ _04274_ VSS VSS VDD VDD _02285_ sky130_fd_sc_hd__a21oi_1
X_15076_ net712 _04256_ VSS VSS VDD VDD _04275_ sky130_fd_sc_hd__nand2_1
X_15077_ _00244_ _04256_ _04275_ VSS VSS VDD VDD _02284_ sky130_fd_sc_hd__o21ai_0
X_15078_ network.neuron_in056.counter\[3\] network.in_period\[56\]\[2\]
+ net352 _00235_ VSS VSS VDD VDD _04276_ sky130_fd_sc_hd__o22ai_1
X_15079_ network.neuron_in056.counter\[2\] _00235_ net374
+ VSS VSS VDD VDD _04277_ sky130_fd_sc_hd__nand3_1
X_15080_ network.in_period\[56\]\[2\] net374 _04277_ VSS VSS
+ VDD VDD _04278_ sky130_fd_sc_hd__o21ai_0
X_15081_ _04258_ _04276_ _04278_ VSS VSS VDD VDD _02289_ sky130_fd_sc_hd__a21oi_1
X_15082_ network.in_period\[56\]\[1\] _04261_ VSS VSS VDD
+ VDD _04279_ sky130_fd_sc_hd__nand2_1
X_15083_ _00236_ _04261_ _04279_ VSS VSS VDD VDD _02288_ sky130_fd_sc_hd__o21ai_0
X_15084_ network.neuron_in060.counter\[2\] VSS VSS VDD VDD
+ _04280_ sky130_fd_sc_hd__inv_1
X_15085_ _04280_ _00211_ VSS VSS VDD VDD _04281_ sky130_fd_sc_hd__nand2_1
X_15086_ network.neuron_in060.counter\[3\] _04281_ VSS VSS
+ VDD VDD _04282_ sky130_fd_sc_hd__or2_2
X_15087_ net374 _04282_ VSS VSS VDD VDD _04283_ sky130_fd_sc_hd__nand2_1
X_15088_ network.in_period\[60\]\[0\] _04283_ VSS VSS VDD
+ VDD _04284_ sky130_fd_sc_hd__nand2_1
X_15089_ network.neuron_in060.counter\[0\] _04283_ _04284_
+ VSS VSS VDD VDD _02303_ sky130_fd_sc_hd__o21ai_0
X_15090_ network.neuron_in059.counter\[2\] VSS VSS VDD VDD
+ _04285_ sky130_fd_sc_hd__inv_1
X_15091_ _04285_ _00223_ VSS VSS VDD VDD _04286_ sky130_fd_sc_hd__nand2_1
X_15092_ network.neuron_in059.counter\[3\] _04286_ VSS VSS
+ VDD VDD _04287_ sky130_fd_sc_hd__or2_2
X_15093_ net375 _04287_ VSS VSS VDD VDD _04288_ sky130_fd_sc_hd__nand2_1
X_15094_ network.in_period\[59\]\[0\] _04288_ VSS VSS VDD
+ VDD _04289_ sky130_fd_sc_hd__nand2_1
X_15095_ network.neuron_in059.counter\[0\] _04288_ _04289_
+ VSS VSS VDD VDD _02299_ sky130_fd_sc_hd__o21ai_0
X_15096_ network.in_period\[60\]\[1\] _04283_ VSS VSS VDD
+ VDD _04290_ sky130_fd_sc_hd__nand2_1
X_15097_ _00212_ _04283_ _04290_ VSS VSS VDD VDD _02304_ sky130_fd_sc_hd__o21ai_0
X_15098_ network.neuron_in058.counter\[3\] _00227_ VSS VSS
+ VDD VDD _04291_ sky130_fd_sc_hd__nand2b_1
X_15099_ network.neuron_in058.counter\[2\] VSS VSS VDD VDD
+ _04292_ sky130_fd_sc_hd__inv_1
X_15100_ _04291_ _04292_ VSS VSS VDD VDD _04293_ sky130_fd_sc_hd__nand2b_1
X_15101_ net375 _04293_ VSS VSS VDD VDD _04294_ sky130_fd_sc_hd__nand2_1
X_15102_ network.in_period\[58\]\[1\] _04294_ VSS VSS VDD
+ VDD _04295_ sky130_fd_sc_hd__nand2_1
X_15103_ _00228_ _04294_ _04295_ VSS VSS VDD VDD _02296_ sky130_fd_sc_hd__o21ai_0
X_15104_ network.neuron_in117.counter\[0\] VSS VSS VDD VDD
+ _00069_ sky130_fd_sc_hd__inv_1
X_15105_ network.neuron_in150.counter\[2\] net381 VSS VSS
+ VDD VDD _04296_ sky130_fd_sc_hd__nand2_1
X_15106_ network.neuron_in150.counter\[3\] network.in_period\[150\]\[2\]
+ _04296_ VSS VSS VDD VDD _04297_ sky130_fd_sc_hd__o21ai_0
X_15107_ _00519_ network.neuron_in150.counter\[2\] net358
+ VSS VSS VDD VDD _04298_ sky130_fd_sc_hd__or3_1
X_15108_ network.in_period\[150\]\[2\] net381 _04298_ VSS
+ VSS VDD VDD _04299_ sky130_fd_sc_hd__o21ai_0
X_15109_ _00519_ _04297_ _04299_ VSS VSS VDD VDD _02665_ sky130_fd_sc_hd__a21oi_1
X_15110_ net392 net396 net410 VSS VSS VDD VDD _04300_ sky130_fd_sc_hd__nand3_1
X_15111_ net392 _07961_ _04300_ VSS VSS VDD VDD _04301_ sky130_fd_sc_hd__o21ai_0
X_15112_ _08052_ net326 _04301_ _03912_ VSS VSS VDD VDD _04302_
+ sky130_fd_sc_hd__a31oi_1
X_15113_ _07283_ _04302_ VSS VSS VDD VDD _01756_ sky130_fd_sc_hd__nor2_1
X_15114_ _04074_ net295 VSS VSS VDD VDD _03226_ sky130_fd_sc_hd__nor2_1
X_15115_ _08631_ _04074_ VSS VSS VDD VDD _03225_ sky130_fd_sc_hd__nor2_1
X_15116_ net308 _04077_ VSS VSS VDD VDD _03211_ sky130_fd_sc_hd__nor2_1
X_15117_ _04077_ _04099_ VSS VSS VDD VDD _03210_ sky130_fd_sc_hd__nor2_1
X_15118_ _04036_ _04088_ VSS VSS VDD VDD _03205_ sky130_fd_sc_hd__nor2_1
X_15119_ _04040_ _04088_ VSS VSS VDD VDD _03204_ sky130_fd_sc_hd__nor2_1
X_15120_ _04088_ _04093_ VSS VSS VDD VDD _03203_ sky130_fd_sc_hd__nor2_1
X_15121_ _04079_ _04088_ VSS VSS VDD VDD _03202_ sky130_fd_sc_hd__nor2_1
X_15122_ _08631_ _04103_ VSS VSS VDD VDD _03243_ sky130_fd_sc_hd__nor2_1
X_15123_ _04074_ _04079_ VSS VSS VDD VDD _03237_ sky130_fd_sc_hd__nor2_1
X_15124_ _04074_ _04085_ VSS VSS VDD VDD _03232_ sky130_fd_sc_hd__nor2_1
X_15125_ _04077_ _04093_ VSS VSS VDD VDD _03221_ sky130_fd_sc_hd__nor2_1
X_15126_ _04034_ _04077_ VSS VSS VDD VDD _03216_ sky130_fd_sc_hd__nor2_1
X_15127_ _04081_ _04088_ VSS VSS VDD VDD _03196_ sky130_fd_sc_hd__nor2_1
X_15128_ _04028_ _04026_ VSS VSS VDD VDD _03188_ sky130_fd_sc_hd__nor2_1
X_15129_ _04079_ _04103_ VSS VSS VDD VDD _03255_ sky130_fd_sc_hd__nor2_1
X_15130_ _04026_ _04081_ VSS VSS VDD VDD _03179_ sky130_fd_sc_hd__nor2_1
X_15131_ _04031_ _04090_ VSS VSS VDD VDD _03159_ sky130_fd_sc_hd__nor2_1
X_15132_ _04022_ _04031_ VSS VSS VDD VDD _03158_ sky130_fd_sc_hd__nor2_1
X_15133_ _04090_ _04103_ VSS VSS VDD VDD _03248_ sky130_fd_sc_hd__nor2_1
X_15134_ network.in_period\[59\]\[1\] _04288_ VSS VSS VDD
+ VDD _04303_ sky130_fd_sc_hd__nand2_1
X_15135_ _00224_ _04288_ _04303_ VSS VSS VDD VDD _02300_ sky130_fd_sc_hd__o21ai_0
X_15136_ _04108_ _04176_ VSS VSS VDD VDD _03094_ sky130_fd_sc_hd__nor2_1
X_15137_ _07937_ _08478_ _08161_ VSS VSS VDD VDD _04304_ sky130_fd_sc_hd__a21oi_1
X_15138_ net331 net318 VSS VSS VDD VDD _04305_ sky130_fd_sc_hd__nand2_1
X_15139_ net339 _07621_ _04305_ VSS VSS VDD VDD _04306_ sky130_fd_sc_hd__o21ai_0
X_15140_ net406 _04306_ VSS VSS VDD VDD _04307_ sky130_fd_sc_hd__nand2_1
X_15141_ net394 _08109_ net400 VSS VSS VDD VDD _04308_ sky130_fd_sc_hd__o21ai_0
X_15142_ net394 net402 _07856_ net323 _08086_ VSS VSS VDD
+ VDD _04309_ sky130_fd_sc_hd__a32oi_1
X_15143_ net408 _04304_ _04307_ _04308_ _04309_ VSS VSS VDD
+ VDD _04310_ sky130_fd_sc_hd__o2111ai_1
X_15144_ _07870_ _07316_ _07274_ VSS VSS VDD VDD _04311_ sky130_fd_sc_hd__a21oi_1
X_15145_ _07603_ _04311_ net339 VSS VSS VDD VDD _04312_ sky130_fd_sc_hd__o21ai_0
X_15146_ net394 _07452_ VSS VSS VDD VDD _04313_ sky130_fd_sc_hd__nand2_1
X_15147_ net406 _08244_ _04312_ _04313_ VSS VSS VDD VDD _04314_
+ sky130_fd_sc_hd__o211ai_1
X_15148_ net339 net316 VSS VSS VDD VDD _04315_ sky130_fd_sc_hd__xnor2_1
X_15149_ network.neuron_hid0.ROM0.address\[0\] _04315_ _07857_
+ net329 VSS VSS VDD VDD _04316_ sky130_fd_sc_hd__a211oi_1
X_15150_ net394 _07354_ _03966_ network.neuron_hid0.ROM0.address\[3\]
+ VSS VSS VDD VDD _04317_ sky130_fd_sc_hd__a211oi_1
X_15151_ _07621_ _08108_ _04316_ _04317_ net401 VSS VSS VDD
+ VDD _04318_ sky130_fd_sc_hd__o221ai_1
X_15152_ net400 _04314_ _04318_ net393 VSS VSS VDD VDD _04319_
+ sky130_fd_sc_hd__o211ai_1
X_15153_ net393 _04310_ _04319_ VSS VSS VDD VDD _04320_ sky130_fd_sc_hd__o21ai_0
X_15154_ net391 _04320_ VSS VSS VDD VDD _04321_ sky130_fd_sc_hd__nand2b_1
X_15155_ _07585_ _07389_ net405 VSS VSS VDD VDD _04322_ sky130_fd_sc_hd__o21ai_0
X_15156_ net409 _07493_ _04322_ VSS VSS VDD VDD _04323_ sky130_fd_sc_hd__o21ai_0
X_15157_ _08109_ _04323_ VSS VSS VDD VDD _04324_ sky130_fd_sc_hd__nor2_1
X_15158_ net403 _07483_ net330 _08404_ _04324_ VSS VSS VDD
+ VDD _04325_ sky130_fd_sc_hd__o32ai_1
X_15159_ net406 net335 net334 VSS VSS VDD VDD _04326_ sky130_fd_sc_hd__nand3_1
X_15160_ _08198_ _04326_ net411 VSS VSS VDD VDD _04327_ sky130_fd_sc_hd__a21oi_1
X_15161_ net397 _07483_ _08010_ _04327_ VSS VSS VDD VDD _04328_
+ sky130_fd_sc_hd__nor4_1
X_15162_ net397 _04325_ _04328_ VSS VSS VDD VDD _04329_ sky130_fd_sc_hd__a21oi_1
X_15163_ _04321_ _04329_ _07282_ VSS VSS VDD VDD _01757_ sky130_fd_sc_hd__a21oi_1
X_15164_ _04031_ net295 VSS VSS VDD VDD _03155_ sky130_fd_sc_hd__nor2_1
X_15165_ _04083_ _04176_ VSS VSS VDD VDD _03093_ sky130_fd_sc_hd__nor2_1
X_15166_ _04034_ _04176_ VSS VSS VDD VDD _03092_ sky130_fd_sc_hd__nor2_1
X_15167_ _04081_ _04176_ VSS VSS VDD VDD _03091_ sky130_fd_sc_hd__nor2_1
X_15168_ _04022_ _04103_ VSS VSS VDD VDD _03247_ sky130_fd_sc_hd__nor2_1
X_15169_ _04085_ _04176_ VSS VSS VDD VDD _03090_ sky130_fd_sc_hd__nor2_1
X_15170_ network.neuron_in060.counter\[3\] network.in_period\[60\]\[2\]
+ _00211_ net353 VSS VSS VDD VDD _04330_ sky130_fd_sc_hd__o22ai_1
X_15171_ network.neuron_in060.counter\[2\] _00211_ net374
+ VSS VSS VDD VDD _04331_ sky130_fd_sc_hd__nand3_1
X_15172_ network.in_period\[60\]\[2\] net374 _04331_ VSS VSS
+ VDD VDD _04332_ sky130_fd_sc_hd__o21ai_0
X_15173_ _04280_ _04330_ _04332_ VSS VSS VDD VDD _02305_ sky130_fd_sc_hd__a21oi_1
X_15174_ _04090_ _04176_ VSS VSS VDD VDD _03089_ sky130_fd_sc_hd__nor2_1
X_15175_ _04028_ _04095_ VSS VSS VDD VDD _03152_ sky130_fd_sc_hd__nor2_1
X_15176_ _04036_ _04095_ VSS VSS VDD VDD _03151_ sky130_fd_sc_hd__nor2_1
X_15177_ _04022_ _04176_ VSS VSS VDD VDD _03088_ sky130_fd_sc_hd__nor2_1
X_15178_ network.neuron_out0.ROM0.address\[1\] network.neuron_out0.ROM0.address\[0\]
+ _08359_ VSS VSS VDD VDD _01758_ sky130_fd_sc_hd__nor3_1
X_15179_ net308 _04176_ VSS VSS VDD VDD _03341_ sky130_fd_sc_hd__nor2_1
X_15180_ _04099_ _04176_ VSS VSS VDD VDD _03340_ sky130_fd_sc_hd__nor2_1
X_15181_ _04099_ _04103_ VSS VSS VDD VDD _03245_ sky130_fd_sc_hd__nor2_1
X_15182_ _04079_ _04095_ VSS VSS VDD VDD _03148_ sky130_fd_sc_hd__nor2_1
X_15183_ network.in_period\[57\]\[0\] _04233_ VSS VSS VDD
+ VDD _04333_ sky130_fd_sc_hd__nand2_1
X_15184_ network.neuron_in057.counter\[0\] _04233_ _04333_
+ VSS VSS VDD VDD _02291_ sky130_fd_sc_hd__o21ai_0
X_15185_ network.neuron_in233.counter\[1\] VSS VSS VDD VDD
+ _00802_ sky130_fd_sc_hd__inv_1
X_15186_ _04083_ _04103_ VSS VSS VDD VDD _03252_ sky130_fd_sc_hd__nor2_1
X_15187_ _08631_ _04176_ VSS VSS VDD VDD _03338_ sky130_fd_sc_hd__nor2_1
X_15188_ net295 _04103_ VSS VSS VDD VDD _03244_ sky130_fd_sc_hd__nor2_1
X_15189_ net308 _04074_ VSS VSS VDD VDD _03228_ sky130_fd_sc_hd__nor2_1
X_15190_ _04074_ _04099_ VSS VSS VDD VDD _03227_ sky130_fd_sc_hd__nor2_1
X_15191_ _04077_ _04090_ VSS VSS VDD VDD _03213_ sky130_fd_sc_hd__nor2_1
X_15192_ _04022_ _04077_ VSS VSS VDD VDD _03212_ sky130_fd_sc_hd__nor2_1
X_15193_ _04022_ _04074_ VSS VSS VDD VDD _03229_ sky130_fd_sc_hd__nor2_1
X_15194_ _04088_ _04099_ VSS VSS VDD VDD _03191_ sky130_fd_sc_hd__nor2_1
X_15195_ _04088_ net295 VSS VSS VDD VDD _03190_ sky130_fd_sc_hd__nor2_1
X_15196_ _04026_ net295 VSS VSS VDD VDD _03172_ sky130_fd_sc_hd__nor2_1
X_15197_ _04031_ _04093_ VSS VSS VDD VDD _03167_ sky130_fd_sc_hd__nor2_1
X_15198_ _04093_ _04103_ VSS VSS VDD VDD _03256_ sky130_fd_sc_hd__nor2_1
X_15199_ _04031_ _04079_ VSS VSS VDD VDD _03166_ sky130_fd_sc_hd__nor2_1
X_15200_ _04031_ _04108_ VSS VSS VDD VDD _03165_ sky130_fd_sc_hd__nor2_1
X_15201_ _04031_ _04034_ VSS VSS VDD VDD _03162_ sky130_fd_sc_hd__nor2_1
X_15202_ _04031_ _04081_ VSS VSS VDD VDD _03161_ sky130_fd_sc_hd__nor2_1
X_15203_ net405 _07870_ _07299_ VSS VSS VDD VDD _04334_ sky130_fd_sc_hd__o21ai_0
X_15204_ net398 _04334_ VSS VSS VDD VDD _04335_ sky130_fd_sc_hd__nand2_1
X_15205_ net335 _07932_ _04335_ VSS VSS VDD VDD _04336_ sky130_fd_sc_hd__o21ai_0
X_15206_ net394 _07916_ VSS VSS VDD VDD _04337_ sky130_fd_sc_hd__nand2_1
X_15207_ net334 _07961_ _04337_ VSS VSS VDD VDD _04338_ sky130_fd_sc_hd__o21ai_0
X_15208_ network.neuron_hid0.ROM0.address\[0\] net331 net311
+ _04338_ net407 VSS VSS VDD VDD _04339_ sky130_fd_sc_hd__a32oi_1
X_15209_ _07316_ _08108_ _04339_ net401 VSS VSS VDD VDD _04340_
+ sky130_fd_sc_hd__o22ai_1
X_15210_ _03945_ _04336_ _04340_ _08434_ VSS VSS VDD VDD _04341_
+ sky130_fd_sc_hd__a22oi_1
X_15211_ net294 _07276_ _07436_ _04341_ _07282_ VSS VSS VDD
+ VDD _01759_ sky130_fd_sc_hd__o32ai_1
X_15212_ _04085_ _04103_ VSS VSS VDD VDD _03249_ sky130_fd_sc_hd__nor2_1
X_15213_ _04031_ _04099_ VSS VSS VDD VDD _03156_ sky130_fd_sc_hd__nor2_1
X_15214_ net308 _04103_ VSS VSS VDD VDD _03246_ sky130_fd_sc_hd__nor2_1
X_15215_ _04040_ _04095_ VSS VSS VDD VDD _03150_ sky130_fd_sc_hd__nor2_1
X_15216_ _04026_ _04085_ VSS VSS VDD VDD _03178_ sky130_fd_sc_hd__nor2_1
X_15217_ _04026_ _04090_ VSS VSS VDD VDD _03177_ sky130_fd_sc_hd__nor2_1
X_15218_ _04081_ _04179_ VSS VSS VDD VDD _03293_ sky130_fd_sc_hd__nor2_1
X_15219_ _04085_ _04179_ VSS VSS VDD VDD _03292_ sky130_fd_sc_hd__nor2_1
X_15220_ _04090_ _04179_ VSS VSS VDD VDD _03291_ sky130_fd_sc_hd__nor2_1
X_15221_ _04088_ _04108_ VSS VSS VDD VDD _03201_ sky130_fd_sc_hd__nor2_1
X_15222_ _04031_ _04083_ VSS VSS VDD VDD _03163_ sky130_fd_sc_hd__nor2_1
X_15223_ _04031_ net308 VSS VSS VDD VDD _03157_ sky130_fd_sc_hd__nor2_1
X_15224_ _04028_ _04042_ VSS VSS VDD VDD _03284_ sky130_fd_sc_hd__nor2_1
X_15225_ network.neuron_in058.counter\[3\] network.in_period\[58\]\[2\]
+ net354 _00227_ VSS VSS VDD VDD _04342_ sky130_fd_sc_hd__o22ai_1
Xplace295 _07245_ VSS VSS VDD VDD net294 sky130_fd_sc_hd__buf_4
X_15227_ network.neuron_in058.counter\[2\] _00227_ net375
+ VSS VSS VDD VDD _04344_ sky130_fd_sc_hd__nand3_1
X_15228_ network.in_period\[58\]\[2\] net375 _04344_ VSS VSS
+ VDD VDD _04345_ sky130_fd_sc_hd__o21ai_0
X_15229_ _04292_ _04342_ _04345_ VSS VSS VDD VDD _02297_ sky130_fd_sc_hd__a21oi_1
X_15230_ network.in_period\[58\]\[0\] _04294_ VSS VSS VDD
+ VDD _04346_ sky130_fd_sc_hd__nand2_1
X_15231_ network.neuron_in058.counter\[0\] _04294_ _04346_
+ VSS VSS VDD VDD _02295_ sky130_fd_sc_hd__o21ai_0
X_15232_ network.neuron_in149.counter\[2\] network.neuron_in149.counter\[3\]
+ VSS VSS VDD VDD _04347_ sky130_fd_sc_hd__nor2_1
X_15233_ _00527_ _04347_ VSS VSS VDD VDD _04348_ sky130_fd_sc_hd__nand2_1
X_15234_ net384 _04348_ VSS VSS VDD VDD _04349_ sky130_fd_sc_hd__nand2_1
X_15235_ network.in_period\[149\]\[0\] _04349_ VSS VSS VDD
+ VDD _04350_ sky130_fd_sc_hd__nand2_1
X_15236_ network.neuron_in149.counter\[0\] _04349_ _04350_
+ VSS VSS VDD VDD _02659_ sky130_fd_sc_hd__o21ai_0
X_15237_ network.neuron_in059.counter\[3\] network.in_period\[59\]\[2\]
+ net353 _00223_ VSS VSS VDD VDD _04351_ sky130_fd_sc_hd__o22ai_1
X_15238_ network.neuron_in059.counter\[2\] _00223_ net375
+ VSS VSS VDD VDD _04352_ sky130_fd_sc_hd__nand3_1
X_15239_ network.in_period\[59\]\[2\] net375 _04352_ VSS VSS
+ VDD VDD _04353_ sky130_fd_sc_hd__o21ai_0
X_15240_ _04285_ _04351_ _04353_ VSS VSS VDD VDD _02301_ sky130_fd_sc_hd__a21oi_1
X_15241_ network.in_period\[149\]\[1\] _04349_ VSS VSS VDD
+ VDD _04354_ sky130_fd_sc_hd__nand2_1
X_15242_ _00528_ _04349_ _04354_ VSS VSS VDD VDD _02660_ sky130_fd_sc_hd__o21ai_0
X_15243_ network.neuron_in064.counter\[2\] VSS VSS VDD VDD
+ _04355_ sky130_fd_sc_hd__inv_1
X_15244_ _04355_ _00199_ VSS VSS VDD VDD _04356_ sky130_fd_sc_hd__nand2_1
X_15245_ network.neuron_in064.counter\[3\] _04356_ VSS VSS
+ VDD VDD _04357_ sky130_fd_sc_hd__or2_2
X_15246_ net372 _04357_ VSS VSS VDD VDD _04358_ sky130_fd_sc_hd__nand2_1
X_15247_ network.in_period\[64\]\[0\] _04358_ VSS VSS VDD
+ VDD _04359_ sky130_fd_sc_hd__nand2_1
X_15248_ network.neuron_in064.counter\[0\] _04358_ _04359_
+ VSS VSS VDD VDD _02319_ sky130_fd_sc_hd__o21ai_0
Xplace289 _04076_ VSS VSS VDD VDD net288 sky130_fd_sc_hd__buf_4
X_15250_ network.neuron_in062.counter\[2\] _00585_ VSS VSS
+ VDD VDD _04361_ sky130_fd_sc_hd__nand2b_1
X_15251_ network.neuron_in062.counter\[3\] _04361_ VSS VSS
+ VDD VDD _04362_ sky130_fd_sc_hd__or2_2
X_15252_ net375 _04362_ VSS VSS VDD VDD _04363_ sky130_fd_sc_hd__nand2_1
X_15253_ network.in_period\[62\]\[1\] _04363_ VSS VSS VDD
+ VDD _04364_ sky130_fd_sc_hd__nand2_1
X_15254_ _00586_ _04363_ _04364_ VSS VSS VDD VDD _02312_ sky130_fd_sc_hd__o21ai_0
X_15255_ _04077_ net295 VSS VSS VDD VDD _03208_ sky130_fd_sc_hd__nor2_1
X_15256_ _08631_ _04088_ VSS VSS VDD VDD _03189_ sky130_fd_sc_hd__nor2_1
X_15257_ _04103_ _04108_ VSS VSS VDD VDD _03254_ sky130_fd_sc_hd__nor2_1
X_15258_ network.in_period\[64\]\[1\] _04358_ VSS VSS VDD
+ VDD _04365_ sky130_fd_sc_hd__nand2_1
X_15259_ _00200_ _04358_ _04365_ VSS VSS VDD VDD _02320_ sky130_fd_sc_hd__o21ai_0
X_15260_ network.neuron_in062.counter\[2\] net375 VSS VSS
+ VDD VDD _04366_ sky130_fd_sc_hd__nand2_1
X_15261_ network.neuron_in062.counter\[3\] network.in_period\[62\]\[2\]
+ _04366_ VSS VSS VDD VDD _04367_ sky130_fd_sc_hd__o21ai_0
Xplace277 _09399_ VSS VSS VDD VDD net276 sky130_fd_sc_hd__buf_4
X_15263_ _00585_ network.neuron_in062.counter\[2\] net354
+ VSS VSS VDD VDD _04369_ sky130_fd_sc_hd__or3_1
X_15264_ network.in_period\[62\]\[2\] net375 _04369_ VSS VSS
+ VDD VDD _04370_ sky130_fd_sc_hd__o21ai_0
X_15265_ _00585_ _04367_ _04370_ VSS VSS VDD VDD _02313_ sky130_fd_sc_hd__a21oi_1
X_15266_ network.neuron_in063.counter\[2\] VSS VSS VDD VDD
+ _04371_ sky130_fd_sc_hd__inv_1
X_15267_ network.neuron_in063.counter\[3\] network.in_period\[63\]\[2\]
+ _00203_ net354 VSS VSS VDD VDD _04372_ sky130_fd_sc_hd__o22ai_1
X_15268_ network.neuron_in063.counter\[2\] _00203_ net374
+ VSS VSS VDD VDD _04373_ sky130_fd_sc_hd__nand3_1
X_15269_ network.in_period\[63\]\[2\] net374 _04373_ VSS VSS
+ VDD VDD _04374_ sky130_fd_sc_hd__o21ai_0
X_15270_ _04371_ _04372_ _04374_ VSS VSS VDD VDD _02317_ sky130_fd_sc_hd__a21oi_1
X_15271_ network.neuron_in064.counter\[3\] network.in_period\[64\]\[2\]
+ _00199_ net349 VSS VSS VDD VDD _04375_ sky130_fd_sc_hd__o22ai_1
X_15272_ network.neuron_in064.counter\[2\] _00199_ net372
+ VSS VSS VDD VDD _04376_ sky130_fd_sc_hd__nand3_1
X_15273_ network.in_period\[64\]\[2\] net372 _04376_ VSS VSS
+ VDD VDD _04377_ sky130_fd_sc_hd__o21ai_0
X_15274_ _04355_ _04375_ _04377_ VSS VSS VDD VDD _02321_ sky130_fd_sc_hd__a21oi_1
X_15275_ _04034_ _04095_ VSS VSS VDD VDD _03145_ sky130_fd_sc_hd__nor2_1
X_15276_ network.neuron_in108.counter\[1\] VSS VSS VDD VDD
+ _01155_ sky130_fd_sc_hd__inv_1
X_15277_ _04040_ _04074_ VSS VSS VDD VDD _03239_ sky130_fd_sc_hd__nor2_1
X_15278_ net392 network.neuron_hid0.ROM0.address\[1\] VSS
+ VSS VDD VDD _04378_ sky130_fd_sc_hd__nand2_1
X_15279_ net407 net325 net300 _07549_ _08099_ VSS VSS VDD
+ VDD _04379_ sky130_fd_sc_hd__a32oi_1
X_15280_ _07283_ _04378_ _04379_ VSS VSS VDD VDD _01760_ sky130_fd_sc_hd__nor3_1
X_15281_ _04090_ _04095_ VSS VSS VDD VDD _03141_ sky130_fd_sc_hd__nor2_1
X_15282_ _04074_ _04093_ VSS VSS VDD VDD _03238_ sky130_fd_sc_hd__nor2_1
X_15283_ _04022_ _04095_ VSS VSS VDD VDD _03140_ sky130_fd_sc_hd__nor2_1
X_15284_ net308 _04095_ VSS VSS VDD VDD _03139_ sky130_fd_sc_hd__nor2_1
X_15285_ _04095_ _04099_ VSS VSS VDD VDD _03138_ sky130_fd_sc_hd__nor2_1
X_15286_ _04095_ net295 VSS VSS VDD VDD _03137_ sky130_fd_sc_hd__nor2_1
X_15287_ _04074_ _04081_ VSS VSS VDD VDD _03233_ sky130_fd_sc_hd__nor2_1
X_15288_ _08631_ _04095_ VSS VSS VDD VDD _03136_ sky130_fd_sc_hd__nor2_1
X_15289_ _04028_ _04097_ VSS VSS VDD VDD _03135_ sky130_fd_sc_hd__nor2_1
X_15290_ _04036_ _04097_ VSS VSS VDD VDD _03134_ sky130_fd_sc_hd__nor2_1
X_15291_ _04040_ _04097_ VSS VSS VDD VDD _03133_ sky130_fd_sc_hd__nor2_1
X_15292_ _04036_ _04077_ VSS VSS VDD VDD _03223_ sky130_fd_sc_hd__nor2_1
X_15293_ _04093_ _04097_ VSS VSS VDD VDD _03132_ sky130_fd_sc_hd__nor2_1
X_15294_ _04079_ _04097_ VSS VSS VDD VDD _03130_ sky130_fd_sc_hd__nor2_1
X_15295_ _04074_ _04108_ VSS VSS VDD VDD _03236_ sky130_fd_sc_hd__nor2_1
X_15296_ _04097_ _04108_ VSS VSS VDD VDD _03129_ sky130_fd_sc_hd__nor2_1
X_15297_ _04077_ _04108_ VSS VSS VDD VDD _03218_ sky130_fd_sc_hd__nor2_1
X_15298_ _04083_ _04097_ VSS VSS VDD VDD _03128_ sky130_fd_sc_hd__nor2_1
X_15299_ _04034_ _04097_ VSS VSS VDD VDD _03127_ sky130_fd_sc_hd__nor2_1
X_15300_ _04081_ _04097_ VSS VSS VDD VDD _03126_ sky130_fd_sc_hd__nor2_1
X_15301_ _04085_ _04097_ VSS VSS VDD VDD _03125_ sky130_fd_sc_hd__nor2_1
X_15302_ _04090_ _04097_ VSS VSS VDD VDD _03124_ sky130_fd_sc_hd__nor2_1
X_15303_ _08631_ _04026_ VSS VSS VDD VDD _03171_ sky130_fd_sc_hd__nor2_1
X_15304_ net308 _04179_ VSS VSS VDD VDD _03289_ sky130_fd_sc_hd__nor2_1
X_15305_ _04034_ _04103_ VSS VSS VDD VDD _03251_ sky130_fd_sc_hd__nor2_1
X_15306_ _04099_ _04179_ VSS VSS VDD VDD _03288_ sky130_fd_sc_hd__nor2_1
X_15307_ net295 _04179_ VSS VSS VDD VDD _03286_ sky130_fd_sc_hd__nor2_1
X_15308_ _04040_ _04106_ VSS VSS VDD VDD _03115_ sky130_fd_sc_hd__nor2_1
X_15309_ net288 _04105_ VSS VSS VDD VDD _04380_ sky130_fd_sc_hd__nand2_2
Xplace294 _07484_ VSS VSS VDD VDD net293 sky130_fd_sc_hd__buf_4
X_15311_ _04028_ _04380_ VSS VSS VDD VDD _03337_ sky130_fd_sc_hd__nor2_1
X_15312_ _08631_ _04179_ VSS VSS VDD VDD _03285_ sky130_fd_sc_hd__nor2_1
X_15313_ _04036_ _04380_ VSS VSS VDD VDD _03336_ sky130_fd_sc_hd__nor2_1
X_15314_ _04040_ _04380_ VSS VSS VDD VDD _03335_ sky130_fd_sc_hd__nor2_1
X_15315_ network.neuron_out0.ROM0.address\[1\] _08355_ _08359_
+ VSS VSS VDD VDD _01762_ sky130_fd_sc_hd__a21oi_1
X_15316_ _08370_ _01762_ VSS VSS VDD VDD _01761_ sky130_fd_sc_hd__and2_1
X_15317_ _04108_ _04380_ VSS VSS VDD VDD _03332_ sky130_fd_sc_hd__nor2_1
X_15318_ _04083_ _04380_ VSS VSS VDD VDD _03330_ sky130_fd_sc_hd__nor2_1
X_15319_ network.neuron_in061.counter\[2\] VSS VSS VDD VDD
+ _04382_ sky130_fd_sc_hd__inv_1
X_15320_ network.neuron_in061.counter\[3\] VSS VSS VDD VDD
+ _04383_ sky130_fd_sc_hd__inv_1
X_15321_ _04382_ _00593_ _04383_ VSS VSS VDD VDD _04384_ sky130_fd_sc_hd__nand3_1
X_15322_ net374 _04384_ VSS VSS VDD VDD _04385_ sky130_fd_sc_hd__nand2_1
X_15323_ network.in_period\[61\]\[0\] _04385_ VSS VSS VDD
+ VDD _04386_ sky130_fd_sc_hd__nand2_1
X_15324_ network.neuron_in061.counter\[0\] _04385_ _04386_
+ VSS VSS VDD VDD _02307_ sky130_fd_sc_hd__o21ai_0
X_15325_ network.neuron_in083.counter\[0\] VSS VSS VDD VDD
+ _00061_ sky130_fd_sc_hd__inv_1
X_15326_ network.neuron_in061.counter\[3\] network.in_period\[61\]\[2\]
+ net353 _00593_ VSS VSS VDD VDD _04387_ sky130_fd_sc_hd__o22ai_1
X_15327_ network.neuron_in061.counter\[2\] _00593_ net374
+ VSS VSS VDD VDD _04388_ sky130_fd_sc_hd__nand3_1
X_15328_ network.in_period\[61\]\[2\] net374 _04388_ VSS VSS
+ VDD VDD _04389_ sky130_fd_sc_hd__o21ai_0
X_15329_ _04382_ _04387_ _04389_ VSS VSS VDD VDD _02309_ sky130_fd_sc_hd__a21oi_1
X_15330_ network.in_period\[61\]\[1\] _04385_ VSS VSS VDD
+ VDD _04390_ sky130_fd_sc_hd__nand2_1
X_15331_ _00594_ _04385_ _04390_ VSS VSS VDD VDD _02308_ sky130_fd_sc_hd__o21ai_0
X_15332_ network.in_period\[62\]\[0\] _04363_ VSS VSS VDD
+ VDD _04391_ sky130_fd_sc_hd__nand2_1
X_15333_ network.neuron_in062.counter\[0\] _04363_ _04391_
+ VSS VSS VDD VDD _02311_ sky130_fd_sc_hd__o21ai_0
X_15334_ _04093_ _04176_ VSS VSS VDD VDD _03096_ sky130_fd_sc_hd__nor2_1
X_15335_ _04090_ _04380_ VSS VSS VDD VDD _03326_ sky130_fd_sc_hd__nor2_1
X_15336_ net308 _04380_ VSS VSS VDD VDD _03324_ sky130_fd_sc_hd__nor2_1
X_15337_ _04371_ _00203_ VSS VSS VDD VDD _04392_ sky130_fd_sc_hd__nand2_1
X_15338_ network.neuron_in063.counter\[3\] _04392_ VSS VSS
+ VDD VDD _04393_ sky130_fd_sc_hd__or2_2
X_15339_ net374 _04393_ VSS VSS VDD VDD _04394_ sky130_fd_sc_hd__nand2_1
X_15340_ network.in_period\[63\]\[1\] _04394_ VSS VSS VDD
+ VDD _04395_ sky130_fd_sc_hd__nand2_1
X_15341_ _00204_ _04394_ _04395_ VSS VSS VDD VDD _02316_ sky130_fd_sc_hd__o21ai_0
X_15342_ _04026_ _04099_ VSS VSS VDD VDD _03173_ sky130_fd_sc_hd__nor2_1
X_15343_ _04040_ _04042_ VSS VSS VDD VDD _03282_ sky130_fd_sc_hd__nor2_1
X_15344_ _04042_ _04093_ VSS VSS VDD VDD _03281_ sky130_fd_sc_hd__nor2_1
X_15345_ net295 _04380_ VSS VSS VDD VDD _03322_ sky130_fd_sc_hd__nor2_1
X_15346_ _08631_ _04380_ VSS VSS VDD VDD _03321_ sky130_fd_sc_hd__nor2_1
X_15347_ _04042_ _04108_ VSS VSS VDD VDD _03279_ sky130_fd_sc_hd__nor2_1
X_15348_ _04042_ _04083_ VSS VSS VDD VDD _03278_ sky130_fd_sc_hd__nor2_1
X_15349_ network.neuron_in063.counter\[0\] VSS VSS VDD VDD
+ _00201_ sky130_fd_sc_hd__inv_1
X_15350_ network.in_period\[63\]\[0\] _04394_ VSS VSS VDD
+ VDD _04396_ sky130_fd_sc_hd__nand2_1
X_15351_ network.neuron_in063.counter\[0\] _04394_ _04396_
+ VSS VSS VDD VDD _02315_ sky130_fd_sc_hd__o21ai_0
X_15352_ _04093_ _04380_ VSS VSS VDD VDD _03334_ sky130_fd_sc_hd__nor2_1
X_15353_ _04079_ _04380_ VSS VSS VDD VDD _03333_ sky130_fd_sc_hd__nor2_1
X_15354_ _04034_ _04380_ VSS VSS VDD VDD _03329_ sky130_fd_sc_hd__nor2_1
X_15355_ _04081_ _04380_ VSS VSS VDD VDD _03328_ sky130_fd_sc_hd__nor2_1
X_15356_ _04085_ _04380_ VSS VSS VDD VDD _03327_ sky130_fd_sc_hd__nor2_1
X_15357_ _04022_ _04380_ VSS VSS VDD VDD _03325_ sky130_fd_sc_hd__nor2_1
X_15358_ _04099_ _04380_ VSS VSS VDD VDD _03323_ sky130_fd_sc_hd__nor2_1
X_15359_ _04087_ _04105_ VSS VSS VDD VDD _04397_ sky130_fd_sc_hd__nand2_2
Xplace290 _09276_ VSS VSS VDD VDD net289 sky130_fd_sc_hd__buf_4
X_15361_ _04028_ _04397_ VSS VSS VDD VDD _03319_ sky130_fd_sc_hd__nor2_1
X_15362_ _08349_ _08356_ VSS VSS VDD VDD _01763_ sky130_fd_sc_hd__nor2_1
X_15363_ _04079_ _04397_ VSS VSS VDD VDD _03315_ sky130_fd_sc_hd__nor2_1
X_15364_ network.neuron_in067.counter\[2\] VSS VSS VDD VDD
+ _04399_ sky130_fd_sc_hd__inv_1
X_15365_ _04399_ _00168_ VSS VSS VDD VDD _04400_ sky130_fd_sc_hd__nand2_1
X_15366_ network.neuron_in067.counter\[3\] _04400_ VSS VSS
+ VDD VDD _04401_ sky130_fd_sc_hd__or2_2
X_15367_ net375 _04401_ VSS VSS VDD VDD _04402_ sky130_fd_sc_hd__nand2_1
X_15368_ network.in_period\[67\]\[0\] _04402_ VSS VSS VDD
+ VDD _04403_ sky130_fd_sc_hd__nand2_1
X_15369_ network.neuron_in067.counter\[0\] _04402_ _04403_
+ VSS VSS VDD VDD _02331_ sky130_fd_sc_hd__o21ai_0
X_15370_ network.in_period\[67\]\[1\] _04402_ VSS VSS VDD
+ VDD _04404_ sky130_fd_sc_hd__nand2_1
X_15371_ _00169_ _04402_ _04404_ VSS VSS VDD VDD _02332_ sky130_fd_sc_hd__o21ai_0
X_15372_ network.neuron_in067.counter\[3\] network.in_period\[67\]\[2\]
+ net354 _00168_ VSS VSS VDD VDD _04405_ sky130_fd_sc_hd__o22ai_1
X_15373_ network.neuron_in067.counter\[2\] _00168_ net375
+ VSS VSS VDD VDD _04406_ sky130_fd_sc_hd__nand3_1
X_15374_ network.in_period\[67\]\[2\] net375 _04406_ VSS VSS
+ VDD VDD _04407_ sky130_fd_sc_hd__o21ai_0
X_15375_ _04399_ _04405_ _04407_ VSS VSS VDD VDD _02333_ sky130_fd_sc_hd__a21oi_1
X_15376_ network.neuron_in065.counter\[2\] net372 VSS VSS
+ VDD VDD _04408_ sky130_fd_sc_hd__nand2_1
X_15377_ network.neuron_in065.counter\[3\] network.in_period\[65\]\[2\]
+ _04408_ VSS VSS VDD VDD _04409_ sky130_fd_sc_hd__o21ai_0
X_15378_ _00184_ network.neuron_in065.counter\[2\] net354
+ VSS VSS VDD VDD _04410_ sky130_fd_sc_hd__or3_1
X_15379_ network.in_period\[65\]\[2\] net372 _04410_ VSS VSS
+ VDD VDD _04411_ sky130_fd_sc_hd__o21ai_0
X_15380_ _00184_ _04409_ _04411_ VSS VSS VDD VDD _02325_ sky130_fd_sc_hd__a21oi_1
Xplace292 _09186_ VSS VSS VDD VDD net291 sky130_fd_sc_hd__buf_4
X_15382_ network.neuron_in066.counter\[2\] net375 VSS VSS
+ VDD VDD _04413_ sky130_fd_sc_hd__nand2_1
X_15383_ network.neuron_in066.counter\[3\] network.in_period\[66\]\[2\]
+ _04413_ VSS VSS VDD VDD _04414_ sky130_fd_sc_hd__o21ai_0
X_15384_ _00174_ network.neuron_in066.counter\[2\] net354
+ VSS VSS VDD VDD _04415_ sky130_fd_sc_hd__or3_1
X_15385_ network.in_period\[66\]\[2\] net375 _04415_ VSS VSS
+ VDD VDD _04416_ sky130_fd_sc_hd__o21ai_0
X_15386_ _00174_ _04414_ _04416_ VSS VSS VDD VDD _02329_ sky130_fd_sc_hd__a21oi_1
X_15387_ network.neuron_in065.counter\[2\] _00184_ VSS VSS
+ VDD VDD _04417_ sky130_fd_sc_hd__nand2b_1
X_15388_ network.neuron_in065.counter\[3\] _04417_ VSS VSS
+ VDD VDD _04418_ sky130_fd_sc_hd__or2_2
X_15389_ net372 _04418_ VSS VSS VDD VDD _04419_ sky130_fd_sc_hd__nand2_1
X_15390_ network.in_period\[65\]\[1\] _04419_ VSS VSS VDD
+ VDD _04420_ sky130_fd_sc_hd__nand2_1
X_15391_ _00185_ _04419_ _04420_ VSS VSS VDD VDD _02324_ sky130_fd_sc_hd__o21ai_0
X_15392_ network.in_period\[65\]\[0\] _04419_ VSS VSS VDD
+ VDD _04421_ sky130_fd_sc_hd__nand2_1
X_15393_ network.neuron_in065.counter\[0\] _04419_ _04421_
+ VSS VSS VDD VDD _02323_ sky130_fd_sc_hd__o21ai_0
X_15394_ network.neuron_in066.counter\[2\] _00174_ VSS VSS
+ VDD VDD _04422_ sky130_fd_sc_hd__nand2b_1
X_15395_ network.neuron_in066.counter\[3\] _04422_ VSS VSS
+ VDD VDD _04423_ sky130_fd_sc_hd__or2_2
X_15396_ net375 _04423_ VSS VSS VDD VDD _04424_ sky130_fd_sc_hd__nand2_1
X_15397_ network.in_period\[66\]\[1\] _04424_ VSS VSS VDD
+ VDD _04425_ sky130_fd_sc_hd__nand2_1
X_15398_ _00175_ _04424_ _04425_ VSS VSS VDD VDD _02328_ sky130_fd_sc_hd__o21ai_0
X_15399_ network.in_period\[66\]\[0\] _04424_ VSS VSS VDD
+ VDD _04426_ sky130_fd_sc_hd__nand2_1
X_15400_ network.neuron_in066.counter\[0\] _04424_ _04426_
+ VSS VSS VDD VDD _02327_ sky130_fd_sc_hd__o21ai_0
X_15401_ _04026_ _04108_ VSS VSS VDD VDD _03182_ sky130_fd_sc_hd__nor2_1
X_15402_ _04079_ _04179_ VSS VSS VDD VDD _03297_ sky130_fd_sc_hd__nor2_1
X_15403_ _04026_ _04083_ VSS VSS VDD VDD _03181_ sky130_fd_sc_hd__nor2_1
X_15404_ _04108_ _04179_ VSS VSS VDD VDD _03296_ sky130_fd_sc_hd__nor2_1
X_15405_ _04083_ _04179_ VSS VSS VDD VDD _03295_ sky130_fd_sc_hd__nor2_1
X_15406_ _04034_ _04179_ VSS VSS VDD VDD _03294_ sky130_fd_sc_hd__nor2_1
X_15407_ network.neuron_in101.counter\[0\] VSS VSS VDD VDD
+ _00833_ sky130_fd_sc_hd__inv_1
X_15408_ network.neuron_in109.counter\[0\] VSS VSS VDD VDD
+ _00551_ sky130_fd_sc_hd__inv_1
X_15409_ _04042_ _04079_ VSS VSS VDD VDD _03280_ sky130_fd_sc_hd__nor2_1
X_15410_ _04034_ _04042_ VSS VSS VDD VDD _03277_ sky130_fd_sc_hd__nor2_1
X_15411_ _04034_ _04208_ VSS VSS VDD VDD _03253_ sky130_fd_sc_hd__nor2_1
X_15412_ _07870_ _07968_ VSS VSS VDD VDD _04427_ sky130_fd_sc_hd__nand2_1
X_15413_ net398 _04427_ _07872_ VSS VSS VDD VDD _04428_ sky130_fd_sc_hd__a21oi_1
X_15414_ net405 _04428_ VSS VSS VDD VDD _04429_ sky130_fd_sc_hd__nor2_1
X_15415_ net396 net304 _07498_ VSS VSS VDD VDD _04430_ sky130_fd_sc_hd__a21oi_1
X_15416_ net401 _07393_ _07897_ VSS VSS VDD VDD _04431_ sky130_fd_sc_hd__and3_1
X_15417_ net343 _07868_ _07586_ _04431_ VSS VSS VDD VDD _04432_
+ sky130_fd_sc_hd__a31oi_1
X_15418_ net392 _04429_ _04430_ _04432_ VSS VSS VDD VDD _04433_
+ sky130_fd_sc_hd__nor4_1
X_15419_ net410 _07495_ _07974_ net392 net396 VSS VSS VDD
+ VDD _04434_ sky130_fd_sc_hd__a2111oi_0
X_15420_ net404 _07453_ _07905_ VSS VSS VDD VDD _04435_ sky130_fd_sc_hd__nand3_1
X_15421_ net404 net409 _07855_ _04435_ VSS VSS VDD VDD _04436_
+ sky130_fd_sc_hd__o31ai_1
X_15422_ net392 net396 net398 _04436_ VSS VSS VDD VDD _04437_
+ sky130_fd_sc_hd__nor4_1
X_15423_ net395 _07387_ _08232_ net345 VSS VSS VDD VDD _04438_
+ sky130_fd_sc_hd__a22oi_1
X_15424_ net402 net313 net394 VSS VSS VDD VDD _04439_ sky130_fd_sc_hd__o21ai_0
X_15425_ _07945_ _04439_ VSS VSS VDD VDD _04440_ sky130_fd_sc_hd__nand2_1
X_15426_ net395 _08000_ VSS VSS VDD VDD _04441_ sky130_fd_sc_hd__nor2_1
X_15427_ net402 _04441_ net411 VSS VSS VDD VDD _04442_ sky130_fd_sc_hd__o21ai_0
X_15428_ net411 _04440_ _04442_ VSS VSS VDD VDD _04443_ sky130_fd_sc_hd__o21ai_0
X_15429_ net404 _04438_ _04443_ VSS VSS VDD VDD _04444_ sky130_fd_sc_hd__o21ai_0
X_15430_ net341 _07489_ _07468_ VSS VSS VDD VDD _04445_ sky130_fd_sc_hd__o21ai_0
X_15431_ net331 net306 net311 _07280_ net396 _04445_ VSS VSS
+ VDD VDD _04446_ sky130_fd_sc_hd__a222oi_1
X_15432_ net397 _04446_ VSS VSS VDD VDD _04447_ sky130_fd_sc_hd__nor2_1
X_15433_ net396 net346 _07872_ VSS VSS VDD VDD _04448_ sky130_fd_sc_hd__a21oi_1
X_15434_ net405 _04448_ net392 VSS VSS VDD VDD _04449_ sky130_fd_sc_hd__o21ai_0
X_15435_ net398 _04444_ _04447_ _04449_ VSS VSS VDD VDD _04450_
+ sky130_fd_sc_hd__a211oi_1
X_15436_ _04433_ _04434_ _04437_ _04450_ VSS VSS VDD VDD _04451_
+ sky130_fd_sc_hd__nor4_1
X_15437_ net342 _04058_ net312 _07621_ VSS VSS VDD VDD _04452_
+ sky130_fd_sc_hd__a2bb2oi_1
X_15438_ net403 _04452_ VSS VSS VDD VDD _04453_ sky130_fd_sc_hd__nor2_1
X_15439_ net341 _07489_ VSS VSS VDD VDD _04454_ sky130_fd_sc_hd__nand2_1
X_15440_ _04052_ _04454_ net397 VSS VSS VDD VDD _04455_ sky130_fd_sc_hd__a21oi_1
X_15441_ _04453_ _04455_ net293 VSS VSS VDD VDD _04456_ sky130_fd_sc_hd__o21ai_0
X_15442_ _07283_ _04451_ _04456_ VSS VSS VDD VDD _01764_ sky130_fd_sc_hd__o21ai_0
X_15443_ _04099_ _04208_ VSS VSS VDD VDD _03186_ sky130_fd_sc_hd__nor2_1
X_15444_ network.neuron_in068.counter\[2\] VSS VSS VDD VDD
+ _04457_ sky130_fd_sc_hd__inv_1
X_15445_ _04457_ _00162_ VSS VSS VDD VDD _04458_ sky130_fd_sc_hd__nand2_1
X_15446_ network.neuron_in068.counter\[3\] _04458_ VSS VSS
+ VDD VDD _04459_ sky130_fd_sc_hd__or2_2
X_15447_ net374 _04459_ VSS VSS VDD VDD _04460_ sky130_fd_sc_hd__nand2_1
X_15448_ network.in_period\[68\]\[1\] _04460_ VSS VSS VDD
+ VDD _04461_ sky130_fd_sc_hd__nand2_1
X_15449_ _00163_ _04460_ _04461_ VSS VSS VDD VDD _02336_ sky130_fd_sc_hd__o21ai_0
X_15450_ _08631_ _04208_ VSS VSS VDD VDD _03164_ sky130_fd_sc_hd__nor2_1
X_15451_ _04036_ _04103_ VSS VSS VDD VDD _03258_ sky130_fd_sc_hd__nor2_1
X_15452_ _04028_ _04235_ VSS VSS VDD VDD _03153_ sky130_fd_sc_hd__nor2_1
X_15453_ _04036_ _04235_ VSS VSS VDD VDD _03142_ sky130_fd_sc_hd__nor2_1
X_15454_ _04040_ _04235_ VSS VSS VDD VDD _03131_ sky130_fd_sc_hd__nor2_1
X_15455_ _04093_ _04235_ VSS VSS VDD VDD _03120_ sky130_fd_sc_hd__nor2_1
X_15456_ _04079_ _04235_ VSS VSS VDD VDD _03109_ sky130_fd_sc_hd__nor2_1
X_15457_ network.neuron_in068.counter\[3\] network.in_period\[68\]\[2\]
+ net354 _00162_ VSS VSS VDD VDD _04462_ sky130_fd_sc_hd__o22ai_1
X_15458_ network.neuron_in068.counter\[2\] _00162_ net374
+ VSS VSS VDD VDD _04463_ sky130_fd_sc_hd__nand3_1
X_15459_ network.in_period\[68\]\[2\] net374 _04463_ VSS VSS
+ VDD VDD _04464_ sky130_fd_sc_hd__o21ai_0
X_15460_ _04457_ _04462_ _04464_ VSS VSS VDD VDD _02337_ sky130_fd_sc_hd__a21oi_1
X_15461_ _04108_ _04235_ VSS VSS VDD VDD _03098_ sky130_fd_sc_hd__nor2_1
X_15462_ _04083_ _04235_ VSS VSS VDD VDD _03342_ sky130_fd_sc_hd__nor2_1
X_15463_ _04034_ _04235_ VSS VSS VDD VDD _03331_ sky130_fd_sc_hd__nor2_1
X_15464_ network.neuron_in069.counter\[2\] VSS VSS VDD VDD
+ _04465_ sky130_fd_sc_hd__inv_1
X_15465_ network.neuron_in069.counter\[3\] VSS VSS VDD VDD
+ _04466_ sky130_fd_sc_hd__inv_1
X_15466_ _04465_ _00154_ _04466_ VSS VSS VDD VDD _04467_ sky130_fd_sc_hd__nand3_1
X_15467_ net372 _04467_ VSS VSS VDD VDD _04468_ sky130_fd_sc_hd__nand2_1
X_15468_ network.in_period\[69\]\[1\] _04468_ VSS VSS VDD
+ VDD _04469_ sky130_fd_sc_hd__nand2_1
X_15469_ _00155_ _04468_ _04469_ VSS VSS VDD VDD _02340_ sky130_fd_sc_hd__o21ai_0
X_15470_ _04085_ _04235_ VSS VSS VDD VDD _03309_ sky130_fd_sc_hd__nor2_1
X_15471_ network.neuron_in070.counter\[2\] VSS VSS VDD VDD
+ _04470_ sky130_fd_sc_hd__inv_1
X_15472_ network.neuron_in070.counter\[3\] VSS VSS VDD VDD
+ _04471_ sky130_fd_sc_hd__inv_1
X_15473_ _04470_ _00150_ _04471_ VSS VSS VDD VDD _04472_ sky130_fd_sc_hd__nand3_1
X_15474_ net372 _04472_ VSS VSS VDD VDD _04473_ sky130_fd_sc_hd__nand2_1
X_15475_ net806 _04473_ VSS VSS VDD VDD _04474_ sky130_fd_sc_hd__nand2_1
X_15476_ network.neuron_in070.counter\[0\] _04473_ _04474_
+ VSS VSS VDD VDD _02343_ sky130_fd_sc_hd__o21ai_0
X_15477_ _04090_ _04235_ VSS VSS VDD VDD _03298_ sky130_fd_sc_hd__nor2_1
X_15478_ _04022_ _04235_ VSS VSS VDD VDD _03287_ sky130_fd_sc_hd__nor2_1
X_15479_ _04099_ _04235_ VSS VSS VDD VDD _03265_ sky130_fd_sc_hd__nor2_1
X_15480_ _04040_ _04397_ VSS VSS VDD VDD _03317_ sky130_fd_sc_hd__nor2_1
X_15481_ _04093_ _04397_ VSS VSS VDD VDD _03316_ sky130_fd_sc_hd__nor2_1
X_15482_ _04108_ _04397_ VSS VSS VDD VDD _03314_ sky130_fd_sc_hd__nor2_1
X_15483_ _04083_ _04397_ VSS VSS VDD VDD _03313_ sky130_fd_sc_hd__nor2_1
X_15484_ _04034_ _04397_ VSS VSS VDD VDD _03312_ sky130_fd_sc_hd__nor2_1
X_15485_ _08359_ _08368_ VSS VSS VDD VDD _01765_ sky130_fd_sc_hd__nor2_1
X_15486_ _04081_ _04397_ VSS VSS VDD VDD _03311_ sky130_fd_sc_hd__nor2_1
X_15487_ _04085_ _04397_ VSS VSS VDD VDD _03310_ sky130_fd_sc_hd__nor2_1
X_15488_ _04090_ _04397_ VSS VSS VDD VDD _03308_ sky130_fd_sc_hd__nor2_1
X_15489_ _04022_ _04397_ VSS VSS VDD VDD _03307_ sky130_fd_sc_hd__nor2_1
X_15490_ net308 _04397_ VSS VSS VDD VDD _03306_ sky130_fd_sc_hd__nor2_1
X_15491_ _04099_ _04397_ VSS VSS VDD VDD _03305_ sky130_fd_sc_hd__nor2_1
X_15492_ net295 _04397_ VSS VSS VDD VDD _03304_ sky130_fd_sc_hd__nor2_1
X_15493_ _08349_ _08357_ VSS VSS VDD VDD _01766_ sky130_fd_sc_hd__nor2_1
X_15494_ _08631_ _04397_ VSS VSS VDD VDD _03303_ sky130_fd_sc_hd__nor2_1
X_15495_ _04026_ _04093_ VSS VSS VDD VDD _03184_ sky130_fd_sc_hd__nor2_1
X_15496_ _04028_ _04179_ VSS VSS VDD VDD _03302_ sky130_fd_sc_hd__nor2_1
X_15497_ _04036_ _04179_ VSS VSS VDD VDD _03301_ sky130_fd_sc_hd__nor2_1
X_15498_ _04040_ _04179_ VSS VSS VDD VDD _03300_ sky130_fd_sc_hd__nor2_1
X_15499_ _04026_ _04079_ VSS VSS VDD VDD _03183_ sky130_fd_sc_hd__nor2_1
X_15500_ network.in_period\[68\]\[0\] _04460_ VSS VSS VDD
+ VDD _04475_ sky130_fd_sc_hd__nand2_1
X_15501_ network.neuron_in068.counter\[0\] _04460_ _04475_
+ VSS VSS VDD VDD _02335_ sky130_fd_sc_hd__o21ai_0
Xclkbuf_1_1__f_clk_root clknet_0_clk_root VSS VSS VDD VDD
+ clknet_1_1__leaf_clk_root sky130_fd_sc_hd__clkbuf_16
X_15503_ network.neuron_in069.counter\[3\] network.in_period\[69\]\[2\]
+ net354 _00154_ VSS VSS VDD VDD _04477_ sky130_fd_sc_hd__o22ai_1
X_15504_ network.neuron_in069.counter\[2\] _00154_ net372
+ VSS VSS VDD VDD _04478_ sky130_fd_sc_hd__nand3_1
X_15505_ network.in_period\[69\]\[2\] net372 _04478_ VSS VSS
+ VDD VDD _04479_ sky130_fd_sc_hd__o21ai_0
X_15506_ _04465_ _04477_ _04479_ VSS VSS VDD VDD _02341_ sky130_fd_sc_hd__a21oi_1
X_15507_ network.in_period\[69\]\[0\] _04468_ VSS VSS VDD
+ VDD _04480_ sky130_fd_sc_hd__nand2_1
X_15508_ network.neuron_in069.counter\[0\] _04468_ _04480_
+ VSS VSS VDD VDD _02339_ sky130_fd_sc_hd__o21ai_0
X_15509_ network.neuron_in070.counter\[3\] network.in_period\[70\]\[2\]
+ net349 _00150_ VSS VSS VDD VDD _04481_ sky130_fd_sc_hd__o22ai_1
X_15510_ network.neuron_in070.counter\[2\] _00150_ net372
+ VSS VSS VDD VDD _04482_ sky130_fd_sc_hd__nand3_1
X_15511_ network.in_period\[70\]\[2\] net372 _04482_ VSS VSS
+ VDD VDD _04483_ sky130_fd_sc_hd__o21ai_0
X_15512_ _04470_ _04481_ _04483_ VSS VSS VDD VDD _02345_ sky130_fd_sc_hd__a21oi_1
X_15513_ net809 _04473_ VSS VSS VDD VDD _04484_ sky130_fd_sc_hd__nand2_1
X_15514_ _00151_ _04473_ _04484_ VSS VSS VDD VDD _02344_ sky130_fd_sc_hd__o21ai_0
X_15515_ network.neuron_in074.counter\[3\] _00121_ VSS VSS
+ VDD VDD _04485_ sky130_fd_sc_hd__nand2b_1
X_15516_ network.neuron_in074.counter\[2\] VSS VSS VDD VDD
+ _04486_ sky130_fd_sc_hd__inv_1
X_15517_ _04485_ _04486_ VSS VSS VDD VDD _04487_ sky130_fd_sc_hd__nand2b_1
X_15518_ net383 _04487_ VSS VSS VDD VDD _04488_ sky130_fd_sc_hd__nand2_1
X_15519_ net797 _04488_ VSS VSS VDD VDD _04489_ sky130_fd_sc_hd__nand2_1
X_15520_ network.neuron_in074.counter\[0\] _04488_ _04489_
+ VSS VSS VDD VDD _02359_ sky130_fd_sc_hd__o21ai_0
X_15521_ network.neuron_in072.counter\[2\] VSS VSS VDD VDD
+ _04490_ sky130_fd_sc_hd__inv_1
X_15522_ _04490_ _00219_ VSS VSS VDD VDD _04491_ sky130_fd_sc_hd__nand2_1
X_15523_ network.neuron_in072.counter\[3\] _04491_ VSS VSS
+ VDD VDD _04492_ sky130_fd_sc_hd__or2_2
X_15524_ net387 _04492_ VSS VSS VDD VDD _04493_ sky130_fd_sc_hd__nand2_1
X_15525_ net651 _04493_ VSS VSS VDD VDD _04494_ sky130_fd_sc_hd__nand2_1
X_15526_ network.neuron_in072.counter\[0\] _04493_ _04494_
+ VSS VSS VDD VDD _02351_ sky130_fd_sc_hd__o21ai_0
X_15527_ network.in_period\[74\]\[1\] _04488_ VSS VSS VDD
+ VDD _04495_ sky130_fd_sc_hd__nand2_1
X_15528_ _00122_ _04488_ _04495_ VSS VSS VDD VDD _02360_ sky130_fd_sc_hd__o21ai_0
X_15529_ network.neuron_in071.counter\[3\] _00141_ VSS VSS
+ VDD VDD _04496_ sky130_fd_sc_hd__nand2b_1
X_15530_ network.neuron_in071.counter\[2\] VSS VSS VDD VDD
+ _04497_ sky130_fd_sc_hd__inv_1
X_15531_ _04496_ _04497_ VSS VSS VDD VDD _04498_ sky130_fd_sc_hd__nand2b_1
X_15532_ net372 _04498_ VSS VSS VDD VDD _04499_ sky130_fd_sc_hd__nand2_1
X_15533_ net800 _04499_ VSS VSS VDD VDD _04500_ sky130_fd_sc_hd__nand2_1
X_15534_ network.neuron_in071.counter\[0\] _04499_ _04500_
+ VSS VSS VDD VDD _02347_ sky130_fd_sc_hd__o21ai_0
X_15535_ net650 _04493_ VSS VSS VDD VDD _04501_ sky130_fd_sc_hd__nand2_1
X_15536_ _00220_ _04493_ _04501_ VSS VSS VDD VDD _02352_ sky130_fd_sc_hd__o21ai_0
X_15537_ network.neuron_in073.counter\[0\] VSS VSS VDD VDD
+ _00131_ sky130_fd_sc_hd__inv_1
X_15538_ network.neuron_in073.counter\[3\] _00133_ VSS VSS
+ VDD VDD _04502_ sky130_fd_sc_hd__nand2b_1
X_15539_ network.neuron_in073.counter\[2\] VSS VSS VDD VDD
+ _04503_ sky130_fd_sc_hd__inv_1
X_15540_ _04502_ _04503_ VSS VSS VDD VDD _04504_ sky130_fd_sc_hd__nand2b_1
X_15541_ net383 _04504_ VSS VSS VDD VDD _04505_ sky130_fd_sc_hd__nand2_1
X_15542_ network.in_period\[73\]\[0\] _04505_ VSS VSS VDD
+ VDD _04506_ sky130_fd_sc_hd__nand2_1
X_15543_ network.neuron_in073.counter\[0\] _04505_ _04506_
+ VSS VSS VDD VDD _02355_ sky130_fd_sc_hd__o21ai_0
X_15544_ network.neuron_in074.counter\[3\] network.in_period\[74\]\[2\]
+ net355 _00121_ VSS VSS VDD VDD _04507_ sky130_fd_sc_hd__o22ai_1
Xclkbuf_regs_0_core_clk delaynet_2_core_clk VSS VSS VDD VDD
+ clk_root_regs sky130_fd_sc_hd__clkbuf_16
X_15546_ network.neuron_in074.counter\[2\] _00121_ net383
+ VSS VSS VDD VDD _04509_ sky130_fd_sc_hd__nand3_1
X_15547_ network.in_period\[74\]\[2\] net383 _04509_ VSS VSS
+ VDD VDD _04510_ sky130_fd_sc_hd__o21ai_0
X_15548_ _04486_ _04507_ _04510_ VSS VSS VDD VDD _02361_ sky130_fd_sc_hd__a21oi_1
X_15549_ net813 _04499_ VSS VSS VDD VDD _04511_ sky130_fd_sc_hd__nand2_1
X_15550_ _00142_ _04499_ _04511_ VSS VSS VDD VDD _02348_ sky130_fd_sc_hd__o21ai_0
X_15551_ network.neuron_in072.counter\[3\] network.in_period\[72\]\[2\]
+ net348 _00219_ VSS VSS VDD VDD _04512_ sky130_fd_sc_hd__o22ai_1
Xwire442 _09371_ VSS VSS VDD VDD net441 sky130_fd_sc_hd__buf_2
X_15553_ network.neuron_in072.counter\[2\] _00219_ net387
+ VSS VSS VDD VDD _04514_ sky130_fd_sc_hd__nand3_1
X_15554_ network.in_period\[72\]\[2\] net387 _04514_ VSS VSS
+ VDD VDD _04515_ sky130_fd_sc_hd__o21ai_0
X_15555_ _04490_ _04512_ _04515_ VSS VSS VDD VDD _02353_ sky130_fd_sc_hd__a21oi_1
X_15556_ net811 _04505_ VSS VSS VDD VDD _04516_ sky130_fd_sc_hd__nand2_1
X_15557_ _00134_ _04505_ _04516_ VSS VSS VDD VDD _02356_ sky130_fd_sc_hd__o21ai_0
X_15558_ network.neuron_in071.counter\[3\] network.in_period\[71\]\[2\]
+ net349 _00141_ VSS VSS VDD VDD _04517_ sky130_fd_sc_hd__o22ai_1
X_15559_ network.neuron_in071.counter\[2\] _00141_ net372
+ VSS VSS VDD VDD _04518_ sky130_fd_sc_hd__nand3_1
X_15560_ network.in_period\[71\]\[2\] net372 _04518_ VSS VSS
+ VDD VDD _04519_ sky130_fd_sc_hd__o21ai_0
X_15561_ _04497_ _04517_ _04519_ VSS VSS VDD VDD _02349_ sky130_fd_sc_hd__a21oi_1
X_15562_ network.neuron_in190.counter\[1\] VSS VSS VDD VDD
+ _00830_ sky130_fd_sc_hd__inv_1
X_15563_ _07870_ _08444_ VSS VSS VDD VDD _04520_ sky130_fd_sc_hd__nand2_1
X_15564_ net336 _04520_ _07393_ VSS VSS VDD VDD _04521_ sky130_fd_sc_hd__a21boi_0
X_15565_ _07870_ _07999_ _04521_ net397 VSS VSS VDD VDD _04522_
+ sky130_fd_sc_hd__o22ai_1
X_15566_ _07243_ _04522_ VSS VSS VDD VDD _04523_ sky130_fd_sc_hd__nand2_1
X_15567_ net344 net332 VSS VSS VDD VDD _04524_ sky130_fd_sc_hd__nand2_1
X_15568_ net318 _07586_ _07894_ _04524_ net392 VSS VSS VDD
+ VDD _04525_ sky130_fd_sc_hd__a41oi_1
X_15569_ _07571_ _04052_ VSS VSS VDD VDD _04526_ sky130_fd_sc_hd__nand2_1
X_15570_ _07469_ _04526_ _07549_ VSS VSS VDD VDD _04527_ sky130_fd_sc_hd__o21ai_0
X_15571_ net330 _07897_ net399 VSS VSS VDD VDD _04528_ sky130_fd_sc_hd__a21oi_1
X_15572_ net306 _07492_ net399 VSS VSS VDD VDD _04529_ sky130_fd_sc_hd__o21ai_0
X_15573_ net404 net301 net403 VSS VSS VDD VDD _04530_ sky130_fd_sc_hd__o21ai_0
X_15574_ net409 _07584_ _04529_ _04530_ VSS VSS VDD VDD _04531_
+ sky130_fd_sc_hd__nand4_1
X_15575_ net409 _03949_ _04528_ _04531_ VSS VSS VDD VDD _04532_
+ sky130_fd_sc_hd__o31ai_1
X_15576_ net395 _07991_ _04532_ VSS VSS VDD VDD _04533_ sky130_fd_sc_hd__nand3_1
X_15577_ net324 _08056_ net403 VSS VSS VDD VDD _04534_ sky130_fd_sc_hd__a21oi_1
X_15578_ _07368_ _07468_ _04534_ VSS VSS VDD VDD _04535_ sky130_fd_sc_hd__a21oi_1
X_15579_ _07888_ _04535_ VSS VSS VDD VDD _04536_ sky130_fd_sc_hd__nor2_1
X_15580_ net406 net327 _07567_ VSS VSS VDD VDD _04537_ sky130_fd_sc_hd__a21oi_1
X_15581_ net406 _07617_ _04537_ VSS VSS VDD VDD _04538_ sky130_fd_sc_hd__o21ai_0
X_15582_ net407 _07855_ net300 _08104_ VSS VSS VDD VDD _04539_
+ sky130_fd_sc_hd__o211ai_1
X_15583_ _07939_ _08109_ net318 VSS VSS VDD VDD _04540_ sky130_fd_sc_hd__o21ai_0
X_15584_ net393 _04538_ _04539_ _04540_ VSS VSS VDD VDD _04541_
+ sky130_fd_sc_hd__nand4_1
X_15585_ _04536_ _04541_ VSS VSS VDD VDD _04542_ sky130_fd_sc_hd__nor2_1
X_15586_ _04525_ _04527_ _04533_ _04542_ net391 VSS VSS VDD
+ VDD _04543_ sky130_fd_sc_hd__a311o_1
X_15587_ _04523_ _04543_ _07282_ VSS VSS VDD VDD _01767_ sky130_fd_sc_hd__a21oi_1
X_15588_ network.neuron_in097.counter\[2\] VSS VSS VDD VDD
+ _04544_ sky130_fd_sc_hd__inv_1
X_15589_ _04544_ _00075_ VSS VSS VDD VDD _04545_ sky130_fd_sc_hd__nand2_1
X_15590_ network.neuron_in097.counter\[3\] _04545_ VSS VSS
+ VDD VDD _04546_ sky130_fd_sc_hd__or2_2
X_15591_ network.in_spk00_06 _09542_ network.in_spk01_06 VSS
+ VSS VDD VDD _04547_ sky130_fd_sc_hd__o21ai_0
X_15592_ _04546_ _04547_ net349 VSS VSS VDD VDD _01768_ sky130_fd_sc_hd__a21oi_1
X_15593_ network.neuron_in096.counter\[3\] _01212_ VSS VSS
+ VDD VDD _04548_ sky130_fd_sc_hd__nand2b_1
X_15594_ network.neuron_in096.counter\[2\] VSS VSS VDD VDD
+ _04549_ sky130_fd_sc_hd__inv_1
X_15595_ _04548_ _04549_ VSS VSS VDD VDD _04550_ sky130_fd_sc_hd__nand2b_1
X_15596_ network.in_spk00_06 _09542_ VSS VSS VDD VDD _04551_
+ sky130_fd_sc_hd__nand2_1
X_15597_ _04550_ _04551_ net349 VSS VSS VDD VDD _01769_ sky130_fd_sc_hd__a21oi_1
X_15598_ network.neuron_in095.counter\[3\] _01247_ VSS VSS
+ VDD VDD _04552_ sky130_fd_sc_hd__nand2b_1
X_15599_ network.neuron_in095.counter\[2\] _04552_ VSS VSS
+ VDD VDD _04553_ sky130_fd_sc_hd__or2_2
X_15600_ _09373_ _09317_ VSS VSS VDD VDD _04554_ sky130_fd_sc_hd__or2_2
X_15601_ network.in_spk12_05 network.in_spk13_05 network.in_spk14_05
+ _04554_ net775 VSS VSS VDD VDD _04555_ sky130_fd_sc_hd__o41ai_1
X_15602_ _04553_ _04555_ net357 VSS VSS VDD VDD _01770_ sky130_fd_sc_hd__a21oi_1
X_15603_ network.neuron_in094.counter\[3\] _01237_ VSS VSS
+ VDD VDD _04556_ sky130_fd_sc_hd__nand2b_1
X_15604_ network.neuron_in094.counter\[2\] _04556_ VSS VSS
+ VDD VDD _04557_ sky130_fd_sc_hd__or2_2
X_15605_ network.in_spk12_05 network.in_spk13_05 _04554_ network.in_spk14_05
+ VSS VSS VDD VDD _04558_ sky130_fd_sc_hd__o31ai_1
X_15606_ _04557_ _04558_ net357 VSS VSS VDD VDD _01771_ sky130_fd_sc_hd__a21oi_1
X_15607_ network.neuron_in093.counter\[2\] network.neuron_in093.counter\[3\]
+ VSS VSS VDD VDD _04559_ sky130_fd_sc_hd__nor2_1
X_15608_ _01233_ _04559_ VSS VSS VDD VDD _04560_ sky130_fd_sc_hd__nand2_1
X_15609_ network.in_spk12_05 _04554_ network.in_spk13_05 VSS
+ VSS VDD VDD _04561_ sky130_fd_sc_hd__o21ai_0
X_15610_ _04560_ _04561_ net357 VSS VSS VDD VDD _01772_ sky130_fd_sc_hd__a21oi_1
X_15611_ network.neuron_in092.counter\[2\] _01229_ VSS VSS
+ VDD VDD _04562_ sky130_fd_sc_hd__nand2b_1
X_15612_ network.neuron_in092.counter\[3\] _04562_ VSS VSS
+ VDD VDD _04563_ sky130_fd_sc_hd__or2_2
X_15613_ network.in_spk12_05 _04554_ VSS VSS VDD VDD _04564_
+ sky130_fd_sc_hd__nand2_1
Xclkbuf_1_0__f_clk_root clknet_0_clk_root VSS VSS VDD VDD
+ clknet_1_0__leaf_clk_root sky130_fd_sc_hd__clkbuf_16
X_15615_ _04563_ _04564_ net357 VSS VSS VDD VDD _01773_ sky130_fd_sc_hd__a21oi_1
X_15616_ network.neuron_in091.counter\[3\] _00137_ VSS VSS
+ VDD VDD _04566_ sky130_fd_sc_hd__nand2b_1
X_15617_ network.neuron_in091.counter\[2\] VSS VSS VDD VDD
+ _04567_ sky130_fd_sc_hd__inv_1
X_15618_ _04566_ _04567_ VSS VSS VDD VDD _04568_ sky130_fd_sc_hd__nand2b_1
X_15619_ network.in_spk08_05 network.in_spk09_05 network.in_spk10_05
+ _09317_ network.in_spk11_05 VSS VSS VDD VDD _04569_ sky130_fd_sc_hd__o41ai_1
X_15620_ _04568_ _04569_ net348 VSS VSS VDD VDD _01774_ sky130_fd_sc_hd__a21oi_1
X_15621_ network.neuron_in090.counter\[2\] network.neuron_in090.counter\[3\]
+ VSS VSS VDD VDD _04570_ sky130_fd_sc_hd__nor2_1
X_15622_ _00597_ _04570_ VSS VSS VDD VDD _04571_ sky130_fd_sc_hd__nand2_1
X_15623_ network.in_spk08_05 network.in_spk09_05 _09317_ network.in_spk10_05
+ VSS VSS VDD VDD _04572_ sky130_fd_sc_hd__o31ai_1
X_15624_ _04571_ _04572_ net348 VSS VSS VDD VDD _01775_ sky130_fd_sc_hd__a21oi_1
X_15625_ network.neuron_in089.counter\[3\] _01220_ VSS VSS
+ VDD VDD _04573_ sky130_fd_sc_hd__nand2b_1
X_15626_ network.neuron_in089.counter\[2\] VSS VSS VDD VDD
+ _04574_ sky130_fd_sc_hd__inv_1
X_15627_ _04573_ _04574_ VSS VSS VDD VDD _04575_ sky130_fd_sc_hd__nand2b_1
X_15628_ network.in_spk08_05 _09317_ network.in_spk09_05 VSS
+ VSS VDD VDD _04576_ sky130_fd_sc_hd__o21ai_0
X_15629_ _04575_ _04576_ net348 VSS VSS VDD VDD _01776_ sky130_fd_sc_hd__a21oi_1
X_15630_ network.neuron_in088.counter\[3\] _01216_ VSS VSS
+ VDD VDD _04577_ sky130_fd_sc_hd__nand2b_1
X_15631_ network.neuron_in088.counter\[2\] VSS VSS VDD VDD
+ _04578_ sky130_fd_sc_hd__inv_1
X_15632_ _04577_ _04578_ VSS VSS VDD VDD _04579_ sky130_fd_sc_hd__nand2b_1
X_15633_ network.in_spk08_05 _09317_ VSS VSS VDD VDD _04580_
+ sky130_fd_sc_hd__nand2_1
X_15634_ _04579_ _04580_ net348 VSS VSS VDD VDD _01777_ sky130_fd_sc_hd__a21oi_1
X_15635_ network.neuron_in087.counter\[3\] _00036_ VSS VSS
+ VDD VDD _04581_ sky130_fd_sc_hd__nand2b_1
X_15636_ network.neuron_in087.counter\[2\] VSS VSS VDD VDD
+ _04582_ sky130_fd_sc_hd__inv_1
X_15637_ _04581_ _04582_ VSS VSS VDD VDD _04583_ sky130_fd_sc_hd__nand2b_1
X_15638_ net292 _09166_ _09284_ VSS VSS VDD VDD _04584_ sky130_fd_sc_hd__nand3_1
X_15639_ network.in_spk04_05 network.in_spk05_05 network.in_spk06_05
+ _04584_ network.in_spk07_05 VSS VSS VDD VDD _04585_ sky130_fd_sc_hd__o41ai_1
X_15640_ _04583_ _04585_ net357 VSS VSS VDD VDD _01778_ sky130_fd_sc_hd__a21oi_1
X_15641_ network.neuron_in086.counter\[3\] _00040_ VSS VSS
+ VDD VDD _04586_ sky130_fd_sc_hd__nand2b_1
X_15642_ network.neuron_in086.counter\[2\] VSS VSS VDD VDD
+ _04587_ sky130_fd_sc_hd__inv_1
X_15643_ _04586_ _04587_ VSS VSS VDD VDD _04588_ sky130_fd_sc_hd__nand2b_1
X_15644_ network.in_spk04_05 network.in_spk05_05 _04584_ network.in_spk06_05
+ VSS VSS VDD VDD _04589_ sky130_fd_sc_hd__o31ai_1
X_15645_ _04588_ _04589_ net357 VSS VSS VDD VDD _01779_ sky130_fd_sc_hd__a21oi_1
X_15646_ network.neuron_in085.counter\[2\] network.neuron_in085.counter\[3\]
+ VSS VSS VDD VDD _04590_ sky130_fd_sc_hd__nor2_1
X_15647_ _00044_ _04590_ VSS VSS VDD VDD _04591_ sky130_fd_sc_hd__nand2_1
X_15648_ network.in_spk04_05 _04584_ network.in_spk05_05 VSS
+ VSS VDD VDD _04592_ sky130_fd_sc_hd__o21ai_0
X_15649_ _04591_ _04592_ net357 VSS VSS VDD VDD _01780_ sky130_fd_sc_hd__a21oi_1
X_15650_ network.neuron_in084.counter\[3\] _00051_ VSS VSS
+ VDD VDD _04593_ sky130_fd_sc_hd__nand2b_1
X_15651_ network.neuron_in084.counter\[2\] VSS VSS VDD VDD
+ _04594_ sky130_fd_sc_hd__inv_1
X_15652_ _04593_ _04594_ VSS VSS VDD VDD _04595_ sky130_fd_sc_hd__nand2b_1
X_15653_ network.in_spk04_05 _04584_ VSS VSS VDD VDD _04596_
+ sky130_fd_sc_hd__nand2_1
X_15654_ _04595_ _04596_ net357 VSS VSS VDD VDD _01781_ sky130_fd_sc_hd__a21oi_1
X_15655_ network.neuron_in083.counter\[3\] _00063_ VSS VSS
+ VDD VDD _04597_ sky130_fd_sc_hd__nand2b_1
X_15656_ network.neuron_in083.counter\[2\] VSS VSS VDD VDD
+ _04598_ sky130_fd_sc_hd__inv_1
X_15657_ _04597_ _04598_ VSS VSS VDD VDD _04599_ sky130_fd_sc_hd__nand2b_1
X_15658_ network.in_spk00_05 network.in_spk01_05 network.in_spk02_05
+ _09285_ network.in_spk03_05 VSS VSS VDD VDD _04600_ sky130_fd_sc_hd__o41ai_1
X_15659_ _04599_ _04600_ net357 VSS VSS VDD VDD _01782_ sky130_fd_sc_hd__a21oi_1
X_15660_ network.neuron_in082.counter\[3\] _00059_ VSS VSS
+ VDD VDD _04601_ sky130_fd_sc_hd__nand2b_1
X_15661_ network.neuron_in082.counter\[2\] VSS VSS VDD VDD
+ _04602_ sky130_fd_sc_hd__inv_1
X_15662_ _04601_ _04602_ VSS VSS VDD VDD _04603_ sky130_fd_sc_hd__nand2b_1
X_15663_ network.in_spk00_05 network.in_spk01_05 _09285_ network.in_spk02_05
+ VSS VSS VDD VDD _04604_ sky130_fd_sc_hd__o31ai_1
Xclkbuf_0_clk_root clk_root VSS VSS VDD VDD clknet_0_clk_root
+ sky130_fd_sc_hd__clkbuf_16
X_15665_ _04603_ _04604_ net357 VSS VSS VDD VDD _01783_ sky130_fd_sc_hd__a21oi_1
X_15666_ network.neuron_in081.counter\[2\] VSS VSS VDD VDD
+ _04606_ sky130_fd_sc_hd__inv_1
X_15667_ _04606_ _00083_ VSS VSS VDD VDD _04607_ sky130_fd_sc_hd__nand2_1
X_15668_ network.neuron_in081.counter\[3\] _04607_ VSS VSS
+ VDD VDD _04608_ sky130_fd_sc_hd__or2_2
X_15669_ network.in_spk01_05 _09615_ VSS VSS VDD VDD _04609_
+ sky130_fd_sc_hd__nand2_1
X_15670_ _04608_ _04609_ net357 VSS VSS VDD VDD _01784_ sky130_fd_sc_hd__a21oi_1
X_15671_ network.neuron_in080.counter\[2\] VSS VSS VDD VDD
+ _04610_ sky130_fd_sc_hd__inv_1
X_15672_ _04610_ _00088_ VSS VSS VDD VDD _04611_ sky130_fd_sc_hd__nand2_1
X_15673_ network.neuron_in080.counter\[3\] _04611_ VSS VSS
+ VDD VDD _04612_ sky130_fd_sc_hd__or2_2
X_15674_ network.in_spk00_05 _09285_ VSS VSS VDD VDD _04613_
+ sky130_fd_sc_hd__nand2_1
X_15675_ _04612_ _04613_ net357 VSS VSS VDD VDD _01785_ sky130_fd_sc_hd__a21oi_1
X_15676_ network.neuron_in079.counter\[2\] _00096_ VSS VSS
+ VDD VDD _04614_ sky130_fd_sc_hd__nand2b_1
X_15677_ network.neuron_in079.counter\[3\] _04614_ VSS VSS
+ VDD VDD _04615_ sky130_fd_sc_hd__or2_2
X_15678_ net292 _09378_ _09482_ VSS VSS VDD VDD _04616_ sky130_fd_sc_hd__nand3_1
X_15679_ network.in_spk15_04 _04616_ VSS VSS VDD VDD _04617_
+ sky130_fd_sc_hd__nand2_1
X_15680_ _04615_ _04617_ net355 VSS VSS VDD VDD _01786_ sky130_fd_sc_hd__a21oi_1
X_15681_ network.neuron_in078.counter\[2\] _00100_ VSS VSS
+ VDD VDD _04618_ sky130_fd_sc_hd__nand2b_1
X_15682_ network.neuron_in078.counter\[3\] _04618_ VSS VSS
+ VDD VDD _04619_ sky130_fd_sc_hd__or2_2
X_15683_ net292 _09482_ VSS VSS VDD VDD _04620_ sky130_fd_sc_hd__nand2_1
X_15684_ network.in_spk12_04 network.in_spk13_04 _04620_ network.in_spk14_04
+ VSS VSS VDD VDD _04621_ sky130_fd_sc_hd__o31ai_1
X_15685_ _04619_ _04621_ net355 VSS VSS VDD VDD _01787_ sky130_fd_sc_hd__a21oi_1
X_15686_ network.neuron_in077.counter\[2\] network.neuron_in077.counter\[3\]
+ VSS VSS VDD VDD _04622_ sky130_fd_sc_hd__nor2_1
X_15687_ _00104_ _04622_ VSS VSS VDD VDD _04623_ sky130_fd_sc_hd__nand2_1
X_15688_ network.in_spk12_04 _04620_ network.in_spk13_04 VSS
+ VSS VDD VDD _04624_ sky130_fd_sc_hd__o21ai_0
X_15689_ _04623_ _04624_ net355 VSS VSS VDD VDD _01788_ sky130_fd_sc_hd__a21oi_1
X_15690_ network.neuron_in076.counter\[3\] _00113_ VSS VSS
+ VDD VDD _04625_ sky130_fd_sc_hd__nand2b_1
X_15691_ network.neuron_in076.counter\[2\] VSS VSS VDD VDD
+ _04626_ sky130_fd_sc_hd__inv_1
X_15692_ _04625_ _04626_ VSS VSS VDD VDD _04627_ sky130_fd_sc_hd__nand2b_1
X_15693_ network.in_spk12_04 _04620_ VSS VSS VDD VDD _04628_
+ sky130_fd_sc_hd__nand2_1
X_15694_ _04627_ _04628_ net355 VSS VSS VDD VDD _01789_ sky130_fd_sc_hd__a21oi_1
X_15695_ network.neuron_in075.counter\[2\] VSS VSS VDD VDD
+ _04629_ sky130_fd_sc_hd__inv_1
X_15696_ _04629_ _00125_ VSS VSS VDD VDD _04630_ sky130_fd_sc_hd__nand2_1
X_15697_ network.neuron_in075.counter\[3\] _04630_ VSS VSS
+ VDD VDD _04631_ sky130_fd_sc_hd__or2_2
X_15698_ net292 _09160_ _09161_ _09484_ VSS VSS VDD VDD _04632_
+ sky130_fd_sc_hd__nand4_1
X_15699_ network.in_spk10_04 _04632_ network.in_spk11_04 VSS
+ VSS VDD VDD _04633_ sky130_fd_sc_hd__o21ai_0
X_15700_ _04631_ _04633_ net355 VSS VSS VDD VDD _01790_ sky130_fd_sc_hd__a21oi_1
X_15701_ network.in_spk10_04 _04632_ VSS VSS VDD VDD _04634_
+ sky130_fd_sc_hd__nand2_1
X_15702_ _04487_ _04634_ net355 VSS VSS VDD VDD _01791_ sky130_fd_sc_hd__a21oi_1
X_15703_ network.in_spk08_04 _09311_ network.in_spk09_04 VSS
+ VSS VDD VDD _04635_ sky130_fd_sc_hd__o21ai_0
X_15704_ _04504_ _04635_ net355 VSS VSS VDD VDD _01792_ sky130_fd_sc_hd__a21oi_1
X_15705_ network.in_spk08_04 _09311_ VSS VSS VDD VDD _04636_
+ sky130_fd_sc_hd__nand2_1
Xmax_cap443 _04030_ VSS VSS VDD VDD net442 sky130_fd_sc_hd__buf_6
X_15707_ _04492_ _04636_ net355 VSS VSS VDD VDD _01793_ sky130_fd_sc_hd__a21oi_1
X_15708_ network.in_spk04_04 network.in_spk05_04 network.in_spk06_04
+ _09377_ network.in_spk07_04 VSS VSS VDD VDD _04638_ sky130_fd_sc_hd__o41ai_1
X_15709_ _04498_ _04638_ net349 VSS VSS VDD VDD _01794_ sky130_fd_sc_hd__a21oi_1
X_15710_ network.in_spk04_04 network.in_spk05_04 _09377_ network.in_spk06_04
+ VSS VSS VDD VDD _04639_ sky130_fd_sc_hd__o31ai_1
X_15711_ _04472_ _04639_ net349 VSS VSS VDD VDD _01795_ sky130_fd_sc_hd__a21oi_1
X_15712_ network.in_spk04_04 _09377_ network.in_spk05_04 VSS
+ VSS VDD VDD _04640_ sky130_fd_sc_hd__o21ai_0
X_15713_ _04467_ _04640_ net349 VSS VSS VDD VDD _01796_ sky130_fd_sc_hd__a21oi_1
X_15714_ network.in_spk04_04 _09377_ VSS VSS VDD VDD _04641_
+ sky130_fd_sc_hd__nand2_1
X_15715_ _04459_ _04641_ net349 VSS VSS VDD VDD _01797_ sky130_fd_sc_hd__a21oi_1
X_15716_ network.in_spk00_04 _09188_ _09164_ VSS VSS VDD VDD
+ _04642_ sky130_fd_sc_hd__or3_1
X_15717_ network.in_spk01_04 network.in_spk02_04 _04642_ network.in_spk03_04
+ VSS VSS VDD VDD _04643_ sky130_fd_sc_hd__o31ai_1
X_15718_ _04401_ _04643_ net349 VSS VSS VDD VDD _01798_ sky130_fd_sc_hd__a21oi_1
X_15719_ network.in_spk01_04 _04642_ network.in_spk02_04 VSS
+ VSS VDD VDD _04644_ sky130_fd_sc_hd__o21ai_0
X_15720_ _04423_ _04644_ net349 VSS VSS VDD VDD _01799_ sky130_fd_sc_hd__a21oi_1
X_15721_ network.in_spk01_04 _04642_ VSS VSS VDD VDD _04645_
+ sky130_fd_sc_hd__nand2_1
X_15722_ _04418_ _04645_ net349 VSS VSS VDD VDD _01800_ sky130_fd_sc_hd__a21oi_1
X_15723_ _09188_ _09164_ network.in_spk00_04 VSS VSS VDD VDD
+ _04646_ sky130_fd_sc_hd__o21ai_0
X_15724_ _04357_ _04646_ net349 VSS VSS VDD VDD _01801_ sky130_fd_sc_hd__a21oi_1
X_15725_ _09141_ net290 _09491_ VSS VSS VDD VDD _04647_ sky130_fd_sc_hd__nand3_1
X_15726_ _09677_ _04647_ VSS VSS VDD VDD _04648_ sky130_fd_sc_hd__nor2_1
X_15727_ _09136_ _04648_ VSS VSS VDD VDD _04649_ sky130_fd_sc_hd__nand2_1
X_15728_ network.in_spk12_03 network.in_spk13_03 network.in_spk14_03
+ _04649_ network.in_spk15_03 VSS VSS VDD VDD _04650_ sky130_fd_sc_hd__o41ai_1
X_15729_ _04393_ _04650_ net353 VSS VSS VDD VDD _01802_ sky130_fd_sc_hd__a21oi_1
X_15730_ network.in_spk12_03 network.in_spk13_03 _04649_ network.in_spk14_03
+ VSS VSS VDD VDD _04651_ sky130_fd_sc_hd__o31ai_1
Xplace441 net450 VSS VSS VDD VDD net440 sky130_fd_sc_hd__buf_4
X_15732_ _04362_ _04651_ net353 VSS VSS VDD VDD _01803_ sky130_fd_sc_hd__a21oi_1
X_15733_ network.in_spk12_03 _04649_ network.in_spk13_03 VSS
+ VSS VDD VDD _04653_ sky130_fd_sc_hd__o21ai_0
X_15734_ _04384_ _04653_ net353 VSS VSS VDD VDD _01804_ sky130_fd_sc_hd__a21oi_1
X_15735_ network.in_spk12_03 _04649_ VSS VSS VDD VDD _04654_
+ sky130_fd_sc_hd__nand2_1
X_15736_ _04282_ _04654_ net353 VSS VSS VDD VDD _01805_ sky130_fd_sc_hd__a21oi_1
X_15737_ _09510_ _04648_ VSS VSS VDD VDD _04655_ sky130_fd_sc_hd__nand2_1
X_15738_ network.in_spk10_03 _04655_ network.in_spk11_03 VSS
+ VSS VDD VDD _04656_ sky130_fd_sc_hd__o21ai_0
X_15739_ _04287_ _04656_ net353 VSS VSS VDD VDD _01806_ sky130_fd_sc_hd__a21oi_1
X_15740_ network.in_spk10_03 _04655_ VSS VSS VDD VDD _04657_
+ sky130_fd_sc_hd__nand2_1
X_15741_ _04293_ _04657_ net353 VSS VSS VDD VDD _01807_ sky130_fd_sc_hd__a21oi_1
X_15742_ _09677_ _04647_ VSS VSS VDD VDD _04658_ sky130_fd_sc_hd__or2_2
X_15743_ network.in_spk08_03 _04658_ network.in_spk09_03 VSS
+ VSS VDD VDD _04659_ sky130_fd_sc_hd__o21ai_0
X_15744_ _04232_ _04659_ net353 VSS VSS VDD VDD _01808_ sky130_fd_sc_hd__a21oi_1
X_15745_ network.in_spk08_03 _04658_ VSS VSS VDD VDD _04660_
+ sky130_fd_sc_hd__nand2_1
X_15746_ _04260_ _04660_ net353 VSS VSS VDD VDD _01809_ sky130_fd_sc_hd__a21oi_1
X_15747_ network.in_spk04_03 network.in_spk05_03 network.in_spk06_03
+ _09384_ network.in_spk07_03 VSS VSS VDD VDD _04661_ sky130_fd_sc_hd__o41ai_1
X_15748_ _04255_ _04661_ net353 VSS VSS VDD VDD _01810_ sky130_fd_sc_hd__a21oi_1
X_15749_ network.in_spk04_03 network.in_spk05_03 _09384_ network.in_spk06_03
+ VSS VSS VDD VDD _04662_ sky130_fd_sc_hd__o31ai_1
X_15750_ _04268_ _04662_ net353 VSS VSS VDD VDD _01811_ sky130_fd_sc_hd__a21oi_1
X_15751_ network.in_spk04_03 _09384_ network.in_spk05_03 VSS
+ VSS VDD VDD _04663_ sky130_fd_sc_hd__o21ai_0
X_15752_ _04247_ _04663_ net353 VSS VSS VDD VDD _01812_ sky130_fd_sc_hd__a21oi_1
X_15753_ network.in_spk04_03 _09384_ VSS VSS VDD VDD _04664_
+ sky130_fd_sc_hd__nand2_1
Xplace439 net450 VSS VSS VDD VDD net438 sky130_fd_sc_hd__buf_6
X_15755_ _04226_ _04664_ net353 VSS VSS VDD VDD _01813_ sky130_fd_sc_hd__a21oi_1
X_15756_ _09383_ _09141_ net290 _09491_ VSS VSS VDD VDD _04666_
+ sky130_fd_sc_hd__nand4_1
X_15757_ network.in_spk02_03 _04666_ network.in_spk03_03 VSS
+ VSS VDD VDD _04667_ sky130_fd_sc_hd__o21ai_0
X_15758_ _04173_ _04667_ net353 VSS VSS VDD VDD _01814_ sky130_fd_sc_hd__a21oi_1
X_15759_ network.in_spk02_03 _04666_ VSS VSS VDD VDD _04668_
+ sky130_fd_sc_hd__nand2_1
X_15760_ _04168_ _04668_ net353 VSS VSS VDD VDD _01815_ sky130_fd_sc_hd__a21oi_1
X_15761_ network.in_spk00_03 _04647_ network.in_spk01_03 VSS
+ VSS VDD VDD _04669_ sky130_fd_sc_hd__o21ai_0
X_15762_ _04149_ _04669_ net353 VSS VSS VDD VDD _01816_ sky130_fd_sc_hd__a21oi_1
X_15763_ network.in_spk00_03 _04647_ VSS VSS VDD VDD _04670_
+ sky130_fd_sc_hd__nand2_1
X_15764_ _04163_ _04670_ net353 VSS VSS VDD VDD _01817_ sky130_fd_sc_hd__a21oi_1
X_15765_ net290 _09156_ VSS VSS VDD VDD _04671_ sky130_fd_sc_hd__nand2_1
X_15766_ _09299_ _04671_ VSS VSS VDD VDD _04672_ sky130_fd_sc_hd__nor2_1
X_15767_ _09154_ _09523_ _04672_ VSS VSS VDD VDD _04673_ sky130_fd_sc_hd__nand3_1
X_15768_ network.in_spk14_02 _04673_ network.in_spk15_02 VSS
+ VSS VDD VDD _04674_ sky130_fd_sc_hd__o21ai_0
X_15769_ _04158_ _04674_ net354 VSS VSS VDD VDD _01818_ sky130_fd_sc_hd__a21oi_1
X_15770_ network.in_spk14_02 _04673_ VSS VSS VDD VDD _04675_
+ sky130_fd_sc_hd__nand2_1
X_15771_ _04122_ _04675_ net354 VSS VSS VDD VDD _01819_ sky130_fd_sc_hd__a21oi_1
X_15772_ _09154_ _04672_ VSS VSS VDD VDD _04676_ sky130_fd_sc_hd__nand2_1
X_15773_ network.in_spk12_02 _04676_ network.in_spk13_02 VSS
+ VSS VDD VDD _04677_ sky130_fd_sc_hd__o21ai_0
X_15774_ _04117_ _04677_ net354 VSS VSS VDD VDD _01820_ sky130_fd_sc_hd__a21oi_1
X_15775_ network.in_spk12_02 _04676_ VSS VSS VDD VDD _04678_
+ sky130_fd_sc_hd__nand2_1
X_15776_ _04131_ _04678_ net354 VSS VSS VDD VDD _01821_ sky130_fd_sc_hd__a21oi_1
X_15777_ net290 _09152_ _09153_ _09156_ VSS VSS VDD VDD _04679_
+ sky130_fd_sc_hd__nand4_1
X_15778_ network.in_spk08_02 network.in_spk09_02 _04679_ VSS
+ VSS VDD VDD _04680_ sky130_fd_sc_hd__or3_1
X_15779_ network.in_spk10_02 _04680_ network.in_spk11_02 VSS
+ VSS VDD VDD _04681_ sky130_fd_sc_hd__o21ai_0
X_15780_ _04126_ _04681_ net354 VSS VSS VDD VDD _01822_ sky130_fd_sc_hd__a21oi_1
X_15781_ network.in_spk10_02 _04680_ VSS VSS VDD VDD _04682_
+ sky130_fd_sc_hd__nand2_1
Xplace438 net438 VSS VSS VDD VDD net437 sky130_fd_sc_hd__buf_4
X_15783_ _03837_ _04682_ net354 VSS VSS VDD VDD _01823_ sky130_fd_sc_hd__a21oi_1
X_15784_ network.in_spk08_02 _04679_ network.in_spk09_02 VSS
+ VSS VDD VDD _04684_ sky130_fd_sc_hd__o21ai_0
X_15785_ _03880_ _04684_ net354 VSS VSS VDD VDD _01824_ sky130_fd_sc_hd__a21oi_1
X_15786_ network.in_spk08_02 _04679_ VSS VSS VDD VDD _04685_
+ sky130_fd_sc_hd__nand2_1
X_15787_ _03862_ _04685_ net354 VSS VSS VDD VDD _01825_ sky130_fd_sc_hd__a21oi_1
X_15788_ net290 _09152_ _09519_ _09156_ VSS VSS VDD VDD _04686_
+ sky130_fd_sc_hd__nand4_1
X_15789_ network.in_spk06_02 _04686_ network.in_spk07_02 VSS
+ VSS VDD VDD _04687_ sky130_fd_sc_hd__o21ai_0
X_15790_ _03725_ _04687_ net354 VSS VSS VDD VDD _01826_ sky130_fd_sc_hd__a21oi_1
X_15791_ network.in_spk06_02 _04686_ VSS VSS VDD VDD _04688_
+ sky130_fd_sc_hd__nand2_1
X_15792_ _03744_ _04688_ net354 VSS VSS VDD VDD _01827_ sky130_fd_sc_hd__a21oi_1
X_15793_ net290 _09152_ _09156_ VSS VSS VDD VDD _04689_ sky130_fd_sc_hd__nand3_1
X_15794_ network.in_spk04_02 _04689_ network.in_spk05_02 VSS
+ VSS VDD VDD _04690_ sky130_fd_sc_hd__o21ai_0
X_15795_ _03730_ _04690_ net354 VSS VSS VDD VDD _01828_ sky130_fd_sc_hd__a21oi_1
X_15796_ network.in_spk04_02 _04689_ VSS VSS VDD VDD _04691_
+ sky130_fd_sc_hd__nand2_1
X_15797_ _03789_ _04691_ net354 VSS VSS VDD VDD _01829_ sky130_fd_sc_hd__a21oi_1
X_15798_ network.in_spk00_02 network.in_spk01_02 network.in_spk02_02
+ _04671_ network.in_spk03_02 VSS VSS VDD VDD _04692_ sky130_fd_sc_hd__o41ai_1
X_15799_ _03697_ _04692_ net354 VSS VSS VDD VDD _01830_ sky130_fd_sc_hd__a21oi_1
X_15800_ network.in_spk00_02 network.in_spk01_02 _04671_ network.in_spk02_02
+ VSS VSS VDD VDD _04693_ sky130_fd_sc_hd__o31ai_1
X_15801_ _03683_ _04693_ net354 VSS VSS VDD VDD _01831_ sky130_fd_sc_hd__a21oi_1
X_15802_ network.in_spk01_02 _09636_ VSS VSS VDD VDD _04694_
+ sky130_fd_sc_hd__nand2_1
X_15803_ _03702_ _04694_ net354 VSS VSS VDD VDD _01832_ sky130_fd_sc_hd__a21oi_1
X_15804_ network.in_spk00_02 _04671_ VSS VSS VDD VDD _04695_
+ sky130_fd_sc_hd__nand2_1
Xplace437 net437 VSS VSS VDD VDD net436 sky130_fd_sc_hd__buf_4
Xplace436 net436 VSS VSS VDD VDD net435 sky130_fd_sc_hd__buf_6
X_15807_ _03667_ _04695_ net354 VSS VSS VDD VDD _01833_ sky130_fd_sc_hd__a21oi_1
X_15808_ _09147_ _09298_ _09286_ VSS VSS VDD VDD _04698_ sky130_fd_sc_hd__nand3_1
X_15809_ network.in_spk12_01 network.in_spk13_01 network.in_spk14_01
+ _04698_ network.in_spk15_01 VSS VSS VDD VDD _04699_ sky130_fd_sc_hd__o41ai_1
X_15810_ _03663_ _04699_ net352 VSS VSS VDD VDD _01834_ sky130_fd_sc_hd__a21oi_1
X_15811_ network.in_spk12_01 network.in_spk13_01 _04698_ network.in_spk14_01
+ VSS VSS VDD VDD _04700_ sky130_fd_sc_hd__o31ai_1
X_15812_ _03635_ _04700_ net352 VSS VSS VDD VDD _01835_ sky130_fd_sc_hd__a21oi_1
X_15813_ network.in_spk12_01 _04698_ network.in_spk13_01 VSS
+ VSS VDD VDD _04701_ sky130_fd_sc_hd__o21ai_0
X_15814_ _07818_ _04701_ net352 VSS VSS VDD VDD _01836_ sky130_fd_sc_hd__a21oi_1
X_15815_ network.in_spk12_01 _04698_ VSS VSS VDD VDD _04702_
+ sky130_fd_sc_hd__nand2_1
X_15816_ _07805_ _04702_ net352 VSS VSS VDD VDD _01837_ sky130_fd_sc_hd__a21oi_1
X_15817_ network.neuron_in027.counter\[2\] VSS VSS VDD VDD
+ _04703_ sky130_fd_sc_hd__inv_1
X_15818_ _04703_ _00466_ VSS VSS VDD VDD _04704_ sky130_fd_sc_hd__nand2_1
X_15819_ network.neuron_in027.counter\[3\] _04704_ VSS VSS
+ VDD VDD _04705_ sky130_fd_sc_hd__or2_2
X_15820_ _09361_ _09306_ _09298_ VSS VSS VDD VDD _04706_ sky130_fd_sc_hd__nand3_1
X_15821_ network.in_spk08_01 network.in_spk09_01 network.in_spk10_01
+ _04706_ network.in_spk11_01 VSS VSS VDD VDD _04707_ sky130_fd_sc_hd__o41ai_1
X_15822_ _04705_ _04707_ net352 VSS VSS VDD VDD _01838_ sky130_fd_sc_hd__a21oi_1
X_15823_ network.in_spk08_01 network.in_spk09_01 _04706_ network.in_spk10_01
+ VSS VSS VDD VDD _04708_ sky130_fd_sc_hd__o31ai_1
X_15824_ _03657_ _04708_ net352 VSS VSS VDD VDD _01839_ sky130_fd_sc_hd__a21oi_1
X_15825_ network.in_spk08_01 _04706_ network.in_spk09_01 VSS
+ VSS VDD VDD _04709_ sky130_fd_sc_hd__o21ai_0
X_15826_ _03640_ _04709_ net352 VSS VSS VDD VDD _01840_ sky130_fd_sc_hd__a21oi_1
X_15827_ network.in_spk08_01 _04706_ VSS VSS VDD VDD _04710_
+ sky130_fd_sc_hd__nand2_1
X_15828_ _03620_ _04710_ net352 VSS VSS VDD VDD _01841_ sky130_fd_sc_hd__a21oi_1
X_15829_ _09149_ _09286_ VSS VSS VDD VDD _04711_ sky130_fd_sc_hd__nand2_1
X_15830_ network.in_spk04_01 network.in_spk05_01 network.in_spk06_01
+ _04711_ network.in_spk07_01 VSS VSS VDD VDD _04712_ sky130_fd_sc_hd__o41ai_1
X_15831_ _03611_ _04712_ net352 VSS VSS VDD VDD _01842_ sky130_fd_sc_hd__a21oi_1
X_15832_ network.in_spk04_01 network.in_spk05_01 _04711_ network.in_spk06_01
+ VSS VSS VDD VDD _04713_ sky130_fd_sc_hd__o31ai_1
Xplace440 net450 VSS VSS VDD VDD net439 sky130_fd_sc_hd__buf_4
X_15834_ _03601_ _04713_ net352 VSS VSS VDD VDD _01843_ sky130_fd_sc_hd__a21oi_1
X_15835_ network.in_spk04_01 _04711_ network.in_spk05_01 VSS
+ VSS VDD VDD _04715_ sky130_fd_sc_hd__o21ai_0
X_15836_ _03591_ _04715_ net352 VSS VSS VDD VDD _01844_ sky130_fd_sc_hd__a21oi_1
X_15837_ network.in_spk04_01 _04711_ VSS VSS VDD VDD _04716_
+ sky130_fd_sc_hd__nand2_1
X_15838_ _03581_ _04716_ net352 VSS VSS VDD VDD _01845_ sky130_fd_sc_hd__a21oi_1
X_15839_ _09294_ _09286_ VSS VSS VDD VDD _04717_ sky130_fd_sc_hd__nand2_1
X_15840_ network.in_spk02_01 _04717_ network.in_spk03_01 VSS
+ VSS VDD VDD _04718_ sky130_fd_sc_hd__o21ai_0
X_15841_ _03571_ _04718_ net350 VSS VSS VDD VDD _01846_ sky130_fd_sc_hd__a21oi_1
X_15842_ network.in_spk02_01 _04717_ VSS VSS VDD VDD _04719_
+ sky130_fd_sc_hd__nand2_1
X_15843_ _03562_ _04719_ net350 VSS VSS VDD VDD _01847_ sky130_fd_sc_hd__a21oi_1
X_15844_ network.in_spk00_01 _09146_ network.in_spk01_01 VSS
+ VSS VDD VDD _04720_ sky130_fd_sc_hd__o21ai_0
X_15845_ _03544_ _04720_ net350 VSS VSS VDD VDD _01848_ sky130_fd_sc_hd__a21oi_1
X_15846_ network.in_spk00_01 _09146_ VSS VSS VDD VDD _04721_
+ sky130_fd_sc_hd__nand2_1
X_15847_ _03553_ _04721_ net350 VSS VSS VDD VDD _01849_ sky130_fd_sc_hd__a21oi_1
X_15848_ network.in_spk12_00 network.in_spk13_00 _09670_ VSS
+ VSS VDD VDD _04722_ sky130_fd_sc_hd__or3_1
X_15849_ network.in_spk14_00 _04722_ network.in_spk15_00 VSS
+ VSS VDD VDD _04723_ sky130_fd_sc_hd__o21ai_0
X_15850_ _03529_ _04723_ net351 VSS VSS VDD VDD _01850_ sky130_fd_sc_hd__a21oi_1
X_15851_ network.in_spk14_00 _04722_ VSS VSS VDD VDD _04724_
+ sky130_fd_sc_hd__nand2_1
X_15852_ _03508_ _04724_ net351 VSS VSS VDD VDD _01851_ sky130_fd_sc_hd__a21oi_1
X_15853_ network.in_spk12_00 _09670_ network.in_spk13_00 VSS
+ VSS VDD VDD _04725_ sky130_fd_sc_hd__o21ai_0
X_15854_ _03512_ _04725_ net351 VSS VSS VDD VDD _01852_ sky130_fd_sc_hd__a21oi_1
X_15855_ network.in_spk12_00 _09670_ VSS VSS VDD VDD _04726_
+ sky130_fd_sc_hd__nand2_1
Xplace434 net434 VSS VSS VDD VDD net433 sky130_fd_sc_hd__buf_4
X_15857_ _03492_ _04726_ net351 VSS VSS VDD VDD _01853_ sky130_fd_sc_hd__a21oi_1
X_15858_ network.in_spk10_00 _09504_ network.in_spk11_00 VSS
+ VSS VDD VDD _04728_ sky130_fd_sc_hd__o21ai_0
X_15859_ _03483_ _04728_ net350 VSS VSS VDD VDD _01854_ sky130_fd_sc_hd__a21oi_1
X_15860_ network.in_spk10_00 _09504_ VSS VSS VDD VDD _04729_
+ sky130_fd_sc_hd__nand2_1
X_15861_ _03472_ _04729_ net350 VSS VSS VDD VDD _01855_ sky130_fd_sc_hd__a21oi_1
X_15862_ network.in_spk08_00 _09293_ network.in_spk09_00 VSS
+ VSS VDD VDD _04730_ sky130_fd_sc_hd__o21ai_0
X_15863_ _03463_ _04730_ net350 VSS VSS VDD VDD _01856_ sky130_fd_sc_hd__a21oi_1
X_15864_ network.in_spk08_00 _09293_ VSS VSS VDD VDD _04731_
+ sky130_fd_sc_hd__nand2_1
X_15865_ _08578_ _04731_ net350 VSS VSS VDD VDD _01857_ sky130_fd_sc_hd__a21oi_1
X_15866_ _09669_ network.in_spk07_00 VSS VSS VDD VDD _04732_
+ sky130_fd_sc_hd__nand2b_1
X_15867_ _08572_ _04732_ net351 VSS VSS VDD VDD _01858_ sky130_fd_sc_hd__a21oi_1
X_15868_ network.in_spk04_00 network.in_spk05_00 _09668_ network.in_spk06_00
+ VSS VSS VDD VDD _04733_ sky130_fd_sc_hd__o31ai_1
X_15869_ _08548_ _04733_ net351 VSS VSS VDD VDD _01859_ sky130_fd_sc_hd__a21oi_1
X_15870_ network.in_spk04_00 _09668_ network.in_spk05_00 VSS
+ VSS VDD VDD _04734_ sky130_fd_sc_hd__o21ai_0
X_15871_ _08557_ _04734_ net351 VSS VSS VDD VDD _01860_ sky130_fd_sc_hd__a21oi_1
X_15872_ network.in_spk04_00 _09668_ VSS VSS VDD VDD _04735_
+ sky130_fd_sc_hd__nand2_1
X_15873_ _08540_ _04735_ net351 VSS VSS VDD VDD _01861_ sky130_fd_sc_hd__a21oi_1
X_15874_ network.in_spk00_00 network.in_spk01_00 network.in_spk02_00
+ network.in_spk03_00 VSS VSS VDD VDD _04736_ sky130_fd_sc_hd__o31ai_1
X_15875_ _08501_ _04736_ net351 VSS VSS VDD VDD _01862_ sky130_fd_sc_hd__a21oi_1
X_15876_ network.in_spk00_00 network.in_spk01_00 network.in_spk02_00
+ VSS VSS VDD VDD _04737_ sky130_fd_sc_hd__o21ai_0
Xplace432 net433 VSS VSS VDD VDD net431 sky130_fd_sc_hd__buf_4
X_15878_ _08516_ _04737_ net351 VSS VSS VDD VDD _01863_ sky130_fd_sc_hd__a21oi_1
X_15879_ network.in_spk00_00 network.in_spk01_00 VSS VSS VDD
+ VDD _04739_ sky130_fd_sc_hd__nand2_1
X_15880_ _08525_ _04739_ net351 VSS VSS VDD VDD _01864_ sky130_fd_sc_hd__a21oi_1
X_15881_ net351 _08520_ VSS VSS VDD VDD _01865_ sky130_fd_sc_hd__nor2_1
X_15882_ _08728_ _03760_ VSS VSS VDD VDD _04740_ sky130_fd_sc_hd__nor2_1
X_15883_ network.cnt_main.counter\[13\] _04740_ VSS VSS VDD
+ VDD _04741_ sky130_fd_sc_hd__xnor2_1
X_15884_ _03752_ _04741_ VSS VSS VDD VDD _01866_ sky130_fd_sc_hd__nor2_1
Xplace431 net434 VSS VSS VDD VDD net430 sky130_fd_sc_hd__buf_4
Xplace430 net434 VSS VSS VDD VDD net429 sky130_fd_sc_hd__buf_4
X_15887_ _08315_ net283 VSS VSS VDD VDD _01249_ sky130_fd_sc_hd__nand2_1
X_15888_ _08310_ net280 VSS VSS VDD VDD _01250_ sky130_fd_sc_hd__nand2_1
Xplace429 net456 VSS VSS VDD VDD net428 sky130_fd_sc_hd__buf_4
X_15890_ _08305_ net280 VSS VSS VDD VDD _01251_ sky130_fd_sc_hd__nand2_1
X_15891_ _08301_ net280 VSS VSS VDD VDD _01252_ sky130_fd_sc_hd__nand2_1
X_15892_ _08295_ net283 VSS VSS VDD VDD _01253_ sky130_fd_sc_hd__nand2_1
X_15893_ _08290_ net280 VSS VSS VDD VDD _01254_ sky130_fd_sc_hd__nand2_1
X_15894_ _08142_ net283 VSS VSS VDD VDD _01255_ sky130_fd_sc_hd__nand2_1
X_15895_ _08138_ net283 VSS VSS VDD VDD _01256_ sky130_fd_sc_hd__nand2_1
X_15896_ _08134_ net283 VSS VSS VDD VDD _01257_ sky130_fd_sc_hd__nand2_1
X_15897_ _08130_ net280 VSS VSS VDD VDD _01258_ sky130_fd_sc_hd__nand2_1
X_15898_ _08115_ net280 VSS VSS VDD VDD _01259_ sky130_fd_sc_hd__nand2_1
X_15899_ _07833_ net283 VSS VSS VDD VDD _01260_ sky130_fd_sc_hd__nand2_1
Xplace433 net433 VSS VSS VDD VDD net432 sky130_fd_sc_hd__buf_4
X_15901_ _07685_ net280 VSS VSS VDD VDD _01261_ sky130_fd_sc_hd__nand2_1
X_15902_ _07703_ net282 VSS VSS VDD VDD _01262_ sky130_fd_sc_hd__nand2_1
X_15903_ _07698_ net282 VSS VSS VDD VDD _01263_ sky130_fd_sc_hd__nand2_1
X_15904_ _07653_ net280 VSS VSS VDD VDD _01264_ sky130_fd_sc_hd__nand2_1
X_15905_ _07648_ net283 VSS VSS VDD VDD _01265_ sky130_fd_sc_hd__nand2_1
X_15906_ _07643_ net283 VSS VSS VDD VDD _01266_ sky130_fd_sc_hd__nand2_1
X_15907_ _07638_ net281 VSS VSS VDD VDD _01267_ sky130_fd_sc_hd__nand2_1
X_15908_ _07505_ net283 VSS VSS VDD VDD _01268_ sky130_fd_sc_hd__nand2_1
X_15909_ _07419_ net283 VSS VSS VDD VDD _01269_ sky130_fd_sc_hd__nand2_1
X_15910_ _07414_ net283 VSS VSS VDD VDD _01270_ sky130_fd_sc_hd__nand2_1
Xplace422 net425 VSS VSS VDD VDD net421 sky130_fd_sc_hd__buf_4
X_15912_ _07238_ net281 VSS VSS VDD VDD _01271_ sky130_fd_sc_hd__nand2_1
X_15913_ _07410_ net281 VSS VSS VDD VDD _01272_ sky130_fd_sc_hd__nand2_1
X_15914_ _07233_ net281 VSS VSS VDD VDD _01273_ sky130_fd_sc_hd__nand2_1
X_15915_ _07514_ net283 VSS VSS VDD VDD _01274_ sky130_fd_sc_hd__nand2_1
X_15916_ _07509_ net282 VSS VSS VDD VDD _01275_ sky130_fd_sc_hd__nand2_1
X_15917_ _07123_ net281 VSS VSS VDD VDD _01276_ sky130_fd_sc_hd__nand2_1
X_15918_ _07215_ net281 VSS VSS VDD VDD _01277_ sky130_fd_sc_hd__nand2_1
X_15919_ _07205_ net281 VSS VSS VDD VDD _01278_ sky130_fd_sc_hd__nand2_1
X_15920_ _07161_ net281 VSS VSS VDD VDD _01279_ sky130_fd_sc_hd__nand2_1
X_15921_ _07192_ net281 VSS VSS VDD VDD _01280_ sky130_fd_sc_hd__nand2_1
Xplace415 net415 VSS VSS VDD VDD net414 sky130_fd_sc_hd__buf_4
X_15923_ _07133_ net280 VSS VSS VDD VDD _01281_ sky130_fd_sc_hd__nand2_1
X_15924_ _07151_ net280 VSS VSS VDD VDD _01282_ sky130_fd_sc_hd__nand2_1
X_15925_ _07128_ net280 VSS VSS VDD VDD _01283_ sky130_fd_sc_hd__nand2_1
X_15926_ _07177_ net280 VSS VSS VDD VDD _01284_ sky130_fd_sc_hd__nand2_1
X_15927_ _07172_ net280 VSS VSS VDD VDD _01285_ sky130_fd_sc_hd__nand2_1
X_15928_ _07015_ net280 VSS VSS VDD VDD _01286_ sky130_fd_sc_hd__nand2_1
X_15929_ _07109_ net280 VSS VSS VDD VDD _01287_ sky130_fd_sc_hd__nand2_1
X_15930_ _07104_ net280 VSS VSS VDD VDD _01288_ sky130_fd_sc_hd__nand2_1
X_15931_ _07059_ net280 VSS VSS VDD VDD _01289_ sky130_fd_sc_hd__nand2_1
X_15932_ _07098_ net280 VSS VSS VDD VDD _01290_ sky130_fd_sc_hd__nand2_1
Xplace426 net458 VSS VSS VDD VDD net425 sky130_fd_sc_hd__buf_6
X_15934_ _07025_ net280 VSS VSS VDD VDD _01291_ sky130_fd_sc_hd__nand2_1
X_15935_ _07049_ net280 VSS VSS VDD VDD _01292_ sky130_fd_sc_hd__nand2_1
X_15936_ _07020_ net280 VSS VSS VDD VDD _01293_ sky130_fd_sc_hd__nand2_1
X_15937_ _07084_ net280 VSS VSS VDD VDD _01294_ sky130_fd_sc_hd__nand2_1
X_15938_ _07075_ net280 VSS VSS VDD VDD _01295_ sky130_fd_sc_hd__nand2_1
X_15939_ _06877_ net280 VSS VSS VDD VDD _01296_ sky130_fd_sc_hd__nand2_1
X_15940_ _06999_ net280 VSS VSS VDD VDD _01297_ sky130_fd_sc_hd__nand2_1
X_15941_ _06891_ net283 VSS VSS VDD VDD _01298_ sky130_fd_sc_hd__nand2_1
X_15942_ _06986_ net283 VSS VSS VDD VDD _01299_ sky130_fd_sc_hd__nand2_1
X_15943_ _06981_ net283 VSS VSS VDD VDD _01300_ sky130_fd_sc_hd__nand2_1
Xplace414 loaded\[6\] VSS VSS VDD VDD net413 sky130_fd_sc_hd__buf_4
X_15945_ _06886_ net283 VSS VSS VDD VDD _01301_ sky130_fd_sc_hd__nand2_1
X_15946_ _06906_ net283 VSS VSS VDD VDD _01302_ sky130_fd_sc_hd__nand2_1
X_15947_ _06882_ net279 VSS VSS VDD VDD _01303_ sky130_fd_sc_hd__nand2_1
X_15948_ _06967_ net279 VSS VSS VDD VDD _01304_ sky130_fd_sc_hd__nand2_1
X_15949_ _06930_ net279 VSS VSS VDD VDD _01305_ sky130_fd_sc_hd__nand2_1
X_15950_ _06763_ net283 VSS VSS VDD VDD _01306_ sky130_fd_sc_hd__nand2_1
X_15951_ _06863_ net279 VSS VSS VDD VDD _01307_ sky130_fd_sc_hd__nand2_1
X_15952_ _06777_ net279 VSS VSS VDD VDD _01308_ sky130_fd_sc_hd__nand2_1
X_15953_ _06852_ net279 VSS VSS VDD VDD _01309_ sky130_fd_sc_hd__nand2_1
X_15954_ _06847_ net279 VSS VSS VDD VDD _01310_ sky130_fd_sc_hd__nand2_1
Xplace413 _08635_ VSS VSS VDD VDD net412 sky130_fd_sc_hd__buf_4
X_15956_ _06773_ net279 VSS VSS VDD VDD _01311_ sky130_fd_sc_hd__nand2_1
X_15957_ _06791_ net279 VSS VSS VDD VDD _01312_ sky130_fd_sc_hd__nand2_1
X_15958_ _06768_ net280 VSS VSS VDD VDD _01313_ sky130_fd_sc_hd__nand2_1
X_15959_ _06828_ net280 VSS VSS VDD VDD _01314_ sky130_fd_sc_hd__nand2_1
X_15960_ _06823_ net280 VSS VSS VDD VDD _01315_ sky130_fd_sc_hd__nand2_1
X_15961_ _06658_ net280 VSS VSS VDD VDD _01316_ sky130_fd_sc_hd__nand2_1
X_15962_ _06707_ net280 VSS VSS VDD VDD _01317_ sky130_fd_sc_hd__nand2_1
X_15963_ _06673_ net280 VSS VSS VDD VDD _01318_ sky130_fd_sc_hd__nand2_1
X_15964_ _06744_ net280 VSS VSS VDD VDD _01319_ sky130_fd_sc_hd__nand2_1
X_15965_ _06739_ net280 VSS VSS VDD VDD _01320_ sky130_fd_sc_hd__nand2_1
Xplace425 net425 VSS VSS VDD VDD net424 sky130_fd_sc_hd__buf_4
X_15967_ _06667_ net280 VSS VSS VDD VDD _01321_ sky130_fd_sc_hd__nand2_1
X_15968_ _06691_ net280 VSS VSS VDD VDD _01322_ sky130_fd_sc_hd__nand2_1
X_15969_ _06662_ net280 VSS VSS VDD VDD _01323_ sky130_fd_sc_hd__nand2_1
X_15970_ _06721_ net280 VSS VSS VDD VDD _01324_ sky130_fd_sc_hd__nand2_1
X_15971_ _06716_ net280 VSS VSS VDD VDD _01325_ sky130_fd_sc_hd__nand2_1
X_15972_ network.neuron_in178.counter\[3\] _00271_ VSS VSS
+ VDD VDD _04752_ sky130_fd_sc_hd__nand2b_1
X_15973_ _04752_ _06799_ VSS VSS VDD VDD _04753_ sky130_fd_sc_hd__nand2b_1
X_15974_ net280 _04753_ VSS VSS VDD VDD _01326_ sky130_fd_sc_hd__nand2_1
X_15975_ _07710_ net280 VSS VSS VDD VDD _01327_ sky130_fd_sc_hd__nand2_1
X_15976_ _07763_ net280 VSS VSS VDD VDD _01328_ sky130_fd_sc_hd__nand2_1
X_15977_ _07758_ net282 VSS VSS VDD VDD _01329_ sky130_fd_sc_hd__nand2_1
X_15978_ _07729_ net283 VSS VSS VDD VDD _01330_ sky130_fd_sc_hd__nand2_1
X_15979_ _07752_ net283 VSS VSS VDD VDD _01331_ sky130_fd_sc_hd__nand2_1
Xplace412 network.neuron_hid0.ROM0.address\[0\] VSS VSS VDD
+ VDD net411 sky130_fd_sc_hd__buf_4
X_15981_ _07715_ net282 VSS VSS VDD VDD _01332_ sky130_fd_sc_hd__nand2_1
X_15982_ _07748_ net282 VSS VSS VDD VDD _01333_ sky130_fd_sc_hd__nand2_1
X_15983_ _07743_ net282 VSS VSS VDD VDD _01334_ sky130_fd_sc_hd__nand2_1
X_15984_ _07721_ net282 VSS VSS VDD VDD _01335_ sky130_fd_sc_hd__nand2_1
X_15985_ _07738_ net282 VSS VSS VDD VDD _01336_ sky130_fd_sc_hd__nand2_1
X_15986_ _07768_ net280 VSS VSS VDD VDD _01337_ sky130_fd_sc_hd__nand2_1
X_15987_ net280 _03825_ VSS VSS VDD VDD _01338_ sky130_fd_sc_hd__nand2_1
X_15988_ net280 _03815_ VSS VSS VDD VDD _01339_ sky130_fd_sc_hd__nand2_1
X_15989_ net280 _03805_ VSS VSS VDD VDD _01340_ sky130_fd_sc_hd__nand2_1
X_15990_ net283 _03793_ VSS VSS VDD VDD _01341_ sky130_fd_sc_hd__nand2_1
X_15991_ _06638_ net280 VSS VSS VDD VDD _01342_ sky130_fd_sc_hd__nand2_1
X_15992_ _06633_ net280 VSS VSS VDD VDD _01343_ sky130_fd_sc_hd__nand2_1
X_15993_ _06629_ net283 VSS VSS VDD VDD _01344_ sky130_fd_sc_hd__nand2_1
X_15994_ _06618_ net282 VSS VSS VDD VDD _01345_ sky130_fd_sc_hd__nand2_1
Xplace411 network.neuron_hid0.ROM0.address\[0\] VSS VSS VDD
+ VDD net410 sky130_fd_sc_hd__buf_4
X_15996_ network.neuron_in158.counter\[3\] _00671_ VSS VSS
+ VDD VDD _04756_ sky130_fd_sc_hd__nand2b_1
X_15997_ network.neuron_in158.counter\[2\] VSS VSS VDD VDD
+ _04757_ sky130_fd_sc_hd__inv_1
X_15998_ _04756_ _04757_ VSS VSS VDD VDD _04758_ sky130_fd_sc_hd__nand2b_1
X_15999_ net282 _04758_ VSS VSS VDD VDD _01346_ sky130_fd_sc_hd__nand2_1
Xplace409 network.neuron_hid0.ROM0.address\[1\] VSS VSS VDD
+ VDD net408 sky130_fd_sc_hd__buf_4
X_16001_ _06962_ net282 VSS VSS VDD VDD _01347_ sky130_fd_sc_hd__nand2_1
X_16002_ _07518_ net282 VSS VSS VDD VDD _01348_ sky130_fd_sc_hd__nand2_1
X_16003_ _06944_ net281 VSS VSS VDD VDD _01349_ sky130_fd_sc_hd__nand2_1
X_16004_ _07829_ net281 VSS VSS VDD VDD _01350_ sky130_fd_sc_hd__nand2_1
X_16005_ network.neuron_in153.counter\[3\] _00494_ VSS VSS
+ VDD VDD _04760_ sky130_fd_sc_hd__nand2b_1
X_16006_ network.neuron_in153.counter\[2\] VSS VSS VDD VDD
+ _04761_ sky130_fd_sc_hd__inv_1
X_16007_ _04760_ _04761_ VSS VSS VDD VDD _04762_ sky130_fd_sc_hd__nand2b_1
X_16008_ net282 _04762_ VSS VSS VDD VDD _01351_ sky130_fd_sc_hd__nand2_1
X_16009_ network.neuron_in152.counter\[3\] _00502_ VSS VSS
+ VDD VDD _04763_ sky130_fd_sc_hd__nand2b_1
X_16010_ network.neuron_in152.counter\[2\] VSS VSS VDD VDD
+ _04764_ sky130_fd_sc_hd__inv_1
X_16011_ _04763_ _04764_ VSS VSS VDD VDD _04765_ sky130_fd_sc_hd__nand2b_1
X_16012_ net281 _04765_ VSS VSS VDD VDD _01352_ sky130_fd_sc_hd__nand2_1
X_16013_ network.neuron_in151.counter\[2\] network.neuron_in151.counter\[3\]
+ VSS VSS VDD VDD _04766_ sky130_fd_sc_hd__nor2_1
X_16014_ _00506_ _04766_ VSS VSS VDD VDD _04767_ sky130_fd_sc_hd__nand2_1
X_16015_ net282 _04767_ VSS VSS VDD VDD _01353_ sky130_fd_sc_hd__nand2_1
X_16016_ _08268_ net282 VSS VSS VDD VDD _01354_ sky130_fd_sc_hd__nand2_1
X_16017_ net281 _04348_ VSS VSS VDD VDD _01355_ sky130_fd_sc_hd__nand2_1
X_16018_ _06952_ net281 VSS VSS VDD VDD _01356_ sky130_fd_sc_hd__nand2_1
X_16019_ net282 _03853_ VSS VSS VDD VDD _01357_ sky130_fd_sc_hd__nand2_1
X_16020_ _06858_ net281 VSS VSS VDD VDD _01358_ sky130_fd_sc_hd__nand2_1
X_16021_ net281 _03876_ VSS VSS VDD VDD _01359_ sky130_fd_sc_hd__nand2_1
X_16022_ _06939_ net281 VSS VSS VDD VDD _01360_ sky130_fd_sc_hd__nand2_1
X_16023_ _06956_ net282 VSS VSS VDD VDD _01361_ sky130_fd_sc_hd__nand2_1
X_16024_ _06991_ net282 VSS VSS VDD VDD _01362_ sky130_fd_sc_hd__nand2_1
Xplace416 net417 VSS VSS VDD VDD net415 sky130_fd_sc_hd__buf_6
X_16026_ _07080_ net282 VSS VSS VDD VDD _01363_ sky130_fd_sc_hd__nand2_1
X_16027_ _07824_ net282 VSS VSS VDD VDD _01364_ sky130_fd_sc_hd__nand2_1
X_16028_ _08340_ net282 VSS VSS VDD VDD _01365_ sky130_fd_sc_hd__nand2_1
X_16029_ _03535_ net282 VSS VSS VDD VDD _01366_ sky130_fd_sc_hd__nand2_1
X_16030_ _03502_ net282 VSS VSS VDD VDD _01367_ sky130_fd_sc_hd__nand2_1
X_16031_ _06683_ net282 VSS VSS VDD VDD _01368_ sky130_fd_sc_hd__nand2_1
X_16032_ _08121_ net282 VSS VSS VDD VDD _01369_ sky130_fd_sc_hd__nand2_1
X_16033_ _07200_ net282 VSS VSS VDD VDD _01370_ sky130_fd_sc_hd__nand2_1
X_16034_ _07036_ net282 VSS VSS VDD VDD _01371_ sky130_fd_sc_hd__nand2_1
X_16035_ net282 _04017_ VSS VSS VDD VDD _01372_ sky130_fd_sc_hd__nand2_1
X_16036_ _03687_ net282 VSS VSS VDD VDD _01373_ sky130_fd_sc_hd__nand2_1
Xplace423 net423 VSS VSS VDD VDD net422 sky130_fd_sc_hd__buf_4
X_16038_ _03626_ net282 VSS VSS VDD VDD _01374_ sky130_fd_sc_hd__nand2_1
X_16039_ _06842_ net281 VSS VSS VDD VDD _01375_ sky130_fd_sc_hd__nand2_1
X_16040_ _07210_ net282 VSS VSS VDD VDD _01376_ sky130_fd_sc_hd__nand2_1
X_16041_ network.neuron_in127.counter\[2\] VSS VSS VDD VDD
+ _04770_ sky130_fd_sc_hd__inv_1
X_16042_ _04770_ _01107_ VSS VSS VDD VDD _04771_ sky130_fd_sc_hd__nand2_1
X_16043_ network.neuron_in127.counter\[3\] _04771_ VSS VSS
+ VDD VDD _04772_ sky130_fd_sc_hd__or2_2
X_16044_ net281 _04772_ VSS VSS VDD VDD _01377_ sky130_fd_sc_hd__nand2_1
X_16045_ network.neuron_in126.counter\[2\] VSS VSS VDD VDD
+ _04773_ sky130_fd_sc_hd__inv_1
X_16046_ _04773_ _00725_ VSS VSS VDD VDD _04774_ sky130_fd_sc_hd__nand2_1
X_16047_ network.neuron_in126.counter\[3\] _04774_ VSS VSS
+ VDD VDD _04775_ sky130_fd_sc_hd__or2_2
X_16048_ net281 _04775_ VSS VSS VDD VDD _01378_ sky130_fd_sc_hd__nand2_1
Xplace410 network.neuron_hid0.ROM0.address\[1\] VSS VSS VDD
+ VDD net409 sky130_fd_sc_hd__buf_4
X_16050_ network.neuron_in125.counter\[2\] VSS VSS VDD VDD
+ _04777_ sky130_fd_sc_hd__inv_1
X_16051_ network.neuron_in125.counter\[3\] VSS VSS VDD VDD
+ _04778_ sky130_fd_sc_hd__inv_1
X_16052_ _04777_ _00486_ _04778_ VSS VSS VDD VDD _04779_ sky130_fd_sc_hd__nand3_1
X_16053_ net281 _04779_ VSS VSS VDD VDD _01379_ sky130_fd_sc_hd__nand2_1
X_16054_ network.neuron_in124.counter\[3\] _00367_ VSS VSS
+ VDD VDD _04780_ sky130_fd_sc_hd__nand2b_1
X_16055_ network.neuron_in124.counter\[2\] VSS VSS VDD VDD
+ _04781_ sky130_fd_sc_hd__inv_1
X_16056_ _04780_ _04781_ VSS VSS VDD VDD _04782_ sky130_fd_sc_hd__nand2b_1
X_16057_ net281 _04782_ VSS VSS VDD VDD _01380_ sky130_fd_sc_hd__nand2_1
X_16058_ network.neuron_in123.counter\[2\] VSS VSS VDD VDD
+ _04783_ sky130_fd_sc_hd__inv_1
X_16059_ _04783_ _00207_ VSS VSS VDD VDD _04784_ sky130_fd_sc_hd__nand2_1
X_16060_ network.neuron_in123.counter\[3\] _04784_ VSS VSS
+ VDD VDD _04785_ sky130_fd_sc_hd__or2_2
X_16061_ net282 _04785_ VSS VSS VDD VDD _01381_ sky130_fd_sc_hd__nand2_1
X_16062_ network.neuron_in122.counter\[2\] network.neuron_in122.counter\[3\]
+ VSS VSS VDD VDD _04786_ sky130_fd_sc_hd__nor2_1
X_16063_ _01060_ _04786_ VSS VSS VDD VDD _04787_ sky130_fd_sc_hd__nand2_1
X_16064_ net277 _04787_ VSS VSS VDD VDD _01382_ sky130_fd_sc_hd__nand2_1
X_16065_ network.neuron_in121.counter\[2\] network.neuron_in121.counter\[3\]
+ VSS VSS VDD VDD _04788_ sky130_fd_sc_hd__nor2_1
X_16066_ _00295_ _04788_ VSS VSS VDD VDD _04789_ sky130_fd_sc_hd__nand2_1
X_16067_ net281 _04789_ VSS VSS VDD VDD _01383_ sky130_fd_sc_hd__nand2_1
X_16068_ network.neuron_in120.counter\[3\] _00964_ VSS VSS
+ VDD VDD _04790_ sky130_fd_sc_hd__nand2b_1
X_16069_ network.neuron_in120.counter\[2\] VSS VSS VDD VDD
+ _04791_ sky130_fd_sc_hd__inv_1
X_16070_ _04790_ _04791_ VSS VSS VDD VDD _04792_ sky130_fd_sc_hd__nand2b_1
X_16071_ net277 _04792_ VSS VSS VDD VDD _01384_ sky130_fd_sc_hd__nand2_1
X_16072_ network.neuron_in119.counter\[2\] network.neuron_in119.counter\[3\]
+ _00602_ VSS VSS VDD VDD _04793_ sky130_fd_sc_hd__or3b_2
X_16073_ net277 _04793_ VSS VSS VDD VDD _01385_ sky130_fd_sc_hd__nand2_1
X_16074_ network.neuron_in118.counter\[2\] network.neuron_in118.counter\[3\]
+ VSS VSS VDD VDD _04794_ sky130_fd_sc_hd__nor2_1
X_16075_ _00108_ _04794_ VSS VSS VDD VDD _04795_ sky130_fd_sc_hd__nand2_1
X_16076_ net281 _04795_ VSS VSS VDD VDD _01386_ sky130_fd_sc_hd__nand2_1
X_16077_ network.neuron_in117.counter\[2\] network.neuron_in117.counter\[3\]
+ VSS VSS VDD VDD _04796_ sky130_fd_sc_hd__nor2_1
X_16078_ _00071_ _04796_ VSS VSS VDD VDD _04797_ sky130_fd_sc_hd__nand2_1
X_16079_ net277 _04797_ VSS VSS VDD VDD _01387_ sky130_fd_sc_hd__nand2_1
X_16080_ network.neuron_in116.counter\[2\] VSS VSS VDD VDD
+ _04798_ sky130_fd_sc_hd__inv_1
X_16081_ _04798_ _00092_ VSS VSS VDD VDD _04799_ sky130_fd_sc_hd__nand2_1
X_16082_ network.neuron_in116.counter\[3\] _04799_ VSS VSS
+ VDD VDD _04800_ sky130_fd_sc_hd__or2_2
X_16083_ net277 _04800_ VSS VSS VDD VDD _01388_ sky130_fd_sc_hd__nand2_1
Xplace406 net406 VSS VSS VDD VDD net405 sky130_fd_sc_hd__buf_4
X_16085_ network.neuron_in115.counter\[3\] _01224_ VSS VSS
+ VDD VDD _04802_ sky130_fd_sc_hd__nand2b_1
X_16086_ network.neuron_in115.counter\[2\] VSS VSS VDD VDD
+ _04803_ sky130_fd_sc_hd__inv_1
X_16087_ _04802_ _04803_ VSS VSS VDD VDD _04804_ sky130_fd_sc_hd__nand2b_1
X_16088_ net281 _04804_ VSS VSS VDD VDD _01389_ sky130_fd_sc_hd__nand2_1
X_16089_ network.neuron_in114.counter\[2\] network.neuron_in114.counter\[3\]
+ VSS VSS VDD VDD _04805_ sky130_fd_sc_hd__nor2_1
X_16090_ _00079_ _04805_ VSS VSS VDD VDD _04806_ sky130_fd_sc_hd__nand2_1
X_16091_ net281 _04806_ VSS VSS VDD VDD _01390_ sky130_fd_sc_hd__nand2_1
X_16092_ network.neuron_in113.counter\[3\] _01091_ VSS VSS
+ VDD VDD _04807_ sky130_fd_sc_hd__nand2b_1
X_16093_ network.neuron_in113.counter\[2\] VSS VSS VDD VDD
+ _04808_ sky130_fd_sc_hd__inv_1
X_16094_ _04807_ _04808_ VSS VSS VDD VDD _04809_ sky130_fd_sc_hd__nand2b_1
X_16095_ net281 _04809_ VSS VSS VDD VDD _01391_ sky130_fd_sc_hd__nand2_1
X_16096_ network.neuron_in112.counter\[3\] _00747_ VSS VSS
+ VDD VDD _04810_ sky130_fd_sc_hd__nand2b_1
X_16097_ network.neuron_in112.counter\[2\] VSS VSS VDD VDD
+ _04811_ sky130_fd_sc_hd__inv_1
X_16098_ _04810_ _04811_ VSS VSS VDD VDD _04812_ sky130_fd_sc_hd__nand2b_1
X_16099_ net277 _04812_ VSS VSS VDD VDD _01392_ sky130_fd_sc_hd__nand2_1
X_16100_ network.neuron_in111.counter\[2\] VSS VSS VDD VDD
+ _04813_ sky130_fd_sc_hd__inv_1
X_16101_ _04813_ _00606_ VSS VSS VDD VDD _04814_ sky130_fd_sc_hd__nand2_1
X_16102_ network.neuron_in111.counter\[3\] _04814_ VSS VSS
+ VDD VDD _04815_ sky130_fd_sc_hd__or2_2
X_16103_ net277 _04815_ VSS VSS VDD VDD _01393_ sky130_fd_sc_hd__nand2_1
X_16104_ network.neuron_in110.counter\[2\] network.neuron_in110.counter\[3\]
+ VSS VSS VDD VDD _04816_ sky130_fd_sc_hd__nor2_1
X_16105_ _00549_ _04816_ VSS VSS VDD VDD _04817_ sky130_fd_sc_hd__nand2_1
X_16106_ net277 _04817_ VSS VSS VDD VDD _01394_ sky130_fd_sc_hd__nand2_1
X_16107_ network.neuron_in109.counter\[2\] network.neuron_in109.counter\[3\]
+ VSS VSS VDD VDD _04818_ sky130_fd_sc_hd__nor2_1
X_16108_ _00553_ _04818_ VSS VSS VDD VDD _04819_ sky130_fd_sc_hd__nand2_1
X_16109_ net277 _04819_ VSS VSS VDD VDD _01395_ sky130_fd_sc_hd__nand2_1
X_16110_ network.neuron_in108.counter\[2\] VSS VSS VDD VDD
+ _04820_ sky130_fd_sc_hd__inv_1
X_16111_ _04820_ _01156_ VSS VSS VDD VDD _04821_ sky130_fd_sc_hd__nand2_1
X_16112_ network.neuron_in108.counter\[3\] _04821_ VSS VSS
+ VDD VDD _04822_ sky130_fd_sc_hd__or2_2
X_16113_ net277 _04822_ VSS VSS VDD VDD _01396_ sky130_fd_sc_hd__nand2_1
X_16114_ network.neuron_in107.counter\[2\] network.neuron_in107.counter\[3\]
+ VSS VSS VDD VDD _04823_ sky130_fd_sc_hd__nor2_1
X_16115_ _00751_ _04823_ VSS VSS VDD VDD _04824_ sky130_fd_sc_hd__nand2_1
X_16116_ net277 _04824_ VSS VSS VDD VDD _01397_ sky130_fd_sc_hd__nand2_1
X_16117_ network.neuron_in106.counter\[3\] _00650_ VSS VSS
+ VDD VDD _04825_ sky130_fd_sc_hd__nand2b_1
X_16118_ network.neuron_in106.counter\[2\] VSS VSS VDD VDD
+ _04826_ sky130_fd_sc_hd__inv_1
X_16119_ _04825_ _04826_ VSS VSS VDD VDD _04827_ sky130_fd_sc_hd__nand2b_1
X_16120_ net277 _04827_ VSS VSS VDD VDD _01398_ sky130_fd_sc_hd__nand2_1
Xplace405 net405 VSS VSS VDD VDD net404 sky130_fd_sc_hd__buf_4
X_16122_ network.neuron_in105.counter\[3\] _00498_ VSS VSS
+ VDD VDD _04829_ sky130_fd_sc_hd__nand2b_1
X_16123_ network.neuron_in105.counter\[2\] VSS VSS VDD VDD
+ _04830_ sky130_fd_sc_hd__inv_1
X_16124_ _04829_ _04830_ VSS VSS VDD VDD _04831_ sky130_fd_sc_hd__nand2b_1
X_16125_ net277 _04831_ VSS VSS VDD VDD _01399_ sky130_fd_sc_hd__nand2_1
X_16126_ network.neuron_in104.counter\[3\] _00531_ VSS VSS
+ VDD VDD _04832_ sky130_fd_sc_hd__nand2b_1
X_16127_ network.neuron_in104.counter\[2\] VSS VSS VDD VDD
+ _04833_ sky130_fd_sc_hd__inv_1
X_16128_ _04832_ _04833_ VSS VSS VDD VDD _04834_ sky130_fd_sc_hd__nand2b_1
X_16129_ net277 _04834_ VSS VSS VDD VDD _01400_ sky130_fd_sc_hd__nand2_1
X_16130_ network.neuron_in103.counter\[3\] _00215_ VSS VSS
+ VDD VDD _04835_ sky130_fd_sc_hd__nand2b_1
X_16131_ network.neuron_in103.counter\[2\] VSS VSS VDD VDD
+ _04836_ sky130_fd_sc_hd__inv_1
X_16132_ _04835_ _04836_ VSS VSS VDD VDD _04837_ sky130_fd_sc_hd__nand2b_1
X_16133_ net277 _04837_ VSS VSS VDD VDD _01401_ sky130_fd_sc_hd__nand2_1
X_16134_ network.neuron_in102.counter\[2\] VSS VSS VDD VDD
+ _04838_ sky130_fd_sc_hd__inv_1
X_16135_ _04838_ _00771_ VSS VSS VDD VDD _04839_ sky130_fd_sc_hd__nand2_1
X_16136_ network.neuron_in102.counter\[3\] _04839_ VSS VSS
+ VDD VDD _04840_ sky130_fd_sc_hd__or2_2
X_16137_ net277 _04840_ VSS VSS VDD VDD _01402_ sky130_fd_sc_hd__nand2_1
X_16138_ network.neuron_in101.counter\[2\] network.neuron_in101.counter\[3\]
+ VSS VSS VDD VDD _04841_ sky130_fd_sc_hd__nor2_1
X_16139_ _00835_ _04841_ VSS VSS VDD VDD _04842_ sky130_fd_sc_hd__nand2_1
X_16140_ net277 _04842_ VSS VSS VDD VDD _01403_ sky130_fd_sc_hd__nand2_1
X_16141_ network.neuron_in100.counter\[2\] VSS VSS VDD VDD
+ _04843_ sky130_fd_sc_hd__inv_1
X_16142_ _04843_ _00055_ VSS VSS VDD VDD _04844_ sky130_fd_sc_hd__nand2_1
X_16143_ network.neuron_in100.counter\[3\] _04844_ VSS VSS
+ VDD VDD _04845_ sky130_fd_sc_hd__or2_2
X_16144_ net277 _04845_ VSS VSS VDD VDD _01404_ sky130_fd_sc_hd__nand2_1
X_16145_ network.neuron_in099.counter\[3\] _00706_ VSS VSS
+ VDD VDD _04846_ sky130_fd_sc_hd__nand2b_1
X_16146_ network.neuron_in099.counter\[2\] VSS VSS VDD VDD
+ _04847_ sky130_fd_sc_hd__inv_1
X_16147_ _04846_ _04847_ VSS VSS VDD VDD _04848_ sky130_fd_sc_hd__nand2b_1
X_16148_ net277 _04848_ VSS VSS VDD VDD _01405_ sky130_fd_sc_hd__nand2_1
X_16149_ network.neuron_in098.counter\[3\] _00721_ VSS VSS
+ VDD VDD _04849_ sky130_fd_sc_hd__nand2b_1
X_16150_ network.neuron_in098.counter\[2\] VSS VSS VDD VDD
+ _04850_ sky130_fd_sc_hd__inv_1
X_16151_ _04849_ _04850_ VSS VSS VDD VDD _04851_ sky130_fd_sc_hd__nand2b_1
X_16152_ net277 _04851_ VSS VSS VDD VDD _01406_ sky130_fd_sc_hd__nand2_1
X_16153_ net277 _04546_ VSS VSS VDD VDD _01407_ sky130_fd_sc_hd__nand2_1
X_16154_ net277 _04550_ VSS VSS VDD VDD _01408_ sky130_fd_sc_hd__nand2_1
Xplace404 network.neuron_hid0.ROM0.address\[3\] VSS VSS VDD
+ VDD net403 sky130_fd_sc_hd__buf_4
X_16156_ net282 _04553_ VSS VSS VDD VDD _01409_ sky130_fd_sc_hd__nand2_1
X_16157_ net282 _04557_ VSS VSS VDD VDD _01410_ sky130_fd_sc_hd__nand2_1
X_16158_ net282 _04560_ VSS VSS VDD VDD _01411_ sky130_fd_sc_hd__nand2_1
X_16159_ net281 _04563_ VSS VSS VDD VDD _01412_ sky130_fd_sc_hd__nand2_1
X_16160_ net281 _04568_ VSS VSS VDD VDD _01413_ sky130_fd_sc_hd__nand2_1
X_16161_ net281 _04571_ VSS VSS VDD VDD _01414_ sky130_fd_sc_hd__nand2_1
X_16162_ net281 _04575_ VSS VSS VDD VDD _01415_ sky130_fd_sc_hd__nand2_1
X_16163_ net281 _04579_ VSS VSS VDD VDD _01416_ sky130_fd_sc_hd__nand2_1
X_16164_ net281 _04583_ VSS VSS VDD VDD _01417_ sky130_fd_sc_hd__nand2_1
X_16165_ net282 _04588_ VSS VSS VDD VDD _01418_ sky130_fd_sc_hd__nand2_1
Xplace403 net403 VSS VSS VDD VDD net402 sky130_fd_sc_hd__buf_4
X_16167_ net282 _04591_ VSS VSS VDD VDD _01419_ sky130_fd_sc_hd__nand2_1
X_16168_ net281 _04595_ VSS VSS VDD VDD _01420_ sky130_fd_sc_hd__nand2_1
X_16169_ net282 _04599_ VSS VSS VDD VDD _01421_ sky130_fd_sc_hd__nand2_1
X_16170_ net281 _04603_ VSS VSS VDD VDD _01422_ sky130_fd_sc_hd__nand2_1
X_16171_ net282 _04608_ VSS VSS VDD VDD _01423_ sky130_fd_sc_hd__nand2_1
X_16172_ net282 _04612_ VSS VSS VDD VDD _01424_ sky130_fd_sc_hd__nand2_1
X_16173_ net278 _04615_ VSS VSS VDD VDD _01425_ sky130_fd_sc_hd__nand2_1
X_16174_ net278 _04619_ VSS VSS VDD VDD _01426_ sky130_fd_sc_hd__nand2_1
X_16175_ net278 _04623_ VSS VSS VDD VDD _01427_ sky130_fd_sc_hd__nand2_1
X_16176_ net281 _04627_ VSS VSS VDD VDD _01428_ sky130_fd_sc_hd__nand2_1
Xplace399 net401 VSS VSS VDD VDD net398 sky130_fd_sc_hd__buf_4
X_16178_ net281 _04631_ VSS VSS VDD VDD _01429_ sky130_fd_sc_hd__nand2_1
X_16179_ net278 _04487_ VSS VSS VDD VDD _01430_ sky130_fd_sc_hd__nand2_1
X_16180_ net277 _04504_ VSS VSS VDD VDD _01431_ sky130_fd_sc_hd__nand2_1
X_16181_ net281 _04492_ VSS VSS VDD VDD _01432_ sky130_fd_sc_hd__nand2_1
X_16182_ net277 _04498_ VSS VSS VDD VDD _01433_ sky130_fd_sc_hd__nand2_1
X_16183_ net277 _04472_ VSS VSS VDD VDD _01434_ sky130_fd_sc_hd__nand2_1
X_16184_ net277 _04467_ VSS VSS VDD VDD _01435_ sky130_fd_sc_hd__nand2_1
X_16185_ net277 _04459_ VSS VSS VDD VDD _01436_ sky130_fd_sc_hd__nand2_1
X_16186_ net277 _04401_ VSS VSS VDD VDD _01437_ sky130_fd_sc_hd__nand2_1
X_16187_ net277 _04423_ VSS VSS VDD VDD _01438_ sky130_fd_sc_hd__nand2_1
Xplace341 _07278_ VSS VSS VDD VDD net340 sky130_fd_sc_hd__buf_4
X_16189_ net277 _04418_ VSS VSS VDD VDD _01439_ sky130_fd_sc_hd__nand2_1
X_16190_ net277 _04357_ VSS VSS VDD VDD _01440_ sky130_fd_sc_hd__nand2_1
X_16191_ net277 _04393_ VSS VSS VDD VDD _01441_ sky130_fd_sc_hd__nand2_1
X_16192_ net277 _04362_ VSS VSS VDD VDD _01442_ sky130_fd_sc_hd__nand2_1
X_16193_ net277 _04384_ VSS VSS VDD VDD _01443_ sky130_fd_sc_hd__nand2_1
X_16194_ net277 _04282_ VSS VSS VDD VDD _01444_ sky130_fd_sc_hd__nand2_1
X_16195_ net277 _04287_ VSS VSS VDD VDD _01445_ sky130_fd_sc_hd__nand2_1
X_16196_ net277 _04293_ VSS VSS VDD VDD _01446_ sky130_fd_sc_hd__nand2_1
X_16197_ net278 _04232_ VSS VSS VDD VDD _01447_ sky130_fd_sc_hd__nand2_1
X_16198_ net277 _04260_ VSS VSS VDD VDD _01448_ sky130_fd_sc_hd__nand2_1
Xplace339 _07299_ VSS VSS VDD VDD net338 sky130_fd_sc_hd__buf_4
X_16200_ net278 _04255_ VSS VSS VDD VDD _01449_ sky130_fd_sc_hd__nand2_1
X_16201_ net278 _04268_ VSS VSS VDD VDD _01450_ sky130_fd_sc_hd__nand2_1
X_16202_ net278 _04247_ VSS VSS VDD VDD _01451_ sky130_fd_sc_hd__nand2_1
X_16203_ net277 _04226_ VSS VSS VDD VDD _01452_ sky130_fd_sc_hd__nand2_1
X_16204_ net278 _04173_ VSS VSS VDD VDD _01453_ sky130_fd_sc_hd__nand2_1
X_16205_ net278 _04168_ VSS VSS VDD VDD _01454_ sky130_fd_sc_hd__nand2_1
X_16206_ net277 _04149_ VSS VSS VDD VDD _01455_ sky130_fd_sc_hd__nand2_1
X_16207_ net277 _04163_ VSS VSS VDD VDD _01456_ sky130_fd_sc_hd__nand2_1
X_16208_ net278 _04158_ VSS VSS VDD VDD _01457_ sky130_fd_sc_hd__nand2_1
X_16209_ net278 _04122_ VSS VSS VDD VDD _01458_ sky130_fd_sc_hd__nand2_1
X_16210_ net277 _04117_ VSS VSS VDD VDD _01459_ sky130_fd_sc_hd__nand2_1
X_16211_ net278 _04131_ VSS VSS VDD VDD _01460_ sky130_fd_sc_hd__nand2_1
X_16212_ net278 _04126_ VSS VSS VDD VDD _01461_ sky130_fd_sc_hd__nand2_1
X_16213_ net278 _03837_ VSS VSS VDD VDD _01462_ sky130_fd_sc_hd__nand2_1
X_16214_ net279 _03880_ VSS VSS VDD VDD _01463_ sky130_fd_sc_hd__nand2_1
X_16215_ net279 _03862_ VSS VSS VDD VDD _01464_ sky130_fd_sc_hd__nand2_1
X_16216_ _03725_ net279 VSS VSS VDD VDD _01465_ sky130_fd_sc_hd__nand2_1
X_16217_ _03744_ net279 VSS VSS VDD VDD _01466_ sky130_fd_sc_hd__nand2_1
X_16218_ _03730_ net278 VSS VSS VDD VDD _01467_ sky130_fd_sc_hd__nand2_1
X_16219_ net279 _03789_ VSS VSS VDD VDD _01468_ sky130_fd_sc_hd__nand2_1
X_16220_ _03697_ net278 VSS VSS VDD VDD _01469_ sky130_fd_sc_hd__nand2_1
X_16221_ _03683_ net278 VSS VSS VDD VDD _01470_ sky130_fd_sc_hd__nand2_1
X_16222_ _03702_ net279 VSS VSS VDD VDD _01471_ sky130_fd_sc_hd__nand2_1
X_16223_ _03667_ net279 VSS VSS VDD VDD _01472_ sky130_fd_sc_hd__nand2_1
Xplace398 net398 VSS VSS VDD VDD net397 sky130_fd_sc_hd__buf_4
X_16225_ _03663_ net278 VSS VSS VDD VDD _01473_ sky130_fd_sc_hd__nand2_1
X_16226_ _03635_ net278 VSS VSS VDD VDD _01474_ sky130_fd_sc_hd__nand2_1
X_16227_ _07818_ net278 VSS VSS VDD VDD _01475_ sky130_fd_sc_hd__nand2_1
X_16228_ _07805_ net277 VSS VSS VDD VDD _01476_ sky130_fd_sc_hd__nand2_1
X_16229_ net278 _04705_ VSS VSS VDD VDD _01477_ sky130_fd_sc_hd__nand2_1
X_16230_ _03657_ net278 VSS VSS VDD VDD _01478_ sky130_fd_sc_hd__nand2_1
X_16231_ _03640_ net277 VSS VSS VDD VDD _01479_ sky130_fd_sc_hd__nand2_1
X_16232_ _03620_ net277 VSS VSS VDD VDD _01480_ sky130_fd_sc_hd__nand2_1
X_16233_ _03611_ net277 VSS VSS VDD VDD _01481_ sky130_fd_sc_hd__nand2_1
X_16234_ _03601_ net278 VSS VSS VDD VDD _01482_ sky130_fd_sc_hd__nand2_1
X_16235_ _03591_ net277 VSS VSS VDD VDD _01483_ sky130_fd_sc_hd__nand2_1
Xplace395 net395 VSS VSS VDD VDD net394 sky130_fd_sc_hd__buf_4
X_16237_ _03581_ net278 VSS VSS VDD VDD _01484_ sky130_fd_sc_hd__nand2_1
X_16238_ _03571_ net278 VSS VSS VDD VDD _01485_ sky130_fd_sc_hd__nand2_1
X_16239_ _03562_ net278 VSS VSS VDD VDD _01486_ sky130_fd_sc_hd__nand2_1
X_16240_ _03544_ net278 VSS VSS VDD VDD _01487_ sky130_fd_sc_hd__nand2_1
X_16241_ _03553_ net278 VSS VSS VDD VDD _01488_ sky130_fd_sc_hd__nand2_1
X_16242_ _03529_ net278 VSS VSS VDD VDD _01489_ sky130_fd_sc_hd__nand2_1
X_16243_ _03508_ net278 VSS VSS VDD VDD _01490_ sky130_fd_sc_hd__nand2_1
X_16244_ _03512_ net278 VSS VSS VDD VDD _01491_ sky130_fd_sc_hd__nand2_1
X_16245_ _03492_ net278 VSS VSS VDD VDD _01492_ sky130_fd_sc_hd__nand2_1
X_16246_ _03483_ net278 VSS VSS VDD VDD _01493_ sky130_fd_sc_hd__nand2_1
Xplace329 _07387_ VSS VSS VDD VDD net328 sky130_fd_sc_hd__buf_4
X_16248_ _03472_ net278 VSS VSS VDD VDD _01494_ sky130_fd_sc_hd__nand2_1
X_16249_ _03463_ net278 VSS VSS VDD VDD _01495_ sky130_fd_sc_hd__nand2_1
X_16250_ _08578_ net278 VSS VSS VDD VDD _01496_ sky130_fd_sc_hd__nand2_1
X_16251_ _08572_ net278 VSS VSS VDD VDD _01497_ sky130_fd_sc_hd__nand2_1
X_16252_ _08548_ net278 VSS VSS VDD VDD _01498_ sky130_fd_sc_hd__nand2_1
X_16253_ _08557_ net278 VSS VSS VDD VDD _01499_ sky130_fd_sc_hd__nand2_1
X_16254_ _08540_ net278 VSS VSS VDD VDD _01500_ sky130_fd_sc_hd__nand2_1
X_16255_ _08501_ net278 VSS VSS VDD VDD _01501_ sky130_fd_sc_hd__nand2_1
X_16256_ _08516_ net278 VSS VSS VDD VDD _01502_ sky130_fd_sc_hd__nand2_1
X_16257_ _08525_ net278 VSS VSS VDD VDD _01503_ sky130_fd_sc_hd__nand2_1
X_16258_ _08520_ net278 VSS VSS VDD VDD _01504_ sky130_fd_sc_hd__nand2_1
X_16259_ network.in_spk09_14 network.in_spk08_14 _09602_ _09261_
+ VSS VSS VDD VDD _04860_ sky130_fd_sc_hd__or4_4
X_16260_ network.in_spk10_14 _04860_ net762 VSS VSS VDD VDD
+ _04861_ sky130_fd_sc_hd__o21ai_2
X_16261_ _07419_ _04861_ net359 VSS VSS VDD VDD _01867_ sky130_fd_sc_hd__a21oi_1
X_16262_ _09235_ _09346_ _09347_ VSS VSS VDD VDD _04862_ sky130_fd_sc_hd__nand3_1
X_16263_ network.in_spk12_14 _04862_ VSS VSS VDD VDD _04863_
+ sky130_fd_sc_hd__nand2_1
X_16264_ _07505_ _04863_ net359 VSS VSS VDD VDD _01868_ sky130_fd_sc_hd__a21oi_1
X_16265_ network.neuron_in252.counter\[1\] VSS VSS VDD VDD
+ _01102_ sky130_fd_sc_hd__inv_1
X_16266_ network.neuron_in118.counter\[0\] VSS VSS VDD VDD
+ _00106_ sky130_fd_sc_hd__inv_1
X_16267_ _09345_ _09261_ network.in_spk07_14 VSS VSS VDD VDD
+ _04864_ sky130_fd_sc_hd__o21ai_0
X_16268_ _07233_ _04864_ net358 VSS VSS VDD VDD _01869_ sky130_fd_sc_hd__a21oi_1
X_16269_ _04085_ _04095_ VSS VSS VDD VDD _03143_ sky130_fd_sc_hd__nor2_1
X_16270_ network.in_spk08_14 _09348_ VSS VSS VDD VDD _04865_
+ sky130_fd_sc_hd__nand2_1
X_16271_ _07410_ _04865_ net358 VSS VSS VDD VDD _01870_ sky130_fd_sc_hd__a21oi_1
X_16272_ network.neuron_in073.counter\[3\] network.in_period\[73\]\[2\]
+ net355 _00133_ VSS VSS VDD VDD _04866_ sky130_fd_sc_hd__o22ai_1
X_16273_ network.neuron_in073.counter\[2\] _00133_ net383
+ VSS VSS VDD VDD _04867_ sky130_fd_sc_hd__nand3_1
X_16274_ network.in_period\[73\]\[2\] net383 _04867_ VSS VSS
+ VDD VDD _04868_ sky130_fd_sc_hd__o21ai_0
X_16275_ _04503_ _04866_ _04868_ VSS VSS VDD VDD _02357_ sky130_fd_sc_hd__a21oi_1
X_16276_ network.neuron_in127.counter\[1\] VSS VSS VDD VDD
+ _01106_ sky130_fd_sc_hd__inv_1
X_16277_ _04042_ _04099_ VSS VSS VDD VDD _03270_ sky130_fd_sc_hd__nor2_1
X_16278_ network.in_spk08_14 _09348_ network.in_spk09_14 VSS
+ VSS VDD VDD _04869_ sky130_fd_sc_hd__o21ai_0
X_16279_ _07238_ _04869_ net358 VSS VSS VDD VDD _01871_ sky130_fd_sc_hd__a21oi_1
X_16280_ network.in_spk10_14 _04860_ VSS VSS VDD VDD _04870_
+ sky130_fd_sc_hd__nand2_1
X_16281_ _07414_ _04870_ net359 VSS VSS VDD VDD _01872_ sky130_fd_sc_hd__a21oi_1
X_16282_ _04036_ _04397_ VSS VSS VDD VDD _03318_ sky130_fd_sc_hd__nor2_1
X_16283_ _04022_ _04097_ VSS VSS VDD VDD _03123_ sky130_fd_sc_hd__nor2_1
X_16284_ network.in_spk12_14 _04862_ network.in_spk13_14 VSS
+ VSS VDD VDD _04871_ sky130_fd_sc_hd__o21ai_0
X_16285_ _07638_ _04871_ net359 VSS VSS VDD VDD _01873_ sky130_fd_sc_hd__a21oi_1
X_16286_ network.in_spk00_14 _09261_ network.in_spk01_14 VSS
+ VSS VDD VDD _04872_ sky130_fd_sc_hd__o21ai_0
X_16287_ _07161_ _04872_ net358 VSS VSS VDD VDD _01874_ sky130_fd_sc_hd__a21oi_1
X_16288_ network.neuron_in000.counter\[1\] network.neuron_in000.counter\[2\]
+ network.neuron_in000.counter\[0\] net351 VSS VSS VDD VDD _04873_
+ sky130_fd_sc_hd__nor4_1
X_16289_ network.in_period\[0\]\[3\] _04873_ _08519_ VSS VSS
+ VDD VDD _04874_ sky130_fd_sc_hd__mux2i_1
Xplace427 net427 VSS VSS VDD VDD net426 sky130_fd_sc_hd__buf_4
Xplace424 net425 VSS VSS VDD VDD net423 sky130_fd_sc_hd__buf_4
X_16292_ network.neuron_in000.counter\[1\] network.neuron_in000.counter\[2\]
+ network.neuron_in000.counter\[0\] network.neuron_in000.counter\[3\]
+ net368 VSS VSS VDD VDD _04877_ sky130_fd_sc_hd__o311a_1
X_16293_ network.in_period\[0\]\[3\] net351 _04877_ VSS VSS
+ VDD VDD _04878_ sky130_fd_sc_hd__a21oi_1
X_16294_ network.neuron_in000.counter\[3\] _04874_ _04878_
+ VSS VSS VDD VDD _02066_ sky130_fd_sc_hd__o21ai_0
Xplace400 net401 VSS VSS VDD VDD net399 sky130_fd_sc_hd__buf_4
X_16296_ net383 _04615_ VSS VSS VDD VDD _04880_ sky130_fd_sc_hd__nand2_1
X_16297_ net750 _04880_ VSS VSS VDD VDD _04881_ sky130_fd_sc_hd__nand2_1
X_16298_ network.neuron_in079.counter\[0\] _04880_ _04881_
+ VSS VSS VDD VDD _02379_ sky130_fd_sc_hd__o21ai_0
X_16299_ network.in_spk13_14 network.in_spk12_14 _04862_ network.in_spk14_14
+ VSS VSS VDD VDD _04882_ sky130_fd_sc_hd__o31ai_1
Xplace408 network.neuron_hid0.ROM0.address\[2\] VSS VSS VDD
+ VDD net407 sky130_fd_sc_hd__buf_4
X_16301_ _07643_ _04882_ net359 VSS VSS VDD VDD _01875_ sky130_fd_sc_hd__a21oi_1
X_16302_ network.neuron_in001.counter\[0\] network.neuron_in001.counter\[1\]
+ network.neuron_in001.counter\[2\] net351 VSS VSS VDD VDD _04884_
+ sky130_fd_sc_hd__nor4_1
X_16303_ network.in_period\[1\]\[3\] _04884_ _08524_ VSS VSS
+ VDD VDD _04885_ sky130_fd_sc_hd__mux2i_1
Xplace417 net417 VSS VSS VDD VDD net416 sky130_fd_sc_hd__buf_4
X_16305_ network.neuron_in001.counter\[0\] network.neuron_in001.counter\[1\]
+ network.neuron_in001.counter\[2\] network.neuron_in001.counter\[3\]
+ net368 VSS VSS VDD VDD _04887_ sky130_fd_sc_hd__o311a_1
X_16306_ network.in_period\[1\]\[3\] net351 _04887_ VSS VSS
+ VDD VDD _04888_ sky130_fd_sc_hd__a21oi_1
X_16307_ network.neuron_in001.counter\[3\] _04885_ _04888_
+ VSS VSS VDD VDD _02070_ sky130_fd_sc_hd__o21ai_0
X_16308_ _09231_ _04862_ network.in_spk15_14 VSS VSS VDD VDD
+ _04889_ sky130_fd_sc_hd__o21ai_0
X_16309_ _07648_ _04889_ net359 VSS VSS VDD VDD _01876_ sky130_fd_sc_hd__a21oi_1
X_16310_ network.in_spk00_14 _09261_ VSS VSS VDD VDD _04890_
+ sky130_fd_sc_hd__nand2_1
X_16311_ _07192_ _04890_ net358 VSS VSS VDD VDD _01877_ sky130_fd_sc_hd__a21oi_1
X_16312_ network.neuron_in002.counter\[0\] network.neuron_in002.counter\[1\]
+ _00759_ VSS VSS VDD VDD _04891_ sky130_fd_sc_hd__o21bai_1
X_16313_ _08515_ _04891_ network.neuron_in002.counter\[3\]
+ VSS VSS VDD VDD _04892_ sky130_fd_sc_hd__a21oi_1
X_16314_ _08515_ _00757_ network.neuron_in002.counter\[3\]
+ _00758_ _04892_ VSS VSS VDD VDD _04893_ sky130_fd_sc_hd__a41o_1
X_16315_ net368 _08514_ network.in_period\[2\]\[3\] VSS VSS
+ VDD VDD _04894_ sky130_fd_sc_hd__a21oi_1
X_16316_ net368 _04893_ _04894_ VSS VSS VDD VDD _02074_ sky130_fd_sc_hd__a21oi_1
X_16317_ net656 _04880_ VSS VSS VDD VDD _04895_ sky130_fd_sc_hd__nand2_1
X_16318_ _00097_ _04880_ _04895_ VSS VSS VDD VDD _02380_ sky130_fd_sc_hd__o21ai_0
X_16319_ network.in_spk00_15 _09260_ VSS VSS VDD VDD _04896_
+ sky130_fd_sc_hd__nand2_1
X_16320_ _07653_ _04896_ net361 VSS VSS VDD VDD _01878_ sky130_fd_sc_hd__a21oi_1
Xplace407 net407 VSS VSS VDD VDD net406 sky130_fd_sc_hd__buf_4
X_16322_ network.neuron_in003.counter\[1\] network.neuron_in003.counter\[0\]
+ _00627_ VSS VSS VDD VDD _04898_ sky130_fd_sc_hd__o21bai_1
X_16323_ _08500_ _04898_ network.neuron_in003.counter\[3\]
+ VSS VSS VDD VDD _04899_ sky130_fd_sc_hd__a21oi_1
X_16324_ _08500_ _00626_ _00625_ network.neuron_in003.counter\[3\]
+ _04899_ VSS VSS VDD VDD _04900_ sky130_fd_sc_hd__a41o_1
X_16325_ net368 _08499_ network.in_period\[3\]\[3\] VSS VSS
+ VDD VDD _04901_ sky130_fd_sc_hd__a21oi_1
X_16326_ net368 _04900_ _04901_ VSS VSS VDD VDD _02078_ sky130_fd_sc_hd__a21oi_1
X_16327_ net383 _04631_ VSS VSS VDD VDD _04902_ sky130_fd_sc_hd__nand2_1
X_16328_ net721 _04902_ VSS VSS VDD VDD _04903_ sky130_fd_sc_hd__nand2_1
X_16329_ network.neuron_in075.counter\[0\] _04902_ _04903_
+ VSS VSS VDD VDD _02363_ sky130_fd_sc_hd__o21ai_0
X_16330_ _09340_ _09584_ VSS VSS VDD VDD _04904_ sky130_fd_sc_hd__nand2_1
X_16331_ network.in_spk01_15 _04904_ VSS VSS VDD VDD _04905_
+ sky130_fd_sc_hd__nand2_1
X_16332_ _07698_ _04905_ net359 VSS VSS VDD VDD _01879_ sky130_fd_sc_hd__a21oi_1
X_16333_ _09593_ net284 _09594_ VSS VSS VDD VDD _04906_ sky130_fd_sc_hd__nand3_1
X_16334_ net665 _04906_ VSS VSS VDD VDD _04907_ sky130_fd_sc_hd__nand2_1
X_16335_ _07133_ _04907_ net362 VSS VSS VDD VDD _01880_ sky130_fd_sc_hd__a21oi_1
X_16336_ network.neuron_in004.counter\[0\] network.neuron_in004.counter\[1\]
+ network.neuron_in004.counter\[2\] net351 VSS VSS VDD VDD _04908_
+ sky130_fd_sc_hd__nor4_1
X_16337_ network.in_period\[4\]\[3\] _04908_ _08539_ VSS VSS
+ VDD VDD _04909_ sky130_fd_sc_hd__mux2i_1
X_16338_ network.neuron_in004.counter\[0\] network.neuron_in004.counter\[1\]
+ network.neuron_in004.counter\[2\] network.neuron_in004.counter\[3\]
+ net368 VSS VSS VDD VDD _04910_ sky130_fd_sc_hd__o311a_1
X_16339_ network.in_period\[4\]\[3\] net351 _04910_ VSS VSS
+ VDD VDD _04911_ sky130_fd_sc_hd__a21oi_1
X_16340_ network.neuron_in004.counter\[3\] _04909_ _04911_
+ VSS VSS VDD VDD _02082_ sky130_fd_sc_hd__o21ai_0
X_16341_ network.in_spk01_15 network.in_spk00_15 _09260_ network.in_spk02_15
+ VSS VSS VDD VDD _04912_ sky130_fd_sc_hd__o31ai_1
X_16342_ _07703_ _04912_ net359 VSS VSS VDD VDD _01881_ sky130_fd_sc_hd__a21oi_1
X_16343_ network.neuron_in005.counter\[0\] network.neuron_in005.counter\[1\]
+ network.neuron_in005.counter\[2\] VSS VSS VDD VDD _04913_
+ sky130_fd_sc_hd__nor3_1
X_16344_ network.neuron_in005.counter\[3\] _04913_ VSS VSS
+ VDD VDD _04914_ sky130_fd_sc_hd__xnor2_1
X_16345_ network.in_period\[5\]\[3\] _08558_ VSS VSS VDD VDD
+ _04915_ sky130_fd_sc_hd__nand2_1
X_16346_ _08558_ _04914_ _04915_ VSS VSS VDD VDD _02086_ sky130_fd_sc_hd__o21ai_0
X_16347_ network.neuron_in078.counter\[2\] net383 VSS VSS
+ VDD VDD _04916_ sky130_fd_sc_hd__nand2_1
X_16348_ network.neuron_in078.counter\[3\] network.in_period\[78\]\[2\]
+ _04916_ VSS VSS VDD VDD _04917_ sky130_fd_sc_hd__o21ai_0
Xplace328 _07389_ VSS VSS VDD VDD net327 sky130_fd_sc_hd__buf_4
X_16350_ _00100_ network.neuron_in078.counter\[2\] net355
+ VSS VSS VDD VDD _04919_ sky130_fd_sc_hd__or3_1
X_16351_ network.in_period\[78\]\[2\] net383 _04919_ VSS VSS
+ VDD VDD _04920_ sky130_fd_sc_hd__o21ai_0
X_16352_ _00100_ _04917_ _04920_ VSS VSS VDD VDD _02377_ sky130_fd_sc_hd__a21oi_1
X_16353_ network.in_spk02_15 network.in_spk01_15 _04904_ network.in_spk03_15
+ VSS VSS VDD VDD _04921_ sky130_fd_sc_hd__o31ai_1
X_16354_ _07685_ _04921_ net361 VSS VSS VDD VDD _01882_ sky130_fd_sc_hd__a21oi_1
X_16355_ net284 _09594_ VSS VSS VDD VDD _04922_ sky130_fd_sc_hd__nand2_1
X_16356_ network.in_spk12_13 network.in_spk13_13 _04922_ network.in_spk14_13
+ VSS VSS VDD VDD _04923_ sky130_fd_sc_hd__o31ai_1
X_16357_ _07151_ _04923_ net362 VSS VSS VDD VDD _01883_ sky130_fd_sc_hd__a21oi_1
X_16358_ network.neuron_in006.counter\[0\] network.neuron_in006.counter\[2\]
+ network.neuron_in006.counter\[1\] VSS VSS VDD VDD _04924_
+ sky130_fd_sc_hd__nor3_1
X_16359_ network.neuron_in006.counter\[3\] _04924_ VSS VSS
+ VDD VDD _04925_ sky130_fd_sc_hd__xnor2_1
X_16360_ network.in_period\[6\]\[3\] _08549_ VSS VSS VDD VDD
+ _04926_ sky130_fd_sc_hd__nand2_1
X_16361_ _08549_ _04925_ _04926_ VSS VSS VDD VDD _02090_ sky130_fd_sc_hd__o21ai_0
X_16362_ network.neuron_in079.counter\[2\] net383 VSS VSS
+ VDD VDD _04927_ sky130_fd_sc_hd__nand2_1
X_16363_ network.neuron_in079.counter\[3\] network.in_period\[79\]\[2\]
+ _04927_ VSS VSS VDD VDD _04928_ sky130_fd_sc_hd__o21ai_0
X_16364_ _00096_ network.neuron_in079.counter\[2\] net355
+ VSS VSS VDD VDD _04929_ sky130_fd_sc_hd__or3_1
X_16365_ network.in_period\[79\]\[2\] net383 _04929_ VSS VSS
+ VDD VDD _04930_ sky130_fd_sc_hd__o21ai_0
X_16366_ _00096_ _04928_ _04930_ VSS VSS VDD VDD _02381_ sky130_fd_sc_hd__a21oi_1
X_16367_ network.in_spk04_15 _09353_ VSS VSS VDD VDD _04931_
+ sky130_fd_sc_hd__nand2_1
X_16368_ _07833_ _04931_ net361 VSS VSS VDD VDD _01884_ sky130_fd_sc_hd__a21oi_1
X_16369_ network.neuron_in007.counter\[1\] network.neuron_in007.counter\[2\]
+ network.neuron_in007.counter\[0\] net351 VSS VSS VDD VDD _04932_
+ sky130_fd_sc_hd__nor4_1
X_16370_ network.in_period\[7\]\[3\] _04932_ _08571_ VSS VSS
+ VDD VDD _04933_ sky130_fd_sc_hd__mux2i_1
X_16371_ network.neuron_in007.counter\[1\] network.neuron_in007.counter\[2\]
+ network.neuron_in007.counter\[0\] network.neuron_in007.counter\[3\]
+ net369 VSS VSS VDD VDD _04934_ sky130_fd_sc_hd__o311a_1
X_16372_ network.in_period\[7\]\[3\] net351 _04934_ VSS VSS
+ VDD VDD _04935_ sky130_fd_sc_hd__a21oi_1
X_16373_ network.neuron_in007.counter\[3\] _04933_ _04935_
+ VSS VSS VDD VDD _02094_ sky130_fd_sc_hd__o21ai_0
X_16374_ network.in_spk04_15 _09353_ network.in_spk05_15 VSS
+ VSS VDD VDD _04936_ sky130_fd_sc_hd__o21ai_0
Xplace304 _07565_ VSS VSS VDD VDD net303 sky130_fd_sc_hd__buf_4
X_16376_ _08115_ _04936_ net361 VSS VSS VDD VDD _01885_ sky130_fd_sc_hd__a21oi_1
X_16377_ network.in_spk12_13 _04922_ network.in_spk13_13 VSS
+ VSS VDD VDD _04938_ sky130_fd_sc_hd__o21ai_0
X_16378_ _07128_ _04938_ net362 VSS VSS VDD VDD _01886_ sky130_fd_sc_hd__a21oi_1
X_16379_ network.neuron_in008.counter\[1\] network.neuron_in008.counter\[0\]
+ _00490_ VSS VSS VDD VDD _04939_ sky130_fd_sc_hd__o21bai_1
X_16380_ _08577_ _04939_ network.neuron_in008.counter\[3\]
+ VSS VSS VDD VDD _04940_ sky130_fd_sc_hd__a21oi_1
X_16381_ _08577_ _00489_ _00488_ network.neuron_in008.counter\[3\]
+ _04940_ VSS VSS VDD VDD _04941_ sky130_fd_sc_hd__a41o_1
Xclkbuf_0_clk_root_regs clk_root_regs VSS VSS VDD VDD clknet_0_clk_root_regs
+ sky130_fd_sc_hd__clkbuf_16
X_16383_ net369 _08576_ network.in_period\[8\]\[3\] VSS VSS
+ VDD VDD _04943_ sky130_fd_sc_hd__a21oi_1
X_16384_ net369 _04941_ _04943_ VSS VSS VDD VDD _02098_ sky130_fd_sc_hd__a21oi_1
X_16385_ net791 _04902_ VSS VSS VDD VDD _04944_ sky130_fd_sc_hd__nand2_1
X_16386_ _00126_ _04902_ _04944_ VSS VSS VDD VDD _02364_ sky130_fd_sc_hd__o21ai_0
X_16387_ network.in_spk05_15 network.in_spk04_15 _09353_ network.in_spk06_15
+ VSS VSS VDD VDD _04945_ sky130_fd_sc_hd__o31ai_1
X_16388_ _08130_ _04945_ net361 VSS VSS VDD VDD _01887_ sky130_fd_sc_hd__a21oi_1
X_16389_ network.neuron_in009.counter\[0\] network.neuron_in009.counter\[2\]
+ network.neuron_in009.counter\[1\] VSS VSS VDD VDD _04946_
+ sky130_fd_sc_hd__nor3_1
X_16390_ network.neuron_in009.counter\[3\] _04946_ VSS VSS
+ VDD VDD _04947_ sky130_fd_sc_hd__xnor2_1
X_16391_ network.in_period\[9\]\[3\] _03464_ VSS VSS VDD VDD
+ _04948_ sky130_fd_sc_hd__nand2_1
X_16392_ _03464_ _04947_ _04948_ VSS VSS VDD VDD _02102_ sky130_fd_sc_hd__o21ai_0
X_16393_ _09246_ _09353_ network.in_spk07_15 VSS VSS VDD VDD
+ _04949_ sky130_fd_sc_hd__o21ai_0
X_16394_ _08134_ _04949_ net361 VSS VSS VDD VDD _01888_ sky130_fd_sc_hd__a21oi_1
X_16395_ network.in_spk12_13 _04922_ VSS VSS VDD VDD _04950_
+ sky130_fd_sc_hd__nand2_1
X_16396_ _07177_ _04950_ net362 VSS VSS VDD VDD _01889_ sky130_fd_sc_hd__a21oi_1
X_16397_ network.neuron_in010.counter\[0\] network.neuron_in010.counter\[1\]
+ _00478_ VSS VSS VDD VDD _04951_ sky130_fd_sc_hd__o21bai_1
X_16398_ _03467_ _04951_ network.neuron_in010.counter\[3\]
+ VSS VSS VDD VDD _04952_ sky130_fd_sc_hd__a21oi_1
X_16399_ _03467_ _00476_ _00477_ network.neuron_in010.counter\[3\]
+ _04952_ VSS VSS VDD VDD _04953_ sky130_fd_sc_hd__a41o_1
X_16400_ net369 _03471_ network.in_period\[10\]\[3\] VSS VSS
+ VDD VDD _04954_ sky130_fd_sc_hd__a21oi_1
X_16401_ net369 _04953_ _04954_ VSS VSS VDD VDD _02106_ sky130_fd_sc_hd__a21oi_1
X_16402_ net387 _04627_ VSS VSS VDD VDD _04955_ sky130_fd_sc_hd__nand2_1
X_16403_ network.in_period\[76\]\[0\] _04955_ VSS VSS VDD
+ VDD _04956_ sky130_fd_sc_hd__nand2_1
X_16404_ network.neuron_in076.counter\[0\] _04955_ _04956_
+ VSS VSS VDD VDD _02367_ sky130_fd_sc_hd__o21ai_0
X_16405_ network.in_spk08_15 _09341_ VSS VSS VDD VDD _04957_
+ sky130_fd_sc_hd__nand2_1
X_16406_ _08138_ _04957_ net359 VSS VSS VDD VDD _01890_ sky130_fd_sc_hd__a21oi_1
X_16407_ network.neuron_in011.counter\[1\] network.neuron_in011.counter\[2\]
+ network.neuron_in011.counter\[0\] net350 VSS VSS VDD VDD _04958_
+ sky130_fd_sc_hd__nor4_1
X_16408_ network.in_period\[11\]\[3\] _04958_ _03482_ VSS
+ VSS VDD VDD _04959_ sky130_fd_sc_hd__mux2i_1
X_16409_ network.neuron_in011.counter\[1\] network.neuron_in011.counter\[2\]
+ network.neuron_in011.counter\[0\] network.neuron_in011.counter\[3\]
+ net369 VSS VSS VDD VDD _04960_ sky130_fd_sc_hd__o311a_1
X_16410_ network.in_period\[11\]\[3\] net350 _04960_ VSS VSS
+ VDD VDD _04961_ sky130_fd_sc_hd__a21oi_1
X_16411_ network.neuron_in011.counter\[3\] _04959_ _04961_
+ VSS VSS VDD VDD _02110_ sky130_fd_sc_hd__o21ai_0
X_16412_ net383 _04623_ VSS VSS VDD VDD _04962_ sky130_fd_sc_hd__nand2_1
X_16413_ net783 _04962_ VSS VSS VDD VDD _04963_ sky130_fd_sc_hd__nand2_1
X_16414_ _00105_ _04962_ _04963_ VSS VSS VDD VDD _02372_ sky130_fd_sc_hd__o21ai_0
X_16415_ network.in_spk08_15 _09341_ network.in_spk09_15 VSS
+ VSS VDD VDD _04964_ sky130_fd_sc_hd__o21ai_0
X_16416_ _08142_ _04964_ net359 VSS VSS VDD VDD _01891_ sky130_fd_sc_hd__a21oi_1
X_16417_ _09342_ _09586_ _09196_ net284 VSS VSS VDD VDD _04965_
+ sky130_fd_sc_hd__nand4_1
X_16418_ network.in_spk10_13 _04965_ network.in_spk11_13 VSS
+ VSS VDD VDD _04966_ sky130_fd_sc_hd__o21ai_0
X_16419_ _07172_ _04966_ net362 VSS VSS VDD VDD _01892_ sky130_fd_sc_hd__a21oi_1
X_16420_ network.neuron_in012.counter\[1\] network.neuron_in012.counter\[0\]
+ network.neuron_in012.counter\[2\] net351 VSS VSS VDD VDD _04967_
+ sky130_fd_sc_hd__nor4_1
X_16421_ network.in_period\[12\]\[3\] _04967_ _03491_ VSS
+ VSS VDD VDD _04968_ sky130_fd_sc_hd__mux2i_1
X_16422_ network.neuron_in012.counter\[1\] network.neuron_in012.counter\[0\]
+ network.neuron_in012.counter\[2\] network.neuron_in012.counter\[3\]
+ net368 VSS VSS VDD VDD _04969_ sky130_fd_sc_hd__o311a_1
X_16423_ network.in_period\[12\]\[3\] net351 _04969_ VSS VSS
+ VDD VDD _04970_ sky130_fd_sc_hd__a21oi_1
X_16424_ network.neuron_in012.counter\[3\] _04968_ _04970_
+ VSS VSS VDD VDD _02114_ sky130_fd_sc_hd__o21ai_0
X_16425_ network.in_spk09_15 network.in_spk08_15 _09341_ network.in_spk10_15
+ VSS VSS VDD VDD _04971_ sky130_fd_sc_hd__o31ai_1
X_16426_ _08290_ _04971_ net361 VSS VSS VDD VDD _01893_ sky130_fd_sc_hd__a21oi_1
X_16427_ network.neuron_in013.counter\[0\] network.neuron_in013.counter\[1\]
+ network.neuron_in013.counter\[2\] VSS VSS VDD VDD _04972_
+ sky130_fd_sc_hd__nor3_1
X_16428_ network.neuron_in013.counter\[3\] _04972_ VSS VSS
+ VDD VDD _04973_ sky130_fd_sc_hd__xnor2_1
X_16429_ network.in_period\[13\]\[3\] _03513_ VSS VSS VDD
+ VDD _04974_ sky130_fd_sc_hd__nand2_1
X_16430_ _03513_ _04973_ _04974_ VSS VSS VDD VDD _02118_ sky130_fd_sc_hd__o21ai_0
X_16431_ _09247_ _09577_ _09340_ VSS VSS VDD VDD _04975_ sky130_fd_sc_hd__nand3_1
X_16432_ net693 _04975_ VSS VSS VDD VDD _04976_ sky130_fd_sc_hd__nand2_1
X_16433_ _08295_ _04976_ net361 VSS VSS VDD VDD _01894_ sky130_fd_sc_hd__a21oi_1
X_16434_ network.in_spk10_13 _04965_ VSS VSS VDD VDD _04977_
+ sky130_fd_sc_hd__nand2_1
Xplace435 net456 VSS VSS VDD VDD net434 sky130_fd_sc_hd__buf_4
X_16436_ _07015_ _04977_ net363 VSS VSS VDD VDD _01895_ sky130_fd_sc_hd__a21oi_1
X_16437_ network.neuron_in014.counter\[1\] network.neuron_in014.counter\[0\]
+ VSS VSS VDD VDD _04979_ sky130_fd_sc_hd__nor2_1
X_16438_ _00440_ _04979_ VSS VSS VDD VDD _04980_ sky130_fd_sc_hd__nor2_1
X_16439_ network.neuron_in014.counter\[2\] _04980_ VSS VSS
+ VDD VDD _04981_ sky130_fd_sc_hd__nor2_1
X_16440_ network.neuron_in014.counter\[2\] network.neuron_in014.counter\[3\]
+ _04979_ VSS VSS VDD VDD _04982_ sky130_fd_sc_hd__nand3b_1
X_16441_ network.neuron_in014.counter\[3\] _04981_ _04982_
+ VSS VSS VDD VDD _04983_ sky130_fd_sc_hd__o21ai_0
X_16442_ net368 _03507_ network.in_period\[14\]\[3\] VSS VSS
+ VDD VDD _04984_ sky130_fd_sc_hd__a21oi_1
X_16443_ net368 _04983_ _04984_ VSS VSS VDD VDD _02122_ sky130_fd_sc_hd__a21oi_1
X_16444_ _09340_ _09571_ VSS VSS VDD VDD _04985_ sky130_fd_sc_hd__nand2_1
X_16445_ network.in_spk12_15 _04985_ VSS VSS VDD VDD _04986_
+ sky130_fd_sc_hd__nand2_1
X_16446_ _08301_ _04986_ net361 VSS VSS VDD VDD _01896_ sky130_fd_sc_hd__a21oi_1
X_16447_ network.neuron_in015.counter\[0\] network.neuron_in015.counter\[2\]
+ network.neuron_in015.counter\[1\] net351 VSS VSS VDD VDD _04987_
+ sky130_fd_sc_hd__nor4_1
X_16448_ network.in_period\[15\]\[3\] _04987_ _03528_ VSS
+ VSS VDD VDD _04988_ sky130_fd_sc_hd__mux2i_1
X_16449_ network.neuron_in015.counter\[0\] network.neuron_in015.counter\[2\]
+ network.neuron_in015.counter\[1\] network.neuron_in015.counter\[3\]
+ net368 VSS VSS VDD VDD _04989_ sky130_fd_sc_hd__o311a_1
X_16450_ network.in_period\[15\]\[3\] net351 _04989_ VSS VSS
+ VDD VDD _04990_ sky130_fd_sc_hd__a21oi_1
X_16451_ network.neuron_in015.counter\[3\] _04988_ _04990_
+ VSS VSS VDD VDD _02126_ sky130_fd_sc_hd__o21ai_0
X_16452_ network.in_spk12_15 _04985_ network.in_spk13_15 VSS
+ VSS VDD VDD _04991_ sky130_fd_sc_hd__o21ai_0
X_16453_ _08305_ _04991_ net361 VSS VSS VDD VDD _01897_ sky130_fd_sc_hd__a21oi_1
X_16454_ network.in_spk08_13 _09343_ network.in_spk09_13 VSS
+ VSS VDD VDD _04992_ sky130_fd_sc_hd__o21ai_0
X_16455_ _07109_ _04992_ net363 VSS VSS VDD VDD _01898_ sky130_fd_sc_hd__a21oi_1
X_16456_ network.neuron_in016.counter\[1\] network.neuron_in016.counter\[0\]
+ network.neuron_in016.counter\[2\] net350 VSS VSS VDD VDD _04993_
+ sky130_fd_sc_hd__nor4_1
X_16457_ network.in_period\[16\]\[3\] _04993_ _03552_ VSS
+ VSS VDD VDD _04994_ sky130_fd_sc_hd__mux2i_1
Xplace327 _07391_ VSS VSS VDD VDD net326 sky130_fd_sc_hd__buf_4
X_16459_ network.neuron_in016.counter\[1\] network.neuron_in016.counter\[0\]
+ network.neuron_in016.counter\[2\] network.neuron_in016.counter\[3\]
+ net369 VSS VSS VDD VDD _04996_ sky130_fd_sc_hd__o311a_1
X_16460_ network.in_period\[16\]\[3\] net350 _04996_ VSS VSS
+ VDD VDD _04997_ sky130_fd_sc_hd__a21oi_1
X_16461_ network.neuron_in016.counter\[3\] _04994_ _04997_
+ VSS VSS VDD VDD _02130_ sky130_fd_sc_hd__o21ai_0
X_16462_ network.in_spk13_15 network.in_spk12_15 _04985_ net760
+ VSS VSS VDD VDD _04998_ sky130_fd_sc_hd__o31ai_1
X_16463_ _08310_ _04998_ net361 VSS VSS VDD VDD _01899_ sky130_fd_sc_hd__a21oi_1
X_16464_ network.neuron_in017.counter\[1\] network.neuron_in017.counter\[0\]
+ _00419_ VSS VSS VDD VDD _04999_ sky130_fd_sc_hd__o21bai_1
X_16465_ _03539_ _04999_ network.neuron_in017.counter\[3\]
+ VSS VSS VDD VDD _05000_ sky130_fd_sc_hd__a21oi_1
X_16466_ _03539_ _00418_ _00417_ network.neuron_in017.counter\[3\]
+ _05000_ VSS VSS VDD VDD _05001_ sky130_fd_sc_hd__a41o_1
X_16467_ net369 _03543_ network.in_period\[17\]\[3\] VSS VSS
+ VDD VDD _05002_ sky130_fd_sc_hd__a21oi_1
X_16468_ net369 _05001_ _05002_ VSS VSS VDD VDD _02134_ sky130_fd_sc_hd__a21oi_1
X_16469_ _09249_ _04985_ network.in_spk15_15 VSS VSS VDD VDD
+ _05003_ sky130_fd_sc_hd__o21ai_0
X_16470_ _08315_ _05003_ net361 VSS VSS VDD VDD _01900_ sky130_fd_sc_hd__a21oi_1
X_16471_ network.in_spk08_13 _09343_ VSS VSS VDD VDD _05004_
+ sky130_fd_sc_hd__nand2_1
X_16472_ _07104_ _05004_ net363 VSS VSS VDD VDD _01901_ sky130_fd_sc_hd__a21oi_1
X_16473_ network.neuron_in018.counter\[1\] network.neuron_in018.counter\[0\]
+ VSS VSS VDD VDD _05005_ sky130_fd_sc_hd__nor2_1
X_16474_ _00423_ _05005_ VSS VSS VDD VDD _05006_ sky130_fd_sc_hd__nor2_1
X_16475_ network.neuron_in018.counter\[2\] _05006_ VSS VSS
+ VDD VDD _05007_ sky130_fd_sc_hd__nor2_1
X_16476_ network.neuron_in018.counter\[2\] network.neuron_in018.counter\[3\]
+ _05005_ VSS VSS VDD VDD _05008_ sky130_fd_sc_hd__nand3b_1
X_16477_ network.neuron_in018.counter\[3\] _05007_ _05008_
+ VSS VSS VDD VDD _05009_ sky130_fd_sc_hd__o21ai_0
X_16478_ net369 _03561_ network.in_period\[18\]\[3\] VSS VSS
+ VDD VDD _05010_ sky130_fd_sc_hd__a21oi_1
X_16479_ net369 _05009_ _05010_ VSS VSS VDD VDD _02138_ sky130_fd_sc_hd__a21oi_1
X_16480_ network.neuron_in075.counter\[3\] network.in_period\[75\]\[2\]
+ net348 _00125_ VSS VSS VDD VDD _05011_ sky130_fd_sc_hd__o22ai_1
X_16481_ network.neuron_in075.counter\[2\] _00125_ net383
+ VSS VSS VDD VDD _05012_ sky130_fd_sc_hd__nand3_1
X_16482_ network.in_period\[75\]\[2\] net383 _05012_ VSS VSS
+ VDD VDD _05013_ sky130_fd_sc_hd__o21ai_0
X_16483_ _04629_ _05011_ _05013_ VSS VSS VDD VDD _02365_ sky130_fd_sc_hd__a21oi_1
X_16484_ _09280_ VSS VSS VDD VDD _01902_ sky130_fd_sc_hd__inv_1
X_16485_ _09209_ _09223_ net287 VSS VSS VDD VDD _05014_ sky130_fd_sc_hd__o21ai_0
X_16486_ _09256_ _05014_ net358 VSS VSS VDD VDD _01903_ sky130_fd_sc_hd__a21oi_1
Xplace303 _07585_ VSS VSS VDD VDD net302 sky130_fd_sc_hd__buf_4
X_16488_ network.neuron_in019.counter\[0\] network.neuron_in019.counter\[2\]
+ network.neuron_in019.counter\[1\] net350 VSS VSS VDD VDD _05016_
+ sky130_fd_sc_hd__nor4_1
X_16489_ network.in_period\[19\]\[3\] _05016_ _03570_ VSS
+ VSS VDD VDD _05017_ sky130_fd_sc_hd__mux2i_1
X_16490_ network.neuron_in019.counter\[0\] network.neuron_in019.counter\[2\]
+ network.neuron_in019.counter\[1\] network.neuron_in019.counter\[3\]
+ net369 VSS VSS VDD VDD _05018_ sky130_fd_sc_hd__o311a_1
X_16491_ network.in_period\[19\]\[3\] net350 _05018_ VSS VSS
+ VDD VDD _05019_ sky130_fd_sc_hd__a21oi_1
X_16492_ network.neuron_in019.counter\[3\] _05017_ _05019_
+ VSS VSS VDD VDD _02142_ sky130_fd_sc_hd__o21ai_0
X_16493_ network.neuron_hid0.IF0.ref_counter\[1\] _09112_
+ VSS VSS VDD VDD _05020_ sky130_fd_sc_hd__nor2_1
X_16494_ _00680_ _09112_ _05020_ _09110_ VSS VSS VDD VDD _01904_
+ sky130_fd_sc_hd__a211oi_1
X_16495_ net284 _09595_ VSS VSS VDD VDD _05021_ sky130_fd_sc_hd__nand2_1
X_16496_ net708 _05021_ VSS VSS VDD VDD _05022_ sky130_fd_sc_hd__nand2_1
X_16497_ _07059_ _05022_ net362 VSS VSS VDD VDD _01905_ sky130_fd_sc_hd__a21oi_1
X_16498_ _09124_ _09118_ network.neuron_hid0.IF0.membrane_potential\[9\]
+ VSS VSS VDD VDD _05023_ sky130_fd_sc_hd__nor3b_1
X_16499_ network.neuron_hid0.IF0.membrane_potential\[10\]
+ _05023_ VSS VSS VDD VDD _05024_ sky130_fd_sc_hd__xnor2_1
X_16500_ _09110_ _05024_ VSS VSS VDD VDD _01906_ sky130_fd_sc_hd__nor2_1
X_16501_ network.neuron_in020.counter\[1\] network.neuron_in020.counter\[0\]
+ _00407_ VSS VSS VDD VDD _05025_ sky130_fd_sc_hd__o21bai_1
X_16502_ _03575_ _05025_ network.neuron_in020.counter\[3\]
+ VSS VSS VDD VDD _05026_ sky130_fd_sc_hd__a21oi_1
X_16503_ _03575_ _00406_ _00405_ network.neuron_in020.counter\[3\]
+ _05026_ VSS VSS VDD VDD _05027_ sky130_fd_sc_hd__a41o_1
X_16504_ net370 _03580_ network.in_period\[20\]\[3\] VSS VSS
+ VDD VDD _05028_ sky130_fd_sc_hd__a21oi_1
X_16505_ net370 _05027_ _05028_ VSS VSS VDD VDD _02146_ sky130_fd_sc_hd__a21oi_1
X_16506_ network.in_spk02_14 network.in_spk00_14 network.in_spk01_14
+ _09261_ network.in_spk03_14 VSS VSS VDD VDD _05029_ sky130_fd_sc_hd__o41ai_1
X_16507_ _07215_ _05029_ net358 VSS VSS VDD VDD _01907_ sky130_fd_sc_hd__a21oi_1
X_16508_ _06645_ _09109_ VSS VSS VDD VDD _01908_ sky130_fd_sc_hd__nor2_1
X_16509_ network.neuron_in021.counter\[0\] network.neuron_in021.counter\[1\]
+ network.neuron_in021.counter\[2\] VSS VSS VDD VDD _05030_
+ sky130_fd_sc_hd__nor3_1
X_16510_ network.neuron_in021.counter\[3\] _05030_ VSS VSS
+ VDD VDD _05031_ sky130_fd_sc_hd__xnor2_1
X_16511_ net772 _03592_ VSS VSS VDD VDD _05032_ sky130_fd_sc_hd__nand2_1
X_16512_ _03592_ _05031_ _05032_ VSS VSS VDD VDD _02150_ sky130_fd_sc_hd__o21ai_0
X_16513_ network.neuron_in076.counter\[3\] network.in_period\[76\]\[2\]
+ net348 _00113_ VSS VSS VDD VDD _05033_ sky130_fd_sc_hd__o22ai_1
X_16514_ network.neuron_in076.counter\[2\] _00113_ net387
+ VSS VSS VDD VDD _05034_ sky130_fd_sc_hd__nand3_1
X_16515_ network.in_period\[76\]\[2\] net387 _05034_ VSS VSS
+ VDD VDD _05035_ sky130_fd_sc_hd__o21ai_0
X_16516_ _04626_ _05033_ _05035_ VSS VSS VDD VDD _02369_ sky130_fd_sc_hd__a21oi_1
X_16517_ net486 net376 VSS VSS VDD VDD _01909_ sky130_fd_sc_hd__and2_1
X_16518_ network.in_spk04_13 network.in_spk05_13 _09402_ _09585_
+ network.in_spk06_13 VSS VSS VDD VDD _05036_ sky130_fd_sc_hd__o41ai_1
Xplace325 _07430_ VSS VSS VDD VDD net324 sky130_fd_sc_hd__buf_4
X_16520_ _07098_ _05036_ net363 VSS VSS VDD VDD _01910_ sky130_fd_sc_hd__a21oi_1
X_16521_ net795 net376 VSS VSS VDD VDD _01911_ sky130_fd_sc_hd__and2_1
X_16522_ network.neuron_in022.counter\[1\] network.neuron_in022.counter\[0\]
+ network.neuron_in022.counter\[2\] VSS VSS VDD VDD _05038_
+ sky130_fd_sc_hd__nor3_1
X_16523_ network.neuron_in022.counter\[3\] _05038_ VSS VSS
+ VDD VDD _05039_ sky130_fd_sc_hd__xnor2_1
X_16524_ network.in_period\[22\]\[3\] _03602_ VSS VSS VDD
+ VDD _05040_ sky130_fd_sc_hd__nand2_1
X_16525_ _03602_ _05039_ _05040_ VSS VSS VDD VDD _02154_ sky130_fd_sc_hd__o21ai_0
X_16526_ net728 _04955_ VSS VSS VDD VDD _05041_ sky130_fd_sc_hd__nand2_1
X_16527_ _00114_ _04955_ _05041_ VSS VSS VDD VDD _02368_ sky130_fd_sc_hd__o21ai_0
X_16528_ network.neuron_hid1.IF0.ref_counter\[1\] _09082_
+ VSS VSS VDD VDD _05042_ sky130_fd_sc_hd__nor2_1
X_16529_ _01017_ _09082_ _05042_ _09080_ VSS VSS VDD VDD _01912_
+ sky130_fd_sc_hd__a211oi_1
X_16530_ _09094_ _09088_ network.neuron_hid1.IF0.membrane_potential\[9\]
+ VSS VSS VDD VDD _05043_ sky130_fd_sc_hd__nor3b_1
X_16531_ network.neuron_hid1.IF0.membrane_potential\[10\]
+ _05043_ VSS VSS VDD VDD _05044_ sky130_fd_sc_hd__xnor2_1
X_16532_ _09080_ _05044_ VSS VSS VDD VDD _01913_ sky130_fd_sc_hd__nor2_1
X_16533_ network.neuron_in023.counter\[0\] network.neuron_in023.counter\[2\]
+ network.neuron_in023.counter\[1\] net352 VSS VSS VDD VDD _05045_
+ sky130_fd_sc_hd__nor4_1
X_16534_ network.in_period\[23\]\[3\] _05045_ _03610_ VSS
+ VSS VDD VDD _05046_ sky130_fd_sc_hd__mux2i_1
X_16535_ network.neuron_in023.counter\[0\] network.neuron_in023.counter\[2\]
+ network.neuron_in023.counter\[1\] network.neuron_in023.counter\[3\]
+ net370 VSS VSS VDD VDD _05047_ sky130_fd_sc_hd__o311a_1
X_16536_ network.in_period\[23\]\[3\] net352 _05047_ VSS VSS
+ VDD VDD _05048_ sky130_fd_sc_hd__a21oi_1
X_16537_ network.neuron_in023.counter\[3\] _05046_ _05048_
+ VSS VSS VDD VDD _02158_ sky130_fd_sc_hd__o21ai_0
X_16538_ network.in_spk04_13 _09402_ _09585_ network.in_spk05_13
+ VSS VSS VDD VDD _05049_ sky130_fd_sc_hd__o31ai_1
X_16539_ _07025_ _05049_ net363 VSS VSS VDD VDD _01914_ sky130_fd_sc_hd__a21oi_1
X_16540_ network.hid_spk1 network.hid_spk0 VSS VSS VDD VDD
+ _05050_ sky130_fd_sc_hd__nand2_1
X_16541_ _09079_ _05050_ _06645_ VSS VSS VDD VDD _01915_ sky130_fd_sc_hd__a21oi_1
X_16542_ network.neuron_in024.counter\[1\] network.neuron_in024.counter\[2\]
+ network.neuron_in024.counter\[0\] net352 VSS VSS VDD VDD _05051_
+ sky130_fd_sc_hd__nor4_1
X_16543_ network.in_period\[24\]\[3\] _05051_ _03619_ VSS
+ VSS VDD VDD _05052_ sky130_fd_sc_hd__mux2i_1
X_16544_ network.neuron_in024.counter\[1\] network.neuron_in024.counter\[2\]
+ network.neuron_in024.counter\[0\] network.neuron_in024.counter\[3\]
+ net373 VSS VSS VDD VDD _05053_ sky130_fd_sc_hd__o311a_1
X_16545_ network.in_period\[24\]\[3\] net352 _05053_ VSS VSS
+ VDD VDD _05054_ sky130_fd_sc_hd__a21oi_1
X_16546_ network.neuron_in024.counter\[3\] _05052_ _05054_
+ VSS VSS VDD VDD _02162_ sky130_fd_sc_hd__o21ai_0
X_16547_ network.neuron_in077.counter\[2\] VSS VSS VDD VDD
+ _05055_ sky130_fd_sc_hd__inv_1
X_16548_ network.neuron_in077.counter\[3\] network.in_period\[77\]\[2\]
+ net355 _00104_ VSS VSS VDD VDD _05056_ sky130_fd_sc_hd__o22ai_1
X_16549_ network.neuron_in077.counter\[2\] _00104_ net383
+ VSS VSS VDD VDD _05057_ sky130_fd_sc_hd__nand3_1
X_16550_ network.in_period\[77\]\[2\] net383 _05057_ VSS VSS
+ VDD VDD _05058_ sky130_fd_sc_hd__o21ai_0
X_16551_ _05055_ _05056_ _05058_ VSS VSS VDD VDD _02373_ sky130_fd_sc_hd__a21oi_1
X_16552_ network.neuron_hid2.IF0.ref_counter\[1\] _09046_
+ VSS VSS VDD VDD _05059_ sky130_fd_sc_hd__nor2_1
X_16553_ _00786_ _09046_ _05059_ _09044_ VSS VSS VDD VDD _01916_
+ sky130_fd_sc_hd__a211oi_1
X_16554_ network.neuron_hid2.IF0.membrane_potential\[8\] network.neuron_hid2.IF0.membrane_potential\[9\]
+ _09067_ VSS VSS VDD VDD _05060_ sky130_fd_sc_hd__nand3_1
X_16555_ network.neuron_hid2.IF0.membrane_potential\[10\]
+ _05060_ VSS VSS VDD VDD _05061_ sky130_fd_sc_hd__xor2_1
X_16556_ _09044_ _05061_ VSS VSS VDD VDD _01917_ sky130_fd_sc_hd__nor2_1
X_16557_ network.neuron_in025.counter\[0\] network.neuron_in025.counter\[1\]
+ VSS VSS VDD VDD _05062_ sky130_fd_sc_hd__nor2_1
X_16558_ _00383_ _05062_ VSS VSS VDD VDD _05063_ sky130_fd_sc_hd__nor2_1
X_16559_ network.neuron_in025.counter\[2\] _05063_ VSS VSS
+ VDD VDD _05064_ sky130_fd_sc_hd__nor2_1
X_16560_ network.neuron_in025.counter\[2\] network.neuron_in025.counter\[3\]
+ _05062_ VSS VSS VDD VDD _05065_ sky130_fd_sc_hd__nand3b_1
X_16561_ network.neuron_in025.counter\[3\] _05064_ _05065_
+ VSS VSS VDD VDD _05066_ sky130_fd_sc_hd__o21ai_0
X_16562_ net373 _03639_ network.in_period\[25\]\[3\] VSS VSS
+ VDD VDD _05067_ sky130_fd_sc_hd__a21oi_1
X_16563_ net373 _05066_ _05067_ VSS VSS VDD VDD _02166_ sky130_fd_sc_hd__a21oi_1
X_16564_ net676 _04962_ VSS VSS VDD VDD _05068_ sky130_fd_sc_hd__nand2_1
X_16565_ network.neuron_in077.counter\[0\] _04962_ _05068_
+ VSS VSS VDD VDD _02371_ sky130_fd_sc_hd__o21ai_0
X_16566_ network.neuron_hid3.IF0.membrane_potential\[9\] network.neuron_hid3.IF0.membrane_potential\[8\]
+ _09031_ VSS VSS VDD VDD _05069_ sky130_fd_sc_hd__nand3_1
X_16567_ network.neuron_hid3.IF0.membrane_potential\[10\]
+ _05069_ VSS VSS VDD VDD _05070_ sky130_fd_sc_hd__xor2_1
X_16568_ _09008_ _05070_ VSS VSS VDD VDD _01918_ sky130_fd_sc_hd__nor2_1
X_16569_ _09402_ _09585_ network.in_spk04_13 VSS VSS VDD VDD
+ _05071_ sky130_fd_sc_hd__o21ai_0
X_16570_ _07049_ _05071_ net363 VSS VSS VDD VDD _01919_ sky130_fd_sc_hd__a21oi_1
X_16571_ network.hid_spk1 network.hid_spk0 network.hid_spk2
+ VSS VSS VDD VDD _05072_ sky130_fd_sc_hd__o21ai_0
X_16572_ _09043_ _05072_ _06645_ VSS VSS VDD VDD _01920_ sky130_fd_sc_hd__a21oi_1
X_16573_ network.neuron_in026.counter\[0\] network.neuron_in026.counter\[1\]
+ _00470_ VSS VSS VDD VDD _05073_ sky130_fd_sc_hd__o21bai_1
X_16574_ _03643_ _05073_ network.neuron_in026.counter\[3\]
+ VSS VSS VDD VDD _05074_ sky130_fd_sc_hd__a21oi_1
X_16575_ _03643_ network.neuron_in026.counter\[3\] _00468_
+ _00469_ _05074_ VSS VSS VDD VDD _05075_ sky130_fd_sc_hd__a41o_1
X_16576_ net370 _03656_ network.in_period\[26\]\[3\] VSS VSS
+ VDD VDD _05076_ sky130_fd_sc_hd__a21oi_1
X_16577_ net370 _05075_ _05076_ VSS VSS VDD VDD _02170_ sky130_fd_sc_hd__a21oi_1
X_16578_ network.hid_spk2 network.hid_spk1 network.hid_spk0
+ network.hid_spk3 VSS VSS VDD VDD _05077_ sky130_fd_sc_hd__o31ai_1
X_16579_ _09007_ _05077_ _06645_ VSS VSS VDD VDD _01921_ sky130_fd_sc_hd__a21oi_1
X_16580_ network.neuron_hid3.IF0.ref_counter\[1\] _09010_
+ VSS VSS VDD VDD _05078_ sky130_fd_sc_hd__nor2_1
X_16581_ _00881_ _09010_ _05078_ _09008_ VSS VSS VDD VDD _01922_
+ sky130_fd_sc_hd__a211oi_1
X_16582_ network.neuron_in027.counter\[0\] network.neuron_in027.counter\[1\]
+ network.neuron_in027.counter\[2\] net352 VSS VSS VDD VDD _05079_
+ sky130_fd_sc_hd__nor4_1
X_16583_ network.in_period\[27\]\[3\] _05079_ _04704_ VSS
+ VSS VDD VDD _05080_ sky130_fd_sc_hd__mux2i_1
Xplace302 _07850_ VSS VSS VDD VDD net301 sky130_fd_sc_hd__buf_4
X_16585_ network.neuron_in027.counter\[0\] network.neuron_in027.counter\[1\]
+ network.neuron_in027.counter\[2\] network.neuron_in027.counter\[3\]
+ net370 VSS VSS VDD VDD _05082_ sky130_fd_sc_hd__o311a_1
X_16586_ network.in_period\[27\]\[3\] net352 _05082_ VSS VSS
+ VDD VDD _05083_ sky130_fd_sc_hd__a21oi_1
X_16587_ network.neuron_in027.counter\[3\] _05080_ _05083_
+ VSS VSS VDD VDD _02174_ sky130_fd_sc_hd__o21ai_0
X_16588_ net383 _04619_ VSS VSS VDD VDD _05084_ sky130_fd_sc_hd__nand2_1
X_16589_ net725 _05084_ VSS VSS VDD VDD _05085_ sky130_fd_sc_hd__nand2_1
X_16590_ _00101_ _05084_ _05085_ VSS VSS VDD VDD _02376_ sky130_fd_sc_hd__o21ai_0
X_16591_ network.neuron_hid4.IF0.ref_counter\[1\] _08980_
+ VSS VSS VDD VDD _05086_ sky130_fd_sc_hd__nor2_1
X_16592_ _01135_ _08980_ _05086_ _08978_ VSS VSS VDD VDD _01923_
+ sky130_fd_sc_hd__a211oi_1
X_16593_ network.in_spk00_13 network.in_spk01_13 _09585_ VSS
+ VSS VDD VDD _05087_ sky130_fd_sc_hd__or3_1
X_16594_ network.in_spk02_13 _05087_ network.in_spk03_13 VSS
+ VSS VDD VDD _05088_ sky130_fd_sc_hd__o21ai_0
X_16595_ _07020_ _05088_ net363 VSS VSS VDD VDD _01924_ sky130_fd_sc_hd__a21oi_1
X_16596_ _08992_ _08986_ network.neuron_hid4.IF0.membrane_potential\[9\]
+ VSS VSS VDD VDD _05089_ sky130_fd_sc_hd__nor3b_1
X_16597_ network.neuron_hid4.IF0.membrane_potential\[10\]
+ _05089_ VSS VSS VDD VDD _05090_ sky130_fd_sc_hd__xnor2_1
X_16598_ _08978_ _05090_ VSS VSS VDD VDD _01925_ sky130_fd_sc_hd__nor2_1
X_16599_ network.neuron_in028.counter\[1\] network.neuron_in028.counter\[2\]
+ network.neuron_in028.counter\[0\] net352 VSS VSS VDD VDD _05091_
+ sky130_fd_sc_hd__nor4_1
X_16600_ network.in_period\[28\]\[3\] _05091_ _07804_ VSS
+ VSS VDD VDD _05092_ sky130_fd_sc_hd__mux2i_1
X_16601_ network.neuron_in028.counter\[1\] network.neuron_in028.counter\[2\]
+ network.neuron_in028.counter\[0\] network.neuron_in028.counter\[3\]
+ net373 VSS VSS VDD VDD _05093_ sky130_fd_sc_hd__o311a_1
X_16602_ network.in_period\[28\]\[3\] net352 _05093_ VSS VSS
+ VDD VDD _05094_ sky130_fd_sc_hd__a21oi_1
X_16603_ network.neuron_in028.counter\[3\] _05092_ _05094_
+ VSS VSS VDD VDD _02178_ sky130_fd_sc_hd__o21ai_0
X_16604_ net691 _05084_ VSS VSS VDD VDD _05095_ sky130_fd_sc_hd__nand2_1
X_16605_ network.neuron_in078.counter\[0\] _05084_ _05095_
+ VSS VSS VDD VDD _02375_ sky130_fd_sc_hd__o21ai_0
X_16606_ network.in_spk04_14 network.in_spk05_14 _09354_ network.in_spk06_14
+ VSS VSS VDD VDD _05096_ sky130_fd_sc_hd__o31ai_1
X_16607_ _07514_ _05096_ net359 VSS VSS VDD VDD _01926_ sky130_fd_sc_hd__a21oi_1
X_16608_ network.hid_spk4 _08859_ VSS VSS VDD VDD _05097_
+ sky130_fd_sc_hd__nand2_1
X_16609_ _08977_ _05097_ _06645_ VSS VSS VDD VDD _01927_ sky130_fd_sc_hd__a21oi_1
X_16610_ network.neuron_in029.counter\[0\] network.neuron_in029.counter\[1\]
+ _00351_ VSS VSS VDD VDD _05098_ sky130_fd_sc_hd__o21bai_1
X_16611_ _07809_ _05098_ network.neuron_in029.counter\[3\]
+ VSS VSS VDD VDD _05099_ sky130_fd_sc_hd__a21oi_1
X_16612_ _07809_ _00349_ _00350_ network.neuron_in029.counter\[3\]
+ _05099_ VSS VSS VDD VDD _05100_ sky130_fd_sc_hd__a41o_1
X_16613_ net370 _07817_ network.in_period\[29\]\[3\] VSS VSS
+ VDD VDD _05101_ sky130_fd_sc_hd__a21oi_1
X_16614_ net370 _05100_ _05101_ VSS VSS VDD VDD _02182_ sky130_fd_sc_hd__a21oi_1
X_16615_ network.neuron_hid5.IF0.ref_counter\[1\] _08949_
+ VSS VSS VDD VDD _05102_ sky130_fd_sc_hd__nor2_1
X_16616_ _00918_ _08949_ _05102_ _08947_ VSS VSS VDD VDD _01928_
+ sky130_fd_sc_hd__a211oi_1
X_16617_ network.in_spk02_13 _05087_ VSS VSS VDD VDD _05103_
+ sky130_fd_sc_hd__nand2_1
X_16618_ _07084_ _05103_ net363 VSS VSS VDD VDD _01929_ sky130_fd_sc_hd__a21oi_1
X_16619_ _08961_ _08955_ network.neuron_hid5.IF0.membrane_potential\[9\]
+ VSS VSS VDD VDD _05104_ sky130_fd_sc_hd__nor3b_1
X_16620_ network.neuron_hid5.IF0.membrane_potential\[10\]
+ _05104_ VSS VSS VDD VDD _05105_ sky130_fd_sc_hd__xnor2_1
X_16621_ _08947_ _05105_ VSS VSS VDD VDD _01930_ sky130_fd_sc_hd__nor2_1
Xplace321 _07542_ VSS VSS VDD VDD net320 sky130_fd_sc_hd__buf_4
X_16623_ network.neuron_in030.counter\[1\] network.neuron_in030.counter\[0\]
+ _00436_ VSS VSS VDD VDD _05107_ sky130_fd_sc_hd__o21bai_1
X_16624_ _03634_ _05107_ network.neuron_in030.counter\[3\]
+ VSS VSS VDD VDD _05108_ sky130_fd_sc_hd__a21oi_1
X_16625_ _03634_ _00435_ network.neuron_in030.counter\[3\]
+ _00434_ _05108_ VSS VSS VDD VDD _05109_ sky130_fd_sc_hd__a41o_1
X_16626_ net369 _03633_ network.in_period\[30\]\[3\] VSS VSS
+ VDD VDD _05110_ sky130_fd_sc_hd__a21oi_1
X_16627_ net369 _05109_ _05110_ VSS VSS VDD VDD _02186_ sky130_fd_sc_hd__a21oi_1
X_16628_ network.hid_spk4 _08859_ network.hid_spk5 VSS VSS
+ VDD VDD _05111_ sky130_fd_sc_hd__o21ai_0
Xplace300 _07910_ VSS VSS VDD VDD net299 sky130_fd_sc_hd__buf_4
X_16630_ _08946_ _05111_ _06645_ VSS VSS VDD VDD _01931_ sky130_fd_sc_hd__a21oi_1
X_16631_ network.neuron_in031.counter\[1\] network.neuron_in031.counter\[0\]
+ _01204_ VSS VSS VDD VDD _05113_ sky130_fd_sc_hd__o21bai_1
X_16632_ _03662_ _05113_ network.neuron_in031.counter\[3\]
+ VSS VSS VDD VDD _05114_ sky130_fd_sc_hd__a21oi_1
X_16633_ _03662_ network.neuron_in031.counter\[3\] _01203_
+ _01202_ _05114_ VSS VSS VDD VDD _05115_ sky130_fd_sc_hd__a41o_1
Xplace301 _07885_ VSS VSS VDD VDD net300 sky130_fd_sc_hd__buf_4
X_16635_ net370 _03661_ network.in_period\[31\]\[3\] VSS VSS
+ VDD VDD _05117_ sky130_fd_sc_hd__a21oi_1
X_16636_ net370 _05115_ _05117_ VSS VSS VDD VDD _02190_ sky130_fd_sc_hd__a21oi_1
X_16637_ network.neuron_hid6.IF0.ref_counter\[1\] _08919_
+ VSS VSS VDD VDD _05118_ sky130_fd_sc_hd__nor2_1
X_16638_ _00735_ _08919_ _05118_ _08917_ VSS VSS VDD VDD _01932_
+ sky130_fd_sc_hd__a211oi_1
X_16639_ _09585_ _09592_ network.in_spk01_13 VSS VSS VDD VDD
+ _05119_ sky130_fd_sc_hd__o21ai_0
X_16640_ _07075_ _05119_ net363 VSS VSS VDD VDD _01933_ sky130_fd_sc_hd__a21oi_1
X_16641_ _08931_ _08925_ network.neuron_hid6.IF0.membrane_potential\[9\]
+ VSS VSS VDD VDD _05120_ sky130_fd_sc_hd__nor3b_1
X_16642_ network.neuron_hid6.IF0.membrane_potential\[10\]
+ _05120_ VSS VSS VDD VDD _05121_ sky130_fd_sc_hd__xnor2_1
X_16643_ _08917_ _05121_ VSS VSS VDD VDD _01934_ sky130_fd_sc_hd__nor2_1
X_16644_ network.neuron_in032.counter\[0\] network.neuron_in032.counter\[1\]
+ network.neuron_in032.counter\[2\] net354 VSS VSS VDD VDD _05122_
+ sky130_fd_sc_hd__nor4_1
X_16645_ network.in_period\[32\]\[3\] _05122_ _03666_ VSS
+ VSS VDD VDD _05123_ sky130_fd_sc_hd__mux2i_1
X_16646_ network.neuron_in032.counter\[0\] network.neuron_in032.counter\[1\]
+ network.neuron_in032.counter\[2\] network.neuron_in032.counter\[3\]
+ net371 VSS VSS VDD VDD _05124_ sky130_fd_sc_hd__o311a_1
X_16647_ network.in_period\[32\]\[3\] net354 _05124_ VSS VSS
+ VDD VDD _05125_ sky130_fd_sc_hd__a21oi_1
X_16648_ network.neuron_in032.counter\[3\] _05123_ _05125_
+ VSS VSS VDD VDD _02194_ sky130_fd_sc_hd__o21ai_0
X_16649_ network.neuron_in089.counter\[3\] network.in_period\[89\]\[2\]
+ net348 _01220_ VSS VSS VDD VDD _05126_ sky130_fd_sc_hd__o22ai_1
X_16650_ network.neuron_in089.counter\[2\] _01220_ net385
+ VSS VSS VDD VDD _05127_ sky130_fd_sc_hd__nand3_1
X_16651_ network.in_period\[89\]\[2\] net385 _05127_ VSS VSS
+ VDD VDD _05128_ sky130_fd_sc_hd__o21ai_0
X_16652_ _04574_ _05126_ _05128_ VSS VSS VDD VDD _02421_ sky130_fd_sc_hd__a21oi_1
X_16653_ network.in_spk04_14 _09354_ network.in_spk05_14 VSS
+ VSS VDD VDD _05129_ sky130_fd_sc_hd__o21ai_0
X_16654_ _07509_ _05129_ net359 VSS VSS VDD VDD _01935_ sky130_fd_sc_hd__a21oi_1
X_16655_ network.hid_spk6 _08865_ VSS VSS VDD VDD _05130_
+ sky130_fd_sc_hd__nand2_1
X_16656_ _08916_ _05130_ _06645_ VSS VSS VDD VDD _01936_ sky130_fd_sc_hd__a21oi_1
X_16657_ network.neuron_in033.counter\[0\] network.neuron_in033.counter\[1\]
+ _00577_ VSS VSS VDD VDD _05131_ sky130_fd_sc_hd__o21bai_1
X_16658_ _03701_ _05131_ network.neuron_in033.counter\[3\]
+ VSS VSS VDD VDD _05132_ sky130_fd_sc_hd__a21oi_1
X_16659_ _03701_ network.neuron_in033.counter\[3\] _00575_
+ _00576_ _05132_ VSS VSS VDD VDD _05133_ sky130_fd_sc_hd__a41o_1
X_16660_ net372 _03700_ network.in_period\[33\]\[3\] VSS VSS
+ VDD VDD _05134_ sky130_fd_sc_hd__a21oi_1
X_16661_ net372 _05133_ _05134_ VSS VSS VDD VDD _02198_ sky130_fd_sc_hd__a21oi_1
X_16662_ net384 _04599_ VSS VSS VDD VDD _05135_ sky130_fd_sc_hd__nand2_1
X_16663_ net608 _05135_ VSS VSS VDD VDD _05136_ sky130_fd_sc_hd__nand2_1
X_16664_ network.neuron_in083.counter\[0\] _05135_ _05136_
+ VSS VSS VDD VDD _02395_ sky130_fd_sc_hd__o21ai_0
X_16665_ network.neuron_hid7.IF0.ref_counter\[1\] _08881_
+ VSS VSS VDD VDD _05137_ sky130_fd_sc_hd__nor2_1
X_16666_ _01127_ _08881_ _05137_ _08879_ VSS VSS VDD VDD _01937_
+ sky130_fd_sc_hd__a211oi_1
X_16667_ network.in_spk00_13 _09585_ VSS VSS VDD VDD _05138_
+ sky130_fd_sc_hd__nand2_1
X_16668_ _06877_ _05138_ net363 VSS VSS VDD VDD _01938_ sky130_fd_sc_hd__a21oi_1
X_16669_ network.neuron_hid7.IF0.membrane_potential\[8\] network.neuron_hid7.IF0.membrane_potential\[9\]
+ _08902_ VSS VSS VDD VDD _05139_ sky130_fd_sc_hd__nand3_1
X_16670_ network.neuron_hid7.IF0.membrane_potential\[10\]
+ _05139_ VSS VSS VDD VDD _05140_ sky130_fd_sc_hd__xor2_1
X_16671_ _08879_ _05140_ VSS VSS VDD VDD _01939_ sky130_fd_sc_hd__nor2_1
X_16672_ network.neuron_in034.counter\[1\] network.neuron_in034.counter\[0\]
+ _00359_ VSS VSS VDD VDD _05141_ sky130_fd_sc_hd__o21bai_1
X_16673_ _03682_ _05141_ network.neuron_in034.counter\[3\]
+ VSS VSS VDD VDD _05142_ sky130_fd_sc_hd__a21oi_1
X_16674_ _03682_ network.neuron_in034.counter\[3\] _00358_
+ _00357_ _05142_ VSS VSS VDD VDD _05143_ sky130_fd_sc_hd__a41o_1
X_16675_ net368 _03681_ network.in_period\[34\]\[3\] VSS VSS
+ VDD VDD _05144_ sky130_fd_sc_hd__a21oi_1
X_16676_ net368 _05143_ _05144_ VSS VSS VDD VDD _02202_ sky130_fd_sc_hd__a21oi_1
X_16677_ net385 _04579_ VSS VSS VDD VDD _05145_ sky130_fd_sc_hd__nand2_1
X_16678_ net744 _05145_ VSS VSS VDD VDD _05146_ sky130_fd_sc_hd__nand2_1
X_16679_ network.neuron_in088.counter\[0\] _05145_ _05146_
+ VSS VSS VDD VDD _02415_ sky130_fd_sc_hd__o21ai_0
X_16680_ network.hid_spk6 _08865_ network.hid_spk7 VSS VSS
+ VDD VDD _05147_ sky130_fd_sc_hd__o21ai_0
X_16681_ _08878_ _05147_ _06645_ VSS VSS VDD VDD _01941_ sky130_fd_sc_hd__a21oi_1
X_16682_ network.neuron_in035.counter\[1\] network.neuron_in035.counter\[0\]
+ _00363_ VSS VSS VDD VDD _05148_ sky130_fd_sc_hd__o21bai_1
X_16683_ _03696_ _05148_ network.neuron_in035.counter\[3\]
+ VSS VSS VDD VDD _05149_ sky130_fd_sc_hd__a21oi_1
X_16684_ _03696_ network.neuron_in035.counter\[3\] _00362_
+ _00361_ _05149_ VSS VSS VDD VDD _05150_ sky130_fd_sc_hd__a41o_1
X_16685_ net371 _03695_ network.in_period\[35\]\[3\] VSS VSS
+ VDD VDD _05151_ sky130_fd_sc_hd__a21oi_1
X_16686_ net371 _05150_ _05151_ VSS VSS VDD VDD _02206_ sky130_fd_sc_hd__a21oi_1
X_16687_ network.neuron_in081.counter\[3\] network.in_period\[81\]\[2\]
+ _00083_ net357 VSS VSS VDD VDD _05152_ sky130_fd_sc_hd__o22ai_1
Xplace309 _04038_ VSS VSS VDD VDD net308 sky130_fd_sc_hd__buf_6
X_16689_ network.neuron_in081.counter\[2\] _00083_ net384
+ VSS VSS VDD VDD _05154_ sky130_fd_sc_hd__nand3_1
X_16690_ network.in_period\[81\]\[2\] net384 _05154_ VSS VSS
+ VDD VDD _05155_ sky130_fd_sc_hd__o21ai_0
X_16691_ _04606_ _05152_ _05155_ VSS VSS VDD VDD _02389_ sky130_fd_sc_hd__a21oi_1
X_16692_ _09241_ _09242_ _09257_ VSS VSS VDD VDD _05156_ sky130_fd_sc_hd__or3_1
X_16693_ _09227_ _05156_ network.in_spk15_12 VSS VSS VDD VDD
+ _05157_ sky130_fd_sc_hd__o21ai_0
X_16694_ _06999_ _05157_ net359 VSS VSS VDD VDD _01942_ sky130_fd_sc_hd__a21oi_1
X_16695_ network.hid_spk5 network.hid_spk4 _08859_ VSS VSS
+ VDD VDD _05158_ sky130_fd_sc_hd__nor3_1
X_16696_ _08866_ _05158_ _06645_ VSS VSS VDD VDD _01943_ sky130_fd_sc_hd__a21oi_1
X_16697_ network.neuron_in036.counter\[1\] network.neuron_in036.counter\[0\]
+ _00347_ VSS VSS VDD VDD _05159_ sky130_fd_sc_hd__o21bai_1
X_16698_ _03734_ _05159_ network.neuron_in036.counter\[3\]
+ VSS VSS VDD VDD _05160_ sky130_fd_sc_hd__a21oi_1
X_16699_ _03734_ _00346_ _00345_ network.neuron_in036.counter\[3\]
+ _05160_ VSS VSS VDD VDD _05161_ sky130_fd_sc_hd__a41o_1
X_16700_ net371 _03788_ network.in_period\[36\]\[3\] VSS VSS
+ VDD VDD _05162_ sky130_fd_sc_hd__a21oi_1
X_16701_ net371 _05161_ _05162_ VSS VSS VDD VDD _02210_ sky130_fd_sc_hd__a21oi_1
X_16702_ net606 _05135_ VSS VSS VDD VDD _05163_ sky130_fd_sc_hd__nand2_1
X_16703_ _00064_ _05135_ _05163_ VSS VSS VDD VDD _02396_ sky130_fd_sc_hd__o21ai_0
X_16704_ network.neuron_in037.counter\[1\] network.neuron_in037.counter\[0\]
+ _00343_ VSS VSS VDD VDD _05164_ sky130_fd_sc_hd__o21bai_1
X_16705_ _03729_ _05164_ network.neuron_in037.counter\[3\]
+ VSS VSS VDD VDD _05165_ sky130_fd_sc_hd__a21oi_1
X_16706_ _03729_ network.neuron_in037.counter\[3\] _00342_
+ _00341_ _05165_ VSS VSS VDD VDD _05166_ sky130_fd_sc_hd__a41o_1
X_16707_ net371 _03728_ network.in_period\[37\]\[3\] VSS VSS
+ VDD VDD _05167_ sky130_fd_sc_hd__a21oi_1
X_16708_ net371 _05166_ _05167_ VSS VSS VDD VDD _02214_ sky130_fd_sc_hd__a21oi_1
Xplace299 _08597_ VSS VSS VDD VDD net298 sky130_fd_sc_hd__buf_4
X_16710_ network.neuron_in086.counter\[3\] network.in_period\[86\]\[2\]
+ net358 _00040_ VSS VSS VDD VDD _05169_ sky130_fd_sc_hd__o22ai_1
X_16711_ network.neuron_in086.counter\[2\] _00040_ net377
+ VSS VSS VDD VDD _05170_ sky130_fd_sc_hd__nand3_1
X_16712_ network.in_period\[86\]\[2\] net377 _05170_ VSS VSS
+ VDD VDD _05171_ sky130_fd_sc_hd__o21ai_0
X_16713_ _04587_ _05169_ _05171_ VSS VSS VDD VDD _02409_ sky130_fd_sc_hd__a21oi_1
X_16714_ network.in_spk11_12 network.in_spk12_12 network.in_spk13_12
+ _05156_ network.in_spk14_12 VSS VSS VDD VDD _05172_ sky130_fd_sc_hd__o41ai_1
X_16715_ _06891_ _05172_ net359 VSS VSS VDD VDD _01944_ sky130_fd_sc_hd__a21oi_1
X_16716_ network.in_spk00_14 network.in_spk01_14 _09261_ network.in_spk02_14
+ VSS VSS VDD VDD _05173_ sky130_fd_sc_hd__o31ai_1
X_16717_ _07205_ _05173_ net359 VSS VSS VDD VDD _01945_ sky130_fd_sc_hd__a21oi_1
X_16718_ network.neuron_in038.counter\[1\] network.neuron_in038.counter\[0\]
+ _00331_ VSS VSS VDD VDD _05174_ sky130_fd_sc_hd__o21bai_1
X_16719_ _03743_ _05174_ network.neuron_in038.counter\[3\]
+ VSS VSS VDD VDD _05175_ sky130_fd_sc_hd__a21oi_1
X_16720_ _03743_ _00330_ _00329_ network.neuron_in038.counter\[3\]
+ _05175_ VSS VSS VDD VDD _05176_ sky130_fd_sc_hd__a41o_1
X_16721_ net371 _03742_ net631 VSS VSS VDD VDD _05177_ sky130_fd_sc_hd__a21oi_1
X_16722_ net371 _05176_ _05177_ VSS VSS VDD VDD _02218_ sky130_fd_sc_hd__a21oi_1
X_16723_ network.in_period\[88\]\[1\] _05145_ VSS VSS VDD
+ VDD _05178_ sky130_fd_sc_hd__nand2_1
X_16724_ _01217_ _05145_ _05178_ VSS VSS VDD VDD _02416_ sky130_fd_sc_hd__o21ai_0
X_16725_ network.neuron_in039.counter\[1\] network.neuron_in039.counter\[0\]
+ VSS VSS VDD VDD _05179_ sky130_fd_sc_hd__nor2_1
X_16726_ _00327_ _05179_ VSS VSS VDD VDD _05180_ sky130_fd_sc_hd__nor2_1
X_16727_ network.neuron_in039.counter\[2\] _05180_ VSS VSS
+ VDD VDD _05181_ sky130_fd_sc_hd__nor2_1
X_16728_ network.neuron_in039.counter\[2\] network.neuron_in039.counter\[3\]
+ _05179_ VSS VSS VDD VDD _05182_ sky130_fd_sc_hd__nand3b_1
X_16729_ network.neuron_in039.counter\[3\] _05181_ _05182_
+ VSS VSS VDD VDD _05183_ sky130_fd_sc_hd__o21ai_0
X_16730_ net375 _03724_ network.in_period\[39\]\[3\] VSS VSS
+ VDD VDD _05184_ sky130_fd_sc_hd__a21oi_1
X_16731_ net375 _05183_ _05184_ VSS VSS VDD VDD _02222_ sky130_fd_sc_hd__a21oi_1
X_16732_ network.in_spk11_12 network.in_spk12_12 _05156_ network.in_spk13_12
+ VSS VSS VDD VDD _05185_ sky130_fd_sc_hd__o31ai_1
Xplace298 _08610_ VSS VSS VDD VDD net297 sky130_fd_sc_hd__buf_4
X_16734_ _06986_ _05185_ net359 VSS VSS VDD VDD _01946_ sky130_fd_sc_hd__a21oi_1
X_16735_ network.in_spk04_14 _09354_ VSS VSS VDD VDD _05187_
+ sky130_fd_sc_hd__nand2_1
X_16736_ _07123_ _05187_ net358 VSS VSS VDD VDD _01947_ sky130_fd_sc_hd__a21oi_1
X_16737_ network.neuron_in040.counter\[1\] network.neuron_in040.counter\[2\]
+ network.neuron_in040.counter\[0\] net355 VSS VSS VDD VDD _05188_
+ sky130_fd_sc_hd__nor4_1
X_16738_ network.in_period\[40\]\[3\] _05188_ _03861_ VSS
+ VSS VDD VDD _05189_ sky130_fd_sc_hd__mux2i_1
X_16739_ network.neuron_in040.counter\[1\] network.neuron_in040.counter\[2\]
+ network.neuron_in040.counter\[0\] network.neuron_in040.counter\[3\]
+ net375 VSS VSS VDD VDD _05190_ sky130_fd_sc_hd__o311a_1
X_16740_ network.in_period\[40\]\[3\] net355 _05190_ VSS VSS
+ VDD VDD _05191_ sky130_fd_sc_hd__a21oi_1
X_16741_ network.neuron_in040.counter\[3\] _05189_ _05191_
+ VSS VSS VDD VDD _02226_ sky130_fd_sc_hd__o21ai_0
X_16742_ net384 _04612_ VSS VSS VDD VDD _05192_ sky130_fd_sc_hd__nand2_1
X_16743_ net647 _05192_ VSS VSS VDD VDD _05193_ sky130_fd_sc_hd__nand2_1
X_16744_ network.neuron_in080.counter\[0\] _05192_ _05193_
+ VSS VSS VDD VDD _02383_ sky130_fd_sc_hd__o21ai_0
X_16745_ network.neuron_in041.counter\[1\] network.neuron_in041.counter\[0\]
+ network.neuron_in041.counter\[2\] VSS VSS VDD VDD _05194_
+ sky130_fd_sc_hd__nor3_1
X_16746_ network.neuron_in041.counter\[3\] _05194_ VSS VSS
+ VDD VDD _05195_ sky130_fd_sc_hd__xnor2_1
X_16747_ network.in_period\[41\]\[3\] _03881_ VSS VSS VDD
+ VDD _05196_ sky130_fd_sc_hd__nand2_1
X_16748_ _03881_ _05195_ _05196_ VSS VSS VDD VDD _02230_ sky130_fd_sc_hd__o21ai_0
X_16749_ network.neuron_in082.counter\[3\] network.in_period\[82\]\[2\]
+ net357 _00059_ VSS VSS VDD VDD _05197_ sky130_fd_sc_hd__o22ai_1
X_16750_ network.neuron_in082.counter\[2\] _00059_ net386
+ VSS VSS VDD VDD _05198_ sky130_fd_sc_hd__nand3_1
X_16751_ network.in_period\[82\]\[2\] net386 _05198_ VSS VSS
+ VDD VDD _05199_ sky130_fd_sc_hd__o21ai_0
X_16752_ _04602_ _05197_ _05199_ VSS VSS VDD VDD _02393_ sky130_fd_sc_hd__a21oi_1
X_16753_ network.arbit.counter\[0\] network.arbit.counter\[1\]
+ network.arbit.counter\[2\] _08729_ VSS VSS VDD VDD _05200_
+ sky130_fd_sc_hd__nor4_1
X_16754_ net480 _05200_ VSS VSS VDD VDD _05201_ sky130_fd_sc_hd__xnor2_1
X_16755_ net389 _05201_ VSS VSS VDD VDD _01948_ sky130_fd_sc_hd__nand2_1
X_16756_ _09338_ _09408_ network.in_spk12_12 VSS VSS VDD VDD
+ _05202_ sky130_fd_sc_hd__o21ai_0
X_16757_ _06981_ _05202_ net364 VSS VSS VDD VDD _01949_ sky130_fd_sc_hd__a21oi_1
X_16758_ network.neuron_in042.counter\[1\] network.neuron_in042.counter\[0\]
+ network.neuron_in042.counter\[2\] VSS VSS VDD VDD _05203_
+ sky130_fd_sc_hd__nor3_1
X_16759_ network.neuron_in042.counter\[3\] _05203_ VSS VSS
+ VDD VDD _05204_ sky130_fd_sc_hd__xnor2_1
X_16760_ network.in_period\[42\]\[3\] _03838_ VSS VSS VDD
+ VDD _05205_ sky130_fd_sc_hd__nand2_1
X_16761_ _03838_ _05204_ _05205_ VSS VSS VDD VDD _02234_ sky130_fd_sc_hd__o21ai_0
X_16762_ network.neuron_in083.counter\[3\] network.in_period\[83\]\[2\]
+ net357 _00063_ VSS VSS VDD VDD _05206_ sky130_fd_sc_hd__o22ai_1
Xplace297 _09203_ VSS VSS VDD VDD net296 sky130_fd_sc_hd__buf_4
X_16764_ network.neuron_in083.counter\[2\] _00063_ net384
+ VSS VSS VDD VDD _05208_ sky130_fd_sc_hd__nand3_1
X_16765_ network.in_period\[83\]\[2\] net384 _05208_ VSS VSS
+ VDD VDD _05209_ sky130_fd_sc_hd__o21ai_0
X_16766_ _04598_ _05206_ _05209_ VSS VSS VDD VDD _02397_ sky130_fd_sc_hd__a21oi_1
X_16767_ net413 loaded\[7\] VSS VSS VDD VDD _05210_ sky130_fd_sc_hd__nand2_1
X_16768_ _08709_ _05210_ VSS VSS VDD VDD _05211_ sky130_fd_sc_hd__nor2_1
X_16769_ loaded\[8\] _05211_ VSS VSS VDD VDD _05212_ sky130_fd_sc_hd__xnor2_1
X_16770_ _08699_ _05212_ VSS VSS VDD VDD _01950_ sky130_fd_sc_hd__nor2_1
X_16771_ _06644_ state\[0\] VSS VSS VDD VDD _05213_ sky130_fd_sc_hd__nand2_1
X_16772_ _08697_ _05213_ net447 VSS VSS VDD VDD _01951_ sky130_fd_sc_hd__a21oi_1
X_16773_ network.neuron_in043.counter\[1\] network.neuron_in043.counter\[2\]
+ network.neuron_in043.counter\[0\] net354 VSS VSS VDD VDD _05214_
+ sky130_fd_sc_hd__nor4_1
X_16774_ network.in_period\[43\]\[3\] _05214_ _04125_ VSS
+ VSS VDD VDD _05215_ sky130_fd_sc_hd__mux2i_1
X_16775_ network.neuron_in043.counter\[1\] network.neuron_in043.counter\[2\]
+ network.neuron_in043.counter\[0\] network.neuron_in043.counter\[3\]
+ net375 VSS VSS VDD VDD _05216_ sky130_fd_sc_hd__o311a_1
X_16776_ network.in_period\[43\]\[3\] net354 _05216_ VSS VSS
+ VDD VDD _05217_ sky130_fd_sc_hd__a21oi_1
X_16777_ network.neuron_in043.counter\[3\] _05215_ _05217_
+ VSS VSS VDD VDD _02238_ sky130_fd_sc_hd__o21ai_0
X_16778_ net386 _04595_ VSS VSS VDD VDD _05218_ sky130_fd_sc_hd__nand2_1
X_16779_ net718 _05218_ VSS VSS VDD VDD _05219_ sky130_fd_sc_hd__nand2_1
X_16780_ network.neuron_in084.counter\[0\] _05218_ _05219_
+ VSS VSS VDD VDD _02399_ sky130_fd_sc_hd__o21ai_0
X_16781_ net310 _08612_ _08616_ net45 VSS VSS VDD VDD _05220_
+ sky130_fd_sc_hd__a22oi_1
X_16782_ net447 _05220_ VSS VSS VDD VDD _01952_ sky130_fd_sc_hd__nor2_1
X_16783_ network.in_spk11_12 _05156_ VSS VSS VDD VDD _05221_
+ sky130_fd_sc_hd__nand2_1
X_16784_ _06886_ _05221_ net359 VSS VSS VDD VDD _01953_ sky130_fd_sc_hd__a21oi_1
X_16785_ net31 net32 _08646_ VSS VSS VDD VDD _05222_ sky130_fd_sc_hd__nand3_1
X_16786_ net310 _05222_ VSS VSS VDD VDD _05223_ sky130_fd_sc_hd__nand2_1
X_16787_ _06611_ _05222_ VSS VSS VDD VDD _05224_ sky130_fd_sc_hd__nor2_1
X_16788_ net33 _05224_ VSS VSS VDD VDD _05225_ sky130_fd_sc_hd__nor2_1
X_16789_ net459 _08638_ _05223_ _05225_ net447 VSS VSS VDD
+ VDD _01954_ sky130_fd_sc_hd__a311oi_1
X_16790_ network.neuron_in044.counter\[1\] network.neuron_in044.counter\[0\]
+ network.neuron_in044.counter\[2\] net355 VSS VSS VDD VDD _05226_
+ sky130_fd_sc_hd__nor4_1
X_16791_ network.in_period\[44\]\[3\] _05226_ _04130_ VSS
+ VSS VDD VDD _05227_ sky130_fd_sc_hd__mux2i_1
X_16792_ network.neuron_in044.counter\[1\] network.neuron_in044.counter\[0\]
+ network.neuron_in044.counter\[2\] network.neuron_in044.counter\[3\]
+ net372 VSS VSS VDD VDD _05228_ sky130_fd_sc_hd__o311a_1
X_16793_ network.in_period\[44\]\[3\] net355 _05228_ VSS VSS
+ VDD VDD _05229_ sky130_fd_sc_hd__a21oi_1
X_16794_ network.neuron_in044.counter\[3\] _05227_ _05229_
+ VSS VSS VDD VDD _02242_ sky130_fd_sc_hd__o21ai_0
X_16795_ net384 _04591_ VSS VSS VDD VDD _05230_ sky130_fd_sc_hd__nand2_1
X_16796_ net685 _05230_ VSS VSS VDD VDD _05231_ sky130_fd_sc_hd__nand2_1
X_16797_ network.neuron_in085.counter\[0\] _05230_ _05231_
+ VSS VSS VDD VDD _02403_ sky130_fd_sc_hd__o21ai_0
X_16798_ net447 _08616_ VSS VSS VDD VDD _01955_ sky130_fd_sc_hd__nor2_1
X_16799_ net47 VSS VSS VDD VDD _05232_ sky130_fd_sc_hd__inv_1
X_16800_ _08588_ net297 VSS VSS VDD VDD _05233_ sky130_fd_sc_hd__nor2_1
X_16801_ _08606_ _05233_ _08602_ VSS VSS VDD VDD _05234_ sky130_fd_sc_hd__o21ai_0
X_16802_ _05232_ _08616_ _05234_ net310 VSS VSS VDD VDD _05235_
+ sky130_fd_sc_hd__a22oi_1
X_16803_ net447 _05235_ VSS VSS VDD VDD _01956_ sky130_fd_sc_hd__or2_2
X_16804_ network.neuron_in045.counter\[0\] network.neuron_in045.counter\[1\]
+ network.neuron_in045.counter\[2\] VSS VSS VDD VDD _05236_
+ sky130_fd_sc_hd__nor3_1
X_16805_ network.neuron_in045.counter\[3\] _05236_ VSS VSS
+ VDD VDD _05237_ sky130_fd_sc_hd__xnor2_1
X_16806_ network.in_period\[45\]\[3\] _04118_ VSS VSS VDD
+ VDD _05238_ sky130_fd_sc_hd__nand2_1
X_16807_ _04118_ _05237_ _05238_ VSS VSS VDD VDD _02246_ sky130_fd_sc_hd__o21ai_0
X_16808_ network.neuron_in087.counter\[3\] network.in_period\[87\]\[2\]
+ net357 _00036_ VSS VSS VDD VDD _05239_ sky130_fd_sc_hd__o22ai_1
X_16809_ network.neuron_in087.counter\[2\] _00036_ net385
+ VSS VSS VDD VDD _05240_ sky130_fd_sc_hd__nand3_1
X_16810_ network.in_period\[87\]\[2\] net385 _05240_ VSS VSS
+ VDD VDD _05241_ sky130_fd_sc_hd__o21ai_0
X_16811_ _04582_ _05239_ _05241_ VSS VSS VDD VDD _02413_ sky130_fd_sc_hd__a21oi_1
X_16812_ network.in_spk08_12 network.in_spk09_12 _09338_ network.in_spk10_12
+ VSS VSS VDD VDD _05242_ sky130_fd_sc_hd__o31ai_1
X_16813_ _06906_ _05242_ net364 VSS VSS VDD VDD _01957_ sky130_fd_sc_hd__a21oi_1
X_16814_ net444 net43 _08719_ _08698_ net25 VSS VSS VDD VDD
+ _05243_ sky130_fd_sc_hd__a32oi_1
X_16815_ net23 _05243_ VSS VSS VDD VDD _01958_ sky130_fd_sc_hd__nor2_1
X_16816_ network.neuron_in046.counter\[1\] network.neuron_in046.counter\[2\]
+ network.neuron_in046.counter\[0\] VSS VSS VDD VDD _05244_
+ sky130_fd_sc_hd__nor3_1
X_16817_ network.neuron_in046.counter\[3\] _05244_ VSS VSS
+ VDD VDD _05245_ sky130_fd_sc_hd__xnor2_1
X_16818_ net745 _04123_ VSS VSS VDD VDD _05246_ sky130_fd_sc_hd__nand2_1
X_16819_ _04123_ _05245_ _05246_ VSS VSS VDD VDD _02250_ sky130_fd_sc_hd__o21ai_0
X_16820_ network.neuron_in088.counter\[3\] network.in_period\[88\]\[2\]
+ net348 _01216_ VSS VSS VDD VDD _05247_ sky130_fd_sc_hd__o22ai_1
X_16821_ network.neuron_in088.counter\[2\] _01216_ net385
+ VSS VSS VDD VDD _05248_ sky130_fd_sc_hd__nand3_1
X_16822_ network.in_period\[88\]\[2\] net385 _05248_ VSS VSS
+ VDD VDD _05249_ sky130_fd_sc_hd__o21ai_0
X_16823_ _04578_ _05247_ _05249_ VSS VSS VDD VDD _02417_ sky130_fd_sc_hd__a21oi_1
X_16824_ network.neuron_in047.counter\[0\] network.neuron_in047.counter\[1\]
+ _00275_ VSS VSS VDD VDD _05250_ sky130_fd_sc_hd__o21bai_1
X_16825_ _04157_ _05250_ network.neuron_in047.counter\[3\]
+ VSS VSS VDD VDD _05251_ sky130_fd_sc_hd__a21oi_1
X_16826_ _04157_ _00273_ _00274_ network.neuron_in047.counter\[3\]
+ _05251_ VSS VSS VDD VDD _05252_ sky130_fd_sc_hd__a41o_1
X_16827_ net372 _04156_ network.in_period\[47\]\[3\] VSS VSS
+ VDD VDD _05253_ sky130_fd_sc_hd__a21oi_1
X_16828_ net372 _05252_ _05253_ VSS VSS VDD VDD _02254_ sky130_fd_sc_hd__a21oi_1
X_16829_ network.in_spk08_12 _09338_ network.in_spk09_12 VSS
+ VSS VDD VDD _05254_ sky130_fd_sc_hd__o21ai_0
X_16830_ _06882_ _05254_ net364 VSS VSS VDD VDD _01959_ sky130_fd_sc_hd__a21oi_1
X_16831_ network.neuron_in048.counter\[0\] network.neuron_in048.counter\[2\]
+ network.neuron_in048.counter\[1\] net352 VSS VSS VDD VDD _05255_
+ sky130_fd_sc_hd__nor4_1
X_16832_ network.in_period\[48\]\[3\] _05255_ _04162_ VSS
+ VSS VDD VDD _05256_ sky130_fd_sc_hd__mux2i_1
Xplace419 net419 VSS VSS VDD VDD net418 sky130_fd_sc_hd__buf_4
X_16834_ network.neuron_in048.counter\[0\] network.neuron_in048.counter\[2\]
+ network.neuron_in048.counter\[1\] network.neuron_in048.counter\[3\]
+ net373 VSS VSS VDD VDD _05258_ sky130_fd_sc_hd__o311a_1
X_16835_ network.in_period\[48\]\[3\] net352 _05258_ VSS VSS
+ VDD VDD _05259_ sky130_fd_sc_hd__a21oi_1
X_16836_ network.neuron_in048.counter\[3\] _05256_ _05259_
+ VSS VSS VDD VDD _02258_ sky130_fd_sc_hd__o21ai_0
Xplace418 net452 VSS VSS VDD VDD net417 sky130_fd_sc_hd__buf_4
X_16838_ network.neuron_in049.counter\[0\] network.neuron_in049.counter\[2\]
+ network.neuron_in049.counter\[1\] net352 VSS VSS VDD VDD _05261_
+ sky130_fd_sc_hd__nor4_1
X_16839_ network.in_period\[49\]\[3\] _05261_ _04148_ VSS
+ VSS VDD VDD _05262_ sky130_fd_sc_hd__mux2i_1
X_16840_ network.neuron_in049.counter\[0\] network.neuron_in049.counter\[2\]
+ network.neuron_in049.counter\[1\] network.neuron_in049.counter\[3\]
+ net374 VSS VSS VDD VDD _05263_ sky130_fd_sc_hd__o311a_1
X_16841_ network.in_period\[49\]\[3\] net352 _05263_ VSS VSS
+ VDD VDD _05264_ sky130_fd_sc_hd__a21oi_1
X_16842_ network.neuron_in049.counter\[3\] _05262_ _05264_
+ VSS VSS VDD VDD _02262_ sky130_fd_sc_hd__o21ai_0
X_16843_ network.neuron_in080.counter\[3\] network.in_period\[80\]\[2\]
+ net357 _00088_ VSS VSS VDD VDD _05265_ sky130_fd_sc_hd__o22ai_1
X_16844_ network.neuron_in080.counter\[2\] _00088_ net384
+ VSS VSS VDD VDD _05266_ sky130_fd_sc_hd__nand3_1
X_16845_ network.in_period\[80\]\[2\] net384 _05266_ VSS VSS
+ VDD VDD _05267_ sky130_fd_sc_hd__o21ai_0
X_16846_ _04610_ _05265_ _05267_ VSS VSS VDD VDD _02385_ sky130_fd_sc_hd__a21oi_1
X_16847_ network.in_spk08_12 _09338_ VSS VSS VDD VDD _05268_
+ sky130_fd_sc_hd__nand2_1
X_16848_ _06967_ _05268_ net364 VSS VSS VDD VDD _01960_ sky130_fd_sc_hd__a21oi_1
X_16849_ network.neuron_in050.counter\[1\] network.neuron_in050.counter\[2\]
+ network.neuron_in050.counter\[0\] VSS VSS VDD VDD _05269_
+ sky130_fd_sc_hd__nor3_1
X_16850_ network.neuron_in050.counter\[3\] _05269_ VSS VSS
+ VDD VDD _05270_ sky130_fd_sc_hd__xnor2_1
X_16851_ net714 _04169_ VSS VSS VDD VDD _05271_ sky130_fd_sc_hd__nand2_1
X_16852_ _04169_ _05270_ _05271_ VSS VSS VDD VDD _02266_ sky130_fd_sc_hd__o21ai_0
X_16853_ net639 _05192_ VSS VSS VDD VDD _05272_ sky130_fd_sc_hd__nand2_1
X_16854_ _00089_ _05192_ _05272_ VSS VSS VDD VDD _02384_ sky130_fd_sc_hd__o21ai_0
X_16855_ network.neuron_in051.counter\[0\] network.neuron_in051.counter\[2\]
+ network.neuron_in051.counter\[1\] net350 VSS VSS VDD VDD _05273_
+ sky130_fd_sc_hd__nor4_1
X_16856_ network.in_period\[51\]\[3\] _05273_ _04172_ VSS
+ VSS VDD VDD _05274_ sky130_fd_sc_hd__mux2i_1
X_16857_ network.neuron_in051.counter\[0\] network.neuron_in051.counter\[2\]
+ network.neuron_in051.counter\[1\] network.neuron_in051.counter\[3\]
+ net369 VSS VSS VDD VDD _05275_ sky130_fd_sc_hd__o311a_1
X_16858_ network.in_period\[51\]\[3\] net350 _05275_ VSS VSS
+ VDD VDD _05276_ sky130_fd_sc_hd__a21oi_1
X_16859_ network.neuron_in051.counter\[3\] _05274_ _05276_
+ VSS VSS VDD VDD _02270_ sky130_fd_sc_hd__o21ai_0
X_16860_ net384 _04608_ VSS VSS VDD VDD _05277_ sky130_fd_sc_hd__nand2_1
X_16861_ network.in_period\[81\]\[1\] _05277_ VSS VSS VDD
+ VDD _05278_ sky130_fd_sc_hd__nand2_1
X_16862_ _00084_ _05277_ _05278_ VSS VSS VDD VDD _02388_ sky130_fd_sc_hd__o21ai_0
X_16863_ network.in_spk04_12 network.in_spk05_12 network.in_spk06_12
+ _09409_ net692 VSS VSS VDD VDD _05279_ sky130_fd_sc_hd__o41ai_1
X_16864_ _06930_ _05279_ net364 VSS VSS VDD VDD _01961_ sky130_fd_sc_hd__a21oi_1
X_16865_ network.neuron_in052.counter\[0\] network.neuron_in052.counter\[2\]
+ network.neuron_in052.counter\[1\] net352 VSS VSS VDD VDD _05280_
+ sky130_fd_sc_hd__nor4_1
X_16866_ network.in_period\[52\]\[3\] _05280_ _04225_ VSS
+ VSS VDD VDD _05281_ sky130_fd_sc_hd__mux2i_1
X_16867_ network.neuron_in052.counter\[0\] network.neuron_in052.counter\[2\]
+ network.neuron_in052.counter\[1\] network.neuron_in052.counter\[3\]
+ net370 VSS VSS VDD VDD _05282_ sky130_fd_sc_hd__o311a_1
X_16868_ network.in_period\[52\]\[3\] net352 _05282_ VSS VSS
+ VDD VDD _05283_ sky130_fd_sc_hd__a21oi_1
X_16869_ network.neuron_in052.counter\[3\] _05281_ _05283_
+ VSS VSS VDD VDD _02274_ sky130_fd_sc_hd__o21ai_0
X_16870_ network.in_period\[81\]\[0\] _05277_ VSS VSS VDD
+ VDD _05284_ sky130_fd_sc_hd__nand2_1
X_16871_ network.neuron_in081.counter\[0\] _05277_ _05284_
+ VSS VSS VDD VDD _02387_ sky130_fd_sc_hd__o21ai_0
Xclkbuf_leaf_0_clk_net clknet_4_0_0_clk_net VSS VSS VDD VDD
+ clknet_leaf_0_clk_net sky130_fd_sc_hd__clkbuf_16
X_16873_ network.neuron_in053.counter\[0\] network.neuron_in053.counter\[1\]
+ _00255_ VSS VSS VDD VDD _05286_ sky130_fd_sc_hd__o21bai_1
X_16874_ _04246_ _05286_ network.neuron_in053.counter\[3\]
+ VSS VSS VDD VDD _05287_ sky130_fd_sc_hd__a21oi_1
X_16875_ _04246_ _00253_ _00254_ network.neuron_in053.counter\[3\]
+ _05287_ VSS VSS VDD VDD _05288_ sky130_fd_sc_hd__a41o_1
X_16876_ net370 _04245_ network.in_period\[53\]\[3\] VSS VSS
+ VDD VDD _05289_ sky130_fd_sc_hd__a21oi_1
X_16877_ net370 _05288_ _05289_ VSS VSS VDD VDD _02278_ sky130_fd_sc_hd__a21oi_1
X_16878_ net386 _04603_ VSS VSS VDD VDD _05290_ sky130_fd_sc_hd__nand2_1
X_16879_ network.in_period\[82\]\[1\] _05290_ VSS VSS VDD
+ VDD _05291_ sky130_fd_sc_hd__nand2_1
X_16880_ _00060_ _05290_ _05291_ VSS VSS VDD VDD _02392_ sky130_fd_sc_hd__o21ai_0
X_16881_ network.in_spk04_12 network.in_spk05_12 _09409_ network.in_spk06_12
+ VSS VSS VDD VDD _05292_ sky130_fd_sc_hd__o31ai_1
X_16882_ _06763_ _05292_ net364 VSS VSS VDD VDD _01962_ sky130_fd_sc_hd__a21oi_1
X_16883_ network.neuron_in054.counter\[0\] network.neuron_in054.counter\[1\]
+ network.neuron_in054.counter\[2\] net350 VSS VSS VDD VDD _05293_
+ sky130_fd_sc_hd__nor4_1
X_16884_ network.in_period\[54\]\[3\] _05293_ _04267_ VSS
+ VSS VDD VDD _05294_ sky130_fd_sc_hd__mux2i_1
Xclkload2 clknet_2_3__leaf_clk_root_regs VSS VSS VDD VDD _unconnected_64
+ sky130_fd_sc_hd__clkinv_4
X_16886_ network.neuron_in054.counter\[0\] network.neuron_in054.counter\[1\]
+ network.neuron_in054.counter\[2\] network.neuron_in054.counter\[3\]
+ net371 VSS VSS VDD VDD _05296_ sky130_fd_sc_hd__o311a_1
X_16887_ network.in_period\[54\]\[3\] net350 _05296_ VSS VSS
+ VDD VDD _05297_ sky130_fd_sc_hd__a21oi_1
X_16888_ network.neuron_in054.counter\[3\] _05294_ _05297_
+ VSS VSS VDD VDD _02282_ sky130_fd_sc_hd__o21ai_0
X_16889_ network.in_period\[82\]\[0\] _05290_ VSS VSS VDD
+ VDD _05298_ sky130_fd_sc_hd__nand2_1
X_16890_ network.neuron_in082.counter\[0\] _05290_ _05298_
+ VSS VSS VDD VDD _02391_ sky130_fd_sc_hd__o21ai_0
X_16891_ network.neuron_in055.counter\[1\] network.neuron_in055.counter\[0\]
+ _00243_ VSS VSS VDD VDD _05299_ sky130_fd_sc_hd__o21bai_1
X_16892_ _04254_ _05299_ network.neuron_in055.counter\[3\]
+ VSS VSS VDD VDD _05300_ sky130_fd_sc_hd__a21oi_1
X_16893_ _04254_ _00242_ _00241_ network.neuron_in055.counter\[3\]
+ _05300_ VSS VSS VDD VDD _05301_ sky130_fd_sc_hd__a41o_1
Xclkbuf_leaf_4_clk_net clknet_4_0_0_clk_net VSS VSS VDD VDD
+ clknet_leaf_4_clk_net sky130_fd_sc_hd__clkbuf_16
X_16895_ net370 _04253_ network.in_period\[55\]\[3\] VSS VSS
+ VDD VDD _05303_ sky130_fd_sc_hd__a21oi_1
X_16896_ net370 _05301_ _05303_ VSS VSS VDD VDD _02286_ sky130_fd_sc_hd__a21oi_1
X_16897_ network.neuron_in084.counter\[3\] network.in_period\[84\]\[2\]
+ net357 _00051_ VSS VSS VDD VDD _05304_ sky130_fd_sc_hd__o22ai_1
X_16898_ network.neuron_in084.counter\[2\] _00051_ net386
+ VSS VSS VDD VDD _05305_ sky130_fd_sc_hd__nand3_1
X_16899_ network.in_period\[84\]\[2\] net386 _05305_ VSS VSS
+ VDD VDD _05306_ sky130_fd_sc_hd__o21ai_0
X_16900_ _04594_ _05304_ _05306_ VSS VSS VDD VDD _02401_ sky130_fd_sc_hd__a21oi_1
X_16901_ network.in_spk04_12 _09409_ network.in_spk05_12 VSS
+ VSS VDD VDD _05307_ sky130_fd_sc_hd__o21ai_0
X_16902_ _06863_ _05307_ net364 VSS VSS VDD VDD _01963_ sky130_fd_sc_hd__a21oi_1
X_16903_ network.neuron_in056.counter\[1\] network.neuron_in056.counter\[2\]
+ network.neuron_in056.counter\[0\] net352 VSS VSS VDD VDD _05308_
+ sky130_fd_sc_hd__nor4_1
X_16904_ network.in_period\[56\]\[3\] _05308_ _04259_ VSS
+ VSS VDD VDD _05309_ sky130_fd_sc_hd__mux2i_1
X_16905_ network.neuron_in056.counter\[1\] network.neuron_in056.counter\[2\]
+ network.neuron_in056.counter\[0\] network.neuron_in056.counter\[3\]
+ net374 VSS VSS VDD VDD _05310_ sky130_fd_sc_hd__o311a_1
X_16906_ network.in_period\[56\]\[3\] net352 _05310_ VSS VSS
+ VDD VDD _05311_ sky130_fd_sc_hd__a21oi_1
X_16907_ network.neuron_in056.counter\[3\] _05309_ _05311_
+ VSS VSS VDD VDD _02290_ sky130_fd_sc_hd__o21ai_0
X_16908_ net681 _05218_ VSS VSS VDD VDD _05312_ sky130_fd_sc_hd__nand2_1
X_16909_ _00052_ _05218_ _05312_ VSS VSS VDD VDD _02400_ sky130_fd_sc_hd__o21ai_0
X_16910_ network.neuron_in057.counter\[0\] network.neuron_in057.counter\[1\]
+ _00239_ VSS VSS VDD VDD _05313_ sky130_fd_sc_hd__o21bai_1
X_16911_ _04231_ _05313_ network.neuron_in057.counter\[3\]
+ VSS VSS VDD VDD _05314_ sky130_fd_sc_hd__a21oi_1
X_16912_ _04231_ _00237_ _00238_ network.neuron_in057.counter\[3\]
+ _05314_ VSS VSS VDD VDD _05315_ sky130_fd_sc_hd__a41o_1
X_16913_ net371 _04230_ network.in_period\[57\]\[3\] VSS VSS
+ VDD VDD _05316_ sky130_fd_sc_hd__a21oi_1
X_16914_ net371 _05315_ _05316_ VSS VSS VDD VDD _02294_ sky130_fd_sc_hd__a21oi_1
X_16915_ network.neuron_in085.counter\[2\] VSS VSS VDD VDD
+ _05317_ sky130_fd_sc_hd__inv_1
X_16916_ network.neuron_in085.counter\[3\] network.in_period\[85\]\[2\]
+ net357 _00044_ VSS VSS VDD VDD _05318_ sky130_fd_sc_hd__o22ai_1
X_16917_ network.neuron_in085.counter\[2\] _00044_ net384
+ VSS VSS VDD VDD _05319_ sky130_fd_sc_hd__nand3_1
X_16918_ network.in_period\[85\]\[2\] net384 _05319_ VSS VSS
+ VDD VDD _05320_ sky130_fd_sc_hd__o21ai_0
X_16919_ _05317_ _05318_ _05320_ VSS VSS VDD VDD _02405_ sky130_fd_sc_hd__a21oi_1
X_16920_ network.in_spk04_12 _09409_ VSS VSS VDD VDD _05321_
+ sky130_fd_sc_hd__nand2_1
Xclkbuf_leaf_3_clk_net clknet_4_0_0_clk_net VSS VSS VDD VDD
+ clknet_leaf_3_clk_net sky130_fd_sc_hd__clkbuf_16
X_16922_ _06777_ _05321_ net364 VSS VSS VDD VDD _01964_ sky130_fd_sc_hd__a21oi_1
X_16923_ network.neuron_in058.counter\[1\] network.neuron_in058.counter\[0\]
+ _00227_ VSS VSS VDD VDD _05323_ sky130_fd_sc_hd__o21bai_1
X_16924_ _04292_ _05323_ network.neuron_in058.counter\[3\]
+ VSS VSS VDD VDD _05324_ sky130_fd_sc_hd__a21oi_1
X_16925_ _04292_ _00226_ _00225_ network.neuron_in058.counter\[3\]
+ _05324_ VSS VSS VDD VDD _05325_ sky130_fd_sc_hd__a41o_1
X_16926_ net375 _04291_ network.in_period\[58\]\[3\] VSS VSS
+ VDD VDD _05326_ sky130_fd_sc_hd__a21oi_1
X_16927_ net375 _05325_ _05326_ VSS VSS VDD VDD _02298_ sky130_fd_sc_hd__a21oi_1
X_16928_ net723 _05230_ VSS VSS VDD VDD _05327_ sky130_fd_sc_hd__nand2_1
X_16929_ _00045_ _05230_ _05327_ VSS VSS VDD VDD _02404_ sky130_fd_sc_hd__o21ai_0
X_16930_ network.neuron_in059.counter\[0\] network.neuron_in059.counter\[1\]
+ network.neuron_in059.counter\[2\] net353 VSS VSS VDD VDD _05328_
+ sky130_fd_sc_hd__nor4_1
X_16931_ network.in_period\[59\]\[3\] _05328_ _04286_ VSS
+ VSS VDD VDD _05329_ sky130_fd_sc_hd__mux2i_1
X_16932_ network.neuron_in059.counter\[0\] network.neuron_in059.counter\[1\]
+ network.neuron_in059.counter\[2\] network.neuron_in059.counter\[3\]
+ net375 VSS VSS VDD VDD _05330_ sky130_fd_sc_hd__o311a_1
X_16933_ network.in_period\[59\]\[3\] net353 _05330_ VSS VSS
+ VDD VDD _05331_ sky130_fd_sc_hd__a21oi_1
X_16934_ network.neuron_in059.counter\[3\] _05329_ _05331_
+ VSS VSS VDD VDD _02302_ sky130_fd_sc_hd__o21ai_0
Xclkbuf_leaf_1_clk_net clknet_4_0_0_clk_net VSS VSS VDD VDD
+ clknet_leaf_1_clk_net sky130_fd_sc_hd__clkbuf_16
X_16936_ net377 _04588_ VSS VSS VDD VDD _05333_ sky130_fd_sc_hd__nand2_1
X_16937_ net648 _05333_ VSS VSS VDD VDD _05334_ sky130_fd_sc_hd__nand2_1
X_16938_ _00041_ _05333_ _05334_ VSS VSS VDD VDD _02408_ sky130_fd_sc_hd__o21ai_0
X_16939_ network.in_spk00_12 network.in_spk01_12 _09254_ VSS
+ VSS VDD VDD _05335_ sky130_fd_sc_hd__or3_1
X_16940_ network.in_spk02_12 _05335_ network.in_spk03_12 VSS
+ VSS VDD VDD _05336_ sky130_fd_sc_hd__o21ai_0
X_16941_ _06852_ _05336_ net364 VSS VSS VDD VDD _01965_ sky130_fd_sc_hd__a21oi_1
X_16942_ network.neuron_in060.counter\[0\] network.neuron_in060.counter\[2\]
+ network.neuron_in060.counter\[1\] net353 VSS VSS VDD VDD _05337_
+ sky130_fd_sc_hd__nor4_1
X_16943_ network.in_period\[60\]\[3\] _05337_ _04281_ VSS
+ VSS VDD VDD _05338_ sky130_fd_sc_hd__mux2i_1
X_16944_ network.neuron_in060.counter\[0\] network.neuron_in060.counter\[2\]
+ network.neuron_in060.counter\[1\] network.neuron_in060.counter\[3\]
+ net374 VSS VSS VDD VDD _05339_ sky130_fd_sc_hd__o311a_1
X_16945_ network.in_period\[60\]\[3\] net353 _05339_ VSS VSS
+ VDD VDD _05340_ sky130_fd_sc_hd__a21oi_1
X_16946_ network.neuron_in060.counter\[3\] _05338_ _05340_
+ VSS VSS VDD VDD _02306_ sky130_fd_sc_hd__o21ai_0
X_16947_ net758 _05333_ VSS VSS VDD VDD _05341_ sky130_fd_sc_hd__nand2_1
X_16948_ network.neuron_in086.counter\[0\] _05333_ _05341_
+ VSS VSS VDD VDD _02407_ sky130_fd_sc_hd__o21ai_0
X_16949_ network.neuron_in061.counter\[1\] network.neuron_in061.counter\[2\]
+ network.neuron_in061.counter\[0\] VSS VSS VDD VDD _05342_
+ sky130_fd_sc_hd__nor3_1
X_16950_ network.neuron_in061.counter\[3\] _05342_ VSS VSS
+ VDD VDD _05343_ sky130_fd_sc_hd__xnor2_1
X_16951_ network.in_period\[61\]\[3\] _04385_ VSS VSS VDD
+ VDD _05344_ sky130_fd_sc_hd__nand2_1
X_16952_ _04385_ _05343_ _05344_ VSS VSS VDD VDD _02310_ sky130_fd_sc_hd__o21ai_0
X_16953_ net385 _04583_ VSS VSS VDD VDD _05345_ sky130_fd_sc_hd__nand2_1
X_16954_ network.in_period\[87\]\[1\] _05345_ VSS VSS VDD
+ VDD _05346_ sky130_fd_sc_hd__nand2_1
X_16955_ _00037_ _05345_ _05346_ VSS VSS VDD VDD _02412_ sky130_fd_sc_hd__o21ai_0
X_16956_ network.in_spk02_12 _05335_ VSS VSS VDD VDD _05347_
+ sky130_fd_sc_hd__nand2_1
X_16957_ _06847_ _05347_ net364 VSS VSS VDD VDD _01966_ sky130_fd_sc_hd__a21oi_1
X_16958_ network.neuron_in062.counter\[0\] network.neuron_in062.counter\[1\]
+ network.neuron_in062.counter\[2\] net353 VSS VSS VDD VDD _05348_
+ sky130_fd_sc_hd__nor4_1
X_16959_ network.in_period\[62\]\[3\] _05348_ _04361_ VSS
+ VSS VDD VDD _05349_ sky130_fd_sc_hd__mux2i_1
X_16960_ network.neuron_in062.counter\[0\] network.neuron_in062.counter\[1\]
+ network.neuron_in062.counter\[2\] network.neuron_in062.counter\[3\]
+ net375 VSS VSS VDD VDD _05350_ sky130_fd_sc_hd__o311a_1
X_16961_ network.in_period\[62\]\[3\] net353 _05350_ VSS VSS
+ VDD VDD _05351_ sky130_fd_sc_hd__a21oi_1
X_16962_ network.neuron_in062.counter\[3\] _05349_ _05351_
+ VSS VSS VDD VDD _02314_ sky130_fd_sc_hd__o21ai_0
X_16963_ network.in_period\[87\]\[0\] _05345_ VSS VSS VDD
+ VDD _05352_ sky130_fd_sc_hd__nand2_1
X_16964_ network.neuron_in087.counter\[0\] _05345_ _05352_
+ VSS VSS VDD VDD _02411_ sky130_fd_sc_hd__o21ai_0
X_16965_ network.neuron_in063.counter\[1\] network.neuron_in063.counter\[2\]
+ network.neuron_in063.counter\[0\] net354 VSS VSS VDD VDD _05353_
+ sky130_fd_sc_hd__nor4_1
X_16966_ network.in_period\[63\]\[3\] _05353_ _04392_ VSS
+ VSS VDD VDD _05354_ sky130_fd_sc_hd__mux2i_1
X_16967_ network.neuron_in063.counter\[1\] network.neuron_in063.counter\[2\]
+ network.neuron_in063.counter\[0\] network.neuron_in063.counter\[3\]
+ net374 VSS VSS VDD VDD _05355_ sky130_fd_sc_hd__o311a_1
X_16968_ network.in_period\[63\]\[3\] net354 _05355_ VSS VSS
+ VDD VDD _05356_ sky130_fd_sc_hd__a21oi_1
X_16969_ network.neuron_in063.counter\[3\] _05354_ _05356_
+ VSS VSS VDD VDD _02318_ sky130_fd_sc_hd__o21ai_0
X_16970_ network.in_spk00_12 _09416_ network.in_spk01_12 VSS
+ VSS VDD VDD _05357_ sky130_fd_sc_hd__o21ai_0
X_16971_ _06773_ _05357_ net364 VSS VSS VDD VDD _01967_ sky130_fd_sc_hd__a21oi_1
X_16972_ network.neuron_in064.counter\[0\] network.neuron_in064.counter\[1\]
+ network.neuron_in064.counter\[2\] net349 VSS VSS VDD VDD _05358_
+ sky130_fd_sc_hd__nor4_1
X_16973_ network.in_period\[64\]\[3\] _05358_ _04356_ VSS
+ VSS VDD VDD _05359_ sky130_fd_sc_hd__mux2i_1
Xclkload1 clknet_2_2__leaf_clk_root_regs VSS VSS VDD VDD _unconnected_65
+ sky130_fd_sc_hd__clkinv_2
X_16975_ network.neuron_in064.counter\[0\] network.neuron_in064.counter\[1\]
+ network.neuron_in064.counter\[2\] network.neuron_in064.counter\[3\]
+ net372 VSS VSS VDD VDD _05361_ sky130_fd_sc_hd__o311a_1
X_16976_ network.in_period\[64\]\[3\] net349 _05361_ VSS VSS
+ VDD VDD _05362_ sky130_fd_sc_hd__a21oi_1
X_16977_ network.neuron_in064.counter\[3\] _05359_ _05362_
+ VSS VSS VDD VDD _02322_ sky130_fd_sc_hd__o21ai_0
Xclkload0 clknet_2_0__leaf_clk_root_regs VSS VSS VDD VDD _unconnected_66
+ sky130_fd_sc_hd__clkinv_2
X_16979_ network.neuron_in065.counter\[0\] network.neuron_in065.counter\[2\]
+ network.neuron_in065.counter\[1\] net354 VSS VSS VDD VDD _05364_
+ sky130_fd_sc_hd__nor4_1
X_16980_ network.in_period\[65\]\[3\] _05364_ _04417_ VSS
+ VSS VDD VDD _05365_ sky130_fd_sc_hd__mux2i_1
X_16981_ network.neuron_in065.counter\[0\] network.neuron_in065.counter\[2\]
+ network.neuron_in065.counter\[1\] network.neuron_in065.counter\[3\]
+ net372 VSS VSS VDD VDD _05366_ sky130_fd_sc_hd__o311a_1
X_16982_ network.in_period\[65\]\[3\] net354 _05366_ VSS VSS
+ VDD VDD _05367_ sky130_fd_sc_hd__a21oi_1
X_16983_ network.neuron_in065.counter\[3\] _05365_ _05367_
+ VSS VSS VDD VDD _02326_ sky130_fd_sc_hd__o21ai_0
X_16984_ net385 _04563_ VSS VSS VDD VDD _05368_ sky130_fd_sc_hd__nand2_1
X_16985_ network.in_period\[92\]\[1\] _05368_ VSS VSS VDD
+ VDD _05369_ sky130_fd_sc_hd__nand2_1
X_16986_ _01230_ _05368_ _05369_ VSS VSS VDD VDD _02432_ sky130_fd_sc_hd__o21ai_0
X_16987_ network.in_spk00_12 _09416_ VSS VSS VDD VDD _05370_
+ sky130_fd_sc_hd__nand2_1
X_16988_ _06791_ _05370_ net364 VSS VSS VDD VDD _01968_ sky130_fd_sc_hd__a21oi_1
X_16989_ network.neuron_in066.counter\[1\] network.neuron_in066.counter\[2\]
+ network.neuron_in066.counter\[0\] net354 VSS VSS VDD VDD _05371_
+ sky130_fd_sc_hd__nor4_1
X_16990_ network.in_period\[66\]\[3\] _05371_ _04422_ VSS
+ VSS VDD VDD _05372_ sky130_fd_sc_hd__mux2i_1
X_16991_ network.neuron_in066.counter\[1\] network.neuron_in066.counter\[2\]
+ network.neuron_in066.counter\[0\] network.neuron_in066.counter\[3\]
+ net375 VSS VSS VDD VDD _05373_ sky130_fd_sc_hd__o311a_1
X_16992_ network.in_period\[66\]\[3\] net354 _05373_ VSS VSS
+ VDD VDD _05374_ sky130_fd_sc_hd__a21oi_1
X_16993_ network.neuron_in066.counter\[3\] _05372_ _05374_
+ VSS VSS VDD VDD _02330_ sky130_fd_sc_hd__o21ai_0
X_16994_ net374 _04550_ VSS VSS VDD VDD _05375_ sky130_fd_sc_hd__nand2_1
X_16995_ network.in_period\[96\]\[0\] _05375_ VSS VSS VDD
+ VDD _05376_ sky130_fd_sc_hd__nand2_1
X_16996_ network.neuron_in096.counter\[0\] _05375_ _05376_
+ VSS VSS VDD VDD _02447_ sky130_fd_sc_hd__o21ai_0
X_16997_ network.neuron_in067.counter\[0\] network.neuron_in067.counter\[1\]
+ network.neuron_in067.counter\[2\] net354 VSS VSS VDD VDD _05377_
+ sky130_fd_sc_hd__nor4_1
X_16998_ network.in_period\[67\]\[3\] _05377_ _04400_ VSS
+ VSS VDD VDD _05378_ sky130_fd_sc_hd__mux2i_1
X_16999_ network.neuron_in067.counter\[0\] network.neuron_in067.counter\[1\]
+ network.neuron_in067.counter\[2\] network.neuron_in067.counter\[3\]
+ net375 VSS VSS VDD VDD _05379_ sky130_fd_sc_hd__o311a_1
X_17000_ network.in_period\[67\]\[3\] net354 _05379_ VSS VSS
+ VDD VDD _05380_ sky130_fd_sc_hd__a21oi_1
X_17001_ network.neuron_in067.counter\[3\] _05378_ _05380_
+ VSS VSS VDD VDD _02334_ sky130_fd_sc_hd__o21ai_0
X_17002_ net385 _04571_ VSS VSS VDD VDD _05381_ sky130_fd_sc_hd__nand2_1
X_17003_ net770 _05381_ VSS VSS VDD VDD _05382_ sky130_fd_sc_hd__nand2_1
X_17004_ _00598_ _05381_ _05382_ VSS VSS VDD VDD _02424_ sky130_fd_sc_hd__o21ai_0
X_17005_ net285 _03386_ VSS VSS VDD VDD _05383_ sky130_fd_sc_hd__or2_2
X_17006_ network.in_spk12_11 network.in_spk13_11 _05383_ VSS
+ VSS VDD VDD _05384_ sky130_fd_sc_hd__or3_1
X_17007_ network.in_spk14_11 _05384_ network.in_spk15_11 VSS
+ VSS VDD VDD _05385_ sky130_fd_sc_hd__o21ai_0
X_17008_ _06768_ _05385_ net362 VSS VSS VDD VDD _01969_ sky130_fd_sc_hd__a21oi_1
X_17009_ network.neuron_in068.counter\[1\] network.neuron_in068.counter\[2\]
+ network.neuron_in068.counter\[0\] net354 VSS VSS VDD VDD _05386_
+ sky130_fd_sc_hd__nor4_1
X_17010_ network.in_period\[68\]\[3\] _05386_ _04458_ VSS
+ VSS VDD VDD _05387_ sky130_fd_sc_hd__mux2i_1
Xclkbuf_leaf_2_clk_net clknet_4_0_0_clk_net VSS VSS VDD VDD
+ clknet_leaf_2_clk_net sky130_fd_sc_hd__clkbuf_16
X_17012_ network.neuron_in068.counter\[1\] network.neuron_in068.counter\[2\]
+ network.neuron_in068.counter\[0\] network.neuron_in068.counter\[3\]
+ net374 VSS VSS VDD VDD _05389_ sky130_fd_sc_hd__o311a_1
X_17013_ network.in_period\[68\]\[3\] net354 _05389_ VSS VSS
+ VDD VDD _05390_ sky130_fd_sc_hd__a21oi_1
X_17014_ network.neuron_in068.counter\[3\] _05387_ _05390_
+ VSS VSS VDD VDD _02338_ sky130_fd_sc_hd__o21ai_0
X_17015_ network.neuron_in092.counter\[2\] net385 VSS VSS
+ VDD VDD _05391_ sky130_fd_sc_hd__nand2_1
X_17016_ network.neuron_in092.counter\[3\] network.in_period\[92\]\[2\]
+ _05391_ VSS VSS VDD VDD _05392_ sky130_fd_sc_hd__o21ai_0
X_17017_ _01229_ network.neuron_in092.counter\[2\] net358
+ VSS VSS VDD VDD _05393_ sky130_fd_sc_hd__or3_1
X_17018_ network.in_period\[92\]\[2\] net385 _05393_ VSS VSS
+ VDD VDD _05394_ sky130_fd_sc_hd__o21ai_0
X_17019_ _01229_ _05392_ _05394_ VSS VSS VDD VDD _02433_ sky130_fd_sc_hd__a21oi_1
X_17020_ network.neuron_in069.counter\[0\] network.neuron_in069.counter\[1\]
+ network.neuron_in069.counter\[2\] VSS VSS VDD VDD _05395_
+ sky130_fd_sc_hd__nor3_1
X_17021_ network.neuron_in069.counter\[3\] _05395_ VSS VSS
+ VDD VDD _05396_ sky130_fd_sc_hd__xnor2_1
X_17022_ network.in_period\[69\]\[3\] _04468_ VSS VSS VDD
+ VDD _05397_ sky130_fd_sc_hd__nand2_1
X_17023_ _04468_ _05396_ _05397_ VSS VSS VDD VDD _02342_ sky130_fd_sc_hd__o21ai_0
X_17024_ net377 _04557_ VSS VSS VDD VDD _05398_ sky130_fd_sc_hd__nand2_1
X_17025_ net784 _05398_ VSS VSS VDD VDD _05399_ sky130_fd_sc_hd__nand2_1
X_17026_ _01238_ _05398_ _05399_ VSS VSS VDD VDD _02440_ sky130_fd_sc_hd__o21ai_0
X_17027_ network.in_spk14_11 _05384_ VSS VSS VDD VDD _05400_
+ sky130_fd_sc_hd__nand2_1
X_17028_ _06828_ _05400_ net362 VSS VSS VDD VDD _01970_ sky130_fd_sc_hd__a21oi_1
X_17029_ network.neuron_in070.counter\[1\] network.neuron_in070.counter\[2\]
+ network.neuron_in070.counter\[0\] VSS VSS VDD VDD _05401_
+ sky130_fd_sc_hd__nor3_1
X_17030_ network.neuron_in070.counter\[3\] _05401_ VSS VSS
+ VDD VDD _05402_ sky130_fd_sc_hd__xnor2_1
X_17031_ network.in_period\[70\]\[3\] _04473_ VSS VSS VDD
+ VDD _05403_ sky130_fd_sc_hd__nand2_1
X_17032_ _04473_ _05402_ _05403_ VSS VSS VDD VDD _02346_ sky130_fd_sc_hd__o21ai_0
X_17033_ network.in_period\[96\]\[1\] _05375_ VSS VSS VDD
+ VDD _05404_ sky130_fd_sc_hd__nand2_1
X_17034_ _01213_ _05375_ _05404_ VSS VSS VDD VDD _02448_ sky130_fd_sc_hd__o21ai_0
X_17035_ network.neuron_in071.counter\[1\] network.neuron_in071.counter\[0\]
+ _00141_ VSS VSS VDD VDD _05405_ sky130_fd_sc_hd__o21bai_1
X_17036_ _04497_ _05405_ network.neuron_in071.counter\[3\]
+ VSS VSS VDD VDD _05406_ sky130_fd_sc_hd__a21oi_1
X_17037_ _04497_ _00140_ _00139_ network.neuron_in071.counter\[3\]
+ _05406_ VSS VSS VDD VDD _05407_ sky130_fd_sc_hd__a41o_1
X_17038_ net372 _04496_ network.in_period\[71\]\[3\] VSS VSS
+ VDD VDD _05408_ sky130_fd_sc_hd__a21oi_1
X_17039_ net372 _05407_ _05408_ VSS VSS VDD VDD _02350_ sky130_fd_sc_hd__a21oi_1
X_17040_ net385 _04575_ VSS VSS VDD VDD _05409_ sky130_fd_sc_hd__nand2_1
X_17041_ network.in_period\[89\]\[0\] _05409_ VSS VSS VDD
+ VDD _05410_ sky130_fd_sc_hd__nand2_1
X_17042_ network.neuron_in089.counter\[0\] _05409_ _05410_
+ VSS VSS VDD VDD _02419_ sky130_fd_sc_hd__o21ai_0
X_17043_ network.in_spk12_11 _05383_ network.in_spk13_11 VSS
+ VSS VDD VDD _05411_ sky130_fd_sc_hd__o21ai_0
X_17044_ _06823_ _05411_ net362 VSS VSS VDD VDD _01971_ sky130_fd_sc_hd__a21oi_1
X_17045_ network.neuron_in072.counter\[0\] network.neuron_in072.counter\[2\]
+ network.neuron_in072.counter\[1\] net348 VSS VSS VDD VDD _05412_
+ sky130_fd_sc_hd__nor4_1
X_17046_ network.in_period\[72\]\[3\] _05412_ _04491_ VSS
+ VSS VDD VDD _05413_ sky130_fd_sc_hd__mux2i_1
X_17047_ network.neuron_in072.counter\[0\] network.neuron_in072.counter\[2\]
+ network.neuron_in072.counter\[1\] network.neuron_in072.counter\[3\]
+ net387 VSS VSS VDD VDD _05414_ sky130_fd_sc_hd__o311a_1
X_17048_ network.in_period\[72\]\[3\] net348 _05414_ VSS VSS
+ VDD VDD _05415_ sky130_fd_sc_hd__a21oi_1
X_17049_ network.neuron_in072.counter\[3\] _05413_ _05415_
+ VSS VSS VDD VDD _02354_ sky130_fd_sc_hd__o21ai_0
X_17050_ network.neuron_in090.counter\[2\] VSS VSS VDD VDD
+ _05416_ sky130_fd_sc_hd__inv_1
X_17051_ network.neuron_in090.counter\[3\] network.in_period\[90\]\[2\]
+ net348 _00597_ VSS VSS VDD VDD _05417_ sky130_fd_sc_hd__o22ai_1
Xclkbuf_2_3__f_clk_root_regs clknet_0_clk_root_regs VSS VSS
+ VDD VDD clknet_2_3__leaf_clk_root_regs sky130_fd_sc_hd__clkbuf_16
X_17053_ network.neuron_in090.counter\[2\] _00597_ net385
+ VSS VSS VDD VDD _05419_ sky130_fd_sc_hd__nand3_1
X_17054_ network.in_period\[90\]\[2\] net385 _05419_ VSS VSS
+ VDD VDD _05420_ sky130_fd_sc_hd__o21ai_0
X_17055_ _05416_ _05417_ _05420_ VSS VSS VDD VDD _02425_ sky130_fd_sc_hd__a21oi_1
X_17056_ network.neuron_in073.counter\[1\] network.neuron_in073.counter\[0\]
+ _00133_ VSS VSS VDD VDD _05421_ sky130_fd_sc_hd__o21bai_1
X_17057_ _04503_ _05421_ network.neuron_in073.counter\[3\]
+ VSS VSS VDD VDD _05422_ sky130_fd_sc_hd__a21oi_1
X_17058_ _04503_ _00132_ _00131_ network.neuron_in073.counter\[3\]
+ _05422_ VSS VSS VDD VDD _05423_ sky130_fd_sc_hd__a41o_1
X_17059_ net383 _04502_ network.in_period\[73\]\[3\] VSS VSS
+ VDD VDD _05424_ sky130_fd_sc_hd__a21oi_1
X_17060_ net383 _05423_ _05424_ VSS VSS VDD VDD _02358_ sky130_fd_sc_hd__a21oi_1
X_17061_ net385 _04568_ VSS VSS VDD VDD _05425_ sky130_fd_sc_hd__nand2_1
X_17062_ network.in_period\[91\]\[1\] _05425_ VSS VSS VDD
+ VDD _05426_ sky130_fd_sc_hd__nand2_1
X_17063_ _00138_ _05425_ _05426_ VSS VSS VDD VDD _02428_ sky130_fd_sc_hd__o21ai_0
X_17064_ network.in_spk12_11 _05383_ VSS VSS VDD VDD _05427_
+ sky130_fd_sc_hd__nand2_1
X_17065_ _06658_ _05427_ net362 VSS VSS VDD VDD _01972_ sky130_fd_sc_hd__a21oi_1
X_17066_ network.neuron_in074.counter\[1\] network.neuron_in074.counter\[0\]
+ _00121_ VSS VSS VDD VDD _05428_ sky130_fd_sc_hd__o21bai_1
X_17067_ _04486_ _05428_ network.neuron_in074.counter\[3\]
+ VSS VSS VDD VDD _05429_ sky130_fd_sc_hd__a21oi_1
X_17068_ _04486_ _00120_ _00119_ network.neuron_in074.counter\[3\]
+ _05429_ VSS VSS VDD VDD _05430_ sky130_fd_sc_hd__a41o_1
X_17069_ net383 _04485_ network.in_period\[74\]\[3\] VSS VSS
+ VDD VDD _05431_ sky130_fd_sc_hd__a21oi_1
X_17070_ net383 _05430_ _05431_ VSS VSS VDD VDD _02362_ sky130_fd_sc_hd__a21oi_1
X_17071_ network.neuron_in075.counter\[0\] network.neuron_in075.counter\[2\]
+ network.neuron_in075.counter\[1\] net348 VSS VSS VDD VDD _05432_
+ sky130_fd_sc_hd__nor4_1
X_17072_ network.in_period\[75\]\[3\] _05432_ _04630_ VSS
+ VSS VDD VDD _05433_ sky130_fd_sc_hd__mux2i_1
X_17073_ network.neuron_in075.counter\[0\] network.neuron_in075.counter\[2\]
+ network.neuron_in075.counter\[1\] network.neuron_in075.counter\[3\]
+ net383 VSS VSS VDD VDD _05434_ sky130_fd_sc_hd__o311a_1
X_17074_ network.in_period\[75\]\[3\] net348 _05434_ VSS VSS
+ VDD VDD _05435_ sky130_fd_sc_hd__a21oi_1
X_17075_ network.neuron_in075.counter\[3\] _05433_ _05435_
+ VSS VSS VDD VDD _02366_ sky130_fd_sc_hd__o21ai_0
Xclkbuf_2_2__f_clk_root_regs clknet_0_clk_root_regs VSS VSS
+ VDD VDD clknet_2_2__leaf_clk_root_regs sky130_fd_sc_hd__clkbuf_16
X_17077_ net377 _04560_ VSS VSS VDD VDD _05437_ sky130_fd_sc_hd__nand2_1
X_17078_ network.in_period\[93\]\[1\] _05437_ VSS VSS VDD
+ VDD _05438_ sky130_fd_sc_hd__nand2_1
X_17079_ _01234_ _05437_ _05438_ VSS VSS VDD VDD _02436_ sky130_fd_sc_hd__o21ai_0
X_17080_ network.neuron_in105.counter\[0\] VSS VSS VDD VDD
+ _00496_ sky130_fd_sc_hd__inv_1
X_17081_ network.in_spk08_11 network.in_spk09_11 _09325_ VSS
+ VSS VDD VDD _05439_ sky130_fd_sc_hd__or3_1
X_17082_ network.in_spk10_11 _05439_ network.in_spk11_11 VSS
+ VSS VDD VDD _05440_ sky130_fd_sc_hd__o21ai_1
X_17083_ _06707_ _05440_ net361 VSS VSS VDD VDD _01973_ sky130_fd_sc_hd__a21oi_1
X_17084_ network.neuron_in076.counter\[1\] network.neuron_in076.counter\[0\]
+ _00113_ VSS VSS VDD VDD _05441_ sky130_fd_sc_hd__o21bai_1
X_17085_ _04626_ _05441_ network.neuron_in076.counter\[3\]
+ VSS VSS VDD VDD _05442_ sky130_fd_sc_hd__a21oi_1
X_17086_ _04626_ _00112_ _00111_ network.neuron_in076.counter\[3\]
+ _05442_ VSS VSS VDD VDD _05443_ sky130_fd_sc_hd__a41o_1
X_17087_ net387 _04625_ network.in_period\[76\]\[3\] VSS VSS
+ VDD VDD _05444_ sky130_fd_sc_hd__a21oi_1
X_17088_ net387 _05443_ _05444_ VSS VSS VDD VDD _02370_ sky130_fd_sc_hd__a21oi_1
X_17089_ network.neuron_in094.counter\[2\] net377 VSS VSS
+ VDD VDD _05445_ sky130_fd_sc_hd__nand2_1
X_17090_ network.neuron_in094.counter\[3\] network.in_period\[94\]\[2\]
+ _05445_ VSS VSS VDD VDD _05446_ sky130_fd_sc_hd__o21ai_0
X_17091_ _01237_ network.neuron_in094.counter\[2\] net358
+ VSS VSS VDD VDD _05447_ sky130_fd_sc_hd__or3_1
X_17092_ network.in_period\[94\]\[2\] net377 _05447_ VSS VSS
+ VDD VDD _05448_ sky130_fd_sc_hd__o21ai_0
X_17093_ _01237_ _05446_ _05448_ VSS VSS VDD VDD _02441_ sky130_fd_sc_hd__a21oi_1
X_17094_ network.neuron_in077.counter\[0\] network.neuron_in077.counter\[1\]
+ network.neuron_in077.counter\[2\] VSS VSS VDD VDD _05449_
+ sky130_fd_sc_hd__nor3_1
X_17095_ network.neuron_in077.counter\[3\] _05449_ VSS VSS
+ VDD VDD _05450_ sky130_fd_sc_hd__xnor2_1
X_17096_ net748 _04962_ VSS VSS VDD VDD _05451_ sky130_fd_sc_hd__nand2_1
X_17097_ _04962_ _05450_ _05451_ VSS VSS VDD VDD _02374_ sky130_fd_sc_hd__o21ai_0
X_17098_ network.neuron_in095.counter\[2\] net377 VSS VSS
+ VDD VDD _05452_ sky130_fd_sc_hd__nand2_1
X_17099_ network.neuron_in095.counter\[3\] network.in_period\[95\]\[2\]
+ _05452_ VSS VSS VDD VDD _05453_ sky130_fd_sc_hd__o21ai_0
X_17100_ _01247_ network.neuron_in095.counter\[2\] net358
+ VSS VSS VDD VDD _05454_ sky130_fd_sc_hd__or3_1
X_17101_ network.in_period\[95\]\[2\] net377 _05454_ VSS VSS
+ VDD VDD _05455_ sky130_fd_sc_hd__o21ai_0
X_17102_ _01247_ _05453_ _05455_ VSS VSS VDD VDD _02445_ sky130_fd_sc_hd__a21oi_1
X_17103_ network.in_spk10_11 _05439_ VSS VSS VDD VDD _05456_
+ sky130_fd_sc_hd__nand2_1
Xclkbuf_2_1__f_clk_root_regs clknet_0_clk_root_regs VSS VSS
+ VDD VDD clknet_2_1__leaf_clk_root_regs sky130_fd_sc_hd__clkbuf_16
X_17105_ _06673_ _05456_ net361 VSS VSS VDD VDD _01974_ sky130_fd_sc_hd__a21oi_1
X_17106_ network.neuron_in078.counter\[1\] network.neuron_in078.counter\[0\]
+ network.neuron_in078.counter\[2\] net355 VSS VSS VDD VDD _05458_
+ sky130_fd_sc_hd__nor4_1
X_17107_ network.in_period\[78\]\[3\] _05458_ _04618_ VSS
+ VSS VDD VDD _05459_ sky130_fd_sc_hd__mux2i_1
X_17108_ network.neuron_in078.counter\[1\] network.neuron_in078.counter\[0\]
+ network.neuron_in078.counter\[2\] network.neuron_in078.counter\[3\]
+ net383 VSS VSS VDD VDD _05460_ sky130_fd_sc_hd__o311a_1
X_17109_ network.in_period\[78\]\[3\] net355 _05460_ VSS VSS
+ VDD VDD _05461_ sky130_fd_sc_hd__a21oi_1
X_17110_ network.neuron_in078.counter\[3\] _05459_ _05461_
+ VSS VSS VDD VDD _02378_ sky130_fd_sc_hd__o21ai_0
X_17111_ network.neuron_in096.counter\[3\] network.in_period\[96\]\[2\]
+ net353 _01212_ VSS VSS VDD VDD _05462_ sky130_fd_sc_hd__o22ai_1
X_17112_ network.neuron_in096.counter\[2\] _01212_ net374
+ VSS VSS VDD VDD _05463_ sky130_fd_sc_hd__nand3_1
X_17113_ network.in_period\[96\]\[2\] net374 _05463_ VSS VSS
+ VDD VDD _05464_ sky130_fd_sc_hd__o21ai_0
X_17114_ _04549_ _05462_ _05464_ VSS VSS VDD VDD _02449_ sky130_fd_sc_hd__a21oi_1
X_17115_ network.neuron_in079.counter\[0\] network.neuron_in079.counter\[1\]
+ network.neuron_in079.counter\[2\] net355 VSS VSS VDD VDD _05465_
+ sky130_fd_sc_hd__nor4_1
X_17116_ network.in_period\[79\]\[3\] _05465_ _04614_ VSS
+ VSS VDD VDD _05466_ sky130_fd_sc_hd__mux2i_1
X_17117_ network.neuron_in079.counter\[0\] network.neuron_in079.counter\[1\]
+ network.neuron_in079.counter\[2\] network.neuron_in079.counter\[3\]
+ net383 VSS VSS VDD VDD _05467_ sky130_fd_sc_hd__o311a_1
X_17118_ network.in_period\[79\]\[3\] net355 _05467_ VSS VSS
+ VDD VDD _05468_ sky130_fd_sc_hd__a21oi_1
X_17119_ network.neuron_in079.counter\[3\] _05466_ _05468_
+ VSS VSS VDD VDD _02382_ sky130_fd_sc_hd__o21ai_0
X_17120_ network.in_spk08_11 _09325_ network.in_spk09_11 VSS
+ VSS VDD VDD _05469_ sky130_fd_sc_hd__o21ai_0
X_17121_ _06744_ _05469_ net361 VSS VSS VDD VDD _01975_ sky130_fd_sc_hd__a21oi_1
X_17122_ network.neuron_in080.counter\[1\] network.neuron_in080.counter\[0\]
+ network.neuron_in080.counter\[2\] net357 VSS VSS VDD VDD _05470_
+ sky130_fd_sc_hd__nor4_1
X_17123_ network.in_period\[80\]\[3\] _05470_ _04611_ VSS
+ VSS VDD VDD _05471_ sky130_fd_sc_hd__mux2i_1
X_17124_ network.neuron_in080.counter\[1\] network.neuron_in080.counter\[0\]
+ network.neuron_in080.counter\[2\] network.neuron_in080.counter\[3\]
+ net384 VSS VSS VDD VDD _05472_ sky130_fd_sc_hd__o311a_1
X_17125_ network.in_period\[80\]\[3\] net357 _05472_ VSS VSS
+ VDD VDD _05473_ sky130_fd_sc_hd__a21oi_1
X_17126_ network.neuron_in080.counter\[3\] _05471_ _05473_
+ VSS VSS VDD VDD _02386_ sky130_fd_sc_hd__o21ai_0
X_17127_ network.in_period\[89\]\[1\] _05409_ VSS VSS VDD
+ VDD _05474_ sky130_fd_sc_hd__nand2_1
X_17128_ _01221_ _05409_ _05474_ VSS VSS VDD VDD _02420_ sky130_fd_sc_hd__o21ai_0
X_17129_ network.neuron_in081.counter\[0\] network.neuron_in081.counter\[2\]
+ network.neuron_in081.counter\[1\] net357 VSS VSS VDD VDD _05475_
+ sky130_fd_sc_hd__nor4_1
X_17130_ network.in_period\[81\]\[3\] _05475_ _04607_ VSS
+ VSS VDD VDD _05476_ sky130_fd_sc_hd__mux2i_1
Xplace428 net458 VSS VSS VDD VDD net427 sky130_fd_sc_hd__buf_4
X_17132_ network.neuron_in081.counter\[0\] network.neuron_in081.counter\[2\]
+ network.neuron_in081.counter\[1\] network.neuron_in081.counter\[3\]
+ net384 VSS VSS VDD VDD _05478_ sky130_fd_sc_hd__o311a_1
X_17133_ network.in_period\[81\]\[3\] net357 _05478_ VSS VSS
+ VDD VDD _05479_ sky130_fd_sc_hd__a21oi_1
X_17134_ network.neuron_in081.counter\[3\] _05476_ _05479_
+ VSS VSS VDD VDD _02390_ sky130_fd_sc_hd__o21ai_0
X_17135_ network.neuron_in148.counter\[3\] network.in_period\[148\]\[2\]
+ _00535_ net348 VSS VSS VDD VDD _05480_ sky130_fd_sc_hd__o22ai_1
X_17136_ network.neuron_in148.counter\[2\] _00535_ net387
+ VSS VSS VDD VDD _05481_ sky130_fd_sc_hd__nand3_1
X_17137_ network.in_period\[148\]\[2\] net387 _05481_ VSS
+ VSS VDD VDD _05482_ sky130_fd_sc_hd__o21ai_0
X_17138_ _06950_ _05480_ _05482_ VSS VSS VDD VDD _02657_ sky130_fd_sc_hd__a21oi_1
X_17139_ network.in_spk08_11 _09325_ VSS VSS VDD VDD _05483_
+ sky130_fd_sc_hd__nand2_1
X_17140_ _06739_ _05483_ net361 VSS VSS VDD VDD _01976_ sky130_fd_sc_hd__a21oi_1
X_17141_ network.neuron_in082.counter\[1\] network.neuron_in082.counter\[0\]
+ _00059_ VSS VSS VDD VDD _05484_ sky130_fd_sc_hd__o21bai_1
X_17142_ _04602_ _05484_ network.neuron_in082.counter\[3\]
+ VSS VSS VDD VDD _05485_ sky130_fd_sc_hd__a21oi_1
X_17143_ _04602_ _00058_ _00057_ network.neuron_in082.counter\[3\]
+ _05485_ VSS VSS VDD VDD _05486_ sky130_fd_sc_hd__a41o_1
X_17144_ net386 _04601_ network.in_period\[82\]\[3\] VSS VSS
+ VDD VDD _05487_ sky130_fd_sc_hd__a21oi_1
X_17145_ net386 _05486_ _05487_ VSS VSS VDD VDD _02394_ sky130_fd_sc_hd__a21oi_1
X_17146_ net737 _05381_ VSS VSS VDD VDD _05488_ sky130_fd_sc_hd__nand2_1
X_17147_ network.neuron_in090.counter\[0\] _05381_ _05488_
+ VSS VSS VDD VDD _02423_ sky130_fd_sc_hd__o21ai_0
X_17148_ network.neuron_in191.counter\[1\] VSS VSS VDD VDD
+ _00826_ sky130_fd_sc_hd__inv_1
X_17149_ network.neuron_in083.counter\[0\] network.neuron_in083.counter\[1\]
+ _00063_ VSS VSS VDD VDD _05489_ sky130_fd_sc_hd__o21bai_1
X_17150_ _04598_ _05489_ network.neuron_in083.counter\[3\]
+ VSS VSS VDD VDD _05490_ sky130_fd_sc_hd__a21oi_1
X_17151_ _04598_ network.neuron_in083.counter\[3\] _00061_
+ _00062_ _05490_ VSS VSS VDD VDD _05491_ sky130_fd_sc_hd__a41o_1
X_17152_ net384 _04597_ network.in_period\[83\]\[3\] VSS VSS
+ VDD VDD _05492_ sky130_fd_sc_hd__a21oi_1
X_17153_ net384 _05491_ _05492_ VSS VSS VDD VDD _02398_ sky130_fd_sc_hd__a21oi_1
Xclkbuf_2_0__f_clk_root_regs clknet_0_clk_root_regs VSS VSS
+ VDD VDD clknet_2_0__leaf_clk_root_regs sky130_fd_sc_hd__clkbuf_16
X_17155_ network.neuron_in091.counter\[3\] network.in_period\[91\]\[2\]
+ net348 _00137_ VSS VSS VDD VDD _05494_ sky130_fd_sc_hd__o22ai_1
X_17156_ network.neuron_in091.counter\[2\] _00137_ net385
+ VSS VSS VDD VDD _05495_ sky130_fd_sc_hd__nand3_1
X_17157_ network.in_period\[91\]\[2\] net385 _05495_ VSS VSS
+ VDD VDD _05496_ sky130_fd_sc_hd__o21ai_0
X_17158_ _04567_ _05494_ _05496_ VSS VSS VDD VDD _02429_ sky130_fd_sc_hd__a21oi_1
X_17159_ network.in_spk06_11 _03390_ _09443_ net285 network.in_spk07_11
+ VSS VSS VDD VDD _05497_ sky130_fd_sc_hd__o41ai_1
X_17160_ _06667_ _05497_ net361 VSS VSS VDD VDD _01977_ sky130_fd_sc_hd__a21oi_1
Xplace378 net380 VSS VSS VDD VDD net377 sky130_fd_sc_hd__buf_4
X_17162_ network.neuron_in084.counter\[0\] network.neuron_in084.counter\[1\]
+ _00051_ VSS VSS VDD VDD _05499_ sky130_fd_sc_hd__o21bai_1
X_17163_ _04594_ _05499_ network.neuron_in084.counter\[3\]
+ VSS VSS VDD VDD _05500_ sky130_fd_sc_hd__a21oi_1
X_17164_ _04594_ network.neuron_in084.counter\[3\] _00049_
+ _00050_ _05500_ VSS VSS VDD VDD _05501_ sky130_fd_sc_hd__a41o_1
X_17165_ net386 _04593_ network.in_period\[84\]\[3\] VSS VSS
+ VDD VDD _05502_ sky130_fd_sc_hd__a21oi_1
X_17166_ net386 _05501_ _05502_ VSS VSS VDD VDD _02402_ sky130_fd_sc_hd__a21oi_1
X_17167_ net765 _05425_ VSS VSS VDD VDD _05503_ sky130_fd_sc_hd__nand2_1
X_17168_ network.neuron_in091.counter\[0\] _05425_ _05503_
+ VSS VSS VDD VDD _02427_ sky130_fd_sc_hd__o21ai_0
X_17169_ network.neuron_in085.counter\[1\] network.neuron_in085.counter\[2\]
+ network.neuron_in085.counter\[0\] VSS VSS VDD VDD _05504_
+ sky130_fd_sc_hd__nor3_1
X_17170_ network.neuron_in085.counter\[3\] _05504_ VSS VSS
+ VDD VDD _05505_ sky130_fd_sc_hd__xnor2_1
X_17171_ network.in_period\[85\]\[3\] _05230_ VSS VSS VDD
+ VDD _05506_ sky130_fd_sc_hd__nand2_1
X_17172_ _05230_ _05505_ _05506_ VSS VSS VDD VDD _02406_ sky130_fd_sc_hd__o21ai_0
X_17173_ _09443_ _09406_ network.in_spk06_11 VSS VSS VDD VDD
+ _05507_ sky130_fd_sc_hd__o21ai_0
X_17174_ _06691_ _05507_ net362 VSS VSS VDD VDD _01978_ sky130_fd_sc_hd__a21oi_1
X_17175_ network.neuron_in086.counter\[0\] network.neuron_in086.counter\[1\]
+ _00040_ VSS VSS VDD VDD _05508_ sky130_fd_sc_hd__o21bai_1
X_17176_ _04587_ _05508_ network.neuron_in086.counter\[3\]
+ VSS VSS VDD VDD _05509_ sky130_fd_sc_hd__a21oi_1
X_17177_ _04587_ network.neuron_in086.counter\[3\] _00038_
+ _00039_ _05509_ VSS VSS VDD VDD _05510_ sky130_fd_sc_hd__a41o_1
Xplace345 _07267_ VSS VSS VDD VDD net344 sky130_fd_sc_hd__buf_4
X_17179_ net377 _04586_ network.in_period\[86\]\[3\] VSS VSS
+ VDD VDD _05512_ sky130_fd_sc_hd__a21oi_1
X_17180_ net377 _05510_ _05512_ VSS VSS VDD VDD _02410_ sky130_fd_sc_hd__a21oi_1
X_17181_ network.in_period\[92\]\[0\] _05368_ VSS VSS VDD
+ VDD _05513_ sky130_fd_sc_hd__nand2_1
X_17182_ network.neuron_in092.counter\[0\] _05368_ _05513_
+ VSS VSS VDD VDD _02431_ sky130_fd_sc_hd__o21ai_0
X_17183_ network.neuron_in087.counter\[0\] network.neuron_in087.counter\[1\]
+ _00036_ VSS VSS VDD VDD _05514_ sky130_fd_sc_hd__o21bai_1
X_17184_ _04582_ _05514_ network.neuron_in087.counter\[3\]
+ VSS VSS VDD VDD _05515_ sky130_fd_sc_hd__a21oi_1
X_17185_ _04582_ network.neuron_in087.counter\[3\] _00034_
+ _00035_ _05515_ VSS VSS VDD VDD _05516_ sky130_fd_sc_hd__a41o_1
X_17186_ net385 _04581_ network.in_period\[87\]\[3\] VSS VSS
+ VDD VDD _05517_ sky130_fd_sc_hd__a21oi_1
X_17187_ net385 _05516_ _05517_ VSS VSS VDD VDD _02414_ sky130_fd_sc_hd__a21oi_1
X_17188_ network.neuron_in093.counter\[2\] VSS VSS VDD VDD
+ _05518_ sky130_fd_sc_hd__inv_1
X_17189_ network.neuron_in093.counter\[3\] network.in_period\[93\]\[2\]
+ _01233_ net358 VSS VSS VDD VDD _05519_ sky130_fd_sc_hd__o22ai_1
Xplace313 _07982_ VSS VSS VDD VDD net312 sky130_fd_sc_hd__buf_4
X_17191_ network.neuron_in093.counter\[2\] _01233_ net377
+ VSS VSS VDD VDD _05521_ sky130_fd_sc_hd__nand3_1
X_17192_ network.in_period\[93\]\[2\] net377 _05521_ VSS VSS
+ VDD VDD _05522_ sky130_fd_sc_hd__o21ai_0
X_17193_ _05518_ _05519_ _05522_ VSS VSS VDD VDD _02437_ sky130_fd_sc_hd__a21oi_1
X_17194_ network.in_spk04_11 _09406_ network.in_spk05_11 VSS
+ VSS VDD VDD _05523_ sky130_fd_sc_hd__o21ai_0
X_17195_ _06662_ _05523_ net362 VSS VSS VDD VDD _01979_ sky130_fd_sc_hd__a21oi_1
X_17196_ network.neuron_in088.counter\[1\] network.neuron_in088.counter\[0\]
+ _01216_ VSS VSS VDD VDD _05524_ sky130_fd_sc_hd__o21bai_1
X_17197_ _04578_ _05524_ network.neuron_in088.counter\[3\]
+ VSS VSS VDD VDD _05525_ sky130_fd_sc_hd__a21oi_1
X_17198_ _04578_ network.neuron_in088.counter\[3\] _01215_
+ _01214_ _05525_ VSS VSS VDD VDD _05526_ sky130_fd_sc_hd__a41o_1
X_17199_ net385 _04577_ network.in_period\[88\]\[3\] VSS VSS
+ VDD VDD _05527_ sky130_fd_sc_hd__a21oi_1
X_17200_ net385 _05526_ _05527_ VSS VSS VDD VDD _02418_ sky130_fd_sc_hd__a21oi_1
X_17201_ network.in_period\[93\]\[0\] _05437_ VSS VSS VDD
+ VDD _05528_ sky130_fd_sc_hd__nand2_1
X_17202_ network.neuron_in093.counter\[0\] _05437_ _05528_
+ VSS VSS VDD VDD _02435_ sky130_fd_sc_hd__o21ai_0
X_17203_ network.neuron_in089.counter\[1\] network.neuron_in089.counter\[0\]
+ _01220_ VSS VSS VDD VDD _05529_ sky130_fd_sc_hd__o21bai_1
X_17204_ _04574_ _05529_ network.neuron_in089.counter\[3\]
+ VSS VSS VDD VDD _05530_ sky130_fd_sc_hd__a21oi_1
X_17205_ _04574_ network.neuron_in089.counter\[3\] _01219_
+ _01218_ _05530_ VSS VSS VDD VDD _05531_ sky130_fd_sc_hd__a41o_1
X_17206_ net385 _04573_ network.in_period\[89\]\[3\] VSS VSS
+ VDD VDD _05532_ sky130_fd_sc_hd__a21oi_1
X_17207_ net385 _05531_ _05532_ VSS VSS VDD VDD _02422_ sky130_fd_sc_hd__a21oi_1
X_17208_ network.in_spk04_11 _09406_ VSS VSS VDD VDD _05533_
+ sky130_fd_sc_hd__nand2_1
X_17209_ _06721_ _05533_ net362 VSS VSS VDD VDD _01980_ sky130_fd_sc_hd__a21oi_1
X_17210_ network.neuron_in090.counter\[0\] network.neuron_in090.counter\[1\]
+ network.neuron_in090.counter\[2\] VSS VSS VDD VDD _05534_
+ sky130_fd_sc_hd__nor3_1
X_17211_ network.neuron_in090.counter\[3\] _05534_ VSS VSS
+ VDD VDD _05535_ sky130_fd_sc_hd__xnor2_1
X_17212_ net777 _05381_ VSS VSS VDD VDD _05536_ sky130_fd_sc_hd__nand2_1
X_17213_ _05381_ _05535_ _05536_ VSS VSS VDD VDD _02426_ sky130_fd_sc_hd__o21ai_0
X_17214_ net755 _05398_ VSS VSS VDD VDD _05537_ sky130_fd_sc_hd__nand2_1
X_17215_ network.neuron_in094.counter\[0\] _05398_ _05537_
+ VSS VSS VDD VDD _02439_ sky130_fd_sc_hd__o21ai_0
X_17216_ network.neuron_in091.counter\[0\] network.neuron_in091.counter\[1\]
+ _00137_ VSS VSS VDD VDD _05538_ sky130_fd_sc_hd__o21bai_1
X_17217_ _04567_ _05538_ network.neuron_in091.counter\[3\]
+ VSS VSS VDD VDD _05539_ sky130_fd_sc_hd__a21oi_1
X_17218_ _04567_ network.neuron_in091.counter\[3\] _00135_
+ _00136_ _05539_ VSS VSS VDD VDD _05540_ sky130_fd_sc_hd__a41o_1
X_17219_ net385 _04566_ network.in_period\[91\]\[3\] VSS VSS
+ VDD VDD _05541_ sky130_fd_sc_hd__a21oi_1
X_17220_ net385 _05540_ _05541_ VSS VSS VDD VDD _02430_ sky130_fd_sc_hd__a21oi_1
X_17221_ network.in_spk00_11 network.in_spk01_11 net285 VSS
+ VSS VDD VDD _05542_ sky130_fd_sc_hd__or3_1
X_17222_ network.in_spk02_11 _05542_ network.in_spk03_11 VSS
+ VSS VDD VDD _05543_ sky130_fd_sc_hd__o21ai_0
X_17223_ _06716_ _05543_ net362 VSS VSS VDD VDD _01981_ sky130_fd_sc_hd__a21oi_1
Xplace311 _08615_ VSS VSS VDD VDD net310 sky130_fd_sc_hd__buf_4
X_17225_ network.neuron_in092.counter\[0\] network.neuron_in092.counter\[2\]
+ network.neuron_in092.counter\[1\] net358 VSS VSS VDD VDD _05545_
+ sky130_fd_sc_hd__nor4_1
X_17226_ network.in_period\[92\]\[3\] _05545_ _04562_ VSS
+ VSS VDD VDD _05546_ sky130_fd_sc_hd__mux2i_1
Xplace312 _08086_ VSS VSS VDD VDD net311 sky130_fd_sc_hd__buf_4
X_17228_ network.neuron_in092.counter\[0\] network.neuron_in092.counter\[2\]
+ network.neuron_in092.counter\[1\] net385 network.neuron_in092.counter\[3\]
+ VSS VSS VDD VDD _05548_ sky130_fd_sc_hd__o311a_1
X_17229_ network.in_period\[92\]\[3\] net358 _05548_ VSS VSS
+ VDD VDD _05549_ sky130_fd_sc_hd__a21oi_1
X_17230_ network.neuron_in092.counter\[3\] _05546_ _05549_
+ VSS VSS VDD VDD _02434_ sky130_fd_sc_hd__o21ai_0
X_17231_ net377 _04553_ VSS VSS VDD VDD _05550_ sky130_fd_sc_hd__nand2_1
X_17232_ network.in_period\[95\]\[1\] _05550_ VSS VSS VDD
+ VDD _05551_ sky130_fd_sc_hd__nand2_1
X_17233_ _01248_ _05550_ _05551_ VSS VSS VDD VDD _02444_ sky130_fd_sc_hd__o21ai_0
X_17234_ network.neuron_in093.counter\[0\] network.neuron_in093.counter\[2\]
+ network.neuron_in093.counter\[1\] VSS VSS VDD VDD _05552_
+ sky130_fd_sc_hd__nor3_1
X_17235_ network.neuron_in093.counter\[3\] _05552_ VSS VSS
+ VDD VDD _05553_ sky130_fd_sc_hd__xnor2_1
X_17236_ network.in_period\[93\]\[3\] _05437_ VSS VSS VDD
+ VDD _05554_ sky130_fd_sc_hd__nand2_1
X_17237_ _05437_ _05553_ _05554_ VSS VSS VDD VDD _02438_ sky130_fd_sc_hd__o21ai_0
X_17238_ net697 _05550_ VSS VSS VDD VDD _05555_ sky130_fd_sc_hd__nand2_1
X_17239_ network.neuron_in095.counter\[0\] _05550_ _05555_
+ VSS VSS VDD VDD _02443_ sky130_fd_sc_hd__o21ai_0
X_17240_ net763 _05542_ VSS VSS VDD VDD _05556_ sky130_fd_sc_hd__nand2_1
X_17241_ _04753_ _05556_ net362 VSS VSS VDD VDD _01982_ sky130_fd_sc_hd__a21oi_1
X_17242_ network.neuron_in094.counter\[0\] network.neuron_in094.counter\[1\]
+ VSS VSS VDD VDD _05557_ sky130_fd_sc_hd__nor2_1
X_17243_ _01237_ _05557_ VSS VSS VDD VDD _05558_ sky130_fd_sc_hd__nor2_1
X_17244_ network.neuron_in094.counter\[2\] _05558_ VSS VSS
+ VDD VDD _05559_ sky130_fd_sc_hd__nor2_1
X_17245_ network.neuron_in094.counter\[2\] network.neuron_in094.counter\[3\]
+ _05557_ VSS VSS VDD VDD _05560_ sky130_fd_sc_hd__nand3b_1
X_17246_ network.neuron_in094.counter\[3\] _05559_ _05560_
+ VSS VSS VDD VDD _05561_ sky130_fd_sc_hd__o21ai_0
X_17247_ net377 _04556_ network.in_period\[94\]\[3\] VSS VSS
+ VDD VDD _05562_ sky130_fd_sc_hd__a21oi_1
X_17248_ net377 _05561_ _05562_ VSS VSS VDD VDD _02442_ sky130_fd_sc_hd__a21oi_1
X_17249_ network.neuron_in095.counter\[0\] network.neuron_in095.counter\[1\]
+ VSS VSS VDD VDD _05563_ sky130_fd_sc_hd__nor2_1
X_17250_ _01247_ _05563_ VSS VSS VDD VDD _05564_ sky130_fd_sc_hd__nor2_1
X_17251_ network.neuron_in095.counter\[2\] _05564_ VSS VSS
+ VDD VDD _05565_ sky130_fd_sc_hd__nor2_1
X_17252_ network.neuron_in095.counter\[2\] network.neuron_in095.counter\[3\]
+ _05563_ VSS VSS VDD VDD _05566_ sky130_fd_sc_hd__nand3b_1
X_17253_ network.neuron_in095.counter\[3\] _05565_ _05566_
+ VSS VSS VDD VDD _05567_ sky130_fd_sc_hd__o21ai_0
X_17254_ net377 _04552_ network.in_period\[95\]\[3\] VSS VSS
+ VDD VDD _05568_ sky130_fd_sc_hd__a21oi_1
X_17255_ net377 _05567_ _05568_ VSS VSS VDD VDD _02446_ sky130_fd_sc_hd__a21oi_1
X_17256_ network.in_spk00_11 net285 network.in_spk01_11 VSS
+ VSS VDD VDD _05569_ sky130_fd_sc_hd__o21ai_0
X_17257_ _07710_ _05569_ net361 VSS VSS VDD VDD _01983_ sky130_fd_sc_hd__a21oi_1
X_17258_ network.neuron_in096.counter\[1\] network.neuron_in096.counter\[0\]
+ _01212_ VSS VSS VDD VDD _05570_ sky130_fd_sc_hd__o21bai_1
X_17259_ _04549_ _05570_ network.neuron_in096.counter\[3\]
+ VSS VSS VDD VDD _05571_ sky130_fd_sc_hd__a21oi_1
X_17260_ _04549_ network.neuron_in096.counter\[3\] _01211_
+ _01210_ _05571_ VSS VSS VDD VDD _05572_ sky130_fd_sc_hd__a41o_1
X_17261_ net374 _04548_ network.in_period\[96\]\[3\] VSS VSS
+ VDD VDD _05573_ sky130_fd_sc_hd__a21oi_1
X_17262_ net374 _05572_ _05573_ VSS VSS VDD VDD _02450_ sky130_fd_sc_hd__a21oi_1
X_17263_ network.neuron_in097.counter\[1\] network.neuron_in097.counter\[2\]
+ network.neuron_in097.counter\[0\] net353 VSS VSS VDD VDD _05574_
+ sky130_fd_sc_hd__nor4_1
X_17264_ network.in_period\[97\]\[3\] _05574_ _04545_ VSS
+ VSS VDD VDD _05575_ sky130_fd_sc_hd__mux2i_1
X_17265_ network.neuron_in097.counter\[1\] network.neuron_in097.counter\[2\]
+ network.neuron_in097.counter\[0\] net373 network.neuron_in097.counter\[3\]
+ VSS VSS VDD VDD _05576_ sky130_fd_sc_hd__o311a_1
X_17266_ network.in_period\[97\]\[3\] net353 _05576_ VSS VSS
+ VDD VDD _05577_ sky130_fd_sc_hd__a21oi_1
X_17267_ network.neuron_in097.counter\[3\] _05575_ _05577_
+ VSS VSS VDD VDD _02454_ sky130_fd_sc_hd__o21ai_0
X_17268_ network.in_spk00_11 net285 VSS VSS VDD VDD _05578_
+ sky130_fd_sc_hd__nand2_1
Xplace343 net343 VSS VSS VDD VDD net342 sky130_fd_sc_hd__buf_4
X_17270_ _07763_ _05578_ net362 VSS VSS VDD VDD _01984_ sky130_fd_sc_hd__a21oi_1
X_17271_ network.neuron_in098.counter\[0\] VSS VSS VDD VDD
+ _00719_ sky130_fd_sc_hd__inv_1
X_17272_ network.neuron_in098.counter\[1\] network.neuron_in098.counter\[0\]
+ _00721_ VSS VSS VDD VDD _05580_ sky130_fd_sc_hd__o21bai_1
X_17273_ _04850_ _05580_ network.neuron_in098.counter\[3\]
+ VSS VSS VDD VDD _05581_ sky130_fd_sc_hd__a21oi_1
X_17274_ _04850_ network.neuron_in098.counter\[3\] _00720_
+ _00719_ _05581_ VSS VSS VDD VDD _05582_ sky130_fd_sc_hd__a41o_1
X_17275_ net373 _04849_ network.in_period\[98\]\[3\] VSS VSS
+ VDD VDD _05583_ sky130_fd_sc_hd__a21oi_1
X_17276_ net373 _05582_ _05583_ VSS VSS VDD VDD _02458_ sky130_fd_sc_hd__a21oi_1
Xplace379 net379 VSS VSS VDD VDD net378 sky130_fd_sc_hd__buf_4
X_17278_ network.neuron_in099.counter\[1\] network.neuron_in099.counter\[0\]
+ _00706_ VSS VSS VDD VDD _05585_ sky130_fd_sc_hd__o21bai_1
X_17279_ _04847_ _05585_ network.neuron_in099.counter\[3\]
+ VSS VSS VDD VDD _05586_ sky130_fd_sc_hd__a21oi_1
X_17280_ _04847_ network.neuron_in099.counter\[3\] _00705_
+ _00704_ _05586_ VSS VSS VDD VDD _05587_ sky130_fd_sc_hd__a41o_1
X_17281_ net373 _04846_ network.in_period\[99\]\[3\] VSS VSS
+ VDD VDD _05588_ sky130_fd_sc_hd__a21oi_1
X_17282_ net373 _05587_ _05588_ VSS VSS VDD VDD _02462_ sky130_fd_sc_hd__a21oi_1
X_17283_ net309 _09322_ _09412_ VSS VSS VDD VDD _05589_ sky130_fd_sc_hd__nand3_1
X_17284_ network.in_spk12_10 network.in_spk13_10 network.in_spk14_10
+ _05589_ net732 VSS VSS VDD VDD _05590_ sky130_fd_sc_hd__o41ai_1
X_17285_ _07758_ _05590_ net360 VSS VSS VDD VDD _01985_ sky130_fd_sc_hd__a21oi_1
X_17286_ network.neuron_in100.counter\[0\] network.neuron_in100.counter\[1\]
+ network.neuron_in100.counter\[2\] net353 VSS VSS VDD VDD _05591_
+ sky130_fd_sc_hd__nor4_1
X_17287_ network.in_period\[100\]\[3\] _05591_ _04844_ VSS
+ VSS VDD VDD _05592_ sky130_fd_sc_hd__mux2i_1
X_17288_ network.neuron_in100.counter\[0\] network.neuron_in100.counter\[1\]
+ network.neuron_in100.counter\[2\] network.neuron_in100.counter\[3\]
+ net374 VSS VSS VDD VDD _05593_ sky130_fd_sc_hd__o311a_1
X_17289_ network.in_period\[100\]\[3\] net353 _05593_ VSS
+ VSS VDD VDD _05594_ sky130_fd_sc_hd__a21oi_1
X_17290_ network.neuron_in100.counter\[3\] _05592_ _05594_
+ VSS VSS VDD VDD _02466_ sky130_fd_sc_hd__o21ai_0
X_17291_ network.neuron_hid0.IF0.ref_counter\[1\] VSS VSS
+ VDD VDD _00678_ sky130_fd_sc_hd__inv_1
X_17292_ net374 _04842_ VSS VSS VDD VDD _05595_ sky130_fd_sc_hd__nand2_1
X_17293_ network.neuron_in101.counter\[1\] network.neuron_in101.counter\[0\]
+ network.neuron_in101.counter\[2\] VSS VSS VDD VDD _05596_
+ sky130_fd_sc_hd__nor3_1
X_17294_ network.neuron_in101.counter\[3\] _05596_ VSS VSS
+ VDD VDD _05597_ sky130_fd_sc_hd__xnor2_1
X_17295_ network.in_period\[101\]\[3\] _05595_ VSS VSS VDD
+ VDD _05598_ sky130_fd_sc_hd__nand2_1
X_17296_ _05595_ _05597_ _05598_ VSS VSS VDD VDD _02470_ sky130_fd_sc_hd__o21ai_0
X_17297_ _09412_ _09429_ VSS VSS VDD VDD _05599_ sky130_fd_sc_hd__nand2_1
X_17298_ network.in_spk14_10 _05599_ VSS VSS VDD VDD _05600_
+ sky130_fd_sc_hd__nand2_1
X_17299_ _07729_ _05600_ net360 VSS VSS VDD VDD _01986_ sky130_fd_sc_hd__a21oi_1
X_17300_ network.neuron_in102.counter\[1\] network.neuron_in102.counter\[2\]
+ network.neuron_in102.counter\[0\] net354 VSS VSS VDD VDD _05601_
+ sky130_fd_sc_hd__nor4_1
X_17301_ network.in_period\[102\]\[3\] _05601_ _04839_ VSS
+ VSS VDD VDD _05602_ sky130_fd_sc_hd__mux2i_1
Xplace305 _07375_ VSS VSS VDD VDD net304 sky130_fd_sc_hd__buf_4
X_17303_ network.neuron_in102.counter\[1\] network.neuron_in102.counter\[2\]
+ network.neuron_in102.counter\[0\] net374 network.neuron_in102.counter\[3\]
+ VSS VSS VDD VDD _05604_ sky130_fd_sc_hd__o311a_1
X_17304_ network.in_period\[102\]\[3\] net354 _05604_ VSS
+ VSS VDD VDD _05605_ sky130_fd_sc_hd__a21oi_1
X_17305_ network.neuron_in102.counter\[3\] _05602_ _05605_
+ VSS VSS VDD VDD _02474_ sky130_fd_sc_hd__o21ai_0
X_17306_ network.neuron_in103.counter\[0\] network.neuron_in103.counter\[1\]
+ _00215_ VSS VSS VDD VDD _05606_ sky130_fd_sc_hd__o21bai_1
X_17307_ _04836_ _05606_ network.neuron_in103.counter\[3\]
+ VSS VSS VDD VDD _05607_ sky130_fd_sc_hd__a21oi_1
X_17308_ _04836_ _00213_ _00214_ network.neuron_in103.counter\[3\]
+ _05607_ VSS VSS VDD VDD _05608_ sky130_fd_sc_hd__a41o_1
Xplace296 _04101_ VSS VSS VDD VDD net295 sky130_fd_sc_hd__buf_6
X_17310_ net374 _04835_ network.in_period\[103\]\[3\] VSS
+ VSS VDD VDD _05610_ sky130_fd_sc_hd__a21oi_1
X_17311_ net374 _05608_ _05610_ VSS VSS VDD VDD _02478_ sky130_fd_sc_hd__a21oi_1
X_17312_ network.in_spk12_10 _05589_ network.in_spk13_10 VSS
+ VSS VDD VDD _05611_ sky130_fd_sc_hd__o21ai_0
X_17313_ _07752_ _05611_ net360 VSS VSS VDD VDD _01987_ sky130_fd_sc_hd__a21oi_1
X_17314_ network.neuron_in104.counter\[1\] network.neuron_in104.counter\[0\]
+ _00531_ VSS VSS VDD VDD _05612_ sky130_fd_sc_hd__o21bai_1
X_17315_ _04833_ _05612_ network.neuron_in104.counter\[3\]
+ VSS VSS VDD VDD _05613_ sky130_fd_sc_hd__a21oi_1
X_17316_ _04833_ network.neuron_in104.counter\[3\] _00530_
+ _00529_ _05613_ VSS VSS VDD VDD _05614_ sky130_fd_sc_hd__a41o_1
X_17317_ net382 _04832_ network.in_period\[104\]\[3\] VSS
+ VSS VDD VDD _05615_ sky130_fd_sc_hd__a21oi_1
X_17318_ net382 _05614_ _05615_ VSS VSS VDD VDD _02482_ sky130_fd_sc_hd__a21oi_1
X_17319_ network.neuron_in105.counter\[1\] network.neuron_in105.counter\[0\]
+ _00498_ VSS VSS VDD VDD _05616_ sky130_fd_sc_hd__o21bai_1
X_17320_ _04830_ _05616_ network.neuron_in105.counter\[3\]
+ VSS VSS VDD VDD _05617_ sky130_fd_sc_hd__a21oi_1
X_17321_ _04830_ network.neuron_in105.counter\[3\] _00497_
+ _00496_ _05617_ VSS VSS VDD VDD _05618_ sky130_fd_sc_hd__a41o_1
X_17322_ net382 _04829_ network.in_period\[105\]\[3\] VSS
+ VSS VDD VDD _05619_ sky130_fd_sc_hd__a21oi_1
X_17323_ net382 _05618_ _05619_ VSS VSS VDD VDD _02486_ sky130_fd_sc_hd__a21oi_1
X_17324_ network.in_spk12_10 _05589_ VSS VSS VDD VDD _05620_
+ sky130_fd_sc_hd__nand2_1
X_17325_ _07715_ _05620_ net360 VSS VSS VDD VDD _01988_ sky130_fd_sc_hd__a21oi_1
X_17326_ network.neuron_in145.counter\[3\] network.in_period\[145\]\[2\]
+ net348 _00643_ VSS VSS VDD VDD _05621_ sky130_fd_sc_hd__o22ai_1
X_17327_ network.neuron_in145.counter\[2\] _00643_ net387
+ VSS VSS VDD VDD _05622_ sky130_fd_sc_hd__nand3_1
X_17328_ network.in_period\[145\]\[2\] net387 _05622_ VSS
+ VSS VDD VDD _05623_ sky130_fd_sc_hd__o21ai_0
X_17329_ _03875_ _05621_ _05623_ VSS VSS VDD VDD _02645_ sky130_fd_sc_hd__a21oi_1
X_17330_ network.neuron_in106.counter\[1\] network.neuron_in106.counter\[0\]
+ _00650_ VSS VSS VDD VDD _05624_ sky130_fd_sc_hd__o21bai_1
X_17331_ _04826_ _05624_ network.neuron_in106.counter\[3\]
+ VSS VSS VDD VDD _05625_ sky130_fd_sc_hd__a21oi_1
X_17332_ _04826_ network.neuron_in106.counter\[3\] _00649_
+ _00648_ _05625_ VSS VSS VDD VDD _05626_ sky130_fd_sc_hd__a41o_1
X_17333_ net382 _04825_ network.in_period\[106\]\[3\] VSS
+ VSS VDD VDD _05627_ sky130_fd_sc_hd__a21oi_1
X_17334_ net382 _05626_ _05627_ VSS VSS VDD VDD _02490_ sky130_fd_sc_hd__a21oi_1
X_17335_ net382 _04824_ VSS VSS VDD VDD _05628_ sky130_fd_sc_hd__nand2_1
X_17336_ network.neuron_in107.counter\[1\] network.neuron_in107.counter\[2\]
+ network.neuron_in107.counter\[0\] VSS VSS VDD VDD _05629_
+ sky130_fd_sc_hd__nor3_1
X_17337_ network.neuron_in107.counter\[3\] _05629_ VSS VSS
+ VDD VDD _05630_ sky130_fd_sc_hd__xnor2_1
X_17338_ network.in_period\[107\]\[3\] _05628_ VSS VSS VDD
+ VDD _05631_ sky130_fd_sc_hd__nand2_1
X_17339_ _05628_ _05630_ _05631_ VSS VSS VDD VDD _02494_ sky130_fd_sc_hd__o21ai_0
X_17340_ _09435_ _09324_ network.in_spk11_10 VSS VSS VDD VDD
+ _05632_ sky130_fd_sc_hd__o21ai_0
X_17341_ _07748_ _05632_ net360 VSS VSS VDD VDD _01989_ sky130_fd_sc_hd__a21oi_1
X_17342_ network.neuron_in108.counter\[0\] network.neuron_in108.counter\[2\]
+ network.neuron_in108.counter\[1\] net349 VSS VSS VDD VDD _05633_
+ sky130_fd_sc_hd__nor4_1
X_17343_ network.in_period\[108\]\[3\] _05633_ _04821_ VSS
+ VSS VDD VDD _05634_ sky130_fd_sc_hd__mux2i_1
X_17344_ network.neuron_in108.counter\[0\] network.neuron_in108.counter\[2\]
+ network.neuron_in108.counter\[1\] net374 network.neuron_in108.counter\[3\]
+ VSS VSS VDD VDD _05635_ sky130_fd_sc_hd__o311a_1
X_17345_ network.in_period\[108\]\[3\] net349 _05635_ VSS
+ VSS VDD VDD _05636_ sky130_fd_sc_hd__a21oi_1
X_17346_ network.neuron_in108.counter\[3\] _05634_ _05636_
+ VSS VSS VDD VDD _02498_ sky130_fd_sc_hd__o21ai_0
X_17347_ net382 _04819_ VSS VSS VDD VDD _05637_ sky130_fd_sc_hd__nand2_1
X_17348_ network.neuron_in109.counter\[1\] network.neuron_in109.counter\[2\]
+ network.neuron_in109.counter\[0\] VSS VSS VDD VDD _05638_
+ sky130_fd_sc_hd__nor3_1
X_17349_ network.neuron_in109.counter\[3\] _05638_ VSS VSS
+ VDD VDD _05639_ sky130_fd_sc_hd__xnor2_1
X_17350_ network.in_period\[109\]\[3\] _05637_ VSS VSS VDD
+ VDD _05640_ sky130_fd_sc_hd__nand2_1
X_17351_ _05637_ _05639_ _05640_ VSS VSS VDD VDD _02502_ sky130_fd_sc_hd__o21ai_0
X_17352_ network.in_spk08_10 network.in_spk09_10 _09324_ network.in_spk10_10
+ VSS VSS VDD VDD _05641_ sky130_fd_sc_hd__o31ai_1
X_17353_ _07743_ _05641_ net360 VSS VSS VDD VDD _01990_ sky130_fd_sc_hd__a21oi_1
X_17354_ net382 _04817_ VSS VSS VDD VDD _05642_ sky130_fd_sc_hd__nand2_1
X_17355_ network.neuron_in110.counter\[1\] network.neuron_in110.counter\[2\]
+ network.neuron_in110.counter\[0\] VSS VSS VDD VDD _05643_
+ sky130_fd_sc_hd__nor3_1
X_17356_ network.neuron_in110.counter\[3\] _05643_ VSS VSS
+ VDD VDD _05644_ sky130_fd_sc_hd__xnor2_1
X_17357_ network.in_period\[110\]\[3\] _05642_ VSS VSS VDD
+ VDD _05645_ sky130_fd_sc_hd__nand2_1
X_17358_ _05642_ _05644_ _05645_ VSS VSS VDD VDD _02506_ sky130_fd_sc_hd__o21ai_0
X_17359_ network.neuron_in139.counter\[1\] VSS VSS VDD VDD
+ _01094_ sky130_fd_sc_hd__inv_1
X_17360_ network.neuron_in111.counter\[0\] network.neuron_in111.counter\[2\]
+ network.neuron_in111.counter\[1\] net355 VSS VSS VDD VDD _05646_
+ sky130_fd_sc_hd__nor4_1
X_17361_ network.in_period\[111\]\[3\] _05646_ _04814_ VSS
+ VSS VDD VDD _05647_ sky130_fd_sc_hd__mux2i_1
X_17362_ network.neuron_in111.counter\[0\] network.neuron_in111.counter\[2\]
+ network.neuron_in111.counter\[1\] net382 network.neuron_in111.counter\[3\]
+ VSS VSS VDD VDD _05648_ sky130_fd_sc_hd__o311a_1
X_17363_ network.in_period\[111\]\[3\] net355 _05648_ VSS
+ VSS VDD VDD _05649_ sky130_fd_sc_hd__a21oi_1
X_17364_ network.neuron_in111.counter\[3\] _05647_ _05649_
+ VSS VSS VDD VDD _02510_ sky130_fd_sc_hd__o21ai_0
X_17365_ network.in_spk08_10 _09324_ network.in_spk09_10 VSS
+ VSS VDD VDD _05650_ sky130_fd_sc_hd__o21ai_0
X_17366_ _07721_ _05650_ net360 VSS VSS VDD VDD _01991_ sky130_fd_sc_hd__a21oi_1
X_17367_ network.neuron_in112.counter\[0\] network.neuron_in112.counter\[1\]
+ _00747_ VSS VSS VDD VDD _05651_ sky130_fd_sc_hd__o21bai_1
X_17368_ _04811_ _05651_ network.neuron_in112.counter\[3\]
+ VSS VSS VDD VDD _05652_ sky130_fd_sc_hd__a21oi_1
X_17369_ _04811_ network.neuron_in112.counter\[3\] _00745_
+ _00746_ _05652_ VSS VSS VDD VDD _05653_ sky130_fd_sc_hd__a41o_1
X_17370_ net382 _04810_ network.in_period\[112\]\[3\] VSS
+ VSS VDD VDD _05654_ sky130_fd_sc_hd__a21oi_1
X_17371_ net382 _05653_ _05654_ VSS VSS VDD VDD _02514_ sky130_fd_sc_hd__a21oi_1
X_17372_ network.neuron_in113.counter\[1\] network.neuron_in113.counter\[0\]
+ _01091_ VSS VSS VDD VDD _05655_ sky130_fd_sc_hd__o21bai_1
X_17373_ _04808_ _05655_ network.neuron_in113.counter\[3\]
+ VSS VSS VDD VDD _05656_ sky130_fd_sc_hd__a21oi_1
X_17374_ _04808_ network.neuron_in113.counter\[3\] _01090_
+ _01089_ _05656_ VSS VSS VDD VDD _05657_ sky130_fd_sc_hd__a41o_1
X_17375_ net383 _04807_ network.in_period\[113\]\[3\] VSS
+ VSS VDD VDD _05658_ sky130_fd_sc_hd__a21oi_1
X_17376_ net383 _05657_ _05658_ VSS VSS VDD VDD _02518_ sky130_fd_sc_hd__a21oi_1
X_17377_ network.in_spk08_10 _09324_ VSS VSS VDD VDD _05659_
+ sky130_fd_sc_hd__nand2_1
X_17378_ _07738_ _05659_ net360 VSS VSS VDD VDD _01992_ sky130_fd_sc_hd__a21oi_1
X_17379_ net386 _04806_ VSS VSS VDD VDD _05660_ sky130_fd_sc_hd__nand2_1
X_17380_ network.neuron_in114.counter\[0\] network.neuron_in114.counter\[1\]
+ network.neuron_in114.counter\[2\] VSS VSS VDD VDD _05661_
+ sky130_fd_sc_hd__nor3_1
X_17381_ network.neuron_in114.counter\[3\] _05661_ VSS VSS
+ VDD VDD _05662_ sky130_fd_sc_hd__xnor2_1
X_17382_ net726 _05660_ VSS VSS VDD VDD _05663_ sky130_fd_sc_hd__nand2_1
X_17383_ _05660_ _05662_ _05663_ VSS VSS VDD VDD _02522_ sky130_fd_sc_hd__o21ai_0
X_17384_ network.neuron_in115.counter\[1\] network.neuron_in115.counter\[0\]
+ _01224_ VSS VSS VDD VDD _05664_ sky130_fd_sc_hd__o21bai_1
X_17385_ _04803_ _05664_ network.neuron_in115.counter\[3\]
+ VSS VSS VDD VDD _05665_ sky130_fd_sc_hd__a21oi_1
X_17386_ _04803_ network.neuron_in115.counter\[3\] _01223_
+ _01222_ _05665_ VSS VSS VDD VDD _05666_ sky130_fd_sc_hd__a41o_1
X_17387_ net386 _04802_ network.in_period\[115\]\[3\] VSS
+ VSS VDD VDD _05667_ sky130_fd_sc_hd__a21oi_1
X_17388_ net386 _05666_ _05667_ VSS VSS VDD VDD _02526_ sky130_fd_sc_hd__a21oi_1
X_17389_ network.in_spk04_10 network.in_spk05_10 network.in_spk06_10
+ _09413_ network.in_spk07_10 VSS VSS VDD VDD _05668_ sky130_fd_sc_hd__o41ai_1
X_17390_ _07768_ _05668_ net360 VSS VSS VDD VDD _01993_ sky130_fd_sc_hd__a21oi_1
X_17391_ network.neuron_in116.counter\[0\] network.neuron_in116.counter\[2\]
+ network.neuron_in116.counter\[1\] net348 VSS VSS VDD VDD _05669_
+ sky130_fd_sc_hd__nor4_1
X_17392_ network.in_period\[116\]\[3\] _05669_ _04799_ VSS
+ VSS VDD VDD _05670_ sky130_fd_sc_hd__mux2i_1
X_17393_ network.neuron_in116.counter\[0\] network.neuron_in116.counter\[2\]
+ network.neuron_in116.counter\[1\] network.neuron_in116.counter\[3\]
+ net383 VSS VSS VDD VDD _05671_ sky130_fd_sc_hd__o311a_1
X_17394_ network.in_period\[116\]\[3\] net348 _05671_ VSS
+ VSS VDD VDD _05672_ sky130_fd_sc_hd__a21oi_1
X_17395_ network.neuron_in116.counter\[3\] _05670_ _05672_
+ VSS VSS VDD VDD _02530_ sky130_fd_sc_hd__o21ai_0
X_17396_ net382 _04797_ VSS VSS VDD VDD _05673_ sky130_fd_sc_hd__nand2_1
X_17397_ network.neuron_in117.counter\[1\] network.neuron_in117.counter\[2\]
+ network.neuron_in117.counter\[0\] VSS VSS VDD VDD _05674_
+ sky130_fd_sc_hd__nor3_1
X_17398_ network.neuron_in117.counter\[3\] _05674_ VSS VSS
+ VDD VDD _05675_ sky130_fd_sc_hd__xnor2_1
X_17399_ net793 _05673_ VSS VSS VDD VDD _05676_ sky130_fd_sc_hd__nand2_1
X_17400_ _05673_ _05675_ _05676_ VSS VSS VDD VDD _02534_ sky130_fd_sc_hd__o21ai_0
X_17401_ network.in_spk04_10 network.in_spk05_10 _09413_ network.in_spk06_10
+ VSS VSS VDD VDD _05677_ sky130_fd_sc_hd__o31ai_1
Xplace286 _09278_ VSS VSS VDD VDD net285 sky130_fd_sc_hd__buf_4
X_17403_ _03825_ _05677_ net360 VSS VSS VDD VDD _01994_ sky130_fd_sc_hd__a21oi_1
X_17404_ net386 _04795_ VSS VSS VDD VDD _05679_ sky130_fd_sc_hd__nand2_1
X_17405_ network.neuron_in118.counter\[0\] network.neuron_in118.counter\[2\]
+ network.neuron_in118.counter\[1\] VSS VSS VDD VDD _05680_
+ sky130_fd_sc_hd__nor3_1
X_17406_ network.neuron_in118.counter\[3\] _05680_ VSS VSS
+ VDD VDD _05681_ sky130_fd_sc_hd__xnor2_1
X_17407_ network.in_period\[118\]\[3\] _05679_ VSS VSS VDD
+ VDD _05682_ sky130_fd_sc_hd__nand2_1
X_17408_ _05679_ _05681_ _05682_ VSS VSS VDD VDD _02538_ sky130_fd_sc_hd__o21ai_0
X_17409_ net383 _04793_ VSS VSS VDD VDD _05683_ sky130_fd_sc_hd__nand2_1
X_17410_ network.neuron_in119.counter\[0\] network.neuron_in119.counter\[1\]
+ network.neuron_in119.counter\[2\] VSS VSS VDD VDD _05684_
+ sky130_fd_sc_hd__nor3_1
X_17411_ network.neuron_in119.counter\[3\] _05684_ VSS VSS
+ VDD VDD _05685_ sky130_fd_sc_hd__xnor2_1
X_17412_ network.in_period\[119\]\[3\] _05683_ VSS VSS VDD
+ VDD _05686_ sky130_fd_sc_hd__nand2_1
X_17413_ _05683_ _05685_ _05686_ VSS VSS VDD VDD _02542_ sky130_fd_sc_hd__o21ai_0
X_17414_ network.in_spk04_10 _09413_ network.in_spk05_10 VSS
+ VSS VDD VDD _05687_ sky130_fd_sc_hd__o21ai_0
X_17415_ _03815_ _05687_ net360 VSS VSS VDD VDD _01995_ sky130_fd_sc_hd__a21oi_1
X_17416_ network.neuron_in120.counter\[0\] network.neuron_in120.counter\[1\]
+ _00964_ VSS VSS VDD VDD _05688_ sky130_fd_sc_hd__o21bai_1
X_17417_ _04791_ _05688_ network.neuron_in120.counter\[3\]
+ VSS VSS VDD VDD _05689_ sky130_fd_sc_hd__a21oi_1
X_17418_ _04791_ network.neuron_in120.counter\[3\] _00962_
+ _00963_ _05689_ VSS VSS VDD VDD _05690_ sky130_fd_sc_hd__a41o_1
X_17419_ net382 _04790_ network.in_period\[120\]\[3\] VSS
+ VSS VDD VDD _05691_ sky130_fd_sc_hd__a21oi_1
X_17420_ net382 _05690_ _05691_ VSS VSS VDD VDD _02546_ sky130_fd_sc_hd__a21oi_1
X_17421_ net386 _04789_ VSS VSS VDD VDD _05692_ sky130_fd_sc_hd__nand2_1
X_17422_ network.neuron_in121.counter\[1\] network.neuron_in121.counter\[0\]
+ network.neuron_in121.counter\[2\] VSS VSS VDD VDD _05693_
+ sky130_fd_sc_hd__nor3_1
X_17423_ network.neuron_in121.counter\[3\] _05693_ VSS VSS
+ VDD VDD _05694_ sky130_fd_sc_hd__xnor2_1
X_17424_ network.in_period\[121\]\[3\] _05692_ VSS VSS VDD
+ VDD _05695_ sky130_fd_sc_hd__nand2_1
X_17425_ _05692_ _05694_ _05695_ VSS VSS VDD VDD _02550_ sky130_fd_sc_hd__o21ai_0
X_17426_ network.in_spk04_10 _09413_ VSS VSS VDD VDD _05696_
+ sky130_fd_sc_hd__nand2_1
X_17427_ _03805_ _05696_ net360 VSS VSS VDD VDD _01996_ sky130_fd_sc_hd__a21oi_1
X_17428_ net383 _04787_ VSS VSS VDD VDD _05697_ sky130_fd_sc_hd__nand2_1
X_17429_ network.neuron_in122.counter\[1\] network.neuron_in122.counter\[0\]
+ network.neuron_in122.counter\[2\] VSS VSS VDD VDD _05698_
+ sky130_fd_sc_hd__nor3_1
X_17430_ network.neuron_in122.counter\[3\] _05698_ VSS VSS
+ VDD VDD _05699_ sky130_fd_sc_hd__xnor2_1
X_17431_ net771 _05697_ VSS VSS VDD VDD _05700_ sky130_fd_sc_hd__nand2_1
X_17432_ _05697_ _05699_ _05700_ VSS VSS VDD VDD _02554_ sky130_fd_sc_hd__o21ai_0
X_17433_ network.neuron_in123.counter\[1\] network.neuron_in123.counter\[0\]
+ network.neuron_in123.counter\[2\] net357 VSS VSS VDD VDD _05701_
+ sky130_fd_sc_hd__nor4_1
X_17434_ network.in_period\[123\]\[3\] _05701_ _04784_ VSS
+ VSS VDD VDD _05702_ sky130_fd_sc_hd__mux2i_1
X_17435_ network.neuron_in123.counter\[1\] network.neuron_in123.counter\[0\]
+ network.neuron_in123.counter\[2\] network.neuron_in123.counter\[3\]
+ net386 VSS VSS VDD VDD _05703_ sky130_fd_sc_hd__o311a_1
X_17436_ network.in_period\[123\]\[3\] net357 _05703_ VSS
+ VSS VDD VDD _05704_ sky130_fd_sc_hd__a21oi_1
X_17437_ network.neuron_in123.counter\[3\] _05702_ _05704_
+ VSS VSS VDD VDD _02558_ sky130_fd_sc_hd__o21ai_0
X_17438_ network.in_spk00_10 network.in_spk01_10 _09272_ VSS
+ VSS VDD VDD _05705_ sky130_fd_sc_hd__or3_1
X_17439_ network.in_spk02_10 _05705_ network.in_spk03_10 VSS
+ VSS VDD VDD _05706_ sky130_fd_sc_hd__o21ai_0
X_17440_ _03793_ _05706_ net360 VSS VSS VDD VDD _01997_ sky130_fd_sc_hd__a21oi_1
X_17441_ network.neuron_in124.counter\[0\] network.neuron_in124.counter\[1\]
+ _00367_ VSS VSS VDD VDD _05707_ sky130_fd_sc_hd__o21bai_1
X_17442_ _04781_ _05707_ network.neuron_in124.counter\[3\]
+ VSS VSS VDD VDD _05708_ sky130_fd_sc_hd__a21oi_1
X_17443_ _04781_ network.neuron_in124.counter\[3\] _00365_
+ _00366_ _05708_ VSS VSS VDD VDD _05709_ sky130_fd_sc_hd__a41o_1
X_17444_ net385 _04780_ network.in_period\[124\]\[3\] VSS
+ VSS VDD VDD _05710_ sky130_fd_sc_hd__a21oi_1
X_17445_ net385 _05709_ _05710_ VSS VSS VDD VDD _02562_ sky130_fd_sc_hd__a21oi_1
X_17446_ net385 _04779_ VSS VSS VDD VDD _05711_ sky130_fd_sc_hd__nand2_1
X_17447_ network.neuron_in125.counter\[0\] network.neuron_in125.counter\[2\]
+ network.neuron_in125.counter\[1\] VSS VSS VDD VDD _05712_
+ sky130_fd_sc_hd__nor3_1
X_17448_ network.neuron_in125.counter\[3\] _05712_ VSS VSS
+ VDD VDD _05713_ sky130_fd_sc_hd__xnor2_1
X_17449_ network.in_period\[125\]\[3\] _05711_ VSS VSS VDD
+ VDD _05714_ sky130_fd_sc_hd__nand2_1
X_17450_ _05711_ _05713_ _05714_ VSS VSS VDD VDD _02566_ sky130_fd_sc_hd__o21ai_0
X_17451_ network.in_spk02_10 _05705_ VSS VSS VDD VDD _05715_
+ sky130_fd_sc_hd__nand2_1
X_17452_ _06638_ _05715_ net360 VSS VSS VDD VDD _01998_ sky130_fd_sc_hd__a21oi_1
X_17453_ network.neuron_in126.counter\[1\] network.neuron_in126.counter\[2\]
+ network.neuron_in126.counter\[0\] net348 VSS VSS VDD VDD _05716_
+ sky130_fd_sc_hd__nor4_1
X_17454_ network.in_period\[126\]\[3\] _05716_ _04774_ VSS
+ VSS VDD VDD _05717_ sky130_fd_sc_hd__mux2i_1
X_17455_ network.neuron_in126.counter\[1\] network.neuron_in126.counter\[2\]
+ network.neuron_in126.counter\[0\] net385 network.neuron_in126.counter\[3\]
+ VSS VSS VDD VDD _05718_ sky130_fd_sc_hd__o311a_1
X_17456_ network.in_period\[126\]\[3\] net348 _05718_ VSS
+ VSS VDD VDD _05719_ sky130_fd_sc_hd__a21oi_1
X_17457_ network.neuron_in126.counter\[3\] _05717_ _05719_
+ VSS VSS VDD VDD _02570_ sky130_fd_sc_hd__o21ai_0
X_17458_ network.neuron_in127.counter\[0\] network.neuron_in127.counter\[2\]
+ network.neuron_in127.counter\[1\] net348 VSS VSS VDD VDD _05720_
+ sky130_fd_sc_hd__nor4_1
X_17459_ network.in_period\[127\]\[3\] _05720_ _04771_ VSS
+ VSS VDD VDD _05721_ sky130_fd_sc_hd__mux2i_1
X_17460_ network.neuron_in127.counter\[0\] network.neuron_in127.counter\[2\]
+ network.neuron_in127.counter\[1\] net386 network.neuron_in127.counter\[3\]
+ VSS VSS VDD VDD _05722_ sky130_fd_sc_hd__o311a_1
X_17461_ network.in_period\[127\]\[3\] net348 _05722_ VSS
+ VSS VDD VDD _05723_ sky130_fd_sc_hd__a21oi_1
X_17462_ network.neuron_in127.counter\[3\] _05721_ _05723_
+ VSS VSS VDD VDD _02574_ sky130_fd_sc_hd__o21ai_0
X_17463_ network.in_spk01_10 _09442_ VSS VSS VDD VDD _05724_
+ sky130_fd_sc_hd__nand2_1
X_17464_ _06633_ _05724_ net360 VSS VSS VDD VDD _01999_ sky130_fd_sc_hd__a21oi_1
Xplace287 _09243_ VSS VSS VDD VDD net286 sky130_fd_sc_hd__buf_4
X_17466_ network.neuron_in128.counter\[1\] network.neuron_in128.counter\[0\]
+ network.neuron_in128.counter\[2\] net357 VSS VSS VDD VDD _05726_
+ sky130_fd_sc_hd__nor4_1
X_17467_ network.in_period\[128\]\[3\] _05726_ _07209_ VSS
+ VSS VDD VDD _05727_ sky130_fd_sc_hd__mux2i_1
X_17468_ network.neuron_in128.counter\[1\] network.neuron_in128.counter\[0\]
+ network.neuron_in128.counter\[2\] network.neuron_in128.counter\[3\]
+ net384 VSS VSS VDD VDD _05728_ sky130_fd_sc_hd__o311a_1
X_17469_ network.in_period\[128\]\[3\] net357 _05728_ VSS
+ VSS VDD VDD _05729_ sky130_fd_sc_hd__a21oi_1
X_17470_ network.neuron_in128.counter\[3\] _05727_ _05729_
+ VSS VSS VDD VDD _02578_ sky130_fd_sc_hd__o21ai_0
Xplace291 _09266_ VSS VSS VDD VDD net290 sky130_fd_sc_hd__buf_4
X_17472_ network.neuron_in129.counter\[0\] network.neuron_in129.counter\[1\]
+ VSS VSS VDD VDD _05731_ sky130_fd_sc_hd__nor2_1
X_17473_ _00403_ _05731_ VSS VSS VDD VDD _05732_ sky130_fd_sc_hd__nor2_1
X_17474_ network.neuron_in129.counter\[2\] _05732_ VSS VSS
+ VDD VDD _05733_ sky130_fd_sc_hd__nor2_1
X_17475_ network.neuron_in129.counter\[2\] network.neuron_in129.counter\[3\]
+ _05731_ VSS VSS VDD VDD _05734_ sky130_fd_sc_hd__nand3b_1
X_17476_ network.neuron_in129.counter\[3\] _05733_ _05734_
+ VSS VSS VDD VDD _05735_ sky130_fd_sc_hd__o21ai_0
X_17477_ net384 _06841_ network.in_period\[129\]\[3\] VSS
+ VSS VDD VDD _05736_ sky130_fd_sc_hd__a21oi_1
X_17478_ net384 _05735_ _05736_ VSS VSS VDD VDD _02582_ sky130_fd_sc_hd__a21oi_1
X_17479_ network.neuron_in027.counter\[3\] network.in_period\[27\]\[2\]
+ net352 _00466_ VSS VSS VDD VDD _05737_ sky130_fd_sc_hd__o22ai_1
X_17480_ network.neuron_in027.counter\[2\] _00466_ net370
+ VSS VSS VDD VDD _05738_ sky130_fd_sc_hd__nand3_1
X_17481_ network.in_period\[27\]\[2\] net370 _05738_ VSS VSS
+ VDD VDD _05739_ sky130_fd_sc_hd__o21ai_0
X_17482_ _04703_ _05737_ _05739_ VSS VSS VDD VDD _02173_ sky130_fd_sc_hd__a21oi_1
X_17483_ network.in_spk00_10 _09272_ VSS VSS VDD VDD _05740_
+ sky130_fd_sc_hd__nand2_1
X_17484_ _06629_ _05740_ net361 VSS VSS VDD VDD _02000_ sky130_fd_sc_hd__a21oi_1
X_17485_ network.neuron_in130.counter\[1\] network.neuron_in130.counter\[0\]
+ _00460_ VSS VSS VDD VDD _05741_ sky130_fd_sc_hd__o21bai_1
X_17486_ _03625_ _05741_ network.neuron_in130.counter\[3\]
+ VSS VSS VDD VDD _05742_ sky130_fd_sc_hd__a21oi_1
X_17487_ _03625_ network.neuron_in130.counter\[3\] _00459_
+ _00458_ _05742_ VSS VSS VDD VDD _05743_ sky130_fd_sc_hd__a41o_1
Xplace293 _09157_ VSS VSS VDD VDD net292 sky130_fd_sc_hd__buf_4
X_17489_ net377 _03624_ network.in_period\[130\]\[3\] VSS
+ VSS VDD VDD _05745_ sky130_fd_sc_hd__a21oi_1
X_17490_ net377 _05743_ _05745_ VSS VSS VDD VDD _02586_ sky130_fd_sc_hd__a21oi_1
X_17491_ net370 _04705_ VSS VSS VDD VDD _05746_ sky130_fd_sc_hd__nand2_1
X_17492_ network.in_period\[27\]\[1\] _05746_ VSS VSS VDD
+ VDD _05747_ sky130_fd_sc_hd__nand2_1
X_17493_ _00467_ _05746_ _05747_ VSS VSS VDD VDD _02172_ sky130_fd_sc_hd__o21ai_0
X_17494_ network.neuron_in131.counter\[1\] network.neuron_in131.counter\[2\]
+ network.neuron_in131.counter\[0\] net357 VSS VSS VDD VDD _05748_
+ sky130_fd_sc_hd__nor4_1
X_17495_ network.in_period\[131\]\[3\] _05748_ _03686_ VSS
+ VSS VDD VDD _05749_ sky130_fd_sc_hd__mux2i_1
X_17496_ network.neuron_in131.counter\[1\] network.neuron_in131.counter\[2\]
+ network.neuron_in131.counter\[0\] network.neuron_in131.counter\[3\]
+ net384 VSS VSS VDD VDD _05750_ sky130_fd_sc_hd__o311a_1
X_17497_ network.in_period\[131\]\[3\] net357 _05750_ VSS
+ VSS VDD VDD _05751_ sky130_fd_sc_hd__a21oi_1
X_17498_ network.neuron_in131.counter\[3\] _05749_ _05751_
+ VSS VSS VDD VDD _02590_ sky130_fd_sc_hd__o21ai_0
X_17499_ network.in_period\[27\]\[0\] _05746_ VSS VSS VDD
+ VDD _05752_ sky130_fd_sc_hd__nand2_1
X_17500_ network.neuron_in027.counter\[0\] _05746_ _05752_
+ VSS VSS VDD VDD _02171_ sky130_fd_sc_hd__o21ai_0
X_17501_ _09283_ _09452_ VSS VSS VDD VDD _05753_ sky130_fd_sc_hd__nand2_1
X_17502_ network.in_spk12_09 network.in_spk13_09 network.in_spk14_09
+ _05753_ net731 VSS VSS VDD VDD _05754_ sky130_fd_sc_hd__o41ai_1
X_17503_ _06618_ _05754_ net356 VSS VSS VDD VDD _02001_ sky130_fd_sc_hd__a21oi_1
X_17504_ network.neuron_in132.counter\[0\] network.neuron_in132.counter\[1\]
+ _00432_ VSS VSS VDD VDD _05755_ sky130_fd_sc_hd__o21bai_1
X_17505_ _03711_ _05755_ network.neuron_in132.counter\[3\]
+ VSS VSS VDD VDD _05756_ sky130_fd_sc_hd__a21oi_1
X_17506_ _03711_ network.neuron_in132.counter\[3\] _00430_
+ _00431_ _05756_ VSS VSS VDD VDD _05757_ sky130_fd_sc_hd__a41o_1
X_17507_ net384 _04016_ network.in_period\[132\]\[3\] VSS
+ VSS VDD VDD _05758_ sky130_fd_sc_hd__a21oi_1
X_17508_ net384 _05757_ _05758_ VSS VSS VDD VDD _02594_ sky130_fd_sc_hd__a21oi_1
X_17509_ network.neuron_in133.counter\[1\] network.neuron_in133.counter\[0\]
+ _00474_ VSS VSS VDD VDD _05759_ sky130_fd_sc_hd__o21bai_1
X_17510_ _07035_ _05759_ network.neuron_in133.counter\[3\]
+ VSS VSS VDD VDD _05760_ sky130_fd_sc_hd__a21oi_1
X_17511_ _07035_ _00473_ _00472_ network.neuron_in133.counter\[3\]
+ _05760_ VSS VSS VDD VDD _05761_ sky130_fd_sc_hd__a41o_1
X_17512_ net381 _07034_ network.in_period\[133\]\[3\] VSS
+ VSS VDD VDD _05762_ sky130_fd_sc_hd__a21oi_1
X_17513_ net381 _05761_ _05762_ VSS VSS VDD VDD _02598_ sky130_fd_sc_hd__a21oi_1
X_17514_ network.in_spk12_09 network.in_spk13_09 _05753_ network.in_spk14_09
+ VSS VSS VDD VDD _05763_ sky130_fd_sc_hd__o31ai_1
X_17515_ _04758_ _05763_ net358 VSS VSS VDD VDD _02002_ sky130_fd_sc_hd__a21oi_1
X_17516_ network.neuron_in134.counter\[1\] network.neuron_in134.counter\[0\]
+ network.neuron_in134.counter\[2\] VSS VSS VDD VDD _05764_
+ sky130_fd_sc_hd__nor3_1
X_17517_ network.neuron_in134.counter\[3\] _05764_ VSS VSS
+ VDD VDD _05765_ sky130_fd_sc_hd__xnor2_1
X_17518_ network.in_period\[134\]\[3\] _07201_ VSS VSS VDD
+ VDD _05766_ sky130_fd_sc_hd__nand2_1
X_17519_ _07201_ _05765_ _05766_ VSS VSS VDD VDD _02602_ sky130_fd_sc_hd__o21ai_0
X_17520_ network.neuron_in135.counter\[1\] network.neuron_in135.counter\[0\]
+ network.neuron_in135.counter\[2\] net357 VSS VSS VDD VDD _05767_
+ sky130_fd_sc_hd__nor4_1
X_17521_ network.in_period\[135\]\[3\] _05767_ _08120_ VSS
+ VSS VDD VDD _05768_ sky130_fd_sc_hd__mux2i_1
X_17522_ network.neuron_in135.counter\[1\] network.neuron_in135.counter\[0\]
+ network.neuron_in135.counter\[2\] network.neuron_in135.counter\[3\]
+ net384 VSS VSS VDD VDD _05769_ sky130_fd_sc_hd__o311a_1
X_17523_ network.in_period\[135\]\[3\] net357 _05769_ VSS
+ VSS VDD VDD _05770_ sky130_fd_sc_hd__a21oi_1
X_17524_ network.neuron_in135.counter\[3\] _05768_ _05770_
+ VSS VSS VDD VDD _02606_ sky130_fd_sc_hd__o21ai_0
X_17525_ network.in_spk12_09 _05753_ network.in_spk13_09 VSS
+ VSS VDD VDD _05771_ sky130_fd_sc_hd__o21ai_0
X_17526_ _06962_ _05771_ net358 VSS VSS VDD VDD _02003_ sky130_fd_sc_hd__a21oi_1
X_17527_ network.neuron_in136.counter\[0\] network.neuron_in136.counter\[2\]
+ network.neuron_in136.counter\[1\] net358 VSS VSS VDD VDD _05772_
+ sky130_fd_sc_hd__nor4_1
X_17528_ network.in_period\[136\]\[3\] _05772_ _06682_ VSS
+ VSS VDD VDD _05773_ sky130_fd_sc_hd__mux2i_1
Xplace288 _09189_ VSS VSS VDD VDD net287 sky130_fd_sc_hd__buf_4
X_17530_ network.neuron_in136.counter\[0\] network.neuron_in136.counter\[2\]
+ network.neuron_in136.counter\[1\] net384 network.neuron_in136.counter\[3\]
+ VSS VSS VDD VDD _05775_ sky130_fd_sc_hd__o311a_1
X_17531_ network.in_period\[136\]\[3\] net358 _05775_ VSS
+ VSS VDD VDD _05776_ sky130_fd_sc_hd__a21oi_1
X_17532_ network.neuron_in136.counter\[3\] _05773_ _05776_
+ VSS VSS VDD VDD _02610_ sky130_fd_sc_hd__o21ai_0
X_17533_ network.neuron_in137.counter\[1\] network.neuron_in137.counter\[0\]
+ network.neuron_in137.counter\[2\] VSS VSS VDD VDD _05777_
+ sky130_fd_sc_hd__nor3_1
X_17534_ network.neuron_in137.counter\[3\] _05777_ VSS VSS
+ VDD VDD _05778_ sky130_fd_sc_hd__xnor2_1
X_17535_ net683 _03503_ VSS VSS VDD VDD _05779_ sky130_fd_sc_hd__nand2_1
X_17536_ _03503_ _05778_ _05779_ VSS VSS VDD VDD _02614_ sky130_fd_sc_hd__o21ai_0
X_17537_ network.in_spk12_09 _05753_ VSS VSS VDD VDD _05780_
+ sky130_fd_sc_hd__nand2_1
Xoutput48 net47 VSS VSS VDD VDD result_class[1] sky130_fd_sc_hd__buf_1
X_17539_ _07518_ _05780_ net356 VSS VSS VDD VDD _02004_ sky130_fd_sc_hd__a21oi_1
X_17540_ network.neuron_in138.counter\[0\] network.neuron_in138.counter\[1\]
+ _00614_ VSS VSS VDD VDD _05782_ sky130_fd_sc_hd__o21bai_1
X_17541_ _03534_ _05782_ network.neuron_in138.counter\[3\]
+ VSS VSS VDD VDD _05783_ sky130_fd_sc_hd__a21oi_1
X_17542_ _03534_ _00612_ _00613_ network.neuron_in138.counter\[3\]
+ _05783_ VSS VSS VDD VDD _05784_ sky130_fd_sc_hd__a41o_1
X_17543_ net377 _03533_ network.in_period\[138\]\[3\] VSS
+ VSS VDD VDD _05785_ sky130_fd_sc_hd__a21oi_1
X_17544_ net377 _05784_ _05785_ VSS VSS VDD VDD _02618_ sky130_fd_sc_hd__a21oi_1
X_17545_ network.neuron_in139.counter\[0\] VSS VSS VDD VDD
+ _01093_ sky130_fd_sc_hd__inv_1
X_17546_ network.neuron_in139.counter\[1\] network.neuron_in139.counter\[0\]
+ _01095_ VSS VSS VDD VDD _05786_ sky130_fd_sc_hd__o21bai_1
X_17547_ _08339_ _05786_ network.neuron_in139.counter\[3\]
+ VSS VSS VDD VDD _05787_ sky130_fd_sc_hd__a21oi_1
X_17548_ _08339_ network.neuron_in139.counter\[3\] _01094_
+ _01093_ _05787_ VSS VSS VDD VDD _05788_ sky130_fd_sc_hd__a41o_1
X_17549_ net377 _08338_ network.in_period\[139\]\[3\] VSS
+ VSS VDD VDD _05789_ sky130_fd_sc_hd__a21oi_1
X_17550_ net377 _05788_ _05789_ VSS VSS VDD VDD _02622_ sky130_fd_sc_hd__a21oi_1
X_17551_ _09386_ _09332_ network.in_spk11_09 VSS VSS VDD VDD
+ _05790_ sky130_fd_sc_hd__o21ai_0
X_17552_ _06944_ _05790_ net356 VSS VSS VDD VDD _02005_ sky130_fd_sc_hd__a21oi_1
X_17553_ network.neuron_in140.counter\[1\] network.neuron_in140.counter\[0\]
+ network.neuron_in140.counter\[2\] net360 VSS VSS VDD VDD _05791_
+ sky130_fd_sc_hd__nor4_1
X_17554_ network.in_period\[140\]\[3\] _05791_ _07823_ VSS
+ VSS VDD VDD _05792_ sky130_fd_sc_hd__mux2i_1
X_17555_ network.neuron_in140.counter\[1\] network.neuron_in140.counter\[0\]
+ network.neuron_in140.counter\[2\] network.neuron_in140.counter\[3\]
+ net377 VSS VSS VDD VDD _05793_ sky130_fd_sc_hd__o311a_1
X_17556_ network.in_period\[140\]\[3\] net360 _05793_ VSS
+ VSS VDD VDD _05794_ sky130_fd_sc_hd__a21oi_1
X_17557_ network.neuron_in140.counter\[3\] _05792_ _05794_
+ VSS VSS VDD VDD _02626_ sky130_fd_sc_hd__o21ai_0
X_17558_ network.neuron_in141.counter\[1\] network.neuron_in141.counter\[0\]
+ network.neuron_in141.counter\[2\] VSS VSS VDD VDD _05795_
+ sky130_fd_sc_hd__nor3_1
X_17559_ network.neuron_in141.counter\[3\] _05795_ VSS VSS
+ VDD VDD _05796_ sky130_fd_sc_hd__xnor2_1
X_17560_ network.in_period\[141\]\[3\] _07081_ VSS VSS VDD
+ VDD _05797_ sky130_fd_sc_hd__nand2_1
X_17561_ _07081_ _05796_ _05797_ VSS VSS VDD VDD _02630_ sky130_fd_sc_hd__o21ai_0
X_17562_ network.in_spk08_09 network.in_spk09_09 _09332_ network.in_spk10_09
+ VSS VSS VDD VDD _05798_ sky130_fd_sc_hd__o31ai_1
X_17563_ _07829_ _05798_ net356 VSS VSS VDD VDD _02006_ sky130_fd_sc_hd__a21oi_1
X_17564_ network.neuron_in142.counter\[0\] network.neuron_in142.counter\[1\]
+ network.neuron_in142.counter\[2\] VSS VSS VDD VDD _05799_
+ sky130_fd_sc_hd__nor3_1
X_17565_ network.neuron_in142.counter\[3\] _05799_ VSS VSS
+ VDD VDD _05800_ sky130_fd_sc_hd__xnor2_1
X_17566_ net662 _06992_ VSS VSS VDD VDD _05801_ sky130_fd_sc_hd__nand2_1
X_17567_ _06992_ _05800_ _05801_ VSS VSS VDD VDD _02634_ sky130_fd_sc_hd__o21ai_0
X_17568_ network.neuron_in102.counter\[0\] VSS VSS VDD VDD
+ _00769_ sky130_fd_sc_hd__inv_1
X_17569_ net374 _04840_ VSS VSS VDD VDD _05802_ sky130_fd_sc_hd__nand2_1
X_17570_ network.in_period\[102\]\[0\] _05802_ VSS VSS VDD
+ VDD _05803_ sky130_fd_sc_hd__nand2_1
X_17571_ network.neuron_in102.counter\[0\] _05802_ _05803_
+ VSS VSS VDD VDD _02471_ sky130_fd_sc_hd__o21ai_0
Xoutput47 net46 VSS VSS VDD VDD result_class[0] sky130_fd_sc_hd__buf_1
X_17573_ net374 _04845_ VSS VSS VDD VDD _05805_ sky130_fd_sc_hd__nand2_1
X_17574_ network.in_period\[100\]\[1\] _05805_ VSS VSS VDD
+ VDD _05806_ sky130_fd_sc_hd__nand2_1
X_17575_ _00056_ _05805_ _05806_ VSS VSS VDD VDD _02464_ sky130_fd_sc_hd__o21ai_0
X_17576_ network.neuron_in143.counter\[1\] network.neuron_in143.counter\[0\]
+ VSS VSS VDD VDD _05807_ sky130_fd_sc_hd__nor2_1
X_17577_ _00717_ _05807_ VSS VSS VDD VDD _05808_ sky130_fd_sc_hd__nor2_1
X_17578_ network.neuron_in143.counter\[2\] _05808_ VSS VSS
+ VDD VDD _05809_ sky130_fd_sc_hd__nor2_1
X_17579_ network.neuron_in143.counter\[2\] network.neuron_in143.counter\[3\]
+ _05807_ VSS VSS VDD VDD _05810_ sky130_fd_sc_hd__nand3b_1
X_17580_ network.neuron_in143.counter\[3\] _05809_ _05810_
+ VSS VSS VDD VDD _05811_ sky130_fd_sc_hd__o21ai_0
X_17581_ network.neuron_in143.counter\[3\] _00717_ VSS VSS
+ VDD VDD _05812_ sky130_fd_sc_hd__nand2b_1
X_17582_ net377 _05812_ network.in_period\[143\]\[3\] VSS
+ VSS VDD VDD _05813_ sky130_fd_sc_hd__a21oi_1
X_17583_ net377 _05811_ _05813_ VSS VSS VDD VDD _02638_ sky130_fd_sc_hd__a21oi_1
X_17584_ network.in_spk08_09 _09332_ network.in_spk09_09 VSS
+ VSS VDD VDD _05814_ sky130_fd_sc_hd__o21ai_0
X_17585_ _04762_ _05814_ net356 VSS VSS VDD VDD _02007_ sky130_fd_sc_hd__a21oi_1
X_17586_ network.neuron_in144.counter\[2\] VSS VSS VDD VDD
+ _05815_ sky130_fd_sc_hd__inv_1
X_17587_ network.neuron_in144.counter\[0\] network.neuron_in144.counter\[1\]
+ VSS VSS VDD VDD _05816_ sky130_fd_sc_hd__nor2_1
X_17588_ network.neuron_in144.counter\[2\] _00667_ net356
+ _05816_ VSS VSS VDD VDD _05817_ sky130_fd_sc_hd__nor4b_1
X_17589_ _05815_ _00667_ network.in_period\[144\]\[3\] _05817_
+ VSS VSS VDD VDD _05818_ sky130_fd_sc_hd__a31oi_1
X_17590_ network.neuron_in144.counter\[0\] network.neuron_in144.counter\[1\]
+ network.neuron_in144.counter\[2\] network.neuron_in144.counter\[3\]
+ net387 VSS VSS VDD VDD _05819_ sky130_fd_sc_hd__o311a_1
X_17591_ network.in_period\[144\]\[3\] net356 _05819_ VSS
+ VSS VDD VDD _05820_ sky130_fd_sc_hd__a21oi_1
X_17592_ network.neuron_in144.counter\[3\] _05818_ _05820_
+ VSS VSS VDD VDD _02642_ sky130_fd_sc_hd__o21ai_0
X_17593_ net373 _04851_ VSS VSS VDD VDD _05821_ sky130_fd_sc_hd__nand2_1
X_17594_ network.in_period\[98\]\[1\] _05821_ VSS VSS VDD
+ VDD _05822_ sky130_fd_sc_hd__nand2_1
X_17595_ _00722_ _05821_ _05822_ VSS VSS VDD VDD _02456_ sky130_fd_sc_hd__o21ai_0
X_17596_ network.neuron_in145.counter\[1\] network.neuron_in145.counter\[0\]
+ _00643_ VSS VSS VDD VDD _05823_ sky130_fd_sc_hd__o21bai_1
X_17597_ _03875_ _05823_ network.neuron_in145.counter\[3\]
+ VSS VSS VDD VDD _05824_ sky130_fd_sc_hd__a21oi_1
X_17598_ _03875_ _00642_ _00641_ network.neuron_in145.counter\[3\]
+ _05824_ VSS VSS VDD VDD _05825_ sky130_fd_sc_hd__a41o_1
X_17599_ net387 _03874_ network.in_period\[145\]\[3\] VSS
+ VSS VDD VDD _05826_ sky130_fd_sc_hd__a21oi_1
X_17600_ net387 _05825_ _05826_ VSS VSS VDD VDD _02646_ sky130_fd_sc_hd__a21oi_1
X_17601_ network.neuron_in100.counter\[3\] network.in_period\[100\]\[2\]
+ net353 _00055_ VSS VSS VDD VDD _05827_ sky130_fd_sc_hd__o22ai_1
X_17602_ network.neuron_in100.counter\[2\] _00055_ net374
+ VSS VSS VDD VDD _05828_ sky130_fd_sc_hd__nand3_1
X_17603_ network.in_period\[100\]\[2\] net374 _05828_ VSS
+ VSS VDD VDD _05829_ sky130_fd_sc_hd__o21ai_0
X_17604_ _04843_ _05827_ _05829_ VSS VSS VDD VDD _02465_ sky130_fd_sc_hd__a21oi_1
X_17605_ network.in_spk08_09 _09332_ VSS VSS VDD VDD _05830_
+ sky130_fd_sc_hd__nand2_1
X_17606_ _04765_ _05830_ net356 VSS VSS VDD VDD _02008_ sky130_fd_sc_hd__a21oi_1
X_17607_ network.neuron_in146.counter\[1\] network.neuron_in146.counter\[0\]
+ network.neuron_in146.counter\[2\] net364 VSS VSS VDD VDD _05831_
+ sky130_fd_sc_hd__nor4_1
X_17608_ network.in_period\[146\]\[3\] _05831_ _06857_ VSS
+ VSS VDD VDD _05832_ sky130_fd_sc_hd__mux2i_1
X_17609_ network.neuron_in146.counter\[1\] network.neuron_in146.counter\[0\]
+ network.neuron_in146.counter\[2\] network.neuron_in146.counter\[3\]
+ net387 VSS VSS VDD VDD _05833_ sky130_fd_sc_hd__o311a_1
X_17610_ network.in_period\[146\]\[3\] net364 _05833_ VSS
+ VSS VDD VDD _05834_ sky130_fd_sc_hd__a21oi_1
X_17611_ network.neuron_in146.counter\[3\] _05832_ _05834_
+ VSS VSS VDD VDD _02650_ sky130_fd_sc_hd__o21ai_0
X_17612_ network.neuron_in147.counter\[1\] network.neuron_in147.counter\[0\]
+ _01200_ VSS VSS VDD VDD _05835_ sky130_fd_sc_hd__o21bai_1
X_17613_ _03852_ _05835_ network.neuron_in147.counter\[3\]
+ VSS VSS VDD VDD _05836_ sky130_fd_sc_hd__a21oi_1
X_17614_ _03852_ _01199_ _01198_ network.neuron_in147.counter\[3\]
+ _05836_ VSS VSS VDD VDD _05837_ sky130_fd_sc_hd__a41o_1
X_17615_ net381 _03851_ net602 VSS VSS VDD VDD _05838_ sky130_fd_sc_hd__a21oi_1
X_17616_ net381 _05837_ _05838_ VSS VSS VDD VDD _02654_ sky130_fd_sc_hd__a21oi_1
X_17617_ network.neuron_in097.counter\[0\] VSS VSS VDD VDD
+ _00073_ sky130_fd_sc_hd__inv_1
X_17618_ net373 _04546_ VSS VSS VDD VDD _05839_ sky130_fd_sc_hd__nand2_1
X_17619_ network.in_period\[97\]\[0\] _05839_ VSS VSS VDD
+ VDD _05840_ sky130_fd_sc_hd__nand2_1
X_17620_ network.neuron_in097.counter\[0\] _05839_ _05840_
+ VSS VSS VDD VDD _02451_ sky130_fd_sc_hd__o21ai_0
X_17621_ _09206_ _09283_ VSS VSS VDD VDD _05841_ sky130_fd_sc_hd__nand2_1
X_17622_ _09329_ _05841_ network.in_spk07_09 VSS VSS VDD VDD
+ _05842_ sky130_fd_sc_hd__o21ai_0
X_17623_ _04767_ _05842_ net356 VSS VSS VDD VDD _02009_ sky130_fd_sc_hd__a21oi_1
X_17624_ network.neuron_hid6.IF0.ref_counter\[1\] VSS VSS
+ VDD VDD _00733_ sky130_fd_sc_hd__inv_1
X_17625_ network.neuron_in148.counter\[1\] network.neuron_in148.counter\[2\]
+ network.neuron_in148.counter\[0\] net348 VSS VSS VDD VDD _05843_
+ sky130_fd_sc_hd__nor4_1
X_17626_ network.in_period\[148\]\[3\] _05843_ _06951_ VSS
+ VSS VDD VDD _05844_ sky130_fd_sc_hd__mux2i_1
Xoutput46 net45 VSS VSS VDD VDD no_spike sky130_fd_sc_hd__buf_1
X_17628_ network.neuron_in148.counter\[1\] network.neuron_in148.counter\[2\]
+ network.neuron_in148.counter\[0\] network.neuron_in148.counter\[3\]
+ net387 VSS VSS VDD VDD _05846_ sky130_fd_sc_hd__o311a_1
X_17629_ network.in_period\[148\]\[3\] net348 _05846_ VSS
+ VSS VDD VDD _05847_ sky130_fd_sc_hd__a21oi_1
X_17630_ network.neuron_in148.counter\[3\] _05844_ _05847_
+ VSS VSS VDD VDD _02658_ sky130_fd_sc_hd__o21ai_0
X_17631_ net373 _04848_ VSS VSS VDD VDD _05848_ sky130_fd_sc_hd__nand2_1
X_17632_ network.in_period\[99\]\[0\] _05848_ VSS VSS VDD
+ VDD _05849_ sky130_fd_sc_hd__nand2_1
X_17633_ network.neuron_in099.counter\[0\] _05848_ _05849_
+ VSS VSS VDD VDD _02459_ sky130_fd_sc_hd__o21ai_0
X_17634_ network.neuron_in149.counter\[1\] network.neuron_in149.counter\[2\]
+ network.neuron_in149.counter\[0\] VSS VSS VDD VDD _05850_
+ sky130_fd_sc_hd__nor3_1
X_17635_ network.neuron_in149.counter\[3\] _05850_ VSS VSS
+ VDD VDD _05851_ sky130_fd_sc_hd__xnor2_1
X_17636_ network.in_period\[149\]\[3\] _04349_ VSS VSS VDD
+ VDD _05852_ sky130_fd_sc_hd__nand2_1
X_17637_ _04349_ _05851_ _05852_ VSS VSS VDD VDD _02662_ sky130_fd_sc_hd__o21ai_0
X_17638_ network.in_spk04_09 network.in_spk05_09 _05841_ network.in_spk06_09
+ VSS VSS VDD VDD _05853_ sky130_fd_sc_hd__o31ai_1
X_17639_ _08268_ _05853_ net356 VSS VSS VDD VDD _02010_ sky130_fd_sc_hd__a21oi_1
X_17640_ network.neuron_in150.counter\[0\] network.neuron_in150.counter\[1\]
+ network.neuron_in150.counter\[2\] VSS VSS VDD VDD _05854_
+ sky130_fd_sc_hd__nor3_1
X_17641_ network.neuron_in150.counter\[3\] _05854_ VSS VSS
+ VDD VDD _05855_ sky130_fd_sc_hd__xnor2_1
X_17642_ net582 _08269_ VSS VSS VDD VDD _05856_ sky130_fd_sc_hd__nand2_1
X_17643_ _08269_ _05855_ _05856_ VSS VSS VDD VDD _02666_ sky130_fd_sc_hd__o21ai_0
X_17644_ network.neuron_in098.counter\[3\] network.in_period\[98\]\[2\]
+ net352 _00721_ VSS VSS VDD VDD _05857_ sky130_fd_sc_hd__o22ai_1
Xoutput45 net44 VSS VSS VDD VDD load_ready sky130_fd_sc_hd__buf_1
X_17646_ network.neuron_in098.counter\[2\] _00721_ net373
+ VSS VSS VDD VDD _05859_ sky130_fd_sc_hd__nand3_1
X_17647_ network.in_period\[98\]\[2\] net373 _05859_ VSS VSS
+ VDD VDD _05860_ sky130_fd_sc_hd__o21ai_0
X_17648_ _04850_ _05857_ _05860_ VSS VSS VDD VDD _02457_ sky130_fd_sc_hd__a21oi_1
X_17649_ net387 _04767_ VSS VSS VDD VDD _05861_ sky130_fd_sc_hd__nand2_1
X_17650_ network.neuron_in151.counter\[0\] network.neuron_in151.counter\[1\]
+ network.neuron_in151.counter\[2\] VSS VSS VDD VDD _05862_
+ sky130_fd_sc_hd__nor3_1
X_17651_ network.neuron_in151.counter\[3\] _05862_ VSS VSS
+ VDD VDD _05863_ sky130_fd_sc_hd__xnor2_1
X_17652_ net565 _05861_ VSS VSS VDD VDD _05864_ sky130_fd_sc_hd__nand2_1
X_17653_ _05861_ _05863_ _05864_ VSS VSS VDD VDD _02670_ sky130_fd_sc_hd__o21ai_0
X_17654_ network.neuron_in097.counter\[3\] network.in_period\[97\]\[2\]
+ _00075_ net353 VSS VSS VDD VDD _05865_ sky130_fd_sc_hd__o22ai_1
X_17655_ network.neuron_in097.counter\[2\] _00075_ net373
+ VSS VSS VDD VDD _05866_ sky130_fd_sc_hd__nand3_1
X_17656_ network.in_period\[97\]\[2\] net373 _05866_ VSS VSS
+ VDD VDD _05867_ sky130_fd_sc_hd__o21ai_0
X_17657_ _04544_ _05865_ _05867_ VSS VSS VDD VDD _02453_ sky130_fd_sc_hd__a21oi_1
X_17658_ network.in_period\[97\]\[1\] _05839_ VSS VSS VDD
+ VDD _05868_ sky130_fd_sc_hd__nand2_1
X_17659_ _00076_ _05839_ _05868_ VSS VSS VDD VDD _02452_ sky130_fd_sc_hd__o21ai_0
X_17660_ network.in_spk04_09 _05841_ network.in_spk05_09 VSS
+ VSS VDD VDD _05869_ sky130_fd_sc_hd__o21ai_0
X_17661_ _04348_ _05869_ net356 VSS VSS VDD VDD _02011_ sky130_fd_sc_hd__a21oi_1
X_17662_ network.in_period\[98\]\[0\] _05821_ VSS VSS VDD
+ VDD _05870_ sky130_fd_sc_hd__nand2_1
X_17663_ network.neuron_in098.counter\[0\] _05821_ _05870_
+ VSS VSS VDD VDD _02455_ sky130_fd_sc_hd__o21ai_0
X_17664_ network.neuron_in152.counter\[0\] network.neuron_in152.counter\[1\]
+ _00502_ VSS VSS VDD VDD _05871_ sky130_fd_sc_hd__o21bai_1
X_17665_ _04764_ _05871_ network.neuron_in152.counter\[3\]
+ VSS VSS VDD VDD _05872_ sky130_fd_sc_hd__a21oi_1
X_17666_ _04764_ _00500_ _00501_ network.neuron_in152.counter\[3\]
+ _05872_ VSS VSS VDD VDD _05873_ sky130_fd_sc_hd__a41o_1
X_17667_ net386 _04763_ network.in_period\[152\]\[3\] VSS
+ VSS VDD VDD _05874_ sky130_fd_sc_hd__a21oi_1
X_17668_ net386 _05873_ _05874_ VSS VSS VDD VDD _02674_ sky130_fd_sc_hd__a21oi_1
X_17669_ network.neuron_in099.counter\[3\] network.in_period\[99\]\[2\]
+ _00706_ net352 VSS VSS VDD VDD _05875_ sky130_fd_sc_hd__o22ai_1
X_17670_ network.neuron_in099.counter\[2\] _00706_ net373
+ VSS VSS VDD VDD _05876_ sky130_fd_sc_hd__nand3_1
X_17671_ network.in_period\[99\]\[2\] net373 _05876_ VSS VSS
+ VDD VDD _05877_ sky130_fd_sc_hd__o21ai_0
X_17672_ _04847_ _05875_ _05877_ VSS VSS VDD VDD _02461_ sky130_fd_sc_hd__a21oi_1
X_17673_ network.in_period\[99\]\[1\] _05848_ VSS VSS VDD
+ VDD _05878_ sky130_fd_sc_hd__nand2_1
X_17674_ _00707_ _05848_ _05878_ VSS VSS VDD VDD _02460_ sky130_fd_sc_hd__o21ai_0
Xoutput44 net43 VSS VSS VDD VDD input_complete sky130_fd_sc_hd__buf_1
X_17676_ network.neuron_in153.counter\[0\] network.neuron_in153.counter\[1\]
+ _00494_ VSS VSS VDD VDD _05880_ sky130_fd_sc_hd__o21bai_1
X_17677_ _04761_ _05880_ network.neuron_in153.counter\[3\]
+ VSS VSS VDD VDD _05881_ sky130_fd_sc_hd__a21oi_1
X_17678_ _04761_ network.neuron_in153.counter\[3\] _00492_
+ _00493_ _05881_ VSS VSS VDD VDD _05882_ sky130_fd_sc_hd__a41o_1
X_17679_ net381 _04760_ network.in_period\[153\]\[3\] VSS
+ VSS VDD VDD _05883_ sky130_fd_sc_hd__a21oi_1
X_17680_ net381 _05882_ _05883_ VSS VSS VDD VDD _02678_ sky130_fd_sc_hd__a21oi_1
X_17681_ network.in_period\[100\]\[0\] _05805_ VSS VSS VDD
+ VDD _05884_ sky130_fd_sc_hd__nand2_1
X_17682_ network.neuron_in100.counter\[0\] _05805_ _05884_
+ VSS VSS VDD VDD _02463_ sky130_fd_sc_hd__o21ai_0
X_17683_ network.neuron_in101.counter\[2\] VSS VSS VDD VDD
+ _05885_ sky130_fd_sc_hd__inv_1
X_17684_ network.neuron_in101.counter\[3\] network.in_period\[101\]\[2\]
+ net354 _00835_ VSS VSS VDD VDD _05886_ sky130_fd_sc_hd__o22ai_1
X_17685_ network.neuron_in101.counter\[2\] _00835_ net374
+ VSS VSS VDD VDD _05887_ sky130_fd_sc_hd__nand3_1
X_17686_ network.in_period\[101\]\[2\] net374 _05887_ VSS
+ VSS VDD VDD _05888_ sky130_fd_sc_hd__o21ai_0
X_17687_ _05885_ _05886_ _05888_ VSS VSS VDD VDD _02469_ sky130_fd_sc_hd__a21oi_1
X_17688_ network.in_spk04_09 _05841_ VSS VSS VDD VDD _05889_
+ sky130_fd_sc_hd__nand2_1
X_17689_ _06952_ _05889_ net356 VSS VSS VDD VDD _02012_ sky130_fd_sc_hd__a21oi_1
X_17690_ network.neuron_in154.counter\[1\] network.neuron_in154.counter\[0\]
+ _01166_ VSS VSS VDD VDD _05890_ sky130_fd_sc_hd__o21bai_1
X_17691_ _07828_ _05890_ network.neuron_in154.counter\[3\]
+ VSS VSS VDD VDD _05891_ sky130_fd_sc_hd__a21oi_1
X_17692_ _07828_ _01165_ _01164_ network.neuron_in154.counter\[3\]
+ _05891_ VSS VSS VDD VDD _05892_ sky130_fd_sc_hd__a41o_1
Xoutput43 net42 VSS VSS VDD VDD inference_cycles[9] sky130_fd_sc_hd__buf_1
X_17694_ net387 _07827_ network.in_period\[154\]\[3\] VSS
+ VSS VDD VDD _05894_ sky130_fd_sc_hd__a21oi_1
X_17695_ net387 _05892_ _05894_ VSS VSS VDD VDD _02682_ sky130_fd_sc_hd__a21oi_1
X_17696_ network.in_period\[101\]\[1\] _05595_ VSS VSS VDD
+ VDD _05895_ sky130_fd_sc_hd__nand2_1
X_17697_ _00836_ _05595_ _05895_ VSS VSS VDD VDD _02468_ sky130_fd_sc_hd__o21ai_0
X_17698_ network.in_period\[101\]\[0\] _05595_ VSS VSS VDD
+ VDD _05896_ sky130_fd_sc_hd__nand2_1
X_17699_ network.neuron_in101.counter\[0\] _05595_ _05896_
+ VSS VSS VDD VDD _02467_ sky130_fd_sc_hd__o21ai_0
X_17700_ network.neuron_in155.counter\[1\] network.neuron_in155.counter\[0\]
+ _01099_ VSS VSS VDD VDD _05897_ sky130_fd_sc_hd__o21bai_1
X_17701_ _06943_ _05897_ network.neuron_in155.counter\[3\]
+ VSS VSS VDD VDD _05898_ sky130_fd_sc_hd__a21oi_1
X_17702_ _06943_ network.neuron_in155.counter\[3\] _01098_
+ _01097_ _05898_ VSS VSS VDD VDD _05899_ sky130_fd_sc_hd__a41o_1
X_17703_ net384 _06942_ network.in_period\[155\]\[3\] VSS
+ VSS VDD VDD _05900_ sky130_fd_sc_hd__a21oi_1
X_17704_ net384 _05899_ _05900_ VSS VSS VDD VDD _02686_ sky130_fd_sc_hd__a21oi_1
X_17705_ network.neuron_in102.counter\[3\] network.in_period\[102\]\[2\]
+ net354 _00771_ VSS VSS VDD VDD _05901_ sky130_fd_sc_hd__o22ai_1
X_17706_ network.neuron_in102.counter\[2\] _00771_ net374
+ VSS VSS VDD VDD _05902_ sky130_fd_sc_hd__nand3_1
X_17707_ network.in_period\[102\]\[2\] net374 _05902_ VSS
+ VSS VDD VDD _05903_ sky130_fd_sc_hd__o21ai_0
X_17708_ _04838_ _05901_ _05903_ VSS VSS VDD VDD _02473_ sky130_fd_sc_hd__a21oi_1
X_17709_ _09326_ _09283_ VSS VSS VDD VDD _05904_ sky130_fd_sc_hd__nand2_1
X_17710_ network.in_spk02_09 _05904_ network.in_spk03_09 VSS
+ VSS VDD VDD _05905_ sky130_fd_sc_hd__o21ai_0
X_17711_ _03853_ _05905_ net356 VSS VSS VDD VDD _02013_ sky130_fd_sc_hd__a21oi_1
X_17712_ network.neuron_in156.counter\[1\] network.neuron_in156.counter\[0\]
+ network.neuron_in156.counter\[2\] net361 VSS VSS VDD VDD _05906_
+ sky130_fd_sc_hd__nor4_1
X_17713_ network.in_period\[156\]\[3\] _05906_ _07517_ VSS
+ VSS VDD VDD _05907_ sky130_fd_sc_hd__mux2i_1
X_17714_ network.neuron_in156.counter\[1\] network.neuron_in156.counter\[0\]
+ network.neuron_in156.counter\[2\] network.neuron_in156.counter\[3\]
+ net381 VSS VSS VDD VDD _05908_ sky130_fd_sc_hd__o311a_1
X_17715_ network.in_period\[156\]\[3\] net361 _05908_ VSS
+ VSS VDD VDD _05909_ sky130_fd_sc_hd__a21oi_1
X_17716_ network.neuron_in156.counter\[3\] _05907_ _05909_
+ VSS VSS VDD VDD _02690_ sky130_fd_sc_hd__o21ai_0
X_17717_ network.in_period\[102\]\[1\] _05802_ VSS VSS VDD
+ VDD _05910_ sky130_fd_sc_hd__nand2_1
X_17718_ _00772_ _05802_ _05910_ VSS VSS VDD VDD _02472_ sky130_fd_sc_hd__o21ai_0
X_17719_ network.neuron_in157.counter\[0\] network.neuron_in157.counter\[2\]
+ network.neuron_in157.counter\[1\] VSS VSS VDD VDD _05911_
+ sky130_fd_sc_hd__nor3_1
X_17720_ network.neuron_in157.counter\[3\] _05911_ VSS VSS
+ VDD VDD _05912_ sky130_fd_sc_hd__xnor2_1
X_17721_ net767 _06963_ VSS VSS VDD VDD _05913_ sky130_fd_sc_hd__nand2_1
X_17722_ _06963_ _05912_ _05913_ VSS VSS VDD VDD _02694_ sky130_fd_sc_hd__o21ai_0
X_17723_ net382 _04831_ VSS VSS VDD VDD _05914_ sky130_fd_sc_hd__nand2_1
X_17724_ network.in_period\[105\]\[0\] _05914_ VSS VSS VDD
+ VDD _05915_ sky130_fd_sc_hd__nand2_1
X_17725_ network.neuron_in105.counter\[0\] _05914_ _05915_
+ VSS VSS VDD VDD _02483_ sky130_fd_sc_hd__o21ai_0
X_17726_ network.in_spk02_09 _05904_ VSS VSS VDD VDD _05916_
+ sky130_fd_sc_hd__nand2_1
Xoutput42 net41 VSS VSS VDD VDD inference_cycles[8] sky130_fd_sc_hd__buf_1
X_17728_ _06858_ _05916_ net356 VSS VSS VDD VDD _02014_ sky130_fd_sc_hd__a21oi_1
X_17729_ network.neuron_in158.counter\[0\] network.neuron_in158.counter\[1\]
+ _00671_ VSS VSS VDD VDD _05918_ sky130_fd_sc_hd__o21bai_1
X_17730_ _04757_ _05918_ network.neuron_in158.counter\[3\]
+ VSS VSS VDD VDD _05919_ sky130_fd_sc_hd__a21oi_1
X_17731_ _04757_ network.neuron_in158.counter\[3\] _00669_
+ _00670_ _05919_ VSS VSS VDD VDD _05920_ sky130_fd_sc_hd__a41o_1
X_17732_ net381 _04756_ network.in_period\[158\]\[3\] VSS
+ VSS VDD VDD _05921_ sky130_fd_sc_hd__a21oi_1
X_17733_ net381 _05920_ _05921_ VSS VSS VDD VDD _02698_ sky130_fd_sc_hd__a21oi_1
X_17734_ network.neuron_in159.counter\[0\] network.neuron_in159.counter\[2\]
+ network.neuron_in159.counter\[1\] net361 VSS VSS VDD VDD _05922_
+ sky130_fd_sc_hd__nor4_1
X_17735_ network.in_period\[159\]\[3\] _05922_ _06617_ VSS
+ VSS VDD VDD _05923_ sky130_fd_sc_hd__mux2i_1
X_17736_ network.neuron_in159.counter\[0\] network.neuron_in159.counter\[2\]
+ network.neuron_in159.counter\[1\] network.neuron_in159.counter\[3\]
+ net381 VSS VSS VDD VDD _05924_ sky130_fd_sc_hd__o311a_1
X_17737_ network.in_period\[159\]\[3\] net361 _05924_ VSS
+ VSS VDD VDD _05925_ sky130_fd_sc_hd__a21oi_1
X_17738_ network.neuron_in159.counter\[3\] _05923_ _05925_
+ VSS VSS VDD VDD _02702_ sky130_fd_sc_hd__o21ai_0
X_17739_ network.neuron_in104.counter\[3\] network.in_period\[104\]\[2\]
+ net349 _00531_ VSS VSS VDD VDD _05926_ sky130_fd_sc_hd__o22ai_1
X_17740_ network.neuron_in104.counter\[2\] _00531_ net382
+ VSS VSS VDD VDD _05927_ sky130_fd_sc_hd__nand3_1
X_17741_ network.in_period\[104\]\[2\] net382 _05927_ VSS
+ VSS VDD VDD _05928_ sky130_fd_sc_hd__o21ai_0
X_17742_ _04833_ _05926_ _05928_ VSS VSS VDD VDD _02481_ sky130_fd_sc_hd__a21oi_1
X_17743_ network.in_spk00_09 _09282_ network.in_spk01_09 VSS
+ VSS VDD VDD _05929_ sky130_fd_sc_hd__o21ai_0
X_17744_ _03876_ _05929_ net356 VSS VSS VDD VDD _02015_ sky130_fd_sc_hd__a21oi_1
X_17745_ network.neuron_in160.counter\[0\] network.neuron_in160.counter\[1\]
+ network.neuron_in160.counter\[2\] net361 VSS VSS VDD VDD _05930_
+ sky130_fd_sc_hd__nor4_1
X_17746_ network.in_period\[160\]\[3\] _05930_ _06625_ VSS
+ VSS VDD VDD _05931_ sky130_fd_sc_hd__mux2i_1
X_17747_ network.neuron_in160.counter\[0\] network.neuron_in160.counter\[1\]
+ network.neuron_in160.counter\[2\] network.neuron_in160.counter\[3\]
+ net380 VSS VSS VDD VDD _05932_ sky130_fd_sc_hd__o311a_1
X_17748_ network.in_period\[160\]\[3\] net361 _05932_ VSS
+ VSS VDD VDD _05933_ sky130_fd_sc_hd__a21oi_1
X_17749_ network.neuron_in160.counter\[3\] _05931_ _05933_
+ VSS VSS VDD VDD _02706_ sky130_fd_sc_hd__o21ai_0
X_17750_ network.neuron_in161.counter\[0\] network.neuron_in161.counter\[1\]
+ VSS VSS VDD VDD _05934_ sky130_fd_sc_hd__nor2_1
X_17751_ _00777_ _05934_ VSS VSS VDD VDD _05935_ sky130_fd_sc_hd__nor2_1
X_17752_ network.neuron_in161.counter\[2\] _05935_ VSS VSS
+ VDD VDD _05936_ sky130_fd_sc_hd__nor2_1
X_17753_ network.neuron_in161.counter\[2\] network.neuron_in161.counter\[3\]
+ _05934_ VSS VSS VDD VDD _05937_ sky130_fd_sc_hd__nand3b_1
X_17754_ network.neuron_in161.counter\[3\] _05936_ _05937_
+ VSS VSS VDD VDD _05938_ sky130_fd_sc_hd__o21ai_0
X_17755_ net379 _06632_ network.in_period\[161\]\[3\] VSS
+ VSS VDD VDD _05939_ sky130_fd_sc_hd__a21oi_1
X_17756_ net379 _05938_ _05939_ VSS VSS VDD VDD _02710_ sky130_fd_sc_hd__a21oi_1
X_17757_ network.in_period\[107\]\[1\] _05628_ VSS VSS VDD
+ VDD _05940_ sky130_fd_sc_hd__nand2_1
X_17758_ _00752_ _05628_ _05940_ VSS VSS VDD VDD _02492_ sky130_fd_sc_hd__o21ai_0
X_17759_ _09208_ _09282_ network.in_spk00_09 VSS VSS VDD VDD
+ _05941_ sky130_fd_sc_hd__o21ai_0
X_17760_ _06939_ _05941_ net356 VSS VSS VDD VDD _02016_ sky130_fd_sc_hd__a21oi_1
Xoutput41 net40 VSS VSS VDD VDD inference_cycles[7] sky130_fd_sc_hd__buf_1
X_17762_ network.neuron_in162.counter\[0\] network.neuron_in162.counter\[1\]
+ network.neuron_in162.counter\[2\] net360 VSS VSS VDD VDD _05943_
+ sky130_fd_sc_hd__nor4_1
X_17763_ network.in_period\[162\]\[3\] _05943_ _06804_ VSS
+ VSS VDD VDD _05944_ sky130_fd_sc_hd__mux2i_1
X_17764_ network.neuron_in162.counter\[0\] network.neuron_in162.counter\[1\]
+ network.neuron_in162.counter\[2\] network.neuron_in162.counter\[3\]
+ net378 VSS VSS VDD VDD _05945_ sky130_fd_sc_hd__o311a_1
X_17765_ network.in_period\[162\]\[3\] net360 _05945_ VSS
+ VSS VDD VDD _05946_ sky130_fd_sc_hd__a21oi_1
X_17766_ network.neuron_in162.counter\[3\] _05944_ _05946_
+ VSS VSS VDD VDD _02714_ sky130_fd_sc_hd__o21ai_0
X_17767_ net374 _04837_ VSS VSS VDD VDD _05947_ sky130_fd_sc_hd__nand2_1
X_17768_ network.in_period\[103\]\[0\] _05947_ VSS VSS VDD
+ VDD _05948_ sky130_fd_sc_hd__nand2_1
X_17769_ network.neuron_in103.counter\[0\] _05947_ _05948_
+ VSS VSS VDD VDD _02475_ sky130_fd_sc_hd__o21ai_0
X_17770_ network.neuron_in163.counter\[0\] network.neuron_in163.counter\[1\]
+ _00819_ VSS VSS VDD VDD _05949_ sky130_fd_sc_hd__o21bai_1
X_17771_ _03784_ _05949_ network.neuron_in163.counter\[3\]
+ VSS VSS VDD VDD _05950_ sky130_fd_sc_hd__a21oi_1
X_17772_ _03784_ network.neuron_in163.counter\[3\] _00817_
+ _00818_ _05950_ VSS VSS VDD VDD _05951_ sky130_fd_sc_hd__a41o_1
X_17773_ net378 _03792_ network.in_period\[163\]\[3\] VSS
+ VSS VDD VDD _05952_ sky130_fd_sc_hd__a21oi_1
X_17774_ net378 _05951_ _05952_ VSS VSS VDD VDD _02718_ sky130_fd_sc_hd__a21oi_1
X_17775_ _09395_ _09203_ _03370_ VSS VSS VDD VDD _05953_ sky130_fd_sc_hd__or3_1
X_17776_ network.in_spk12_08 network.in_spk13_08 _05953_ VSS
+ VSS VDD VDD _05954_ sky130_fd_sc_hd__or3_1
X_17777_ network.in_spk14_08 _05954_ network.in_spk15_08 VSS
+ VSS VDD VDD _05955_ sky130_fd_sc_hd__o21ai_0
X_17778_ _06956_ _05955_ net358 VSS VSS VDD VDD _02017_ sky130_fd_sc_hd__a21oi_1
X_17779_ network.neuron_in164.counter\[0\] network.neuron_in164.counter\[1\]
+ _00862_ VSS VSS VDD VDD _05956_ sky130_fd_sc_hd__o21bai_1
X_17780_ _03798_ _05956_ network.neuron_in164.counter\[3\]
+ VSS VSS VDD VDD _05957_ sky130_fd_sc_hd__a21oi_1
X_17781_ _03798_ network.neuron_in164.counter\[3\] _00860_
+ _00861_ _05957_ VSS VSS VDD VDD _05958_ sky130_fd_sc_hd__a41o_1
X_17782_ net378 _03804_ network.in_period\[164\]\[3\] VSS
+ VSS VDD VDD _05959_ sky130_fd_sc_hd__a21oi_1
X_17783_ net378 _05958_ _05959_ VSS VSS VDD VDD _02722_ sky130_fd_sc_hd__a21oi_1
X_17784_ net382 _04827_ VSS VSS VDD VDD _05960_ sky130_fd_sc_hd__nand2_1
X_17785_ network.in_period\[106\]\[0\] _05960_ VSS VSS VDD
+ VDD _05961_ sky130_fd_sc_hd__nand2_1
X_17786_ network.neuron_in106.counter\[0\] _05960_ _05961_
+ VSS VSS VDD VDD _02487_ sky130_fd_sc_hd__o21ai_0
X_17787_ network.neuron_in165.counter\[0\] network.neuron_in165.counter\[1\]
+ _00872_ VSS VSS VDD VDD _05962_ sky130_fd_sc_hd__o21bai_1
X_17788_ _03809_ _05962_ network.neuron_in165.counter\[3\]
+ VSS VSS VDD VDD _05963_ sky130_fd_sc_hd__a21oi_1
X_17789_ _03809_ network.neuron_in165.counter\[3\] _00870_
+ _00871_ _05963_ VSS VSS VDD VDD _05964_ sky130_fd_sc_hd__a41o_1
X_17790_ net378 _03814_ network.in_period\[165\]\[3\] VSS
+ VSS VDD VDD _05965_ sky130_fd_sc_hd__a21oi_1
X_17791_ net378 _05964_ _05965_ VSS VSS VDD VDD _02726_ sky130_fd_sc_hd__a21oi_1
X_17792_ network.neuron_in107.counter\[2\] net382 VSS VSS
+ VDD VDD _05966_ sky130_fd_sc_hd__nand2_1
X_17793_ network.neuron_in107.counter\[3\] network.in_period\[107\]\[2\]
+ _05966_ VSS VSS VDD VDD _05967_ sky130_fd_sc_hd__o21ai_0
X_17794_ _00751_ network.neuron_in107.counter\[2\] net355
+ VSS VSS VDD VDD _05968_ sky130_fd_sc_hd__or3_1
X_17795_ network.in_period\[107\]\[2\] net382 _05968_ VSS
+ VSS VDD VDD _05969_ sky130_fd_sc_hd__o21ai_0
X_17796_ _00751_ _05967_ _05969_ VSS VSS VDD VDD _02493_ sky130_fd_sc_hd__a21oi_1
X_17797_ network.in_spk14_08 _05954_ VSS VSS VDD VDD _05970_
+ sky130_fd_sc_hd__nand2_1
X_17798_ _06991_ _05970_ net358 VSS VSS VDD VDD _02018_ sky130_fd_sc_hd__a21oi_1
X_17799_ network.neuron_in166.counter\[0\] network.neuron_in166.counter\[1\]
+ _00889_ VSS VSS VDD VDD _05971_ sky130_fd_sc_hd__o21bai_1
X_17800_ _03820_ _05971_ network.neuron_in166.counter\[3\]
+ VSS VSS VDD VDD _05972_ sky130_fd_sc_hd__a21oi_1
X_17801_ _03820_ network.neuron_in166.counter\[3\] _00887_
+ _00888_ _05972_ VSS VSS VDD VDD _05973_ sky130_fd_sc_hd__a41o_1
X_17802_ net378 _03824_ network.in_period\[166\]\[3\] VSS
+ VSS VDD VDD _05974_ sky130_fd_sc_hd__a21oi_1
X_17803_ net378 _05973_ _05974_ VSS VSS VDD VDD _02730_ sky130_fd_sc_hd__a21oi_1
X_17804_ network.neuron_in167.counter\[1\] network.neuron_in167.counter\[0\]
+ _00922_ VSS VSS VDD VDD _05975_ sky130_fd_sc_hd__o21bai_1
X_17805_ _07767_ _05975_ network.neuron_in167.counter\[3\]
+ VSS VSS VDD VDD _05976_ sky130_fd_sc_hd__a21oi_1
X_17806_ _07767_ network.neuron_in167.counter\[3\] _00921_
+ _00920_ _05976_ VSS VSS VDD VDD _05977_ sky130_fd_sc_hd__a41o_1
X_17807_ net378 _07766_ network.in_period\[167\]\[3\] VSS
+ VSS VDD VDD _05978_ sky130_fd_sc_hd__a21oi_1
X_17808_ net378 _05977_ _05978_ VSS VSS VDD VDD _02734_ sky130_fd_sc_hd__a21oi_1
X_17809_ network.in_spk12_08 _05953_ network.in_spk13_08 VSS
+ VSS VDD VDD _05979_ sky130_fd_sc_hd__o21ai_0
X_17810_ _07080_ _05979_ net358 VSS VSS VDD VDD _02019_ sky130_fd_sc_hd__a21oi_1
Xoutput40 net39 VSS VSS VDD VDD inference_cycles[6] sky130_fd_sc_hd__buf_1
X_17812_ network.neuron_in168.counter\[1\] network.neuron_in168.counter\[0\]
+ _00952_ VSS VSS VDD VDD _05981_ sky130_fd_sc_hd__o21bai_1
X_17813_ _07737_ _05981_ network.neuron_in168.counter\[3\]
+ VSS VSS VDD VDD _05982_ sky130_fd_sc_hd__a21oi_1
X_17814_ _07737_ network.neuron_in168.counter\[3\] _00951_
+ _00950_ _05982_ VSS VSS VDD VDD _05983_ sky130_fd_sc_hd__a41o_1
X_17815_ net380 _07736_ network.in_period\[168\]\[3\] VSS
+ VSS VDD VDD _05984_ sky130_fd_sc_hd__a21oi_1
X_17816_ net380 _05983_ _05984_ VSS VSS VDD VDD _02738_ sky130_fd_sc_hd__a21oi_1
X_17817_ network.neuron_in103.counter\[3\] network.in_period\[103\]\[2\]
+ net353 _00215_ VSS VSS VDD VDD _05985_ sky130_fd_sc_hd__o22ai_1
Xoutput39 net38 VSS VSS VDD VDD inference_cycles[5] sky130_fd_sc_hd__buf_1
X_17819_ network.neuron_in103.counter\[2\] _00215_ net374
+ VSS VSS VDD VDD _05987_ sky130_fd_sc_hd__nand3_1
X_17820_ network.in_period\[103\]\[2\] net374 _05987_ VSS
+ VSS VDD VDD _05988_ sky130_fd_sc_hd__o21ai_0
X_17821_ _04836_ _05985_ _05988_ VSS VSS VDD VDD _02477_ sky130_fd_sc_hd__a21oi_1
X_17822_ network.neuron_in169.counter\[1\] network.neuron_in169.counter\[0\]
+ _00980_ VSS VSS VDD VDD _05989_ sky130_fd_sc_hd__o21bai_1
X_17823_ _07720_ _05989_ network.neuron_in169.counter\[3\]
+ VSS VSS VDD VDD _05990_ sky130_fd_sc_hd__a21oi_1
X_17824_ _07720_ network.neuron_in169.counter\[3\] _00979_
+ _00978_ _05990_ VSS VSS VDD VDD _05991_ sky130_fd_sc_hd__a41o_1
Xoutput38 net37 VSS VSS VDD VDD inference_cycles[4] sky130_fd_sc_hd__buf_1
X_17826_ net380 _07719_ network.in_period\[169\]\[3\] VSS
+ VSS VDD VDD _05993_ sky130_fd_sc_hd__a21oi_1
X_17827_ net380 _05991_ _05993_ VSS VSS VDD VDD _02742_ sky130_fd_sc_hd__a21oi_1
X_17828_ network.in_period\[103\]\[1\] _05947_ VSS VSS VDD
+ VDD _05994_ sky130_fd_sc_hd__nand2_1
X_17829_ _00216_ _05947_ _05994_ VSS VSS VDD VDD _02476_ sky130_fd_sc_hd__o21ai_0
X_17830_ network.in_spk12_08 _05953_ VSS VSS VDD VDD _05995_
+ sky130_fd_sc_hd__nand2_1
X_17831_ _07824_ _05995_ net358 VSS VSS VDD VDD _02020_ sky130_fd_sc_hd__a21oi_1
X_17832_ network.neuron_in170.counter\[1\] network.neuron_in170.counter\[0\]
+ network.neuron_in170.counter\[2\] VSS VSS VDD VDD _05996_
+ sky130_fd_sc_hd__nor3_1
X_17833_ network.neuron_in170.counter\[3\] _05996_ VSS VSS
+ VDD VDD _05997_ sky130_fd_sc_hd__xnor2_1
X_17834_ network.in_period\[170\]\[3\] _07744_ VSS VSS VDD
+ VDD _05998_ sky130_fd_sc_hd__nand2_1
X_17835_ _07744_ _05997_ _05998_ VSS VSS VDD VDD _02746_ sky130_fd_sc_hd__o21ai_0
X_17836_ net382 _04834_ VSS VSS VDD VDD _05999_ sky130_fd_sc_hd__nand2_1
X_17837_ net810 _05999_ VSS VSS VDD VDD _06000_ sky130_fd_sc_hd__nand2_1
X_17838_ _00532_ _05999_ _06000_ VSS VSS VDD VDD _02480_ sky130_fd_sc_hd__o21ai_0
X_17839_ network.neuron_in171.counter\[1\] network.neuron_in171.counter\[0\]
+ _01028_ VSS VSS VDD VDD _06001_ sky130_fd_sc_hd__o21bai_1
X_17840_ _07747_ _06001_ network.neuron_in171.counter\[3\]
+ VSS VSS VDD VDD _06002_ sky130_fd_sc_hd__a21oi_1
X_17841_ _07747_ network.neuron_in171.counter\[3\] _01027_
+ _01026_ _06002_ VSS VSS VDD VDD _06003_ sky130_fd_sc_hd__a41o_1
X_17842_ net380 _07746_ network.in_period\[171\]\[3\] VSS
+ VSS VDD VDD _06004_ sky130_fd_sc_hd__a21oi_1
X_17843_ net377 _06003_ _06004_ VSS VSS VDD VDD _02750_ sky130_fd_sc_hd__a21oi_1
X_17844_ network.in_period\[104\]\[0\] _05999_ VSS VSS VDD
+ VDD _06005_ sky130_fd_sc_hd__nand2_1
X_17845_ network.neuron_in104.counter\[0\] _05999_ _06005_
+ VSS VSS VDD VDD _02479_ sky130_fd_sc_hd__o21ai_0
X_17846_ network.in_spk08_08 network.in_spk09_08 network.in_spk10_08
+ _09319_ network.in_spk11_08 VSS VSS VDD VDD _06006_ sky130_fd_sc_hd__o41ai_1
X_17847_ _08340_ _06006_ net358 VSS VSS VDD VDD _02021_ sky130_fd_sc_hd__a21oi_1
X_17848_ network.neuron_in172.counter\[1\] network.neuron_in172.counter\[0\]
+ _01050_ VSS VSS VDD VDD _06007_ sky130_fd_sc_hd__o21bai_1
X_17849_ _07714_ _06007_ network.neuron_in172.counter\[3\]
+ VSS VSS VDD VDD _06008_ sky130_fd_sc_hd__a21oi_1
X_17850_ _07714_ network.neuron_in172.counter\[3\] _01049_
+ _01048_ _06008_ VSS VSS VDD VDD _06009_ sky130_fd_sc_hd__a41o_1
X_17851_ net378 _07713_ network.in_period\[172\]\[3\] VSS
+ VSS VDD VDD _06010_ sky130_fd_sc_hd__a21oi_1
X_17852_ net378 _06009_ _06010_ VSS VSS VDD VDD _02754_ sky130_fd_sc_hd__a21oi_1
X_17853_ network.neuron_in105.counter\[3\] network.in_period\[105\]\[2\]
+ net349 _00498_ VSS VSS VDD VDD _06011_ sky130_fd_sc_hd__o22ai_1
X_17854_ network.neuron_in105.counter\[2\] _00498_ net382
+ VSS VSS VDD VDD _06012_ sky130_fd_sc_hd__nand3_1
X_17855_ network.in_period\[105\]\[2\] net382 _06012_ VSS
+ VSS VDD VDD _06013_ sky130_fd_sc_hd__o21ai_0
X_17856_ _04830_ _06011_ _06013_ VSS VSS VDD VDD _02485_ sky130_fd_sc_hd__a21oi_1
X_17857_ network.neuron_in173.counter\[1\] network.neuron_in173.counter\[2\]
+ network.neuron_in173.counter\[0\] VSS VSS VDD VDD _06014_
+ sky130_fd_sc_hd__nor3_1
X_17858_ network.neuron_in173.counter\[3\] _06014_ VSS VSS
+ VDD VDD _06015_ sky130_fd_sc_hd__xnor2_1
X_17859_ network.in_period\[173\]\[3\] _07753_ VSS VSS VDD
+ VDD _06016_ sky130_fd_sc_hd__nand2_1
X_17860_ _07753_ _06015_ _06016_ VSS VSS VDD VDD _02758_ sky130_fd_sc_hd__o21ai_0
X_17861_ network.in_period\[105\]\[1\] _05914_ VSS VSS VDD
+ VDD _06017_ sky130_fd_sc_hd__nand2_1
X_17862_ _00499_ _05914_ _06017_ VSS VSS VDD VDD _02484_ sky130_fd_sc_hd__o21ai_0
X_17863_ network.in_spk08_08 network.in_spk09_08 _09319_ network.in_spk10_08
+ VSS VSS VDD VDD _06018_ sky130_fd_sc_hd__o31ai_1
X_17864_ _03535_ _06018_ net358 VSS VSS VDD VDD _02022_ sky130_fd_sc_hd__a21oi_1
X_17865_ network.neuron_in174.counter\[0\] network.neuron_in174.counter\[1\]
+ _00909_ VSS VSS VDD VDD _06019_ sky130_fd_sc_hd__o21bai_1
X_17866_ _07728_ _06019_ network.neuron_in174.counter\[3\]
+ VSS VSS VDD VDD _06020_ sky130_fd_sc_hd__a21oi_1
X_17867_ _07728_ network.neuron_in174.counter\[3\] _00907_
+ _00908_ _06020_ VSS VSS VDD VDD _06021_ sky130_fd_sc_hd__a41o_1
X_17868_ net378 _07727_ network.in_period\[174\]\[3\] VSS
+ VSS VDD VDD _06022_ sky130_fd_sc_hd__a21oi_1
X_17869_ net378 _06021_ _06022_ VSS VSS VDD VDD _02762_ sky130_fd_sc_hd__a21oi_1
Xoutput37 net36 VSS VSS VDD VDD inference_cycles[3] sky130_fd_sc_hd__buf_1
X_17871_ network.neuron_in106.counter\[3\] network.in_period\[106\]\[2\]
+ net355 _00650_ VSS VSS VDD VDD _06024_ sky130_fd_sc_hd__o22ai_1
X_17872_ network.neuron_in106.counter\[2\] _00650_ net382
+ VSS VSS VDD VDD _06025_ sky130_fd_sc_hd__nand3_1
X_17873_ network.in_period\[106\]\[2\] net382 _06025_ VSS
+ VSS VDD VDD _06026_ sky130_fd_sc_hd__o21ai_0
X_17874_ _04826_ _06024_ _06026_ VSS VSS VDD VDD _02489_ sky130_fd_sc_hd__a21oi_1
X_17875_ network.neuron_in175.counter\[1\] network.neuron_in175.counter\[0\]
+ _00807_ VSS VSS VDD VDD _06027_ sky130_fd_sc_hd__o21bai_1
X_17876_ _07757_ _06027_ network.neuron_in175.counter\[3\]
+ VSS VSS VDD VDD _06028_ sky130_fd_sc_hd__a21oi_1
X_17877_ _07757_ network.neuron_in175.counter\[3\] _00806_
+ _00805_ _06028_ VSS VSS VDD VDD _06029_ sky130_fd_sc_hd__a41o_1
X_17878_ net378 _07756_ network.in_period\[175\]\[3\] VSS
+ VSS VDD VDD _06030_ sky130_fd_sc_hd__a21oi_1
X_17879_ net378 _06029_ _06030_ VSS VSS VDD VDD _02766_ sky130_fd_sc_hd__a21oi_1
X_17880_ network.in_period\[106\]\[1\] _05960_ VSS VSS VDD
+ VDD _06031_ sky130_fd_sc_hd__nand2_1
X_17881_ _00651_ _05960_ _06031_ VSS VSS VDD VDD _02488_ sky130_fd_sc_hd__o21ai_0
X_17882_ network.in_spk08_08 _09319_ network.in_spk09_08 VSS
+ VSS VDD VDD _06032_ sky130_fd_sc_hd__o21ai_0
X_17883_ _03502_ _06032_ net358 VSS VSS VDD VDD _02023_ sky130_fd_sc_hd__a21oi_1
X_17884_ network.neuron_in176.counter\[1\] network.neuron_in176.counter\[0\]
+ _00729_ VSS VSS VDD VDD _06033_ sky130_fd_sc_hd__o21bai_1
X_17885_ _07762_ _06033_ network.neuron_in176.counter\[3\]
+ VSS VSS VDD VDD _06034_ sky130_fd_sc_hd__a21oi_1
X_17886_ _07762_ network.neuron_in176.counter\[3\] _00728_
+ _00727_ _06034_ VSS VSS VDD VDD _06035_ sky130_fd_sc_hd__a41o_1
X_17887_ net366 _07761_ network.in_period\[176\]\[3\] VSS
+ VSS VDD VDD _06036_ sky130_fd_sc_hd__a21oi_1
X_17888_ net366 _06035_ _06036_ VSS VSS VDD VDD _02770_ sky130_fd_sc_hd__a21oi_1
X_17889_ network.neuron_in177.counter\[0\] network.neuron_in177.counter\[1\]
+ _00589_ VSS VSS VDD VDD _06037_ sky130_fd_sc_hd__o21bai_1
X_17890_ _07709_ _06037_ network.neuron_in177.counter\[3\]
+ VSS VSS VDD VDD _06038_ sky130_fd_sc_hd__a21oi_1
X_17891_ _07709_ network.neuron_in177.counter\[3\] _00587_
+ _00588_ _06038_ VSS VSS VDD VDD _06039_ sky130_fd_sc_hd__a41o_1
X_17892_ net379 _07708_ network.in_period\[177\]\[3\] VSS
+ VSS VDD VDD _06040_ sky130_fd_sc_hd__a21oi_1
X_17893_ net379 _06039_ _06040_ VSS VSS VDD VDD _02774_ sky130_fd_sc_hd__a21oi_1
X_17894_ network.in_spk08_08 _09319_ VSS VSS VDD VDD _06041_
+ sky130_fd_sc_hd__nand2_1
Xoutput36 net35 VSS VSS VDD VDD inference_cycles[2] sky130_fd_sc_hd__buf_1
X_17896_ _06683_ _06041_ net358 VSS VSS VDD VDD _02024_ sky130_fd_sc_hd__a21oi_1
X_17897_ network.neuron_in178.counter\[1\] network.neuron_in178.counter\[0\]
+ _00271_ VSS VSS VDD VDD _06043_ sky130_fd_sc_hd__o21bai_1
X_17898_ _06799_ _06043_ network.neuron_in178.counter\[3\]
+ VSS VSS VDD VDD _06044_ sky130_fd_sc_hd__a21oi_1
X_17899_ _06799_ network.neuron_in178.counter\[3\] _00270_
+ _00269_ _06044_ VSS VSS VDD VDD _06045_ sky130_fd_sc_hd__a41o_1
X_17900_ net365 _04752_ network.in_period\[178\]\[3\] VSS
+ VSS VDD VDD _06046_ sky130_fd_sc_hd__a21oi_1
X_17901_ net365 _06045_ _06046_ VSS VSS VDD VDD _02778_ sky130_fd_sc_hd__a21oi_1
X_17902_ net808 _05628_ VSS VSS VDD VDD _06047_ sky130_fd_sc_hd__nand2_1
X_17903_ network.neuron_in107.counter\[0\] _05628_ _06047_
+ VSS VSS VDD VDD _02491_ sky130_fd_sc_hd__o21ai_0
X_17904_ network.neuron_in179.counter\[0\] network.neuron_in179.counter\[1\]
+ _00565_ VSS VSS VDD VDD _06048_ sky130_fd_sc_hd__o21bai_1
X_17905_ _06715_ _06048_ network.neuron_in179.counter\[3\]
+ VSS VSS VDD VDD _06049_ sky130_fd_sc_hd__a21oi_1
X_17906_ _06715_ network.neuron_in179.counter\[3\] _00563_
+ _00564_ _06049_ VSS VSS VDD VDD _06050_ sky130_fd_sc_hd__a41o_1
X_17907_ net365 _06714_ network.in_period\[179\]\[3\] VSS
+ VSS VDD VDD _06051_ sky130_fd_sc_hd__a21oi_1
X_17908_ net365 _06050_ _06051_ VSS VSS VDD VDD _02782_ sky130_fd_sc_hd__a21oi_1
X_17909_ network.neuron_in108.counter\[3\] network.in_period\[108\]\[2\]
+ net349 _01156_ VSS VSS VDD VDD _06052_ sky130_fd_sc_hd__o22ai_1
Xoutput35 net34 VSS VSS VDD VDD inference_cycles[1] sky130_fd_sc_hd__buf_1
X_17911_ network.neuron_in108.counter\[2\] _01156_ net374
+ VSS VSS VDD VDD _06054_ sky130_fd_sc_hd__nand3_1
X_17912_ network.in_period\[108\]\[2\] net374 _06054_ VSS
+ VSS VDD VDD _06055_ sky130_fd_sc_hd__o21ai_0
X_17913_ _04820_ _06052_ _06055_ VSS VSS VDD VDD _02497_ sky130_fd_sc_hd__a21oi_1
X_17914_ net287 _09268_ _03377_ VSS VSS VDD VDD _06056_ sky130_fd_sc_hd__nand3_1
X_17915_ net696 _06056_ VSS VSS VDD VDD _06057_ sky130_fd_sc_hd__nand2_1
X_17916_ _08121_ _06057_ net357 VSS VSS VDD VDD _02025_ sky130_fd_sc_hd__a21oi_1
Xoutput34 net33 VSS VSS VDD VDD inference_cycles[15] sky130_fd_sc_hd__buf_1
X_17918_ network.neuron_in180.counter\[1\] network.neuron_in180.counter\[0\]
+ VSS VSS VDD VDD _06059_ sky130_fd_sc_hd__nor2_1
X_17919_ _00851_ _06059_ VSS VSS VDD VDD _06060_ sky130_fd_sc_hd__nor2_1
X_17920_ network.neuron_in180.counter\[2\] _06060_ VSS VSS
+ VDD VDD _06061_ sky130_fd_sc_hd__nor2_1
X_17921_ network.neuron_in180.counter\[2\] network.neuron_in180.counter\[3\]
+ _06059_ VSS VSS VDD VDD _06062_ sky130_fd_sc_hd__nand3b_1
X_17922_ network.neuron_in180.counter\[3\] _06061_ _06062_
+ VSS VSS VDD VDD _06063_ sky130_fd_sc_hd__o21ai_0
X_17923_ net365 _06720_ network.in_period\[180\]\[3\] VSS
+ VSS VDD VDD _06064_ sky130_fd_sc_hd__a21oi_1
X_17924_ net365 _06063_ _06064_ VSS VSS VDD VDD _02786_ sky130_fd_sc_hd__a21oi_1
X_17925_ net374 _04822_ VSS VSS VDD VDD _06065_ sky130_fd_sc_hd__nand2_1
X_17926_ network.in_period\[108\]\[1\] _06065_ VSS VSS VDD
+ VDD _06066_ sky130_fd_sc_hd__nand2_1
X_17927_ _01157_ _06065_ _06066_ VSS VSS VDD VDD _02496_ sky130_fd_sc_hd__o21ai_0
X_17928_ network.neuron_in181.counter\[1\] network.neuron_in181.counter\[0\]
+ VSS VSS VDD VDD _06067_ sky130_fd_sc_hd__nor2_1
X_17929_ _00847_ _06067_ VSS VSS VDD VDD _06068_ sky130_fd_sc_hd__nor2_1
X_17930_ network.neuron_in181.counter\[2\] _06068_ VSS VSS
+ VDD VDD _06069_ sky130_fd_sc_hd__nor2_1
X_17931_ network.neuron_in181.counter\[2\] network.neuron_in181.counter\[3\]
+ _06067_ VSS VSS VDD VDD _06070_ sky130_fd_sc_hd__nand3b_1
X_17932_ network.neuron_in181.counter\[3\] _06069_ _06070_
+ VSS VSS VDD VDD _06071_ sky130_fd_sc_hd__o21ai_0
Xoutput33 net32 VSS VSS VDD VDD inference_cycles[14] sky130_fd_sc_hd__buf_1
X_17934_ net365 _06661_ network.in_period\[181\]\[3\] VSS
+ VSS VDD VDD _06073_ sky130_fd_sc_hd__a21oi_1
X_17935_ net365 _06071_ _06073_ VSS VSS VDD VDD _02790_ sky130_fd_sc_hd__a21oi_1
X_17936_ network.in_period\[108\]\[0\] _06065_ VSS VSS VDD
+ VDD _06074_ sky130_fd_sc_hd__nand2_1
X_17937_ network.neuron_in108.counter\[0\] _06065_ _06074_
+ VSS VSS VDD VDD _02495_ sky130_fd_sc_hd__o21ai_0
X_17938_ net287 _09268_ VSS VSS VDD VDD _06075_ sky130_fd_sc_hd__nand2_1
X_17939_ network.in_spk04_08 network.in_spk05_08 _09200_ _06075_
+ net757 VSS VSS VDD VDD _06076_ sky130_fd_sc_hd__o41ai_1
X_17940_ _07200_ _06076_ net358 VSS VSS VDD VDD _02026_ sky130_fd_sc_hd__a21oi_1
X_17941_ network.neuron_in182.counter\[0\] network.neuron_in182.counter\[1\]
+ VSS VSS VDD VDD _06077_ sky130_fd_sc_hd__nor2_1
X_17942_ _00839_ _06077_ VSS VSS VDD VDD _06078_ sky130_fd_sc_hd__nor2_1
X_17943_ network.neuron_in182.counter\[2\] _06078_ VSS VSS
+ VDD VDD _06079_ sky130_fd_sc_hd__nor2_1
X_17944_ network.neuron_in182.counter\[2\] network.neuron_in182.counter\[3\]
+ _06077_ VSS VSS VDD VDD _06080_ sky130_fd_sc_hd__nand3b_1
X_17945_ network.neuron_in182.counter\[3\] _06079_ _06080_
+ VSS VSS VDD VDD _06081_ sky130_fd_sc_hd__o21ai_0
X_17946_ net366 _06690_ network.in_period\[182\]\[3\] VSS
+ VSS VDD VDD _06082_ sky130_fd_sc_hd__a21oi_1
X_17947_ net366 _06081_ _06082_ VSS VSS VDD VDD _02794_ sky130_fd_sc_hd__a21oi_1
X_17948_ network.neuron_in183.counter\[1\] network.neuron_in183.counter\[0\]
+ _01140_ VSS VSS VDD VDD _06083_ sky130_fd_sc_hd__o21bai_1
X_17949_ _06666_ _06083_ network.neuron_in183.counter\[3\]
+ VSS VSS VDD VDD _06084_ sky130_fd_sc_hd__a21oi_1
X_17950_ _06666_ network.neuron_in183.counter\[3\] _01139_
+ _01138_ _06084_ VSS VSS VDD VDD _06085_ sky130_fd_sc_hd__a41o_1
X_17951_ net379 _06665_ network.in_period\[183\]\[3\] VSS
+ VSS VDD VDD _06086_ sky130_fd_sc_hd__a21oi_1
X_17952_ net379 _06085_ _06086_ VSS VSS VDD VDD _02798_ sky130_fd_sc_hd__a21oi_1
X_17953_ network.in_spk04_08 _09200_ _06075_ network.in_spk05_08
+ VSS VSS VDD VDD _06087_ sky130_fd_sc_hd__o31ai_1
X_17954_ _07036_ _06087_ net358 VSS VSS VDD VDD _02027_ sky130_fd_sc_hd__a21oi_1
X_17955_ net626 _03877_ VSS VSS VDD VDD _06088_ sky130_fd_sc_hd__nand2_1
X_17956_ _00644_ _03877_ _06088_ VSS VSS VDD VDD _02644_ sky130_fd_sc_hd__o21ai_0
X_17957_ network.neuron_in184.counter\[1\] network.neuron_in184.counter\[0\]
+ VSS VSS VDD VDD _06089_ sky130_fd_sc_hd__nor2_1
X_17958_ _00984_ _06089_ VSS VSS VDD VDD _06090_ sky130_fd_sc_hd__nor2_1
X_17959_ network.neuron_in184.counter\[2\] _06090_ VSS VSS
+ VDD VDD _06091_ sky130_fd_sc_hd__nor2_1
X_17960_ network.neuron_in184.counter\[2\] network.neuron_in184.counter\[3\]
+ _06089_ VSS VSS VDD VDD _06092_ sky130_fd_sc_hd__nand3b_1
X_17961_ network.neuron_in184.counter\[3\] _06091_ _06092_
+ VSS VSS VDD VDD _06093_ sky130_fd_sc_hd__o21ai_0
X_17962_ net379 _06738_ network.in_period\[184\]\[3\] VSS
+ VSS VDD VDD _06094_ sky130_fd_sc_hd__a21oi_1
X_17963_ net379 _06093_ _06094_ VSS VSS VDD VDD _02802_ sky130_fd_sc_hd__a21oi_1
X_17964_ network.neuron_in185.counter\[1\] network.neuron_in185.counter\[0\]
+ VSS VSS VDD VDD _06095_ sky130_fd_sc_hd__nor2_1
X_17965_ _00763_ _06095_ VSS VSS VDD VDD _06096_ sky130_fd_sc_hd__nor2_1
X_17966_ network.neuron_in185.counter\[2\] _06096_ VSS VSS
+ VDD VDD _06097_ sky130_fd_sc_hd__nor2_1
X_17967_ network.neuron_in185.counter\[2\] network.neuron_in185.counter\[3\]
+ _06095_ VSS VSS VDD VDD _06098_ sky130_fd_sc_hd__nand3b_1
X_17968_ network.neuron_in185.counter\[3\] _06097_ _06098_
+ VSS VSS VDD VDD _06099_ sky130_fd_sc_hd__o21ai_0
X_17969_ net379 _06743_ network.in_period\[185\]\[3\] VSS
+ VSS VDD VDD _06100_ sky130_fd_sc_hd__a21oi_1
X_17970_ net379 _06099_ _06100_ VSS VSS VDD VDD _02806_ sky130_fd_sc_hd__a21oi_1
X_17971_ _09200_ _06075_ network.in_spk04_08 VSS VSS VDD VDD
+ _06101_ sky130_fd_sc_hd__o21ai_0
X_17972_ _04017_ _06101_ net357 VSS VSS VDD VDD _02028_ sky130_fd_sc_hd__a21oi_1
X_17973_ network.neuron_in186.counter\[0\] network.neuron_in186.counter\[2\]
+ network.neuron_in186.counter\[1\] VSS VSS VDD VDD _06102_
+ sky130_fd_sc_hd__nor3_1
X_17974_ network.neuron_in186.counter\[3\] _06102_ VSS VSS
+ VDD VDD _06103_ sky130_fd_sc_hd__xnor2_1
X_17975_ network.in_period\[186\]\[3\] _06674_ VSS VSS VDD
+ VDD _06104_ sky130_fd_sc_hd__nand2_1
X_17976_ _06674_ _06103_ _06104_ VSS VSS VDD VDD _02810_ sky130_fd_sc_hd__o21ai_0
X_17977_ network.neuron_in187.counter\[0\] network.neuron_in187.counter\[1\]
+ _00742_ VSS VSS VDD VDD _06105_ sky130_fd_sc_hd__o21bai_1
X_17978_ _06706_ _06105_ network.neuron_in187.counter\[3\]
+ VSS VSS VDD VDD _06106_ sky130_fd_sc_hd__a21oi_1
X_17979_ _06706_ network.neuron_in187.counter\[3\] _00740_
+ _00741_ _06106_ VSS VSS VDD VDD _06107_ sky130_fd_sc_hd__a41o_1
X_17980_ net379 _06705_ network.in_period\[187\]\[3\] VSS
+ VSS VDD VDD _06108_ sky130_fd_sc_hd__a21oi_1
X_17981_ net379 _06107_ _06108_ VSS VSS VDD VDD _02814_ sky130_fd_sc_hd__a21oi_1
X_17982_ net799 _05642_ VSS VSS VDD VDD _06109_ sky130_fd_sc_hd__nand2_1
X_17983_ network.neuron_in110.counter\[0\] _05642_ _06109_
+ VSS VSS VDD VDD _02503_ sky130_fd_sc_hd__o21ai_0
X_17984_ network.in_spk00_08 network.in_spk01_08 network.in_spk02_08
+ _06075_ network.in_spk03_08 VSS VSS VDD VDD _06110_ sky130_fd_sc_hd__o41ai_1
X_17985_ _03687_ _06110_ net357 VSS VSS VDD VDD _02029_ sky130_fd_sc_hd__a21oi_1
X_17986_ network.neuron_in188.counter\[1\] network.neuron_in188.counter\[0\]
+ VSS VSS VDD VDD _06111_ sky130_fd_sc_hd__nor2_1
X_17987_ _00231_ _06111_ VSS VSS VDD VDD _06112_ sky130_fd_sc_hd__nor2_1
X_17988_ network.neuron_in188.counter\[2\] _06112_ VSS VSS
+ VDD VDD _06113_ sky130_fd_sc_hd__nor2_1
X_17989_ network.neuron_in188.counter\[2\] network.neuron_in188.counter\[3\]
+ _06111_ VSS VSS VDD VDD _06114_ sky130_fd_sc_hd__nand3b_1
X_17990_ network.neuron_in188.counter\[3\] _06113_ _06114_
+ VSS VSS VDD VDD _06115_ sky130_fd_sc_hd__o21ai_0
X_17991_ net366 _06657_ network.in_period\[188\]\[3\] VSS
+ VSS VDD VDD _06116_ sky130_fd_sc_hd__a21oi_1
X_17992_ net366 _06115_ _06116_ VSS VSS VDD VDD _02818_ sky130_fd_sc_hd__a21oi_1
X_17993_ net382 _04812_ VSS VSS VDD VDD _06117_ sky130_fd_sc_hd__nand2_1
X_17994_ net782 _06117_ VSS VSS VDD VDD _06118_ sky130_fd_sc_hd__nand2_1
X_17995_ network.neuron_in112.counter\[0\] _06117_ _06118_
+ VSS VSS VDD VDD _02511_ sky130_fd_sc_hd__o21ai_0
X_17996_ network.neuron_in189.counter\[1\] network.neuron_in189.counter\[0\]
+ VSS VSS VDD VDD _06119_ sky130_fd_sc_hd__nor2_1
X_17997_ _00976_ _06119_ VSS VSS VDD VDD _06120_ sky130_fd_sc_hd__nor2_1
X_17998_ network.neuron_in189.counter\[2\] _06120_ VSS VSS
+ VDD VDD _06121_ sky130_fd_sc_hd__nor2_1
X_17999_ network.neuron_in189.counter\[2\] network.neuron_in189.counter\[3\]
+ _06119_ VSS VSS VDD VDD _06122_ sky130_fd_sc_hd__nand3b_1
X_18000_ network.neuron_in189.counter\[3\] _06121_ _06122_
+ VSS VSS VDD VDD _06123_ sky130_fd_sc_hd__o21ai_0
X_18001_ net366 _06822_ network.in_period\[189\]\[3\] VSS
+ VSS VDD VDD _06124_ sky130_fd_sc_hd__a21oi_1
X_18002_ net366 _06123_ _06124_ VSS VSS VDD VDD _02822_ sky130_fd_sc_hd__a21oi_1
X_18003_ net669 _05660_ VSS VSS VDD VDD _06125_ sky130_fd_sc_hd__nand2_1
X_18004_ _00080_ _05660_ _06125_ VSS VSS VDD VDD _02520_ sky130_fd_sc_hd__o21ai_0
X_18005_ network.in_spk00_08 network.in_spk01_08 _06075_ network.in_spk02_08
+ VSS VSS VDD VDD _06126_ sky130_fd_sc_hd__o31ai_1
X_18006_ _03626_ _06126_ net357 VSS VSS VDD VDD _02030_ sky130_fd_sc_hd__a21oi_1
X_18007_ network.neuron_in190.counter\[0\] network.neuron_in190.counter\[1\]
+ _00831_ VSS VSS VDD VDD _06127_ sky130_fd_sc_hd__o21bai_1
X_18008_ _06781_ _06127_ network.neuron_in190.counter\[3\]
+ VSS VSS VDD VDD _06128_ sky130_fd_sc_hd__a21oi_1
X_18009_ _06781_ network.neuron_in190.counter\[3\] _00829_
+ _00830_ _06128_ VSS VSS VDD VDD _06129_ sky130_fd_sc_hd__a41o_1
X_18010_ net366 _06827_ network.in_period\[190\]\[3\] VSS
+ VSS VDD VDD _06130_ sky130_fd_sc_hd__a21oi_1
X_18011_ net366 _06129_ _06130_ VSS VSS VDD VDD _02826_ sky130_fd_sc_hd__a21oi_1
Xoutput32 net31 VSS VSS VDD VDD inference_cycles[13] sky130_fd_sc_hd__buf_1
X_18013_ network.neuron_in191.counter\[0\] network.neuron_in191.counter\[1\]
+ _00827_ VSS VSS VDD VDD _06132_ sky130_fd_sc_hd__o21bai_1
X_18014_ _06767_ _06132_ network.neuron_in191.counter\[3\]
+ VSS VSS VDD VDD _06133_ sky130_fd_sc_hd__a21oi_1
X_18015_ _06767_ network.neuron_in191.counter\[3\] _00825_
+ _00826_ _06133_ VSS VSS VDD VDD _06134_ sky130_fd_sc_hd__a41o_1
X_18016_ net366 _06766_ network.in_period\[191\]\[3\] VSS
+ VSS VDD VDD _06135_ sky130_fd_sc_hd__a21oi_1
X_18017_ net366 _06134_ _06135_ VSS VSS VDD VDD _02830_ sky130_fd_sc_hd__a21oi_1
X_18018_ network.in_spk00_08 _09395_ network.in_spk01_08 VSS
+ VSS VDD VDD _06136_ sky130_fd_sc_hd__o21ai_0
X_18019_ _06842_ _06136_ net357 VSS VSS VDD VDD _02031_ sky130_fd_sc_hd__a21oi_1
X_18020_ network.neuron_in192.counter\[1\] network.neuron_in192.counter\[0\]
+ _01032_ VSS VSS VDD VDD _06137_ sky130_fd_sc_hd__o21bai_1
X_18021_ _06790_ _06137_ network.neuron_in192.counter\[3\]
+ VSS VSS VDD VDD _06138_ sky130_fd_sc_hd__a21oi_1
X_18022_ _06790_ network.neuron_in192.counter\[3\] _01031_
+ _01030_ _06138_ VSS VSS VDD VDD _06139_ sky130_fd_sc_hd__a41o_1
Xoutput31 net30 VSS VSS VDD VDD inference_cycles[12] sky130_fd_sc_hd__buf_1
X_18024_ net376 _06789_ net507 VSS VSS VDD VDD _06141_ sky130_fd_sc_hd__a21oi_1
X_18025_ net376 _06139_ _06141_ VSS VSS VDD VDD _02834_ sky130_fd_sc_hd__a21oi_1
X_18026_ network.neuron_in193.counter\[0\] network.neuron_in193.counter\[1\]
+ _00251_ VSS VSS VDD VDD _06142_ sky130_fd_sc_hd__o21bai_1
X_18027_ _06772_ _06142_ network.neuron_in193.counter\[3\]
+ VSS VSS VDD VDD _06143_ sky130_fd_sc_hd__a21oi_1
X_18028_ _06772_ network.neuron_in193.counter\[3\] _00249_
+ _00250_ _06143_ VSS VSS VDD VDD _06144_ sky130_fd_sc_hd__a41o_1
X_18029_ net376 _06771_ net503 VSS VSS VDD VDD _06145_ sky130_fd_sc_hd__a21oi_1
X_18030_ net376 _06144_ _06145_ VSS VSS VDD VDD _02838_ sky130_fd_sc_hd__a21oi_1
Xoutput30 net29 VSS VSS VDD VDD inference_cycles[11] sky130_fd_sc_hd__buf_1
X_18032_ net382 _04815_ VSS VSS VDD VDD _06147_ sky130_fd_sc_hd__nand2_1
X_18033_ network.in_period\[111\]\[0\] _06147_ VSS VSS VDD
+ VDD _06148_ sky130_fd_sc_hd__nand2_1
X_18034_ network.neuron_in111.counter\[0\] _06147_ _06148_
+ VSS VSS VDD VDD _02507_ sky130_fd_sc_hd__o21ai_0
X_18035_ network.in_spk00_08 _06075_ VSS VSS VDD VDD _06149_
+ sky130_fd_sc_hd__nand2_1
X_18036_ _07210_ _06149_ net357 VSS VSS VDD VDD _02032_ sky130_fd_sc_hd__a21oi_1
X_18037_ network.neuron_in194.counter\[0\] network.neuron_in194.counter\[1\]
+ VSS VSS VDD VDD _06150_ sky130_fd_sc_hd__nor2_1
X_18038_ _01148_ _06150_ VSS VSS VDD VDD _06151_ sky130_fd_sc_hd__nor2_1
X_18039_ network.neuron_in194.counter\[2\] _06151_ VSS VSS
+ VDD VDD _06152_ sky130_fd_sc_hd__nor2_1
X_18040_ network.neuron_in194.counter\[2\] network.neuron_in194.counter\[3\]
+ _06150_ VSS VSS VDD VDD _06153_ sky130_fd_sc_hd__nand3b_1
X_18041_ network.neuron_in194.counter\[3\] _06152_ _06153_
+ VSS VSS VDD VDD _06154_ sky130_fd_sc_hd__o21ai_0
X_18042_ net376 _06846_ network.in_period\[194\]\[3\] VSS
+ VSS VDD VDD _06155_ sky130_fd_sc_hd__a21oi_1
X_18043_ net376 _06154_ _06155_ VSS VSS VDD VDD _02842_ sky130_fd_sc_hd__a21oi_1
X_18044_ network.neuron_in195.counter\[1\] network.neuron_in195.counter\[0\]
+ VSS VSS VDD VDD _06156_ sky130_fd_sc_hd__nor2_1
X_18045_ _00823_ _06156_ VSS VSS VDD VDD _06157_ sky130_fd_sc_hd__nor2_1
X_18046_ network.neuron_in195.counter\[2\] _06157_ VSS VSS
+ VDD VDD _06158_ sky130_fd_sc_hd__nor2_1
X_18047_ network.neuron_in195.counter\[2\] network.neuron_in195.counter\[3\]
+ _06156_ VSS VSS VDD VDD _06159_ sky130_fd_sc_hd__nand3b_1
X_18048_ network.neuron_in195.counter\[3\] _06158_ _06159_
+ VSS VSS VDD VDD _06160_ sky130_fd_sc_hd__o21ai_0
X_18049_ net372 _06851_ network.in_period\[195\]\[3\] VSS
+ VSS VDD VDD _06161_ sky130_fd_sc_hd__a21oi_1
X_18050_ net376 _06160_ _06161_ VSS VSS VDD VDD _02846_ sky130_fd_sc_hd__a21oi_1
X_18051_ net383 _04809_ VSS VSS VDD VDD _06162_ sky130_fd_sc_hd__nand2_1
X_18052_ network.in_period\[113\]\[1\] _06162_ VSS VSS VDD
+ VDD _06163_ sky130_fd_sc_hd__nand2_1
X_18053_ _01092_ _06162_ _06163_ VSS VSS VDD VDD _02516_ sky130_fd_sc_hd__o21ai_0
X_18054_ _09290_ _09560_ VSS VSS VDD VDD _06164_ sky130_fd_sc_hd__nand2b_1
X_18055_ network.in_spk12_07 network.in_spk13_07 _06164_ VSS
+ VSS VDD VDD _06165_ sky130_fd_sc_hd__or3_1
X_18056_ network.in_spk14_07 _06165_ network.in_spk15_07 VSS
+ VSS VDD VDD _06166_ sky130_fd_sc_hd__o21ai_0
X_18057_ _04772_ _06166_ net348 VSS VSS VDD VDD _02033_ sky130_fd_sc_hd__a21oi_1
X_18058_ network.neuron_in196.counter\[0\] network.neuron_in196.counter\[1\]
+ VSS VSS VDD VDD _06167_ sky130_fd_sc_hd__nor2_1
X_18059_ _00972_ _06167_ VSS VSS VDD VDD _06168_ sky130_fd_sc_hd__nor2_1
X_18060_ network.neuron_in196.counter\[2\] _06168_ VSS VSS
+ VDD VDD _06169_ sky130_fd_sc_hd__nor2_1
X_18061_ network.neuron_in196.counter\[2\] network.neuron_in196.counter\[3\]
+ _06167_ VSS VSS VDD VDD _06170_ sky130_fd_sc_hd__nand3b_1
X_18062_ network.neuron_in196.counter\[3\] _06169_ _06170_
+ VSS VSS VDD VDD _06171_ sky130_fd_sc_hd__o21ai_0
X_18063_ net376 _06776_ net496 VSS VSS VDD VDD _06172_ sky130_fd_sc_hd__a21oi_1
X_18064_ net376 _06171_ _06172_ VSS VSS VDD VDD _02850_ sky130_fd_sc_hd__a21oi_1
X_18065_ network.neuron_in197.counter\[1\] network.neuron_in197.counter\[2\]
+ network.neuron_in197.counter\[0\] VSS VSS VDD VDD _06173_
+ sky130_fd_sc_hd__nor3_1
X_18066_ network.neuron_in197.counter\[3\] _06173_ VSS VSS
+ VDD VDD _06174_ sky130_fd_sc_hd__xnor2_1
X_18067_ net583 _06864_ VSS VSS VDD VDD _06175_ sky130_fd_sc_hd__nand2_1
X_18068_ _06864_ _06174_ _06175_ VSS VSS VDD VDD _02854_ sky130_fd_sc_hd__o21ai_0
X_18069_ network.in_period\[109\]\[0\] _05637_ VSS VSS VDD
+ VDD _06176_ sky130_fd_sc_hd__nand2_1
X_18070_ network.neuron_in109.counter\[0\] _05637_ _06176_
+ VSS VSS VDD VDD _02499_ sky130_fd_sc_hd__o21ai_0
X_18071_ network.in_spk14_07 _06165_ VSS VSS VDD VDD _06177_
+ sky130_fd_sc_hd__nand2_1
Xoutput29 net28 VSS VSS VDD VDD inference_cycles[10] sky130_fd_sc_hd__buf_1
X_18073_ _04775_ _06177_ net348 VSS VSS VDD VDD _02034_ sky130_fd_sc_hd__a21oi_1
X_18074_ network.neuron_in198.counter\[0\] network.neuron_in198.counter\[1\]
+ VSS VSS VDD VDD _06179_ sky130_fd_sc_hd__nor2_1
X_18075_ _01176_ _06179_ VSS VSS VDD VDD _06180_ sky130_fd_sc_hd__nor2_1
X_18076_ network.neuron_in198.counter\[2\] _06180_ VSS VSS
+ VDD VDD _06181_ sky130_fd_sc_hd__nor2_1
X_18077_ network.neuron_in198.counter\[2\] network.neuron_in198.counter\[3\]
+ _06179_ VSS VSS VDD VDD _06182_ sky130_fd_sc_hd__nand3b_1
X_18078_ network.neuron_in198.counter\[3\] _06181_ _06182_
+ VSS VSS VDD VDD _06183_ sky130_fd_sc_hd__o21ai_0
X_18079_ net389 _06762_ net508 VSS VSS VDD VDD _06184_ sky130_fd_sc_hd__a21oi_1
X_18080_ net389 _06183_ _06184_ VSS VSS VDD VDD _02858_ sky130_fd_sc_hd__a21oi_1
X_18081_ network.neuron_in109.counter\[2\] net382 VSS VSS
+ VDD VDD _06185_ sky130_fd_sc_hd__nand2_1
X_18082_ network.neuron_in109.counter\[3\] network.in_period\[109\]\[2\]
+ _06185_ VSS VSS VDD VDD _06186_ sky130_fd_sc_hd__o21ai_0
X_18083_ _00553_ network.neuron_in109.counter\[2\] net355
+ VSS VSS VDD VDD _06187_ sky130_fd_sc_hd__or3_1
X_18084_ network.in_period\[109\]\[2\] net382 _06187_ VSS
+ VSS VDD VDD _06188_ sky130_fd_sc_hd__o21ai_0
X_18085_ _00553_ _06186_ _06188_ VSS VSS VDD VDD _02501_ sky130_fd_sc_hd__a21oi_1
X_18086_ network.neuron_in199.counter\[0\] network.neuron_in199.counter\[1\]
+ VSS VSS VDD VDD _06189_ sky130_fd_sc_hd__nor2_1
X_18087_ _01180_ _06189_ VSS VSS VDD VDD _06190_ sky130_fd_sc_hd__nor2_1
X_18088_ network.neuron_in199.counter\[2\] _06190_ VSS VSS
+ VDD VDD _06191_ sky130_fd_sc_hd__nor2_1
X_18089_ network.neuron_in199.counter\[2\] network.neuron_in199.counter\[3\]
+ _06189_ VSS VSS VDD VDD _06192_ sky130_fd_sc_hd__nand3b_1
X_18090_ network.neuron_in199.counter\[3\] _06191_ _06192_
+ VSS VSS VDD VDD _06193_ sky130_fd_sc_hd__o21ai_0
X_18091_ net376 _06929_ network.in_period\[199\]\[3\] VSS
+ VSS VDD VDD _06194_ sky130_fd_sc_hd__a21oi_1
X_18092_ net376 _06193_ _06194_ VSS VSS VDD VDD _02862_ sky130_fd_sc_hd__a21oi_1
X_18093_ network.in_period\[109\]\[1\] _05637_ VSS VSS VDD
+ VDD _06195_ sky130_fd_sc_hd__nand2_1
X_18094_ _00554_ _05637_ _06195_ VSS VSS VDD VDD _02500_ sky130_fd_sc_hd__o21ai_0
X_18095_ network.in_spk12_07 _06164_ network.in_spk13_07 VSS
+ VSS VDD VDD _06196_ sky130_fd_sc_hd__o21ai_0
X_18096_ _04779_ _06196_ net348 VSS VSS VDD VDD _02035_ sky130_fd_sc_hd__a21oi_1
X_18097_ network.neuron_in200.counter\[1\] network.neuron_in200.counter\[0\]
+ _00968_ VSS VSS VDD VDD _06197_ sky130_fd_sc_hd__o21bai_1
X_18098_ _06895_ _06197_ network.neuron_in200.counter\[3\]
+ VSS VSS VDD VDD _06198_ sky130_fd_sc_hd__a21oi_1
X_18099_ _06895_ network.neuron_in200.counter\[3\] _00967_
+ _00966_ _06198_ VSS VSS VDD VDD _06199_ sky130_fd_sc_hd__a41o_1
X_18100_ net372 _06966_ network.in_period\[200\]\[3\] VSS
+ VSS VDD VDD _06200_ sky130_fd_sc_hd__a21oi_1
X_18101_ net375 _06199_ _06200_ VSS VSS VDD VDD _02866_ sky130_fd_sc_hd__a21oi_1
X_18102_ net674 _08341_ VSS VSS VDD VDD _06201_ sky130_fd_sc_hd__nand2_1
X_18103_ network.neuron_in139.counter\[0\] _08341_ _06201_
+ VSS VSS VDD VDD _02619_ sky130_fd_sc_hd__o21ai_0
X_18104_ network.neuron_in201.counter\[1\] network.neuron_in201.counter\[0\]
+ _01152_ VSS VSS VDD VDD _06202_ sky130_fd_sc_hd__o21bai_1
X_18105_ _06881_ _06202_ network.neuron_in201.counter\[3\]
+ VSS VSS VDD VDD _06203_ sky130_fd_sc_hd__a21oi_1
X_18106_ _06881_ network.neuron_in201.counter\[3\] _01151_
+ _01150_ _06203_ VSS VSS VDD VDD _06204_ sky130_fd_sc_hd__a41o_1
X_18107_ net376 _06880_ net502 VSS VSS VDD VDD _06205_ sky130_fd_sc_hd__a21oi_1
X_18108_ net376 _06204_ _06205_ VSS VSS VDD VDD _02870_ sky130_fd_sc_hd__a21oi_1
X_18109_ network.in_spk12_07 _06164_ VSS VSS VDD VDD _06206_
+ sky130_fd_sc_hd__nand2_1
X_18110_ _04782_ _06206_ net348 VSS VSS VDD VDD _02036_ sky130_fd_sc_hd__a21oi_1
Xoutput28 net27 VSS VSS VDD VDD inference_cycles[0] sky130_fd_sc_hd__buf_1
X_18112_ network.neuron_in202.counter\[1\] network.neuron_in202.counter\[0\]
+ _00675_ VSS VSS VDD VDD _06208_ sky130_fd_sc_hd__o21bai_1
X_18113_ _06905_ _06208_ network.neuron_in202.counter\[3\]
+ VSS VSS VDD VDD _06209_ sky130_fd_sc_hd__a21oi_1
X_18114_ _06905_ network.neuron_in202.counter\[3\] _00674_
+ _00673_ _06209_ VSS VSS VDD VDD _06210_ sky130_fd_sc_hd__a41o_1
X_18115_ net367 _06904_ net494 VSS VSS VDD VDD _06211_ sky130_fd_sc_hd__a21oi_1
X_18116_ net367 _06210_ _06211_ VSS VSS VDD VDD _02874_ sky130_fd_sc_hd__a21oi_1
X_18117_ network.neuron_in110.counter\[2\] net382 VSS VSS
+ VDD VDD _06212_ sky130_fd_sc_hd__nand2_1
X_18118_ network.neuron_in110.counter\[3\] network.in_period\[110\]\[2\]
+ _06212_ VSS VSS VDD VDD _06213_ sky130_fd_sc_hd__o21ai_0
X_18119_ _00549_ network.neuron_in110.counter\[2\] net355
+ VSS VSS VDD VDD _06214_ sky130_fd_sc_hd__or3_1
X_18120_ network.in_period\[110\]\[2\] net382 _06214_ VSS
+ VSS VDD VDD _06215_ sky130_fd_sc_hd__o21ai_0
X_18121_ _00549_ _06213_ _06215_ VSS VSS VDD VDD _02505_ sky130_fd_sc_hd__a21oi_1
X_18122_ network.neuron_in203.counter\[0\] network.neuron_in203.counter\[1\]
+ network.neuron_in203.counter\[2\] VSS VSS VDD VDD _06216_
+ sky130_fd_sc_hd__nor3_1
X_18123_ network.neuron_in203.counter\[3\] _06216_ VSS VSS
+ VDD VDD _06217_ sky130_fd_sc_hd__xnor2_1
X_18124_ net476 _06887_ VSS VSS VDD VDD _06218_ sky130_fd_sc_hd__nand2_1
X_18125_ _06887_ _06217_ _06218_ VSS VSS VDD VDD _02878_ sky130_fd_sc_hd__o21ai_0
X_18126_ net790 _05642_ VSS VSS VDD VDD _06219_ sky130_fd_sc_hd__nand2_1
X_18127_ _00550_ _05642_ _06219_ VSS VSS VDD VDD _02504_ sky130_fd_sc_hd__o21ai_0
X_18128_ network.in_spk08_07 network.in_spk09_07 network.in_spk10_07
+ _09336_ network.in_spk11_07 VSS VSS VDD VDD _06220_ sky130_fd_sc_hd__o41ai_1
X_18129_ _04785_ _06220_ net356 VSS VSS VDD VDD _02037_ sky130_fd_sc_hd__a21oi_1
X_18130_ network.neuron_in204.counter\[1\] network.neuron_in204.counter\[2\]
+ network.neuron_in204.counter\[0\] VSS VSS VDD VDD _06221_
+ sky130_fd_sc_hd__nor3_1
X_18131_ network.neuron_in204.counter\[3\] _06221_ VSS VSS
+ VDD VDD _06222_ sky130_fd_sc_hd__xnor2_1
X_18132_ net568 _06982_ VSS VSS VDD VDD _06223_ sky130_fd_sc_hd__nand2_1
X_18133_ _06982_ _06222_ _06223_ VSS VSS VDD VDD _02882_ sky130_fd_sc_hd__o21ai_0
X_18134_ network.neuron_in111.counter\[3\] network.in_period\[111\]\[2\]
+ net355 _00606_ VSS VSS VDD VDD _06224_ sky130_fd_sc_hd__o22ai_1
X_18135_ network.neuron_in111.counter\[2\] _00606_ net382
+ VSS VSS VDD VDD _06225_ sky130_fd_sc_hd__nand3_1
X_18136_ network.in_period\[111\]\[2\] net382 _06225_ VSS
+ VSS VDD VDD _06226_ sky130_fd_sc_hd__o21ai_0
X_18137_ _04813_ _06224_ _06226_ VSS VSS VDD VDD _02509_ sky130_fd_sc_hd__a21oi_1
X_18138_ network.neuron_in205.counter\[1\] network.neuron_in205.counter\[0\]
+ _00960_ VSS VSS VDD VDD _06227_ sky130_fd_sc_hd__o21bai_1
X_18139_ _06910_ _06227_ network.neuron_in205.counter\[3\]
+ VSS VSS VDD VDD _06228_ sky130_fd_sc_hd__a21oi_1
X_18140_ _06910_ network.neuron_in205.counter\[3\] _00959_
+ _00958_ _06228_ VSS VSS VDD VDD _06229_ sky130_fd_sc_hd__a41o_1
Xoutput27 net26 VSS VSS VDD VDD done sky130_fd_sc_hd__buf_1
X_18142_ net367 _06985_ net498 VSS VSS VDD VDD _06231_ sky130_fd_sc_hd__a21oi_1
X_18143_ net367 _06229_ _06231_ VSS VSS VDD VDD _02886_ sky130_fd_sc_hd__a21oi_1
X_18144_ net796 _06147_ VSS VSS VDD VDD _06232_ sky130_fd_sc_hd__nand2_1
X_18145_ _00607_ _06147_ _06232_ VSS VSS VDD VDD _02508_ sky130_fd_sc_hd__o21ai_0
X_18146_ network.in_spk08_07 network.in_spk09_07 _09336_ network.in_spk10_07
+ VSS VSS VDD VDD _06233_ sky130_fd_sc_hd__o31ai_1
X_18147_ _04787_ _06233_ net348 VSS VSS VDD VDD _02038_ sky130_fd_sc_hd__a21oi_1
X_18148_ network.neuron_in206.counter\[1\] network.neuron_in206.counter\[0\]
+ _00996_ VSS VSS VDD VDD _06234_ sky130_fd_sc_hd__o21bai_1
X_18149_ _06890_ _06234_ network.neuron_in206.counter\[3\]
+ VSS VSS VDD VDD _06235_ sky130_fd_sc_hd__a21oi_1
X_18150_ _06890_ network.neuron_in206.counter\[3\] _00995_
+ _00994_ _06235_ VSS VSS VDD VDD _06236_ sky130_fd_sc_hd__a41o_1
X_18151_ net367 _06889_ net490 VSS VSS VDD VDD _06237_ sky130_fd_sc_hd__a21oi_1
X_18152_ net367 _06236_ _06237_ VSS VSS VDD VDD _02890_ sky130_fd_sc_hd__a21oi_1
X_18153_ network.neuron_in112.counter\[3\] network.in_period\[112\]\[2\]
+ net348 _00747_ VSS VSS VDD VDD _06238_ sky130_fd_sc_hd__o22ai_1
X_18154_ network.neuron_in112.counter\[2\] _00747_ net382
+ VSS VSS VDD VDD _06239_ sky130_fd_sc_hd__nand3_1
X_18155_ network.in_period\[112\]\[2\] net382 _06239_ VSS
+ VSS VDD VDD _06240_ sky130_fd_sc_hd__o21ai_0
X_18156_ _04811_ _06238_ _06240_ VSS VSS VDD VDD _02513_ sky130_fd_sc_hd__a21oi_1
X_18157_ network.neuron_in207.counter\[1\] network.neuron_in207.counter\[2\]
+ network.neuron_in207.counter\[0\] VSS VSS VDD VDD _06241_
+ sky130_fd_sc_hd__nor3_1
X_18158_ network.neuron_in207.counter\[3\] _06241_ VSS VSS
+ VDD VDD _06242_ sky130_fd_sc_hd__xnor2_1
X_18159_ net546 _07000_ VSS VSS VDD VDD _06243_ sky130_fd_sc_hd__nand2_1
X_18160_ _07000_ _06242_ _06243_ VSS VSS VDD VDD _02894_ sky130_fd_sc_hd__o21ai_0
X_18161_ net736 _06117_ VSS VSS VDD VDD _06244_ sky130_fd_sc_hd__nand2_1
X_18162_ _00748_ _06117_ _06244_ VSS VSS VDD VDD _02512_ sky130_fd_sc_hd__o21ai_0
X_18163_ network.in_spk08_07 _09336_ network.in_spk09_07 VSS
+ VSS VDD VDD _06245_ sky130_fd_sc_hd__o21ai_0
X_18164_ _04789_ _06245_ net356 VSS VSS VDD VDD _02039_ sky130_fd_sc_hd__a21oi_1
X_18165_ network.neuron_in208.counter\[0\] network.neuron_in208.counter\[1\]
+ _00515_ VSS VSS VDD VDD _06246_ sky130_fd_sc_hd__o21bai_1
X_18166_ _06876_ _06246_ network.neuron_in208.counter\[3\]
+ VSS VSS VDD VDD _06247_ sky130_fd_sc_hd__a21oi_1
X_18167_ _06876_ network.neuron_in208.counter\[3\] _00513_
+ _00514_ _06247_ VSS VSS VDD VDD _06248_ sky130_fd_sc_hd__a41o_1
X_18168_ net365 _06875_ network.in_period\[208\]\[3\] VSS
+ VSS VDD VDD _06249_ sky130_fd_sc_hd__a21oi_1
X_18169_ net365 _06248_ _06249_ VSS VSS VDD VDD _02898_ sky130_fd_sc_hd__a21oi_1
X_18170_ network.neuron_in209.counter\[1\] network.neuron_in209.counter\[0\]
+ VSS VSS VDD VDD _06250_ sky130_fd_sc_hd__nor2_1
X_18171_ _00811_ _06250_ VSS VSS VDD VDD _06251_ sky130_fd_sc_hd__nor2_1
X_18172_ network.neuron_in209.counter\[2\] _06251_ VSS VSS
+ VDD VDD _06252_ sky130_fd_sc_hd__nor2_1
X_18173_ network.neuron_in209.counter\[2\] network.neuron_in209.counter\[3\]
+ _06250_ VSS VSS VDD VDD _06253_ sky130_fd_sc_hd__nand3b_1
X_18174_ network.neuron_in209.counter\[3\] _06252_ _06253_
+ VSS VSS VDD VDD _06254_ sky130_fd_sc_hd__o21ai_0
X_18175_ net367 _07074_ net489 VSS VSS VDD VDD _06255_ sky130_fd_sc_hd__a21oi_1
X_18176_ net367 _06254_ _06255_ VSS VSS VDD VDD _02902_ sky130_fd_sc_hd__a21oi_1
X_18177_ network.neuron_in113.counter\[3\] network.in_period\[113\]\[2\]
+ net348 _01091_ VSS VSS VDD VDD _06256_ sky130_fd_sc_hd__o22ai_1
X_18178_ network.neuron_in113.counter\[2\] _01091_ net383
+ VSS VSS VDD VDD _06257_ sky130_fd_sc_hd__nand3_1
X_18179_ network.in_period\[113\]\[2\] net383 _06257_ VSS
+ VSS VDD VDD _06258_ sky130_fd_sc_hd__o21ai_0
X_18180_ _04808_ _06256_ _06258_ VSS VSS VDD VDD _02517_ sky130_fd_sc_hd__a21oi_1
X_18181_ network.in_spk08_07 _09336_ VSS VSS VDD VDD _06259_
+ sky130_fd_sc_hd__nand2_1
X_18182_ _04792_ _06259_ net348 VSS VSS VDD VDD _02040_ sky130_fd_sc_hd__a21oi_1
X_18183_ network.neuron_in210.counter\[0\] network.neuron_in210.counter\[1\]
+ VSS VSS VDD VDD _06260_ sky130_fd_sc_hd__nor2_1
X_18184_ _01144_ _06260_ VSS VSS VDD VDD _06261_ sky130_fd_sc_hd__nor2_1
X_18185_ network.neuron_in210.counter\[2\] _06261_ VSS VSS
+ VDD VDD _06262_ sky130_fd_sc_hd__nor2_1
X_18186_ network.neuron_in210.counter\[2\] network.neuron_in210.counter\[3\]
+ _06260_ VSS VSS VDD VDD _06263_ sky130_fd_sc_hd__nand3b_1
X_18187_ network.neuron_in210.counter\[3\] _06262_ _06263_
+ VSS VSS VDD VDD _06264_ sky130_fd_sc_hd__o21ai_0
X_18188_ net367 _07083_ net488 VSS VSS VDD VDD _06265_ sky130_fd_sc_hd__a21oi_1
X_18189_ net367 _06264_ _06265_ VSS VSS VDD VDD _02906_ sky130_fd_sc_hd__a21oi_1
X_18190_ net798 _06162_ VSS VSS VDD VDD _06266_ sky130_fd_sc_hd__nand2_1
X_18191_ network.neuron_in113.counter\[0\] _06162_ _06266_
+ VSS VSS VDD VDD _02515_ sky130_fd_sc_hd__o21ai_0
X_18192_ network.neuron_in211.counter\[0\] network.neuron_in211.counter\[1\]
+ _00956_ VSS VSS VDD VDD _06267_ sky130_fd_sc_hd__o21bai_1
X_18193_ _07019_ _06267_ network.neuron_in211.counter\[3\]
+ VSS VSS VDD VDD _06268_ sky130_fd_sc_hd__a21oi_1
X_18194_ _07019_ network.neuron_in211.counter\[3\] _00954_
+ _00955_ _06268_ VSS VSS VDD VDD _06269_ sky130_fd_sc_hd__a41o_1
X_18195_ net367 _07018_ network.in_period\[211\]\[3\] VSS
+ VSS VDD VDD _06270_ sky130_fd_sc_hd__a21oi_1
X_18196_ net367 _06269_ _06270_ VSS VSS VDD VDD _02910_ sky130_fd_sc_hd__a21oi_1
X_18197_ network.neuron_in114.counter\[2\] VSS VSS VDD VDD
+ _06271_ sky130_fd_sc_hd__inv_1
X_18198_ network.neuron_in114.counter\[3\] network.in_period\[114\]\[2\]
+ _00079_ net356 VSS VSS VDD VDD _06272_ sky130_fd_sc_hd__o22ai_1
X_18199_ network.neuron_in114.counter\[2\] _00079_ net386
+ VSS VSS VDD VDD _06273_ sky130_fd_sc_hd__nand3_1
X_18200_ network.in_period\[114\]\[2\] net386 _06273_ VSS
+ VSS VDD VDD _06274_ sky130_fd_sc_hd__o21ai_0
X_18201_ _06271_ _06272_ _06274_ VSS VSS VDD VDD _02521_ sky130_fd_sc_hd__a21oi_1
X_18202_ network.in_spk04_07 network.in_spk05_07 network.in_spk06_07
+ _09393_ network.in_spk07_07 VSS VSS VDD VDD _06275_ sky130_fd_sc_hd__o41ai_1
X_18203_ _04793_ _06275_ net348 VSS VSS VDD VDD _02041_ sky130_fd_sc_hd__a21oi_1
X_18204_ network.neuron_in212.counter\[0\] network.neuron_in212.counter\[2\]
+ network.neuron_in212.counter\[1\] net363 VSS VSS VDD VDD _06276_
+ sky130_fd_sc_hd__nor4_1
X_18205_ network.in_period\[212\]\[3\] _06276_ _07048_ VSS
+ VSS VDD VDD _06277_ sky130_fd_sc_hd__mux2i_1
X_18206_ network.neuron_in212.counter\[0\] network.neuron_in212.counter\[2\]
+ network.neuron_in212.counter\[1\] net367 network.neuron_in212.counter\[3\]
+ VSS VSS VDD VDD _06278_ sky130_fd_sc_hd__o311a_1
X_18207_ net761 net363 _06278_ VSS VSS VDD VDD _06279_ sky130_fd_sc_hd__a21oi_1
X_18208_ network.neuron_in212.counter\[3\] _06277_ _06279_
+ VSS VSS VDD VDD _02914_ sky130_fd_sc_hd__o21ai_0
X_18209_ network.neuron_in213.counter\[1\] network.neuron_in213.counter\[0\]
+ _00992_ VSS VSS VDD VDD _06280_ sky130_fd_sc_hd__o21bai_1
X_18210_ _07024_ _06280_ network.neuron_in213.counter\[3\]
+ VSS VSS VDD VDD _06281_ sky130_fd_sc_hd__a21oi_1
X_18211_ _07024_ network.neuron_in213.counter\[3\] _00991_
+ _00990_ _06281_ VSS VSS VDD VDD _06282_ sky130_fd_sc_hd__a41o_1
X_18212_ net365 _07023_ net689 VSS VSS VDD VDD _06283_ sky130_fd_sc_hd__a21oi_1
X_18213_ net365 _06282_ _06283_ VSS VSS VDD VDD _02918_ sky130_fd_sc_hd__a21oi_1
X_18214_ network.in_spk04_07 network.in_spk05_07 _09393_ network.in_spk06_07
+ VSS VSS VDD VDD _06284_ sky130_fd_sc_hd__o31ai_1
X_18215_ _04795_ _06284_ net356 VSS VSS VDD VDD _02042_ sky130_fd_sc_hd__a21oi_1
X_18216_ network.neuron_in214.counter\[1\] network.neuron_in214.counter\[0\]
+ _01000_ VSS VSS VDD VDD _06285_ sky130_fd_sc_hd__o21bai_1
X_18217_ _07007_ _06285_ network.neuron_in214.counter\[3\]
+ VSS VSS VDD VDD _06286_ sky130_fd_sc_hd__a21oi_1
X_18218_ _07007_ network.neuron_in214.counter\[3\] _00999_
+ _00998_ _06286_ VSS VSS VDD VDD _06287_ sky130_fd_sc_hd__a41o_1
X_18219_ net365 _07097_ network.in_period\[214\]\[3\] VSS
+ VSS VDD VDD _06288_ sky130_fd_sc_hd__a21oi_1
X_18220_ net365 _06287_ _06288_ VSS VSS VDD VDD _02922_ sky130_fd_sc_hd__a21oi_1
X_18221_ network.neuron_in215.counter\[1\] network.neuron_in215.counter\[0\]
+ _00303_ VSS VSS VDD VDD _06289_ sky130_fd_sc_hd__o21bai_1
X_18222_ _07053_ _06289_ network.neuron_in215.counter\[3\]
+ VSS VSS VDD VDD _06290_ sky130_fd_sc_hd__a21oi_1
X_18223_ _07053_ _00302_ _00301_ network.neuron_in215.counter\[3\]
+ _06290_ VSS VSS VDD VDD _06291_ sky130_fd_sc_hd__a41o_1
X_18224_ net365 _07058_ network.in_period\[215\]\[3\] VSS
+ VSS VDD VDD _06292_ sky130_fd_sc_hd__a21oi_1
X_18225_ net365 _06291_ _06292_ VSS VSS VDD VDD _02926_ sky130_fd_sc_hd__a21oi_1
X_18226_ network.in_spk04_07 _09393_ network.in_spk05_07 VSS
+ VSS VDD VDD _06293_ sky130_fd_sc_hd__o21ai_0
X_18227_ _04797_ _06293_ net348 VSS VSS VDD VDD _02043_ sky130_fd_sc_hd__a21oi_1
Xoutput26 net25 VSS VSS VDD VDD busy sky130_fd_sc_hd__buf_1
X_18229_ network.neuron_in216.counter\[1\] network.neuron_in216.counter\[0\]
+ _00938_ VSS VSS VDD VDD _06295_ sky130_fd_sc_hd__o21bai_1
X_18230_ _07028_ _06295_ network.neuron_in216.counter\[3\]
+ VSS VSS VDD VDD _06296_ sky130_fd_sc_hd__a21oi_1
X_18231_ _07028_ network.neuron_in216.counter\[3\] _00937_
+ _00936_ _06296_ VSS VSS VDD VDD _06297_ sky130_fd_sc_hd__a41o_1
X_18232_ net366 _07103_ network.in_period\[216\]\[3\] VSS
+ VSS VDD VDD _06298_ sky130_fd_sc_hd__a21oi_1
X_18233_ net366 _06297_ _06298_ VSS VSS VDD VDD _02930_ sky130_fd_sc_hd__a21oi_1
X_18234_ network.neuron_in217.counter\[1\] network.neuron_in217.counter\[0\]
+ network.neuron_in217.counter\[2\] VSS VSS VDD VDD _06299_
+ sky130_fd_sc_hd__nor3_1
X_18235_ network.neuron_in217.counter\[3\] _06299_ VSS VSS
+ VDD VDD _06300_ sky130_fd_sc_hd__xnor2_1
X_18236_ net569 _07110_ VSS VSS VDD VDD _06301_ sky130_fd_sc_hd__nand2_1
X_18237_ _07110_ _06300_ _06301_ VSS VSS VDD VDD _02934_ sky130_fd_sc_hd__o21ai_0
X_18238_ network.in_spk04_07 _09393_ VSS VSS VDD VDD _06302_
+ sky130_fd_sc_hd__nand2_1
Xinput25 net443 VSS VSS VDD VDD net24 sky130_fd_sc_hd__buf_1
X_18240_ _04800_ _06302_ net348 VSS VSS VDD VDD _02044_ sky130_fd_sc_hd__a21oi_1
X_18241_ network.neuron_in218.counter\[1\] network.neuron_in218.counter\[0\]
+ _00988_ VSS VSS VDD VDD _06304_ sky130_fd_sc_hd__o21bai_1
X_18242_ _07014_ _06304_ network.neuron_in218.counter\[3\]
+ VSS VSS VDD VDD _06305_ sky130_fd_sc_hd__a21oi_1
X_18243_ _07014_ network.neuron_in218.counter\[3\] _00987_
+ _00986_ _06305_ VSS VSS VDD VDD _06306_ sky130_fd_sc_hd__a41o_1
Xinput24 net446 VSS VSS VDD VDD net23 sky130_fd_sc_hd__clkbuf_2
X_18245_ net365 _07013_ network.in_period\[218\]\[3\] VSS
+ VSS VDD VDD _06308_ sky130_fd_sc_hd__a21oi_1
X_18246_ net365 _06306_ _06308_ VSS VSS VDD VDD _02938_ sky130_fd_sc_hd__a21oi_1
X_18247_ network.neuron_in219.counter\[0\] network.neuron_in219.counter\[1\]
+ network.neuron_in219.counter\[2\] net362 VSS VSS VDD VDD _06309_
+ sky130_fd_sc_hd__nor4_1
X_18248_ network.in_period\[219\]\[3\] _06309_ _07171_ VSS
+ VSS VDD VDD _06310_ sky130_fd_sc_hd__mux2i_1
Xinput23 net460 VSS VSS VDD VDD net22 sky130_fd_sc_hd__buf_1
X_18250_ network.neuron_in219.counter\[0\] network.neuron_in219.counter\[1\]
+ network.neuron_in219.counter\[2\] network.neuron_in219.counter\[3\]
+ net366 VSS VSS VDD VDD _06312_ sky130_fd_sc_hd__o311a_1
X_18251_ network.in_period\[219\]\[3\] net362 _06312_ VSS
+ VSS VDD VDD _06313_ sky130_fd_sc_hd__a21oi_1
X_18252_ network.neuron_in219.counter\[3\] _06310_ _06313_
+ VSS VSS VDD VDD _02942_ sky130_fd_sc_hd__o21ai_0
X_18253_ network.in_spk00_07 network.in_spk01_07 network.in_spk02_07
+ _09290_ network.in_spk03_07 VSS VSS VDD VDD _06314_ sky130_fd_sc_hd__o41ai_1
X_18254_ _04804_ _06314_ net356 VSS VSS VDD VDD _02045_ sky130_fd_sc_hd__a21oi_1
X_18255_ network.neuron_in220.counter\[1\] network.neuron_in220.counter\[2\]
+ network.neuron_in220.counter\[0\] net362 VSS VSS VDD VDD _06315_
+ sky130_fd_sc_hd__nor4_1
X_18256_ network.in_period\[220\]\[3\] _06315_ _07176_ VSS
+ VSS VDD VDD _06316_ sky130_fd_sc_hd__mux2i_1
X_18257_ network.neuron_in220.counter\[1\] network.neuron_in220.counter\[2\]
+ network.neuron_in220.counter\[0\] net366 network.neuron_in220.counter\[3\]
+ VSS VSS VDD VDD _06317_ sky130_fd_sc_hd__o311a_1
X_18258_ network.in_period\[220\]\[3\] net362 _06317_ VSS
+ VSS VDD VDD _06318_ sky130_fd_sc_hd__a21oi_1
X_18259_ network.neuron_in220.counter\[3\] _06316_ _06318_
+ VSS VSS VDD VDD _02946_ sky130_fd_sc_hd__o21ai_0
X_18260_ network.neuron_in221.counter\[0\] network.neuron_in221.counter\[1\]
+ _00897_ VSS VSS VDD VDD _06319_ sky130_fd_sc_hd__o21bai_1
X_18261_ _07127_ _06319_ network.neuron_in221.counter\[3\]
+ VSS VSS VDD VDD _06320_ sky130_fd_sc_hd__a21oi_1
X_18262_ _07127_ network.neuron_in221.counter\[3\] _00895_
+ _00896_ _06320_ VSS VSS VDD VDD _06321_ sky130_fd_sc_hd__a41o_1
X_18263_ net365 _07126_ network.in_period\[221\]\[3\] VSS
+ VSS VDD VDD _06322_ sky130_fd_sc_hd__a21oi_1
X_18264_ net365 _06321_ _06322_ VSS VSS VDD VDD _02950_ sky130_fd_sc_hd__a21oi_1
X_18265_ network.neuron_in116.counter\[3\] network.in_period\[116\]\[2\]
+ net348 _00092_ VSS VSS VDD VDD _06323_ sky130_fd_sc_hd__o22ai_1
X_18266_ network.neuron_in116.counter\[2\] _00092_ net383
+ VSS VSS VDD VDD _06324_ sky130_fd_sc_hd__nand3_1
X_18267_ network.in_period\[116\]\[2\] net383 _06324_ VSS
+ VSS VDD VDD _06325_ sky130_fd_sc_hd__o21ai_0
X_18268_ _04798_ _06323_ _06325_ VSS VSS VDD VDD _02529_ sky130_fd_sc_hd__a21oi_1
X_18269_ network.in_spk00_07 network.in_spk01_07 _09290_ network.in_spk02_07
+ VSS VSS VDD VDD _06326_ sky130_fd_sc_hd__o31ai_1
X_18270_ _04806_ _06326_ net356 VSS VSS VDD VDD _02046_ sky130_fd_sc_hd__a21oi_1
X_18271_ network.neuron_in222.counter\[0\] network.neuron_in222.counter\[2\]
+ network.neuron_in222.counter\[1\] VSS VSS VDD VDD _06327_
+ sky130_fd_sc_hd__nor3_1
X_18272_ network.neuron_in222.counter\[3\] _06327_ VSS VSS
+ VDD VDD _06328_ sky130_fd_sc_hd__xnor2_1
X_18273_ net670 _07152_ VSS VSS VDD VDD _06329_ sky130_fd_sc_hd__nand2_1
X_18274_ _07152_ _06328_ _06329_ VSS VSS VDD VDD _02954_ sky130_fd_sc_hd__o21ai_0
X_18275_ network.neuron_in117.counter\[2\] VSS VSS VDD VDD
+ _06330_ sky130_fd_sc_hd__inv_1
X_18276_ network.neuron_in117.counter\[3\] network.in_period\[117\]\[2\]
+ net348 _00071_ VSS VSS VDD VDD _06331_ sky130_fd_sc_hd__o22ai_1
X_18277_ network.neuron_in117.counter\[2\] _00071_ net382
+ VSS VSS VDD VDD _06332_ sky130_fd_sc_hd__nand3_1
X_18278_ network.in_period\[117\]\[2\] net382 _06332_ VSS
+ VSS VDD VDD _06333_ sky130_fd_sc_hd__o21ai_0
X_18279_ _06330_ _06331_ _06333_ VSS VSS VDD VDD _02533_ sky130_fd_sc_hd__a21oi_1
X_18280_ network.neuron_in223.counter\[0\] network.neuron_in223.counter\[2\]
+ network.neuron_in223.counter\[1\] net362 VSS VSS VDD VDD _06334_
+ sky130_fd_sc_hd__nor4_1
X_18281_ network.in_period\[223\]\[3\] _06334_ _07132_ VSS
+ VSS VDD VDD _06335_ sky130_fd_sc_hd__mux2i_1
X_18282_ network.neuron_in223.counter\[0\] network.neuron_in223.counter\[2\]
+ network.neuron_in223.counter\[1\] net366 network.neuron_in223.counter\[3\]
+ VSS VSS VDD VDD _06336_ sky130_fd_sc_hd__o311a_1
X_18283_ network.in_period\[223\]\[3\] net362 _06336_ VSS
+ VSS VDD VDD _06337_ sky130_fd_sc_hd__a21oi_1
X_18284_ network.neuron_in223.counter\[3\] _06335_ _06337_
+ VSS VSS VDD VDD _02958_ sky130_fd_sc_hd__o21ai_0
X_18285_ network.in_period\[118\]\[0\] _05679_ VSS VSS VDD
+ VDD _06338_ sky130_fd_sc_hd__nand2_1
X_18286_ network.neuron_in118.counter\[0\] _05679_ _06338_
+ VSS VSS VDD VDD _02535_ sky130_fd_sc_hd__o21ai_0
X_18287_ network.neuron_in119.counter\[2\] net383 VSS VSS
+ VDD VDD _06339_ sky130_fd_sc_hd__nand2_1
X_18288_ network.neuron_in119.counter\[3\] network.in_period\[119\]\[2\]
+ _06339_ VSS VSS VDD VDD _06340_ sky130_fd_sc_hd__o21ai_0
X_18289_ _00602_ network.neuron_in119.counter\[2\] net348
+ VSS VSS VDD VDD _06341_ sky130_fd_sc_hd__or3_1
X_18290_ network.in_period\[119\]\[2\] net383 _06341_ VSS
+ VSS VDD VDD _06342_ sky130_fd_sc_hd__o21ai_0
X_18291_ _00602_ _06340_ _06342_ VSS VSS VDD VDD _02541_ sky130_fd_sc_hd__a21oi_1
X_18292_ network.in_spk01_07 _09565_ VSS VSS VDD VDD _06343_
+ sky130_fd_sc_hd__nand2_1
X_18293_ _04809_ _06343_ net348 VSS VSS VDD VDD _02047_ sky130_fd_sc_hd__a21oi_1
X_18294_ network.neuron_in224.counter\[1\] network.neuron_in224.counter\[0\]
+ _01190_ VSS VSS VDD VDD _06344_ sky130_fd_sc_hd__o21bai_1
X_18295_ _07117_ _06344_ network.neuron_in224.counter\[3\]
+ VSS VSS VDD VDD _06345_ sky130_fd_sc_hd__a21oi_1
X_18296_ _07117_ network.neuron_in224.counter\[3\] _01189_
+ _01188_ _06345_ VSS VSS VDD VDD _06346_ sky130_fd_sc_hd__a41o_1
X_18297_ net388 _07191_ net500 VSS VSS VDD VDD _06347_ sky130_fd_sc_hd__a21oi_1
X_18298_ net388 _06346_ _06347_ VSS VSS VDD VDD _02962_ sky130_fd_sc_hd__a21oi_1
X_18299_ network.neuron_in115.counter\[3\] network.in_period\[115\]\[2\]
+ net356 _01224_ VSS VSS VDD VDD _06348_ sky130_fd_sc_hd__o22ai_1
Xinput22 net451 VSS VSS VDD VDD net21 sky130_fd_sc_hd__buf_1
Xinput21 net457 VSS VSS VDD VDD net20 sky130_fd_sc_hd__buf_1
X_18302_ network.neuron_in115.counter\[2\] _01224_ net386
+ VSS VSS VDD VDD _06351_ sky130_fd_sc_hd__nand3_1
X_18303_ network.in_period\[115\]\[2\] net386 _06351_ VSS
+ VSS VDD VDD _06352_ sky130_fd_sc_hd__o21ai_0
X_18304_ _04803_ _06348_ _06352_ VSS VSS VDD VDD _02525_ sky130_fd_sc_hd__a21oi_1
X_18305_ net617 _05660_ VSS VSS VDD VDD _06353_ sky130_fd_sc_hd__nand2_1
X_18306_ network.neuron_in114.counter\[0\] _05660_ _06353_
+ VSS VSS VDD VDD _02519_ sky130_fd_sc_hd__o21ai_0
X_18307_ network.neuron_in225.counter\[1\] network.neuron_in225.counter\[0\]
+ _00843_ VSS VSS VDD VDD _06354_ sky130_fd_sc_hd__o21bai_1
X_18308_ _07155_ _06354_ network.neuron_in225.counter\[3\]
+ VSS VSS VDD VDD _06355_ sky130_fd_sc_hd__a21oi_1
X_18309_ _07155_ network.neuron_in225.counter\[3\] _00842_
+ _00841_ _06355_ VSS VSS VDD VDD _06356_ sky130_fd_sc_hd__a41o_1
X_18310_ net388 _07160_ network.in_period\[225\]\[3\] VSS
+ VSS VDD VDD _06357_ sky130_fd_sc_hd__a21oi_1
X_18311_ net388 _06356_ _06357_ VSS VSS VDD VDD _02966_ sky130_fd_sc_hd__a21oi_1
X_18312_ net386 _04804_ VSS VSS VDD VDD _06358_ sky130_fd_sc_hd__nand2_1
X_18313_ net628 _06358_ VSS VSS VDD VDD _06359_ sky130_fd_sc_hd__nand2_1
X_18314_ _01225_ _06358_ _06359_ VSS VSS VDD VDD _02524_ sky130_fd_sc_hd__o21ai_0
X_18315_ net623 _06358_ VSS VSS VDD VDD _06360_ sky130_fd_sc_hd__nand2_1
X_18316_ network.neuron_in115.counter\[0\] _06358_ _06360_
+ VSS VSS VDD VDD _02523_ sky130_fd_sc_hd__o21ai_0
X_18317_ network.in_spk00_07 _09290_ VSS VSS VDD VDD _06361_
+ sky130_fd_sc_hd__nand2_1
X_18318_ _04812_ _06361_ net348 VSS VSS VDD VDD _02048_ sky130_fd_sc_hd__a21oi_1
X_18319_ net383 _04800_ VSS VSS VDD VDD _06362_ sky130_fd_sc_hd__nand2_1
X_18320_ net792 _06362_ VSS VSS VDD VDD _06363_ sky130_fd_sc_hd__nand2_1
X_18321_ _00093_ _06362_ _06363_ VSS VSS VDD VDD _02528_ sky130_fd_sc_hd__o21ai_0
X_18322_ network.neuron_in226.counter\[0\] network.neuron_in226.counter\[1\]
+ VSS VSS VDD VDD _06364_ sky130_fd_sc_hd__nor2_1
X_18323_ _00799_ _06364_ VSS VSS VDD VDD _06365_ sky130_fd_sc_hd__nor2_1
X_18324_ network.neuron_in226.counter\[2\] _06365_ VSS VSS
+ VDD VDD _06366_ sky130_fd_sc_hd__nor2_1
X_18325_ network.neuron_in226.counter\[2\] network.neuron_in226.counter\[3\]
+ _06364_ VSS VSS VDD VDD _06367_ sky130_fd_sc_hd__nand3b_1
X_18326_ network.neuron_in226.counter\[3\] _06366_ _06367_
+ VSS VSS VDD VDD _06368_ sky130_fd_sc_hd__o21ai_0
X_18327_ net388 _07204_ net495 VSS VSS VDD VDD _06369_ sky130_fd_sc_hd__a21oi_1
X_18328_ net388 _06368_ _06369_ VSS VSS VDD VDD _02970_ sky130_fd_sc_hd__a21oi_1
X_18329_ network.neuron_in116.counter\[0\] VSS VSS VDD VDD
+ _00090_ sky130_fd_sc_hd__inv_1
X_18330_ network.in_period\[116\]\[0\] _06362_ VSS VSS VDD
+ VDD _06370_ sky130_fd_sc_hd__nand2_1
X_18331_ network.neuron_in116.counter\[0\] _06362_ _06370_
+ VSS VSS VDD VDD _02527_ sky130_fd_sc_hd__o21ai_0
X_18332_ net801 _05673_ VSS VSS VDD VDD _06371_ sky130_fd_sc_hd__nand2_1
X_18333_ _00072_ _05673_ _06371_ VSS VSS VDD VDD _02532_ sky130_fd_sc_hd__o21ai_0
X_18334_ net804 _05673_ VSS VSS VDD VDD _06372_ sky130_fd_sc_hd__nand2_1
X_18335_ network.neuron_in117.counter\[0\] _05673_ _06372_
+ VSS VSS VDD VDD _02531_ sky130_fd_sc_hd__o21ai_0
X_18336_ network.neuron_in227.counter\[1\] network.neuron_in227.counter\[0\]
+ _00930_ VSS VSS VDD VDD _06373_ sky130_fd_sc_hd__o21bai_1
X_18337_ _07164_ _06373_ network.neuron_in227.counter\[3\]
+ VSS VSS VDD VDD _06374_ sky130_fd_sc_hd__a21oi_1
X_18338_ _07164_ network.neuron_in227.counter\[3\] _00929_
+ _00928_ _06374_ VSS VSS VDD VDD _06375_ sky130_fd_sc_hd__a41o_1
X_18339_ net372 _07214_ network.in_period\[227\]\[3\] VSS
+ VSS VDD VDD _06376_ sky130_fd_sc_hd__a21oi_1
X_18340_ net372 _06375_ _06376_ VSS VSS VDD VDD _02974_ sky130_fd_sc_hd__a21oi_1
X_18341_ network.neuron_in118.counter\[2\] VSS VSS VDD VDD
+ _06377_ sky130_fd_sc_hd__inv_1
X_18342_ network.neuron_in118.counter\[3\] network.in_period\[118\]\[2\]
+ net356 _00108_ VSS VSS VDD VDD _06378_ sky130_fd_sc_hd__o22ai_1
X_18343_ network.neuron_in118.counter\[2\] _00108_ net386
+ VSS VSS VDD VDD _06379_ sky130_fd_sc_hd__nand3_1
X_18344_ network.in_period\[118\]\[2\] net386 _06379_ VSS
+ VSS VDD VDD _06380_ sky130_fd_sc_hd__o21ai_0
X_18345_ _06377_ _06378_ _06380_ VSS VSS VDD VDD _02537_ sky130_fd_sc_hd__a21oi_1
X_18346_ net604 _05679_ VSS VSS VDD VDD _06381_ sky130_fd_sc_hd__nand2_1
X_18347_ _00109_ _05679_ _06381_ VSS VSS VDD VDD _02536_ sky130_fd_sc_hd__o21ai_0
X_18348_ net292 _09289_ _09274_ _09547_ VSS VSS VDD VDD _06382_
+ sky130_fd_sc_hd__nand4_1
X_18349_ network.in_spk10_06 network.in_spk11_06 _06382_ VSS
+ VSS VDD VDD _06383_ sky130_fd_sc_hd__or3_1
X_18350_ network.in_spk12_06 network.in_spk13_06 network.in_spk14_06
+ _06383_ net720 VSS VSS VDD VDD _06384_ sky130_fd_sc_hd__o41ai_1
X_18351_ _04815_ _06384_ net355 VSS VSS VDD VDD _02049_ sky130_fd_sc_hd__a21oi_1
X_18352_ network.neuron_in228.counter\[1\] network.neuron_in228.counter\[0\]
+ _01020_ VSS VSS VDD VDD _06385_ sky130_fd_sc_hd__o21bai_1
X_18353_ _07122_ _06385_ network.neuron_in228.counter\[3\]
+ VSS VSS VDD VDD _06386_ sky130_fd_sc_hd__a21oi_1
X_18354_ _07122_ network.neuron_in228.counter\[3\] _01019_
+ _01018_ _06386_ VSS VSS VDD VDD _06387_ sky130_fd_sc_hd__a41o_1
X_18355_ net388 _07121_ net504 VSS VSS VDD VDD _06388_ sky130_fd_sc_hd__a21oi_1
X_18356_ net388 _06387_ _06388_ VSS VSS VDD VDD _02978_ sky130_fd_sc_hd__a21oi_1
X_18357_ network.in_period\[119\]\[1\] _05683_ VSS VSS VDD
+ VDD _06389_ sky130_fd_sc_hd__nand2_1
X_18358_ _00603_ _05683_ _06389_ VSS VSS VDD VDD _02540_ sky130_fd_sc_hd__o21ai_0
X_18359_ net789 _05683_ VSS VSS VDD VDD _06390_ sky130_fd_sc_hd__nand2_1
X_18360_ network.neuron_in119.counter\[0\] _05683_ _06390_
+ VSS VSS VDD VDD _02539_ sky130_fd_sc_hd__o21ai_0
X_18361_ network.neuron_in229.counter\[1\] network.neuron_in229.counter\[0\]
+ _00661_ VSS VSS VDD VDD _06391_ sky130_fd_sc_hd__o21bai_1
X_18362_ _07113_ _06391_ network.neuron_in229.counter\[3\]
+ VSS VSS VDD VDD _06392_ sky130_fd_sc_hd__a21oi_1
X_18363_ _07113_ network.neuron_in229.counter\[3\] _00660_
+ _00659_ _06392_ VSS VSS VDD VDD _06393_ sky130_fd_sc_hd__a41o_1
X_18364_ net381 _07508_ network.in_period\[229\]\[3\] VSS
+ VSS VDD VDD _06394_ sky130_fd_sc_hd__a21oi_1
X_18365_ net381 _06393_ _06394_ VSS VSS VDD VDD _02982_ sky130_fd_sc_hd__a21oi_1
X_18366_ network.in_spk12_06 network.in_spk13_06 _06383_ network.in_spk14_06
+ VSS VSS VDD VDD _06395_ sky130_fd_sc_hd__o31ai_1
X_18367_ _04817_ _06395_ net355 VSS VSS VDD VDD _02050_ sky130_fd_sc_hd__a21oi_1
X_18368_ network.neuron_in230.counter\[0\] network.neuron_in230.counter\[2\]
+ network.neuron_in230.counter\[1\] VSS VSS VDD VDD _06396_
+ sky130_fd_sc_hd__nor3_1
X_18369_ network.neuron_in230.counter\[3\] _06396_ VSS VSS
+ VDD VDD _06397_ sky130_fd_sc_hd__xnor2_1
X_18370_ net471 _07515_ VSS VSS VDD VDD _06398_ sky130_fd_sc_hd__nand2_1
X_18371_ _07515_ _06397_ _06398_ VSS VSS VDD VDD _02986_ sky130_fd_sc_hd__o21ai_0
X_18372_ network.neuron_in231.counter\[0\] network.neuron_in231.counter\[1\]
+ network.neuron_in231.counter\[2\] VSS VSS VDD VDD _06399_
+ sky130_fd_sc_hd__nor3_1
X_18373_ network.neuron_in231.counter\[3\] _06399_ VSS VSS
+ VDD VDD _06400_ sky130_fd_sc_hd__xnor2_1
X_18374_ net566 _07234_ VSS VSS VDD VDD _06401_ sky130_fd_sc_hd__nand2_1
X_18375_ _07234_ _06400_ _06401_ VSS VSS VDD VDD _02990_ sky130_fd_sc_hd__o21ai_0
X_18376_ network.in_spk12_06 _06383_ network.in_spk13_06 VSS
+ VSS VDD VDD _06402_ sky130_fd_sc_hd__o21ai_0
X_18377_ _04819_ _06402_ net355 VSS VSS VDD VDD _02051_ sky130_fd_sc_hd__a21oi_1
X_18378_ network.neuron_in232.counter\[1\] network.neuron_in232.counter\[0\]
+ network.neuron_in232.counter\[2\] net358 VSS VSS VDD VDD _06403_
+ sky130_fd_sc_hd__nor4_1
X_18379_ network.in_period\[232\]\[3\] _06403_ _07409_ VSS
+ VSS VDD VDD _06404_ sky130_fd_sc_hd__mux2i_1
X_18380_ network.neuron_in232.counter\[1\] network.neuron_in232.counter\[0\]
+ network.neuron_in232.counter\[2\] network.neuron_in232.counter\[3\]
+ net387 VSS VSS VDD VDD _06405_ sky130_fd_sc_hd__o311a_1
X_18381_ net703 net358 _06405_ VSS VSS VDD VDD _06406_ sky130_fd_sc_hd__a21oi_1
X_18382_ network.neuron_in232.counter\[3\] _06404_ _06406_
+ VSS VSS VDD VDD _02994_ sky130_fd_sc_hd__o21ai_0
X_18383_ network.neuron_in233.counter\[1\] network.neuron_in233.counter\[0\]
+ _00803_ VSS VSS VDD VDD _06407_ sky130_fd_sc_hd__o21bai_1
X_18384_ _07237_ _06407_ network.neuron_in233.counter\[3\]
+ VSS VSS VDD VDD _06408_ sky130_fd_sc_hd__a21oi_1
X_18385_ _07237_ network.neuron_in233.counter\[3\] _00802_
+ _00801_ _06408_ VSS VSS VDD VDD _06409_ sky130_fd_sc_hd__a41o_1
X_18386_ net372 _07236_ network.in_period\[233\]\[3\] VSS
+ VSS VDD VDD _06410_ sky130_fd_sc_hd__a21oi_1
X_18387_ net372 _06409_ _06410_ VSS VSS VDD VDD _02998_ sky130_fd_sc_hd__a21oi_1
X_18388_ network.in_spk12_06 _06383_ VSS VSS VDD VDD _06411_
+ sky130_fd_sc_hd__nand2_1
X_18389_ _04822_ _06411_ net355 VSS VSS VDD VDD _02052_ sky130_fd_sc_hd__a21oi_1
X_18390_ network.neuron_in234.counter\[1\] network.neuron_in234.counter\[0\]
+ network.neuron_in234.counter\[2\] VSS VSS VDD VDD _06412_
+ sky130_fd_sc_hd__nor3_1
X_18391_ network.neuron_in234.counter\[3\] _06412_ VSS VSS
+ VDD VDD _06413_ sky130_fd_sc_hd__xnor2_1
X_18392_ net474 _07415_ VSS VSS VDD VDD _06414_ sky130_fd_sc_hd__nand2_1
X_18393_ _07415_ _06413_ _06414_ VSS VSS VDD VDD _03002_ sky130_fd_sc_hd__o21ai_0
X_18394_ network.neuron_in120.counter\[3\] network.in_period\[120\]\[2\]
+ net348 _00964_ VSS VSS VDD VDD _06415_ sky130_fd_sc_hd__o22ai_1
X_18395_ network.neuron_in120.counter\[2\] _00964_ net382
+ VSS VSS VDD VDD _06416_ sky130_fd_sc_hd__nand3_1
X_18396_ network.in_period\[120\]\[2\] net382 _06416_ VSS
+ VSS VDD VDD _06417_ sky130_fd_sc_hd__o21ai_0
X_18397_ _04791_ _06415_ _06417_ VSS VSS VDD VDD _02545_ sky130_fd_sc_hd__a21oi_1
Xinput20 net455 VSS VSS VDD VDD net19 sky130_fd_sc_hd__buf_1
X_18399_ network.neuron_in235.counter\[1\] network.neuron_in235.counter\[0\]
+ _00319_ VSS VSS VDD VDD _06419_ sky130_fd_sc_hd__o21bai_1
X_18400_ _07418_ _06419_ network.neuron_in235.counter\[3\]
+ VSS VSS VDD VDD _06420_ sky130_fd_sc_hd__a21oi_1
X_18401_ _07418_ network.neuron_in235.counter\[3\] _00318_
+ _00317_ _06420_ VSS VSS VDD VDD _06421_ sky130_fd_sc_hd__a41o_1
X_18402_ net390 _07417_ net464 VSS VSS VDD VDD _06422_ sky130_fd_sc_hd__a21oi_1
X_18403_ net390 _06421_ _06422_ VSS VSS VDD VDD _03006_ sky130_fd_sc_hd__a21oi_1
X_18404_ network.in_spk10_06 _06382_ network.in_spk11_06 VSS
+ VSS VDD VDD _06423_ sky130_fd_sc_hd__o21ai_0
X_18405_ _04824_ _06423_ net355 VSS VSS VDD VDD _02053_ sky130_fd_sc_hd__a21oi_1
X_18406_ network.neuron_in236.counter\[0\] network.neuron_in236.counter\[1\]
+ _00371_ VSS VSS VDD VDD _06424_ sky130_fd_sc_hd__o21bai_1
X_18407_ _07504_ _06424_ network.neuron_in236.counter\[3\]
+ VSS VSS VDD VDD _06425_ sky130_fd_sc_hd__a21oi_1
X_18408_ _07504_ _00369_ _00370_ network.neuron_in236.counter\[3\]
+ _06425_ VSS VSS VDD VDD _06426_ sky130_fd_sc_hd__a41o_1
X_18409_ net388 _07503_ net505 VSS VSS VDD VDD _06427_ sky130_fd_sc_hd__a21oi_1
X_18410_ net388 _06426_ _06427_ VSS VSS VDD VDD _03010_ sky130_fd_sc_hd__a21oi_1
X_18411_ net382 _04792_ VSS VSS VDD VDD _06428_ sky130_fd_sc_hd__nand2_1
X_18412_ network.in_period\[120\]\[1\] _06428_ VSS VSS VDD
+ VDD _06429_ sky130_fd_sc_hd__nand2_1
X_18413_ _00965_ _06428_ _06429_ VSS VSS VDD VDD _02544_ sky130_fd_sc_hd__o21ai_0
X_18414_ network.in_period\[120\]\[0\] _06428_ VSS VSS VDD
+ VDD _06430_ sky130_fd_sc_hd__nand2_1
X_18415_ network.neuron_in120.counter\[0\] _06428_ _06430_
+ VSS VSS VDD VDD _02543_ sky130_fd_sc_hd__o21ai_0
X_18416_ network.neuron_in237.counter\[0\] network.neuron_in237.counter\[1\]
+ _00610_ VSS VSS VDD VDD _06431_ sky130_fd_sc_hd__o21bai_1
X_18417_ _07637_ _06431_ network.neuron_in237.counter\[3\]
+ VSS VSS VDD VDD _06432_ sky130_fd_sc_hd__a21oi_1
X_18418_ _07637_ network.neuron_in237.counter\[3\] _00608_
+ _00609_ _06432_ VSS VSS VDD VDD _06433_ sky130_fd_sc_hd__a41o_1
X_18419_ net388 _07636_ net493 VSS VSS VDD VDD _06434_ sky130_fd_sc_hd__a21oi_1
X_18420_ net388 _06433_ _06434_ VSS VSS VDD VDD _03014_ sky130_fd_sc_hd__a21oi_1
X_18421_ network.in_spk10_06 _06382_ VSS VSS VDD VDD _06435_
+ sky130_fd_sc_hd__nand2_1
X_18422_ _04827_ _06435_ net355 VSS VSS VDD VDD _02054_ sky130_fd_sc_hd__a21oi_1
X_18423_ network.neuron_in238.counter\[1\] network.neuron_in238.counter\[0\]
+ _00926_ VSS VSS VDD VDD _06436_ sky130_fd_sc_hd__o21bai_1
X_18424_ _07642_ _06436_ network.neuron_in238.counter\[3\]
+ VSS VSS VDD VDD _06437_ sky130_fd_sc_hd__a21oi_1
X_18425_ _07642_ network.neuron_in238.counter\[3\] _00925_
+ _00924_ _06437_ VSS VSS VDD VDD _06438_ sky130_fd_sc_hd__a41o_1
X_18426_ net390 _07641_ net463 VSS VSS VDD VDD _06439_ sky130_fd_sc_hd__a21oi_1
X_18427_ net390 _06438_ _06439_ VSS VSS VDD VDD _03018_ sky130_fd_sc_hd__a21oi_1
X_18428_ network.neuron_in239.counter\[1\] network.neuron_in239.counter\[2\]
+ network.neuron_in239.counter\[0\] net363 VSS VSS VDD VDD _06440_
+ sky130_fd_sc_hd__nor4_1
X_18429_ network.in_period\[239\]\[3\] _06440_ _07647_ VSS
+ VSS VDD VDD _06441_ sky130_fd_sc_hd__mux2i_1
X_18430_ network.neuron_in239.counter\[1\] network.neuron_in239.counter\[2\]
+ network.neuron_in239.counter\[0\] net390 network.neuron_in239.counter\[3\]
+ VSS VSS VDD VDD _06442_ sky130_fd_sc_hd__o311a_1
X_18431_ net481 net363 _06442_ VSS VSS VDD VDD _06443_ sky130_fd_sc_hd__a21oi_1
X_18432_ network.neuron_in239.counter\[3\] _06441_ _06443_
+ VSS VSS VDD VDD _03022_ sky130_fd_sc_hd__o21ai_0
X_18433_ network.neuron_in121.counter\[2\] net386 VSS VSS
+ VDD VDD _06444_ sky130_fd_sc_hd__nand2_1
X_18434_ network.neuron_in121.counter\[3\] network.in_period\[121\]\[2\]
+ _06444_ VSS VSS VDD VDD _06445_ sky130_fd_sc_hd__o21ai_0
X_18435_ _00295_ network.neuron_in121.counter\[2\] net356
+ VSS VSS VDD VDD _06446_ sky130_fd_sc_hd__or3_1
X_18436_ network.in_period\[121\]\[2\] net386 _06446_ VSS
+ VSS VDD VDD _06447_ sky130_fd_sc_hd__o21ai_0
X_18437_ _00295_ _06445_ _06447_ VSS VSS VDD VDD _02549_ sky130_fd_sc_hd__a21oi_1
X_18438_ network.in_period\[121\]\[1\] _05692_ VSS VSS VDD
+ VDD _06448_ sky130_fd_sc_hd__nand2_1
X_18439_ _00296_ _05692_ _06448_ VSS VSS VDD VDD _02548_ sky130_fd_sc_hd__o21ai_0
X_18440_ _09542_ _09546_ network.in_spk09_06 VSS VSS VDD VDD
+ _06449_ sky130_fd_sc_hd__o21ai_0
X_18441_ _04831_ _06449_ net355 VSS VSS VDD VDD _02055_ sky130_fd_sc_hd__a21oi_1
X_18442_ network.in_period\[121\]\[0\] _05692_ VSS VSS VDD
+ VDD _06450_ sky130_fd_sc_hd__nand2_1
X_18443_ network.neuron_in121.counter\[0\] _05692_ _06450_
+ VSS VSS VDD VDD _02547_ sky130_fd_sc_hd__o21ai_0
X_18444_ network.neuron_in240.counter\[1\] network.neuron_in240.counter\[2\]
+ network.neuron_in240.counter\[0\] net361 VSS VSS VDD VDD _06451_
+ sky130_fd_sc_hd__nor4_1
X_18445_ network.in_period\[240\]\[3\] _06451_ _07652_ VSS
+ VSS VDD VDD _06452_ sky130_fd_sc_hd__mux2i_1
X_18446_ network.neuron_in240.counter\[1\] network.neuron_in240.counter\[2\]
+ network.neuron_in240.counter\[0\] net379 network.neuron_in240.counter\[3\]
+ VSS VSS VDD VDD _06453_ sky130_fd_sc_hd__o311a_1
X_18447_ network.in_period\[240\]\[3\] net361 _06453_ VSS
+ VSS VDD VDD _06454_ sky130_fd_sc_hd__a21oi_1
X_18448_ network.neuron_in240.counter\[3\] _06452_ _06454_
+ VSS VSS VDD VDD _03026_ sky130_fd_sc_hd__o21ai_0
X_18449_ network.neuron_in241.counter\[1\] network.neuron_in241.counter\[0\]
+ _00543_ VSS VSS VDD VDD _06455_ sky130_fd_sc_hd__o21bai_1
X_18450_ _07632_ _06455_ network.neuron_in241.counter\[3\]
+ VSS VSS VDD VDD _06456_ sky130_fd_sc_hd__a21oi_1
X_18451_ _07632_ _00542_ network.neuron_in241.counter\[3\]
+ _00541_ _06456_ VSS VSS VDD VDD _06457_ sky130_fd_sc_hd__a41o_1
X_18452_ net381 _07697_ network.in_period\[241\]\[3\] VSS
+ VSS VDD VDD _06458_ sky130_fd_sc_hd__a21oi_1
X_18453_ net381 _06457_ _06458_ VSS VSS VDD VDD _03030_ sky130_fd_sc_hd__a21oi_1
X_18454_ _09315_ _09542_ network.in_spk08_06 VSS VSS VDD VDD
+ _06459_ sky130_fd_sc_hd__o21ai_0
X_18455_ _04834_ _06459_ net355 VSS VSS VDD VDD _02056_ sky130_fd_sc_hd__a21oi_1
X_18456_ network.neuron_in242.counter\[1\] network.neuron_in242.counter\[0\]
+ VSS VSS VDD VDD _06460_ sky130_fd_sc_hd__nor2_1
X_18457_ _00379_ _06460_ VSS VSS VDD VDD _06461_ sky130_fd_sc_hd__nor2_1
X_18458_ network.neuron_in242.counter\[2\] _06461_ VSS VSS
+ VDD VDD _06462_ sky130_fd_sc_hd__nor2_1
X_18459_ network.neuron_in242.counter\[2\] network.neuron_in242.counter\[3\]
+ _06460_ VSS VSS VDD VDD _06463_ sky130_fd_sc_hd__nand3b_1
X_18460_ network.neuron_in242.counter\[3\] _06462_ _06463_
+ VSS VSS VDD VDD _06464_ sky130_fd_sc_hd__o21ai_0
X_18461_ net381 _07702_ network.in_period\[242\]\[3\] VSS
+ VSS VDD VDD _06465_ sky130_fd_sc_hd__a21oi_1
X_18462_ net381 _06464_ _06465_ VSS VSS VDD VDD _03034_ sky130_fd_sc_hd__a21oi_1
X_18463_ net386 _04785_ VSS VSS VDD VDD _06466_ sky130_fd_sc_hd__nand2_1
X_18464_ net715 _06466_ VSS VSS VDD VDD _06467_ sky130_fd_sc_hd__nand2_1
X_18465_ _00208_ _06466_ _06467_ VSS VSS VDD VDD _02556_ sky130_fd_sc_hd__o21ai_0
X_18466_ network.neuron_in122.counter\[2\] net383 VSS VSS
+ VDD VDD _06468_ sky130_fd_sc_hd__nand2_1
X_18467_ network.neuron_in122.counter\[3\] network.in_period\[122\]\[2\]
+ _06468_ VSS VSS VDD VDD _06469_ sky130_fd_sc_hd__o21ai_0
X_18468_ _01060_ network.neuron_in122.counter\[2\] net348
+ VSS VSS VDD VDD _06470_ sky130_fd_sc_hd__or3_1
X_18469_ network.in_period\[122\]\[2\] net383 _06470_ VSS
+ VSS VDD VDD _06471_ sky130_fd_sc_hd__o21ai_0
X_18470_ _01060_ _06469_ _06471_ VSS VSS VDD VDD _02553_ sky130_fd_sc_hd__a21oi_1
X_18471_ network.neuron_in243.counter\[2\] VSS VSS VDD VDD
+ _06472_ sky130_fd_sc_hd__inv_1
X_18472_ _00912_ _06472_ _00911_ net380 VSS VSS VDD VDD _06473_
+ sky130_fd_sc_hd__nand4_1
X_18473_ _06472_ _00913_ _06473_ VSS VSS VDD VDD _06474_ sky130_fd_sc_hd__a21oi_1
X_18474_ _06472_ _00913_ network.in_period\[243\]\[3\] _06474_
+ VSS VSS VDD VDD _06475_ sky130_fd_sc_hd__a31oi_1
X_18475_ network.neuron_in243.counter\[1\] network.neuron_in243.counter\[2\]
+ network.neuron_in243.counter\[0\] net380 network.neuron_in243.counter\[3\]
+ VSS VSS VDD VDD _06476_ sky130_fd_sc_hd__o311a_1
X_18476_ network.in_period\[243\]\[3\] net363 _06476_ VSS
+ VSS VDD VDD _06477_ sky130_fd_sc_hd__a21oi_1
X_18477_ network.neuron_in243.counter\[3\] _06475_ _06477_
+ VSS VSS VDD VDD _03038_ sky130_fd_sc_hd__o21ai_0
X_18478_ network.in_period\[122\]\[1\] _05697_ VSS VSS VDD
+ VDD _06478_ sky130_fd_sc_hd__nand2_1
X_18479_ _01061_ _05697_ _06478_ VSS VSS VDD VDD _02552_ sky130_fd_sc_hd__o21ai_0
X_18480_ network.in_period\[122\]\[0\] _05697_ VSS VSS VDD
+ VDD _06479_ sky130_fd_sc_hd__nand2_1
X_18481_ network.neuron_in122.counter\[0\] _05697_ _06479_
+ VSS VSS VDD VDD _02551_ sky130_fd_sc_hd__o21ai_0
X_18482_ _09313_ _03364_ VSS VSS VDD VDD _06480_ sky130_fd_sc_hd__nand2_1
X_18483_ _09542_ _06480_ network.in_spk07_06 VSS VSS VDD VDD
+ _06481_ sky130_fd_sc_hd__o21ai_0
X_18484_ _04837_ _06481_ net349 VSS VSS VDD VDD _02057_ sky130_fd_sc_hd__a21oi_1
Xinput19 net449 VSS VSS VDD VDD net18 sky130_fd_sc_hd__buf_2
X_18486_ network.neuron_in123.counter\[3\] network.in_period\[123\]\[2\]
+ net357 _00207_ VSS VSS VDD VDD _06483_ sky130_fd_sc_hd__o22ai_1
X_18487_ network.neuron_in123.counter\[2\] _00207_ net386
+ VSS VSS VDD VDD _06484_ sky130_fd_sc_hd__nand3_1
X_18488_ network.in_period\[123\]\[2\] net386 _06484_ VSS
+ VSS VDD VDD _06485_ sky130_fd_sc_hd__o21ai_0
X_18489_ _04783_ _06483_ _06485_ VSS VSS VDD VDD _02557_ sky130_fd_sc_hd__a21oi_1
X_18490_ network.neuron_in244.counter\[1\] network.neuron_in244.counter\[0\]
+ _01004_ VSS VSS VDD VDD _06486_ sky130_fd_sc_hd__o21bai_1
X_18491_ _07688_ _06486_ network.neuron_in244.counter\[3\]
+ VSS VSS VDD VDD _06487_ sky130_fd_sc_hd__a21oi_1
X_18492_ _07688_ _01003_ _01002_ network.neuron_in244.counter\[3\]
+ _06487_ VSS VSS VDD VDD _06488_ sky130_fd_sc_hd__a41o_1
X_18493_ net388 _07832_ network.in_period\[244\]\[3\] VSS
+ VSS VDD VDD _06489_ sky130_fd_sc_hd__a21oi_1
X_18494_ net388 _06488_ _06489_ VSS VSS VDD VDD _03042_ sky130_fd_sc_hd__a21oi_1
X_18495_ network.neuron_in245.counter\[0\] network.neuron_in245.counter\[1\]
+ _00697_ VSS VSS VDD VDD _06490_ sky130_fd_sc_hd__o21bai_1
X_18496_ _07692_ _06490_ network.neuron_in245.counter\[3\]
+ VSS VSS VDD VDD _06491_ sky130_fd_sc_hd__a21oi_1
X_18497_ _07692_ _00695_ _00696_ network.neuron_in245.counter\[3\]
+ _06491_ VSS VSS VDD VDD _06492_ sky130_fd_sc_hd__a41o_1
X_18498_ net379 _08114_ network.in_period\[245\]\[3\] VSS
+ VSS VDD VDD _06493_ sky130_fd_sc_hd__a21oi_1
X_18499_ net379 _06492_ _06493_ VSS VSS VDD VDD _03046_ sky130_fd_sc_hd__a21oi_1
X_18500_ net292 _09289_ _09313_ _09274_ VSS VSS VDD VDD _06494_
+ sky130_fd_sc_hd__nand4_1
X_18501_ network.in_spk04_06 network.in_spk05_06 _06494_ network.in_spk06_06
+ VSS VSS VDD VDD _06495_ sky130_fd_sc_hd__o31ai_1
X_18502_ _04840_ _06495_ net349 VSS VSS VDD VDD _02058_ sky130_fd_sc_hd__a21oi_1
X_18503_ network.neuron_in246.counter\[1\] network.neuron_in246.counter\[2\]
+ network.neuron_in246.counter\[0\] VSS VSS VDD VDD _06496_
+ sky130_fd_sc_hd__nor3_1
X_18504_ network.neuron_in246.counter\[3\] _06496_ VSS VSS
+ VDD VDD _06497_ sky130_fd_sc_hd__xnor2_1
X_18505_ net600 _08131_ VSS VSS VDD VDD _06498_ sky130_fd_sc_hd__nand2_1
X_18506_ _08131_ _06497_ _06498_ VSS VSS VDD VDD _03050_ sky130_fd_sc_hd__o21ai_0
X_18507_ network.in_period\[123\]\[0\] _06466_ VSS VSS VDD
+ VDD _06499_ sky130_fd_sc_hd__nand2_1
X_18508_ network.neuron_in123.counter\[0\] _06466_ _06499_
+ VSS VSS VDD VDD _02555_ sky130_fd_sc_hd__o21ai_0
X_18509_ network.neuron_in124.counter\[3\] network.in_period\[124\]\[2\]
+ net348 _00367_ VSS VSS VDD VDD _06500_ sky130_fd_sc_hd__o22ai_1
X_18510_ network.neuron_in124.counter\[2\] _00367_ net385
+ VSS VSS VDD VDD _06501_ sky130_fd_sc_hd__nand3_1
X_18511_ network.in_period\[124\]\[2\] net385 _06501_ VSS
+ VSS VDD VDD _06502_ sky130_fd_sc_hd__o21ai_0
X_18512_ _04781_ _06500_ _06502_ VSS VSS VDD VDD _02561_ sky130_fd_sc_hd__a21oi_1
X_18513_ network.neuron_in247.counter\[0\] network.neuron_in247.counter\[1\]
+ VSS VSS VDD VDD _06503_ sky130_fd_sc_hd__nor2_1
X_18514_ _00893_ _06503_ VSS VSS VDD VDD _06504_ sky130_fd_sc_hd__nor2_1
X_18515_ network.neuron_in247.counter\[2\] _06504_ VSS VSS
+ VDD VDD _06505_ sky130_fd_sc_hd__nor2_1
X_18516_ network.neuron_in247.counter\[2\] network.neuron_in247.counter\[3\]
+ _06503_ VSS VSS VDD VDD _06506_ sky130_fd_sc_hd__nand3b_1
X_18517_ network.neuron_in247.counter\[3\] _06505_ _06506_
+ VSS VSS VDD VDD _06507_ sky130_fd_sc_hd__o21ai_0
X_18518_ net380 _08133_ network.in_period\[247\]\[3\] VSS
+ VSS VDD VDD _06508_ sky130_fd_sc_hd__a21oi_1
X_18519_ net380 _06507_ _06508_ VSS VSS VDD VDD _03054_ sky130_fd_sc_hd__a21oi_1
X_18520_ net385 _04782_ VSS VSS VDD VDD _06509_ sky130_fd_sc_hd__nand2_1
X_18521_ net781 _06509_ VSS VSS VDD VDD _06510_ sky130_fd_sc_hd__nand2_1
X_18522_ _00368_ _06509_ _06510_ VSS VSS VDD VDD _02560_ sky130_fd_sc_hd__o21ai_0
X_18523_ network.in_period\[124\]\[0\] _06509_ VSS VSS VDD
+ VDD _06511_ sky130_fd_sc_hd__nand2_1
X_18524_ network.neuron_in124.counter\[0\] _06509_ _06511_
+ VSS VSS VDD VDD _02559_ sky130_fd_sc_hd__o21ai_0
X_18525_ network.in_spk04_06 _06494_ network.in_spk05_06 VSS
+ VSS VDD VDD _06512_ sky130_fd_sc_hd__o21ai_0
X_18526_ _04842_ _06512_ net349 VSS VSS VDD VDD _02059_ sky130_fd_sc_hd__a21oi_1
X_18527_ network.neuron_in125.counter\[3\] network.in_period\[125\]\[2\]
+ net348 _00486_ VSS VSS VDD VDD _06513_ sky130_fd_sc_hd__o22ai_1
X_18528_ network.neuron_in125.counter\[2\] _00486_ net385
+ VSS VSS VDD VDD _06514_ sky130_fd_sc_hd__nand3_1
X_18529_ network.in_period\[125\]\[2\] net385 _06514_ VSS
+ VSS VDD VDD _06515_ sky130_fd_sc_hd__o21ai_0
X_18530_ _04777_ _06513_ _06515_ VSS VSS VDD VDD _02565_ sky130_fd_sc_hd__a21oi_1
X_18531_ network.neuron_in248.counter\[1\] network.neuron_in248.counter\[0\]
+ network.neuron_in248.counter\[2\] net359 VSS VSS VDD VDD _06516_
+ sky130_fd_sc_hd__nor4_1
X_18532_ network.in_period\[248\]\[3\] _06516_ _08137_ VSS
+ VSS VDD VDD _06517_ sky130_fd_sc_hd__mux2i_1
X_18533_ network.neuron_in248.counter\[1\] network.neuron_in248.counter\[0\]
+ network.neuron_in248.counter\[2\] network.neuron_in248.counter\[3\]
+ net388 VSS VSS VDD VDD _06518_ sky130_fd_sc_hd__o311a_1
X_18534_ network.in_period\[248\]\[3\] net359 _06518_ VSS
+ VSS VDD VDD _06519_ sky130_fd_sc_hd__a21oi_1
X_18535_ network.neuron_in248.counter\[3\] _06517_ _06519_
+ VSS VSS VDD VDD _03058_ sky130_fd_sc_hd__o21ai_0
X_18536_ network.in_period\[125\]\[1\] _05711_ VSS VSS VDD
+ VDD _06520_ sky130_fd_sc_hd__nand2_1
X_18537_ _00487_ _05711_ _06520_ VSS VSS VDD VDD _02564_ sky130_fd_sc_hd__o21ai_0
X_18538_ network.neuron_in249.counter\[0\] network.neuron_in249.counter\[1\]
+ network.neuron_in249.counter\[2\] VSS VSS VDD VDD _06521_
+ sky130_fd_sc_hd__nor3_1
X_18539_ network.neuron_in249.counter\[3\] _06521_ VSS VSS
+ VDD VDD _06522_ sky130_fd_sc_hd__xnor2_1
X_18540_ network.in_period\[249\]\[3\] _08143_ VSS VSS VDD
+ VDD _06523_ sky130_fd_sc_hd__nand2_1
X_18541_ _08143_ _06522_ _06523_ VSS VSS VDD VDD _03062_ sky130_fd_sc_hd__o21ai_0
X_18542_ network.in_spk04_06 _06494_ VSS VSS VDD VDD _06524_
+ sky130_fd_sc_hd__nand2_1
X_18543_ _04845_ _06524_ net349 VSS VSS VDD VDD _02060_ sky130_fd_sc_hd__a21oi_1
X_18544_ network.neuron_in250.counter\[1\] network.neuron_in250.counter\[0\]
+ _00905_ VSS VSS VDD VDD _06525_ sky130_fd_sc_hd__o21bai_1
X_18545_ _08125_ _06525_ network.neuron_in250.counter\[3\]
+ VSS VSS VDD VDD _06526_ sky130_fd_sc_hd__a21oi_1
X_18546_ _08125_ network.neuron_in250.counter\[3\] _00904_
+ _00903_ _06526_ VSS VSS VDD VDD _06527_ sky130_fd_sc_hd__a41o_1
X_18547_ net380 _08289_ network.in_period\[250\]\[3\] VSS
+ VSS VDD VDD _06528_ sky130_fd_sc_hd__a21oi_1
X_18548_ net380 _06527_ _06528_ VSS VSS VDD VDD _03066_ sky130_fd_sc_hd__a21oi_1
X_18549_ network.neuron_in251.counter\[1\] network.neuron_in251.counter\[0\]
+ network.neuron_in251.counter\[2\] VSS VSS VDD VDD _06529_
+ sky130_fd_sc_hd__nor3_1
X_18550_ network.neuron_in251.counter\[3\] _06529_ VSS VSS
+ VDD VDD _06530_ sky130_fd_sc_hd__xnor2_1
X_18551_ net601 _08296_ VSS VSS VDD VDD _06531_ sky130_fd_sc_hd__nand2_1
X_18552_ _08296_ _06530_ _06531_ VSS VSS VDD VDD _03070_ sky130_fd_sc_hd__o21ai_0
X_18553_ network.in_period\[125\]\[0\] _05711_ VSS VSS VDD
+ VDD _06532_ sky130_fd_sc_hd__nand2_1
X_18554_ network.neuron_in125.counter\[0\] _05711_ _06532_
+ VSS VSS VDD VDD _02563_ sky130_fd_sc_hd__o21ai_0
X_18555_ network.neuron_in126.counter\[3\] network.in_period\[126\]\[2\]
+ net348 _00725_ VSS VSS VDD VDD _06533_ sky130_fd_sc_hd__o22ai_1
X_18556_ network.neuron_in126.counter\[2\] _00725_ net385
+ VSS VSS VDD VDD _06534_ sky130_fd_sc_hd__nand3_1
X_18557_ network.in_period\[126\]\[2\] net385 _06534_ VSS
+ VSS VDD VDD _06535_ sky130_fd_sc_hd__o21ai_0
X_18558_ _04773_ _06533_ _06535_ VSS VSS VDD VDD _02569_ sky130_fd_sc_hd__a21oi_1
X_18559_ network.in_spk02_06 network.in_spk00_06 network.in_spk01_06
+ _09542_ network.in_spk03_06 VSS VSS VDD VDD _06536_ sky130_fd_sc_hd__o41ai_1
X_18560_ _04848_ _06536_ net349 VSS VSS VDD VDD _02061_ sky130_fd_sc_hd__a21oi_1
X_18561_ net385 _04775_ VSS VSS VDD VDD _06537_ sky130_fd_sc_hd__nand2_1
X_18562_ net710 _06537_ VSS VSS VDD VDD _06538_ sky130_fd_sc_hd__nand2_1
X_18563_ _00726_ _06537_ _06538_ VSS VSS VDD VDD _02568_ sky130_fd_sc_hd__o21ai_0
X_18564_ network.neuron_in252.counter\[1\] network.neuron_in252.counter\[2\]
+ network.neuron_in252.counter\[0\] net362 VSS VSS VDD VDD _06539_
+ sky130_fd_sc_hd__nor4_1
X_18565_ network.in_period\[252\]\[3\] _06539_ _08300_ VSS
+ VSS VDD VDD _06540_ sky130_fd_sc_hd__mux2i_1
X_18566_ network.neuron_in252.counter\[1\] network.neuron_in252.counter\[2\]
+ network.neuron_in252.counter\[0\] network.neuron_in252.counter\[3\]
+ net379 VSS VSS VDD VDD _06541_ sky130_fd_sc_hd__o311a_1
X_18567_ network.in_period\[252\]\[3\] net362 _06541_ VSS
+ VSS VDD VDD _06542_ sky130_fd_sc_hd__a21oi_1
X_18568_ network.neuron_in252.counter\[3\] _06540_ _06542_
+ VSS VSS VDD VDD _03074_ sky130_fd_sc_hd__o21ai_0
X_18569_ net727 _06537_ VSS VSS VDD VDD _06543_ sky130_fd_sc_hd__nand2_1
X_18570_ network.neuron_in126.counter\[0\] _06537_ _06543_
+ VSS VSS VDD VDD _02567_ sky130_fd_sc_hd__o21ai_0
X_18571_ network.neuron_in127.counter\[3\] network.in_period\[127\]\[2\]
+ net348 _01107_ VSS VSS VDD VDD _06544_ sky130_fd_sc_hd__o22ai_1
X_18572_ network.neuron_in127.counter\[2\] _01107_ net385
+ VSS VSS VDD VDD _06545_ sky130_fd_sc_hd__nand3_1
X_18573_ network.in_period\[127\]\[2\] net385 _06545_ VSS
+ VSS VDD VDD _06546_ sky130_fd_sc_hd__o21ai_0
X_18574_ _04770_ _06544_ _06546_ VSS VSS VDD VDD _02573_ sky130_fd_sc_hd__a21oi_1
X_18575_ net385 _04772_ VSS VSS VDD VDD _06547_ sky130_fd_sc_hd__nand2_1
X_18576_ net733 _06547_ VSS VSS VDD VDD _06548_ sky130_fd_sc_hd__nand2_1
X_18577_ _01108_ _06547_ _06548_ VSS VSS VDD VDD _02572_ sky130_fd_sc_hd__o21ai_0
X_18578_ network.neuron_in253.counter\[0\] network.neuron_in253.counter\[2\]
+ network.neuron_in253.counter\[1\] VSS VSS VDD VDD _06549_
+ sky130_fd_sc_hd__nor3_1
X_18579_ network.neuron_in253.counter\[3\] _06549_ VSS VSS
+ VDD VDD _06550_ sky130_fd_sc_hd__xnor2_1
X_18580_ net742 _08306_ VSS VSS VDD VDD _06551_ sky130_fd_sc_hd__nand2_1
X_18581_ _08306_ _06550_ _06551_ VSS VSS VDD VDD _03078_ sky130_fd_sc_hd__o21ai_0
X_18582_ net717 _06547_ VSS VSS VDD VDD _06552_ sky130_fd_sc_hd__nand2_1
X_18583_ network.neuron_in127.counter\[0\] _06547_ _06552_
+ VSS VSS VDD VDD _02571_ sky130_fd_sc_hd__o21ai_0
X_18584_ network.in_spk00_06 network.in_spk01_06 _09542_ network.in_spk02_06
+ VSS VSS VDD VDD _06553_ sky130_fd_sc_hd__o31ai_1
X_18585_ _04851_ _06553_ net349 VSS VSS VDD VDD _02062_ sky130_fd_sc_hd__a21oi_1
X_18586_ network.neuron_in254.counter\[0\] network.neuron_in254.counter\[2\]
+ network.neuron_in254.counter\[1\] VSS VSS VDD VDD _06554_
+ sky130_fd_sc_hd__nor3_1
X_18587_ network.neuron_in254.counter\[3\] _06554_ VSS VSS
+ VDD VDD _06555_ sky130_fd_sc_hd__xnor2_1
X_18588_ network.in_period\[254\]\[3\] _08311_ VSS VSS VDD
+ VDD _06556_ sky130_fd_sc_hd__nand2_1
X_18589_ _08311_ _06555_ _06556_ VSS VSS VDD VDD _03082_ sky130_fd_sc_hd__o21ai_0
X_18590_ network.neuron_in255.counter\[1\] network.neuron_in255.counter\[0\]
+ network.neuron_in255.counter\[2\] net361 VSS VSS VDD VDD _06557_
+ sky130_fd_sc_hd__nor4_1
X_18591_ network.in_period\[255\]\[3\] _06557_ _08314_ VSS
+ VSS VDD VDD _06558_ sky130_fd_sc_hd__mux2i_1
X_18592_ network.neuron_in255.counter\[1\] network.neuron_in255.counter\[0\]
+ network.neuron_in255.counter\[2\] network.neuron_in255.counter\[3\]
+ net380 VSS VSS VDD VDD _06559_ sky130_fd_sc_hd__o311a_1
X_18593_ network.in_period\[255\]\[3\] net361 _06559_ VSS
+ VSS VDD VDD _06560_ sky130_fd_sc_hd__a21oi_1
X_18594_ network.neuron_in255.counter\[3\] _06558_ _06560_
+ VSS VSS VDD VDD _03086_ sky130_fd_sc_hd__o21ai_0
X_18595_ _04093_ _04179_ VSS VSS VDD VDD _03299_ sky130_fd_sc_hd__nor2_1
X_18596_ net22 net24 net26 icg_net.en VSS VSS VDD VDD icg_root.en
+ sky130_fd_sc_hd__or4_1
X_18597_ net381 _04762_ VSS VSS VDD VDD _06561_ sky130_fd_sc_hd__nand2_1
X_18598_ network.in_period\[153\]\[0\] _06561_ VSS VSS VDD
+ VDD _06562_ sky130_fd_sc_hd__nand2_1
X_18599_ network.neuron_in153.counter\[0\] _06561_ _06562_
+ VSS VSS VDD VDD _02675_ sky130_fd_sc_hd__o21ai_0
X_18600_ net386 _04765_ VSS VSS VDD VDD _06563_ sky130_fd_sc_hd__nand2_1
X_18601_ net729 _06563_ VSS VSS VDD VDD _06564_ sky130_fd_sc_hd__nand2_1
X_18602_ network.neuron_in152.counter\[0\] _06563_ _06564_
+ VSS VSS VDD VDD _02671_ sky130_fd_sc_hd__o21ai_0
X_18603_ net677 _06563_ VSS VSS VDD VDD _06565_ sky130_fd_sc_hd__nand2_1
X_18604_ _00503_ _06563_ _06565_ VSS VSS VDD VDD _02672_ sky130_fd_sc_hd__o21ai_0
X_18605_ network.neuron_in152.counter\[3\] network.in_period\[152\]\[2\]
+ net356 _00502_ VSS VSS VDD VDD _06566_ sky130_fd_sc_hd__o22ai_1
X_18606_ network.neuron_in152.counter\[2\] _00502_ net386
+ VSS VSS VDD VDD _06567_ sky130_fd_sc_hd__nand3_1
X_18607_ network.in_period\[152\]\[2\] net386 _06567_ VSS
+ VSS VDD VDD _06568_ sky130_fd_sc_hd__o21ai_0
X_18608_ _04764_ _06566_ _06568_ VSS VSS VDD VDD _02673_ sky130_fd_sc_hd__a21oi_1
X_18609_ net605 _05861_ VSS VSS VDD VDD _06569_ sky130_fd_sc_hd__nand2_1
X_18610_ network.neuron_in151.counter\[0\] _05861_ _06569_
+ VSS VSS VDD VDD _02667_ sky130_fd_sc_hd__o21ai_0
X_18611_ net589 _05861_ VSS VSS VDD VDD _06570_ sky130_fd_sc_hd__nand2_1
X_18612_ _00507_ _05861_ _06570_ VSS VSS VDD VDD _02668_ sky130_fd_sc_hd__o21ai_0
X_18613_ network.in_period\[160\]\[0\] _06630_ VSS VSS VDD
+ VDD _06571_ sky130_fd_sc_hd__nand2_1
X_18614_ network.neuron_in160.counter\[0\] _06630_ _06571_
+ VSS VSS VDD VDD _02703_ sky130_fd_sc_hd__o21ai_0
X_18615_ network.neuron_in130.counter\[3\] network.in_period\[130\]\[2\]
+ net358 _00460_ VSS VSS VDD VDD _06572_ sky130_fd_sc_hd__o22ai_1
X_18616_ network.neuron_in130.counter\[2\] _00460_ net377
+ VSS VSS VDD VDD _06573_ sky130_fd_sc_hd__nand3_1
X_18617_ network.in_period\[130\]\[2\] net377 _06573_ VSS
+ VSS VDD VDD _06574_ sky130_fd_sc_hd__o21ai_0
X_18618_ _03625_ _06572_ _06574_ VSS VSS VDD VDD _02585_ sky130_fd_sc_hd__a21oi_1
X_18619_ net780 _03627_ VSS VSS VDD VDD _06575_ sky130_fd_sc_hd__nand2_1
X_18620_ _00461_ _03627_ _06575_ VSS VSS VDD VDD _02584_ sky130_fd_sc_hd__o21ai_0
X_18621_ network.neuron_in158.counter\[3\] network.in_period\[158\]\[2\]
+ net358 _00671_ VSS VSS VDD VDD _06576_ sky130_fd_sc_hd__o22ai_1
X_18622_ network.neuron_in158.counter\[2\] _00671_ net381
+ VSS VSS VDD VDD _06577_ sky130_fd_sc_hd__nand3_1
X_18623_ network.in_period\[158\]\[2\] net381 _06577_ VSS
+ VSS VDD VDD _06578_ sky130_fd_sc_hd__o21ai_0
X_18624_ _04757_ _06576_ _06578_ VSS VSS VDD VDD _02697_ sky130_fd_sc_hd__a21oi_1
X_18625_ network.neuron_in157.counter\[2\] VSS VSS VDD VDD
+ _06579_ sky130_fd_sc_hd__inv_1
X_18626_ network.neuron_in157.counter\[3\] network.in_period\[157\]\[2\]
+ net358 _00691_ VSS VSS VDD VDD _06580_ sky130_fd_sc_hd__o22ai_1
X_18627_ network.neuron_in157.counter\[2\] _00691_ net381
+ VSS VSS VDD VDD _06581_ sky130_fd_sc_hd__nand3_1
X_18628_ network.in_period\[157\]\[2\] net381 _06581_ VSS
+ VSS VDD VDD _06582_ sky130_fd_sc_hd__o21ai_0
X_18629_ _06579_ _06580_ _06582_ VSS VSS VDD VDD _02693_ sky130_fd_sc_hd__a21oi_1
X_18630_ net754 _06945_ VSS VSS VDD VDD _06583_ sky130_fd_sc_hd__nand2_1
X_18631_ network.neuron_in155.counter\[0\] _06945_ _06583_
+ VSS VSS VDD VDD _02683_ sky130_fd_sc_hd__o21ai_0
X_18632_ net593 _07830_ VSS VSS VDD VDD _06584_ sky130_fd_sc_hd__nand2_1
X_18633_ network.neuron_in154.counter\[0\] _07830_ _06584_
+ VSS VSS VDD VDD _02679_ sky130_fd_sc_hd__o21ai_0
X_18634_ net365 _04753_ VSS VSS VDD VDD _06585_ sky130_fd_sc_hd__nand2_1
X_18635_ net646 _06585_ VSS VSS VDD VDD _06586_ sky130_fd_sc_hd__nand2_1
X_18636_ _00272_ _06585_ _06586_ VSS VSS VDD VDD _02776_ sky130_fd_sc_hd__o21ai_0
X_18637_ network.neuron_in161.counter\[2\] net379 VSS VSS
+ VDD VDD _06587_ sky130_fd_sc_hd__nand2_1
X_18638_ network.neuron_in161.counter\[3\] network.in_period\[161\]\[2\]
+ _06587_ VSS VSS VDD VDD _06588_ sky130_fd_sc_hd__o21ai_0
X_18639_ _00777_ network.neuron_in161.counter\[2\] net360
+ VSS VSS VDD VDD _06589_ sky130_fd_sc_hd__or3_1
X_18640_ network.in_period\[161\]\[2\] net379 _06589_ VSS
+ VSS VDD VDD _06590_ sky130_fd_sc_hd__o21ai_0
X_18641_ _00777_ _06588_ _06590_ VSS VSS VDD VDD _02709_ sky130_fd_sc_hd__a21oi_1
X_18642_ net381 _04758_ VSS VSS VDD VDD _06591_ sky130_fd_sc_hd__nand2_1
X_18643_ network.in_period\[158\]\[1\] _06591_ VSS VSS VDD
+ VDD _06592_ sky130_fd_sc_hd__nand2_1
X_18644_ _00672_ _06591_ _06592_ VSS VSS VDD VDD _02696_ sky130_fd_sc_hd__o21ai_0
X_18645_ network.neuron_in156.counter\[2\] net381 VSS VSS
+ VDD VDD _06593_ sky130_fd_sc_hd__nand2_1
X_18646_ network.neuron_in156.counter\[3\] network.in_period\[156\]\[2\]
+ _06593_ VSS VSS VDD VDD _06594_ sky130_fd_sc_hd__o21ai_0
X_18647_ _01077_ network.neuron_in156.counter\[2\] net361
+ VSS VSS VDD VDD _06595_ sky130_fd_sc_hd__or3_1
X_18648_ network.in_period\[156\]\[2\] net381 _06595_ VSS
+ VSS VDD VDD _06596_ sky130_fd_sc_hd__o21ai_0
X_18649_ _01077_ _06594_ _06596_ VSS VSS VDD VDD _02689_ sky130_fd_sc_hd__a21oi_1
X_18650_ net622 _06585_ VSS VSS VDD VDD _06597_ sky130_fd_sc_hd__nand2_1
X_18651_ network.neuron_in178.counter\[0\] _06585_ _06597_
+ VSS VSS VDD VDD _02775_ sky130_fd_sc_hd__o21ai_0
X_18652_ network.in_period\[158\]\[0\] _06591_ VSS VSS VDD
+ VDD _06598_ sky130_fd_sc_hd__nand2_1
X_18653_ network.neuron_in158.counter\[0\] _06591_ _06598_
+ VSS VSS VDD VDD _02695_ sky130_fd_sc_hd__o21ai_0
X_18654_ network.neuron_in179.counter\[3\] network.in_period\[179\]\[2\]
+ net363 _00565_ VSS VSS VDD VDD _06599_ sky130_fd_sc_hd__o22ai_1
X_18655_ network.neuron_in179.counter\[2\] _00565_ net365
+ VSS VSS VDD VDD _06600_ sky130_fd_sc_hd__nand3_1
X_18656_ network.in_period\[179\]\[2\] net365 _06600_ VSS
+ VSS VDD VDD _06601_ sky130_fd_sc_hd__o21ai_0
X_18657_ _06715_ _06599_ _06601_ VSS VSS VDD VDD _02781_ sky130_fd_sc_hd__a21oi_1
X_18658_ net680 _06561_ VSS VSS VDD VDD _06602_ sky130_fd_sc_hd__nand2_1
X_18659_ _00495_ _06561_ _06602_ VSS VSS VDD VDD _02676_ sky130_fd_sc_hd__o21ai_0
X_18660_ network.neuron_in153.counter\[3\] network.in_period\[153\]\[2\]
+ net358 _00494_ VSS VSS VDD VDD _06603_ sky130_fd_sc_hd__o22ai_1
X_18661_ network.neuron_in153.counter\[2\] _00494_ net381
+ VSS VSS VDD VDD _06604_ sky130_fd_sc_hd__nand3_1
X_18662_ network.in_period\[153\]\[2\] net381 _06604_ VSS
+ VSS VDD VDD _06605_ sky130_fd_sc_hd__o21ai_0
X_18663_ _04761_ _06603_ _06605_ VSS VSS VDD VDD _02677_ sky130_fd_sc_hd__a21oi_1
X_18664_ network.neuron_in159.counter\[3\] network.in_period\[159\]\[2\]
+ net361 _00639_ VSS VSS VDD VDD _06606_ sky130_fd_sc_hd__o22ai_1
X_18665_ network.neuron_in159.counter\[2\] _00639_ net381
+ VSS VSS VDD VDD _06607_ sky130_fd_sc_hd__nand3_1
X_18666_ network.in_period\[159\]\[2\] net381 _06607_ VSS
+ VSS VDD VDD _06608_ sky130_fd_sc_hd__o21ai_0
X_18667_ _06616_ _06606_ _06608_ VSS VSS VDD VDD _02701_ sky130_fd_sc_hd__a21oi_1
X_18668_ network.neuron_hid5.IF0.membrane_potential\[1\] network.neuron_hid5.IF0.input_current\[1\]
+ _00000_ VSS VSS VDD VDD _00001_ network.neuron_hid5.IF0.add_out\[1\]
+ sky130_fd_sc_hd__fa_1
X_18669_ network.neuron_hid6.IF0.membrane_potential\[1\] network.neuron_hid6.IF0.input_current\[1\]
+ _00002_ VSS VSS VDD VDD _00003_ network.neuron_hid6.IF0.add_out\[1\]
+ sky130_fd_sc_hd__fa_1
X_18670_ network.neuron_hid0.IF0.membrane_potential\[1\] network.neuron_hid0.IF0.input_current\[1\]
+ _00004_ VSS VSS VDD VDD _00005_ network.neuron_hid0.IF0.add_out\[1\]
+ sky130_fd_sc_hd__fa_1
X_18671_ network.neuron_hid7.IF0.membrane_potential\[1\] network.neuron_hid7.IF0.input_current\[1\]
+ _00006_ VSS VSS VDD VDD _00007_ network.neuron_hid7.IF0.add_out\[1\]
+ sky130_fd_sc_hd__fa_1
X_18672_ network.neuron_out1.IF0.membrane_potential\[1\] network.neuron_out1.IF0.input_current\[1\]
+ _00008_ VSS VSS VDD VDD _00009_ _00010_ sky130_fd_sc_hd__fa_1
X_18673_ network.neuron_hid3.IF0.membrane_potential\[1\] network.neuron_hid3.IF0.input_current\[1\]
+ _00011_ VSS VSS VDD VDD _00012_ network.neuron_hid3.IF0.add_out\[1\]
+ sky130_fd_sc_hd__fa_1
X_18674_ network.neuron_out2.IF0.membrane_potential\[1\] network.neuron_out2.IF0.input_current\[1\]
+ _00013_ VSS VSS VDD VDD _00014_ _00015_ sky130_fd_sc_hd__fa_1
X_18675_ network.neuron_hid4.IF0.membrane_potential\[1\] network.neuron_hid4.IF0.input_current\[1\]
+ _00016_ VSS VSS VDD VDD _00017_ network.neuron_hid4.IF0.add_out\[1\]
+ sky130_fd_sc_hd__fa_1
X_18676_ network.neuron_out3.IF0.membrane_potential\[1\] network.neuron_out3.IF0.input_current\[1\]
+ _00018_ VSS VSS VDD VDD _00019_ _00020_ sky130_fd_sc_hd__fa_1
X_18677_ network.neuron_hid2.IF0.membrane_potential\[1\] network.neuron_hid2.IF0.input_current\[1\]
+ _00021_ VSS VSS VDD VDD _00022_ network.neuron_hid2.IF0.add_out\[1\]
+ sky130_fd_sc_hd__fa_1
X_18678_ network.neuron_out5.IF0.membrane_potential\[1\] network.neuron_out5.IF0.input_current\[1\]
+ _00023_ VSS VSS VDD VDD _00024_ _00025_ sky130_fd_sc_hd__fa_1
X_18679_ network.neuron_hid1.IF0.membrane_potential\[1\] network.neuron_hid1.IF0.input_current\[1\]
+ _00026_ VSS VSS VDD VDD _00027_ network.neuron_hid1.IF0.add_out\[1\]
+ sky130_fd_sc_hd__fa_1
X_18680_ network.neuron_out0.IF0.membrane_potential\[1\] network.neuron_out0.IF0.input_current\[1\]
+ _00028_ VSS VSS VDD VDD _00029_ _00030_ sky130_fd_sc_hd__fa_1
X_18681_ network.neuron_out4.IF0.membrane_potential\[1\] network.neuron_out4.IF0.input_current\[1\]
+ _00031_ VSS VSS VDD VDD _00032_ _00033_ sky130_fd_sc_hd__fa_1
X_18682_ _00034_ _00035_ VSS VSS VDD VDD _00036_ _00037_ sky130_fd_sc_hd__ha_1
X_18683_ _00038_ _00039_ VSS VSS VDD VDD _00040_ _00041_ sky130_fd_sc_hd__ha_1
X_18684_ _00042_ _00043_ VSS VSS VDD VDD _00044_ _00045_ sky130_fd_sc_hd__ha_1
X_18685_ network.neuron_out2.IF0.membrane_potential\[4\] network.neuron_out2.IF0.input_current\[4\]
+ VSS VSS VDD VDD _00047_ _00048_ sky130_fd_sc_hd__ha_1
X_18686_ _00049_ _00050_ VSS VSS VDD VDD _00051_ _00052_ sky130_fd_sc_hd__ha_1
X_18687_ _00053_ _00054_ VSS VSS VDD VDD _00055_ _00056_ sky130_fd_sc_hd__ha_1
X_18688_ _00057_ _00058_ VSS VSS VDD VDD _00059_ _00060_ sky130_fd_sc_hd__ha_1
X_18689_ _00061_ _00062_ VSS VSS VDD VDD _00063_ _00064_ sky130_fd_sc_hd__ha_1
X_18690_ network.neuron_hid4.IF0.membrane_potential\[2\] network.neuron_hid4.IF0.input_current\[2\]
+ VSS VSS VDD VDD _00065_ _00066_ sky130_fd_sc_hd__ha_1
X_18691_ network.neuron_hid4.IF0.membrane_potential\[4\] network.neuron_hid4.IF0.input_current\[4\]
+ VSS VSS VDD VDD _00067_ _00068_ sky130_fd_sc_hd__ha_1
X_18692_ _00069_ _00070_ VSS VSS VDD VDD _00071_ _00072_ sky130_fd_sc_hd__ha_1
X_18693_ _00073_ _00074_ VSS VSS VDD VDD _00075_ _00076_ sky130_fd_sc_hd__ha_1
X_18694_ _00077_ _00078_ VSS VSS VDD VDD _00079_ _00080_ sky130_fd_sc_hd__ha_1
X_18695_ _00081_ _00082_ VSS VSS VDD VDD _00083_ _00084_ sky130_fd_sc_hd__ha_1
X_18696_ _00086_ _00087_ VSS VSS VDD VDD _00088_ _00089_ sky130_fd_sc_hd__ha_1
X_18697_ _00090_ _00091_ VSS VSS VDD VDD _00092_ _00093_ sky130_fd_sc_hd__ha_1
X_18698_ _00094_ _00095_ VSS VSS VDD VDD _00096_ _00097_ sky130_fd_sc_hd__ha_1
X_18699_ _00098_ _00099_ VSS VSS VDD VDD _00100_ _00101_ sky130_fd_sc_hd__ha_1
X_18700_ _00102_ _00103_ VSS VSS VDD VDD _00104_ _00105_ sky130_fd_sc_hd__ha_1
X_18701_ _00106_ _00107_ VSS VSS VDD VDD _00108_ _00109_ sky130_fd_sc_hd__ha_1
X_18702_ network.neuron_out5.IF0.membrane_potential\[0\] network.neuron_out5.IF0.input_current\[0\]
+ VSS VSS VDD VDD _00023_ _00110_ sky130_fd_sc_hd__ha_1
X_18703_ _00111_ _00112_ VSS VSS VDD VDD _00113_ _00114_ sky130_fd_sc_hd__ha_1
X_18704_ _00115_ _00116_ VSS VSS VDD VDD _00117_ _00118_ sky130_fd_sc_hd__ha_1
X_18705_ _00119_ _00120_ VSS VSS VDD VDD _00121_ _00122_ sky130_fd_sc_hd__ha_1
X_18706_ _00123_ _00124_ VSS VSS VDD VDD _00125_ _00126_ sky130_fd_sc_hd__ha_1
X_18707_ network.neuron_out5.IF0.membrane_potential\[1\] network.neuron_out5.IF0.input_current\[1\]
+ VSS VSS VDD VDD _00127_ _00128_ sky130_fd_sc_hd__ha_1
X_18708_ network.neuron_hid7.IF0.membrane_potential\[2\] network.neuron_hid7.IF0.input_current\[2\]
+ VSS VSS VDD VDD _00129_ _00130_ sky130_fd_sc_hd__ha_1
X_18709_ _00131_ _00132_ VSS VSS VDD VDD _00133_ _00134_ sky130_fd_sc_hd__ha_1
X_18710_ _00135_ _00136_ VSS VSS VDD VDD _00137_ _00138_ sky130_fd_sc_hd__ha_1
X_18711_ _00139_ _00140_ VSS VSS VDD VDD _00141_ _00142_ sky130_fd_sc_hd__ha_1
X_18712_ network.neuron_hid5.IF0.membrane_potential\[3\] network.neuron_hid5.IF0.input_current\[3\]
+ VSS VSS VDD VDD _00143_ _00144_ sky130_fd_sc_hd__ha_1
X_18713_ network.neuron_hid5.IF0.membrane_potential\[2\] network.neuron_hid5.IF0.input_current\[2\]
+ VSS VSS VDD VDD _00145_ _00146_ sky130_fd_sc_hd__ha_1
X_18714_ network.neuron_out3.IF0.membrane_potential\[0\] network.neuron_out3.IF0.input_current\[0\]
+ VSS VSS VDD VDD _00018_ _00147_ sky130_fd_sc_hd__ha_1
X_18715_ _00148_ _00149_ VSS VSS VDD VDD _00150_ _00151_ sky130_fd_sc_hd__ha_1
X_18716_ _00152_ _00153_ VSS VSS VDD VDD _00154_ _00155_ sky130_fd_sc_hd__ha_1
X_18717_ _00156_ _00157_ VSS VSS VDD VDD _00158_ _00159_ sky130_fd_sc_hd__ha_1
X_18718_ _00160_ _00161_ VSS VSS VDD VDD _00162_ _00163_ sky130_fd_sc_hd__ha_1
X_18719_ network.neuron_out5.IF0.membrane_potential\[2\] network.neuron_out0.IF0.input_current\[2\]
+ VSS VSS VDD VDD _00164_ _00165_ sky130_fd_sc_hd__ha_1
X_18720_ _00166_ _00167_ VSS VSS VDD VDD _00168_ _00169_ sky130_fd_sc_hd__ha_1
X_18721_ network.neuron_out1.IF0.membrane_potential\[1\] network.neuron_out1.IF0.input_current\[1\]
+ VSS VSS VDD VDD _00170_ _00171_ sky130_fd_sc_hd__ha_1
X_18722_ _00172_ _00173_ VSS VSS VDD VDD _00174_ _00175_ sky130_fd_sc_hd__ha_1
X_18723_ network.neuron_hid6.IF0.membrane_potential\[0\] network.neuron_hid6.IF0.input_current\[0\]
+ VSS VSS VDD VDD _00002_ network.neuron_hid6.IF0.add_out\[0\]
+ sky130_fd_sc_hd__ha_1
X_18724_ network.neuron_out4.IF0.membrane_potential\[2\] network.neuron_out1.IF0.input_current\[2\]
+ VSS VSS VDD VDD _00176_ _00177_ sky130_fd_sc_hd__ha_1
X_18725_ network.neuron_hid7.IF0.membrane_potential\[7\] network.neuron_hid2.IF0.input_current\[7\]
+ VSS VSS VDD VDD _00178_ _00179_ sky130_fd_sc_hd__ha_1
X_18726_ network.neuron_out2.IF0.membrane_potential\[2\] network.neuron_out2.IF0.input_current\[2\]
+ VSS VSS VDD VDD _00180_ _00181_ sky130_fd_sc_hd__ha_1
X_18727_ _00182_ _00183_ VSS VSS VDD VDD _00184_ _00185_ sky130_fd_sc_hd__ha_1
X_18728_ _00186_ _00187_ VSS VSS VDD VDD _00188_ _00189_ sky130_fd_sc_hd__ha_1
X_18729_ _00190_ _00191_ VSS VSS VDD VDD _00192_ _00193_ sky130_fd_sc_hd__ha_1
X_18730_ _00190_ loaded\[1\] VSS VSS VDD VDD _00194_ _09687_
+ sky130_fd_sc_hd__ha_1
X_18731_ loaded\[0\] _00191_ VSS VSS VDD VDD _00195_ _09688_
+ sky130_fd_sc_hd__ha_1
X_18732_ loaded\[0\] loaded\[1\] VSS VSS VDD VDD _00196_ _09689_
+ sky130_fd_sc_hd__ha_1
X_18733_ _00197_ _00198_ VSS VSS VDD VDD _00199_ _00200_ sky130_fd_sc_hd__ha_1
X_18734_ _00201_ _00202_ VSS VSS VDD VDD _00203_ _00204_ sky130_fd_sc_hd__ha_1
X_18735_ _00205_ _00206_ VSS VSS VDD VDD _00207_ _00208_ sky130_fd_sc_hd__ha_1
X_18736_ _00209_ _00210_ VSS VSS VDD VDD _00211_ _00212_ sky130_fd_sc_hd__ha_1
X_18737_ _00213_ _00214_ VSS VSS VDD VDD _00215_ _00216_ sky130_fd_sc_hd__ha_1
X_18738_ _00217_ _00218_ VSS VSS VDD VDD _00219_ _00220_ sky130_fd_sc_hd__ha_1
X_18739_ _00221_ _00222_ VSS VSS VDD VDD _00223_ _00224_ sky130_fd_sc_hd__ha_1
X_18740_ _00225_ _00226_ VSS VSS VDD VDD _00227_ _00228_ sky130_fd_sc_hd__ha_1
X_18741_ _00229_ _00230_ VSS VSS VDD VDD _00231_ _00232_ sky130_fd_sc_hd__ha_1
X_18742_ _00233_ _00234_ VSS VSS VDD VDD _00235_ _00236_ sky130_fd_sc_hd__ha_1
X_18743_ _00237_ _00238_ VSS VSS VDD VDD _00239_ _00240_ sky130_fd_sc_hd__ha_1
X_18744_ _00241_ _00242_ VSS VSS VDD VDD _00243_ _00244_ sky130_fd_sc_hd__ha_1
X_18745_ _00245_ _00246_ VSS VSS VDD VDD _00247_ _00248_ sky130_fd_sc_hd__ha_1
X_18746_ _00249_ _00250_ VSS VSS VDD VDD _00251_ _00252_ sky130_fd_sc_hd__ha_1
X_18747_ _00253_ _00254_ VSS VSS VDD VDD _00255_ _00256_ sky130_fd_sc_hd__ha_1
X_18748_ _00257_ _00258_ VSS VSS VDD VDD _00259_ _00260_ sky130_fd_sc_hd__ha_1
X_18749_ _00261_ _00262_ VSS VSS VDD VDD _00263_ _00264_ sky130_fd_sc_hd__ha_1
X_18750_ _00265_ _00266_ VSS VSS VDD VDD _00267_ _00268_ sky130_fd_sc_hd__ha_1
X_18751_ _00269_ _00270_ VSS VSS VDD VDD _00271_ _00272_ sky130_fd_sc_hd__ha_1
X_18752_ _00273_ _00274_ VSS VSS VDD VDD _00275_ _00276_ sky130_fd_sc_hd__ha_1
X_18753_ _00277_ _00278_ VSS VSS VDD VDD _00279_ _00280_ sky130_fd_sc_hd__ha_1
X_18754_ _00281_ _00282_ VSS VSS VDD VDD _00283_ _00284_ sky130_fd_sc_hd__ha_1
X_18755_ _00285_ _00286_ VSS VSS VDD VDD _00287_ _00288_ sky130_fd_sc_hd__ha_1
X_18756_ _00289_ _00290_ VSS VSS VDD VDD _00291_ _00292_ sky130_fd_sc_hd__ha_1
X_18757_ _00293_ _00294_ VSS VSS VDD VDD _00295_ _00296_ sky130_fd_sc_hd__ha_1
X_18758_ _00297_ _00298_ VSS VSS VDD VDD _00299_ _00300_ sky130_fd_sc_hd__ha_1
X_18759_ _00301_ _00302_ VSS VSS VDD VDD _00303_ _00304_ sky130_fd_sc_hd__ha_1
X_18760_ _00305_ _00306_ VSS VSS VDD VDD _00307_ _00308_ sky130_fd_sc_hd__ha_1
X_18761_ _00309_ _00310_ VSS VSS VDD VDD _00311_ _00312_ sky130_fd_sc_hd__ha_1
X_18762_ _00313_ _00314_ VSS VSS VDD VDD _00315_ _00316_ sky130_fd_sc_hd__ha_1
X_18763_ _00317_ _00318_ VSS VSS VDD VDD _00319_ _00320_ sky130_fd_sc_hd__ha_1
X_18764_ _00321_ _00322_ VSS VSS VDD VDD _00323_ _00324_ sky130_fd_sc_hd__ha_1
X_18765_ _00325_ _00326_ VSS VSS VDD VDD _00327_ _00328_ sky130_fd_sc_hd__ha_1
X_18766_ _00329_ _00330_ VSS VSS VDD VDD _00331_ _00332_ sky130_fd_sc_hd__ha_1
X_18767_ _00333_ _00334_ VSS VSS VDD VDD _00335_ _00336_ sky130_fd_sc_hd__ha_1
X_18768_ _00337_ _00338_ VSS VSS VDD VDD _00339_ _00340_ sky130_fd_sc_hd__ha_1
X_18769_ _00341_ _00342_ VSS VSS VDD VDD _00343_ _00344_ sky130_fd_sc_hd__ha_1
X_18770_ _00345_ _00346_ VSS VSS VDD VDD _00347_ _00348_ sky130_fd_sc_hd__ha_1
X_18771_ _00349_ _00350_ VSS VSS VDD VDD _00351_ _00352_ sky130_fd_sc_hd__ha_1
X_18772_ _00353_ _00354_ VSS VSS VDD VDD _00355_ _00356_ sky130_fd_sc_hd__ha_1
X_18773_ _00357_ _00358_ VSS VSS VDD VDD _00359_ _00360_ sky130_fd_sc_hd__ha_1
X_18774_ _00361_ _00362_ VSS VSS VDD VDD _00363_ _00364_ sky130_fd_sc_hd__ha_1
X_18775_ _00365_ _00366_ VSS VSS VDD VDD _00367_ _00368_ sky130_fd_sc_hd__ha_1
X_18776_ _00369_ _00370_ VSS VSS VDD VDD _00371_ _00372_ sky130_fd_sc_hd__ha_1
X_18777_ _00373_ _00374_ VSS VSS VDD VDD _00375_ _00376_ sky130_fd_sc_hd__ha_1
X_18778_ _00377_ _00378_ VSS VSS VDD VDD _00379_ _00380_ sky130_fd_sc_hd__ha_1
X_18779_ _00381_ _00382_ VSS VSS VDD VDD _00383_ _00384_ sky130_fd_sc_hd__ha_1
X_18780_ _00385_ _00386_ VSS VSS VDD VDD _00387_ _00388_ sky130_fd_sc_hd__ha_1
X_18781_ network.neuron_hid6.IF0.membrane_potential\[3\] network.neuron_hid6.IF0.input_current\[3\]
+ VSS VSS VDD VDD _00389_ _00390_ sky130_fd_sc_hd__ha_1
X_18782_ network.neuron_out3.IF0.membrane_potential\[1\] network.neuron_out3.IF0.input_current\[1\]
+ VSS VSS VDD VDD _00391_ _00392_ sky130_fd_sc_hd__ha_1
X_18783_ _00393_ _00394_ VSS VSS VDD VDD _00395_ _00396_ sky130_fd_sc_hd__ha_1
X_18784_ _00397_ _00398_ VSS VSS VDD VDD _00399_ _00400_ sky130_fd_sc_hd__ha_1
X_18785_ _00401_ _00402_ VSS VSS VDD VDD _00403_ _00404_ sky130_fd_sc_hd__ha_1
X_18786_ _00405_ _00406_ VSS VSS VDD VDD _00407_ _00408_ sky130_fd_sc_hd__ha_1
X_18787_ _00409_ _00410_ VSS VSS VDD VDD _00411_ _00412_ sky130_fd_sc_hd__ha_1
X_18788_ _00413_ _00414_ VSS VSS VDD VDD _00415_ _00416_ sky130_fd_sc_hd__ha_1
X_18789_ _00417_ _00418_ VSS VSS VDD VDD _00419_ _00420_ sky130_fd_sc_hd__ha_1
X_18790_ _00421_ _00422_ VSS VSS VDD VDD _00423_ _00424_ sky130_fd_sc_hd__ha_1
X_18791_ _00425_ _00426_ VSS VSS VDD VDD _00427_ _00428_ sky130_fd_sc_hd__ha_1
X_18792_ _00430_ _00431_ VSS VSS VDD VDD _00432_ _00433_ sky130_fd_sc_hd__ha_1
X_18793_ _00434_ _00435_ VSS VSS VDD VDD _00436_ _00437_ sky130_fd_sc_hd__ha_1
X_18794_ _00438_ _00439_ VSS VSS VDD VDD _00440_ _00441_ sky130_fd_sc_hd__ha_1
X_18795_ _00442_ _00443_ VSS VSS VDD VDD _00444_ _00445_ sky130_fd_sc_hd__ha_1
X_18796_ _00446_ _00447_ VSS VSS VDD VDD _00448_ _00449_ sky130_fd_sc_hd__ha_1
X_18797_ _00450_ _00451_ VSS VSS VDD VDD _00452_ _00453_ sky130_fd_sc_hd__ha_1
X_18798_ _00454_ _00455_ VSS VSS VDD VDD _00456_ _00457_ sky130_fd_sc_hd__ha_1
X_18799_ _00458_ _00459_ VSS VSS VDD VDD _00460_ _00461_ sky130_fd_sc_hd__ha_1
X_18800_ network.neuron_hid1.IF0.membrane_potential\[3\] network.neuron_hid1.IF0.input_current\[3\]
+ VSS VSS VDD VDD _00462_ _00463_ sky130_fd_sc_hd__ha_1
X_18801_ _00464_ _00465_ VSS VSS VDD VDD _00466_ _00467_ sky130_fd_sc_hd__ha_1
X_18802_ _00468_ _00469_ VSS VSS VDD VDD _00470_ _00471_ sky130_fd_sc_hd__ha_1
X_18803_ _00472_ _00473_ VSS VSS VDD VDD _00474_ _00475_ sky130_fd_sc_hd__ha_1
X_18804_ _00476_ _00477_ VSS VSS VDD VDD _00478_ _00479_ sky130_fd_sc_hd__ha_1
X_18805_ _00480_ _00481_ VSS VSS VDD VDD _00482_ _00483_ sky130_fd_sc_hd__ha_1
X_18806_ _00484_ _00485_ VSS VSS VDD VDD _00486_ _00487_ sky130_fd_sc_hd__ha_1
X_18807_ _00488_ _00489_ VSS VSS VDD VDD _00490_ _00491_ sky130_fd_sc_hd__ha_1
X_18808_ _00492_ _00493_ VSS VSS VDD VDD _00494_ _00495_ sky130_fd_sc_hd__ha_1
X_18809_ _00496_ _00497_ VSS VSS VDD VDD _00498_ _00499_ sky130_fd_sc_hd__ha_1
X_18810_ _00500_ _00501_ VSS VSS VDD VDD _00502_ _00503_ sky130_fd_sc_hd__ha_1
X_18811_ _00504_ _00505_ VSS VSS VDD VDD _00506_ _00507_ sky130_fd_sc_hd__ha_1
X_18812_ _00509_ _00510_ VSS VSS VDD VDD _00511_ _00512_ sky130_fd_sc_hd__ha_1
X_18813_ _00513_ _00514_ VSS VSS VDD VDD _00515_ _00516_ sky130_fd_sc_hd__ha_1
X_18814_ _00517_ _00518_ VSS VSS VDD VDD _00519_ _00520_ sky130_fd_sc_hd__ha_1
X_18815_ _00521_ _00522_ VSS VSS VDD VDD _00523_ _00524_ sky130_fd_sc_hd__ha_1
X_18816_ _00525_ _00526_ VSS VSS VDD VDD _00527_ _00528_ sky130_fd_sc_hd__ha_1
X_18817_ _00529_ _00530_ VSS VSS VDD VDD _00531_ _00532_ sky130_fd_sc_hd__ha_1
X_18818_ _00533_ _00534_ VSS VSS VDD VDD _00535_ _00536_ sky130_fd_sc_hd__ha_1
X_18819_ _00537_ _00538_ VSS VSS VDD VDD _00539_ _00540_ sky130_fd_sc_hd__ha_1
X_18820_ _00541_ _00542_ VSS VSS VDD VDD _00543_ _00544_ sky130_fd_sc_hd__ha_1
X_18821_ network.neuron_hid3.IF0.membrane_potential\[7\] network.neuron_hid2.IF0.input_current\[7\]
+ VSS VSS VDD VDD _00545_ _00546_ sky130_fd_sc_hd__ha_1
X_18822_ _00547_ _00548_ VSS VSS VDD VDD _00549_ _00550_ sky130_fd_sc_hd__ha_1
X_18823_ _00551_ _00552_ VSS VSS VDD VDD _00553_ _00554_ sky130_fd_sc_hd__ha_1
X_18824_ _00555_ _00556_ VSS VSS VDD VDD _00557_ _00558_ sky130_fd_sc_hd__ha_1
X_18825_ _00559_ _00560_ VSS VSS VDD VDD _00561_ _00562_ sky130_fd_sc_hd__ha_1
X_18826_ _00563_ _00564_ VSS VSS VDD VDD _00565_ _00566_ sky130_fd_sc_hd__ha_1
X_18827_ _00567_ _00568_ VSS VSS VDD VDD _00569_ _00570_ sky130_fd_sc_hd__ha_1
X_18828_ network.neuron_hid0.IF0.membrane_potential\[0\] network.neuron_hid0.IF0.input_current\[0\]
+ VSS VSS VDD VDD _00004_ network.neuron_hid0.IF0.add_out\[0\]
+ sky130_fd_sc_hd__ha_1
X_18829_ _00571_ _00572_ VSS VSS VDD VDD _00573_ _00574_ sky130_fd_sc_hd__ha_1
X_18830_ _00575_ _00576_ VSS VSS VDD VDD _00577_ _00578_ sky130_fd_sc_hd__ha_1
X_18831_ _00579_ _00580_ VSS VSS VDD VDD _00581_ _00582_ sky130_fd_sc_hd__ha_1
X_18832_ _00583_ _00584_ VSS VSS VDD VDD _00585_ _00586_ sky130_fd_sc_hd__ha_1
X_18833_ _00587_ _00588_ VSS VSS VDD VDD _00589_ _00590_ sky130_fd_sc_hd__ha_1
X_18834_ _00591_ _00592_ VSS VSS VDD VDD _00593_ _00594_ sky130_fd_sc_hd__ha_1
X_18835_ _00595_ _00596_ VSS VSS VDD VDD _00597_ _00598_ sky130_fd_sc_hd__ha_1
X_18836_ _00600_ _00601_ VSS VSS VDD VDD _00602_ _00603_ sky130_fd_sc_hd__ha_1
X_18837_ _00604_ _00605_ VSS VSS VDD VDD _00606_ _00607_ sky130_fd_sc_hd__ha_1
X_18838_ _00608_ _00609_ VSS VSS VDD VDD _00610_ _00611_ sky130_fd_sc_hd__ha_1
X_18839_ _00612_ _00613_ VSS VSS VDD VDD _00614_ _00615_ sky130_fd_sc_hd__ha_1
X_18840_ _00616_ _00617_ VSS VSS VDD VDD _00618_ _00619_ sky130_fd_sc_hd__ha_1
X_18841_ _00620_ _00621_ VSS VSS VDD VDD _00622_ _00623_ sky130_fd_sc_hd__ha_1
X_18842_ _00625_ _00626_ VSS VSS VDD VDD _00627_ _00628_ sky130_fd_sc_hd__ha_1
X_18843_ _00629_ _00630_ VSS VSS VDD VDD _00631_ _00632_ sky130_fd_sc_hd__ha_1
X_18844_ _00633_ _00634_ VSS VSS VDD VDD _00635_ _00636_ sky130_fd_sc_hd__ha_1
X_18845_ _00637_ _00638_ VSS VSS VDD VDD _00639_ _00640_ sky130_fd_sc_hd__ha_1
X_18846_ _00641_ _00642_ VSS VSS VDD VDD _00643_ _00644_ sky130_fd_sc_hd__ha_1
X_18847_ network.neuron_hid5.IF0.membrane_potential\[4\] network.neuron_hid5.IF0.input_current\[4\]
+ VSS VSS VDD VDD _00645_ _00646_ sky130_fd_sc_hd__ha_1
X_18848_ network.neuron_out4.IF0.membrane_potential\[0\] network.neuron_out4.IF0.input_current\[0\]
+ VSS VSS VDD VDD _00031_ _00647_ sky130_fd_sc_hd__ha_1
X_18849_ _00648_ _00649_ VSS VSS VDD VDD _00650_ _00651_ sky130_fd_sc_hd__ha_1
X_18850_ net27 net34 VSS VSS VDD VDD _00652_ _00653_ sky130_fd_sc_hd__ha_1
X_18851_ network.neuron_out5.IF0.membrane_potential\[3\] network.neuron_out5.IF0.input_current\[3\]
+ VSS VSS VDD VDD _00654_ _00655_ sky130_fd_sc_hd__ha_1
X_18852_ network.neuron_hid5.IF0.membrane_potential\[0\] network.neuron_hid5.IF0.input_current\[0\]
+ VSS VSS VDD VDD _00000_ network.neuron_hid5.IF0.add_out\[0\]
+ sky130_fd_sc_hd__ha_1
X_18853_ network.neuron_out1.IF0.membrane_potential\[3\] network.neuron_out1.IF0.input_current\[3\]
+ VSS VSS VDD VDD _00656_ _00657_ sky130_fd_sc_hd__ha_1
X_18854_ network.neuron_out2.IF0.membrane_potential\[0\] network.neuron_out2.IF0.input_current\[0\]
+ VSS VSS VDD VDD _00013_ _00658_ sky130_fd_sc_hd__ha_1
X_18855_ _00659_ _00660_ VSS VSS VDD VDD _00661_ _00662_ sky130_fd_sc_hd__ha_1
X_18856_ network.neuron_out5.IF0.membrane_potential\[5\] network.neuron_out5.IF0.input_current\[5\]
+ VSS VSS VDD VDD _00663_ _00664_ sky130_fd_sc_hd__ha_1
X_18857_ _00665_ _00666_ VSS VSS VDD VDD _00667_ _00668_ sky130_fd_sc_hd__ha_1
X_18858_ _00669_ _00670_ VSS VSS VDD VDD _00671_ _00672_ sky130_fd_sc_hd__ha_1
X_18859_ _00673_ _00674_ VSS VSS VDD VDD _00675_ _00676_ sky130_fd_sc_hd__ha_1
X_18860_ _00677_ _00678_ VSS VSS VDD VDD _00679_ _00680_ sky130_fd_sc_hd__ha_1
X_18861_ network.neuron_out4.IF0.membrane_potential\[1\] network.neuron_out4.IF0.input_current\[1\]
+ VSS VSS VDD VDD _00681_ _00682_ sky130_fd_sc_hd__ha_1
X_18862_ _00683_ _00684_ VSS VSS VDD VDD _00685_ _00686_ sky130_fd_sc_hd__ha_1
X_18863_ network.neuron_out0.IF0.membrane_potential\[4\] network.neuron_out0.IF0.input_current\[4\]
+ VSS VSS VDD VDD _00687_ _00688_ sky130_fd_sc_hd__ha_1
X_18864_ _00689_ _00690_ VSS VSS VDD VDD _00691_ _00692_ sky130_fd_sc_hd__ha_1
X_18865_ network.neuron_hid7.IF0.membrane_potential\[5\] network.neuron_hid2.IF0.input_current\[5\]
+ VSS VSS VDD VDD _00693_ _00694_ sky130_fd_sc_hd__ha_1
X_18866_ _00695_ _00696_ VSS VSS VDD VDD _00697_ _00698_ sky130_fd_sc_hd__ha_1
X_18867_ _00699_ _00700_ VSS VSS VDD VDD _00701_ _00702_ sky130_fd_sc_hd__ha_1
X_18868_ network.neuron_hid0.IF0.membrane_potential\[1\] network.neuron_hid0.IF0.input_current\[1\]
+ VSS VSS VDD VDD _00703_ _00429_ sky130_fd_sc_hd__ha_1
X_18869_ _00704_ _00705_ VSS VSS VDD VDD _00706_ _00707_ sky130_fd_sc_hd__ha_1
X_18870_ network.neuron_hid2.IF0.membrane_potential\[7\] network.neuron_hid2.IF0.input_current\[7\]
+ VSS VSS VDD VDD _00709_ _00710_ sky130_fd_sc_hd__ha_1
X_18871_ network.neuron_hid2.IF0.membrane_potential\[1\] network.neuron_hid2.IF0.input_current\[1\]
+ VSS VSS VDD VDD _00711_ _00712_ sky130_fd_sc_hd__ha_1
X_18872_ network.neuron_hid3.IF0.membrane_potential\[5\] network.neuron_hid2.IF0.input_current\[5\]
+ VSS VSS VDD VDD _00713_ _00714_ sky130_fd_sc_hd__ha_1
X_18873_ _00715_ _00716_ VSS VSS VDD VDD _00717_ _00718_ sky130_fd_sc_hd__ha_1
X_18874_ _00719_ _00720_ VSS VSS VDD VDD _00721_ _00722_ sky130_fd_sc_hd__ha_1
X_18875_ _00723_ _00724_ VSS VSS VDD VDD _00725_ _00726_ sky130_fd_sc_hd__ha_1
X_18876_ _00727_ _00728_ VSS VSS VDD VDD _00729_ _00730_ sky130_fd_sc_hd__ha_1
X_18877_ network.neuron_hid4.IF0.membrane_potential\[1\] network.neuron_hid4.IF0.input_current\[1\]
+ VSS VSS VDD VDD _00731_ _00708_ sky130_fd_sc_hd__ha_1
X_18878_ _00732_ _00733_ VSS VSS VDD VDD _00734_ _00735_ sky130_fd_sc_hd__ha_1
X_18879_ _00736_ _00737_ VSS VSS VDD VDD _00738_ _00739_ sky130_fd_sc_hd__ha_1
X_18880_ network.neuron_hid4.IF0.membrane_potential\[0\] network.neuron_hid4.IF0.input_current\[0\]
+ VSS VSS VDD VDD _00016_ network.neuron_hid4.IF0.add_out\[0\]
+ sky130_fd_sc_hd__ha_1
X_18881_ _00740_ _00741_ VSS VSS VDD VDD _00742_ _00743_ sky130_fd_sc_hd__ha_1
X_18882_ network.neuron_out1.IF0.membrane_potential\[0\] network.neuron_out1.IF0.input_current\[0\]
+ VSS VSS VDD VDD _00008_ _00744_ sky130_fd_sc_hd__ha_1
X_18883_ _00745_ _00746_ VSS VSS VDD VDD _00747_ _00748_ sky130_fd_sc_hd__ha_1
X_18884_ _00749_ _00750_ VSS VSS VDD VDD _00751_ _00752_ sky130_fd_sc_hd__ha_1
X_18885_ _00753_ _00754_ VSS VSS VDD VDD _00755_ _00756_ sky130_fd_sc_hd__ha_1
X_18886_ _00757_ _00758_ VSS VSS VDD VDD _00759_ _00760_ sky130_fd_sc_hd__ha_1
X_18887_ _00761_ _00762_ VSS VSS VDD VDD _00763_ _00764_ sky130_fd_sc_hd__ha_1
X_18888_ _00765_ _00766_ VSS VSS VDD VDD _00767_ _00768_ sky130_fd_sc_hd__ha_1
X_18889_ _00769_ _00770_ VSS VSS VDD VDD _00771_ _00772_ sky130_fd_sc_hd__ha_1
X_18890_ network.neuron_hid7.IF0.membrane_potential\[3\] network.neuron_hid7.IF0.input_current\[3\]
+ VSS VSS VDD VDD _00773_ _00774_ sky130_fd_sc_hd__ha_1
X_18891_ _00775_ _00776_ VSS VSS VDD VDD _00777_ _00778_ sky130_fd_sc_hd__ha_1
X_18892_ network.neuron_hid2.IF0.membrane_potential\[5\] network.neuron_hid2.IF0.input_current\[5\]
+ VSS VSS VDD VDD _00779_ _00780_ sky130_fd_sc_hd__ha_1
X_18893_ network.neuron_out5.IF0.membrane_potential\[6\] network.neuron_out5.IF0.input_current\[6\]
+ VSS VSS VDD VDD _00781_ _00782_ sky130_fd_sc_hd__ha_1
X_18894_ _00783_ _00784_ VSS VSS VDD VDD _00785_ _00786_ sky130_fd_sc_hd__ha_1
X_18895_ _00787_ _00788_ VSS VSS VDD VDD _00789_ _00790_ sky130_fd_sc_hd__ha_1
X_18896_ _00791_ _00792_ VSS VSS VDD VDD _00793_ _00794_ sky130_fd_sc_hd__ha_1
X_18897_ network.neuron_hid1.IF0.membrane_potential\[1\] network.neuron_hid1.IF0.input_current\[1\]
+ VSS VSS VDD VDD _00795_ _00796_ sky130_fd_sc_hd__ha_1
X_18898_ _00797_ _00798_ VSS VSS VDD VDD _00799_ _00800_ sky130_fd_sc_hd__ha_1
X_18899_ _00801_ _00802_ VSS VSS VDD VDD _00803_ _00804_ sky130_fd_sc_hd__ha_1
X_18900_ _00805_ _00806_ VSS VSS VDD VDD _00807_ _00808_ sky130_fd_sc_hd__ha_1
X_18901_ _00809_ _00810_ VSS VSS VDD VDD _00811_ _00812_ sky130_fd_sc_hd__ha_1
X_18902_ _00813_ _00814_ VSS VSS VDD VDD _00815_ _00816_ sky130_fd_sc_hd__ha_1
X_18903_ _00817_ _00818_ VSS VSS VDD VDD _00819_ _00820_ sky130_fd_sc_hd__ha_1
X_18904_ _00821_ _00822_ VSS VSS VDD VDD _00823_ _00824_ sky130_fd_sc_hd__ha_1
X_18905_ _00825_ _00826_ VSS VSS VDD VDD _00827_ _00828_ sky130_fd_sc_hd__ha_1
X_18906_ _00829_ _00830_ VSS VSS VDD VDD _00831_ _00832_ sky130_fd_sc_hd__ha_1
X_18907_ _00833_ _00834_ VSS VSS VDD VDD _00835_ _00836_ sky130_fd_sc_hd__ha_1
X_18908_ _00837_ _00838_ VSS VSS VDD VDD _00839_ _00840_ sky130_fd_sc_hd__ha_1
X_18909_ _00841_ _00842_ VSS VSS VDD VDD _00843_ _00844_ sky130_fd_sc_hd__ha_1
X_18910_ _00845_ _00846_ VSS VSS VDD VDD _00847_ _00848_ sky130_fd_sc_hd__ha_1
X_18911_ _00849_ _00850_ VSS VSS VDD VDD _00851_ _00852_ sky130_fd_sc_hd__ha_1
X_18912_ network.neuron_hid7.IF0.membrane_potential\[0\] network.neuron_hid7.IF0.input_current\[0\]
+ VSS VSS VDD VDD _00006_ network.neuron_hid7.IF0.add_out\[0\]
+ sky130_fd_sc_hd__ha_1
X_18913_ network.neuron_out4.IF0.membrane_potential\[4\] network.neuron_out4.IF0.input_current\[4\]
+ VSS VSS VDD VDD _00853_ _00854_ sky130_fd_sc_hd__ha_1
X_18914_ network.neuron_hid6.IF0.membrane_potential\[4\] network.neuron_hid6.IF0.input_current\[4\]
+ VSS VSS VDD VDD _00855_ _00856_ sky130_fd_sc_hd__ha_1
X_18915_ network.neuron_hid0.IF0.membrane_potential\[4\] network.neuron_hid0.IF0.input_current\[4\]
+ VSS VSS VDD VDD _00857_ _00858_ sky130_fd_sc_hd__ha_1
X_18916_ network.neuron_hid6.IF0.membrane_potential\[1\] network.neuron_hid6.IF0.input_current\[1\]
+ VSS VSS VDD VDD _00859_ _00085_ sky130_fd_sc_hd__ha_1
X_18917_ _00860_ _00861_ VSS VSS VDD VDD _00862_ _00863_ sky130_fd_sc_hd__ha_1
X_18918_ network.neuron_out4.IF0.membrane_potential\[3\] network.neuron_out4.IF0.input_current\[0\]
+ VSS VSS VDD VDD _00864_ _00865_ sky130_fd_sc_hd__ha_1
X_18919_ network.neuron_out0.IF0.membrane_potential\[5\] network.neuron_out0.IF0.input_current\[5\]
+ VSS VSS VDD VDD _00866_ _00867_ sky130_fd_sc_hd__ha_1
X_18920_ network.neuron_out1.IF0.membrane_potential\[4\] network.neuron_out1.IF0.input_current\[4\]
+ VSS VSS VDD VDD _00868_ _00869_ sky130_fd_sc_hd__ha_1
X_18921_ _00870_ _00871_ VSS VSS VDD VDD _00872_ _00873_ sky130_fd_sc_hd__ha_1
X_18922_ _00874_ _00875_ VSS VSS VDD VDD _00876_ _00877_ sky130_fd_sc_hd__ha_1
X_18923_ _00878_ _00879_ VSS VSS VDD VDD _00880_ _00881_ sky130_fd_sc_hd__ha_1
X_18924_ network.neuron_hid7.IF0.membrane_potential\[1\] network.neuron_hid7.IF0.input_current\[1\]
+ VSS VSS VDD VDD _00882_ _00508_ sky130_fd_sc_hd__ha_1
X_18925_ _00883_ _00884_ VSS VSS VDD VDD _00885_ _00886_ sky130_fd_sc_hd__ha_1
X_18926_ _00887_ _00888_ VSS VSS VDD VDD _00889_ _00890_ sky130_fd_sc_hd__ha_1
X_18927_ _00891_ _00892_ VSS VSS VDD VDD _00893_ _00894_ sky130_fd_sc_hd__ha_1
X_18928_ _00895_ _00896_ VSS VSS VDD VDD _00897_ _00898_ sky130_fd_sc_hd__ha_1
X_18929_ _00899_ _00900_ VSS VSS VDD VDD _00901_ _00902_ sky130_fd_sc_hd__ha_1
X_18930_ _00903_ _00904_ VSS VSS VDD VDD _00905_ _00906_ sky130_fd_sc_hd__ha_1
X_18931_ _00907_ _00908_ VSS VSS VDD VDD _00909_ _00910_ sky130_fd_sc_hd__ha_1
X_18932_ _00911_ _00912_ VSS VSS VDD VDD _00913_ _00914_ sky130_fd_sc_hd__ha_1
X_18933_ _00915_ _00916_ VSS VSS VDD VDD _00917_ _00918_ sky130_fd_sc_hd__ha_1
X_18934_ network.neuron_out2.IF0.membrane_potential\[1\] network.neuron_out2.IF0.input_current\[1\]
+ VSS VSS VDD VDD _00919_ _00624_ sky130_fd_sc_hd__ha_1
X_18935_ _00920_ _00921_ VSS VSS VDD VDD _00922_ _00923_ sky130_fd_sc_hd__ha_1
X_18936_ _00924_ _00925_ VSS VSS VDD VDD _00926_ _00927_ sky130_fd_sc_hd__ha_1
X_18937_ _00928_ _00929_ VSS VSS VDD VDD _00930_ _00931_ sky130_fd_sc_hd__ha_1
X_18938_ _00932_ _00933_ VSS VSS VDD VDD _00934_ _00935_ sky130_fd_sc_hd__ha_1
X_18939_ _00936_ _00937_ VSS VSS VDD VDD _00938_ _00939_ sky130_fd_sc_hd__ha_1
X_18940_ network.neuron_out3.IF0.membrane_potential\[2\] network.neuron_out3.IF0.input_current\[2\]
+ VSS VSS VDD VDD _00940_ _00941_ sky130_fd_sc_hd__ha_1
X_18941_ _00942_ _00943_ VSS VSS VDD VDD _00944_ _00945_ sky130_fd_sc_hd__ha_1
X_18942_ _00946_ _00947_ VSS VSS VDD VDD _00948_ _00949_ sky130_fd_sc_hd__ha_1
X_18943_ _00950_ _00951_ VSS VSS VDD VDD _00952_ _00953_ sky130_fd_sc_hd__ha_1
X_18944_ _00954_ _00955_ VSS VSS VDD VDD _00956_ _00957_ sky130_fd_sc_hd__ha_1
X_18945_ _00958_ _00959_ VSS VSS VDD VDD _00960_ _00961_ sky130_fd_sc_hd__ha_1
X_18946_ _00962_ _00963_ VSS VSS VDD VDD _00964_ _00965_ sky130_fd_sc_hd__ha_1
X_18947_ _00966_ _00967_ VSS VSS VDD VDD _00968_ _00969_ sky130_fd_sc_hd__ha_1
X_18948_ _00970_ _00971_ VSS VSS VDD VDD _00972_ _00973_ sky130_fd_sc_hd__ha_1
X_18949_ _00974_ _00975_ VSS VSS VDD VDD _00976_ _00977_ sky130_fd_sc_hd__ha_1
X_18950_ _00978_ _00979_ VSS VSS VDD VDD _00980_ _00981_ sky130_fd_sc_hd__ha_1
X_18951_ _00982_ _00983_ VSS VSS VDD VDD _00984_ _00985_ sky130_fd_sc_hd__ha_1
X_18952_ _00986_ _00987_ VSS VSS VDD VDD _00988_ _00989_ sky130_fd_sc_hd__ha_1
X_18953_ _00990_ _00991_ VSS VSS VDD VDD _00992_ _00993_ sky130_fd_sc_hd__ha_1
X_18954_ _00994_ _00995_ VSS VSS VDD VDD _00996_ _00997_ sky130_fd_sc_hd__ha_1
X_18955_ _00998_ _00999_ VSS VSS VDD VDD _01000_ _01001_ sky130_fd_sc_hd__ha_1
X_18956_ _01002_ _01003_ VSS VSS VDD VDD _01004_ _01005_ sky130_fd_sc_hd__ha_1
X_18957_ _01006_ _01007_ VSS VSS VDD VDD _01008_ _01009_ sky130_fd_sc_hd__ha_1
X_18958_ _01010_ _01011_ VSS VSS VDD VDD _01012_ _01013_ sky130_fd_sc_hd__ha_1
X_18959_ _01014_ _01015_ VSS VSS VDD VDD _01016_ _01017_ sky130_fd_sc_hd__ha_1
X_18960_ _01018_ _01019_ VSS VSS VDD VDD _01020_ _01021_ sky130_fd_sc_hd__ha_1
X_18961_ network.neuron_hid3.IF0.membrane_potential\[6\] network.neuron_hid2.IF0.input_current\[6\]
+ VSS VSS VDD VDD _01022_ _01023_ sky130_fd_sc_hd__ha_1
X_18962_ network.neuron_hid3.IF0.membrane_potential\[1\] network.neuron_hid3.IF0.input_current\[1\]
+ VSS VSS VDD VDD _01024_ _00599_ sky130_fd_sc_hd__ha_1
X_18963_ network.neuron_out0.IF0.membrane_potential\[0\] network.neuron_out0.IF0.input_current\[0\]
+ VSS VSS VDD VDD _00028_ _01025_ sky130_fd_sc_hd__ha_1
X_18964_ _01026_ _01027_ VSS VSS VDD VDD _01028_ _01029_ sky130_fd_sc_hd__ha_1
X_18965_ _01030_ _01031_ VSS VSS VDD VDD _01032_ _01033_ sky130_fd_sc_hd__ha_1
X_18966_ _01034_ _01035_ VSS VSS VDD VDD _01036_ _01037_ sky130_fd_sc_hd__ha_1
X_18967_ _01038_ _01039_ VSS VSS VDD VDD _01040_ _01041_ sky130_fd_sc_hd__ha_1
X_18968_ network.neuron_hid7.IF0.membrane_potential\[4\] network.neuron_hid2.IF0.input_current\[4\]
+ VSS VSS VDD VDD _01042_ _01043_ sky130_fd_sc_hd__ha_1
X_18969_ _01044_ _01045_ VSS VSS VDD VDD _01046_ _01047_ sky130_fd_sc_hd__ha_1
X_18970_ _01048_ _01049_ VSS VSS VDD VDD _01050_ _01051_ sky130_fd_sc_hd__ha_1
X_18971_ network.neuron_hid3.IF0.membrane_potential\[3\] network.neuron_hid2.IF0.input_current\[3\]
+ VSS VSS VDD VDD _01052_ _01053_ sky130_fd_sc_hd__ha_1
X_18972_ network.neuron_out1.IF0.membrane_potential\[2\] network.neuron_out1.IF0.input_current\[2\]
+ VSS VSS VDD VDD _01054_ _01055_ sky130_fd_sc_hd__ha_1
X_18973_ network.neuron_out3.IF0.membrane_potential\[4\] network.neuron_out3.IF0.input_current\[4\]
+ VSS VSS VDD VDD _01056_ _01057_ sky130_fd_sc_hd__ha_1
X_18974_ _01058_ _01059_ VSS VSS VDD VDD _01060_ _01061_ sky130_fd_sc_hd__ha_1
X_18975_ network.neuron_hid3.IF0.membrane_potential\[4\] network.neuron_hid2.IF0.input_current\[4\]
+ VSS VSS VDD VDD _01062_ _01063_ sky130_fd_sc_hd__ha_1
X_18976_ network.neuron_hid3.IF0.membrane_potential\[0\] network.neuron_hid3.IF0.input_current\[0\]
+ VSS VSS VDD VDD _00011_ network.neuron_hid3.IF0.add_out\[0\]
+ sky130_fd_sc_hd__ha_1
X_18977_ network.neuron_out0.IF0.membrane_potential\[2\] network.neuron_out0.IF0.input_current\[2\]
+ VSS VSS VDD VDD _01064_ _01065_ sky130_fd_sc_hd__ha_1
X_18978_ network.neuron_hid5.IF0.membrane_potential\[1\] network.neuron_hid5.IF0.input_current\[1\]
+ VSS VSS VDD VDD _01066_ _00046_ sky130_fd_sc_hd__ha_1
X_18979_ network.neuron_out5.IF0.membrane_potential\[4\] network.neuron_out5.IF0.input_current\[4\]
+ VSS VSS VDD VDD _01067_ _01068_ sky130_fd_sc_hd__ha_1
X_18980_ network.neuron_hid6.IF0.membrane_potential\[2\] network.neuron_hid6.IF0.input_current\[2\]
+ VSS VSS VDD VDD _01069_ _01070_ sky130_fd_sc_hd__ha_1
X_18981_ _01071_ _01072_ VSS VSS VDD VDD _01073_ _01074_ sky130_fd_sc_hd__ha_1
X_18982_ _01075_ _01076_ VSS VSS VDD VDD _01077_ _01078_ sky130_fd_sc_hd__ha_1
X_18983_ _01079_ _01080_ VSS VSS VDD VDD _01081_ _01082_ sky130_fd_sc_hd__ha_1
X_18984_ network.neuron_hid0.IF0.membrane_potential\[3\] network.neuron_hid0.IF0.input_current\[3\]
+ VSS VSS VDD VDD _01083_ _01084_ sky130_fd_sc_hd__ha_1
X_18985_ _01085_ _01086_ VSS VSS VDD VDD _01087_ _01088_ sky130_fd_sc_hd__ha_1
X_18986_ _01089_ _01090_ VSS VSS VDD VDD _01091_ _01092_ sky130_fd_sc_hd__ha_1
X_18987_ _01093_ _01094_ VSS VSS VDD VDD _01095_ _01096_ sky130_fd_sc_hd__ha_1
X_18988_ _01097_ _01098_ VSS VSS VDD VDD _01099_ _01100_ sky130_fd_sc_hd__ha_1
X_18989_ _01101_ _01102_ VSS VSS VDD VDD _01103_ _01104_ sky130_fd_sc_hd__ha_1
X_18990_ _01105_ _01106_ VSS VSS VDD VDD _01107_ _01108_ sky130_fd_sc_hd__ha_1
X_18991_ _01109_ _01110_ VSS VSS VDD VDD _01111_ _01112_ sky130_fd_sc_hd__ha_1
X_18992_ _01113_ _01114_ VSS VSS VDD VDD _01115_ _01116_ sky130_fd_sc_hd__ha_1
X_18993_ _01118_ _01119_ VSS VSS VDD VDD _01120_ _01121_ sky130_fd_sc_hd__ha_1
X_18994_ network.neuron_out3.IF0.membrane_potential\[3\] network.neuron_out3.IF0.input_current\[3\]
+ VSS VSS VDD VDD _01122_ _01123_ sky130_fd_sc_hd__ha_1
X_18995_ _01124_ _01125_ VSS VSS VDD VDD _01126_ _01127_ sky130_fd_sc_hd__ha_1
X_18996_ network.neuron_hid3.IF0.membrane_potential\[2\] network.neuron_hid3.IF0.input_current\[2\]
+ VSS VSS VDD VDD _01128_ _01129_ sky130_fd_sc_hd__ha_1
X_18997_ network.neuron_hid7.IF0.membrane_potential\[6\] network.neuron_hid2.IF0.input_current\[6\]
+ VSS VSS VDD VDD _01130_ _01131_ sky130_fd_sc_hd__ha_1
X_18998_ _01132_ _01133_ VSS VSS VDD VDD _01134_ _01135_ sky130_fd_sc_hd__ha_1
X_18999_ network.neuron_out0.IF0.membrane_potential\[3\] network.neuron_out0.IF0.input_current\[3\]
+ VSS VSS VDD VDD _01136_ _01137_ sky130_fd_sc_hd__ha_1
X_19000_ _01138_ _01139_ VSS VSS VDD VDD _01140_ _01141_ sky130_fd_sc_hd__ha_1
X_19001_ _01142_ _01143_ VSS VSS VDD VDD _01144_ _01145_ sky130_fd_sc_hd__ha_1
X_19002_ _01146_ _01147_ VSS VSS VDD VDD _01148_ _01149_ sky130_fd_sc_hd__ha_1
X_19003_ _01150_ _01151_ VSS VSS VDD VDD _01152_ _01153_ sky130_fd_sc_hd__ha_1
X_19004_ _01154_ _01155_ VSS VSS VDD VDD _01156_ _01157_ sky130_fd_sc_hd__ha_1
X_19005_ network.neuron_out2.IF0.membrane_potential\[3\] network.neuron_out2.IF0.input_current\[3\]
+ VSS VSS VDD VDD _01158_ _01159_ sky130_fd_sc_hd__ha_1
X_19006_ network.neuron_hid1.IF0.membrane_potential\[0\] network.neuron_hid1.IF0.input_current\[0\]
+ VSS VSS VDD VDD _00026_ network.neuron_hid1.IF0.add_out\[0\]
+ sky130_fd_sc_hd__ha_1
X_19007_ _01160_ _01161_ VSS VSS VDD VDD _01162_ _01163_ sky130_fd_sc_hd__ha_1
X_19008_ _01164_ _01165_ VSS VSS VDD VDD _01166_ _01167_ sky130_fd_sc_hd__ha_1
X_19009_ network.neuron_hid4.IF0.membrane_potential\[3\] network.neuron_hid4.IF0.input_current\[3\]
+ VSS VSS VDD VDD _01168_ _01169_ sky130_fd_sc_hd__ha_1
X_19010_ _01170_ _01171_ VSS VSS VDD VDD _01172_ _01173_ sky130_fd_sc_hd__ha_1
X_19011_ _01174_ _01175_ VSS VSS VDD VDD _01176_ _01177_ sky130_fd_sc_hd__ha_1
X_19012_ _01178_ _01179_ VSS VSS VDD VDD _01180_ _01181_ sky130_fd_sc_hd__ha_1
X_19013_ _01182_ _01183_ VSS VSS VDD VDD _01184_ _01185_ sky130_fd_sc_hd__ha_1
X_19014_ network.neuron_hid0.IF0.membrane_potential\[2\] network.neuron_hid0.IF0.input_current\[2\]
+ VSS VSS VDD VDD _01186_ _01187_ sky130_fd_sc_hd__ha_1
X_19015_ _01188_ _01189_ VSS VSS VDD VDD _01190_ _01191_ sky130_fd_sc_hd__ha_1
X_19016_ _01192_ _01193_ VSS VSS VDD VDD _01194_ _01195_ sky130_fd_sc_hd__ha_1
X_19017_ network.neuron_hid1.IF0.membrane_potential\[2\] network.neuron_hid1.IF0.input_current\[2\]
+ VSS VSS VDD VDD _01196_ _01197_ sky130_fd_sc_hd__ha_1
X_19018_ _01198_ _01199_ VSS VSS VDD VDD _01200_ _01201_ sky130_fd_sc_hd__ha_1
X_19019_ _01202_ _01203_ VSS VSS VDD VDD _01204_ _01205_ sky130_fd_sc_hd__ha_1
X_19020_ network.neuron_hid1.IF0.membrane_potential\[4\] network.neuron_hid1.IF0.input_current\[4\]
+ VSS VSS VDD VDD _01206_ _01207_ sky130_fd_sc_hd__ha_1
X_19021_ network.neuron_hid2.IF0.membrane_potential\[0\] network.neuron_hid2.IF0.input_current\[0\]
+ VSS VSS VDD VDD _00021_ network.neuron_hid2.IF0.add_out\[0\]
+ sky130_fd_sc_hd__ha_1
X_19022_ network.neuron_hid2.IF0.membrane_potential\[6\] network.neuron_hid2.IF0.input_current\[6\]
+ VSS VSS VDD VDD _01208_ _01209_ sky130_fd_sc_hd__ha_1
X_19023_ _01210_ _01211_ VSS VSS VDD VDD _01212_ _01213_ sky130_fd_sc_hd__ha_1
X_19024_ _01214_ _01215_ VSS VSS VDD VDD _01216_ _01217_ sky130_fd_sc_hd__ha_1
X_19025_ _01218_ _01219_ VSS VSS VDD VDD _01220_ _01221_ sky130_fd_sc_hd__ha_1
X_19026_ _01222_ _01223_ VSS VSS VDD VDD _01224_ _01225_ sky130_fd_sc_hd__ha_1
X_19027_ network.neuron_out0.IF0.membrane_potential\[1\] network.neuron_out0.IF0.input_current\[1\]
+ VSS VSS VDD VDD _01226_ _01117_ sky130_fd_sc_hd__ha_1
X_19028_ _01227_ _01228_ VSS VSS VDD VDD _01229_ _01230_ sky130_fd_sc_hd__ha_1
X_19029_ _01231_ _01232_ VSS VSS VDD VDD _01233_ _01234_ sky130_fd_sc_hd__ha_1
X_19030_ _01235_ _01236_ VSS VSS VDD VDD _01237_ _01238_ sky130_fd_sc_hd__ha_1
X_19031_ network.neuron_hid2.IF0.membrane_potential\[4\] network.neuron_hid2.IF0.input_current\[4\]
+ VSS VSS VDD VDD _01239_ _01240_ sky130_fd_sc_hd__ha_1
X_19032_ network.neuron_hid2.IF0.membrane_potential\[2\] network.neuron_hid2.IF0.input_current\[2\]
+ VSS VSS VDD VDD _01241_ _01242_ sky130_fd_sc_hd__ha_1
X_19033_ network.neuron_hid2.IF0.membrane_potential\[3\] network.neuron_hid2.IF0.input_current\[3\]
+ VSS VSS VDD VDD _01243_ _01244_ sky130_fd_sc_hd__ha_1
X_19034_ _01245_ _01246_ VSS VSS VDD VDD _01247_ _01248_ sky130_fd_sc_hd__ha_1
XTAP_TAPCELL_ROW_0_0 VSS VDD sky130_fd_sc_hd__tapvpwrvgnd_1
Xbusy$_SDFFE_PP0P_ clknet_2_2__leaf_clk_root_regs net445 VSS
+ VSS VDD VDD net25 sky130_fd_sc_hd__dfxtp_1
Xdone$_SDFF_PP0_ clknet_2_3__leaf_clk_root_regs _01955_ VSS
+ VSS VDD VDD net26 sky130_fd_sc_hd__dfxtp_1
Xicg_load.icg clknet_1_0__leaf_clk_root icg_load.en VSS VSS
+ VDD VDD clk_load sky130_fd_sc_hd__dlclkp_1
Xicg_net.icg clknet_1_1__leaf_clk_root icg_net.en VSS VSS
+ VDD VDD clk_net sky130_fd_sc_hd__dlclkp_1
Xicg_root.icg clk icg_root.en VSS VSS VDD VDD clk_root sky130_fd_sc_hd__dlclkp_1
Xinference_cycles\[0\]$_SDFFE_PP0P_ clknet_2_1__leaf_clk_root_regs
+ _01564_ VSS VSS VDD VDD net27 sky130_fd_sc_hd__dfxtp_1
Xinference_cycles\[10\]$_SDFFE_PP0P_ clknet_2_1__leaf_clk_root_regs
+ _01554_ VSS VSS VDD VDD net28 sky130_fd_sc_hd__dfxtp_1
Xinference_cycles\[11\]$_SDFFE_PP0P_ clknet_2_2__leaf_clk_root_regs
+ _01553_ VSS VSS VDD VDD net29 sky130_fd_sc_hd__dfxtp_1
Xinference_cycles\[12\]$_SDFFE_PP0P_ clknet_2_0__leaf_clk_root_regs
+ _01552_ VSS VSS VDD VDD net30 sky130_fd_sc_hd__dfxtp_1
Xinference_cycles\[13\]$_SDFFE_PP0P_ clknet_2_1__leaf_clk_root_regs
+ _01551_ VSS VSS VDD VDD net31 sky130_fd_sc_hd__dfxtp_1
Xinference_cycles\[14\]$_SDFFE_PP0P_ clknet_2_1__leaf_clk_root_regs
+ _01550_ VSS VSS VDD VDD net32 sky130_fd_sc_hd__dfxtp_1
Xinference_cycles\[15\]$_SDFFE_PP0P_ clknet_2_1__leaf_clk_root_regs
+ _01954_ VSS VSS VDD VDD net33 sky130_fd_sc_hd__dfxtp_1
Xinference_cycles\[1\]$_SDFFE_PP0P_ clknet_2_3__leaf_clk_root_regs
+ _01563_ VSS VSS VDD VDD net34 sky130_fd_sc_hd__dfxtp_1
Xinference_cycles\[2\]$_SDFFE_PP0P_ clknet_2_0__leaf_clk_root_regs
+ _01562_ VSS VSS VDD VDD net35 sky130_fd_sc_hd__dfxtp_1
Xinference_cycles\[3\]$_SDFFE_PP0P_ clknet_2_1__leaf_clk_root_regs
+ _01561_ VSS VSS VDD VDD net36 sky130_fd_sc_hd__dfxtp_1
Xinference_cycles\[4\]$_SDFFE_PP0P_ clknet_2_1__leaf_clk_root_regs
+ _01560_ VSS VSS VDD VDD net37 sky130_fd_sc_hd__dfxtp_1
Xinference_cycles\[5\]$_SDFFE_PP0P_ clknet_2_1__leaf_clk_root_regs
+ _01559_ VSS VSS VDD VDD net38 sky130_fd_sc_hd__dfxtp_1
Xinference_cycles\[6\]$_SDFFE_PP0P_ clknet_2_0__leaf_clk_root_regs
+ _01558_ VSS VSS VDD VDD net39 sky130_fd_sc_hd__dfxtp_1
Xinference_cycles\[7\]$_SDFFE_PP0P_ clknet_2_1__leaf_clk_root_regs
+ _01557_ VSS VSS VDD VDD net40 sky130_fd_sc_hd__dfxtp_1
Xinference_cycles\[8\]$_SDFFE_PP0P_ clknet_2_1__leaf_clk_root_regs
+ _01556_ VSS VSS VDD VDD net41 sky130_fd_sc_hd__dfxtp_1
Xinference_cycles\[9\]$_SDFFE_PP0P_ clknet_2_1__leaf_clk_root_regs
+ _01555_ VSS VSS VDD VDD net42 sky130_fd_sc_hd__dfxtp_1
Xloaded\[0\]$_SDFFE_PP0P_ clknet_2_2__leaf_clk_root_regs _01572_
+ VSS VSS VDD VDD loaded\[0\] sky130_fd_sc_hd__dfxtp_1
Xloaded\[1\]$_SDFFE_PP0P_ clknet_2_2__leaf_clk_root_regs _01571_
+ VSS VSS VDD VDD loaded\[1\] sky130_fd_sc_hd__dfxtp_1
Xloaded\[2\]$_SDFFE_PP0P_ clknet_2_0__leaf_clk_root_regs _01570_
+ VSS VSS VDD VDD loaded\[2\] sky130_fd_sc_hd__dfxtp_1
Xloaded\[3\]$_SDFFE_PP0P_ clknet_2_0__leaf_clk_root_regs _01569_
+ VSS VSS VDD VDD loaded\[3\] sky130_fd_sc_hd__dfxtp_1
Xloaded\[4\]$_SDFFE_PP0P_ clknet_2_2__leaf_clk_root_regs _01568_
+ VSS VSS VDD VDD loaded\[4\] sky130_fd_sc_hd__dfxtp_1
Xloaded\[5\]$_SDFFE_PP0P_ clknet_2_2__leaf_clk_root_regs _01567_
+ VSS VSS VDD VDD loaded\[5\] sky130_fd_sc_hd__dfxtp_1
Xloaded\[6\]$_SDFFE_PP0P_ clknet_2_0__leaf_clk_root_regs _01566_
+ VSS VSS VDD VDD loaded\[6\] sky130_fd_sc_hd__dfxtp_1
Xloaded\[7\]$_SDFFE_PP0P_ clknet_2_0__leaf_clk_root_regs _01565_
+ VSS VSS VDD VDD loaded\[7\] sky130_fd_sc_hd__dfxtp_1
Xloaded\[8\]$_SDFFE_PP0P_ clknet_2_0__leaf_clk_root_regs _01950_
+ VSS VSS VDD VDD loaded\[8\] sky130_fd_sc_hd__dfxtp_1
Xnetwork.arbit.counter\[0\]$_SDFFE_PP0N_ clknet_leaf_84_clk_net
+ _01576_ VSS VSS VDD VDD network.arbit.counter\[0\] sky130_fd_sc_hd__dfxtp_1
Xnetwork.arbit.counter\[1\]$_SDFFE_PP0N_ clknet_leaf_84_clk_net
+ _01575_ VSS VSS VDD VDD network.arbit.counter\[1\] sky130_fd_sc_hd__dfxtp_1
Xnetwork.arbit.counter\[2\]$_SDFFE_PP1N_ clknet_leaf_88_clk_net
+ _01574_ VSS VSS VDD VDD network.arbit.counter\[2\] sky130_fd_sc_hd__dfxtp_1
Xnetwork.arbit.counter\[3\]$_SDFFE_PP1N_ clknet_leaf_88_clk_net
+ _01948_ VSS VSS VDD VDD network.arbit.counter\[3\] sky130_fd_sc_hd__dfxtp_1
Xnetwork.cnt_main.counter\[0\]$_SDFF_PP0_ clknet_leaf_90_clk_net
+ _01741_ VSS VSS VDD VDD network.cnt_main.counter\[0\] sky130_fd_sc_hd__dfxtp_1
Xnetwork.cnt_main.counter\[10\]$_SDFF_PP0_ clknet_leaf_94_clk_net
+ _01731_ VSS VSS VDD VDD network.cnt_main.counter\[10\] sky130_fd_sc_hd__dfxtp_1
Xnetwork.cnt_main.counter\[11\]$_SDFF_PP1_ clknet_leaf_94_clk_net
+ _01730_ VSS VSS VDD VDD network.cnt_main.counter\[11\] sky130_fd_sc_hd__dfxtp_1
Xnetwork.cnt_main.counter\[12\]$_SDFF_PP0_ clknet_leaf_94_clk_net
+ _01729_ VSS VSS VDD VDD network.cnt_main.counter\[12\] sky130_fd_sc_hd__dfxtp_1
Xnetwork.cnt_main.counter\[13\]$_SDFF_PP0_ clknet_leaf_84_clk_net
+ _01866_ VSS VSS VDD VDD network.cnt_main.counter\[13\] sky130_fd_sc_hd__dfxtp_1
Xnetwork.cnt_main.counter\[1\]$_SDFF_PP0_ clknet_leaf_93_clk_net
+ _01740_ VSS VSS VDD VDD network.cnt_main.counter\[1\] sky130_fd_sc_hd__dfxtp_1
Xnetwork.cnt_main.counter\[2\]$_SDFF_PP1_ clknet_leaf_93_clk_net
+ _01739_ VSS VSS VDD VDD network.cnt_main.counter\[2\] sky130_fd_sc_hd__dfxtp_1
Xnetwork.cnt_main.counter\[3\]$_SDFF_PP0_ clknet_leaf_90_clk_net
+ _01738_ VSS VSS VDD VDD network.cnt_main.counter\[3\] sky130_fd_sc_hd__dfxtp_1
Xnetwork.cnt_main.counter\[4\]$_SDFF_PP0_ clknet_leaf_90_clk_net
+ _01737_ VSS VSS VDD VDD network.cnt_main.counter\[4\] sky130_fd_sc_hd__dfxtp_1
Xnetwork.cnt_main.counter\[5\]$_SDFF_PP0_ clknet_leaf_93_clk_net
+ _01736_ VSS VSS VDD VDD network.cnt_main.counter\[5\] sky130_fd_sc_hd__dfxtp_1
Xnetwork.cnt_main.counter\[6\]$_SDFF_PP1_ clknet_leaf_93_clk_net
+ _01735_ VSS VSS VDD VDD network.cnt_main.counter\[6\] sky130_fd_sc_hd__dfxtp_1
Xnetwork.cnt_main.counter\[7\]$_SDFF_PP1_ clknet_leaf_93_clk_net
+ _01734_ VSS VSS VDD VDD network.cnt_main.counter\[7\] sky130_fd_sc_hd__dfxtp_1
Xnetwork.cnt_main.counter\[8\]$_SDFF_PP1_ clknet_leaf_94_clk_net
+ _01733_ VSS VSS VDD VDD network.cnt_main.counter\[8\] sky130_fd_sc_hd__dfxtp_1
Xnetwork.cnt_main.counter\[9\]$_SDFF_PP0_ clknet_leaf_93_clk_net
+ _01732_ VSS VSS VDD VDD network.cnt_main.counter\[9\] sky130_fd_sc_hd__dfxtp_1
Xnetwork.hid_controler.addr_out\[0\]$_SDFF_PP0_ clknet_leaf_66_clk_net
+ _01728_ VSS VSS VDD VDD network.ctrl_addr\[0\] sky130_fd_sc_hd__dfxtp_1
Xnetwork.hid_controler.addr_out\[1\]$_SDFF_PP0_ clknet_leaf_100_clk_net
+ _01727_ VSS VSS VDD VDD network.ctrl_addr\[1\] sky130_fd_sc_hd__dfxtp_1
Xnetwork.hid_controler.addr_out\[2\]$_SDFF_PP0_ clknet_leaf_97_clk_net
+ _01726_ VSS VSS VDD VDD network.ctrl_addr\[2\] sky130_fd_sc_hd__dfxtp_1
Xnetwork.hid_controler.addr_out\[3\]$_SDFF_PP0_ clknet_leaf_100_clk_net
+ _01725_ VSS VSS VDD VDD network.ctrl_addr\[3\] sky130_fd_sc_hd__dfxtp_1
Xnetwork.hid_controler.addr_out\[4\]$_SDFF_PP0_ clknet_leaf_102_clk_net
+ _01724_ VSS VSS VDD VDD network.ctrl_addr\[4\] sky130_fd_sc_hd__dfxtp_1
Xnetwork.hid_controler.addr_out\[5\]$_SDFF_PP0_ clknet_leaf_66_clk_net
+ _01723_ VSS VSS VDD VDD network.ctrl_addr\[5\] sky130_fd_sc_hd__dfxtp_1
Xnetwork.hid_controler.addr_out\[6\]$_SDFF_PP0_ clknet_leaf_100_clk_net
+ _01722_ VSS VSS VDD VDD network.ctrl_addr\[6\] sky130_fd_sc_hd__dfxtp_1
Xnetwork.hid_controler.addr_out\[7\]$_SDFF_PP0_ clknet_leaf_100_clk_net
+ _01903_ VSS VSS VDD VDD network.ctrl_addr\[7\] sky130_fd_sc_hd__dfxtp_1
Xnetwork.hid_controler.spike_out$_SDFF_PP0_ clknet_leaf_99_clk_net
+ _01902_ VSS VSS VDD VDD network.ctrl_spk sky130_fd_sc_hd__dfxtp_1
Xnetwork.in_period\[0\]\[0\]$_DFFE_PP_ clknet_leaf_43_clk_load
+ net439 _03087_ VSS VSS VDD VDD network.in_period\[0\]\[0\]
+ sky130_fd_sc_hd__edfxtp_1
Xnetwork.in_period\[0\]\[1\]$_DFFE_PP_ clknet_leaf_43_clk_load
+ net430 _03087_ VSS VSS VDD VDD network.in_period\[0\]\[1\]
+ sky130_fd_sc_hd__edfxtp_1
Xnetwork.in_period\[0\]\[2\]$_DFFE_PP_ clknet_leaf_43_clk_load
+ net425 _03087_ VSS VSS VDD VDD network.in_period\[0\]\[2\]
+ sky130_fd_sc_hd__edfxtp_1
Xnetwork.in_period\[0\]\[3\]$_DFFE_PP_ clknet_leaf_43_clk_load
+ net415 _03087_ VSS VSS VDD VDD network.in_period\[0\]\[3\]
+ sky130_fd_sc_hd__edfxtp_1
Xnetwork.in_period\[100\]\[0\]$_DFFE_PP_ clknet_leaf_24_clk_load
+ net440 _03088_ VSS VSS VDD VDD network.in_period\[100\]\[0\]
+ sky130_fd_sc_hd__edfxtp_1
Xnetwork.in_period\[100\]\[1\]$_DFFE_PP_ clknet_leaf_24_clk_load
+ net429 _03088_ VSS VSS VDD VDD network.in_period\[100\]\[1\]
+ sky130_fd_sc_hd__edfxtp_1
Xnetwork.in_period\[100\]\[2\]$_DFFE_PP_ clknet_leaf_24_clk_load
+ net427 _03088_ VSS VSS VDD VDD network.in_period\[100\]\[2\]
+ sky130_fd_sc_hd__edfxtp_1
Xnetwork.in_period\[100\]\[3\]$_DFFE_PP_ clknet_leaf_25_clk_load
+ net414 _03088_ VSS VSS VDD VDD network.in_period\[100\]\[3\]
+ sky130_fd_sc_hd__edfxtp_1
Xnetwork.in_period\[101\]\[0\]$_DFFE_PP_ clknet_leaf_24_clk_load
+ net440 _03089_ VSS VSS VDD VDD network.in_period\[101\]\[0\]
+ sky130_fd_sc_hd__edfxtp_1
Xnetwork.in_period\[101\]\[1\]$_DFFE_PP_ clknet_leaf_24_clk_load
+ net429 _03089_ VSS VSS VDD VDD network.in_period\[101\]\[1\]
+ sky130_fd_sc_hd__edfxtp_1
Xnetwork.in_period\[101\]\[2\]$_DFFE_PP_ clknet_leaf_24_clk_load
+ net427 _03089_ VSS VSS VDD VDD network.in_period\[101\]\[2\]
+ sky130_fd_sc_hd__edfxtp_1
Xnetwork.in_period\[101\]\[3\]$_DFFE_PP_ clknet_leaf_24_clk_load
+ net414 _03089_ VSS VSS VDD VDD network.in_period\[101\]\[3\]
+ sky130_fd_sc_hd__edfxtp_1
Xnetwork.in_period\[102\]\[0\]$_DFFE_PP_ clknet_leaf_24_clk_load
+ net440 _03090_ VSS VSS VDD VDD network.in_period\[102\]\[0\]
+ sky130_fd_sc_hd__edfxtp_1
Xnetwork.in_period\[102\]\[1\]$_DFFE_PP_ clknet_leaf_24_clk_load
+ net429 _03090_ VSS VSS VDD VDD network.in_period\[102\]\[1\]
+ sky130_fd_sc_hd__edfxtp_1
Xnetwork.in_period\[102\]\[2\]$_DFFE_PP_ clknet_leaf_24_clk_load
+ net427 _03090_ VSS VSS VDD VDD network.in_period\[102\]\[2\]
+ sky130_fd_sc_hd__edfxtp_1
Xnetwork.in_period\[102\]\[3\]$_DFFE_PP_ clknet_leaf_24_clk_load
+ net414 _03090_ VSS VSS VDD VDD network.in_period\[102\]\[3\]
+ sky130_fd_sc_hd__edfxtp_1
Xnetwork.in_period\[103\]\[0\]$_DFFE_PP_ clknet_leaf_25_clk_load
+ net440 _03091_ VSS VSS VDD VDD network.in_period\[103\]\[0\]
+ sky130_fd_sc_hd__edfxtp_1
Xnetwork.in_period\[103\]\[1\]$_DFFE_PP_ clknet_leaf_25_clk_load
+ net429 _03091_ VSS VSS VDD VDD network.in_period\[103\]\[1\]
+ sky130_fd_sc_hd__edfxtp_1
Xnetwork.in_period\[103\]\[2\]$_DFFE_PP_ clknet_leaf_25_clk_load
+ net426 _03091_ VSS VSS VDD VDD network.in_period\[103\]\[2\]
+ sky130_fd_sc_hd__edfxtp_1
Xnetwork.in_period\[103\]\[3\]$_DFFE_PP_ clknet_leaf_25_clk_load
+ net414 _03091_ VSS VSS VDD VDD network.in_period\[103\]\[3\]
+ sky130_fd_sc_hd__edfxtp_1
Xnetwork.in_period\[104\]\[0\]$_DFFE_PP_ clknet_leaf_23_clk_load
+ net440 _03092_ VSS VSS VDD VDD network.in_period\[104\]\[0\]
+ sky130_fd_sc_hd__edfxtp_1
Xnetwork.in_period\[104\]\[1\]$_DFFE_PP_ clknet_leaf_23_clk_load
+ net434 _03092_ VSS VSS VDD VDD network.in_period\[104\]\[1\]
+ sky130_fd_sc_hd__edfxtp_1
Xnetwork.in_period\[104\]\[2\]$_DFFE_PP_ clknet_leaf_23_clk_load
+ net427 _03092_ VSS VSS VDD VDD network.in_period\[104\]\[2\]
+ sky130_fd_sc_hd__edfxtp_1
Xnetwork.in_period\[104\]\[3\]$_DFFE_PP_ clknet_leaf_23_clk_load
+ net415 _03092_ VSS VSS VDD VDD network.in_period\[104\]\[3\]
+ sky130_fd_sc_hd__edfxtp_1
Xnetwork.in_period\[105\]\[0\]$_DFFE_PP_ clknet_leaf_8_clk_load
+ net450 _03093_ VSS VSS VDD VDD network.in_period\[105\]\[0\]
+ sky130_fd_sc_hd__edfxtp_1
Xnetwork.in_period\[105\]\[1\]$_DFFE_PP_ clknet_leaf_8_clk_load
+ net434 _03093_ VSS VSS VDD VDD network.in_period\[105\]\[1\]
+ sky130_fd_sc_hd__edfxtp_1
Xnetwork.in_period\[105\]\[2\]$_DFFE_PP_ clknet_leaf_8_clk_load
+ net427 _03093_ VSS VSS VDD VDD network.in_period\[105\]\[2\]
+ sky130_fd_sc_hd__edfxtp_1
Xnetwork.in_period\[105\]\[3\]$_DFFE_PP_ clknet_leaf_8_clk_load
+ net415 _03093_ VSS VSS VDD VDD network.in_period\[105\]\[3\]
+ sky130_fd_sc_hd__edfxtp_1
Xnetwork.in_period\[106\]\[0\]$_DFFE_PP_ clknet_leaf_7_clk_load
+ net438 _03094_ VSS VSS VDD VDD network.in_period\[106\]\[0\]
+ sky130_fd_sc_hd__edfxtp_1
Xnetwork.in_period\[106\]\[1\]$_DFFE_PP_ clknet_leaf_7_clk_load
+ net434 _03094_ VSS VSS VDD VDD network.in_period\[106\]\[1\]
+ sky130_fd_sc_hd__edfxtp_1
Xnetwork.in_period\[106\]\[2\]$_DFFE_PP_ clknet_leaf_7_clk_load
+ net427 _03094_ VSS VSS VDD VDD network.in_period\[106\]\[2\]
+ sky130_fd_sc_hd__edfxtp_1
Xnetwork.in_period\[106\]\[3\]$_DFFE_PP_ clknet_leaf_7_clk_load
+ net415 _03094_ VSS VSS VDD VDD network.in_period\[106\]\[3\]
+ sky130_fd_sc_hd__edfxtp_1
Xnetwork.in_period\[107\]\[0\]$_DFFE_PP_ clknet_leaf_6_clk_load
+ net438 _03095_ VSS VSS VDD VDD network.in_period\[107\]\[0\]
+ sky130_fd_sc_hd__edfxtp_1
Xnetwork.in_period\[107\]\[1\]$_DFFE_PP_ clknet_leaf_6_clk_load
+ net430 _03095_ VSS VSS VDD VDD network.in_period\[107\]\[1\]
+ sky130_fd_sc_hd__edfxtp_1
Xnetwork.in_period\[107\]\[2\]$_DFFE_PP_ clknet_leaf_6_clk_load
+ net427 _03095_ VSS VSS VDD VDD network.in_period\[107\]\[2\]
+ sky130_fd_sc_hd__edfxtp_1
Xnetwork.in_period\[107\]\[3\]$_DFFE_PP_ clknet_leaf_6_clk_load
+ net415 _03095_ VSS VSS VDD VDD network.in_period\[107\]\[3\]
+ sky130_fd_sc_hd__edfxtp_1
Xnetwork.in_period\[108\]\[0\]$_DFFE_PP_ clknet_leaf_23_clk_load
+ net440 _03096_ VSS VSS VDD VDD network.in_period\[108\]\[0\]
+ sky130_fd_sc_hd__edfxtp_1
Xnetwork.in_period\[108\]\[1\]$_DFFE_PP_ clknet_leaf_23_clk_load
+ net434 _03096_ VSS VSS VDD VDD network.in_period\[108\]\[1\]
+ sky130_fd_sc_hd__edfxtp_1
Xnetwork.in_period\[108\]\[2\]$_DFFE_PP_ clknet_leaf_23_clk_load
+ net427 _03096_ VSS VSS VDD VDD network.in_period\[108\]\[2\]
+ sky130_fd_sc_hd__edfxtp_1
Xnetwork.in_period\[108\]\[3\]$_DFFE_PP_ clknet_leaf_23_clk_load
+ net414 _03096_ VSS VSS VDD VDD network.in_period\[108\]\[3\]
+ sky130_fd_sc_hd__edfxtp_1
Xnetwork.in_period\[109\]\[0\]$_DFFE_PP_ clknet_leaf_7_clk_load
+ net438 _03097_ VSS VSS VDD VDD network.in_period\[109\]\[0\]
+ sky130_fd_sc_hd__edfxtp_1
Xnetwork.in_period\[109\]\[1\]$_DFFE_PP_ clknet_leaf_7_clk_load
+ net434 _03097_ VSS VSS VDD VDD network.in_period\[109\]\[1\]
+ sky130_fd_sc_hd__edfxtp_1
Xnetwork.in_period\[109\]\[2\]$_DFFE_PP_ clknet_leaf_7_clk_load
+ net427 _03097_ VSS VSS VDD VDD network.in_period\[109\]\[2\]
+ sky130_fd_sc_hd__edfxtp_1
Xnetwork.in_period\[109\]\[3\]$_DFFE_PP_ clknet_leaf_7_clk_load
+ net415 _03097_ VSS VSS VDD VDD network.in_period\[109\]\[3\]
+ sky130_fd_sc_hd__edfxtp_1
Xnetwork.in_period\[10\]\[0\]$_DFFE_PP_ clknet_leaf_36_clk_load
+ net440 _03098_ VSS VSS VDD VDD network.in_period\[10\]\[0\]
+ sky130_fd_sc_hd__edfxtp_1
Xnetwork.in_period\[10\]\[1\]$_DFFE_PP_ clknet_leaf_36_clk_load
+ net429 _03098_ VSS VSS VDD VDD network.in_period\[10\]\[1\]
+ sky130_fd_sc_hd__edfxtp_1
Xnetwork.in_period\[10\]\[2\]$_DFFE_PP_ clknet_leaf_36_clk_load
+ net427 _03098_ VSS VSS VDD VDD network.in_period\[10\]\[2\]
+ sky130_fd_sc_hd__edfxtp_1
Xnetwork.in_period\[10\]\[3\]$_DFFE_PP_ clknet_leaf_36_clk_load
+ net414 _03098_ VSS VSS VDD VDD network.in_period\[10\]\[3\]
+ sky130_fd_sc_hd__edfxtp_1
Xnetwork.in_period\[110\]\[0\]$_DFFE_PP_ clknet_leaf_7_clk_load
+ net438 _03099_ VSS VSS VDD VDD network.in_period\[110\]\[0\]
+ sky130_fd_sc_hd__edfxtp_1
Xnetwork.in_period\[110\]\[1\]$_DFFE_PP_ clknet_leaf_7_clk_load
+ net434 _03099_ VSS VSS VDD VDD network.in_period\[110\]\[1\]
+ sky130_fd_sc_hd__edfxtp_1
Xnetwork.in_period\[110\]\[2\]$_DFFE_PP_ clknet_leaf_7_clk_load
+ net427 _03099_ VSS VSS VDD VDD network.in_period\[110\]\[2\]
+ sky130_fd_sc_hd__edfxtp_1
Xnetwork.in_period\[110\]\[3\]$_DFFE_PP_ clknet_leaf_7_clk_load
+ net415 _03099_ VSS VSS VDD VDD network.in_period\[110\]\[3\]
+ sky130_fd_sc_hd__edfxtp_1
Xnetwork.in_period\[111\]\[0\]$_DFFE_PP_ clknet_leaf_8_clk_load
+ net437 _03100_ VSS VSS VDD VDD network.in_period\[111\]\[0\]
+ sky130_fd_sc_hd__edfxtp_1
Xnetwork.in_period\[111\]\[1\]$_DFFE_PP_ clknet_leaf_8_clk_load
+ net430 _03100_ VSS VSS VDD VDD network.in_period\[111\]\[1\]
+ sky130_fd_sc_hd__edfxtp_1
Xnetwork.in_period\[111\]\[2\]$_DFFE_PP_ clknet_leaf_8_clk_load
+ net427 _03100_ VSS VSS VDD VDD network.in_period\[111\]\[2\]
+ sky130_fd_sc_hd__edfxtp_1
Xnetwork.in_period\[111\]\[3\]$_DFFE_PP_ clknet_leaf_8_clk_load
+ net415 _03100_ VSS VSS VDD VDD network.in_period\[111\]\[3\]
+ sky130_fd_sc_hd__edfxtp_1
Xnetwork.in_period\[112\]\[0\]$_DFFE_PP_ clknet_leaf_5_clk_load
+ net438 _03101_ VSS VSS VDD VDD network.in_period\[112\]\[0\]
+ sky130_fd_sc_hd__edfxtp_1
Xnetwork.in_period\[112\]\[1\]$_DFFE_PP_ clknet_leaf_5_clk_load
+ net434 _03101_ VSS VSS VDD VDD network.in_period\[112\]\[1\]
+ sky130_fd_sc_hd__edfxtp_1
Xnetwork.in_period\[112\]\[2\]$_DFFE_PP_ clknet_leaf_5_clk_load
+ net427 _03101_ VSS VSS VDD VDD network.in_period\[112\]\[2\]
+ sky130_fd_sc_hd__edfxtp_1
Xnetwork.in_period\[112\]\[3\]$_DFFE_PP_ clknet_leaf_5_clk_load
+ net415 _03101_ VSS VSS VDD VDD network.in_period\[112\]\[3\]
+ sky130_fd_sc_hd__edfxtp_1
Xnetwork.in_period\[113\]\[0\]$_DFFE_PP_ clknet_leaf_3_clk_load
+ net437 _03102_ VSS VSS VDD VDD network.in_period\[113\]\[0\]
+ sky130_fd_sc_hd__edfxtp_1
Xnetwork.in_period\[113\]\[1\]$_DFFE_PP_ clknet_leaf_3_clk_load
+ net434 _03102_ VSS VSS VDD VDD network.in_period\[113\]\[1\]
+ sky130_fd_sc_hd__edfxtp_1
Xnetwork.in_period\[113\]\[2\]$_DFFE_PP_ clknet_leaf_3_clk_load
+ net427 _03102_ VSS VSS VDD VDD network.in_period\[113\]\[2\]
+ sky130_fd_sc_hd__edfxtp_1
Xnetwork.in_period\[113\]\[3\]$_DFFE_PP_ clknet_leaf_3_clk_load
+ net415 _03102_ VSS VSS VDD VDD network.in_period\[113\]\[3\]
+ sky130_fd_sc_hd__edfxtp_1
Xnetwork.in_period\[114\]\[0\]$_DFFE_PP_ clknet_leaf_12_clk_load
+ net437 _03103_ VSS VSS VDD VDD network.in_period\[114\]\[0\]
+ sky130_fd_sc_hd__edfxtp_1
Xnetwork.in_period\[114\]\[1\]$_DFFE_PP_ clknet_leaf_12_clk_load
+ net434 _03103_ VSS VSS VDD VDD network.in_period\[114\]\[1\]
+ sky130_fd_sc_hd__edfxtp_1
Xnetwork.in_period\[114\]\[2\]$_DFFE_PP_ clknet_leaf_12_clk_load
+ net425 _03103_ VSS VSS VDD VDD network.in_period\[114\]\[2\]
+ sky130_fd_sc_hd__edfxtp_1
Xnetwork.in_period\[114\]\[3\]$_DFFE_PP_ clknet_leaf_12_clk_load
+ net417 _03103_ VSS VSS VDD VDD network.in_period\[114\]\[3\]
+ sky130_fd_sc_hd__edfxtp_1
Xnetwork.in_period\[115\]\[0\]$_DFFE_PP_ clknet_leaf_11_clk_load
+ net437 _03104_ VSS VSS VDD VDD network.in_period\[115\]\[0\]
+ sky130_fd_sc_hd__edfxtp_1
Xnetwork.in_period\[115\]\[1\]$_DFFE_PP_ clknet_leaf_10_clk_load
+ net434 _03104_ VSS VSS VDD VDD network.in_period\[115\]\[1\]
+ sky130_fd_sc_hd__edfxtp_1
Xnetwork.in_period\[115\]\[2\]$_DFFE_PP_ clknet_leaf_10_clk_load
+ net425 _03104_ VSS VSS VDD VDD network.in_period\[115\]\[2\]
+ sky130_fd_sc_hd__edfxtp_1
Xnetwork.in_period\[115\]\[3\]$_DFFE_PP_ clknet_leaf_10_clk_load
+ net417 _03104_ VSS VSS VDD VDD network.in_period\[115\]\[3\]
+ sky130_fd_sc_hd__edfxtp_1
Xnetwork.in_period\[116\]\[0\]$_DFFE_PP_ clknet_leaf_6_clk_load
+ net438 _03105_ VSS VSS VDD VDD network.in_period\[116\]\[0\]
+ sky130_fd_sc_hd__edfxtp_1
Xnetwork.in_period\[116\]\[1\]$_DFFE_PP_ clknet_leaf_6_clk_load
+ net430 _03105_ VSS VSS VDD VDD network.in_period\[116\]\[1\]
+ sky130_fd_sc_hd__edfxtp_1
Xnetwork.in_period\[116\]\[2\]$_DFFE_PP_ clknet_leaf_6_clk_load
+ net427 _03105_ VSS VSS VDD VDD network.in_period\[116\]\[2\]
+ sky130_fd_sc_hd__edfxtp_1
Xnetwork.in_period\[116\]\[3\]$_DFFE_PP_ clknet_leaf_6_clk_load
+ net415 _03105_ VSS VSS VDD VDD network.in_period\[116\]\[3\]
+ sky130_fd_sc_hd__edfxtp_1
Xnetwork.in_period\[117\]\[0\]$_DFFE_PP_ clknet_leaf_5_clk_load
+ net438 _03106_ VSS VSS VDD VDD network.in_period\[117\]\[0\]
+ sky130_fd_sc_hd__edfxtp_1
Xnetwork.in_period\[117\]\[1\]$_DFFE_PP_ clknet_leaf_5_clk_load
+ net428 _03106_ VSS VSS VDD VDD network.in_period\[117\]\[1\]
+ sky130_fd_sc_hd__edfxtp_1
Xnetwork.in_period\[117\]\[2\]$_DFFE_PP_ clknet_leaf_5_clk_load
+ net427 _03106_ VSS VSS VDD VDD network.in_period\[117\]\[2\]
+ sky130_fd_sc_hd__edfxtp_1
Xnetwork.in_period\[117\]\[3\]$_DFFE_PP_ clknet_leaf_5_clk_load
+ net415 _03106_ VSS VSS VDD VDD network.in_period\[117\]\[3\]
+ sky130_fd_sc_hd__edfxtp_1
Xnetwork.in_period\[118\]\[0\]$_DFFE_PP_ clknet_leaf_11_clk_load
+ net437 _03107_ VSS VSS VDD VDD network.in_period\[118\]\[0\]
+ sky130_fd_sc_hd__edfxtp_1
Xnetwork.in_period\[118\]\[1\]$_DFFE_PP_ clknet_leaf_11_clk_load
+ net434 _03107_ VSS VSS VDD VDD network.in_period\[118\]\[1\]
+ sky130_fd_sc_hd__edfxtp_1
Xnetwork.in_period\[118\]\[2\]$_DFFE_PP_ clknet_leaf_11_clk_load
+ net425 _03107_ VSS VSS VDD VDD network.in_period\[118\]\[2\]
+ sky130_fd_sc_hd__edfxtp_1
Xnetwork.in_period\[118\]\[3\]$_DFFE_PP_ clknet_leaf_11_clk_load
+ net417 _03107_ VSS VSS VDD VDD network.in_period\[118\]\[3\]
+ sky130_fd_sc_hd__edfxtp_1
Xnetwork.in_period\[119\]\[0\]$_DFFE_PP_ clknet_leaf_3_clk_load
+ net438 _03108_ VSS VSS VDD VDD network.in_period\[119\]\[0\]
+ sky130_fd_sc_hd__edfxtp_1
Xnetwork.in_period\[119\]\[1\]$_DFFE_PP_ clknet_leaf_4_clk_load
+ net434 _03108_ VSS VSS VDD VDD network.in_period\[119\]\[1\]
+ sky130_fd_sc_hd__edfxtp_1
Xnetwork.in_period\[119\]\[2\]$_DFFE_PP_ clknet_leaf_3_clk_load
+ net427 _03108_ VSS VSS VDD VDD network.in_period\[119\]\[2\]
+ sky130_fd_sc_hd__edfxtp_1
Xnetwork.in_period\[119\]\[3\]$_DFFE_PP_ clknet_leaf_3_clk_load
+ net415 _03108_ VSS VSS VDD VDD network.in_period\[119\]\[3\]
+ sky130_fd_sc_hd__edfxtp_1
Xnetwork.in_period\[11\]\[0\]$_DFFE_PP_ clknet_leaf_38_clk_load
+ net440 _03109_ VSS VSS VDD VDD network.in_period\[11\]\[0\]
+ sky130_fd_sc_hd__edfxtp_1
Xnetwork.in_period\[11\]\[1\]$_DFFE_PP_ clknet_leaf_38_clk_load
+ net429 _03109_ VSS VSS VDD VDD network.in_period\[11\]\[1\]
+ sky130_fd_sc_hd__edfxtp_1
Xnetwork.in_period\[11\]\[2\]$_DFFE_PP_ clknet_leaf_38_clk_load
+ net426 _03109_ VSS VSS VDD VDD network.in_period\[11\]\[2\]
+ sky130_fd_sc_hd__edfxtp_1
Xnetwork.in_period\[11\]\[3\]$_DFFE_PP_ clknet_leaf_38_clk_load
+ net414 _03109_ VSS VSS VDD VDD network.in_period\[11\]\[3\]
+ sky130_fd_sc_hd__edfxtp_1
Xnetwork.in_period\[120\]\[0\]$_DFFE_PP_ clknet_leaf_4_clk_load
+ net438 _03110_ VSS VSS VDD VDD network.in_period\[120\]\[0\]
+ sky130_fd_sc_hd__edfxtp_1
Xnetwork.in_period\[120\]\[1\]$_DFFE_PP_ clknet_leaf_4_clk_load
+ net428 _03110_ VSS VSS VDD VDD network.in_period\[120\]\[1\]
+ sky130_fd_sc_hd__edfxtp_1
Xnetwork.in_period\[120\]\[2\]$_DFFE_PP_ clknet_leaf_4_clk_load
+ net427 _03110_ VSS VSS VDD VDD network.in_period\[120\]\[2\]
+ sky130_fd_sc_hd__edfxtp_1
Xnetwork.in_period\[120\]\[3\]$_DFFE_PP_ clknet_leaf_4_clk_load
+ net415 _03110_ VSS VSS VDD VDD network.in_period\[120\]\[3\]
+ sky130_fd_sc_hd__edfxtp_1
Xnetwork.in_period\[121\]\[0\]$_DFFE_PP_ clknet_leaf_2_clk_load
+ net438 _03111_ VSS VSS VDD VDD network.in_period\[121\]\[0\]
+ sky130_fd_sc_hd__edfxtp_1
Xnetwork.in_period\[121\]\[1\]$_DFFE_PP_ clknet_leaf_2_clk_load
+ net428 _03111_ VSS VSS VDD VDD network.in_period\[121\]\[1\]
+ sky130_fd_sc_hd__edfxtp_1
Xnetwork.in_period\[121\]\[2\]$_DFFE_PP_ clknet_leaf_2_clk_load
+ net425 _03111_ VSS VSS VDD VDD network.in_period\[121\]\[2\]
+ sky130_fd_sc_hd__edfxtp_1
Xnetwork.in_period\[121\]\[3\]$_DFFE_PP_ clknet_leaf_2_clk_load
+ net453 _03111_ VSS VSS VDD VDD network.in_period\[121\]\[3\]
+ sky130_fd_sc_hd__edfxtp_1
Xnetwork.in_period\[122\]\[0\]$_DFFE_PP_ clknet_leaf_4_clk_load
+ net438 _03112_ VSS VSS VDD VDD network.in_period\[122\]\[0\]
+ sky130_fd_sc_hd__edfxtp_1
Xnetwork.in_period\[122\]\[1\]$_DFFE_PP_ clknet_leaf_4_clk_load
+ net434 _03112_ VSS VSS VDD VDD network.in_period\[122\]\[1\]
+ sky130_fd_sc_hd__edfxtp_1
Xnetwork.in_period\[122\]\[2\]$_DFFE_PP_ clknet_leaf_4_clk_load
+ net427 _03112_ VSS VSS VDD VDD network.in_period\[122\]\[2\]
+ sky130_fd_sc_hd__edfxtp_1
Xnetwork.in_period\[122\]\[3\]$_DFFE_PP_ clknet_leaf_4_clk_load
+ net415 _03112_ VSS VSS VDD VDD network.in_period\[122\]\[3\]
+ sky130_fd_sc_hd__edfxtp_1
Xnetwork.in_period\[123\]\[0\]$_DFFE_PP_ clknet_leaf_2_clk_load
+ net438 _03113_ VSS VSS VDD VDD network.in_period\[123\]\[0\]
+ sky130_fd_sc_hd__edfxtp_1
Xnetwork.in_period\[123\]\[1\]$_DFFE_PP_ clknet_leaf_2_clk_load
+ net428 _03113_ VSS VSS VDD VDD network.in_period\[123\]\[1\]
+ sky130_fd_sc_hd__edfxtp_1
Xnetwork.in_period\[123\]\[2\]$_DFFE_PP_ clknet_leaf_2_clk_load
+ net421 _03113_ VSS VSS VDD VDD network.in_period\[123\]\[2\]
+ sky130_fd_sc_hd__edfxtp_1
Xnetwork.in_period\[123\]\[3\]$_DFFE_PP_ clknet_leaf_2_clk_load
+ net453 _03113_ VSS VSS VDD VDD network.in_period\[123\]\[3\]
+ sky130_fd_sc_hd__edfxtp_1
Xnetwork.in_period\[124\]\[0\]$_DFFE_PP_ clknet_leaf_4_clk_load
+ net438 _03114_ VSS VSS VDD VDD network.in_period\[124\]\[0\]
+ sky130_fd_sc_hd__edfxtp_1
Xnetwork.in_period\[124\]\[1\]$_DFFE_PP_ clknet_leaf_0_clk_load
+ net428 _03114_ VSS VSS VDD VDD network.in_period\[124\]\[1\]
+ sky130_fd_sc_hd__edfxtp_1
Xnetwork.in_period\[124\]\[2\]$_DFFE_PP_ clknet_leaf_0_clk_load
+ net427 _03114_ VSS VSS VDD VDD network.in_period\[124\]\[2\]
+ sky130_fd_sc_hd__edfxtp_1
Xnetwork.in_period\[124\]\[3\]$_DFFE_PP_ clknet_leaf_0_clk_load
+ net415 _03114_ VSS VSS VDD VDD network.in_period\[124\]\[3\]
+ sky130_fd_sc_hd__edfxtp_1
Xnetwork.in_period\[125\]\[0\]$_DFFE_PP_ clknet_leaf_0_clk_load
+ net438 _03115_ VSS VSS VDD VDD network.in_period\[125\]\[0\]
+ sky130_fd_sc_hd__edfxtp_1
Xnetwork.in_period\[125\]\[1\]$_DFFE_PP_ clknet_leaf_0_clk_load
+ net428 _03115_ VSS VSS VDD VDD network.in_period\[125\]\[1\]
+ sky130_fd_sc_hd__edfxtp_1
Xnetwork.in_period\[125\]\[2\]$_DFFE_PP_ clknet_leaf_0_clk_load
+ net427 _03115_ VSS VSS VDD VDD network.in_period\[125\]\[2\]
+ sky130_fd_sc_hd__edfxtp_1
Xnetwork.in_period\[125\]\[3\]$_DFFE_PP_ clknet_leaf_0_clk_load
+ net415 _03115_ VSS VSS VDD VDD network.in_period\[125\]\[3\]
+ sky130_fd_sc_hd__edfxtp_1
Xnetwork.in_period\[126\]\[0\]$_DFFE_PP_ clknet_leaf_0_clk_load
+ net438 _03116_ VSS VSS VDD VDD network.in_period\[126\]\[0\]
+ sky130_fd_sc_hd__edfxtp_1
Xnetwork.in_period\[126\]\[1\]$_DFFE_PP_ clknet_leaf_0_clk_load
+ net428 _03116_ VSS VSS VDD VDD network.in_period\[126\]\[1\]
+ sky130_fd_sc_hd__edfxtp_1
Xnetwork.in_period\[126\]\[2\]$_DFFE_PP_ clknet_leaf_109_clk_load
+ net425 _03116_ VSS VSS VDD VDD network.in_period\[126\]\[2\]
+ sky130_fd_sc_hd__edfxtp_1
Xnetwork.in_period\[126\]\[3\]$_DFFE_PP_ clknet_leaf_1_clk_load
+ net415 _03116_ VSS VSS VDD VDD network.in_period\[126\]\[3\]
+ sky130_fd_sc_hd__edfxtp_1
Xnetwork.in_period\[127\]\[0\]$_DFFE_PP_ clknet_leaf_1_clk_load
+ net438 _03117_ VSS VSS VDD VDD network.in_period\[127\]\[0\]
+ sky130_fd_sc_hd__edfxtp_1
Xnetwork.in_period\[127\]\[1\]$_DFFE_PP_ clknet_leaf_1_clk_load
+ net428 _03117_ VSS VSS VDD VDD network.in_period\[127\]\[1\]
+ sky130_fd_sc_hd__edfxtp_1
Xnetwork.in_period\[127\]\[2\]$_DFFE_PP_ clknet_leaf_1_clk_load
+ net425 _03117_ VSS VSS VDD VDD network.in_period\[127\]\[2\]
+ sky130_fd_sc_hd__edfxtp_1
Xnetwork.in_period\[127\]\[3\]$_DFFE_PP_ clknet_leaf_1_clk_load
+ net453 _03117_ VSS VSS VDD VDD network.in_period\[127\]\[3\]
+ sky130_fd_sc_hd__edfxtp_1
Xnetwork.in_period\[128\]\[0\]$_DFFE_PP_ clknet_leaf_103_clk_load
+ net438 _03118_ VSS VSS VDD VDD network.in_period\[128\]\[0\]
+ sky130_fd_sc_hd__edfxtp_1
Xnetwork.in_period\[128\]\[1\]$_DFFE_PP_ clknet_leaf_103_clk_load
+ net428 _03118_ VSS VSS VDD VDD network.in_period\[128\]\[1\]
+ sky130_fd_sc_hd__edfxtp_1
Xnetwork.in_period\[128\]\[2\]$_DFFE_PP_ clknet_leaf_103_clk_load
+ net421 _03118_ VSS VSS VDD VDD network.in_period\[128\]\[2\]
+ sky130_fd_sc_hd__edfxtp_1
Xnetwork.in_period\[128\]\[3\]$_DFFE_PP_ clknet_leaf_103_clk_load
+ net420 _03118_ VSS VSS VDD VDD network.in_period\[128\]\[3\]
+ sky130_fd_sc_hd__edfxtp_1
Xnetwork.in_period\[129\]\[0\]$_DFFE_PP_ clknet_leaf_95_clk_load
+ net437 _03119_ VSS VSS VDD VDD network.in_period\[129\]\[0\]
+ sky130_fd_sc_hd__edfxtp_1
Xnetwork.in_period\[129\]\[1\]$_DFFE_PP_ clknet_leaf_95_clk_load
+ net434 _03119_ VSS VSS VDD VDD network.in_period\[129\]\[1\]
+ sky130_fd_sc_hd__edfxtp_1
Xnetwork.in_period\[129\]\[2\]$_DFFE_PP_ clknet_leaf_95_clk_load
+ net424 _03119_ VSS VSS VDD VDD network.in_period\[129\]\[2\]
+ sky130_fd_sc_hd__edfxtp_1
Xnetwork.in_period\[129\]\[3\]$_DFFE_PP_ clknet_leaf_95_clk_load
+ net417 _03119_ VSS VSS VDD VDD network.in_period\[129\]\[3\]
+ sky130_fd_sc_hd__edfxtp_1
Xnetwork.in_period\[12\]\[0\]$_DFFE_PP_ clknet_leaf_43_clk_load
+ net439 _03120_ VSS VSS VDD VDD network.in_period\[12\]\[0\]
+ sky130_fd_sc_hd__edfxtp_1
Xnetwork.in_period\[12\]\[1\]$_DFFE_PP_ clknet_leaf_43_clk_load
+ net430 _03120_ VSS VSS VDD VDD network.in_period\[12\]\[1\]
+ sky130_fd_sc_hd__edfxtp_1
Xnetwork.in_period\[12\]\[2\]$_DFFE_PP_ clknet_leaf_43_clk_load
+ net425 _03120_ VSS VSS VDD VDD network.in_period\[12\]\[2\]
+ sky130_fd_sc_hd__edfxtp_1
Xnetwork.in_period\[12\]\[3\]$_DFFE_PP_ clknet_leaf_43_clk_load
+ net415 _03120_ VSS VSS VDD VDD network.in_period\[12\]\[3\]
+ sky130_fd_sc_hd__edfxtp_1
Xnetwork.in_period\[130\]\[0\]$_DFFE_PP_ clknet_leaf_101_clk_load
+ net438 _03121_ VSS VSS VDD VDD network.in_period\[130\]\[0\]
+ sky130_fd_sc_hd__edfxtp_1
Xnetwork.in_period\[130\]\[1\]$_DFFE_PP_ clknet_leaf_101_clk_load
+ net428 _03121_ VSS VSS VDD VDD network.in_period\[130\]\[1\]
+ sky130_fd_sc_hd__edfxtp_1
Xnetwork.in_period\[130\]\[2\]$_DFFE_PP_ clknet_leaf_101_clk_load
+ net421 _03121_ VSS VSS VDD VDD network.in_period\[130\]\[2\]
+ sky130_fd_sc_hd__edfxtp_1
Xnetwork.in_period\[130\]\[3\]$_DFFE_PP_ clknet_leaf_103_clk_load
+ net420 _03121_ VSS VSS VDD VDD network.in_period\[130\]\[3\]
+ sky130_fd_sc_hd__edfxtp_1
Xnetwork.in_period\[131\]\[0\]$_DFFE_PP_ clknet_leaf_95_clk_load
+ net437 _03122_ VSS VSS VDD VDD network.in_period\[131\]\[0\]
+ sky130_fd_sc_hd__edfxtp_1
Xnetwork.in_period\[131\]\[1\]$_DFFE_PP_ clknet_leaf_95_clk_load
+ net434 _03122_ VSS VSS VDD VDD network.in_period\[131\]\[1\]
+ sky130_fd_sc_hd__edfxtp_1
Xnetwork.in_period\[131\]\[2\]$_DFFE_PP_ clknet_leaf_95_clk_load
+ net424 _03122_ VSS VSS VDD VDD network.in_period\[131\]\[2\]
+ sky130_fd_sc_hd__edfxtp_1
Xnetwork.in_period\[131\]\[3\]$_DFFE_PP_ clknet_leaf_95_clk_load
+ net417 _03122_ VSS VSS VDD VDD network.in_period\[131\]\[3\]
+ sky130_fd_sc_hd__edfxtp_1
Xnetwork.in_period\[132\]\[0\]$_DFFE_PP_ clknet_leaf_103_clk_load
+ net438 _03123_ VSS VSS VDD VDD network.in_period\[132\]\[0\]
+ sky130_fd_sc_hd__edfxtp_1
Xnetwork.in_period\[132\]\[1\]$_DFFE_PP_ clknet_leaf_103_clk_load
+ net428 _03123_ VSS VSS VDD VDD network.in_period\[132\]\[1\]
+ sky130_fd_sc_hd__edfxtp_1
Xnetwork.in_period\[132\]\[2\]$_DFFE_PP_ clknet_leaf_103_clk_load
+ net421 _03123_ VSS VSS VDD VDD network.in_period\[132\]\[2\]
+ sky130_fd_sc_hd__edfxtp_1
Xnetwork.in_period\[132\]\[3\]$_DFFE_PP_ clknet_leaf_103_clk_load
+ net420 _03123_ VSS VSS VDD VDD network.in_period\[132\]\[3\]
+ sky130_fd_sc_hd__edfxtp_1
Xnetwork.in_period\[133\]\[0\]$_DFFE_PP_ clknet_leaf_96_clk_load
+ net437 _03124_ VSS VSS VDD VDD network.in_period\[133\]\[0\]
+ sky130_fd_sc_hd__edfxtp_1
Xnetwork.in_period\[133\]\[1\]$_DFFE_PP_ clknet_leaf_96_clk_load
+ net433 _03124_ VSS VSS VDD VDD network.in_period\[133\]\[1\]
+ sky130_fd_sc_hd__edfxtp_1
Xnetwork.in_period\[133\]\[2\]$_DFFE_PP_ clknet_leaf_97_clk_load
+ net424 _03124_ VSS VSS VDD VDD network.in_period\[133\]\[2\]
+ sky130_fd_sc_hd__edfxtp_1
Xnetwork.in_period\[133\]\[3\]$_DFFE_PP_ clknet_leaf_96_clk_load
+ net420 _03124_ VSS VSS VDD VDD network.in_period\[133\]\[3\]
+ sky130_fd_sc_hd__edfxtp_1
Xnetwork.in_period\[134\]\[0\]$_DFFE_PP_ clknet_leaf_96_clk_load
+ net437 _03125_ VSS VSS VDD VDD network.in_period\[134\]\[0\]
+ sky130_fd_sc_hd__edfxtp_1
Xnetwork.in_period\[134\]\[1\]$_DFFE_PP_ clknet_leaf_98_clk_load
+ net433 _03125_ VSS VSS VDD VDD network.in_period\[134\]\[1\]
+ sky130_fd_sc_hd__edfxtp_1
Xnetwork.in_period\[134\]\[2\]$_DFFE_PP_ clknet_leaf_96_clk_load
+ net424 _03125_ VSS VSS VDD VDD network.in_period\[134\]\[2\]
+ sky130_fd_sc_hd__edfxtp_1
Xnetwork.in_period\[134\]\[3\]$_DFFE_PP_ clknet_leaf_96_clk_load
+ net420 _03125_ VSS VSS VDD VDD network.in_period\[134\]\[3\]
+ sky130_fd_sc_hd__edfxtp_1
Xnetwork.in_period\[135\]\[0\]$_DFFE_PP_ clknet_leaf_96_clk_load
+ net437 _03126_ VSS VSS VDD VDD network.in_period\[135\]\[0\]
+ sky130_fd_sc_hd__edfxtp_1
Xnetwork.in_period\[135\]\[1\]$_DFFE_PP_ clknet_leaf_96_clk_load
+ net434 _03126_ VSS VSS VDD VDD network.in_period\[135\]\[1\]
+ sky130_fd_sc_hd__edfxtp_1
Xnetwork.in_period\[135\]\[2\]$_DFFE_PP_ clknet_leaf_96_clk_load
+ net424 _03126_ VSS VSS VDD VDD network.in_period\[135\]\[2\]
+ sky130_fd_sc_hd__edfxtp_1
Xnetwork.in_period\[135\]\[3\]$_DFFE_PP_ clknet_leaf_96_clk_load
+ net453 _03126_ VSS VSS VDD VDD network.in_period\[135\]\[3\]
+ sky130_fd_sc_hd__edfxtp_1
Xnetwork.in_period\[136\]\[0\]$_DFFE_PP_ clknet_leaf_103_clk_load
+ net438 _03127_ VSS VSS VDD VDD network.in_period\[136\]\[0\]
+ sky130_fd_sc_hd__edfxtp_1
Xnetwork.in_period\[136\]\[1\]$_DFFE_PP_ clknet_leaf_102_clk_load
+ net428 _03127_ VSS VSS VDD VDD network.in_period\[136\]\[1\]
+ sky130_fd_sc_hd__edfxtp_1
Xnetwork.in_period\[136\]\[2\]$_DFFE_PP_ clknet_leaf_102_clk_load
+ net421 _03127_ VSS VSS VDD VDD network.in_period\[136\]\[2\]
+ sky130_fd_sc_hd__edfxtp_1
Xnetwork.in_period\[136\]\[3\]$_DFFE_PP_ clknet_leaf_102_clk_load
+ net420 _03127_ VSS VSS VDD VDD network.in_period\[136\]\[3\]
+ sky130_fd_sc_hd__edfxtp_1
Xnetwork.in_period\[137\]\[0\]$_DFFE_PP_ clknet_leaf_102_clk_load
+ net438 _03128_ VSS VSS VDD VDD network.in_period\[137\]\[0\]
+ sky130_fd_sc_hd__edfxtp_1
Xnetwork.in_period\[137\]\[1\]$_DFFE_PP_ clknet_leaf_102_clk_load
+ net428 _03128_ VSS VSS VDD VDD network.in_period\[137\]\[1\]
+ sky130_fd_sc_hd__edfxtp_1
Xnetwork.in_period\[137\]\[2\]$_DFFE_PP_ clknet_leaf_102_clk_load
+ net421 _03128_ VSS VSS VDD VDD network.in_period\[137\]\[2\]
+ sky130_fd_sc_hd__edfxtp_1
Xnetwork.in_period\[137\]\[3\]$_DFFE_PP_ clknet_leaf_102_clk_load
+ net420 _03128_ VSS VSS VDD VDD network.in_period\[137\]\[3\]
+ sky130_fd_sc_hd__edfxtp_1
Xnetwork.in_period\[138\]\[0\]$_DFFE_PP_ clknet_leaf_101_clk_load
+ net438 _03129_ VSS VSS VDD VDD network.in_period\[138\]\[0\]
+ sky130_fd_sc_hd__edfxtp_1
Xnetwork.in_period\[138\]\[1\]$_DFFE_PP_ clknet_leaf_101_clk_load
+ net428 _03129_ VSS VSS VDD VDD network.in_period\[138\]\[1\]
+ sky130_fd_sc_hd__edfxtp_1
Xnetwork.in_period\[138\]\[2\]$_DFFE_PP_ clknet_leaf_101_clk_load
+ net421 _03129_ VSS VSS VDD VDD network.in_period\[138\]\[2\]
+ sky130_fd_sc_hd__edfxtp_1
Xnetwork.in_period\[138\]\[3\]$_DFFE_PP_ clknet_leaf_101_clk_load
+ net419 _03129_ VSS VSS VDD VDD network.in_period\[138\]\[3\]
+ sky130_fd_sc_hd__edfxtp_1
Xnetwork.in_period\[139\]\[0\]$_DFFE_PP_ clknet_leaf_102_clk_load
+ net438 _03130_ VSS VSS VDD VDD network.in_period\[139\]\[0\]
+ sky130_fd_sc_hd__edfxtp_1
Xnetwork.in_period\[139\]\[1\]$_DFFE_PP_ clknet_leaf_102_clk_load
+ net428 _03130_ VSS VSS VDD VDD network.in_period\[139\]\[1\]
+ sky130_fd_sc_hd__edfxtp_1
Xnetwork.in_period\[139\]\[2\]$_DFFE_PP_ clknet_leaf_102_clk_load
+ net421 _03130_ VSS VSS VDD VDD network.in_period\[139\]\[2\]
+ sky130_fd_sc_hd__edfxtp_1
Xnetwork.in_period\[139\]\[3\]$_DFFE_PP_ clknet_leaf_102_clk_load
+ net419 _03130_ VSS VSS VDD VDD network.in_period\[139\]\[3\]
+ sky130_fd_sc_hd__edfxtp_1
Xnetwork.in_period\[13\]\[0\]$_DFFE_PP_ clknet_leaf_38_clk_load
+ net439 _03131_ VSS VSS VDD VDD network.in_period\[13\]\[0\]
+ sky130_fd_sc_hd__edfxtp_1
Xnetwork.in_period\[13\]\[1\]$_DFFE_PP_ clknet_leaf_38_clk_load
+ net430 _03131_ VSS VSS VDD VDD network.in_period\[13\]\[1\]
+ sky130_fd_sc_hd__edfxtp_1
Xnetwork.in_period\[13\]\[2\]$_DFFE_PP_ clknet_leaf_44_clk_load
+ net425 _03131_ VSS VSS VDD VDD network.in_period\[13\]\[2\]
+ sky130_fd_sc_hd__edfxtp_1
Xnetwork.in_period\[13\]\[3\]$_DFFE_PP_ clknet_leaf_38_clk_load
+ net415 _03131_ VSS VSS VDD VDD network.in_period\[13\]\[3\]
+ sky130_fd_sc_hd__edfxtp_1
Xnetwork.in_period\[140\]\[0\]$_DFFE_PP_ clknet_leaf_98_clk_load
+ net437 _03132_ VSS VSS VDD VDD network.in_period\[140\]\[0\]
+ sky130_fd_sc_hd__edfxtp_1
Xnetwork.in_period\[140\]\[1\]$_DFFE_PP_ clknet_leaf_100_clk_load
+ net433 _03132_ VSS VSS VDD VDD network.in_period\[140\]\[1\]
+ sky130_fd_sc_hd__edfxtp_1
Xnetwork.in_period\[140\]\[2\]$_DFFE_PP_ clknet_leaf_100_clk_load
+ net421 _03132_ VSS VSS VDD VDD network.in_period\[140\]\[2\]
+ sky130_fd_sc_hd__edfxtp_1
Xnetwork.in_period\[140\]\[3\]$_DFFE_PP_ clknet_leaf_98_clk_load
+ net420 _03132_ VSS VSS VDD VDD network.in_period\[140\]\[3\]
+ sky130_fd_sc_hd__edfxtp_1
Xnetwork.in_period\[141\]\[0\]$_DFFE_PP_ clknet_leaf_100_clk_load
+ net438 _03133_ VSS VSS VDD VDD network.in_period\[141\]\[0\]
+ sky130_fd_sc_hd__edfxtp_1
Xnetwork.in_period\[141\]\[1\]$_DFFE_PP_ clknet_leaf_100_clk_load
+ net428 _03133_ VSS VSS VDD VDD network.in_period\[141\]\[1\]
+ sky130_fd_sc_hd__edfxtp_1
Xnetwork.in_period\[141\]\[2\]$_DFFE_PP_ clknet_leaf_100_clk_load
+ net421 _03133_ VSS VSS VDD VDD network.in_period\[141\]\[2\]
+ sky130_fd_sc_hd__edfxtp_1
Xnetwork.in_period\[141\]\[3\]$_DFFE_PP_ clknet_leaf_100_clk_load
+ net419 _03133_ VSS VSS VDD VDD network.in_period\[141\]\[3\]
+ sky130_fd_sc_hd__edfxtp_1
Xnetwork.in_period\[142\]\[0\]$_DFFE_PP_ clknet_leaf_101_clk_load
+ net438 _03134_ VSS VSS VDD VDD network.in_period\[142\]\[0\]
+ sky130_fd_sc_hd__edfxtp_1
Xnetwork.in_period\[142\]\[1\]$_DFFE_PP_ clknet_leaf_101_clk_load
+ net428 _03134_ VSS VSS VDD VDD network.in_period\[142\]\[1\]
+ sky130_fd_sc_hd__edfxtp_1
Xnetwork.in_period\[142\]\[2\]$_DFFE_PP_ clknet_leaf_101_clk_load
+ net421 _03134_ VSS VSS VDD VDD network.in_period\[142\]\[2\]
+ sky130_fd_sc_hd__edfxtp_1
Xnetwork.in_period\[142\]\[3\]$_DFFE_PP_ clknet_leaf_101_clk_load
+ net419 _03134_ VSS VSS VDD VDD network.in_period\[142\]\[3\]
+ sky130_fd_sc_hd__edfxtp_1
Xnetwork.in_period\[143\]\[0\]$_DFFE_PP_ clknet_leaf_100_clk_load
+ net438 _03135_ VSS VSS VDD VDD network.in_period\[143\]\[0\]
+ sky130_fd_sc_hd__edfxtp_1
Xnetwork.in_period\[143\]\[1\]$_DFFE_PP_ clknet_leaf_100_clk_load
+ net428 _03135_ VSS VSS VDD VDD network.in_period\[143\]\[1\]
+ sky130_fd_sc_hd__edfxtp_1
Xnetwork.in_period\[143\]\[2\]$_DFFE_PP_ clknet_leaf_100_clk_load
+ net421 _03135_ VSS VSS VDD VDD network.in_period\[143\]\[2\]
+ sky130_fd_sc_hd__edfxtp_1
Xnetwork.in_period\[143\]\[3\]$_DFFE_PP_ clknet_leaf_100_clk_load
+ net419 _03135_ VSS VSS VDD VDD network.in_period\[143\]\[3\]
+ sky130_fd_sc_hd__edfxtp_1
Xnetwork.in_period\[144\]\[0\]$_DFFE_PP_ clknet_leaf_94_clk_load
+ net437 _03136_ VSS VSS VDD VDD network.in_period\[144\]\[0\]
+ sky130_fd_sc_hd__edfxtp_1
Xnetwork.in_period\[144\]\[1\]$_DFFE_PP_ clknet_leaf_94_clk_load
+ net433 _03136_ VSS VSS VDD VDD network.in_period\[144\]\[1\]
+ sky130_fd_sc_hd__edfxtp_1
Xnetwork.in_period\[144\]\[2\]$_DFFE_PP_ clknet_leaf_94_clk_load
+ net425 _03136_ VSS VSS VDD VDD network.in_period\[144\]\[2\]
+ sky130_fd_sc_hd__edfxtp_1
Xnetwork.in_period\[144\]\[3\]$_DFFE_PP_ clknet_leaf_94_clk_load
+ net788 _03136_ VSS VSS VDD VDD network.in_period\[144\]\[3\]
+ sky130_fd_sc_hd__edfxtp_1
Xnetwork.in_period\[145\]\[0\]$_DFFE_PP_ clknet_leaf_15_clk_load
+ net439 _03137_ VSS VSS VDD VDD network.in_period\[145\]\[0\]
+ sky130_fd_sc_hd__edfxtp_1
Xnetwork.in_period\[145\]\[1\]$_DFFE_PP_ clknet_leaf_15_clk_load
+ net433 _03137_ VSS VSS VDD VDD network.in_period\[145\]\[1\]
+ sky130_fd_sc_hd__edfxtp_1
Xnetwork.in_period\[145\]\[2\]$_DFFE_PP_ clknet_leaf_15_clk_load
+ net423 _03137_ VSS VSS VDD VDD network.in_period\[145\]\[2\]
+ sky130_fd_sc_hd__edfxtp_1
Xnetwork.in_period\[145\]\[3\]$_DFFE_PP_ clknet_leaf_15_clk_load
+ net788 _03137_ VSS VSS VDD VDD network.in_period\[145\]\[3\]
+ sky130_fd_sc_hd__edfxtp_1
Xnetwork.in_period\[146\]\[0\]$_DFFE_PP_ clknet_leaf_92_clk_load
+ net436 _03138_ VSS VSS VDD VDD network.in_period\[146\]\[0\]
+ sky130_fd_sc_hd__edfxtp_1
Xnetwork.in_period\[146\]\[1\]$_DFFE_PP_ clknet_leaf_16_clk_load
+ net433 _03138_ VSS VSS VDD VDD network.in_period\[146\]\[1\]
+ sky130_fd_sc_hd__edfxtp_1
Xnetwork.in_period\[146\]\[2\]$_DFFE_PP_ clknet_leaf_92_clk_load
+ net423 _03138_ VSS VSS VDD VDD network.in_period\[146\]\[2\]
+ sky130_fd_sc_hd__edfxtp_1
Xnetwork.in_period\[146\]\[3\]$_DFFE_PP_ clknet_leaf_16_clk_load
+ net788 _03138_ VSS VSS VDD VDD network.in_period\[146\]\[3\]
+ sky130_fd_sc_hd__edfxtp_1
Xnetwork.in_period\[147\]\[0\]$_DFFE_PP_ clknet_leaf_90_clk_load
+ net436 _03139_ VSS VSS VDD VDD network.in_period\[147\]\[0\]
+ sky130_fd_sc_hd__edfxtp_1
Xnetwork.in_period\[147\]\[1\]$_DFFE_PP_ clknet_leaf_90_clk_load
+ net433 _03139_ VSS VSS VDD VDD network.in_period\[147\]\[1\]
+ sky130_fd_sc_hd__edfxtp_1
Xnetwork.in_period\[147\]\[2\]$_DFFE_PP_ clknet_leaf_91_clk_load
+ net422 _03139_ VSS VSS VDD VDD network.in_period\[147\]\[2\]
+ sky130_fd_sc_hd__edfxtp_1
Xnetwork.in_period\[147\]\[3\]$_DFFE_PP_ clknet_leaf_91_clk_load
+ net420 _03139_ VSS VSS VDD VDD network.in_period\[147\]\[3\]
+ sky130_fd_sc_hd__edfxtp_1
Xnetwork.in_period\[148\]\[0\]$_DFFE_PP_ clknet_leaf_15_clk_load
+ net436 _03140_ VSS VSS VDD VDD network.in_period\[148\]\[0\]
+ sky130_fd_sc_hd__edfxtp_1
Xnetwork.in_period\[148\]\[1\]$_DFFE_PP_ clknet_leaf_14_clk_load
+ net433 _03140_ VSS VSS VDD VDD network.in_period\[148\]\[1\]
+ sky130_fd_sc_hd__edfxtp_1
Xnetwork.in_period\[148\]\[2\]$_DFFE_PP_ clknet_leaf_15_clk_load
+ net423 _03140_ VSS VSS VDD VDD network.in_period\[148\]\[2\]
+ sky130_fd_sc_hd__edfxtp_1
Xnetwork.in_period\[148\]\[3\]$_DFFE_PP_ clknet_leaf_15_clk_load
+ net788 _03140_ VSS VSS VDD VDD network.in_period\[148\]\[3\]
+ sky130_fd_sc_hd__edfxtp_1
Xnetwork.in_period\[149\]\[0\]$_DFFE_PP_ clknet_leaf_93_clk_load
+ net437 _03141_ VSS VSS VDD VDD network.in_period\[149\]\[0\]
+ sky130_fd_sc_hd__edfxtp_1
Xnetwork.in_period\[149\]\[1\]$_DFFE_PP_ clknet_leaf_93_clk_load
+ net433 _03141_ VSS VSS VDD VDD network.in_period\[149\]\[1\]
+ sky130_fd_sc_hd__edfxtp_1
Xnetwork.in_period\[149\]\[2\]$_DFFE_PP_ clknet_leaf_93_clk_load
+ net424 _03141_ VSS VSS VDD VDD network.in_period\[149\]\[2\]
+ sky130_fd_sc_hd__edfxtp_1
Xnetwork.in_period\[149\]\[3\]$_DFFE_PP_ clknet_leaf_93_clk_load
+ net453 _03141_ VSS VSS VDD VDD network.in_period\[149\]\[3\]
+ sky130_fd_sc_hd__edfxtp_1
Xnetwork.in_period\[14\]\[0\]$_DFFE_PP_ clknet_leaf_41_clk_load
+ net439 _03142_ VSS VSS VDD VDD network.in_period\[14\]\[0\]
+ sky130_fd_sc_hd__edfxtp_1
Xnetwork.in_period\[14\]\[1\]$_DFFE_PP_ clknet_leaf_41_clk_load
+ net430 _03142_ VSS VSS VDD VDD network.in_period\[14\]\[1\]
+ sky130_fd_sc_hd__edfxtp_1
Xnetwork.in_period\[14\]\[2\]$_DFFE_PP_ clknet_leaf_42_clk_load
+ net425 _03142_ VSS VSS VDD VDD network.in_period\[14\]\[2\]
+ sky130_fd_sc_hd__edfxtp_1
Xnetwork.in_period\[14\]\[3\]$_DFFE_PP_ clknet_leaf_42_clk_load
+ net415 _03142_ VSS VSS VDD VDD network.in_period\[14\]\[3\]
+ sky130_fd_sc_hd__edfxtp_1
Xnetwork.in_period\[150\]\[0\]$_DFFE_PP_ clknet_leaf_91_clk_load
+ net435 _03143_ VSS VSS VDD VDD network.in_period\[150\]\[0\]
+ sky130_fd_sc_hd__edfxtp_1
Xnetwork.in_period\[150\]\[1\]$_DFFE_PP_ clknet_leaf_91_clk_load
+ net433 _03143_ VSS VSS VDD VDD network.in_period\[150\]\[1\]
+ sky130_fd_sc_hd__edfxtp_1
Xnetwork.in_period\[150\]\[2\]$_DFFE_PP_ clknet_leaf_91_clk_load
+ net422 _03143_ VSS VSS VDD VDD network.in_period\[150\]\[2\]
+ sky130_fd_sc_hd__edfxtp_1
Xnetwork.in_period\[150\]\[3\]$_DFFE_PP_ clknet_leaf_91_clk_load
+ net788 _03143_ VSS VSS VDD VDD network.in_period\[150\]\[3\]
+ sky130_fd_sc_hd__edfxtp_1
Xnetwork.in_period\[151\]\[0\]$_DFFE_PP_ clknet_leaf_92_clk_load
+ net436 _03144_ VSS VSS VDD VDD network.in_period\[151\]\[0\]
+ sky130_fd_sc_hd__edfxtp_1
Xnetwork.in_period\[151\]\[1\]$_DFFE_PP_ clknet_leaf_92_clk_load
+ net433 _03144_ VSS VSS VDD VDD network.in_period\[151\]\[1\]
+ sky130_fd_sc_hd__edfxtp_1
Xnetwork.in_period\[151\]\[2\]$_DFFE_PP_ clknet_leaf_92_clk_load
+ net422 _03144_ VSS VSS VDD VDD network.in_period\[151\]\[2\]
+ sky130_fd_sc_hd__edfxtp_1
Xnetwork.in_period\[151\]\[3\]$_DFFE_PP_ clknet_leaf_92_clk_load
+ net788 _03144_ VSS VSS VDD VDD network.in_period\[151\]\[3\]
+ sky130_fd_sc_hd__edfxtp_1
Xnetwork.in_period\[152\]\[0\]$_DFFE_PP_ clknet_leaf_12_clk_load
+ net437 _03145_ VSS VSS VDD VDD network.in_period\[152\]\[0\]
+ sky130_fd_sc_hd__edfxtp_1
Xnetwork.in_period\[152\]\[1\]$_DFFE_PP_ clknet_leaf_12_clk_load
+ net434 _03145_ VSS VSS VDD VDD network.in_period\[152\]\[1\]
+ sky130_fd_sc_hd__edfxtp_1
Xnetwork.in_period\[152\]\[2\]$_DFFE_PP_ clknet_leaf_12_clk_load
+ net425 _03145_ VSS VSS VDD VDD network.in_period\[152\]\[2\]
+ sky130_fd_sc_hd__edfxtp_1
Xnetwork.in_period\[152\]\[3\]$_DFFE_PP_ clknet_leaf_12_clk_load
+ net416 _03145_ VSS VSS VDD VDD network.in_period\[152\]\[3\]
+ sky130_fd_sc_hd__edfxtp_1
Xnetwork.in_period\[153\]\[0\]$_DFFE_PP_ clknet_leaf_89_clk_load
+ net436 _03146_ VSS VSS VDD VDD network.in_period\[153\]\[0\]
+ sky130_fd_sc_hd__edfxtp_1
Xnetwork.in_period\[153\]\[1\]$_DFFE_PP_ clknet_leaf_89_clk_load
+ net433 _03146_ VSS VSS VDD VDD network.in_period\[153\]\[1\]
+ sky130_fd_sc_hd__edfxtp_1
Xnetwork.in_period\[153\]\[2\]$_DFFE_PP_ clknet_leaf_89_clk_load
+ net424 _03146_ VSS VSS VDD VDD network.in_period\[153\]\[2\]
+ sky130_fd_sc_hd__edfxtp_1
Xnetwork.in_period\[153\]\[3\]$_DFFE_PP_ clknet_leaf_89_clk_load
+ net420 _03146_ VSS VSS VDD VDD network.in_period\[153\]\[3\]
+ sky130_fd_sc_hd__edfxtp_1
Xnetwork.in_period\[154\]\[0\]$_DFFE_PP_ clknet_leaf_92_clk_load
+ net436 _03147_ VSS VSS VDD VDD network.in_period\[154\]\[0\]
+ sky130_fd_sc_hd__edfxtp_1
Xnetwork.in_period\[154\]\[1\]$_DFFE_PP_ clknet_leaf_15_clk_load
+ net433 _03147_ VSS VSS VDD VDD network.in_period\[154\]\[1\]
+ sky130_fd_sc_hd__edfxtp_1
Xnetwork.in_period\[154\]\[2\]$_DFFE_PP_ clknet_leaf_15_clk_load
+ net423 _03147_ VSS VSS VDD VDD network.in_period\[154\]\[2\]
+ sky130_fd_sc_hd__edfxtp_1
Xnetwork.in_period\[154\]\[3\]$_DFFE_PP_ clknet_leaf_15_clk_load
+ net788 _03147_ VSS VSS VDD VDD network.in_period\[154\]\[3\]
+ sky130_fd_sc_hd__edfxtp_1
Xnetwork.in_period\[155\]\[0\]$_DFFE_PP_ clknet_leaf_94_clk_load
+ net437 _03148_ VSS VSS VDD VDD network.in_period\[155\]\[0\]
+ sky130_fd_sc_hd__edfxtp_1
Xnetwork.in_period\[155\]\[1\]$_DFFE_PP_ clknet_leaf_94_clk_load
+ net433 _03148_ VSS VSS VDD VDD network.in_period\[155\]\[1\]
+ sky130_fd_sc_hd__edfxtp_1
Xnetwork.in_period\[155\]\[2\]$_DFFE_PP_ clknet_leaf_94_clk_load
+ net424 _03148_ VSS VSS VDD VDD network.in_period\[155\]\[2\]
+ sky130_fd_sc_hd__edfxtp_1
Xnetwork.in_period\[155\]\[3\]$_DFFE_PP_ clknet_leaf_94_clk_load
+ net453 _03148_ VSS VSS VDD VDD network.in_period\[155\]\[3\]
+ sky130_fd_sc_hd__edfxtp_1
Xnetwork.in_period\[156\]\[0\]$_DFFE_PP_ clknet_leaf_84_clk_load
+ net436 _03149_ VSS VSS VDD VDD network.in_period\[156\]\[0\]
+ sky130_fd_sc_hd__edfxtp_1
Xnetwork.in_period\[156\]\[1\]$_DFFE_PP_ clknet_leaf_85_clk_load
+ net432 _03149_ VSS VSS VDD VDD network.in_period\[156\]\[1\]
+ sky130_fd_sc_hd__edfxtp_1
Xnetwork.in_period\[156\]\[2\]$_DFFE_PP_ clknet_leaf_85_clk_load
+ net424 _03149_ VSS VSS VDD VDD network.in_period\[156\]\[2\]
+ sky130_fd_sc_hd__edfxtp_1
Xnetwork.in_period\[156\]\[3\]$_DFFE_PP_ clknet_leaf_85_clk_load
+ net420 _03149_ VSS VSS VDD VDD network.in_period\[156\]\[3\]
+ sky130_fd_sc_hd__edfxtp_1
Xnetwork.in_period\[157\]\[0\]$_DFFE_PP_ clknet_leaf_93_clk_load
+ net437 _03150_ VSS VSS VDD VDD network.in_period\[157\]\[0\]
+ sky130_fd_sc_hd__edfxtp_1
Xnetwork.in_period\[157\]\[1\]$_DFFE_PP_ clknet_leaf_93_clk_load
+ net432 _03150_ VSS VSS VDD VDD network.in_period\[157\]\[1\]
+ sky130_fd_sc_hd__edfxtp_1
Xnetwork.in_period\[157\]\[2\]$_DFFE_PP_ clknet_leaf_93_clk_load
+ net424 _03150_ VSS VSS VDD VDD network.in_period\[157\]\[2\]
+ sky130_fd_sc_hd__edfxtp_1
Xnetwork.in_period\[157\]\[3\]$_DFFE_PP_ clknet_leaf_93_clk_load
+ net453 _03150_ VSS VSS VDD VDD network.in_period\[157\]\[3\]
+ sky130_fd_sc_hd__edfxtp_1
Xnetwork.in_period\[158\]\[0\]$_DFFE_PP_ clknet_leaf_97_clk_load
+ net437 _03151_ VSS VSS VDD VDD network.in_period\[158\]\[0\]
+ sky130_fd_sc_hd__edfxtp_1
Xnetwork.in_period\[158\]\[1\]$_DFFE_PP_ clknet_leaf_97_clk_load
+ net432 _03151_ VSS VSS VDD VDD network.in_period\[158\]\[1\]
+ sky130_fd_sc_hd__edfxtp_1
Xnetwork.in_period\[158\]\[2\]$_DFFE_PP_ clknet_leaf_97_clk_load
+ net424 _03151_ VSS VSS VDD VDD network.in_period\[158\]\[2\]
+ sky130_fd_sc_hd__edfxtp_1
Xnetwork.in_period\[158\]\[3\]$_DFFE_PP_ clknet_leaf_96_clk_load
+ net453 _03151_ VSS VSS VDD VDD network.in_period\[158\]\[3\]
+ sky130_fd_sc_hd__edfxtp_1
Xnetwork.in_period\[159\]\[0\]$_DFFE_PP_ clknet_leaf_89_clk_load
+ net436 _03152_ VSS VSS VDD VDD network.in_period\[159\]\[0\]
+ sky130_fd_sc_hd__edfxtp_1
Xnetwork.in_period\[159\]\[1\]$_DFFE_PP_ clknet_leaf_89_clk_load
+ net432 _03152_ VSS VSS VDD VDD network.in_period\[159\]\[1\]
+ sky130_fd_sc_hd__edfxtp_1
Xnetwork.in_period\[159\]\[2\]$_DFFE_PP_ clknet_leaf_89_clk_load
+ net424 _03152_ VSS VSS VDD VDD network.in_period\[159\]\[2\]
+ sky130_fd_sc_hd__edfxtp_1
Xnetwork.in_period\[159\]\[3\]$_DFFE_PP_ clknet_leaf_89_clk_load
+ net420 _03152_ VSS VSS VDD VDD network.in_period\[159\]\[3\]
+ sky130_fd_sc_hd__edfxtp_1
Xnetwork.in_period\[15\]\[0\]$_DFFE_PP_ clknet_leaf_41_clk_load
+ net439 _03153_ VSS VSS VDD VDD network.in_period\[15\]\[0\]
+ sky130_fd_sc_hd__edfxtp_1
Xnetwork.in_period\[15\]\[1\]$_DFFE_PP_ clknet_leaf_41_clk_load
+ net430 _03153_ VSS VSS VDD VDD network.in_period\[15\]\[1\]
+ sky130_fd_sc_hd__edfxtp_1
Xnetwork.in_period\[15\]\[2\]$_DFFE_PP_ clknet_leaf_42_clk_load
+ net426 _03153_ VSS VSS VDD VDD network.in_period\[15\]\[2\]
+ sky130_fd_sc_hd__edfxtp_1
Xnetwork.in_period\[15\]\[3\]$_DFFE_PP_ clknet_leaf_41_clk_load
+ net414 _03153_ VSS VSS VDD VDD network.in_period\[15\]\[3\]
+ sky130_fd_sc_hd__edfxtp_1
Xnetwork.in_period\[160\]\[0\]$_DFFE_PP_ clknet_leaf_85_clk_load
+ net437 _03154_ VSS VSS VDD VDD network.in_period\[160\]\[0\]
+ sky130_fd_sc_hd__edfxtp_1
Xnetwork.in_period\[160\]\[1\]$_DFFE_PP_ clknet_leaf_84_clk_load
+ net432 _03154_ VSS VSS VDD VDD network.in_period\[160\]\[1\]
+ sky130_fd_sc_hd__edfxtp_1
Xnetwork.in_period\[160\]\[2\]$_DFFE_PP_ clknet_leaf_84_clk_load
+ net424 _03154_ VSS VSS VDD VDD network.in_period\[160\]\[2\]
+ sky130_fd_sc_hd__edfxtp_1
Xnetwork.in_period\[160\]\[3\]$_DFFE_PP_ clknet_leaf_84_clk_load
+ net420 _03154_ VSS VSS VDD VDD network.in_period\[160\]\[3\]
+ sky130_fd_sc_hd__edfxtp_1
Xnetwork.in_period\[161\]\[0\]$_DFFE_PP_ clknet_leaf_79_clk_load
+ net436 _03155_ VSS VSS VDD VDD network.in_period\[161\]\[0\]
+ sky130_fd_sc_hd__edfxtp_1
Xnetwork.in_period\[161\]\[1\]$_DFFE_PP_ clknet_leaf_79_clk_load
+ net432 _03155_ VSS VSS VDD VDD network.in_period\[161\]\[1\]
+ sky130_fd_sc_hd__edfxtp_1
Xnetwork.in_period\[161\]\[2\]$_DFFE_PP_ clknet_leaf_79_clk_load
+ net421 _03155_ VSS VSS VDD VDD network.in_period\[161\]\[2\]
+ sky130_fd_sc_hd__edfxtp_1
Xnetwork.in_period\[161\]\[3\]$_DFFE_PP_ clknet_leaf_79_clk_load
+ net418 _03155_ VSS VSS VDD VDD network.in_period\[161\]\[3\]
+ sky130_fd_sc_hd__edfxtp_1
Xnetwork.in_period\[162\]\[0\]$_DFFE_PP_ clknet_leaf_81_clk_load
+ net436 _03156_ VSS VSS VDD VDD network.in_period\[162\]\[0\]
+ sky130_fd_sc_hd__edfxtp_1
Xnetwork.in_period\[162\]\[1\]$_DFFE_PP_ clknet_leaf_81_clk_load
+ net432 _03156_ VSS VSS VDD VDD network.in_period\[162\]\[1\]
+ sky130_fd_sc_hd__edfxtp_1
Xnetwork.in_period\[162\]\[2\]$_DFFE_PP_ clknet_leaf_81_clk_load
+ net421 _03156_ VSS VSS VDD VDD network.in_period\[162\]\[2\]
+ sky130_fd_sc_hd__edfxtp_1
Xnetwork.in_period\[162\]\[3\]$_DFFE_PP_ clknet_leaf_81_clk_load
+ net418 _03156_ VSS VSS VDD VDD network.in_period\[162\]\[3\]
+ sky130_fd_sc_hd__edfxtp_1
Xnetwork.in_period\[163\]\[0\]$_DFFE_PP_ clknet_leaf_83_clk_load
+ net437 _03157_ VSS VSS VDD VDD network.in_period\[163\]\[0\]
+ sky130_fd_sc_hd__edfxtp_1
Xnetwork.in_period\[163\]\[1\]$_DFFE_PP_ clknet_leaf_83_clk_load
+ net433 _03157_ VSS VSS VDD VDD network.in_period\[163\]\[1\]
+ sky130_fd_sc_hd__edfxtp_1
Xnetwork.in_period\[163\]\[2\]$_DFFE_PP_ clknet_leaf_84_clk_load
+ net421 _03157_ VSS VSS VDD VDD network.in_period\[163\]\[2\]
+ sky130_fd_sc_hd__edfxtp_1
Xnetwork.in_period\[163\]\[3\]$_DFFE_PP_ clknet_leaf_84_clk_load
+ net418 _03157_ VSS VSS VDD VDD network.in_period\[163\]\[3\]
+ sky130_fd_sc_hd__edfxtp_1
Xnetwork.in_period\[164\]\[0\]$_DFFE_PP_ clknet_leaf_81_clk_load
+ net438 _03158_ VSS VSS VDD VDD network.in_period\[164\]\[0\]
+ sky130_fd_sc_hd__edfxtp_1
Xnetwork.in_period\[164\]\[1\]$_DFFE_PP_ clknet_leaf_81_clk_load
+ net433 _03158_ VSS VSS VDD VDD network.in_period\[164\]\[1\]
+ sky130_fd_sc_hd__edfxtp_1
Xnetwork.in_period\[164\]\[2\]$_DFFE_PP_ clknet_leaf_81_clk_load
+ net421 _03158_ VSS VSS VDD VDD network.in_period\[164\]\[2\]
+ sky130_fd_sc_hd__edfxtp_1
Xnetwork.in_period\[164\]\[3\]$_DFFE_PP_ clknet_leaf_81_clk_load
+ net419 _03158_ VSS VSS VDD VDD network.in_period\[164\]\[3\]
+ sky130_fd_sc_hd__edfxtp_1
Xnetwork.in_period\[165\]\[0\]$_DFFE_PP_ clknet_leaf_82_clk_load
+ net438 _03159_ VSS VSS VDD VDD network.in_period\[165\]\[0\]
+ sky130_fd_sc_hd__edfxtp_1
Xnetwork.in_period\[165\]\[1\]$_DFFE_PP_ clknet_leaf_82_clk_load
+ net433 _03159_ VSS VSS VDD VDD network.in_period\[165\]\[1\]
+ sky130_fd_sc_hd__edfxtp_1
Xnetwork.in_period\[165\]\[2\]$_DFFE_PP_ clknet_leaf_82_clk_load
+ net421 _03159_ VSS VSS VDD VDD network.in_period\[165\]\[2\]
+ sky130_fd_sc_hd__edfxtp_1
Xnetwork.in_period\[165\]\[3\]$_DFFE_PP_ clknet_leaf_82_clk_load
+ net418 _03159_ VSS VSS VDD VDD network.in_period\[165\]\[3\]
+ sky130_fd_sc_hd__edfxtp_1
Xnetwork.in_period\[166\]\[0\]$_DFFE_PP_ clknet_leaf_82_clk_load
+ net438 _03160_ VSS VSS VDD VDD network.in_period\[166\]\[0\]
+ sky130_fd_sc_hd__edfxtp_1
Xnetwork.in_period\[166\]\[1\]$_DFFE_PP_ clknet_leaf_82_clk_load
+ net433 _03160_ VSS VSS VDD VDD network.in_period\[166\]\[1\]
+ sky130_fd_sc_hd__edfxtp_1
Xnetwork.in_period\[166\]\[2\]$_DFFE_PP_ clknet_leaf_82_clk_load
+ net421 _03160_ VSS VSS VDD VDD network.in_period\[166\]\[2\]
+ sky130_fd_sc_hd__edfxtp_1
Xnetwork.in_period\[166\]\[3\]$_DFFE_PP_ clknet_leaf_82_clk_load
+ net419 _03160_ VSS VSS VDD VDD network.in_period\[166\]\[3\]
+ sky130_fd_sc_hd__edfxtp_1
Xnetwork.in_period\[167\]\[0\]$_DFFE_PP_ clknet_leaf_79_clk_load
+ net436 _03161_ VSS VSS VDD VDD network.in_period\[167\]\[0\]
+ sky130_fd_sc_hd__edfxtp_1
Xnetwork.in_period\[167\]\[1\]$_DFFE_PP_ clknet_leaf_79_clk_load
+ net432 _03161_ VSS VSS VDD VDD network.in_period\[167\]\[1\]
+ sky130_fd_sc_hd__edfxtp_1
Xnetwork.in_period\[167\]\[2\]$_DFFE_PP_ clknet_leaf_79_clk_load
+ net421 _03161_ VSS VSS VDD VDD network.in_period\[167\]\[2\]
+ sky130_fd_sc_hd__edfxtp_1
Xnetwork.in_period\[167\]\[3\]$_DFFE_PP_ clknet_leaf_79_clk_load
+ net418 _03161_ VSS VSS VDD VDD network.in_period\[167\]\[3\]
+ sky130_fd_sc_hd__edfxtp_1
Xnetwork.in_period\[168\]\[0\]$_DFFE_PP_ clknet_leaf_98_clk_load
+ net437 _03162_ VSS VSS VDD VDD network.in_period\[168\]\[0\]
+ sky130_fd_sc_hd__edfxtp_1
Xnetwork.in_period\[168\]\[1\]$_DFFE_PP_ clknet_leaf_98_clk_load
+ net433 _03162_ VSS VSS VDD VDD network.in_period\[168\]\[1\]
+ sky130_fd_sc_hd__edfxtp_1
Xnetwork.in_period\[168\]\[2\]$_DFFE_PP_ clknet_leaf_98_clk_load
+ net421 _03162_ VSS VSS VDD VDD network.in_period\[168\]\[2\]
+ sky130_fd_sc_hd__edfxtp_1
Xnetwork.in_period\[168\]\[3\]$_DFFE_PP_ clknet_leaf_98_clk_load
+ net420 _03162_ VSS VSS VDD VDD network.in_period\[168\]\[3\]
+ sky130_fd_sc_hd__edfxtp_1
Xnetwork.in_period\[169\]\[0\]$_DFFE_PP_ clknet_leaf_83_clk_load
+ net437 _03163_ VSS VSS VDD VDD network.in_period\[169\]\[0\]
+ sky130_fd_sc_hd__edfxtp_1
Xnetwork.in_period\[169\]\[1\]$_DFFE_PP_ clknet_leaf_84_clk_load
+ net433 _03163_ VSS VSS VDD VDD network.in_period\[169\]\[1\]
+ sky130_fd_sc_hd__edfxtp_1
Xnetwork.in_period\[169\]\[2\]$_DFFE_PP_ clknet_leaf_83_clk_load
+ net421 _03163_ VSS VSS VDD VDD network.in_period\[169\]\[2\]
+ sky130_fd_sc_hd__edfxtp_1
Xnetwork.in_period\[169\]\[3\]$_DFFE_PP_ clknet_leaf_83_clk_load
+ net420 _03163_ VSS VSS VDD VDD network.in_period\[169\]\[3\]
+ sky130_fd_sc_hd__edfxtp_1
Xnetwork.in_period\[16\]\[0\]$_DFFE_PP_ clknet_leaf_34_clk_load
+ net440 _03164_ VSS VSS VDD VDD network.in_period\[16\]\[0\]
+ sky130_fd_sc_hd__edfxtp_1
Xnetwork.in_period\[16\]\[1\]$_DFFE_PP_ clknet_leaf_34_clk_load
+ net429 _03164_ VSS VSS VDD VDD network.in_period\[16\]\[1\]
+ sky130_fd_sc_hd__edfxtp_1
Xnetwork.in_period\[16\]\[2\]$_DFFE_PP_ clknet_leaf_34_clk_load
+ net426 _03164_ VSS VSS VDD VDD network.in_period\[16\]\[2\]
+ sky130_fd_sc_hd__edfxtp_1
Xnetwork.in_period\[16\]\[3\]$_DFFE_PP_ clknet_leaf_34_clk_load
+ net414 _03164_ VSS VSS VDD VDD network.in_period\[16\]\[3\]
+ sky130_fd_sc_hd__edfxtp_1
Xnetwork.in_period\[170\]\[0\]$_DFFE_PP_ clknet_leaf_97_clk_load
+ net437 _03165_ VSS VSS VDD VDD network.in_period\[170\]\[0\]
+ sky130_fd_sc_hd__edfxtp_1
Xnetwork.in_period\[170\]\[1\]$_DFFE_PP_ clknet_leaf_97_clk_load
+ net432 _03165_ VSS VSS VDD VDD network.in_period\[170\]\[1\]
+ sky130_fd_sc_hd__edfxtp_1
Xnetwork.in_period\[170\]\[2\]$_DFFE_PP_ clknet_leaf_97_clk_load
+ net424 _03165_ VSS VSS VDD VDD network.in_period\[170\]\[2\]
+ sky130_fd_sc_hd__edfxtp_1
Xnetwork.in_period\[170\]\[3\]$_DFFE_PP_ clknet_leaf_97_clk_load
+ net420 _03165_ VSS VSS VDD VDD network.in_period\[170\]\[3\]
+ sky130_fd_sc_hd__edfxtp_1
Xnetwork.in_period\[171\]\[0\]$_DFFE_PP_ clknet_leaf_98_clk_load
+ net437 _03166_ VSS VSS VDD VDD network.in_period\[171\]\[0\]
+ sky130_fd_sc_hd__edfxtp_1
Xnetwork.in_period\[171\]\[1\]$_DFFE_PP_ clknet_leaf_99_clk_load
+ net433 _03166_ VSS VSS VDD VDD network.in_period\[171\]\[1\]
+ sky130_fd_sc_hd__edfxtp_1
Xnetwork.in_period\[171\]\[2\]$_DFFE_PP_ clknet_leaf_99_clk_load
+ net421 _03166_ VSS VSS VDD VDD network.in_period\[171\]\[2\]
+ sky130_fd_sc_hd__edfxtp_1
Xnetwork.in_period\[171\]\[3\]$_DFFE_PP_ clknet_leaf_98_clk_load
+ net420 _03166_ VSS VSS VDD VDD network.in_period\[171\]\[3\]
+ sky130_fd_sc_hd__edfxtp_1
Xnetwork.in_period\[172\]\[0\]$_DFFE_PP_ clknet_leaf_99_clk_load
+ net438 _03167_ VSS VSS VDD VDD network.in_period\[172\]\[0\]
+ sky130_fd_sc_hd__edfxtp_1
Xnetwork.in_period\[172\]\[1\]$_DFFE_PP_ clknet_leaf_99_clk_load
+ net433 _03167_ VSS VSS VDD VDD network.in_period\[172\]\[1\]
+ sky130_fd_sc_hd__edfxtp_1
Xnetwork.in_period\[172\]\[2\]$_DFFE_PP_ clknet_leaf_99_clk_load
+ net421 _03167_ VSS VSS VDD VDD network.in_period\[172\]\[2\]
+ sky130_fd_sc_hd__edfxtp_1
Xnetwork.in_period\[172\]\[3\]$_DFFE_PP_ clknet_leaf_99_clk_load
+ net419 _03167_ VSS VSS VDD VDD network.in_period\[172\]\[3\]
+ sky130_fd_sc_hd__edfxtp_1
Xnetwork.in_period\[173\]\[0\]$_DFFE_PP_ clknet_leaf_83_clk_load
+ net437 _03168_ VSS VSS VDD VDD network.in_period\[173\]\[0\]
+ sky130_fd_sc_hd__edfxtp_1
Xnetwork.in_period\[173\]\[1\]$_DFFE_PP_ clknet_leaf_83_clk_load
+ net433 _03168_ VSS VSS VDD VDD network.in_period\[173\]\[1\]
+ sky130_fd_sc_hd__edfxtp_1
Xnetwork.in_period\[173\]\[2\]$_DFFE_PP_ clknet_leaf_83_clk_load
+ net421 _03168_ VSS VSS VDD VDD network.in_period\[173\]\[2\]
+ sky130_fd_sc_hd__edfxtp_1
Xnetwork.in_period\[173\]\[3\]$_DFFE_PP_ clknet_leaf_83_clk_load
+ net420 _03168_ VSS VSS VDD VDD network.in_period\[173\]\[3\]
+ sky130_fd_sc_hd__edfxtp_1
Xnetwork.in_period\[174\]\[0\]$_DFFE_PP_ clknet_leaf_83_clk_load
+ net438 _03169_ VSS VSS VDD VDD network.in_period\[174\]\[0\]
+ sky130_fd_sc_hd__edfxtp_1
Xnetwork.in_period\[174\]\[1\]$_DFFE_PP_ clknet_leaf_83_clk_load
+ net433 _03169_ VSS VSS VDD VDD network.in_period\[174\]\[1\]
+ sky130_fd_sc_hd__edfxtp_1
Xnetwork.in_period\[174\]\[2\]$_DFFE_PP_ clknet_leaf_82_clk_load
+ net421 _03169_ VSS VSS VDD VDD network.in_period\[174\]\[2\]
+ sky130_fd_sc_hd__edfxtp_1
Xnetwork.in_period\[174\]\[3\]$_DFFE_PP_ clknet_leaf_82_clk_load
+ net419 _03169_ VSS VSS VDD VDD network.in_period\[174\]\[3\]
+ sky130_fd_sc_hd__edfxtp_1
Xnetwork.in_period\[175\]\[0\]$_DFFE_PP_ clknet_leaf_99_clk_load
+ net438 _03170_ VSS VSS VDD VDD network.in_period\[175\]\[0\]
+ sky130_fd_sc_hd__edfxtp_1
Xnetwork.in_period\[175\]\[1\]$_DFFE_PP_ clknet_leaf_99_clk_load
+ net433 _03170_ VSS VSS VDD VDD network.in_period\[175\]\[1\]
+ sky130_fd_sc_hd__edfxtp_1
Xnetwork.in_period\[175\]\[2\]$_DFFE_PP_ clknet_leaf_99_clk_load
+ net421 _03170_ VSS VSS VDD VDD network.in_period\[175\]\[2\]
+ sky130_fd_sc_hd__edfxtp_1
Xnetwork.in_period\[175\]\[3\]$_DFFE_PP_ clknet_leaf_99_clk_load
+ net419 _03170_ VSS VSS VDD VDD network.in_period\[175\]\[3\]
+ sky130_fd_sc_hd__edfxtp_1
Xnetwork.in_period\[176\]\[0\]$_DFFE_PP_ clknet_leaf_71_clk_load
+ net435 _03171_ VSS VSS VDD VDD network.in_period\[176\]\[0\]
+ sky130_fd_sc_hd__edfxtp_1
Xnetwork.in_period\[176\]\[1\]$_DFFE_PP_ clknet_leaf_71_clk_load
+ net432 _03171_ VSS VSS VDD VDD network.in_period\[176\]\[1\]
+ sky130_fd_sc_hd__edfxtp_1
Xnetwork.in_period\[176\]\[2\]$_DFFE_PP_ clknet_leaf_71_clk_load
+ net424 _03171_ VSS VSS VDD VDD network.in_period\[176\]\[2\]
+ sky130_fd_sc_hd__edfxtp_1
Xnetwork.in_period\[176\]\[3\]$_DFFE_PP_ clknet_leaf_71_clk_load
+ net419 _03171_ VSS VSS VDD VDD network.in_period\[176\]\[3\]
+ sky130_fd_sc_hd__edfxtp_1
Xnetwork.in_period\[177\]\[0\]$_DFFE_PP_ clknet_leaf_77_clk_load
+ net436 _03172_ VSS VSS VDD VDD network.in_period\[177\]\[0\]
+ sky130_fd_sc_hd__edfxtp_1
Xnetwork.in_period\[177\]\[1\]$_DFFE_PP_ clknet_leaf_77_clk_load
+ net432 _03172_ VSS VSS VDD VDD network.in_period\[177\]\[1\]
+ sky130_fd_sc_hd__edfxtp_1
Xnetwork.in_period\[177\]\[2\]$_DFFE_PP_ clknet_leaf_77_clk_load
+ net421 _03172_ VSS VSS VDD VDD network.in_period\[177\]\[2\]
+ sky130_fd_sc_hd__edfxtp_1
Xnetwork.in_period\[177\]\[3\]$_DFFE_PP_ clknet_leaf_77_clk_load
+ net419 _03172_ VSS VSS VDD VDD network.in_period\[177\]\[3\]
+ sky130_fd_sc_hd__edfxtp_1
Xnetwork.in_period\[178\]\[0\]$_DFFE_PP_ clknet_leaf_73_clk_load
+ net435 _03173_ VSS VSS VDD VDD network.in_period\[178\]\[0\]
+ sky130_fd_sc_hd__edfxtp_1
Xnetwork.in_period\[178\]\[1\]$_DFFE_PP_ clknet_leaf_73_clk_load
+ net432 _03173_ VSS VSS VDD VDD network.in_period\[178\]\[1\]
+ sky130_fd_sc_hd__edfxtp_1
Xnetwork.in_period\[178\]\[2\]$_DFFE_PP_ clknet_leaf_73_clk_load
+ net424 _03173_ VSS VSS VDD VDD network.in_period\[178\]\[2\]
+ sky130_fd_sc_hd__edfxtp_1
Xnetwork.in_period\[178\]\[3\]$_DFFE_PP_ clknet_leaf_73_clk_load
+ net419 _03173_ VSS VSS VDD VDD network.in_period\[178\]\[3\]
+ sky130_fd_sc_hd__edfxtp_1
Xnetwork.in_period\[179\]\[0\]$_DFFE_PP_ clknet_leaf_73_clk_load
+ net435 _03174_ VSS VSS VDD VDD network.in_period\[179\]\[0\]
+ sky130_fd_sc_hd__edfxtp_1
Xnetwork.in_period\[179\]\[1\]$_DFFE_PP_ clknet_leaf_73_clk_load
+ net432 _03174_ VSS VSS VDD VDD network.in_period\[179\]\[1\]
+ sky130_fd_sc_hd__edfxtp_1
Xnetwork.in_period\[179\]\[2\]$_DFFE_PP_ clknet_leaf_73_clk_load
+ net421 _03174_ VSS VSS VDD VDD network.in_period\[179\]\[2\]
+ sky130_fd_sc_hd__edfxtp_1
Xnetwork.in_period\[179\]\[3\]$_DFFE_PP_ clknet_leaf_73_clk_load
+ net419 _03174_ VSS VSS VDD VDD network.in_period\[179\]\[3\]
+ sky130_fd_sc_hd__edfxtp_1
Xnetwork.in_period\[17\]\[0\]$_DFFE_PP_ clknet_leaf_35_clk_load
+ net440 _03175_ VSS VSS VDD VDD network.in_period\[17\]\[0\]
+ sky130_fd_sc_hd__edfxtp_1
Xnetwork.in_period\[17\]\[1\]$_DFFE_PP_ clknet_leaf_35_clk_load
+ net429 _03175_ VSS VSS VDD VDD network.in_period\[17\]\[1\]
+ sky130_fd_sc_hd__edfxtp_1
Xnetwork.in_period\[17\]\[2\]$_DFFE_PP_ clknet_leaf_35_clk_load
+ net426 _03175_ VSS VSS VDD VDD network.in_period\[17\]\[2\]
+ sky130_fd_sc_hd__edfxtp_1
Xnetwork.in_period\[17\]\[3\]$_DFFE_PP_ clknet_leaf_35_clk_load
+ net414 _03175_ VSS VSS VDD VDD network.in_period\[17\]\[3\]
+ sky130_fd_sc_hd__edfxtp_1
Xnetwork.in_period\[180\]\[0\]$_DFFE_PP_ clknet_leaf_74_clk_load
+ net435 _03176_ VSS VSS VDD VDD network.in_period\[180\]\[0\]
+ sky130_fd_sc_hd__edfxtp_1
Xnetwork.in_period\[180\]\[1\]$_DFFE_PP_ clknet_leaf_74_clk_load
+ net432 _03176_ VSS VSS VDD VDD network.in_period\[180\]\[1\]
+ sky130_fd_sc_hd__edfxtp_1
Xnetwork.in_period\[180\]\[2\]$_DFFE_PP_ clknet_leaf_74_clk_load
+ net421 _03176_ VSS VSS VDD VDD network.in_period\[180\]\[2\]
+ sky130_fd_sc_hd__edfxtp_1
Xnetwork.in_period\[180\]\[3\]$_DFFE_PP_ clknet_leaf_74_clk_load
+ net419 _03176_ VSS VSS VDD VDD network.in_period\[180\]\[3\]
+ sky130_fd_sc_hd__edfxtp_1
Xnetwork.in_period\[181\]\[0\]$_DFFE_PP_ clknet_leaf_75_clk_load
+ net435 _03177_ VSS VSS VDD VDD network.in_period\[181\]\[0\]
+ sky130_fd_sc_hd__edfxtp_1
Xnetwork.in_period\[181\]\[1\]$_DFFE_PP_ clknet_leaf_74_clk_load
+ net432 _03177_ VSS VSS VDD VDD network.in_period\[181\]\[1\]
+ sky130_fd_sc_hd__edfxtp_1
Xnetwork.in_period\[181\]\[2\]$_DFFE_PP_ clknet_leaf_74_clk_load
+ net421 _03177_ VSS VSS VDD VDD network.in_period\[181\]\[2\]
+ sky130_fd_sc_hd__edfxtp_1
Xnetwork.in_period\[181\]\[3\]$_DFFE_PP_ clknet_leaf_74_clk_load
+ net419 _03177_ VSS VSS VDD VDD network.in_period\[181\]\[3\]
+ sky130_fd_sc_hd__edfxtp_1
Xnetwork.in_period\[182\]\[0\]$_DFFE_PP_ clknet_leaf_71_clk_load
+ net435 _03178_ VSS VSS VDD VDD network.in_period\[182\]\[0\]
+ sky130_fd_sc_hd__edfxtp_1
Xnetwork.in_period\[182\]\[1\]$_DFFE_PP_ clknet_leaf_74_clk_load
+ net432 _03178_ VSS VSS VDD VDD network.in_period\[182\]\[1\]
+ sky130_fd_sc_hd__edfxtp_1
Xnetwork.in_period\[182\]\[2\]$_DFFE_PP_ clknet_leaf_73_clk_load
+ net424 _03178_ VSS VSS VDD VDD network.in_period\[182\]\[2\]
+ sky130_fd_sc_hd__edfxtp_1
Xnetwork.in_period\[182\]\[3\]$_DFFE_PP_ clknet_leaf_74_clk_load
+ net419 _03178_ VSS VSS VDD VDD network.in_period\[182\]\[3\]
+ sky130_fd_sc_hd__edfxtp_1
Xnetwork.in_period\[183\]\[0\]$_DFFE_PP_ clknet_leaf_76_clk_load
+ net436 _03179_ VSS VSS VDD VDD network.in_period\[183\]\[0\]
+ sky130_fd_sc_hd__edfxtp_1
Xnetwork.in_period\[183\]\[1\]$_DFFE_PP_ clknet_leaf_77_clk_load
+ net432 _03179_ VSS VSS VDD VDD network.in_period\[183\]\[1\]
+ sky130_fd_sc_hd__edfxtp_1
Xnetwork.in_period\[183\]\[2\]$_DFFE_PP_ clknet_leaf_76_clk_load
+ net421 _03179_ VSS VSS VDD VDD network.in_period\[183\]\[2\]
+ sky130_fd_sc_hd__edfxtp_1
Xnetwork.in_period\[183\]\[3\]$_DFFE_PP_ clknet_leaf_77_clk_load
+ net419 _03179_ VSS VSS VDD VDD network.in_period\[183\]\[3\]
+ sky130_fd_sc_hd__edfxtp_1
Xnetwork.in_period\[184\]\[0\]$_DFFE_PP_ clknet_leaf_80_clk_load
+ net436 _03180_ VSS VSS VDD VDD network.in_period\[184\]\[0\]
+ sky130_fd_sc_hd__edfxtp_1
Xnetwork.in_period\[184\]\[1\]$_DFFE_PP_ clknet_leaf_81_clk_load
+ net432 _03180_ VSS VSS VDD VDD network.in_period\[184\]\[1\]
+ sky130_fd_sc_hd__edfxtp_1
Xnetwork.in_period\[184\]\[2\]$_DFFE_PP_ clknet_leaf_80_clk_load
+ net421 _03180_ VSS VSS VDD VDD network.in_period\[184\]\[2\]
+ sky130_fd_sc_hd__edfxtp_1
Xnetwork.in_period\[184\]\[3\]$_DFFE_PP_ clknet_leaf_80_clk_load
+ net419 _03180_ VSS VSS VDD VDD network.in_period\[184\]\[3\]
+ sky130_fd_sc_hd__edfxtp_1
Xnetwork.in_period\[185\]\[0\]$_DFFE_PP_ clknet_leaf_80_clk_load
+ net436 _03181_ VSS VSS VDD VDD network.in_period\[185\]\[0\]
+ sky130_fd_sc_hd__edfxtp_1
Xnetwork.in_period\[185\]\[1\]$_DFFE_PP_ clknet_leaf_80_clk_load
+ net432 _03181_ VSS VSS VDD VDD network.in_period\[185\]\[1\]
+ sky130_fd_sc_hd__edfxtp_1
Xnetwork.in_period\[185\]\[2\]$_DFFE_PP_ clknet_leaf_80_clk_load
+ net421 _03181_ VSS VSS VDD VDD network.in_period\[185\]\[2\]
+ sky130_fd_sc_hd__edfxtp_1
Xnetwork.in_period\[185\]\[3\]$_DFFE_PP_ clknet_leaf_80_clk_load
+ net419 _03181_ VSS VSS VDD VDD network.in_period\[185\]\[3\]
+ sky130_fd_sc_hd__edfxtp_1
Xnetwork.in_period\[186\]\[0\]$_DFFE_PP_ clknet_leaf_80_clk_load
+ net436 _03182_ VSS VSS VDD VDD network.in_period\[186\]\[0\]
+ sky130_fd_sc_hd__edfxtp_1
Xnetwork.in_period\[186\]\[1\]$_DFFE_PP_ clknet_leaf_80_clk_load
+ net432 _03182_ VSS VSS VDD VDD network.in_period\[186\]\[1\]
+ sky130_fd_sc_hd__edfxtp_1
Xnetwork.in_period\[186\]\[2\]$_DFFE_PP_ clknet_leaf_80_clk_load
+ net421 _03182_ VSS VSS VDD VDD network.in_period\[186\]\[2\]
+ sky130_fd_sc_hd__edfxtp_1
Xnetwork.in_period\[186\]\[3\]$_DFFE_PP_ clknet_leaf_80_clk_load
+ net419 _03182_ VSS VSS VDD VDD network.in_period\[186\]\[3\]
+ sky130_fd_sc_hd__edfxtp_1
Xnetwork.in_period\[187\]\[0\]$_DFFE_PP_ clknet_leaf_76_clk_load
+ net436 _03183_ VSS VSS VDD VDD network.in_period\[187\]\[0\]
+ sky130_fd_sc_hd__edfxtp_1
Xnetwork.in_period\[187\]\[1\]$_DFFE_PP_ clknet_leaf_76_clk_load
+ net432 _03183_ VSS VSS VDD VDD network.in_period\[187\]\[1\]
+ sky130_fd_sc_hd__edfxtp_1
Xnetwork.in_period\[187\]\[2\]$_DFFE_PP_ clknet_leaf_76_clk_load
+ net421 _03183_ VSS VSS VDD VDD network.in_period\[187\]\[2\]
+ sky130_fd_sc_hd__edfxtp_1
Xnetwork.in_period\[187\]\[3\]$_DFFE_PP_ clknet_leaf_76_clk_load
+ net419 _03183_ VSS VSS VDD VDD network.in_period\[187\]\[3\]
+ sky130_fd_sc_hd__edfxtp_1
Xnetwork.in_period\[188\]\[0\]$_DFFE_PP_ clknet_leaf_75_clk_load
+ net435 _03184_ VSS VSS VDD VDD network.in_period\[188\]\[0\]
+ sky130_fd_sc_hd__edfxtp_1
Xnetwork.in_period\[188\]\[1\]$_DFFE_PP_ clknet_leaf_75_clk_load
+ net432 _03184_ VSS VSS VDD VDD network.in_period\[188\]\[1\]
+ sky130_fd_sc_hd__edfxtp_1
Xnetwork.in_period\[188\]\[2\]$_DFFE_PP_ clknet_leaf_74_clk_load
+ net421 _03184_ VSS VSS VDD VDD network.in_period\[188\]\[2\]
+ sky130_fd_sc_hd__edfxtp_1
Xnetwork.in_period\[188\]\[3\]$_DFFE_PP_ clknet_leaf_75_clk_load
+ net419 _03184_ VSS VSS VDD VDD network.in_period\[188\]\[3\]
+ sky130_fd_sc_hd__edfxtp_1
Xnetwork.in_period\[189\]\[0\]$_DFFE_PP_ clknet_leaf_75_clk_load
+ net435 _03185_ VSS VSS VDD VDD network.in_period\[189\]\[0\]
+ sky130_fd_sc_hd__edfxtp_1
Xnetwork.in_period\[189\]\[1\]$_DFFE_PP_ clknet_leaf_75_clk_load
+ net432 _03185_ VSS VSS VDD VDD network.in_period\[189\]\[1\]
+ sky130_fd_sc_hd__edfxtp_1
Xnetwork.in_period\[189\]\[2\]$_DFFE_PP_ clknet_leaf_75_clk_load
+ net421 _03185_ VSS VSS VDD VDD network.in_period\[189\]\[2\]
+ sky130_fd_sc_hd__edfxtp_1
Xnetwork.in_period\[189\]\[3\]$_DFFE_PP_ clknet_leaf_75_clk_load
+ net419 _03185_ VSS VSS VDD VDD network.in_period\[189\]\[3\]
+ sky130_fd_sc_hd__edfxtp_1
Xnetwork.in_period\[18\]\[0\]$_DFFE_PP_ clknet_leaf_35_clk_load
+ net440 _03186_ VSS VSS VDD VDD network.in_period\[18\]\[0\]
+ sky130_fd_sc_hd__edfxtp_1
Xnetwork.in_period\[18\]\[1\]$_DFFE_PP_ clknet_leaf_35_clk_load
+ net429 _03186_ VSS VSS VDD VDD network.in_period\[18\]\[1\]
+ sky130_fd_sc_hd__edfxtp_1
Xnetwork.in_period\[18\]\[2\]$_DFFE_PP_ clknet_leaf_35_clk_load
+ net426 _03186_ VSS VSS VDD VDD network.in_period\[18\]\[2\]
+ sky130_fd_sc_hd__edfxtp_1
Xnetwork.in_period\[18\]\[3\]$_DFFE_PP_ clknet_leaf_35_clk_load
+ net414 _03186_ VSS VSS VDD VDD network.in_period\[18\]\[3\]
+ sky130_fd_sc_hd__edfxtp_1
Xnetwork.in_period\[190\]\[0\]$_DFFE_PP_ clknet_leaf_75_clk_load
+ net435 _03187_ VSS VSS VDD VDD network.in_period\[190\]\[0\]
+ sky130_fd_sc_hd__edfxtp_1
Xnetwork.in_period\[190\]\[1\]$_DFFE_PP_ clknet_leaf_75_clk_load
+ net432 _03187_ VSS VSS VDD VDD network.in_period\[190\]\[1\]
+ sky130_fd_sc_hd__edfxtp_1
Xnetwork.in_period\[190\]\[2\]$_DFFE_PP_ clknet_leaf_75_clk_load
+ net421 _03187_ VSS VSS VDD VDD network.in_period\[190\]\[2\]
+ sky130_fd_sc_hd__edfxtp_1
Xnetwork.in_period\[190\]\[3\]$_DFFE_PP_ clknet_leaf_75_clk_load
+ net419 _03187_ VSS VSS VDD VDD network.in_period\[190\]\[3\]
+ sky130_fd_sc_hd__edfxtp_1
Xnetwork.in_period\[191\]\[0\]$_DFFE_PP_ clknet_leaf_76_clk_load
+ net436 _03188_ VSS VSS VDD VDD network.in_period\[191\]\[0\]
+ sky130_fd_sc_hd__edfxtp_1
Xnetwork.in_period\[191\]\[1\]$_DFFE_PP_ clknet_leaf_76_clk_load
+ net432 _03188_ VSS VSS VDD VDD network.in_period\[191\]\[1\]
+ sky130_fd_sc_hd__edfxtp_1
Xnetwork.in_period\[191\]\[2\]$_DFFE_PP_ clknet_leaf_76_clk_load
+ net421 _03188_ VSS VSS VDD VDD network.in_period\[191\]\[2\]
+ sky130_fd_sc_hd__edfxtp_1
Xnetwork.in_period\[191\]\[3\]$_DFFE_PP_ clknet_leaf_76_clk_load
+ net419 _03188_ VSS VSS VDD VDD network.in_period\[191\]\[3\]
+ sky130_fd_sc_hd__edfxtp_1
Xnetwork.in_period\[192\]\[0\]$_DFFE_PP_ clknet_leaf_56_clk_load
+ net439 _03189_ VSS VSS VDD VDD network.in_period\[192\]\[0\]
+ sky130_fd_sc_hd__edfxtp_1
Xnetwork.in_period\[192\]\[1\]$_DFFE_PP_ clknet_leaf_56_clk_load
+ net431 _03189_ VSS VSS VDD VDD network.in_period\[192\]\[1\]
+ sky130_fd_sc_hd__edfxtp_1
Xnetwork.in_period\[192\]\[2\]$_DFFE_PP_ clknet_leaf_56_clk_load
+ net422 _03189_ VSS VSS VDD VDD network.in_period\[192\]\[2\]
+ sky130_fd_sc_hd__edfxtp_1
Xnetwork.in_period\[192\]\[3\]$_DFFE_PP_ clknet_leaf_57_clk_load
+ net788 _03189_ VSS VSS VDD VDD network.in_period\[192\]\[3\]
+ sky130_fd_sc_hd__edfxtp_1
Xnetwork.in_period\[193\]\[0\]$_DFFE_PP_ clknet_leaf_50_clk_load
+ net439 _03190_ VSS VSS VDD VDD network.in_period\[193\]\[0\]
+ sky130_fd_sc_hd__edfxtp_1
Xnetwork.in_period\[193\]\[1\]$_DFFE_PP_ clknet_leaf_49_clk_load
+ net433 _03190_ VSS VSS VDD VDD network.in_period\[193\]\[1\]
+ sky130_fd_sc_hd__edfxtp_1
Xnetwork.in_period\[193\]\[2\]$_DFFE_PP_ clknet_leaf_50_clk_load
+ net423 _03190_ VSS VSS VDD VDD network.in_period\[193\]\[2\]
+ sky130_fd_sc_hd__edfxtp_1
Xnetwork.in_period\[193\]\[3\]$_DFFE_PP_ clknet_leaf_50_clk_load
+ net416 _03190_ VSS VSS VDD VDD network.in_period\[193\]\[3\]
+ sky130_fd_sc_hd__edfxtp_1
Xnetwork.in_period\[194\]\[0\]$_DFFE_PP_ clknet_leaf_50_clk_load
+ net439 _03191_ VSS VSS VDD VDD network.in_period\[194\]\[0\]
+ sky130_fd_sc_hd__edfxtp_1
Xnetwork.in_period\[194\]\[1\]$_DFFE_PP_ clknet_leaf_50_clk_load
+ net433 _03191_ VSS VSS VDD VDD network.in_period\[194\]\[1\]
+ sky130_fd_sc_hd__edfxtp_1
Xnetwork.in_period\[194\]\[2\]$_DFFE_PP_ clknet_leaf_56_clk_load
+ net423 _03191_ VSS VSS VDD VDD network.in_period\[194\]\[2\]
+ sky130_fd_sc_hd__edfxtp_1
Xnetwork.in_period\[194\]\[3\]$_DFFE_PP_ clknet_leaf_56_clk_load
+ net788 _03191_ VSS VSS VDD VDD network.in_period\[194\]\[3\]
+ sky130_fd_sc_hd__edfxtp_1
Xnetwork.in_period\[195\]\[0\]$_DFFE_PP_ clknet_leaf_56_clk_load
+ net439 _03192_ VSS VSS VDD VDD network.in_period\[195\]\[0\]
+ sky130_fd_sc_hd__edfxtp_1
Xnetwork.in_period\[195\]\[1\]$_DFFE_PP_ clknet_leaf_49_clk_load
+ net433 _03192_ VSS VSS VDD VDD network.in_period\[195\]\[1\]
+ sky130_fd_sc_hd__edfxtp_1
Xnetwork.in_period\[195\]\[2\]$_DFFE_PP_ clknet_leaf_50_clk_load
+ net423 _03192_ VSS VSS VDD VDD network.in_period\[195\]\[2\]
+ sky130_fd_sc_hd__edfxtp_1
Xnetwork.in_period\[195\]\[3\]$_DFFE_PP_ clknet_leaf_56_clk_load
+ net788 _03192_ VSS VSS VDD VDD network.in_period\[195\]\[3\]
+ sky130_fd_sc_hd__edfxtp_1
Xnetwork.in_period\[196\]\[0\]$_DFFE_PP_ clknet_leaf_54_clk_load
+ net439 _03193_ VSS VSS VDD VDD network.in_period\[196\]\[0\]
+ sky130_fd_sc_hd__edfxtp_1
Xnetwork.in_period\[196\]\[1\]$_DFFE_PP_ clknet_leaf_55_clk_load
+ net433 _03193_ VSS VSS VDD VDD network.in_period\[196\]\[1\]
+ sky130_fd_sc_hd__edfxtp_1
Xnetwork.in_period\[196\]\[2\]$_DFFE_PP_ clknet_leaf_56_clk_load
+ net423 _03193_ VSS VSS VDD VDD network.in_period\[196\]\[2\]
+ sky130_fd_sc_hd__edfxtp_1
Xnetwork.in_period\[196\]\[3\]$_DFFE_PP_ clknet_leaf_54_clk_load
+ net788 _03193_ VSS VSS VDD VDD network.in_period\[196\]\[3\]
+ sky130_fd_sc_hd__edfxtp_1
Xnetwork.in_period\[197\]\[0\]$_DFFE_PP_ clknet_leaf_54_clk_load
+ net439 _03194_ VSS VSS VDD VDD network.in_period\[197\]\[0\]
+ sky130_fd_sc_hd__edfxtp_1
Xnetwork.in_period\[197\]\[1\]$_DFFE_PP_ clknet_leaf_54_clk_load
+ net433 _03194_ VSS VSS VDD VDD network.in_period\[197\]\[1\]
+ sky130_fd_sc_hd__edfxtp_1
Xnetwork.in_period\[197\]\[2\]$_DFFE_PP_ clknet_leaf_54_clk_load
+ net423 _03194_ VSS VSS VDD VDD network.in_period\[197\]\[2\]
+ sky130_fd_sc_hd__edfxtp_1
Xnetwork.in_period\[197\]\[3\]$_DFFE_PP_ clknet_leaf_54_clk_load
+ net788 _03194_ VSS VSS VDD VDD network.in_period\[197\]\[3\]
+ sky130_fd_sc_hd__edfxtp_1
Xnetwork.in_period\[198\]\[0\]$_DFFE_PP_ clknet_leaf_52_clk_load
+ net439 _03195_ VSS VSS VDD VDD network.in_period\[198\]\[0\]
+ sky130_fd_sc_hd__edfxtp_1
Xnetwork.in_period\[198\]\[1\]$_DFFE_PP_ clknet_leaf_52_clk_load
+ net431 _03195_ VSS VSS VDD VDD network.in_period\[198\]\[1\]
+ sky130_fd_sc_hd__edfxtp_1
Xnetwork.in_period\[198\]\[2\]$_DFFE_PP_ clknet_leaf_52_clk_load
+ net422 _03195_ VSS VSS VDD VDD network.in_period\[198\]\[2\]
+ sky130_fd_sc_hd__edfxtp_1
Xnetwork.in_period\[198\]\[3\]$_DFFE_PP_ clknet_leaf_52_clk_load
+ net788 _03195_ VSS VSS VDD VDD network.in_period\[198\]\[3\]
+ sky130_fd_sc_hd__edfxtp_1
Xnetwork.in_period\[199\]\[0\]$_DFFE_PP_ clknet_leaf_55_clk_load
+ net439 _03196_ VSS VSS VDD VDD network.in_period\[199\]\[0\]
+ sky130_fd_sc_hd__edfxtp_1
Xnetwork.in_period\[199\]\[1\]$_DFFE_PP_ clknet_leaf_55_clk_load
+ net433 _03196_ VSS VSS VDD VDD network.in_period\[199\]\[1\]
+ sky130_fd_sc_hd__edfxtp_1
Xnetwork.in_period\[199\]\[2\]$_DFFE_PP_ clknet_leaf_55_clk_load
+ net423 _03196_ VSS VSS VDD VDD network.in_period\[199\]\[2\]
+ sky130_fd_sc_hd__edfxtp_1
Xnetwork.in_period\[199\]\[3\]$_DFFE_PP_ clknet_leaf_55_clk_load
+ net788 _03196_ VSS VSS VDD VDD network.in_period\[199\]\[3\]
+ sky130_fd_sc_hd__edfxtp_1
Xnetwork.in_period\[19\]\[0\]$_DFFE_PP_ clknet_leaf_36_clk_load
+ net440 _03197_ VSS VSS VDD VDD network.in_period\[19\]\[0\]
+ sky130_fd_sc_hd__edfxtp_1
Xnetwork.in_period\[19\]\[1\]$_DFFE_PP_ clknet_leaf_36_clk_load
+ net429 _03197_ VSS VSS VDD VDD network.in_period\[19\]\[1\]
+ sky130_fd_sc_hd__edfxtp_1
Xnetwork.in_period\[19\]\[2\]$_DFFE_PP_ clknet_leaf_35_clk_load
+ net426 _03197_ VSS VSS VDD VDD network.in_period\[19\]\[2\]
+ sky130_fd_sc_hd__edfxtp_1
Xnetwork.in_period\[19\]\[3\]$_DFFE_PP_ clknet_leaf_35_clk_load
+ net414 _03197_ VSS VSS VDD VDD network.in_period\[19\]\[3\]
+ sky130_fd_sc_hd__edfxtp_1
Xnetwork.in_period\[1\]\[0\]$_DFFE_PP_ clknet_leaf_42_clk_load
+ net439 _03198_ VSS VSS VDD VDD network.in_period\[1\]\[0\]
+ sky130_fd_sc_hd__edfxtp_1
Xnetwork.in_period\[1\]\[1\]$_DFFE_PP_ clknet_leaf_42_clk_load
+ net430 _03198_ VSS VSS VDD VDD network.in_period\[1\]\[1\]
+ sky130_fd_sc_hd__edfxtp_1
Xnetwork.in_period\[1\]\[2\]$_DFFE_PP_ clknet_leaf_42_clk_load
+ net426 _03198_ VSS VSS VDD VDD network.in_period\[1\]\[2\]
+ sky130_fd_sc_hd__edfxtp_1
Xnetwork.in_period\[1\]\[3\]$_DFFE_PP_ clknet_leaf_42_clk_load
+ net414 _03198_ VSS VSS VDD VDD network.in_period\[1\]\[3\]
+ sky130_fd_sc_hd__edfxtp_1
Xnetwork.in_period\[200\]\[0\]$_DFFE_PP_ clknet_leaf_49_clk_load
+ net439 _03199_ VSS VSS VDD VDD network.in_period\[200\]\[0\]
+ sky130_fd_sc_hd__edfxtp_1
Xnetwork.in_period\[200\]\[1\]$_DFFE_PP_ clknet_leaf_49_clk_load
+ net433 _03199_ VSS VSS VDD VDD network.in_period\[200\]\[1\]
+ sky130_fd_sc_hd__edfxtp_1
Xnetwork.in_period\[200\]\[2\]$_DFFE_PP_ clknet_leaf_49_clk_load
+ net423 _03199_ VSS VSS VDD VDD network.in_period\[200\]\[2\]
+ sky130_fd_sc_hd__edfxtp_1
Xnetwork.in_period\[200\]\[3\]$_DFFE_PP_ clknet_leaf_49_clk_load
+ net416 _03199_ VSS VSS VDD VDD network.in_period\[200\]\[3\]
+ sky130_fd_sc_hd__edfxtp_1
Xnetwork.in_period\[201\]\[0\]$_DFFE_PP_ clknet_leaf_55_clk_load
+ net439 _03200_ VSS VSS VDD VDD network.in_period\[201\]\[0\]
+ sky130_fd_sc_hd__edfxtp_1
Xnetwork.in_period\[201\]\[1\]$_DFFE_PP_ clknet_leaf_55_clk_load
+ net433 _03200_ VSS VSS VDD VDD network.in_period\[201\]\[1\]
+ sky130_fd_sc_hd__edfxtp_1
Xnetwork.in_period\[201\]\[2\]$_DFFE_PP_ clknet_leaf_55_clk_load
+ net423 _03200_ VSS VSS VDD VDD network.in_period\[201\]\[2\]
+ sky130_fd_sc_hd__edfxtp_1
Xnetwork.in_period\[201\]\[3\]$_DFFE_PP_ clknet_leaf_55_clk_load
+ net788 _03200_ VSS VSS VDD VDD network.in_period\[201\]\[3\]
+ sky130_fd_sc_hd__edfxtp_1
Xnetwork.in_period\[202\]\[0\]$_DFFE_PP_ clknet_leaf_52_clk_load
+ net439 _03201_ VSS VSS VDD VDD network.in_period\[202\]\[0\]
+ sky130_fd_sc_hd__edfxtp_1
Xnetwork.in_period\[202\]\[1\]$_DFFE_PP_ clknet_leaf_52_clk_load
+ net431 _03201_ VSS VSS VDD VDD network.in_period\[202\]\[1\]
+ sky130_fd_sc_hd__edfxtp_1
Xnetwork.in_period\[202\]\[2\]$_DFFE_PP_ clknet_leaf_52_clk_load
+ net422 _03201_ VSS VSS VDD VDD network.in_period\[202\]\[2\]
+ sky130_fd_sc_hd__edfxtp_1
Xnetwork.in_period\[202\]\[3\]$_DFFE_PP_ clknet_leaf_52_clk_load
+ net788 _03201_ VSS VSS VDD VDD network.in_period\[202\]\[3\]
+ sky130_fd_sc_hd__edfxtp_1
Xnetwork.in_period\[203\]\[0\]$_DFFE_PP_ clknet_leaf_53_clk_load
+ net435 _03202_ VSS VSS VDD VDD network.in_period\[203\]\[0\]
+ sky130_fd_sc_hd__edfxtp_1
Xnetwork.in_period\[203\]\[1\]$_DFFE_PP_ clknet_leaf_53_clk_load
+ net431 _03202_ VSS VSS VDD VDD network.in_period\[203\]\[1\]
+ sky130_fd_sc_hd__edfxtp_1
Xnetwork.in_period\[203\]\[2\]$_DFFE_PP_ clknet_leaf_53_clk_load
+ net422 _03202_ VSS VSS VDD VDD network.in_period\[203\]\[2\]
+ sky130_fd_sc_hd__edfxtp_1
Xnetwork.in_period\[203\]\[3\]$_DFFE_PP_ clknet_leaf_53_clk_load
+ net788 _03202_ VSS VSS VDD VDD network.in_period\[203\]\[3\]
+ sky130_fd_sc_hd__edfxtp_1
Xnetwork.in_period\[204\]\[0\]$_DFFE_PP_ clknet_leaf_54_clk_load
+ net439 _03203_ VSS VSS VDD VDD network.in_period\[204\]\[0\]
+ sky130_fd_sc_hd__edfxtp_1
Xnetwork.in_period\[204\]\[1\]$_DFFE_PP_ clknet_leaf_54_clk_load
+ net433 _03203_ VSS VSS VDD VDD network.in_period\[204\]\[1\]
+ sky130_fd_sc_hd__edfxtp_1
Xnetwork.in_period\[204\]\[2\]$_DFFE_PP_ clknet_leaf_53_clk_load
+ net423 _03203_ VSS VSS VDD VDD network.in_period\[204\]\[2\]
+ sky130_fd_sc_hd__edfxtp_1
Xnetwork.in_period\[204\]\[3\]$_DFFE_PP_ clknet_leaf_53_clk_load
+ net788 _03203_ VSS VSS VDD VDD network.in_period\[204\]\[3\]
+ sky130_fd_sc_hd__edfxtp_1
Xnetwork.in_period\[205\]\[0\]$_DFFE_PP_ clknet_leaf_51_clk_load
+ net435 _03204_ VSS VSS VDD VDD network.in_period\[205\]\[0\]
+ sky130_fd_sc_hd__edfxtp_1
Xnetwork.in_period\[205\]\[1\]$_DFFE_PP_ clknet_leaf_51_clk_load
+ net431 _03204_ VSS VSS VDD VDD network.in_period\[205\]\[1\]
+ sky130_fd_sc_hd__edfxtp_1
Xnetwork.in_period\[205\]\[2\]$_DFFE_PP_ clknet_leaf_51_clk_load
+ net422 _03204_ VSS VSS VDD VDD network.in_period\[205\]\[2\]
+ sky130_fd_sc_hd__edfxtp_1
Xnetwork.in_period\[205\]\[3\]$_DFFE_PP_ clknet_leaf_51_clk_load
+ net788 _03204_ VSS VSS VDD VDD network.in_period\[205\]\[3\]
+ sky130_fd_sc_hd__edfxtp_1
Xnetwork.in_period\[206\]\[0\]$_DFFE_PP_ clknet_leaf_51_clk_load
+ net435 _03205_ VSS VSS VDD VDD network.in_period\[206\]\[0\]
+ sky130_fd_sc_hd__edfxtp_1
Xnetwork.in_period\[206\]\[1\]$_DFFE_PP_ clknet_leaf_51_clk_load
+ net431 _03205_ VSS VSS VDD VDD network.in_period\[206\]\[1\]
+ sky130_fd_sc_hd__edfxtp_1
Xnetwork.in_period\[206\]\[2\]$_DFFE_PP_ clknet_leaf_51_clk_load
+ net422 _03205_ VSS VSS VDD VDD network.in_period\[206\]\[2\]
+ sky130_fd_sc_hd__edfxtp_1
Xnetwork.in_period\[206\]\[3\]$_DFFE_PP_ clknet_leaf_51_clk_load
+ net788 _03205_ VSS VSS VDD VDD network.in_period\[206\]\[3\]
+ sky130_fd_sc_hd__edfxtp_1
Xnetwork.in_period\[207\]\[0\]$_DFFE_PP_ clknet_leaf_52_clk_load
+ net435 _03206_ VSS VSS VDD VDD network.in_period\[207\]\[0\]
+ sky130_fd_sc_hd__edfxtp_1
Xnetwork.in_period\[207\]\[1\]$_DFFE_PP_ clknet_leaf_53_clk_load
+ net431 _03206_ VSS VSS VDD VDD network.in_period\[207\]\[1\]
+ sky130_fd_sc_hd__edfxtp_1
Xnetwork.in_period\[207\]\[2\]$_DFFE_PP_ clknet_leaf_53_clk_load
+ net422 _03206_ VSS VSS VDD VDD network.in_period\[207\]\[2\]
+ sky130_fd_sc_hd__edfxtp_1
Xnetwork.in_period\[207\]\[3\]$_DFFE_PP_ clknet_leaf_52_clk_load
+ net788 _03206_ VSS VSS VDD VDD network.in_period\[207\]\[3\]
+ sky130_fd_sc_hd__edfxtp_1
Xnetwork.in_period\[208\]\[0\]$_DFFE_PP_ clknet_leaf_66_clk_load
+ net435 _03207_ VSS VSS VDD VDD network.in_period\[208\]\[0\]
+ sky130_fd_sc_hd__edfxtp_1
Xnetwork.in_period\[208\]\[1\]$_DFFE_PP_ clknet_leaf_65_clk_load
+ net431 _03207_ VSS VSS VDD VDD network.in_period\[208\]\[1\]
+ sky130_fd_sc_hd__edfxtp_1
Xnetwork.in_period\[208\]\[2\]$_DFFE_PP_ clknet_leaf_66_clk_load
+ net422 _03207_ VSS VSS VDD VDD network.in_period\[208\]\[2\]
+ sky130_fd_sc_hd__edfxtp_1
Xnetwork.in_period\[208\]\[3\]$_DFFE_PP_ clknet_leaf_66_clk_load
+ net418 _03207_ VSS VSS VDD VDD network.in_period\[208\]\[3\]
+ sky130_fd_sc_hd__edfxtp_1
Xnetwork.in_period\[209\]\[0\]$_DFFE_PP_ clknet_leaf_65_clk_load
+ net435 _03208_ VSS VSS VDD VDD network.in_period\[209\]\[0\]
+ sky130_fd_sc_hd__edfxtp_1
Xnetwork.in_period\[209\]\[1\]$_DFFE_PP_ clknet_leaf_65_clk_load
+ net431 _03208_ VSS VSS VDD VDD network.in_period\[209\]\[1\]
+ sky130_fd_sc_hd__edfxtp_1
Xnetwork.in_period\[209\]\[2\]$_DFFE_PP_ clknet_leaf_65_clk_load
+ net422 _03208_ VSS VSS VDD VDD network.in_period\[209\]\[2\]
+ sky130_fd_sc_hd__edfxtp_1
Xnetwork.in_period\[209\]\[3\]$_DFFE_PP_ clknet_leaf_65_clk_load
+ net418 _03208_ VSS VSS VDD VDD network.in_period\[209\]\[3\]
+ sky130_fd_sc_hd__edfxtp_1
Xnetwork.in_period\[20\]\[0\]$_DFFE_PP_ clknet_leaf_33_clk_load
+ net440 _03209_ VSS VSS VDD VDD network.in_period\[20\]\[0\]
+ sky130_fd_sc_hd__edfxtp_1
Xnetwork.in_period\[20\]\[1\]$_DFFE_PP_ clknet_leaf_33_clk_load
+ net429 _03209_ VSS VSS VDD VDD network.in_period\[20\]\[1\]
+ sky130_fd_sc_hd__edfxtp_1
Xnetwork.in_period\[20\]\[2\]$_DFFE_PP_ clknet_leaf_33_clk_load
+ net426 _03209_ VSS VSS VDD VDD network.in_period\[20\]\[2\]
+ sky130_fd_sc_hd__edfxtp_1
Xnetwork.in_period\[20\]\[3\]$_DFFE_PP_ clknet_leaf_33_clk_load
+ net414 _03209_ VSS VSS VDD VDD network.in_period\[20\]\[3\]
+ sky130_fd_sc_hd__edfxtp_1
Xnetwork.in_period\[210\]\[0\]$_DFFE_PP_ clknet_leaf_65_clk_load
+ net435 _03210_ VSS VSS VDD VDD network.in_period\[210\]\[0\]
+ sky130_fd_sc_hd__edfxtp_1
Xnetwork.in_period\[210\]\[1\]$_DFFE_PP_ clknet_leaf_65_clk_load
+ net431 _03210_ VSS VSS VDD VDD network.in_period\[210\]\[1\]
+ sky130_fd_sc_hd__edfxtp_1
Xnetwork.in_period\[210\]\[2\]$_DFFE_PP_ clknet_leaf_65_clk_load
+ net422 _03210_ VSS VSS VDD VDD network.in_period\[210\]\[2\]
+ sky130_fd_sc_hd__edfxtp_1
Xnetwork.in_period\[210\]\[3\]$_DFFE_PP_ clknet_leaf_66_clk_load
+ net418 _03210_ VSS VSS VDD VDD network.in_period\[210\]\[3\]
+ sky130_fd_sc_hd__edfxtp_1
Xnetwork.in_period\[211\]\[0\]$_DFFE_PP_ clknet_leaf_64_clk_load
+ net435 _03211_ VSS VSS VDD VDD network.in_period\[211\]\[0\]
+ sky130_fd_sc_hd__edfxtp_1
Xnetwork.in_period\[211\]\[1\]$_DFFE_PP_ clknet_leaf_65_clk_load
+ net431 _03211_ VSS VSS VDD VDD network.in_period\[211\]\[1\]
+ sky130_fd_sc_hd__edfxtp_1
Xnetwork.in_period\[211\]\[2\]$_DFFE_PP_ clknet_leaf_65_clk_load
+ net422 _03211_ VSS VSS VDD VDD network.in_period\[211\]\[2\]
+ sky130_fd_sc_hd__edfxtp_1
Xnetwork.in_period\[211\]\[3\]$_DFFE_PP_ clknet_leaf_65_clk_load
+ net418 _03211_ VSS VSS VDD VDD network.in_period\[211\]\[3\]
+ sky130_fd_sc_hd__edfxtp_1
Xnetwork.in_period\[212\]\[0\]$_DFFE_PP_ clknet_leaf_64_clk_load
+ net435 _03212_ VSS VSS VDD VDD network.in_period\[212\]\[0\]
+ sky130_fd_sc_hd__edfxtp_1
Xnetwork.in_period\[212\]\[1\]$_DFFE_PP_ clknet_leaf_64_clk_load
+ net431 _03212_ VSS VSS VDD VDD network.in_period\[212\]\[1\]
+ sky130_fd_sc_hd__edfxtp_1
Xnetwork.in_period\[212\]\[2\]$_DFFE_PP_ clknet_leaf_64_clk_load
+ net422 _03212_ VSS VSS VDD VDD network.in_period\[212\]\[2\]
+ sky130_fd_sc_hd__edfxtp_1
Xnetwork.in_period\[212\]\[3\]$_DFFE_PP_ clknet_leaf_64_clk_load
+ net418 _03212_ VSS VSS VDD VDD network.in_period\[212\]\[3\]
+ sky130_fd_sc_hd__edfxtp_1
Xnetwork.in_period\[213\]\[0\]$_DFFE_PP_ clknet_leaf_66_clk_load
+ net435 _03213_ VSS VSS VDD VDD network.in_period\[213\]\[0\]
+ sky130_fd_sc_hd__edfxtp_1
Xnetwork.in_period\[213\]\[1\]$_DFFE_PP_ clknet_leaf_66_clk_load
+ net431 _03213_ VSS VSS VDD VDD network.in_period\[213\]\[1\]
+ sky130_fd_sc_hd__edfxtp_1
Xnetwork.in_period\[213\]\[2\]$_DFFE_PP_ clknet_leaf_66_clk_load
+ net422 _03213_ VSS VSS VDD VDD network.in_period\[213\]\[2\]
+ sky130_fd_sc_hd__edfxtp_1
Xnetwork.in_period\[213\]\[3\]$_DFFE_PP_ clknet_leaf_66_clk_load
+ net418 _03213_ VSS VSS VDD VDD network.in_period\[213\]\[3\]
+ sky130_fd_sc_hd__edfxtp_1
Xnetwork.in_period\[214\]\[0\]$_DFFE_PP_ clknet_leaf_67_clk_load
+ net435 _03214_ VSS VSS VDD VDD network.in_period\[214\]\[0\]
+ sky130_fd_sc_hd__edfxtp_1
Xnetwork.in_period\[214\]\[1\]$_DFFE_PP_ clknet_leaf_67_clk_load
+ net431 _03214_ VSS VSS VDD VDD network.in_period\[214\]\[1\]
+ sky130_fd_sc_hd__edfxtp_1
Xnetwork.in_period\[214\]\[2\]$_DFFE_PP_ clknet_leaf_67_clk_load
+ net424 _03214_ VSS VSS VDD VDD network.in_period\[214\]\[2\]
+ sky130_fd_sc_hd__edfxtp_1
Xnetwork.in_period\[214\]\[3\]$_DFFE_PP_ clknet_leaf_67_clk_load
+ net418 _03214_ VSS VSS VDD VDD network.in_period\[214\]\[3\]
+ sky130_fd_sc_hd__edfxtp_1
Xnetwork.in_period\[215\]\[0\]$_DFFE_PP_ clknet_leaf_67_clk_load
+ net435 _03215_ VSS VSS VDD VDD network.in_period\[215\]\[0\]
+ sky130_fd_sc_hd__edfxtp_1
Xnetwork.in_period\[215\]\[1\]$_DFFE_PP_ clknet_leaf_67_clk_load
+ net432 _03215_ VSS VSS VDD VDD network.in_period\[215\]\[1\]
+ sky130_fd_sc_hd__edfxtp_1
Xnetwork.in_period\[215\]\[2\]$_DFFE_PP_ clknet_leaf_67_clk_load
+ net424 _03215_ VSS VSS VDD VDD network.in_period\[215\]\[2\]
+ sky130_fd_sc_hd__edfxtp_1
Xnetwork.in_period\[215\]\[3\]$_DFFE_PP_ clknet_leaf_67_clk_load
+ net418 _03215_ VSS VSS VDD VDD network.in_period\[215\]\[3\]
+ sky130_fd_sc_hd__edfxtp_1
Xnetwork.in_period\[216\]\[0\]$_DFFE_PP_ clknet_leaf_69_clk_load
+ net435 _03216_ VSS VSS VDD VDD network.in_period\[216\]\[0\]
+ sky130_fd_sc_hd__edfxtp_1
Xnetwork.in_period\[216\]\[1\]$_DFFE_PP_ clknet_leaf_69_clk_load
+ net431 _03216_ VSS VSS VDD VDD network.in_period\[216\]\[1\]
+ sky130_fd_sc_hd__edfxtp_1
Xnetwork.in_period\[216\]\[2\]$_DFFE_PP_ clknet_leaf_68_clk_load
+ net422 _03216_ VSS VSS VDD VDD network.in_period\[216\]\[2\]
+ sky130_fd_sc_hd__edfxtp_1
Xnetwork.in_period\[216\]\[3\]$_DFFE_PP_ clknet_leaf_68_clk_load
+ net418 _03216_ VSS VSS VDD VDD network.in_period\[216\]\[3\]
+ sky130_fd_sc_hd__edfxtp_1
Xnetwork.in_period\[217\]\[0\]$_DFFE_PP_ clknet_leaf_62_clk_load
+ net435 _03217_ VSS VSS VDD VDD network.in_period\[217\]\[0\]
+ sky130_fd_sc_hd__edfxtp_1
Xnetwork.in_period\[217\]\[1\]$_DFFE_PP_ clknet_leaf_62_clk_load
+ net431 _03217_ VSS VSS VDD VDD network.in_period\[217\]\[1\]
+ sky130_fd_sc_hd__edfxtp_1
Xnetwork.in_period\[217\]\[2\]$_DFFE_PP_ clknet_leaf_62_clk_load
+ net422 _03217_ VSS VSS VDD VDD network.in_period\[217\]\[2\]
+ sky130_fd_sc_hd__edfxtp_1
Xnetwork.in_period\[217\]\[3\]$_DFFE_PP_ clknet_leaf_62_clk_load
+ net418 _03217_ VSS VSS VDD VDD network.in_period\[217\]\[3\]
+ sky130_fd_sc_hd__edfxtp_1
Xnetwork.in_period\[218\]\[0\]$_DFFE_PP_ clknet_leaf_66_clk_load
+ net435 _03218_ VSS VSS VDD VDD network.in_period\[218\]\[0\]
+ sky130_fd_sc_hd__edfxtp_1
Xnetwork.in_period\[218\]\[1\]$_DFFE_PP_ clknet_leaf_66_clk_load
+ net431 _03218_ VSS VSS VDD VDD network.in_period\[218\]\[1\]
+ sky130_fd_sc_hd__edfxtp_1
Xnetwork.in_period\[218\]\[2\]$_DFFE_PP_ clknet_leaf_67_clk_load
+ net424 _03218_ VSS VSS VDD VDD network.in_period\[218\]\[2\]
+ sky130_fd_sc_hd__edfxtp_1
Xnetwork.in_period\[218\]\[3\]$_DFFE_PP_ clknet_leaf_67_clk_load
+ net418 _03218_ VSS VSS VDD VDD network.in_period\[218\]\[3\]
+ sky130_fd_sc_hd__edfxtp_1
Xnetwork.in_period\[219\]\[0\]$_DFFE_PP_ clknet_leaf_69_clk_load
+ net435 _03219_ VSS VSS VDD VDD network.in_period\[219\]\[0\]
+ sky130_fd_sc_hd__edfxtp_1
Xnetwork.in_period\[219\]\[1\]$_DFFE_PP_ clknet_leaf_70_clk_load
+ net432 _03219_ VSS VSS VDD VDD network.in_period\[219\]\[1\]
+ sky130_fd_sc_hd__edfxtp_1
Xnetwork.in_period\[219\]\[2\]$_DFFE_PP_ clknet_leaf_68_clk_load
+ net424 _03219_ VSS VSS VDD VDD network.in_period\[219\]\[2\]
+ sky130_fd_sc_hd__edfxtp_1
Xnetwork.in_period\[219\]\[3\]$_DFFE_PP_ clknet_leaf_68_clk_load
+ net418 _03219_ VSS VSS VDD VDD network.in_period\[219\]\[3\]
+ sky130_fd_sc_hd__edfxtp_1
Xnetwork.in_period\[21\]\[0\]$_DFFE_PP_ clknet_leaf_32_clk_load
+ net440 _03220_ VSS VSS VDD VDD network.in_period\[21\]\[0\]
+ sky130_fd_sc_hd__edfxtp_1
Xnetwork.in_period\[21\]\[1\]$_DFFE_PP_ clknet_leaf_32_clk_load
+ net429 _03220_ VSS VSS VDD VDD network.in_period\[21\]\[1\]
+ sky130_fd_sc_hd__edfxtp_1
Xnetwork.in_period\[21\]\[2\]$_DFFE_PP_ clknet_leaf_32_clk_load
+ net426 _03220_ VSS VSS VDD VDD network.in_period\[21\]\[2\]
+ sky130_fd_sc_hd__edfxtp_1
Xnetwork.in_period\[21\]\[3\]$_DFFE_PP_ clknet_leaf_32_clk_load
+ net414 _03220_ VSS VSS VDD VDD network.in_period\[21\]\[3\]
+ sky130_fd_sc_hd__edfxtp_1
Xnetwork.in_period\[220\]\[0\]$_DFFE_PP_ clknet_leaf_72_clk_load
+ net435 _03221_ VSS VSS VDD VDD network.in_period\[220\]\[0\]
+ sky130_fd_sc_hd__edfxtp_1
Xnetwork.in_period\[220\]\[1\]$_DFFE_PP_ clknet_leaf_72_clk_load
+ net432 _03221_ VSS VSS VDD VDD network.in_period\[220\]\[1\]
+ sky130_fd_sc_hd__edfxtp_1
Xnetwork.in_period\[220\]\[2\]$_DFFE_PP_ clknet_leaf_72_clk_load
+ net424 _03221_ VSS VSS VDD VDD network.in_period\[220\]\[2\]
+ sky130_fd_sc_hd__edfxtp_1
Xnetwork.in_period\[220\]\[3\]$_DFFE_PP_ clknet_leaf_72_clk_load
+ net418 _03221_ VSS VSS VDD VDD network.in_period\[220\]\[3\]
+ sky130_fd_sc_hd__edfxtp_1
Xnetwork.in_period\[221\]\[0\]$_DFFE_PP_ clknet_leaf_72_clk_load
+ net435 _03222_ VSS VSS VDD VDD network.in_period\[221\]\[0\]
+ sky130_fd_sc_hd__edfxtp_1
Xnetwork.in_period\[221\]\[1\]$_DFFE_PP_ clknet_leaf_72_clk_load
+ net432 _03222_ VSS VSS VDD VDD network.in_period\[221\]\[1\]
+ sky130_fd_sc_hd__edfxtp_1
Xnetwork.in_period\[221\]\[2\]$_DFFE_PP_ clknet_leaf_72_clk_load
+ net424 _03222_ VSS VSS VDD VDD network.in_period\[221\]\[2\]
+ sky130_fd_sc_hd__edfxtp_1
Xnetwork.in_period\[221\]\[3\]$_DFFE_PP_ clknet_leaf_72_clk_load
+ net418 _03222_ VSS VSS VDD VDD network.in_period\[221\]\[3\]
+ sky130_fd_sc_hd__edfxtp_1
Xnetwork.in_period\[222\]\[0\]$_DFFE_PP_ clknet_leaf_68_clk_load
+ net435 _03223_ VSS VSS VDD VDD network.in_period\[222\]\[0\]
+ sky130_fd_sc_hd__edfxtp_1
Xnetwork.in_period\[222\]\[1\]$_DFFE_PP_ clknet_leaf_68_clk_load
+ net432 _03223_ VSS VSS VDD VDD network.in_period\[222\]\[1\]
+ sky130_fd_sc_hd__edfxtp_1
Xnetwork.in_period\[222\]\[2\]$_DFFE_PP_ clknet_leaf_72_clk_load
+ net424 _03223_ VSS VSS VDD VDD network.in_period\[222\]\[2\]
+ sky130_fd_sc_hd__edfxtp_1
Xnetwork.in_period\[222\]\[3\]$_DFFE_PP_ clknet_leaf_68_clk_load
+ net418 _03223_ VSS VSS VDD VDD network.in_period\[222\]\[3\]
+ sky130_fd_sc_hd__edfxtp_1
Xnetwork.in_period\[223\]\[0\]$_DFFE_PP_ clknet_leaf_70_clk_load
+ net435 _03224_ VSS VSS VDD VDD network.in_period\[223\]\[0\]
+ sky130_fd_sc_hd__edfxtp_1
Xnetwork.in_period\[223\]\[1\]$_DFFE_PP_ clknet_leaf_70_clk_load
+ net432 _03224_ VSS VSS VDD VDD network.in_period\[223\]\[1\]
+ sky130_fd_sc_hd__edfxtp_1
Xnetwork.in_period\[223\]\[2\]$_DFFE_PP_ clknet_leaf_70_clk_load
+ net424 _03224_ VSS VSS VDD VDD network.in_period\[223\]\[2\]
+ sky130_fd_sc_hd__edfxtp_1
Xnetwork.in_period\[223\]\[3\]$_DFFE_PP_ clknet_leaf_70_clk_load
+ net418 _03224_ VSS VSS VDD VDD network.in_period\[223\]\[3\]
+ sky130_fd_sc_hd__edfxtp_1
Xnetwork.in_period\[224\]\[0\]$_DFFE_PP_ clknet_leaf_58_clk_load
+ net435 _03225_ VSS VSS VDD VDD network.in_period\[224\]\[0\]
+ sky130_fd_sc_hd__edfxtp_1
Xnetwork.in_period\[224\]\[1\]$_DFFE_PP_ clknet_leaf_58_clk_load
+ net431 _03225_ VSS VSS VDD VDD network.in_period\[224\]\[1\]
+ sky130_fd_sc_hd__edfxtp_1
Xnetwork.in_period\[224\]\[2\]$_DFFE_PP_ clknet_leaf_58_clk_load
+ net422 _03225_ VSS VSS VDD VDD network.in_period\[224\]\[2\]
+ sky130_fd_sc_hd__edfxtp_1
Xnetwork.in_period\[224\]\[3\]$_DFFE_PP_ clknet_leaf_58_clk_load
+ net788 _03225_ VSS VSS VDD VDD network.in_period\[224\]\[3\]
+ sky130_fd_sc_hd__edfxtp_1
Xnetwork.in_period\[225\]\[0\]$_DFFE_PP_ clknet_leaf_56_clk_load
+ net435 _03226_ VSS VSS VDD VDD network.in_period\[225\]\[0\]
+ sky130_fd_sc_hd__edfxtp_1
Xnetwork.in_period\[225\]\[1\]$_DFFE_PP_ clknet_leaf_59_clk_load
+ net431 _03226_ VSS VSS VDD VDD network.in_period\[225\]\[1\]
+ sky130_fd_sc_hd__edfxtp_1
Xnetwork.in_period\[225\]\[2\]$_DFFE_PP_ clknet_leaf_59_clk_load
+ net422 _03226_ VSS VSS VDD VDD network.in_period\[225\]\[2\]
+ sky130_fd_sc_hd__edfxtp_1
Xnetwork.in_period\[225\]\[3\]$_DFFE_PP_ clknet_leaf_59_clk_load
+ net788 _03226_ VSS VSS VDD VDD network.in_period\[225\]\[3\]
+ sky130_fd_sc_hd__edfxtp_1
Xnetwork.in_period\[226\]\[0\]$_DFFE_PP_ clknet_leaf_59_clk_load
+ net435 _03227_ VSS VSS VDD VDD network.in_period\[226\]\[0\]
+ sky130_fd_sc_hd__edfxtp_1
Xnetwork.in_period\[226\]\[1\]$_DFFE_PP_ clknet_leaf_59_clk_load
+ net431 _03227_ VSS VSS VDD VDD network.in_period\[226\]\[1\]
+ sky130_fd_sc_hd__edfxtp_1
Xnetwork.in_period\[226\]\[2\]$_DFFE_PP_ clknet_leaf_59_clk_load
+ net422 _03227_ VSS VSS VDD VDD network.in_period\[226\]\[2\]
+ sky130_fd_sc_hd__edfxtp_1
Xnetwork.in_period\[226\]\[3\]$_DFFE_PP_ clknet_leaf_59_clk_load
+ net788 _03227_ VSS VSS VDD VDD network.in_period\[226\]\[3\]
+ sky130_fd_sc_hd__edfxtp_1
Xnetwork.in_period\[227\]\[0\]$_DFFE_PP_ clknet_leaf_57_clk_load
+ net435 _03228_ VSS VSS VDD VDD network.in_period\[227\]\[0\]
+ sky130_fd_sc_hd__edfxtp_1
Xnetwork.in_period\[227\]\[1\]$_DFFE_PP_ clknet_leaf_57_clk_load
+ net431 _03228_ VSS VSS VDD VDD network.in_period\[227\]\[1\]
+ sky130_fd_sc_hd__edfxtp_1
Xnetwork.in_period\[227\]\[2\]$_DFFE_PP_ clknet_leaf_57_clk_load
+ net422 _03228_ VSS VSS VDD VDD network.in_period\[227\]\[2\]
+ sky130_fd_sc_hd__edfxtp_1
Xnetwork.in_period\[227\]\[3\]$_DFFE_PP_ clknet_leaf_57_clk_load
+ net788 _03228_ VSS VSS VDD VDD network.in_period\[227\]\[3\]
+ sky130_fd_sc_hd__edfxtp_1
Xnetwork.in_period\[228\]\[0\]$_DFFE_PP_ clknet_leaf_90_clk_load
+ net435 _03229_ VSS VSS VDD VDD network.in_period\[228\]\[0\]
+ sky130_fd_sc_hd__edfxtp_1
Xnetwork.in_period\[228\]\[1\]$_DFFE_PP_ clknet_leaf_90_clk_load
+ net431 _03229_ VSS VSS VDD VDD network.in_period\[228\]\[1\]
+ sky130_fd_sc_hd__edfxtp_1
Xnetwork.in_period\[228\]\[2\]$_DFFE_PP_ clknet_leaf_90_clk_load
+ net422 _03229_ VSS VSS VDD VDD network.in_period\[228\]\[2\]
+ sky130_fd_sc_hd__edfxtp_1
Xnetwork.in_period\[228\]\[3\]$_DFFE_PP_ clknet_leaf_90_clk_load
+ net788 _03229_ VSS VSS VDD VDD network.in_period\[228\]\[3\]
+ sky130_fd_sc_hd__edfxtp_1
Xnetwork.in_period\[229\]\[0\]$_DFFE_PP_ clknet_leaf_90_clk_load
+ net435 _03230_ VSS VSS VDD VDD network.in_period\[229\]\[0\]
+ sky130_fd_sc_hd__edfxtp_1
Xnetwork.in_period\[229\]\[1\]$_DFFE_PP_ clknet_leaf_90_clk_load
+ net431 _03230_ VSS VSS VDD VDD network.in_period\[229\]\[1\]
+ sky130_fd_sc_hd__edfxtp_1
Xnetwork.in_period\[229\]\[2\]$_DFFE_PP_ clknet_leaf_90_clk_load
+ net422 _03230_ VSS VSS VDD VDD network.in_period\[229\]\[2\]
+ sky130_fd_sc_hd__edfxtp_1
Xnetwork.in_period\[229\]\[3\]$_DFFE_PP_ clknet_leaf_90_clk_load
+ net788 _03230_ VSS VSS VDD VDD network.in_period\[229\]\[3\]
+ sky130_fd_sc_hd__edfxtp_1
Xnetwork.in_period\[22\]\[0\]$_DFFE_PP_ clknet_leaf_33_clk_load
+ net440 _03231_ VSS VSS VDD VDD network.in_period\[22\]\[0\]
+ sky130_fd_sc_hd__edfxtp_1
Xnetwork.in_period\[22\]\[1\]$_DFFE_PP_ clknet_leaf_34_clk_load
+ net429 _03231_ VSS VSS VDD VDD network.in_period\[22\]\[1\]
+ sky130_fd_sc_hd__edfxtp_1
Xnetwork.in_period\[22\]\[2\]$_DFFE_PP_ clknet_leaf_33_clk_load
+ net426 _03231_ VSS VSS VDD VDD network.in_period\[22\]\[2\]
+ sky130_fd_sc_hd__edfxtp_1
Xnetwork.in_period\[22\]\[3\]$_DFFE_PP_ clknet_leaf_33_clk_load
+ net414 _03231_ VSS VSS VDD VDD network.in_period\[22\]\[3\]
+ sky130_fd_sc_hd__edfxtp_1
Xnetwork.in_period\[230\]\[0\]$_DFFE_PP_ clknet_leaf_62_clk_load
+ net435 _03232_ VSS VSS VDD VDD network.in_period\[230\]\[0\]
+ sky130_fd_sc_hd__edfxtp_1
Xnetwork.in_period\[230\]\[1\]$_DFFE_PP_ clknet_leaf_62_clk_load
+ net431 _03232_ VSS VSS VDD VDD network.in_period\[230\]\[1\]
+ sky130_fd_sc_hd__edfxtp_1
Xnetwork.in_period\[230\]\[2\]$_DFFE_PP_ clknet_leaf_62_clk_load
+ net422 _03232_ VSS VSS VDD VDD network.in_period\[230\]\[2\]
+ sky130_fd_sc_hd__edfxtp_1
Xnetwork.in_period\[230\]\[3\]$_DFFE_PP_ clknet_leaf_62_clk_load
+ net418 _03232_ VSS VSS VDD VDD network.in_period\[230\]\[3\]
+ sky130_fd_sc_hd__edfxtp_1
Xnetwork.in_period\[231\]\[0\]$_DFFE_PP_ clknet_leaf_91_clk_load
+ net435 _03233_ VSS VSS VDD VDD network.in_period\[231\]\[0\]
+ sky130_fd_sc_hd__edfxtp_1
Xnetwork.in_period\[231\]\[1\]$_DFFE_PP_ clknet_leaf_91_clk_load
+ net431 _03233_ VSS VSS VDD VDD network.in_period\[231\]\[1\]
+ sky130_fd_sc_hd__edfxtp_1
Xnetwork.in_period\[231\]\[2\]$_DFFE_PP_ clknet_leaf_91_clk_load
+ net422 _03233_ VSS VSS VDD VDD network.in_period\[231\]\[2\]
+ sky130_fd_sc_hd__edfxtp_1
Xnetwork.in_period\[231\]\[3\]$_DFFE_PP_ clknet_leaf_91_clk_load
+ net788 _03233_ VSS VSS VDD VDD network.in_period\[231\]\[3\]
+ sky130_fd_sc_hd__edfxtp_1
Xnetwork.in_period\[232\]\[0\]$_DFFE_PP_ clknet_leaf_57_clk_load
+ net435 _03234_ VSS VSS VDD VDD network.in_period\[232\]\[0\]
+ sky130_fd_sc_hd__edfxtp_1
Xnetwork.in_period\[232\]\[1\]$_DFFE_PP_ clknet_leaf_57_clk_load
+ net431 _03234_ VSS VSS VDD VDD network.in_period\[232\]\[1\]
+ sky130_fd_sc_hd__edfxtp_1
Xnetwork.in_period\[232\]\[2\]$_DFFE_PP_ clknet_leaf_57_clk_load
+ net422 _03234_ VSS VSS VDD VDD network.in_period\[232\]\[2\]
+ sky130_fd_sc_hd__edfxtp_1
Xnetwork.in_period\[232\]\[3\]$_DFFE_PP_ clknet_leaf_57_clk_load
+ net788 _03234_ VSS VSS VDD VDD network.in_period\[232\]\[3\]
+ sky130_fd_sc_hd__edfxtp_1
Xnetwork.in_period\[233\]\[0\]$_DFFE_PP_ clknet_leaf_57_clk_load
+ net435 _03235_ VSS VSS VDD VDD network.in_period\[233\]\[0\]
+ sky130_fd_sc_hd__edfxtp_1
Xnetwork.in_period\[233\]\[1\]$_DFFE_PP_ clknet_leaf_57_clk_load
+ net431 _03235_ VSS VSS VDD VDD network.in_period\[233\]\[1\]
+ sky130_fd_sc_hd__edfxtp_1
Xnetwork.in_period\[233\]\[2\]$_DFFE_PP_ clknet_leaf_57_clk_load
+ net422 _03235_ VSS VSS VDD VDD network.in_period\[233\]\[2\]
+ sky130_fd_sc_hd__edfxtp_1
Xnetwork.in_period\[233\]\[3\]$_DFFE_PP_ clknet_leaf_91_clk_load
+ net788 _03235_ VSS VSS VDD VDD network.in_period\[233\]\[3\]
+ sky130_fd_sc_hd__edfxtp_1
Xnetwork.in_period\[234\]\[0\]$_DFFE_PP_ clknet_leaf_63_clk_load
+ net435 _03236_ VSS VSS VDD VDD network.in_period\[234\]\[0\]
+ sky130_fd_sc_hd__edfxtp_1
Xnetwork.in_period\[234\]\[1\]$_DFFE_PP_ clknet_leaf_63_clk_load
+ net431 _03236_ VSS VSS VDD VDD network.in_period\[234\]\[1\]
+ sky130_fd_sc_hd__edfxtp_1
Xnetwork.in_period\[234\]\[2\]$_DFFE_PP_ clknet_leaf_63_clk_load
+ net422 _03236_ VSS VSS VDD VDD network.in_period\[234\]\[2\]
+ sky130_fd_sc_hd__edfxtp_1
Xnetwork.in_period\[234\]\[3\]$_DFFE_PP_ clknet_leaf_63_clk_load
+ net788 _03236_ VSS VSS VDD VDD network.in_period\[234\]\[3\]
+ sky130_fd_sc_hd__edfxtp_1
Xnetwork.in_period\[235\]\[0\]$_DFFE_PP_ clknet_leaf_64_clk_load
+ net435 _03237_ VSS VSS VDD VDD network.in_period\[235\]\[0\]
+ sky130_fd_sc_hd__edfxtp_1
Xnetwork.in_period\[235\]\[1\]$_DFFE_PP_ clknet_leaf_64_clk_load
+ net431 _03237_ VSS VSS VDD VDD network.in_period\[235\]\[1\]
+ sky130_fd_sc_hd__edfxtp_1
Xnetwork.in_period\[235\]\[2\]$_DFFE_PP_ clknet_leaf_64_clk_load
+ net422 _03237_ VSS VSS VDD VDD network.in_period\[235\]\[2\]
+ sky130_fd_sc_hd__edfxtp_1
Xnetwork.in_period\[235\]\[3\]$_DFFE_PP_ clknet_leaf_64_clk_load
+ net418 _03237_ VSS VSS VDD VDD network.in_period\[235\]\[3\]
+ sky130_fd_sc_hd__edfxtp_1
Xnetwork.in_period\[236\]\[0\]$_DFFE_PP_ clknet_leaf_60_clk_load
+ net435 _03238_ VSS VSS VDD VDD network.in_period\[236\]\[0\]
+ sky130_fd_sc_hd__edfxtp_1
Xnetwork.in_period\[236\]\[1\]$_DFFE_PP_ clknet_leaf_58_clk_load
+ net431 _03238_ VSS VSS VDD VDD network.in_period\[236\]\[1\]
+ sky130_fd_sc_hd__edfxtp_1
Xnetwork.in_period\[236\]\[2\]$_DFFE_PP_ clknet_leaf_58_clk_load
+ net422 _03238_ VSS VSS VDD VDD network.in_period\[236\]\[2\]
+ sky130_fd_sc_hd__edfxtp_1
Xnetwork.in_period\[236\]\[3\]$_DFFE_PP_ clknet_leaf_58_clk_load
+ net420 _03238_ VSS VSS VDD VDD network.in_period\[236\]\[3\]
+ sky130_fd_sc_hd__edfxtp_1
Xnetwork.in_period\[237\]\[0\]$_DFFE_PP_ clknet_leaf_59_clk_load
+ net435 _03239_ VSS VSS VDD VDD network.in_period\[237\]\[0\]
+ sky130_fd_sc_hd__edfxtp_1
Xnetwork.in_period\[237\]\[1\]$_DFFE_PP_ clknet_leaf_59_clk_load
+ net431 _03239_ VSS VSS VDD VDD network.in_period\[237\]\[1\]
+ sky130_fd_sc_hd__edfxtp_1
Xnetwork.in_period\[237\]\[2\]$_DFFE_PP_ clknet_leaf_60_clk_load
+ net422 _03239_ VSS VSS VDD VDD network.in_period\[237\]\[2\]
+ sky130_fd_sc_hd__edfxtp_1
Xnetwork.in_period\[237\]\[3\]$_DFFE_PP_ clknet_leaf_59_clk_load
+ net788 _03239_ VSS VSS VDD VDD network.in_period\[237\]\[3\]
+ sky130_fd_sc_hd__edfxtp_1
Xnetwork.in_period\[238\]\[0\]$_DFFE_PP_ clknet_leaf_60_clk_load
+ net435 _03240_ VSS VSS VDD VDD network.in_period\[238\]\[0\]
+ sky130_fd_sc_hd__edfxtp_1
Xnetwork.in_period\[238\]\[1\]$_DFFE_PP_ clknet_leaf_60_clk_load
+ net431 _03240_ VSS VSS VDD VDD network.in_period\[238\]\[1\]
+ sky130_fd_sc_hd__edfxtp_1
Xnetwork.in_period\[238\]\[2\]$_DFFE_PP_ clknet_leaf_63_clk_load
+ net422 _03240_ VSS VSS VDD VDD network.in_period\[238\]\[2\]
+ sky130_fd_sc_hd__edfxtp_1
Xnetwork.in_period\[238\]\[3\]$_DFFE_PP_ clknet_leaf_60_clk_load
+ net418 _03240_ VSS VSS VDD VDD network.in_period\[238\]\[3\]
+ sky130_fd_sc_hd__edfxtp_1
Xnetwork.in_period\[239\]\[0\]$_DFFE_PP_ clknet_leaf_63_clk_load
+ net435 _03241_ VSS VSS VDD VDD network.in_period\[239\]\[0\]
+ sky130_fd_sc_hd__edfxtp_1
Xnetwork.in_period\[239\]\[1\]$_DFFE_PP_ clknet_leaf_63_clk_load
+ net431 _03241_ VSS VSS VDD VDD network.in_period\[239\]\[1\]
+ sky130_fd_sc_hd__edfxtp_1
Xnetwork.in_period\[239\]\[2\]$_DFFE_PP_ clknet_leaf_63_clk_load
+ net422 _03241_ VSS VSS VDD VDD network.in_period\[239\]\[2\]
+ sky130_fd_sc_hd__edfxtp_1
Xnetwork.in_period\[239\]\[3\]$_DFFE_PP_ clknet_leaf_63_clk_load
+ net418 _03241_ VSS VSS VDD VDD network.in_period\[239\]\[3\]
+ sky130_fd_sc_hd__edfxtp_1
Xnetwork.in_period\[23\]\[0\]$_DFFE_PP_ clknet_leaf_32_clk_load
+ net440 _03242_ VSS VSS VDD VDD network.in_period\[23\]\[0\]
+ sky130_fd_sc_hd__edfxtp_1
Xnetwork.in_period\[23\]\[1\]$_DFFE_PP_ clknet_leaf_32_clk_load
+ net429 _03242_ VSS VSS VDD VDD network.in_period\[23\]\[1\]
+ sky130_fd_sc_hd__edfxtp_1
Xnetwork.in_period\[23\]\[2\]$_DFFE_PP_ clknet_leaf_33_clk_load
+ net426 _03242_ VSS VSS VDD VDD network.in_period\[23\]\[2\]
+ sky130_fd_sc_hd__edfxtp_1
Xnetwork.in_period\[23\]\[3\]$_DFFE_PP_ clknet_leaf_33_clk_load
+ net414 _03242_ VSS VSS VDD VDD network.in_period\[23\]\[3\]
+ sky130_fd_sc_hd__edfxtp_1
Xnetwork.in_period\[240\]\[0\]$_DFFE_PP_ clknet_leaf_78_clk_load
+ net436 _03243_ VSS VSS VDD VDD network.in_period\[240\]\[0\]
+ sky130_fd_sc_hd__edfxtp_1
Xnetwork.in_period\[240\]\[1\]$_DFFE_PP_ clknet_leaf_77_clk_load
+ net432 _03243_ VSS VSS VDD VDD network.in_period\[240\]\[1\]
+ sky130_fd_sc_hd__edfxtp_1
Xnetwork.in_period\[240\]\[2\]$_DFFE_PP_ clknet_leaf_78_clk_load
+ net424 _03243_ VSS VSS VDD VDD network.in_period\[240\]\[2\]
+ sky130_fd_sc_hd__edfxtp_1
Xnetwork.in_period\[240\]\[3\]$_DFFE_PP_ clknet_leaf_78_clk_load
+ net418 _03243_ VSS VSS VDD VDD network.in_period\[240\]\[3\]
+ sky130_fd_sc_hd__edfxtp_1
Xnetwork.in_period\[241\]\[0\]$_DFFE_PP_ clknet_leaf_85_clk_load
+ net436 _03244_ VSS VSS VDD VDD network.in_period\[241\]\[0\]
+ sky130_fd_sc_hd__edfxtp_1
Xnetwork.in_period\[241\]\[1\]$_DFFE_PP_ clknet_leaf_85_clk_load
+ net432 _03244_ VSS VSS VDD VDD network.in_period\[241\]\[1\]
+ sky130_fd_sc_hd__edfxtp_1
Xnetwork.in_period\[241\]\[2\]$_DFFE_PP_ clknet_leaf_85_clk_load
+ net424 _03244_ VSS VSS VDD VDD network.in_period\[241\]\[2\]
+ sky130_fd_sc_hd__edfxtp_1
Xnetwork.in_period\[241\]\[3\]$_DFFE_PP_ clknet_leaf_85_clk_load
+ net420 _03244_ VSS VSS VDD VDD network.in_period\[241\]\[3\]
+ sky130_fd_sc_hd__edfxtp_1
Xnetwork.in_period\[242\]\[0\]$_DFFE_PP_ clknet_leaf_88_clk_load
+ net436 _03245_ VSS VSS VDD VDD network.in_period\[242\]\[0\]
+ sky130_fd_sc_hd__edfxtp_1
Xnetwork.in_period\[242\]\[1\]$_DFFE_PP_ clknet_leaf_88_clk_load
+ net432 _03245_ VSS VSS VDD VDD network.in_period\[242\]\[1\]
+ sky130_fd_sc_hd__edfxtp_1
Xnetwork.in_period\[242\]\[2\]$_DFFE_PP_ clknet_leaf_88_clk_load
+ net424 _03245_ VSS VSS VDD VDD network.in_period\[242\]\[2\]
+ sky130_fd_sc_hd__edfxtp_1
Xnetwork.in_period\[242\]\[3\]$_DFFE_PP_ clknet_leaf_88_clk_load
+ net420 _03245_ VSS VSS VDD VDD network.in_period\[242\]\[3\]
+ sky130_fd_sc_hd__edfxtp_1
Xnetwork.in_period\[243\]\[0\]$_DFFE_PP_ clknet_leaf_61_clk_load
+ net435 _03246_ VSS VSS VDD VDD network.in_period\[243\]\[0\]
+ sky130_fd_sc_hd__edfxtp_1
Xnetwork.in_period\[243\]\[1\]$_DFFE_PP_ clknet_leaf_61_clk_load
+ net431 _03246_ VSS VSS VDD VDD network.in_period\[243\]\[1\]
+ sky130_fd_sc_hd__edfxtp_1
Xnetwork.in_period\[243\]\[2\]$_DFFE_PP_ clknet_leaf_61_clk_load
+ net424 _03246_ VSS VSS VDD VDD network.in_period\[243\]\[2\]
+ sky130_fd_sc_hd__edfxtp_1
Xnetwork.in_period\[243\]\[3\]$_DFFE_PP_ clknet_leaf_61_clk_load
+ net418 _03246_ VSS VSS VDD VDD network.in_period\[243\]\[3\]
+ sky130_fd_sc_hd__edfxtp_1
Xnetwork.in_period\[244\]\[0\]$_DFFE_PP_ clknet_leaf_85_clk_load
+ net436 _03247_ VSS VSS VDD VDD network.in_period\[244\]\[0\]
+ sky130_fd_sc_hd__edfxtp_1
Xnetwork.in_period\[244\]\[1\]$_DFFE_PP_ clknet_leaf_86_clk_load
+ net432 _03247_ VSS VSS VDD VDD network.in_period\[244\]\[1\]
+ sky130_fd_sc_hd__edfxtp_1
Xnetwork.in_period\[244\]\[2\]$_DFFE_PP_ clknet_leaf_86_clk_load
+ net424 _03247_ VSS VSS VDD VDD network.in_period\[244\]\[2\]
+ sky130_fd_sc_hd__edfxtp_1
Xnetwork.in_period\[244\]\[3\]$_DFFE_PP_ clknet_leaf_87_clk_load
+ net420 _03247_ VSS VSS VDD VDD network.in_period\[244\]\[3\]
+ sky130_fd_sc_hd__edfxtp_1
Xnetwork.in_period\[245\]\[0\]$_DFFE_PP_ clknet_leaf_78_clk_load
+ net436 _03248_ VSS VSS VDD VDD network.in_period\[245\]\[0\]
+ sky130_fd_sc_hd__edfxtp_1
Xnetwork.in_period\[245\]\[1\]$_DFFE_PP_ clknet_leaf_78_clk_load
+ net432 _03248_ VSS VSS VDD VDD network.in_period\[245\]\[1\]
+ sky130_fd_sc_hd__edfxtp_1
Xnetwork.in_period\[245\]\[2\]$_DFFE_PP_ clknet_leaf_78_clk_load
+ net424 _03248_ VSS VSS VDD VDD network.in_period\[245\]\[2\]
+ sky130_fd_sc_hd__edfxtp_1
Xnetwork.in_period\[245\]\[3\]$_DFFE_PP_ clknet_leaf_78_clk_load
+ net418 _03248_ VSS VSS VDD VDD network.in_period\[245\]\[3\]
+ sky130_fd_sc_hd__edfxtp_1
Xnetwork.in_period\[246\]\[0\]$_DFFE_PP_ clknet_leaf_61_clk_load
+ net435 _03249_ VSS VSS VDD VDD network.in_period\[246\]\[0\]
+ sky130_fd_sc_hd__edfxtp_1
Xnetwork.in_period\[246\]\[1\]$_DFFE_PP_ clknet_leaf_61_clk_load
+ net431 _03249_ VSS VSS VDD VDD network.in_period\[246\]\[1\]
+ sky130_fd_sc_hd__edfxtp_1
Xnetwork.in_period\[246\]\[2\]$_DFFE_PP_ clknet_leaf_61_clk_load
+ net424 _03249_ VSS VSS VDD VDD network.in_period\[246\]\[2\]
+ sky130_fd_sc_hd__edfxtp_1
Xnetwork.in_period\[246\]\[3\]$_DFFE_PP_ clknet_leaf_60_clk_load
+ net418 _03249_ VSS VSS VDD VDD network.in_period\[246\]\[3\]
+ sky130_fd_sc_hd__edfxtp_1
Xnetwork.in_period\[247\]\[0\]$_DFFE_PP_ clknet_leaf_87_clk_load
+ net436 _03250_ VSS VSS VDD VDD network.in_period\[247\]\[0\]
+ sky130_fd_sc_hd__edfxtp_1
Xnetwork.in_period\[247\]\[1\]$_DFFE_PP_ clknet_leaf_86_clk_load
+ net432 _03250_ VSS VSS VDD VDD network.in_period\[247\]\[1\]
+ sky130_fd_sc_hd__edfxtp_1
Xnetwork.in_period\[247\]\[2\]$_DFFE_PP_ clknet_leaf_87_clk_load
+ net424 _03250_ VSS VSS VDD VDD network.in_period\[247\]\[2\]
+ sky130_fd_sc_hd__edfxtp_1
Xnetwork.in_period\[247\]\[3\]$_DFFE_PP_ clknet_leaf_87_clk_load
+ net418 _03250_ VSS VSS VDD VDD network.in_period\[247\]\[3\]
+ sky130_fd_sc_hd__edfxtp_1
Xnetwork.in_period\[248\]\[0\]$_DFFE_PP_ clknet_leaf_88_clk_load
+ net436 _03251_ VSS VSS VDD VDD network.in_period\[248\]\[0\]
+ sky130_fd_sc_hd__edfxtp_1
Xnetwork.in_period\[248\]\[1\]$_DFFE_PP_ clknet_leaf_88_clk_load
+ net432 _03251_ VSS VSS VDD VDD network.in_period\[248\]\[1\]
+ sky130_fd_sc_hd__edfxtp_1
Xnetwork.in_period\[248\]\[2\]$_DFFE_PP_ clknet_leaf_88_clk_load
+ net424 _03251_ VSS VSS VDD VDD network.in_period\[248\]\[2\]
+ sky130_fd_sc_hd__edfxtp_1
Xnetwork.in_period\[248\]\[3\]$_DFFE_PP_ clknet_leaf_88_clk_load
+ net420 _03251_ VSS VSS VDD VDD network.in_period\[248\]\[3\]
+ sky130_fd_sc_hd__edfxtp_1
Xnetwork.in_period\[249\]\[0\]$_DFFE_PP_ clknet_leaf_87_clk_load
+ net435 _03252_ VSS VSS VDD VDD network.in_period\[249\]\[0\]
+ sky130_fd_sc_hd__edfxtp_1
Xnetwork.in_period\[249\]\[1\]$_DFFE_PP_ clknet_leaf_88_clk_load
+ net431 _03252_ VSS VSS VDD VDD network.in_period\[249\]\[1\]
+ sky130_fd_sc_hd__edfxtp_1
Xnetwork.in_period\[249\]\[2\]$_DFFE_PP_ clknet_leaf_87_clk_load
+ net422 _03252_ VSS VSS VDD VDD network.in_period\[249\]\[2\]
+ sky130_fd_sc_hd__edfxtp_1
Xnetwork.in_period\[249\]\[3\]$_DFFE_PP_ clknet_leaf_87_clk_load
+ net420 _03252_ VSS VSS VDD VDD network.in_period\[249\]\[3\]
+ sky130_fd_sc_hd__edfxtp_1
Xnetwork.in_period\[24\]\[0\]$_DFFE_PP_ clknet_leaf_30_clk_load
+ net440 _03253_ VSS VSS VDD VDD network.in_period\[24\]\[0\]
+ sky130_fd_sc_hd__edfxtp_1
Xnetwork.in_period\[24\]\[1\]$_DFFE_PP_ clknet_leaf_30_clk_load
+ net429 _03253_ VSS VSS VDD VDD network.in_period\[24\]\[1\]
+ sky130_fd_sc_hd__edfxtp_1
Xnetwork.in_period\[24\]\[2\]$_DFFE_PP_ clknet_leaf_30_clk_load
+ net426 _03253_ VSS VSS VDD VDD network.in_period\[24\]\[2\]
+ sky130_fd_sc_hd__edfxtp_1
Xnetwork.in_period\[24\]\[3\]$_DFFE_PP_ clknet_leaf_30_clk_load
+ net414 _03253_ VSS VSS VDD VDD network.in_period\[24\]\[3\]
+ sky130_fd_sc_hd__edfxtp_1
Xnetwork.in_period\[250\]\[0\]$_DFFE_PP_ clknet_leaf_69_clk_load
+ net435 _03254_ VSS VSS VDD VDD network.in_period\[250\]\[0\]
+ sky130_fd_sc_hd__edfxtp_1
Xnetwork.in_period\[250\]\[1\]$_DFFE_PP_ clknet_leaf_69_clk_load
+ net432 _03254_ VSS VSS VDD VDD network.in_period\[250\]\[1\]
+ sky130_fd_sc_hd__edfxtp_1
Xnetwork.in_period\[250\]\[2\]$_DFFE_PP_ clknet_leaf_69_clk_load
+ net424 _03254_ VSS VSS VDD VDD network.in_period\[250\]\[2\]
+ sky130_fd_sc_hd__edfxtp_1
Xnetwork.in_period\[250\]\[3\]$_DFFE_PP_ clknet_leaf_69_clk_load
+ net418 _03254_ VSS VSS VDD VDD network.in_period\[250\]\[3\]
+ sky130_fd_sc_hd__edfxtp_1
Xnetwork.in_period\[251\]\[0\]$_DFFE_PP_ clknet_leaf_78_clk_load
+ net436 _03255_ VSS VSS VDD VDD network.in_period\[251\]\[0\]
+ sky130_fd_sc_hd__edfxtp_1
Xnetwork.in_period\[251\]\[1\]$_DFFE_PP_ clknet_leaf_78_clk_load
+ net432 _03255_ VSS VSS VDD VDD network.in_period\[251\]\[1\]
+ sky130_fd_sc_hd__edfxtp_1
Xnetwork.in_period\[251\]\[2\]$_DFFE_PP_ clknet_leaf_78_clk_load
+ net424 _03255_ VSS VSS VDD VDD network.in_period\[251\]\[2\]
+ sky130_fd_sc_hd__edfxtp_1
Xnetwork.in_period\[251\]\[3\]$_DFFE_PP_ clknet_leaf_78_clk_load
+ net418 _03255_ VSS VSS VDD VDD network.in_period\[251\]\[3\]
+ sky130_fd_sc_hd__edfxtp_1
Xnetwork.in_period\[252\]\[0\]$_DFFE_PP_ clknet_leaf_70_clk_load
+ net436 _03256_ VSS VSS VDD VDD network.in_period\[252\]\[0\]
+ sky130_fd_sc_hd__edfxtp_1
Xnetwork.in_period\[252\]\[1\]$_DFFE_PP_ clknet_leaf_70_clk_load
+ net432 _03256_ VSS VSS VDD VDD network.in_period\[252\]\[1\]
+ sky130_fd_sc_hd__edfxtp_1
Xnetwork.in_period\[252\]\[2\]$_DFFE_PP_ clknet_leaf_71_clk_load
+ net424 _03256_ VSS VSS VDD VDD network.in_period\[252\]\[2\]
+ sky130_fd_sc_hd__edfxtp_1
Xnetwork.in_period\[252\]\[3\]$_DFFE_PP_ clknet_leaf_70_clk_load
+ net418 _03256_ VSS VSS VDD VDD network.in_period\[252\]\[3\]
+ sky130_fd_sc_hd__edfxtp_1
Xnetwork.in_period\[253\]\[0\]$_DFFE_PP_ clknet_leaf_69_clk_load
+ net436 _03257_ VSS VSS VDD VDD network.in_period\[253\]\[0\]
+ sky130_fd_sc_hd__edfxtp_1
Xnetwork.in_period\[253\]\[1\]$_DFFE_PP_ clknet_leaf_70_clk_load
+ net432 _03257_ VSS VSS VDD VDD network.in_period\[253\]\[1\]
+ sky130_fd_sc_hd__edfxtp_1
Xnetwork.in_period\[253\]\[2\]$_DFFE_PP_ clknet_leaf_69_clk_load
+ net424 _03257_ VSS VSS VDD VDD network.in_period\[253\]\[2\]
+ sky130_fd_sc_hd__edfxtp_1
Xnetwork.in_period\[253\]\[3\]$_DFFE_PP_ clknet_leaf_70_clk_load
+ net418 _03257_ VSS VSS VDD VDD network.in_period\[253\]\[3\]
+ sky130_fd_sc_hd__edfxtp_1
Xnetwork.in_period\[254\]\[0\]$_DFFE_PP_ clknet_leaf_86_clk_load
+ net436 _03258_ VSS VSS VDD VDD network.in_period\[254\]\[0\]
+ sky130_fd_sc_hd__edfxtp_1
Xnetwork.in_period\[254\]\[1\]$_DFFE_PP_ clknet_leaf_79_clk_load
+ net432 _03258_ VSS VSS VDD VDD network.in_period\[254\]\[1\]
+ sky130_fd_sc_hd__edfxtp_1
Xnetwork.in_period\[254\]\[2\]$_DFFE_PP_ clknet_leaf_86_clk_load
+ net424 _03258_ VSS VSS VDD VDD network.in_period\[254\]\[2\]
+ sky130_fd_sc_hd__edfxtp_1
Xnetwork.in_period\[254\]\[3\]$_DFFE_PP_ clknet_leaf_86_clk_load
+ net418 _03258_ VSS VSS VDD VDD network.in_period\[254\]\[3\]
+ sky130_fd_sc_hd__edfxtp_1
Xnetwork.in_period\[255\]\[0\]$_DFFE_PP_ clknet_leaf_86_clk_load
+ net436 _03259_ VSS VSS VDD VDD network.in_period\[255\]\[0\]
+ sky130_fd_sc_hd__edfxtp_1
Xnetwork.in_period\[255\]\[1\]$_DFFE_PP_ clknet_leaf_86_clk_load
+ net432 _03259_ VSS VSS VDD VDD network.in_period\[255\]\[1\]
+ sky130_fd_sc_hd__edfxtp_1
Xnetwork.in_period\[255\]\[2\]$_DFFE_PP_ clknet_leaf_86_clk_load
+ net424 _03259_ VSS VSS VDD VDD network.in_period\[255\]\[2\]
+ sky130_fd_sc_hd__edfxtp_1
Xnetwork.in_period\[255\]\[3\]$_DFFE_PP_ clknet_leaf_86_clk_load
+ net420 _03259_ VSS VSS VDD VDD network.in_period\[255\]\[3\]
+ sky130_fd_sc_hd__edfxtp_1
Xnetwork.in_period\[25\]\[0\]$_DFFE_PP_ clknet_leaf_30_clk_load
+ net440 _03260_ VSS VSS VDD VDD network.in_period\[25\]\[0\]
+ sky130_fd_sc_hd__edfxtp_1
Xnetwork.in_period\[25\]\[1\]$_DFFE_PP_ clknet_leaf_30_clk_load
+ net429 _03260_ VSS VSS VDD VDD network.in_period\[25\]\[1\]
+ sky130_fd_sc_hd__edfxtp_1
Xnetwork.in_period\[25\]\[2\]$_DFFE_PP_ clknet_leaf_30_clk_load
+ net426 _03260_ VSS VSS VDD VDD network.in_period\[25\]\[2\]
+ sky130_fd_sc_hd__edfxtp_1
Xnetwork.in_period\[25\]\[3\]$_DFFE_PP_ clknet_leaf_30_clk_load
+ net414 _03260_ VSS VSS VDD VDD network.in_period\[25\]\[3\]
+ sky130_fd_sc_hd__edfxtp_1
Xnetwork.in_period\[26\]\[0\]$_DFFE_PP_ clknet_leaf_31_clk_load
+ net440 _03261_ VSS VSS VDD VDD network.in_period\[26\]\[0\]
+ sky130_fd_sc_hd__edfxtp_1
Xnetwork.in_period\[26\]\[1\]$_DFFE_PP_ clknet_leaf_31_clk_load
+ net429 _03261_ VSS VSS VDD VDD network.in_period\[26\]\[1\]
+ sky130_fd_sc_hd__edfxtp_1
Xnetwork.in_period\[26\]\[2\]$_DFFE_PP_ clknet_leaf_31_clk_load
+ net426 _03261_ VSS VSS VDD VDD network.in_period\[26\]\[2\]
+ sky130_fd_sc_hd__edfxtp_1
Xnetwork.in_period\[26\]\[3\]$_DFFE_PP_ clknet_leaf_31_clk_load
+ net414 _03261_ VSS VSS VDD VDD network.in_period\[26\]\[3\]
+ sky130_fd_sc_hd__edfxtp_1
Xnetwork.in_period\[27\]\[0\]$_DFFE_PP_ clknet_leaf_31_clk_load
+ net440 _03262_ VSS VSS VDD VDD network.in_period\[27\]\[0\]
+ sky130_fd_sc_hd__edfxtp_1
Xnetwork.in_period\[27\]\[1\]$_DFFE_PP_ clknet_leaf_32_clk_load
+ net429 _03262_ VSS VSS VDD VDD network.in_period\[27\]\[1\]
+ sky130_fd_sc_hd__edfxtp_1
Xnetwork.in_period\[27\]\[2\]$_DFFE_PP_ clknet_leaf_32_clk_load
+ net426 _03262_ VSS VSS VDD VDD network.in_period\[27\]\[2\]
+ sky130_fd_sc_hd__edfxtp_1
Xnetwork.in_period\[27\]\[3\]$_DFFE_PP_ clknet_leaf_32_clk_load
+ net414 _03262_ VSS VSS VDD VDD network.in_period\[27\]\[3\]
+ sky130_fd_sc_hd__edfxtp_1
Xnetwork.in_period\[28\]\[0\]$_DFFE_PP_ clknet_leaf_32_clk_load
+ net440 _03263_ VSS VSS VDD VDD network.in_period\[28\]\[0\]
+ sky130_fd_sc_hd__edfxtp_1
Xnetwork.in_period\[28\]\[1\]$_DFFE_PP_ clknet_leaf_31_clk_load
+ net429 _03263_ VSS VSS VDD VDD network.in_period\[28\]\[1\]
+ sky130_fd_sc_hd__edfxtp_1
Xnetwork.in_period\[28\]\[2\]$_DFFE_PP_ clknet_leaf_31_clk_load
+ net426 _03263_ VSS VSS VDD VDD network.in_period\[28\]\[2\]
+ sky130_fd_sc_hd__edfxtp_1
Xnetwork.in_period\[28\]\[3\]$_DFFE_PP_ clknet_leaf_31_clk_load
+ net414 _03263_ VSS VSS VDD VDD network.in_period\[28\]\[3\]
+ sky130_fd_sc_hd__edfxtp_1
Xnetwork.in_period\[29\]\[0\]$_DFFE_PP_ clknet_leaf_33_clk_load
+ net440 _03264_ VSS VSS VDD VDD network.in_period\[29\]\[0\]
+ sky130_fd_sc_hd__edfxtp_1
Xnetwork.in_period\[29\]\[1\]$_DFFE_PP_ clknet_leaf_34_clk_load
+ net429 _03264_ VSS VSS VDD VDD network.in_period\[29\]\[1\]
+ sky130_fd_sc_hd__edfxtp_1
Xnetwork.in_period\[29\]\[2\]$_DFFE_PP_ clknet_leaf_33_clk_load
+ net426 _03264_ VSS VSS VDD VDD network.in_period\[29\]\[2\]
+ sky130_fd_sc_hd__edfxtp_1
Xnetwork.in_period\[29\]\[3\]$_DFFE_PP_ clknet_leaf_33_clk_load
+ net414 _03264_ VSS VSS VDD VDD network.in_period\[29\]\[3\]
+ sky130_fd_sc_hd__edfxtp_1
Xnetwork.in_period\[2\]\[0\]$_DFFE_PP_ clknet_leaf_41_clk_load
+ net440 _03265_ VSS VSS VDD VDD network.in_period\[2\]\[0\]
+ sky130_fd_sc_hd__edfxtp_1
Xnetwork.in_period\[2\]\[1\]$_DFFE_PP_ clknet_leaf_41_clk_load
+ net429 _03265_ VSS VSS VDD VDD network.in_period\[2\]\[1\]
+ sky130_fd_sc_hd__edfxtp_1
Xnetwork.in_period\[2\]\[2\]$_DFFE_PP_ clknet_leaf_40_clk_load
+ net426 _03265_ VSS VSS VDD VDD network.in_period\[2\]\[2\]
+ sky130_fd_sc_hd__edfxtp_1
Xnetwork.in_period\[2\]\[3\]$_DFFE_PP_ clknet_leaf_40_clk_load
+ net414 _03265_ VSS VSS VDD VDD network.in_period\[2\]\[3\]
+ sky130_fd_sc_hd__edfxtp_1
Xnetwork.in_period\[30\]\[0\]$_DFFE_PP_ clknet_leaf_34_clk_load
+ net440 _03266_ VSS VSS VDD VDD network.in_period\[30\]\[0\]
+ sky130_fd_sc_hd__edfxtp_1
Xnetwork.in_period\[30\]\[1\]$_DFFE_PP_ clknet_leaf_34_clk_load
+ net429 _03266_ VSS VSS VDD VDD network.in_period\[30\]\[1\]
+ sky130_fd_sc_hd__edfxtp_1
Xnetwork.in_period\[30\]\[2\]$_DFFE_PP_ clknet_leaf_34_clk_load
+ net426 _03266_ VSS VSS VDD VDD network.in_period\[30\]\[2\]
+ sky130_fd_sc_hd__edfxtp_1
Xnetwork.in_period\[30\]\[3\]$_DFFE_PP_ clknet_leaf_34_clk_load
+ net414 _03266_ VSS VSS VDD VDD network.in_period\[30\]\[3\]
+ sky130_fd_sc_hd__edfxtp_1
Xnetwork.in_period\[31\]\[0\]$_DFFE_PP_ clknet_leaf_30_clk_load
+ net440 _03267_ VSS VSS VDD VDD network.in_period\[31\]\[0\]
+ sky130_fd_sc_hd__edfxtp_1
Xnetwork.in_period\[31\]\[1\]$_DFFE_PP_ clknet_leaf_31_clk_load
+ net429 _03267_ VSS VSS VDD VDD network.in_period\[31\]\[1\]
+ sky130_fd_sc_hd__edfxtp_1
Xnetwork.in_period\[31\]\[2\]$_DFFE_PP_ clknet_leaf_29_clk_load
+ net426 _03267_ VSS VSS VDD VDD network.in_period\[31\]\[2\]
+ sky130_fd_sc_hd__edfxtp_1
Xnetwork.in_period\[31\]\[3\]$_DFFE_PP_ clknet_leaf_31_clk_load
+ net414 _03267_ VSS VSS VDD VDD network.in_period\[31\]\[3\]
+ sky130_fd_sc_hd__edfxtp_1
Xnetwork.in_period\[32\]\[0\]$_DFFE_PP_ clknet_leaf_47_clk_load
+ net439 _03268_ VSS VSS VDD VDD network.in_period\[32\]\[0\]
+ sky130_fd_sc_hd__edfxtp_1
Xnetwork.in_period\[32\]\[1\]$_DFFE_PP_ clknet_leaf_47_clk_load
+ net433 _03268_ VSS VSS VDD VDD network.in_period\[32\]\[1\]
+ sky130_fd_sc_hd__edfxtp_1
Xnetwork.in_period\[32\]\[2\]$_DFFE_PP_ clknet_leaf_47_clk_load
+ net423 _03268_ VSS VSS VDD VDD network.in_period\[32\]\[2\]
+ sky130_fd_sc_hd__edfxtp_1
Xnetwork.in_period\[32\]\[3\]$_DFFE_PP_ clknet_leaf_47_clk_load
+ net416 _03268_ VSS VSS VDD VDD network.in_period\[32\]\[3\]
+ sky130_fd_sc_hd__edfxtp_1
Xnetwork.in_period\[33\]\[0\]$_DFFE_PP_ clknet_leaf_16_clk_load
+ net439 _03269_ VSS VSS VDD VDD network.in_period\[33\]\[0\]
+ sky130_fd_sc_hd__edfxtp_1
Xnetwork.in_period\[33\]\[1\]$_DFFE_PP_ clknet_leaf_16_clk_load
+ net433 _03269_ VSS VSS VDD VDD network.in_period\[33\]\[1\]
+ sky130_fd_sc_hd__edfxtp_1
Xnetwork.in_period\[33\]\[2\]$_DFFE_PP_ clknet_leaf_16_clk_load
+ net423 _03269_ VSS VSS VDD VDD network.in_period\[33\]\[2\]
+ sky130_fd_sc_hd__edfxtp_1
Xnetwork.in_period\[33\]\[3\]$_DFFE_PP_ clknet_leaf_16_clk_load
+ net788 _03269_ VSS VSS VDD VDD network.in_period\[33\]\[3\]
+ sky130_fd_sc_hd__edfxtp_1
Xnetwork.in_period\[34\]\[0\]$_DFFE_PP_ clknet_leaf_46_clk_load
+ net439 _03270_ VSS VSS VDD VDD network.in_period\[34\]\[0\]
+ sky130_fd_sc_hd__edfxtp_1
Xnetwork.in_period\[34\]\[1\]$_DFFE_PP_ clknet_leaf_46_clk_load
+ net430 _03270_ VSS VSS VDD VDD network.in_period\[34\]\[1\]
+ sky130_fd_sc_hd__edfxtp_1
Xnetwork.in_period\[34\]\[2\]$_DFFE_PP_ clknet_leaf_46_clk_load
+ net425 _03270_ VSS VSS VDD VDD network.in_period\[34\]\[2\]
+ sky130_fd_sc_hd__edfxtp_1
Xnetwork.in_period\[34\]\[3\]$_DFFE_PP_ clknet_leaf_46_clk_load
+ net415 _03270_ VSS VSS VDD VDD network.in_period\[34\]\[3\]
+ sky130_fd_sc_hd__edfxtp_1
Xnetwork.in_period\[35\]\[0\]$_DFFE_PP_ clknet_leaf_45_clk_load
+ net439 _03271_ VSS VSS VDD VDD network.in_period\[35\]\[0\]
+ sky130_fd_sc_hd__edfxtp_1
Xnetwork.in_period\[35\]\[1\]$_DFFE_PP_ clknet_leaf_45_clk_load
+ net430 _03271_ VSS VSS VDD VDD network.in_period\[35\]\[1\]
+ sky130_fd_sc_hd__edfxtp_1
Xnetwork.in_period\[35\]\[2\]$_DFFE_PP_ clknet_leaf_45_clk_load
+ net425 _03271_ VSS VSS VDD VDD network.in_period\[35\]\[2\]
+ sky130_fd_sc_hd__edfxtp_1
Xnetwork.in_period\[35\]\[3\]$_DFFE_PP_ clknet_leaf_45_clk_load
+ net415 _03271_ VSS VSS VDD VDD network.in_period\[35\]\[3\]
+ sky130_fd_sc_hd__edfxtp_1
Xnetwork.in_period\[36\]\[0\]$_DFFE_PP_ clknet_leaf_47_clk_load
+ net439 _03272_ VSS VSS VDD VDD network.in_period\[36\]\[0\]
+ sky130_fd_sc_hd__edfxtp_1
Xnetwork.in_period\[36\]\[1\]$_DFFE_PP_ clknet_leaf_47_clk_load
+ net430 _03272_ VSS VSS VDD VDD network.in_period\[36\]\[1\]
+ sky130_fd_sc_hd__edfxtp_1
Xnetwork.in_period\[36\]\[2\]$_DFFE_PP_ clknet_leaf_47_clk_load
+ net425 _03272_ VSS VSS VDD VDD network.in_period\[36\]\[2\]
+ sky130_fd_sc_hd__edfxtp_1
Xnetwork.in_period\[36\]\[3\]$_DFFE_PP_ clknet_leaf_47_clk_load
+ net415 _03272_ VSS VSS VDD VDD network.in_period\[36\]\[3\]
+ sky130_fd_sc_hd__edfxtp_1
Xnetwork.in_period\[37\]\[0\]$_DFFE_PP_ clknet_leaf_46_clk_load
+ net439 _03273_ VSS VSS VDD VDD network.in_period\[37\]\[0\]
+ sky130_fd_sc_hd__edfxtp_1
Xnetwork.in_period\[37\]\[1\]$_DFFE_PP_ clknet_leaf_46_clk_load
+ net430 _03273_ VSS VSS VDD VDD network.in_period\[37\]\[1\]
+ sky130_fd_sc_hd__edfxtp_1
Xnetwork.in_period\[37\]\[2\]$_DFFE_PP_ clknet_leaf_46_clk_load
+ net425 _03273_ VSS VSS VDD VDD network.in_period\[37\]\[2\]
+ sky130_fd_sc_hd__edfxtp_1
Xnetwork.in_period\[37\]\[3\]$_DFFE_PP_ clknet_leaf_46_clk_load
+ net415 _03273_ VSS VSS VDD VDD network.in_period\[37\]\[3\]
+ sky130_fd_sc_hd__edfxtp_1
Xnetwork.in_period\[38\]\[0\]$_DFFE_PP_ clknet_leaf_49_clk_load
+ net439 _03274_ VSS VSS VDD VDD network.in_period\[38\]\[0\]
+ sky130_fd_sc_hd__edfxtp_1
Xnetwork.in_period\[38\]\[1\]$_DFFE_PP_ clknet_leaf_49_clk_load
+ net433 _03274_ VSS VSS VDD VDD network.in_period\[38\]\[1\]
+ sky130_fd_sc_hd__edfxtp_1
Xnetwork.in_period\[38\]\[2\]$_DFFE_PP_ clknet_leaf_49_clk_load
+ net423 _03274_ VSS VSS VDD VDD network.in_period\[38\]\[2\]
+ sky130_fd_sc_hd__edfxtp_1
Xnetwork.in_period\[38\]\[3\]$_DFFE_PP_ clknet_leaf_49_clk_load
+ net416 _03274_ VSS VSS VDD VDD network.in_period\[38\]\[3\]
+ sky130_fd_sc_hd__edfxtp_1
Xnetwork.in_period\[39\]\[0\]$_DFFE_PP_ clknet_leaf_48_clk_load
+ net439 _03275_ VSS VSS VDD VDD network.in_period\[39\]\[0\]
+ sky130_fd_sc_hd__edfxtp_1
Xnetwork.in_period\[39\]\[1\]$_DFFE_PP_ clknet_leaf_48_clk_load
+ net433 _03275_ VSS VSS VDD VDD network.in_period\[39\]\[1\]
+ sky130_fd_sc_hd__edfxtp_1
Xnetwork.in_period\[39\]\[2\]$_DFFE_PP_ clknet_leaf_48_clk_load
+ net423 _03275_ VSS VSS VDD VDD network.in_period\[39\]\[2\]
+ sky130_fd_sc_hd__edfxtp_1
Xnetwork.in_period\[39\]\[3\]$_DFFE_PP_ clknet_leaf_48_clk_load
+ net788 _03275_ VSS VSS VDD VDD network.in_period\[39\]\[3\]
+ sky130_fd_sc_hd__edfxtp_1
Xnetwork.in_period\[3\]\[0\]$_DFFE_PP_ clknet_leaf_39_clk_load
+ net440 _03276_ VSS VSS VDD VDD network.in_period\[3\]\[0\]
+ sky130_fd_sc_hd__edfxtp_1
Xnetwork.in_period\[3\]\[1\]$_DFFE_PP_ clknet_leaf_39_clk_load
+ net429 _03276_ VSS VSS VDD VDD network.in_period\[3\]\[1\]
+ sky130_fd_sc_hd__edfxtp_1
Xnetwork.in_period\[3\]\[2\]$_DFFE_PP_ clknet_leaf_39_clk_load
+ net426 _03276_ VSS VSS VDD VDD network.in_period\[3\]\[2\]
+ sky130_fd_sc_hd__edfxtp_1
Xnetwork.in_period\[3\]\[3\]$_DFFE_PP_ clknet_leaf_39_clk_load
+ net414 _03276_ VSS VSS VDD VDD network.in_period\[3\]\[3\]
+ sky130_fd_sc_hd__edfxtp_1
Xnetwork.in_period\[40\]\[0\]$_DFFE_PP_ clknet_leaf_48_clk_load
+ net439 _03277_ VSS VSS VDD VDD network.in_period\[40\]\[0\]
+ sky130_fd_sc_hd__edfxtp_1
Xnetwork.in_period\[40\]\[1\]$_DFFE_PP_ clknet_leaf_48_clk_load
+ net433 _03277_ VSS VSS VDD VDD network.in_period\[40\]\[1\]
+ sky130_fd_sc_hd__edfxtp_1
Xnetwork.in_period\[40\]\[2\]$_DFFE_PP_ clknet_leaf_48_clk_load
+ net423 _03277_ VSS VSS VDD VDD network.in_period\[40\]\[2\]
+ sky130_fd_sc_hd__edfxtp_1
Xnetwork.in_period\[40\]\[3\]$_DFFE_PP_ clknet_leaf_48_clk_load
+ net416 _03277_ VSS VSS VDD VDD network.in_period\[40\]\[3\]
+ sky130_fd_sc_hd__edfxtp_1
Xnetwork.in_period\[41\]\[0\]$_DFFE_PP_ clknet_leaf_47_clk_load
+ net439 _03278_ VSS VSS VDD VDD network.in_period\[41\]\[0\]
+ sky130_fd_sc_hd__edfxtp_1
Xnetwork.in_period\[41\]\[1\]$_DFFE_PP_ clknet_leaf_47_clk_load
+ net433 _03278_ VSS VSS VDD VDD network.in_period\[41\]\[1\]
+ sky130_fd_sc_hd__edfxtp_1
Xnetwork.in_period\[41\]\[2\]$_DFFE_PP_ clknet_leaf_48_clk_load
+ net423 _03278_ VSS VSS VDD VDD network.in_period\[41\]\[2\]
+ sky130_fd_sc_hd__edfxtp_1
Xnetwork.in_period\[41\]\[3\]$_DFFE_PP_ clknet_leaf_48_clk_load
+ net416 _03278_ VSS VSS VDD VDD network.in_period\[41\]\[3\]
+ sky130_fd_sc_hd__edfxtp_1
Xnetwork.in_period\[42\]\[0\]$_DFFE_PP_ clknet_leaf_46_clk_load
+ net439 _03279_ VSS VSS VDD VDD network.in_period\[42\]\[0\]
+ sky130_fd_sc_hd__edfxtp_1
Xnetwork.in_period\[42\]\[1\]$_DFFE_PP_ clknet_leaf_46_clk_load
+ net430 _03279_ VSS VSS VDD VDD network.in_period\[42\]\[1\]
+ sky130_fd_sc_hd__edfxtp_1
Xnetwork.in_period\[42\]\[2\]$_DFFE_PP_ clknet_leaf_46_clk_load
+ net425 _03279_ VSS VSS VDD VDD network.in_period\[42\]\[2\]
+ sky130_fd_sc_hd__edfxtp_1
Xnetwork.in_period\[42\]\[3\]$_DFFE_PP_ clknet_leaf_46_clk_load
+ net415 _03279_ VSS VSS VDD VDD network.in_period\[42\]\[3\]
+ sky130_fd_sc_hd__edfxtp_1
Xnetwork.in_period\[43\]\[0\]$_DFFE_PP_ clknet_leaf_17_clk_load
+ net439 _03280_ VSS VSS VDD VDD network.in_period\[43\]\[0\]
+ sky130_fd_sc_hd__edfxtp_1
Xnetwork.in_period\[43\]\[1\]$_DFFE_PP_ clknet_leaf_17_clk_load
+ net434 _03280_ VSS VSS VDD VDD network.in_period\[43\]\[1\]
+ sky130_fd_sc_hd__edfxtp_1
Xnetwork.in_period\[43\]\[2\]$_DFFE_PP_ clknet_leaf_17_clk_load
+ net423 _03280_ VSS VSS VDD VDD network.in_period\[43\]\[2\]
+ sky130_fd_sc_hd__edfxtp_1
Xnetwork.in_period\[43\]\[3\]$_DFFE_PP_ clknet_leaf_17_clk_load
+ net416 _03280_ VSS VSS VDD VDD network.in_period\[43\]\[3\]
+ sky130_fd_sc_hd__edfxtp_1
Xnetwork.in_period\[44\]\[0\]$_DFFE_PP_ clknet_leaf_17_clk_load
+ net439 _03281_ VSS VSS VDD VDD network.in_period\[44\]\[0\]
+ sky130_fd_sc_hd__edfxtp_1
Xnetwork.in_period\[44\]\[1\]$_DFFE_PP_ clknet_leaf_17_clk_load
+ net434 _03281_ VSS VSS VDD VDD network.in_period\[44\]\[1\]
+ sky130_fd_sc_hd__edfxtp_1
Xnetwork.in_period\[44\]\[2\]$_DFFE_PP_ clknet_leaf_17_clk_load
+ net423 _03281_ VSS VSS VDD VDD network.in_period\[44\]\[2\]
+ sky130_fd_sc_hd__edfxtp_1
Xnetwork.in_period\[44\]\[3\]$_DFFE_PP_ clknet_leaf_17_clk_load
+ net416 _03281_ VSS VSS VDD VDD network.in_period\[44\]\[3\]
+ sky130_fd_sc_hd__edfxtp_1
Xnetwork.in_period\[45\]\[0\]$_DFFE_PP_ clknet_leaf_17_clk_load
+ net439 _03282_ VSS VSS VDD VDD network.in_period\[45\]\[0\]
+ sky130_fd_sc_hd__edfxtp_1
Xnetwork.in_period\[45\]\[1\]$_DFFE_PP_ clknet_leaf_17_clk_load
+ net434 _03282_ VSS VSS VDD VDD network.in_period\[45\]\[1\]
+ sky130_fd_sc_hd__edfxtp_1
Xnetwork.in_period\[45\]\[2\]$_DFFE_PP_ clknet_leaf_17_clk_load
+ net423 _03282_ VSS VSS VDD VDD network.in_period\[45\]\[2\]
+ sky130_fd_sc_hd__edfxtp_1
Xnetwork.in_period\[45\]\[3\]$_DFFE_PP_ clknet_leaf_17_clk_load
+ net416 _03282_ VSS VSS VDD VDD network.in_period\[45\]\[3\]
+ sky130_fd_sc_hd__edfxtp_1
Xnetwork.in_period\[46\]\[0\]$_DFFE_PP_ clknet_leaf_16_clk_load
+ net439 _03283_ VSS VSS VDD VDD network.in_period\[46\]\[0\]
+ sky130_fd_sc_hd__edfxtp_1
Xnetwork.in_period\[46\]\[1\]$_DFFE_PP_ clknet_leaf_16_clk_load
+ net433 _03283_ VSS VSS VDD VDD network.in_period\[46\]\[1\]
+ sky130_fd_sc_hd__edfxtp_1
Xnetwork.in_period\[46\]\[2\]$_DFFE_PP_ clknet_leaf_16_clk_load
+ net423 _03283_ VSS VSS VDD VDD network.in_period\[46\]\[2\]
+ sky130_fd_sc_hd__edfxtp_1
Xnetwork.in_period\[46\]\[3\]$_DFFE_PP_ clknet_leaf_16_clk_load
+ net788 _03283_ VSS VSS VDD VDD network.in_period\[46\]\[3\]
+ sky130_fd_sc_hd__edfxtp_1
Xnetwork.in_period\[47\]\[0\]$_DFFE_PP_ clknet_leaf_18_clk_load
+ net439 _03284_ VSS VSS VDD VDD network.in_period\[47\]\[0\]
+ sky130_fd_sc_hd__edfxtp_1
Xnetwork.in_period\[47\]\[1\]$_DFFE_PP_ clknet_leaf_18_clk_load
+ net434 _03284_ VSS VSS VDD VDD network.in_period\[47\]\[1\]
+ sky130_fd_sc_hd__edfxtp_1
Xnetwork.in_period\[47\]\[2\]$_DFFE_PP_ clknet_leaf_18_clk_load
+ net423 _03284_ VSS VSS VDD VDD network.in_period\[47\]\[2\]
+ sky130_fd_sc_hd__edfxtp_1
Xnetwork.in_period\[47\]\[3\]$_DFFE_PP_ clknet_leaf_18_clk_load
+ net416 _03284_ VSS VSS VDD VDD network.in_period\[47\]\[3\]
+ sky130_fd_sc_hd__edfxtp_1
Xnetwork.in_period\[48\]\[0\]$_DFFE_PP_ clknet_leaf_29_clk_load
+ net440 _03285_ VSS VSS VDD VDD network.in_period\[48\]\[0\]
+ sky130_fd_sc_hd__edfxtp_1
Xnetwork.in_period\[48\]\[1\]$_DFFE_PP_ clknet_leaf_28_clk_load
+ net429 _03285_ VSS VSS VDD VDD network.in_period\[48\]\[1\]
+ sky130_fd_sc_hd__edfxtp_1
Xnetwork.in_period\[48\]\[2\]$_DFFE_PP_ clknet_leaf_29_clk_load
+ net426 _03285_ VSS VSS VDD VDD network.in_period\[48\]\[2\]
+ sky130_fd_sc_hd__edfxtp_1
Xnetwork.in_period\[48\]\[3\]$_DFFE_PP_ clknet_leaf_29_clk_load
+ net414 _03285_ VSS VSS VDD VDD network.in_period\[48\]\[3\]
+ sky130_fd_sc_hd__edfxtp_1
Xnetwork.in_period\[49\]\[0\]$_DFFE_PP_ clknet_leaf_27_clk_load
+ net440 _03286_ VSS VSS VDD VDD network.in_period\[49\]\[0\]
+ sky130_fd_sc_hd__edfxtp_1
Xnetwork.in_period\[49\]\[1\]$_DFFE_PP_ clknet_leaf_27_clk_load
+ net429 _03286_ VSS VSS VDD VDD network.in_period\[49\]\[1\]
+ sky130_fd_sc_hd__edfxtp_1
Xnetwork.in_period\[49\]\[2\]$_DFFE_PP_ clknet_leaf_30_clk_load
+ net427 _03286_ VSS VSS VDD VDD network.in_period\[49\]\[2\]
+ sky130_fd_sc_hd__edfxtp_1
Xnetwork.in_period\[49\]\[3\]$_DFFE_PP_ clknet_leaf_27_clk_load
+ net414 _03286_ VSS VSS VDD VDD network.in_period\[49\]\[3\]
+ sky130_fd_sc_hd__edfxtp_1
Xnetwork.in_period\[4\]\[0\]$_DFFE_PP_ clknet_leaf_40_clk_load
+ net440 _03287_ VSS VSS VDD VDD network.in_period\[4\]\[0\]
+ sky130_fd_sc_hd__edfxtp_1
Xnetwork.in_period\[4\]\[1\]$_DFFE_PP_ clknet_leaf_40_clk_load
+ net429 _03287_ VSS VSS VDD VDD network.in_period\[4\]\[1\]
+ sky130_fd_sc_hd__edfxtp_1
Xnetwork.in_period\[4\]\[2\]$_DFFE_PP_ clknet_leaf_40_clk_load
+ net426 _03287_ VSS VSS VDD VDD network.in_period\[4\]\[2\]
+ sky130_fd_sc_hd__edfxtp_1
Xnetwork.in_period\[4\]\[3\]$_DFFE_PP_ clknet_leaf_40_clk_load
+ net414 _03287_ VSS VSS VDD VDD network.in_period\[4\]\[3\]
+ sky130_fd_sc_hd__edfxtp_1
Xnetwork.in_period\[50\]\[0\]$_DFFE_PP_ clknet_leaf_28_clk_load
+ net440 _03288_ VSS VSS VDD VDD network.in_period\[50\]\[0\]
+ sky130_fd_sc_hd__edfxtp_1
Xnetwork.in_period\[50\]\[1\]$_DFFE_PP_ clknet_leaf_28_clk_load
+ net429 _03288_ VSS VSS VDD VDD network.in_period\[50\]\[1\]
+ sky130_fd_sc_hd__edfxtp_1
Xnetwork.in_period\[50\]\[2\]$_DFFE_PP_ clknet_leaf_28_clk_load
+ net427 _03288_ VSS VSS VDD VDD network.in_period\[50\]\[2\]
+ sky130_fd_sc_hd__edfxtp_1
Xnetwork.in_period\[50\]\[3\]$_DFFE_PP_ clknet_leaf_28_clk_load
+ net414 _03288_ VSS VSS VDD VDD network.in_period\[50\]\[3\]
+ sky130_fd_sc_hd__edfxtp_1
Xnetwork.in_period\[51\]\[0\]$_DFFE_PP_ clknet_leaf_44_clk_load
+ net439 _03289_ VSS VSS VDD VDD network.in_period\[51\]\[0\]
+ sky130_fd_sc_hd__edfxtp_1
Xnetwork.in_period\[51\]\[1\]$_DFFE_PP_ clknet_leaf_44_clk_load
+ net430 _03289_ VSS VSS VDD VDD network.in_period\[51\]\[1\]
+ sky130_fd_sc_hd__edfxtp_1
Xnetwork.in_period\[51\]\[2\]$_DFFE_PP_ clknet_leaf_44_clk_load
+ net425 _03289_ VSS VSS VDD VDD network.in_period\[51\]\[2\]
+ sky130_fd_sc_hd__edfxtp_1
Xnetwork.in_period\[51\]\[3\]$_DFFE_PP_ clknet_leaf_44_clk_load
+ net415 _03289_ VSS VSS VDD VDD network.in_period\[51\]\[3\]
+ sky130_fd_sc_hd__edfxtp_1
Xnetwork.in_period\[52\]\[0\]$_DFFE_PP_ clknet_leaf_29_clk_load
+ net440 _03290_ VSS VSS VDD VDD network.in_period\[52\]\[0\]
+ sky130_fd_sc_hd__edfxtp_1
Xnetwork.in_period\[52\]\[1\]$_DFFE_PP_ clknet_leaf_29_clk_load
+ net429 _03290_ VSS VSS VDD VDD network.in_period\[52\]\[1\]
+ sky130_fd_sc_hd__edfxtp_1
Xnetwork.in_period\[52\]\[2\]$_DFFE_PP_ clknet_leaf_28_clk_load
+ net427 _03290_ VSS VSS VDD VDD network.in_period\[52\]\[2\]
+ sky130_fd_sc_hd__edfxtp_1
Xnetwork.in_period\[52\]\[3\]$_DFFE_PP_ clknet_leaf_29_clk_load
+ net414 _03290_ VSS VSS VDD VDD network.in_period\[52\]\[3\]
+ sky130_fd_sc_hd__edfxtp_1
Xnetwork.in_period\[53\]\[0\]$_DFFE_PP_ clknet_leaf_29_clk_load
+ net440 _03291_ VSS VSS VDD VDD network.in_period\[53\]\[0\]
+ sky130_fd_sc_hd__edfxtp_1
Xnetwork.in_period\[53\]\[1\]$_DFFE_PP_ clknet_leaf_29_clk_load
+ net429 _03291_ VSS VSS VDD VDD network.in_period\[53\]\[1\]
+ sky130_fd_sc_hd__edfxtp_1
Xnetwork.in_period\[53\]\[2\]$_DFFE_PP_ clknet_leaf_29_clk_load
+ net427 _03291_ VSS VSS VDD VDD network.in_period\[53\]\[2\]
+ sky130_fd_sc_hd__edfxtp_1
Xnetwork.in_period\[53\]\[3\]$_DFFE_PP_ clknet_leaf_29_clk_load
+ net414 _03291_ VSS VSS VDD VDD network.in_period\[53\]\[3\]
+ sky130_fd_sc_hd__edfxtp_1
Xnetwork.in_period\[54\]\[0\]$_DFFE_PP_ clknet_leaf_37_clk_load
+ net440 _03292_ VSS VSS VDD VDD network.in_period\[54\]\[0\]
+ sky130_fd_sc_hd__edfxtp_1
Xnetwork.in_period\[54\]\[1\]$_DFFE_PP_ clknet_leaf_37_clk_load
+ net429 _03292_ VSS VSS VDD VDD network.in_period\[54\]\[1\]
+ sky130_fd_sc_hd__edfxtp_1
Xnetwork.in_period\[54\]\[2\]$_DFFE_PP_ clknet_leaf_37_clk_load
+ net427 _03292_ VSS VSS VDD VDD network.in_period\[54\]\[2\]
+ sky130_fd_sc_hd__edfxtp_1
Xnetwork.in_period\[54\]\[3\]$_DFFE_PP_ clknet_leaf_37_clk_load
+ net414 _03292_ VSS VSS VDD VDD network.in_period\[54\]\[3\]
+ sky130_fd_sc_hd__edfxtp_1
Xnetwork.in_period\[55\]\[0\]$_DFFE_PP_ clknet_leaf_36_clk_load
+ net440 _03293_ VSS VSS VDD VDD network.in_period\[55\]\[0\]
+ sky130_fd_sc_hd__edfxtp_1
Xnetwork.in_period\[55\]\[1\]$_DFFE_PP_ clknet_leaf_37_clk_load
+ net429 _03293_ VSS VSS VDD VDD network.in_period\[55\]\[1\]
+ sky130_fd_sc_hd__edfxtp_1
Xnetwork.in_period\[55\]\[2\]$_DFFE_PP_ clknet_leaf_37_clk_load
+ net427 _03293_ VSS VSS VDD VDD network.in_period\[55\]\[2\]
+ sky130_fd_sc_hd__edfxtp_1
Xnetwork.in_period\[55\]\[3\]$_DFFE_PP_ clknet_leaf_36_clk_load
+ net414 _03293_ VSS VSS VDD VDD network.in_period\[55\]\[3\]
+ sky130_fd_sc_hd__edfxtp_1
Xnetwork.in_period\[56\]\[0\]$_DFFE_PP_ clknet_leaf_28_clk_load
+ net440 _03294_ VSS VSS VDD VDD network.in_period\[56\]\[0\]
+ sky130_fd_sc_hd__edfxtp_1
Xnetwork.in_period\[56\]\[1\]$_DFFE_PP_ clknet_leaf_28_clk_load
+ net429 _03294_ VSS VSS VDD VDD network.in_period\[56\]\[1\]
+ sky130_fd_sc_hd__edfxtp_1
Xnetwork.in_period\[56\]\[2\]$_DFFE_PP_ clknet_leaf_28_clk_load
+ net427 _03294_ VSS VSS VDD VDD network.in_period\[56\]\[2\]
+ sky130_fd_sc_hd__edfxtp_1
Xnetwork.in_period\[56\]\[3\]$_DFFE_PP_ clknet_leaf_28_clk_load
+ net414 _03294_ VSS VSS VDD VDD network.in_period\[56\]\[3\]
+ sky130_fd_sc_hd__edfxtp_1
Xnetwork.in_period\[57\]\[0\]$_DFFE_PP_ clknet_leaf_45_clk_load
+ net440 _03295_ VSS VSS VDD VDD network.in_period\[57\]\[0\]
+ sky130_fd_sc_hd__edfxtp_1
Xnetwork.in_period\[57\]\[1\]$_DFFE_PP_ clknet_leaf_45_clk_load
+ net429 _03295_ VSS VSS VDD VDD network.in_period\[57\]\[1\]
+ sky130_fd_sc_hd__edfxtp_1
Xnetwork.in_period\[57\]\[2\]$_DFFE_PP_ clknet_leaf_44_clk_load
+ net427 _03295_ VSS VSS VDD VDD network.in_period\[57\]\[2\]
+ sky130_fd_sc_hd__edfxtp_1
Xnetwork.in_period\[57\]\[3\]$_DFFE_PP_ clknet_leaf_45_clk_load
+ net414 _03295_ VSS VSS VDD VDD network.in_period\[57\]\[3\]
+ sky130_fd_sc_hd__edfxtp_1
Xnetwork.in_period\[58\]\[0\]$_DFFE_PP_ clknet_leaf_19_clk_load
+ net439 _03296_ VSS VSS VDD VDD network.in_period\[58\]\[0\]
+ sky130_fd_sc_hd__edfxtp_1
Xnetwork.in_period\[58\]\[1\]$_DFFE_PP_ clknet_leaf_19_clk_load
+ net430 _03296_ VSS VSS VDD VDD network.in_period\[58\]\[1\]
+ sky130_fd_sc_hd__edfxtp_1
Xnetwork.in_period\[58\]\[2\]$_DFFE_PP_ clknet_leaf_19_clk_load
+ net425 _03296_ VSS VSS VDD VDD network.in_period\[58\]\[2\]
+ sky130_fd_sc_hd__edfxtp_1
Xnetwork.in_period\[58\]\[3\]$_DFFE_PP_ clknet_leaf_19_clk_load
+ net415 _03296_ VSS VSS VDD VDD network.in_period\[58\]\[3\]
+ sky130_fd_sc_hd__edfxtp_1
Xnetwork.in_period\[59\]\[0\]$_DFFE_PP_ clknet_leaf_19_clk_load
+ net439 _03297_ VSS VSS VDD VDD network.in_period\[59\]\[0\]
+ sky130_fd_sc_hd__edfxtp_1
Xnetwork.in_period\[59\]\[1\]$_DFFE_PP_ clknet_leaf_19_clk_load
+ net430 _03297_ VSS VSS VDD VDD network.in_period\[59\]\[1\]
+ sky130_fd_sc_hd__edfxtp_1
Xnetwork.in_period\[59\]\[2\]$_DFFE_PP_ clknet_leaf_19_clk_load
+ net425 _03297_ VSS VSS VDD VDD network.in_period\[59\]\[2\]
+ sky130_fd_sc_hd__edfxtp_1
Xnetwork.in_period\[59\]\[3\]$_DFFE_PP_ clknet_leaf_19_clk_load
+ net415 _03297_ VSS VSS VDD VDD network.in_period\[59\]\[3\]
+ sky130_fd_sc_hd__edfxtp_1
Xnetwork.in_period\[5\]\[0\]$_DFFE_PP_ clknet_leaf_41_clk_load
+ net439 _03298_ VSS VSS VDD VDD network.in_period\[5\]\[0\]
+ sky130_fd_sc_hd__edfxtp_1
Xnetwork.in_period\[5\]\[1\]$_DFFE_PP_ clknet_leaf_41_clk_load
+ net430 _03298_ VSS VSS VDD VDD network.in_period\[5\]\[1\]
+ sky130_fd_sc_hd__edfxtp_1
Xnetwork.in_period\[5\]\[2\]$_DFFE_PP_ clknet_leaf_41_clk_load
+ net425 _03298_ VSS VSS VDD VDD network.in_period\[5\]\[2\]
+ sky130_fd_sc_hd__edfxtp_1
Xnetwork.in_period\[5\]\[3\]$_DFFE_PP_ clknet_leaf_41_clk_load
+ net415 _03298_ VSS VSS VDD VDD network.in_period\[5\]\[3\]
+ sky130_fd_sc_hd__edfxtp_1
Xnetwork.in_period\[60\]\[0\]$_DFFE_PP_ clknet_leaf_27_clk_load
+ net440 _03299_ VSS VSS VDD VDD network.in_period\[60\]\[0\]
+ sky130_fd_sc_hd__edfxtp_1
Xnetwork.in_period\[60\]\[1\]$_DFFE_PP_ clknet_leaf_27_clk_load
+ net429 _03299_ VSS VSS VDD VDD network.in_period\[60\]\[1\]
+ sky130_fd_sc_hd__edfxtp_1
Xnetwork.in_period\[60\]\[2\]$_DFFE_PP_ clknet_leaf_27_clk_load
+ net427 _03299_ VSS VSS VDD VDD network.in_period\[60\]\[2\]
+ sky130_fd_sc_hd__edfxtp_1
Xnetwork.in_period\[60\]\[3\]$_DFFE_PP_ clknet_leaf_27_clk_load
+ net414 _03299_ VSS VSS VDD VDD network.in_period\[60\]\[3\]
+ sky130_fd_sc_hd__edfxtp_1
Xnetwork.in_period\[61\]\[0\]$_DFFE_PP_ clknet_leaf_20_clk_load
+ net450 _03300_ VSS VSS VDD VDD network.in_period\[61\]\[0\]
+ sky130_fd_sc_hd__edfxtp_1
Xnetwork.in_period\[61\]\[1\]$_DFFE_PP_ clknet_leaf_27_clk_load
+ net430 _03300_ VSS VSS VDD VDD network.in_period\[61\]\[1\]
+ sky130_fd_sc_hd__edfxtp_1
Xnetwork.in_period\[61\]\[2\]$_DFFE_PP_ clknet_leaf_20_clk_load
+ net427 _03300_ VSS VSS VDD VDD network.in_period\[61\]\[2\]
+ sky130_fd_sc_hd__edfxtp_1
Xnetwork.in_period\[61\]\[3\]$_DFFE_PP_ clknet_leaf_27_clk_load
+ net415 _03300_ VSS VSS VDD VDD network.in_period\[61\]\[3\]
+ sky130_fd_sc_hd__edfxtp_1
Xnetwork.in_period\[62\]\[0\]$_DFFE_PP_ clknet_leaf_19_clk_load
+ net439 _03301_ VSS VSS VDD VDD network.in_period\[62\]\[0\]
+ sky130_fd_sc_hd__edfxtp_1
Xnetwork.in_period\[62\]\[1\]$_DFFE_PP_ clknet_leaf_19_clk_load
+ net430 _03301_ VSS VSS VDD VDD network.in_period\[62\]\[1\]
+ sky130_fd_sc_hd__edfxtp_1
Xnetwork.in_period\[62\]\[2\]$_DFFE_PP_ clknet_leaf_19_clk_load
+ net425 _03301_ VSS VSS VDD VDD network.in_period\[62\]\[2\]
+ sky130_fd_sc_hd__edfxtp_1
Xnetwork.in_period\[62\]\[3\]$_DFFE_PP_ clknet_leaf_19_clk_load
+ net415 _03301_ VSS VSS VDD VDD network.in_period\[62\]\[3\]
+ sky130_fd_sc_hd__edfxtp_1
Xnetwork.in_period\[63\]\[0\]$_DFFE_PP_ clknet_leaf_20_clk_load
+ net450 _03302_ VSS VSS VDD VDD network.in_period\[63\]\[0\]
+ sky130_fd_sc_hd__edfxtp_1
Xnetwork.in_period\[63\]\[1\]$_DFFE_PP_ clknet_leaf_20_clk_load
+ net430 _03302_ VSS VSS VDD VDD network.in_period\[63\]\[1\]
+ sky130_fd_sc_hd__edfxtp_1
Xnetwork.in_period\[63\]\[2\]$_DFFE_PP_ clknet_leaf_20_clk_load
+ net427 _03302_ VSS VSS VDD VDD network.in_period\[63\]\[2\]
+ sky130_fd_sc_hd__edfxtp_1
Xnetwork.in_period\[63\]\[3\]$_DFFE_PP_ clknet_leaf_20_clk_load
+ net415 _03302_ VSS VSS VDD VDD network.in_period\[63\]\[3\]
+ sky130_fd_sc_hd__edfxtp_1
Xnetwork.in_period\[64\]\[0\]$_DFFE_PP_ clknet_leaf_18_clk_load
+ net439 _03303_ VSS VSS VDD VDD network.in_period\[64\]\[0\]
+ sky130_fd_sc_hd__edfxtp_1
Xnetwork.in_period\[64\]\[1\]$_DFFE_PP_ clknet_leaf_18_clk_load
+ net430 _03303_ VSS VSS VDD VDD network.in_period\[64\]\[1\]
+ sky130_fd_sc_hd__edfxtp_1
Xnetwork.in_period\[64\]\[2\]$_DFFE_PP_ clknet_leaf_18_clk_load
+ net425 _03303_ VSS VSS VDD VDD network.in_period\[64\]\[2\]
+ sky130_fd_sc_hd__edfxtp_1
Xnetwork.in_period\[64\]\[3\]$_DFFE_PP_ clknet_leaf_18_clk_load
+ net415 _03303_ VSS VSS VDD VDD network.in_period\[64\]\[3\]
+ sky130_fd_sc_hd__edfxtp_1
Xnetwork.in_period\[65\]\[0\]$_DFFE_PP_ clknet_leaf_22_clk_load
+ net440 _03304_ VSS VSS VDD VDD network.in_period\[65\]\[0\]
+ sky130_fd_sc_hd__edfxtp_1
Xnetwork.in_period\[65\]\[1\]$_DFFE_PP_ clknet_leaf_22_clk_load
+ net429 _03304_ VSS VSS VDD VDD network.in_period\[65\]\[1\]
+ sky130_fd_sc_hd__edfxtp_1
Xnetwork.in_period\[65\]\[2\]$_DFFE_PP_ clknet_leaf_22_clk_load
+ net427 _03304_ VSS VSS VDD VDD network.in_period\[65\]\[2\]
+ sky130_fd_sc_hd__edfxtp_1
Xnetwork.in_period\[65\]\[3\]$_DFFE_PP_ clknet_leaf_22_clk_load
+ net414 _03304_ VSS VSS VDD VDD network.in_period\[65\]\[3\]
+ sky130_fd_sc_hd__edfxtp_1
Xnetwork.in_period\[66\]\[0\]$_DFFE_PP_ clknet_leaf_21_clk_load
+ net450 _03305_ VSS VSS VDD VDD network.in_period\[66\]\[0\]
+ sky130_fd_sc_hd__edfxtp_1
Xnetwork.in_period\[66\]\[1\]$_DFFE_PP_ clknet_leaf_21_clk_load
+ net430 _03305_ VSS VSS VDD VDD network.in_period\[66\]\[1\]
+ sky130_fd_sc_hd__edfxtp_1
Xnetwork.in_period\[66\]\[2\]$_DFFE_PP_ clknet_leaf_21_clk_load
+ net425 _03305_ VSS VSS VDD VDD network.in_period\[66\]\[2\]
+ sky130_fd_sc_hd__edfxtp_1
Xnetwork.in_period\[66\]\[3\]$_DFFE_PP_ clknet_leaf_21_clk_load
+ net415 _03305_ VSS VSS VDD VDD network.in_period\[66\]\[3\]
+ sky130_fd_sc_hd__edfxtp_1
Xnetwork.in_period\[67\]\[0\]$_DFFE_PP_ clknet_leaf_20_clk_load
+ net450 _03306_ VSS VSS VDD VDD network.in_period\[67\]\[0\]
+ sky130_fd_sc_hd__edfxtp_1
Xnetwork.in_period\[67\]\[1\]$_DFFE_PP_ clknet_leaf_20_clk_load
+ net430 _03306_ VSS VSS VDD VDD network.in_period\[67\]\[1\]
+ sky130_fd_sc_hd__edfxtp_1
Xnetwork.in_period\[67\]\[2\]$_DFFE_PP_ clknet_leaf_20_clk_load
+ net427 _03306_ VSS VSS VDD VDD network.in_period\[67\]\[2\]
+ sky130_fd_sc_hd__edfxtp_1
Xnetwork.in_period\[67\]\[3\]$_DFFE_PP_ clknet_leaf_20_clk_load
+ net415 _03306_ VSS VSS VDD VDD network.in_period\[67\]\[3\]
+ sky130_fd_sc_hd__edfxtp_1
Xnetwork.in_period\[68\]\[0\]$_DFFE_PP_ clknet_leaf_22_clk_load
+ net440 _03307_ VSS VSS VDD VDD network.in_period\[68\]\[0\]
+ sky130_fd_sc_hd__edfxtp_1
Xnetwork.in_period\[68\]\[1\]$_DFFE_PP_ clknet_leaf_22_clk_load
+ net429 _03307_ VSS VSS VDD VDD network.in_period\[68\]\[1\]
+ sky130_fd_sc_hd__edfxtp_1
Xnetwork.in_period\[68\]\[2\]$_DFFE_PP_ clknet_leaf_22_clk_load
+ net427 _03307_ VSS VSS VDD VDD network.in_period\[68\]\[2\]
+ sky130_fd_sc_hd__edfxtp_1
Xnetwork.in_period\[68\]\[3\]$_DFFE_PP_ clknet_leaf_22_clk_load
+ net414 _03307_ VSS VSS VDD VDD network.in_period\[68\]\[3\]
+ sky130_fd_sc_hd__edfxtp_1
Xnetwork.in_period\[69\]\[0\]$_DFFE_PP_ clknet_leaf_18_clk_load
+ net439 _03308_ VSS VSS VDD VDD network.in_period\[69\]\[0\]
+ sky130_fd_sc_hd__edfxtp_1
Xnetwork.in_period\[69\]\[1\]$_DFFE_PP_ clknet_leaf_18_clk_load
+ net430 _03308_ VSS VSS VDD VDD network.in_period\[69\]\[1\]
+ sky130_fd_sc_hd__edfxtp_1
Xnetwork.in_period\[69\]\[2\]$_DFFE_PP_ clknet_leaf_19_clk_load
+ net425 _03308_ VSS VSS VDD VDD network.in_period\[69\]\[2\]
+ sky130_fd_sc_hd__edfxtp_1
Xnetwork.in_period\[69\]\[3\]$_DFFE_PP_ clknet_leaf_18_clk_load
+ net415 _03308_ VSS VSS VDD VDD network.in_period\[69\]\[3\]
+ sky130_fd_sc_hd__edfxtp_1
Xnetwork.in_period\[6\]\[0\]$_DFFE_PP_ clknet_leaf_39_clk_load
+ net440 _03309_ VSS VSS VDD VDD network.in_period\[6\]\[0\]
+ sky130_fd_sc_hd__edfxtp_1
Xnetwork.in_period\[6\]\[1\]$_DFFE_PP_ clknet_leaf_39_clk_load
+ net429 _03309_ VSS VSS VDD VDD network.in_period\[6\]\[1\]
+ sky130_fd_sc_hd__edfxtp_1
Xnetwork.in_period\[6\]\[2\]$_DFFE_PP_ clknet_leaf_39_clk_load
+ net426 _03309_ VSS VSS VDD VDD network.in_period\[6\]\[2\]
+ sky130_fd_sc_hd__edfxtp_1
Xnetwork.in_period\[6\]\[3\]$_DFFE_PP_ clknet_leaf_36_clk_load
+ net414 _03309_ VSS VSS VDD VDD network.in_period\[6\]\[3\]
+ sky130_fd_sc_hd__edfxtp_1
Xnetwork.in_period\[70\]\[0\]$_DFFE_PP_ clknet_leaf_21_clk_load
+ net450 _03310_ VSS VSS VDD VDD network.in_period\[70\]\[0\]
+ sky130_fd_sc_hd__edfxtp_1
Xnetwork.in_period\[70\]\[1\]$_DFFE_PP_ clknet_leaf_21_clk_load
+ net430 _03310_ VSS VSS VDD VDD network.in_period\[70\]\[1\]
+ sky130_fd_sc_hd__edfxtp_1
Xnetwork.in_period\[70\]\[2\]$_DFFE_PP_ clknet_leaf_9_clk_load
+ net427 _03310_ VSS VSS VDD VDD network.in_period\[70\]\[2\]
+ sky130_fd_sc_hd__edfxtp_1
Xnetwork.in_period\[70\]\[3\]$_DFFE_PP_ clknet_leaf_21_clk_load
+ net415 _03310_ VSS VSS VDD VDD network.in_period\[70\]\[3\]
+ sky130_fd_sc_hd__edfxtp_1
Xnetwork.in_period\[71\]\[0\]$_DFFE_PP_ clknet_leaf_22_clk_load
+ net450 _03311_ VSS VSS VDD VDD network.in_period\[71\]\[0\]
+ sky130_fd_sc_hd__edfxtp_1
Xnetwork.in_period\[71\]\[1\]$_DFFE_PP_ clknet_leaf_22_clk_load
+ net430 _03311_ VSS VSS VDD VDD network.in_period\[71\]\[1\]
+ sky130_fd_sc_hd__edfxtp_1
Xnetwork.in_period\[71\]\[2\]$_DFFE_PP_ clknet_leaf_22_clk_load
+ net427 _03311_ VSS VSS VDD VDD network.in_period\[71\]\[2\]
+ sky130_fd_sc_hd__edfxtp_1
Xnetwork.in_period\[71\]\[3\]$_DFFE_PP_ clknet_leaf_22_clk_load
+ net415 _03311_ VSS VSS VDD VDD network.in_period\[71\]\[3\]
+ sky130_fd_sc_hd__edfxtp_1
Xnetwork.in_period\[72\]\[0\]$_DFFE_PP_ clknet_leaf_13_clk_load
+ net437 _03312_ VSS VSS VDD VDD network.in_period\[72\]\[0\]
+ sky130_fd_sc_hd__edfxtp_1
Xnetwork.in_period\[72\]\[1\]$_DFFE_PP_ clknet_leaf_10_clk_load
+ net434 _03312_ VSS VSS VDD VDD network.in_period\[72\]\[1\]
+ sky130_fd_sc_hd__edfxtp_1
Xnetwork.in_period\[72\]\[2\]$_DFFE_PP_ clknet_leaf_13_clk_load
+ net425 _03312_ VSS VSS VDD VDD network.in_period\[72\]\[2\]
+ sky130_fd_sc_hd__edfxtp_1
Xnetwork.in_period\[72\]\[3\]$_DFFE_PP_ clknet_leaf_10_clk_load
+ net417 _03312_ VSS VSS VDD VDD network.in_period\[72\]\[3\]
+ sky130_fd_sc_hd__edfxtp_1
Xnetwork.in_period\[73\]\[0\]$_DFFE_PP_ clknet_leaf_9_clk_load
+ net450 _03313_ VSS VSS VDD VDD network.in_period\[73\]\[0\]
+ sky130_fd_sc_hd__edfxtp_1
Xnetwork.in_period\[73\]\[1\]$_DFFE_PP_ clknet_leaf_9_clk_load
+ net430 _03313_ VSS VSS VDD VDD network.in_period\[73\]\[1\]
+ sky130_fd_sc_hd__edfxtp_1
Xnetwork.in_period\[73\]\[2\]$_DFFE_PP_ clknet_leaf_9_clk_load
+ net427 _03313_ VSS VSS VDD VDD network.in_period\[73\]\[2\]
+ sky130_fd_sc_hd__edfxtp_1
Xnetwork.in_period\[73\]\[3\]$_DFFE_PP_ clknet_leaf_9_clk_load
+ net415 _03313_ VSS VSS VDD VDD network.in_period\[73\]\[3\]
+ sky130_fd_sc_hd__edfxtp_1
Xnetwork.in_period\[74\]\[0\]$_DFFE_PP_ clknet_leaf_9_clk_load
+ net437 _03314_ VSS VSS VDD VDD network.in_period\[74\]\[0\]
+ sky130_fd_sc_hd__edfxtp_1
Xnetwork.in_period\[74\]\[1\]$_DFFE_PP_ clknet_leaf_9_clk_load
+ net430 _03314_ VSS VSS VDD VDD network.in_period\[74\]\[1\]
+ sky130_fd_sc_hd__edfxtp_1
Xnetwork.in_period\[74\]\[2\]$_DFFE_PP_ clknet_leaf_10_clk_load
+ net427 _03314_ VSS VSS VDD VDD network.in_period\[74\]\[2\]
+ sky130_fd_sc_hd__edfxtp_1
Xnetwork.in_period\[74\]\[3\]$_DFFE_PP_ clknet_leaf_9_clk_load
+ net415 _03314_ VSS VSS VDD VDD network.in_period\[74\]\[3\]
+ sky130_fd_sc_hd__edfxtp_1
Xnetwork.in_period\[75\]\[0\]$_DFFE_PP_ clknet_leaf_10_clk_load
+ net437 _03315_ VSS VSS VDD VDD network.in_period\[75\]\[0\]
+ sky130_fd_sc_hd__edfxtp_1
Xnetwork.in_period\[75\]\[1\]$_DFFE_PP_ clknet_leaf_10_clk_load
+ net430 _03315_ VSS VSS VDD VDD network.in_period\[75\]\[1\]
+ sky130_fd_sc_hd__edfxtp_1
Xnetwork.in_period\[75\]\[2\]$_DFFE_PP_ clknet_leaf_10_clk_load
+ net427 _03315_ VSS VSS VDD VDD network.in_period\[75\]\[2\]
+ sky130_fd_sc_hd__edfxtp_1
Xnetwork.in_period\[75\]\[3\]$_DFFE_PP_ clknet_leaf_10_clk_load
+ net415 _03315_ VSS VSS VDD VDD network.in_period\[75\]\[3\]
+ sky130_fd_sc_hd__edfxtp_1
Xnetwork.in_period\[76\]\[0\]$_DFFE_PP_ clknet_leaf_13_clk_load
+ net436 _03316_ VSS VSS VDD VDD network.in_period\[76\]\[0\]
+ sky130_fd_sc_hd__edfxtp_1
Xnetwork.in_period\[76\]\[1\]$_DFFE_PP_ clknet_leaf_13_clk_load
+ net434 _03316_ VSS VSS VDD VDD network.in_period\[76\]\[1\]
+ sky130_fd_sc_hd__edfxtp_1
Xnetwork.in_period\[76\]\[2\]$_DFFE_PP_ clknet_leaf_13_clk_load
+ net425 _03316_ VSS VSS VDD VDD network.in_period\[76\]\[2\]
+ sky130_fd_sc_hd__edfxtp_1
Xnetwork.in_period\[76\]\[3\]$_DFFE_PP_ clknet_leaf_13_clk_load
+ net416 _03316_ VSS VSS VDD VDD network.in_period\[76\]\[3\]
+ sky130_fd_sc_hd__edfxtp_1
Xnetwork.in_period\[77\]\[0\]$_DFFE_PP_ clknet_leaf_14_clk_load
+ net439 _03317_ VSS VSS VDD VDD network.in_period\[77\]\[0\]
+ sky130_fd_sc_hd__edfxtp_1
Xnetwork.in_period\[77\]\[1\]$_DFFE_PP_ clknet_leaf_14_clk_load
+ net434 _03317_ VSS VSS VDD VDD network.in_period\[77\]\[1\]
+ sky130_fd_sc_hd__edfxtp_1
Xnetwork.in_period\[77\]\[2\]$_DFFE_PP_ clknet_leaf_14_clk_load
+ net423 _03317_ VSS VSS VDD VDD network.in_period\[77\]\[2\]
+ sky130_fd_sc_hd__edfxtp_1
Xnetwork.in_period\[77\]\[3\]$_DFFE_PP_ clknet_leaf_14_clk_load
+ net416 _03317_ VSS VSS VDD VDD network.in_period\[77\]\[3\]
+ sky130_fd_sc_hd__edfxtp_1
Xnetwork.in_period\[78\]\[0\]$_DFFE_PP_ clknet_leaf_13_clk_load
+ net437 _03318_ VSS VSS VDD VDD network.in_period\[78\]\[0\]
+ sky130_fd_sc_hd__edfxtp_1
Xnetwork.in_period\[78\]\[1\]$_DFFE_PP_ clknet_leaf_13_clk_load
+ net430 _03318_ VSS VSS VDD VDD network.in_period\[78\]\[1\]
+ sky130_fd_sc_hd__edfxtp_1
Xnetwork.in_period\[78\]\[2\]$_DFFE_PP_ clknet_leaf_13_clk_load
+ net425 _03318_ VSS VSS VDD VDD network.in_period\[78\]\[2\]
+ sky130_fd_sc_hd__edfxtp_1
Xnetwork.in_period\[78\]\[3\]$_DFFE_PP_ clknet_leaf_13_clk_load
+ net415 _03318_ VSS VSS VDD VDD network.in_period\[78\]\[3\]
+ sky130_fd_sc_hd__edfxtp_1
Xnetwork.in_period\[79\]\[0\]$_DFFE_PP_ clknet_leaf_14_clk_load
+ net436 _03319_ VSS VSS VDD VDD network.in_period\[79\]\[0\]
+ sky130_fd_sc_hd__edfxtp_1
Xnetwork.in_period\[79\]\[1\]$_DFFE_PP_ clknet_leaf_14_clk_load
+ net434 _03319_ VSS VSS VDD VDD network.in_period\[79\]\[1\]
+ sky130_fd_sc_hd__edfxtp_1
Xnetwork.in_period\[79\]\[2\]$_DFFE_PP_ clknet_leaf_14_clk_load
+ net423 _03319_ VSS VSS VDD VDD network.in_period\[79\]\[2\]
+ sky130_fd_sc_hd__edfxtp_1
Xnetwork.in_period\[79\]\[3\]$_DFFE_PP_ clknet_leaf_14_clk_load
+ net416 _03319_ VSS VSS VDD VDD network.in_period\[79\]\[3\]
+ sky130_fd_sc_hd__edfxtp_1
Xnetwork.in_period\[7\]\[0\]$_DFFE_PP_ clknet_leaf_39_clk_load
+ net440 _03320_ VSS VSS VDD VDD network.in_period\[7\]\[0\]
+ sky130_fd_sc_hd__edfxtp_1
Xnetwork.in_period\[7\]\[1\]$_DFFE_PP_ clknet_leaf_39_clk_load
+ net429 _03320_ VSS VSS VDD VDD network.in_period\[7\]\[1\]
+ sky130_fd_sc_hd__edfxtp_1
Xnetwork.in_period\[7\]\[2\]$_DFFE_PP_ clknet_leaf_39_clk_load
+ net426 _03320_ VSS VSS VDD VDD network.in_period\[7\]\[2\]
+ sky130_fd_sc_hd__edfxtp_1
Xnetwork.in_period\[7\]\[3\]$_DFFE_PP_ clknet_leaf_39_clk_load
+ net414 _03320_ VSS VSS VDD VDD network.in_period\[7\]\[3\]
+ sky130_fd_sc_hd__edfxtp_1
Xnetwork.in_period\[80\]\[0\]$_DFFE_PP_ clknet_leaf_104_clk_load
+ net438 _03321_ VSS VSS VDD VDD network.in_period\[80\]\[0\]
+ sky130_fd_sc_hd__edfxtp_1
Xnetwork.in_period\[80\]\[1\]$_DFFE_PP_ clknet_leaf_104_clk_load
+ net428 _03321_ VSS VSS VDD VDD network.in_period\[80\]\[1\]
+ sky130_fd_sc_hd__edfxtp_1
Xnetwork.in_period\[80\]\[2\]$_DFFE_PP_ clknet_leaf_104_clk_load
+ net425 _03321_ VSS VSS VDD VDD network.in_period\[80\]\[2\]
+ sky130_fd_sc_hd__edfxtp_1
Xnetwork.in_period\[80\]\[3\]$_DFFE_PP_ clknet_leaf_104_clk_load
+ net420 _03321_ VSS VSS VDD VDD network.in_period\[80\]\[3\]
+ sky130_fd_sc_hd__edfxtp_1
Xnetwork.in_period\[81\]\[0\]$_DFFE_PP_ clknet_leaf_2_clk_load
+ net437 _03322_ VSS VSS VDD VDD network.in_period\[81\]\[0\]
+ sky130_fd_sc_hd__edfxtp_1
Xnetwork.in_period\[81\]\[1\]$_DFFE_PP_ clknet_leaf_2_clk_load
+ net434 _03322_ VSS VSS VDD VDD network.in_period\[81\]\[1\]
+ sky130_fd_sc_hd__edfxtp_1
Xnetwork.in_period\[81\]\[2\]$_DFFE_PP_ clknet_leaf_11_clk_load
+ net425 _03322_ VSS VSS VDD VDD network.in_period\[81\]\[2\]
+ sky130_fd_sc_hd__edfxtp_1
Xnetwork.in_period\[81\]\[3\]$_DFFE_PP_ clknet_leaf_11_clk_load
+ net417 _03322_ VSS VSS VDD VDD network.in_period\[81\]\[3\]
+ sky130_fd_sc_hd__edfxtp_1
Xnetwork.in_period\[82\]\[0\]$_DFFE_PP_ clknet_leaf_1_clk_load
+ net438 _03323_ VSS VSS VDD VDD network.in_period\[82\]\[0\]
+ sky130_fd_sc_hd__edfxtp_1
Xnetwork.in_period\[82\]\[1\]$_DFFE_PP_ clknet_leaf_1_clk_load
+ net428 _03323_ VSS VSS VDD VDD network.in_period\[82\]\[1\]
+ sky130_fd_sc_hd__edfxtp_1
Xnetwork.in_period\[82\]\[2\]$_DFFE_PP_ clknet_leaf_1_clk_load
+ net425 _03323_ VSS VSS VDD VDD network.in_period\[82\]\[2\]
+ sky130_fd_sc_hd__edfxtp_1
Xnetwork.in_period\[82\]\[3\]$_DFFE_PP_ clknet_leaf_1_clk_load
+ net453 _03323_ VSS VSS VDD VDD network.in_period\[82\]\[3\]
+ sky130_fd_sc_hd__edfxtp_1
Xnetwork.in_period\[83\]\[0\]$_DFFE_PP_ clknet_leaf_104_clk_load
+ net438 _03324_ VSS VSS VDD VDD network.in_period\[83\]\[0\]
+ sky130_fd_sc_hd__edfxtp_1
Xnetwork.in_period\[83\]\[1\]$_DFFE_PP_ clknet_leaf_104_clk_load
+ net428 _03324_ VSS VSS VDD VDD network.in_period\[83\]\[1\]
+ sky130_fd_sc_hd__edfxtp_1
Xnetwork.in_period\[83\]\[2\]$_DFFE_PP_ clknet_leaf_104_clk_load
+ net425 _03324_ VSS VSS VDD VDD network.in_period\[83\]\[2\]
+ sky130_fd_sc_hd__edfxtp_1
Xnetwork.in_period\[83\]\[3\]$_DFFE_PP_ clknet_leaf_104_clk_load
+ net420 _03324_ VSS VSS VDD VDD network.in_period\[83\]\[3\]
+ sky130_fd_sc_hd__edfxtp_1
Xnetwork.in_period\[84\]\[0\]$_DFFE_PP_ clknet_leaf_106_clk_load
+ net438 _03325_ VSS VSS VDD VDD network.in_period\[84\]\[0\]
+ sky130_fd_sc_hd__edfxtp_1
Xnetwork.in_period\[84\]\[1\]$_DFFE_PP_ clknet_leaf_106_clk_load
+ net428 _03325_ VSS VSS VDD VDD network.in_period\[84\]\[1\]
+ sky130_fd_sc_hd__edfxtp_1
Xnetwork.in_period\[84\]\[2\]$_DFFE_PP_ clknet_leaf_106_clk_load
+ net425 _03325_ VSS VSS VDD VDD network.in_period\[84\]\[2\]
+ sky130_fd_sc_hd__edfxtp_1
Xnetwork.in_period\[84\]\[3\]$_DFFE_PP_ clknet_leaf_106_clk_load
+ net453 _03325_ VSS VSS VDD VDD network.in_period\[84\]\[3\]
+ sky130_fd_sc_hd__edfxtp_1
Xnetwork.in_period\[85\]\[0\]$_DFFE_PP_ clknet_leaf_105_clk_load
+ net438 _03326_ VSS VSS VDD VDD network.in_period\[85\]\[0\]
+ sky130_fd_sc_hd__edfxtp_1
Xnetwork.in_period\[85\]\[1\]$_DFFE_PP_ clknet_leaf_105_clk_load
+ net428 _03326_ VSS VSS VDD VDD network.in_period\[85\]\[1\]
+ sky130_fd_sc_hd__edfxtp_1
Xnetwork.in_period\[85\]\[2\]$_DFFE_PP_ clknet_leaf_105_clk_load
+ net425 _03326_ VSS VSS VDD VDD network.in_period\[85\]\[2\]
+ sky130_fd_sc_hd__edfxtp_1
Xnetwork.in_period\[85\]\[3\]$_DFFE_PP_ clknet_leaf_105_clk_load
+ net420 _03326_ VSS VSS VDD VDD network.in_period\[85\]\[3\]
+ sky130_fd_sc_hd__edfxtp_1
Xnetwork.in_period\[86\]\[0\]$_DFFE_PP_ clknet_leaf_104_clk_load
+ net438 _03327_ VSS VSS VDD VDD network.in_period\[86\]\[0\]
+ sky130_fd_sc_hd__edfxtp_1
Xnetwork.in_period\[86\]\[1\]$_DFFE_PP_ clknet_leaf_104_clk_load
+ net428 _03327_ VSS VSS VDD VDD network.in_period\[86\]\[1\]
+ sky130_fd_sc_hd__edfxtp_1
Xnetwork.in_period\[86\]\[2\]$_DFFE_PP_ clknet_leaf_104_clk_load
+ net425 _03327_ VSS VSS VDD VDD network.in_period\[86\]\[2\]
+ sky130_fd_sc_hd__edfxtp_1
Xnetwork.in_period\[86\]\[3\]$_DFFE_PP_ clknet_leaf_104_clk_load
+ net420 _03327_ VSS VSS VDD VDD network.in_period\[86\]\[3\]
+ sky130_fd_sc_hd__edfxtp_1
Xnetwork.in_period\[87\]\[0\]$_DFFE_PP_ clknet_leaf_108_clk_load
+ net438 _03328_ VSS VSS VDD VDD network.in_period\[87\]\[0\]
+ sky130_fd_sc_hd__edfxtp_1
Xnetwork.in_period\[87\]\[1\]$_DFFE_PP_ clknet_leaf_109_clk_load
+ net428 _03328_ VSS VSS VDD VDD network.in_period\[87\]\[1\]
+ sky130_fd_sc_hd__edfxtp_1
Xnetwork.in_period\[87\]\[2\]$_DFFE_PP_ clknet_leaf_109_clk_load
+ net425 _03328_ VSS VSS VDD VDD network.in_period\[87\]\[2\]
+ sky130_fd_sc_hd__edfxtp_1
Xnetwork.in_period\[87\]\[3\]$_DFFE_PP_ clknet_leaf_109_clk_load
+ net453 _03328_ VSS VSS VDD VDD network.in_period\[87\]\[3\]
+ sky130_fd_sc_hd__edfxtp_1
Xnetwork.in_period\[88\]\[0\]$_DFFE_PP_ clknet_leaf_108_clk_load
+ net438 _03329_ VSS VSS VDD VDD network.in_period\[88\]\[0\]
+ sky130_fd_sc_hd__edfxtp_1
Xnetwork.in_period\[88\]\[1\]$_DFFE_PP_ clknet_leaf_108_clk_load
+ net428 _03329_ VSS VSS VDD VDD network.in_period\[88\]\[1\]
+ sky130_fd_sc_hd__edfxtp_1
Xnetwork.in_period\[88\]\[2\]$_DFFE_PP_ clknet_leaf_108_clk_load
+ net425 _03329_ VSS VSS VDD VDD network.in_period\[88\]\[2\]
+ sky130_fd_sc_hd__edfxtp_1
Xnetwork.in_period\[88\]\[3\]$_DFFE_PP_ clknet_leaf_108_clk_load
+ net420 _03329_ VSS VSS VDD VDD network.in_period\[88\]\[3\]
+ sky130_fd_sc_hd__edfxtp_1
Xnetwork.in_period\[89\]\[0\]$_DFFE_PP_ clknet_leaf_108_clk_load
+ net438 _03330_ VSS VSS VDD VDD network.in_period\[89\]\[0\]
+ sky130_fd_sc_hd__edfxtp_1
Xnetwork.in_period\[89\]\[1\]$_DFFE_PP_ clknet_leaf_109_clk_load
+ net428 _03330_ VSS VSS VDD VDD network.in_period\[89\]\[1\]
+ sky130_fd_sc_hd__edfxtp_1
Xnetwork.in_period\[89\]\[2\]$_DFFE_PP_ clknet_leaf_109_clk_load
+ net425 _03330_ VSS VSS VDD VDD network.in_period\[89\]\[2\]
+ sky130_fd_sc_hd__edfxtp_1
Xnetwork.in_period\[89\]\[3\]$_DFFE_PP_ clknet_leaf_109_clk_load
+ net415 _03330_ VSS VSS VDD VDD network.in_period\[89\]\[3\]
+ sky130_fd_sc_hd__edfxtp_1
Xnetwork.in_period\[8\]\[0\]$_DFFE_PP_ clknet_leaf_44_clk_load
+ net439 _03331_ VSS VSS VDD VDD network.in_period\[8\]\[0\]
+ sky130_fd_sc_hd__edfxtp_1
Xnetwork.in_period\[8\]\[1\]$_DFFE_PP_ clknet_leaf_44_clk_load
+ net430 _03331_ VSS VSS VDD VDD network.in_period\[8\]\[1\]
+ sky130_fd_sc_hd__edfxtp_1
Xnetwork.in_period\[8\]\[2\]$_DFFE_PP_ clknet_leaf_38_clk_load
+ net425 _03331_ VSS VSS VDD VDD network.in_period\[8\]\[2\]
+ sky130_fd_sc_hd__edfxtp_1
Xnetwork.in_period\[8\]\[3\]$_DFFE_PP_ clknet_leaf_44_clk_load
+ net415 _03331_ VSS VSS VDD VDD network.in_period\[8\]\[3\]
+ sky130_fd_sc_hd__edfxtp_1
Xnetwork.in_period\[90\]\[0\]$_DFFE_PP_ clknet_leaf_109_clk_load
+ net438 _03332_ VSS VSS VDD VDD network.in_period\[90\]\[0\]
+ sky130_fd_sc_hd__edfxtp_1
Xnetwork.in_period\[90\]\[1\]$_DFFE_PP_ clknet_leaf_109_clk_load
+ net428 _03332_ VSS VSS VDD VDD network.in_period\[90\]\[1\]
+ sky130_fd_sc_hd__edfxtp_1
Xnetwork.in_period\[90\]\[2\]$_DFFE_PP_ clknet_leaf_0_clk_load
+ net425 _03332_ VSS VSS VDD VDD network.in_period\[90\]\[2\]
+ sky130_fd_sc_hd__edfxtp_1
Xnetwork.in_period\[90\]\[3\]$_DFFE_PP_ clknet_leaf_109_clk_load
+ net415 _03332_ VSS VSS VDD VDD network.in_period\[90\]\[3\]
+ sky130_fd_sc_hd__edfxtp_1
Xnetwork.in_period\[91\]\[0\]$_DFFE_PP_ clknet_leaf_107_clk_load
+ net438 _03333_ VSS VSS VDD VDD network.in_period\[91\]\[0\]
+ sky130_fd_sc_hd__edfxtp_1
Xnetwork.in_period\[91\]\[1\]$_DFFE_PP_ clknet_leaf_107_clk_load
+ net428 _03333_ VSS VSS VDD VDD network.in_period\[91\]\[1\]
+ sky130_fd_sc_hd__edfxtp_1
Xnetwork.in_period\[91\]\[2\]$_DFFE_PP_ clknet_leaf_107_clk_load
+ net425 _03333_ VSS VSS VDD VDD network.in_period\[91\]\[2\]
+ sky130_fd_sc_hd__edfxtp_1
Xnetwork.in_period\[91\]\[3\]$_DFFE_PP_ clknet_leaf_107_clk_load
+ net420 _03333_ VSS VSS VDD VDD network.in_period\[91\]\[3\]
+ sky130_fd_sc_hd__edfxtp_1
Xnetwork.in_period\[92\]\[0\]$_DFFE_PP_ clknet_leaf_107_clk_load
+ net438 _03334_ VSS VSS VDD VDD network.in_period\[92\]\[0\]
+ sky130_fd_sc_hd__edfxtp_1
Xnetwork.in_period\[92\]\[1\]$_DFFE_PP_ clknet_leaf_108_clk_load
+ net428 _03334_ VSS VSS VDD VDD network.in_period\[92\]\[1\]
+ sky130_fd_sc_hd__edfxtp_1
Xnetwork.in_period\[92\]\[2\]$_DFFE_PP_ clknet_leaf_107_clk_load
+ net425 _03334_ VSS VSS VDD VDD network.in_period\[92\]\[2\]
+ sky130_fd_sc_hd__edfxtp_1
Xnetwork.in_period\[92\]\[3\]$_DFFE_PP_ clknet_leaf_108_clk_load
+ net420 _03334_ VSS VSS VDD VDD network.in_period\[92\]\[3\]
+ sky130_fd_sc_hd__edfxtp_1
Xnetwork.in_period\[93\]\[0\]$_DFFE_PP_ clknet_leaf_106_clk_load
+ net438 _03335_ VSS VSS VDD VDD network.in_period\[93\]\[0\]
+ sky130_fd_sc_hd__edfxtp_1
Xnetwork.in_period\[93\]\[1\]$_DFFE_PP_ clknet_leaf_106_clk_load
+ net428 _03335_ VSS VSS VDD VDD network.in_period\[93\]\[1\]
+ sky130_fd_sc_hd__edfxtp_1
Xnetwork.in_period\[93\]\[2\]$_DFFE_PP_ clknet_leaf_106_clk_load
+ net425 _03335_ VSS VSS VDD VDD network.in_period\[93\]\[2\]
+ sky130_fd_sc_hd__edfxtp_1
Xnetwork.in_period\[93\]\[3\]$_DFFE_PP_ clknet_leaf_106_clk_load
+ net420 _03335_ VSS VSS VDD VDD network.in_period\[93\]\[3\]
+ sky130_fd_sc_hd__edfxtp_1
Xnetwork.in_period\[94\]\[0\]$_DFFE_PP_ clknet_leaf_105_clk_load
+ net438 _03336_ VSS VSS VDD VDD network.in_period\[94\]\[0\]
+ sky130_fd_sc_hd__edfxtp_1
Xnetwork.in_period\[94\]\[1\]$_DFFE_PP_ clknet_leaf_105_clk_load
+ net428 _03336_ VSS VSS VDD VDD network.in_period\[94\]\[1\]
+ sky130_fd_sc_hd__edfxtp_1
Xnetwork.in_period\[94\]\[2\]$_DFFE_PP_ clknet_leaf_105_clk_load
+ net425 _03336_ VSS VSS VDD VDD network.in_period\[94\]\[2\]
+ sky130_fd_sc_hd__edfxtp_1
Xnetwork.in_period\[94\]\[3\]$_DFFE_PP_ clknet_leaf_105_clk_load
+ net420 _03336_ VSS VSS VDD VDD network.in_period\[94\]\[3\]
+ sky130_fd_sc_hd__edfxtp_1
Xnetwork.in_period\[95\]\[0\]$_DFFE_PP_ clknet_leaf_107_clk_load
+ net438 _03337_ VSS VSS VDD VDD network.in_period\[95\]\[0\]
+ sky130_fd_sc_hd__edfxtp_1
Xnetwork.in_period\[95\]\[1\]$_DFFE_PP_ clknet_leaf_107_clk_load
+ net428 _03337_ VSS VSS VDD VDD network.in_period\[95\]\[1\]
+ sky130_fd_sc_hd__edfxtp_1
Xnetwork.in_period\[95\]\[2\]$_DFFE_PP_ clknet_leaf_107_clk_load
+ net425 _03337_ VSS VSS VDD VDD network.in_period\[95\]\[2\]
+ sky130_fd_sc_hd__edfxtp_1
Xnetwork.in_period\[95\]\[3\]$_DFFE_PP_ clknet_leaf_107_clk_load
+ net420 _03337_ VSS VSS VDD VDD network.in_period\[95\]\[3\]
+ sky130_fd_sc_hd__edfxtp_1
Xnetwork.in_period\[96\]\[0\]$_DFFE_PP_ clknet_leaf_26_clk_load
+ net440 _03338_ VSS VSS VDD VDD network.in_period\[96\]\[0\]
+ sky130_fd_sc_hd__edfxtp_1
Xnetwork.in_period\[96\]\[1\]$_DFFE_PP_ clknet_leaf_25_clk_load
+ net429 _03338_ VSS VSS VDD VDD network.in_period\[96\]\[1\]
+ sky130_fd_sc_hd__edfxtp_1
Xnetwork.in_period\[96\]\[2\]$_DFFE_PP_ clknet_leaf_26_clk_load
+ net426 _03338_ VSS VSS VDD VDD network.in_period\[96\]\[2\]
+ sky130_fd_sc_hd__edfxtp_1
Xnetwork.in_period\[96\]\[3\]$_DFFE_PP_ clknet_leaf_26_clk_load
+ net414 _03338_ VSS VSS VDD VDD network.in_period\[96\]\[3\]
+ sky130_fd_sc_hd__edfxtp_1
Xnetwork.in_period\[97\]\[0\]$_DFFE_PP_ clknet_leaf_25_clk_load
+ net440 _03339_ VSS VSS VDD VDD network.in_period\[97\]\[0\]
+ sky130_fd_sc_hd__edfxtp_1
Xnetwork.in_period\[97\]\[1\]$_DFFE_PP_ clknet_leaf_25_clk_load
+ net429 _03339_ VSS VSS VDD VDD network.in_period\[97\]\[1\]
+ sky130_fd_sc_hd__edfxtp_1
Xnetwork.in_period\[97\]\[2\]$_DFFE_PP_ clknet_leaf_27_clk_load
+ net427 _03339_ VSS VSS VDD VDD network.in_period\[97\]\[2\]
+ sky130_fd_sc_hd__edfxtp_1
Xnetwork.in_period\[97\]\[3\]$_DFFE_PP_ clknet_leaf_25_clk_load
+ net414 _03339_ VSS VSS VDD VDD network.in_period\[97\]\[3\]
+ sky130_fd_sc_hd__edfxtp_1
Xnetwork.in_period\[98\]\[0\]$_DFFE_PP_ clknet_leaf_26_clk_load
+ net440 _03340_ VSS VSS VDD VDD network.in_period\[98\]\[0\]
+ sky130_fd_sc_hd__edfxtp_1
Xnetwork.in_period\[98\]\[1\]$_DFFE_PP_ clknet_leaf_26_clk_load
+ net429 _03340_ VSS VSS VDD VDD network.in_period\[98\]\[1\]
+ sky130_fd_sc_hd__edfxtp_1
Xnetwork.in_period\[98\]\[2\]$_DFFE_PP_ clknet_leaf_26_clk_load
+ net426 _03340_ VSS VSS VDD VDD network.in_period\[98\]\[2\]
+ sky130_fd_sc_hd__edfxtp_1
Xnetwork.in_period\[98\]\[3\]$_DFFE_PP_ clknet_leaf_26_clk_load
+ net414 _03340_ VSS VSS VDD VDD network.in_period\[98\]\[3\]
+ sky130_fd_sc_hd__edfxtp_1
Xnetwork.in_period\[99\]\[0\]$_DFFE_PP_ clknet_leaf_26_clk_load
+ net440 _03341_ VSS VSS VDD VDD network.in_period\[99\]\[0\]
+ sky130_fd_sc_hd__edfxtp_1
Xnetwork.in_period\[99\]\[1\]$_DFFE_PP_ clknet_leaf_26_clk_load
+ net429 _03341_ VSS VSS VDD VDD network.in_period\[99\]\[1\]
+ sky130_fd_sc_hd__edfxtp_1
Xnetwork.in_period\[99\]\[2\]$_DFFE_PP_ clknet_leaf_26_clk_load
+ net426 _03341_ VSS VSS VDD VDD network.in_period\[99\]\[2\]
+ sky130_fd_sc_hd__edfxtp_1
Xnetwork.in_period\[99\]\[3\]$_DFFE_PP_ clknet_leaf_26_clk_load
+ net414 _03341_ VSS VSS VDD VDD network.in_period\[99\]\[3\]
+ sky130_fd_sc_hd__edfxtp_1
Xnetwork.in_period\[9\]\[0\]$_DFFE_PP_ clknet_leaf_37_clk_load
+ net440 _03342_ VSS VSS VDD VDD network.in_period\[9\]\[0\]
+ sky130_fd_sc_hd__edfxtp_1
Xnetwork.in_period\[9\]\[1\]$_DFFE_PP_ clknet_leaf_37_clk_load
+ net429 _03342_ VSS VSS VDD VDD network.in_period\[9\]\[1\]
+ sky130_fd_sc_hd__edfxtp_1
Xnetwork.in_period\[9\]\[2\]$_DFFE_PP_ clknet_leaf_37_clk_load
+ net427 _03342_ VSS VSS VDD VDD network.in_period\[9\]\[2\]
+ sky130_fd_sc_hd__edfxtp_1
Xnetwork.in_period\[9\]\[3\]$_DFFE_PP_ clknet_leaf_37_clk_load
+ net414 _03342_ VSS VSS VDD VDD network.in_period\[9\]\[3\]
+ sky130_fd_sc_hd__edfxtp_1
Xnetwork.neuron_hid0.IF0.membrane_potential\[0\]$_SDFF_PP0_
+ clknet_leaf_69_clk_net _01721_ VSS VSS VDD VDD network.neuron_hid0.IF0.membrane_potential\[0\]
+ sky130_fd_sc_hd__dfxtp_1
Xnetwork.neuron_hid0.IF0.membrane_potential\[10\]$_SDFF_PP0_
+ clknet_leaf_71_clk_net _01906_ VSS VSS VDD VDD network.neuron_hid0.IF0.membrane_potential\[10\]
+ sky130_fd_sc_hd__dfxtp_1
Xnetwork.neuron_hid0.IF0.membrane_potential\[1\]$_SDFF_PP0_
+ clknet_leaf_72_clk_net _01720_ VSS VSS VDD VDD network.neuron_hid0.IF0.membrane_potential\[1\]
+ sky130_fd_sc_hd__dfxtp_1
Xnetwork.neuron_hid0.IF0.membrane_potential\[2\]$_SDFF_PP0_
+ clknet_leaf_71_clk_net _01719_ VSS VSS VDD VDD network.neuron_hid0.IF0.membrane_potential\[2\]
+ sky130_fd_sc_hd__dfxtp_1
Xnetwork.neuron_hid0.IF0.membrane_potential\[3\]$_SDFF_PP0_
+ clknet_leaf_71_clk_net _01718_ VSS VSS VDD VDD network.neuron_hid0.IF0.membrane_potential\[3\]
+ sky130_fd_sc_hd__dfxtp_1
Xnetwork.neuron_hid0.IF0.membrane_potential\[4\]$_SDFF_PP0_
+ clknet_leaf_71_clk_net _01717_ VSS VSS VDD VDD network.neuron_hid0.IF0.membrane_potential\[4\]
+ sky130_fd_sc_hd__dfxtp_1
Xnetwork.neuron_hid0.IF0.membrane_potential\[5\]$_SDFF_PP0_
+ clknet_leaf_71_clk_net _01716_ VSS VSS VDD VDD network.neuron_hid0.IF0.membrane_potential\[5\]
+ sky130_fd_sc_hd__dfxtp_1
Xnetwork.neuron_hid0.IF0.membrane_potential\[6\]$_SDFF_PP0_
+ clknet_leaf_70_clk_net _01715_ VSS VSS VDD VDD network.neuron_hid0.IF0.membrane_potential\[6\]
+ sky130_fd_sc_hd__dfxtp_1
Xnetwork.neuron_hid0.IF0.membrane_potential\[7\]$_SDFF_PP0_
+ clknet_leaf_71_clk_net _01714_ VSS VSS VDD VDD network.neuron_hid0.IF0.membrane_potential\[7\]
+ sky130_fd_sc_hd__dfxtp_1
Xnetwork.neuron_hid0.IF0.membrane_potential\[8\]$_SDFF_PP0_
+ clknet_leaf_71_clk_net _01713_ VSS VSS VDD VDD network.neuron_hid0.IF0.membrane_potential\[8\]
+ sky130_fd_sc_hd__dfxtp_1
Xnetwork.neuron_hid0.IF0.membrane_potential\[9\]$_SDFF_PP0_
+ clknet_leaf_71_clk_net _01712_ VSS VSS VDD VDD network.neuron_hid0.IF0.membrane_potential\[9\]
+ sky130_fd_sc_hd__dfxtp_1
Xnetwork.neuron_hid0.IF0.ref_counter\[0\]$_SDFFE_PP0P_ clknet_leaf_71_clk_net
+ _01711_ VSS VSS VDD VDD network.neuron_hid0.IF0.ref_counter\[0\]
+ sky130_fd_sc_hd__dfxtp_1
Xnetwork.neuron_hid0.IF0.ref_counter\[1\]$_SDFFE_PP0P_ clknet_leaf_71_clk_net
+ _01904_ VSS VSS VDD VDD network.neuron_hid0.IF0.ref_counter\[1\]
+ sky130_fd_sc_hd__dfxtp_1
Xnetwork.neuron_hid0.IF_in\[0\]$_SDFF_PP0_ clknet_leaf_70_clk_net
+ _01548_ VSS VSS VDD VDD network.neuron_hid0.IF0.input_current\[0\]
+ sky130_fd_sc_hd__dfxtp_1
Xnetwork.neuron_hid0.IF_in\[1\]$_SDFF_PP0_ clknet_leaf_70_clk_net
+ _01542_ VSS VSS VDD VDD network.neuron_hid0.IF0.input_current\[1\]
+ sky130_fd_sc_hd__dfxtp_1
Xnetwork.neuron_hid0.IF_in\[2\]$_SDFF_PP0_ clknet_leaf_70_clk_net
+ _01541_ VSS VSS VDD VDD network.neuron_hid0.IF0.input_current\[2\]
+ sky130_fd_sc_hd__dfxtp_1
Xnetwork.neuron_hid0.IF_in\[3\]$_SDFF_PP0_ clknet_leaf_70_clk_net
+ _01540_ VSS VSS VDD VDD network.neuron_hid0.IF0.input_current\[3\]
+ sky130_fd_sc_hd__dfxtp_1
Xnetwork.neuron_hid0.IF_in\[4\]$_SDFF_PP0_ clknet_leaf_70_clk_net
+ _01767_ VSS VSS VDD VDD network.neuron_hid0.IF0.input_current\[4\]
+ sky130_fd_sc_hd__dfxtp_1
Xnetwork.neuron_hid0.ROM_address\[0\]$_SDFF_PP0_ clknet_leaf_67_clk_net
+ _01710_ VSS VSS VDD VDD network.neuron_hid0.ROM0.address\[0\]
+ sky130_fd_sc_hd__dfxtp_2
Xnetwork.neuron_hid0.ROM_address\[1\]$_SDFF_PP0_ clknet_leaf_67_clk_net
+ _01709_ VSS VSS VDD VDD network.neuron_hid0.ROM0.address\[1\]
+ sky130_fd_sc_hd__dfxtp_1
Xnetwork.neuron_hid0.ROM_address\[2\]$_SDFF_PP0_ clknet_leaf_97_clk_net
+ _01708_ VSS VSS VDD VDD network.neuron_hid0.ROM0.address\[2\]
+ sky130_fd_sc_hd__dfxtp_1
Xnetwork.neuron_hid0.ROM_address\[3\]$_SDFF_PP0_ clknet_leaf_97_clk_net
+ _01707_ VSS VSS VDD VDD network.neuron_hid0.ROM0.address\[3\]
+ sky130_fd_sc_hd__dfxtp_1
Xnetwork.neuron_hid0.ROM_address\[4\]$_SDFF_PP0_ clknet_leaf_67_clk_net
+ _01706_ VSS VSS VDD VDD network.neuron_hid0.ROM0.address\[4\]
+ sky130_fd_sc_hd__dfxtp_1
Xnetwork.neuron_hid0.ROM_address\[5\]$_SDFF_PP0_ clknet_leaf_67_clk_net
+ _01705_ VSS VSS VDD VDD network.neuron_hid0.ROM0.address\[5\]
+ sky130_fd_sc_hd__dfxtp_1
Xnetwork.neuron_hid0.ROM_address\[6\]$_SDFF_PP0_ clknet_leaf_97_clk_net
+ _01704_ VSS VSS VDD VDD network.neuron_hid0.ROM0.address\[6\]
+ sky130_fd_sc_hd__dfxtp_1
Xnetwork.neuron_hid0.ROM_address\[7\]$_SDFF_PP0_ clknet_leaf_97_clk_net
+ _01909_ VSS VSS VDD VDD network.neuron_hid0.ROM0.address\[7\]
+ sky130_fd_sc_hd__dfxtp_1
Xnetwork.neuron_hid0.enable$_SDFF_PP0_ clknet_leaf_97_clk_net
+ _01911_ VSS VSS VDD VDD network.neuron_hid0.ROM0.read_en sky130_fd_sc_hd__dfxtp_1
Xnetwork.neuron_hid0.spike_out$_SDFFE_PP0P_ clknet_leaf_81_clk_net
+ _01908_ VSS VSS VDD VDD network.hid_spk0 sky130_fd_sc_hd__dfxtp_1
Xnetwork.neuron_hid1.IF0.membrane_potential\[0\]$_SDFF_PP0_
+ clknet_leaf_74_clk_net _01703_ VSS VSS VDD VDD network.neuron_hid1.IF0.membrane_potential\[0\]
+ sky130_fd_sc_hd__dfxtp_1
Xnetwork.neuron_hid1.IF0.membrane_potential\[10\]$_SDFF_PP0_
+ clknet_leaf_74_clk_net _01913_ VSS VSS VDD VDD network.neuron_hid1.IF0.membrane_potential\[10\]
+ sky130_fd_sc_hd__dfxtp_1
Xnetwork.neuron_hid1.IF0.membrane_potential\[1\]$_SDFF_PP0_
+ clknet_leaf_73_clk_net _01702_ VSS VSS VDD VDD network.neuron_hid1.IF0.membrane_potential\[1\]
+ sky130_fd_sc_hd__dfxtp_1
Xnetwork.neuron_hid1.IF0.membrane_potential\[2\]$_SDFF_PP0_
+ clknet_leaf_72_clk_net _01701_ VSS VSS VDD VDD network.neuron_hid1.IF0.membrane_potential\[2\]
+ sky130_fd_sc_hd__dfxtp_1
Xnetwork.neuron_hid1.IF0.membrane_potential\[3\]$_SDFF_PP0_
+ clknet_leaf_72_clk_net _01700_ VSS VSS VDD VDD network.neuron_hid1.IF0.membrane_potential\[3\]
+ sky130_fd_sc_hd__dfxtp_1
Xnetwork.neuron_hid1.IF0.membrane_potential\[4\]$_SDFF_PP0_
+ clknet_leaf_72_clk_net _01699_ VSS VSS VDD VDD network.neuron_hid1.IF0.membrane_potential\[4\]
+ sky130_fd_sc_hd__dfxtp_1
Xnetwork.neuron_hid1.IF0.membrane_potential\[5\]$_SDFF_PP0_
+ clknet_leaf_72_clk_net _01698_ VSS VSS VDD VDD network.neuron_hid1.IF0.membrane_potential\[5\]
+ sky130_fd_sc_hd__dfxtp_1
Xnetwork.neuron_hid1.IF0.membrane_potential\[6\]$_SDFF_PP0_
+ clknet_leaf_72_clk_net _01697_ VSS VSS VDD VDD network.neuron_hid1.IF0.membrane_potential\[6\]
+ sky130_fd_sc_hd__dfxtp_1
Xnetwork.neuron_hid1.IF0.membrane_potential\[7\]$_SDFF_PP0_
+ clknet_leaf_74_clk_net _01696_ VSS VSS VDD VDD network.neuron_hid1.IF0.membrane_potential\[7\]
+ sky130_fd_sc_hd__dfxtp_1
Xnetwork.neuron_hid1.IF0.membrane_potential\[8\]$_SDFF_PP0_
+ clknet_leaf_74_clk_net _01695_ VSS VSS VDD VDD network.neuron_hid1.IF0.membrane_potential\[8\]
+ sky130_fd_sc_hd__dfxtp_1
Xnetwork.neuron_hid1.IF0.membrane_potential\[9\]$_SDFF_PP0_
+ clknet_leaf_74_clk_net _01694_ VSS VSS VDD VDD network.neuron_hid1.IF0.membrane_potential\[9\]
+ sky130_fd_sc_hd__dfxtp_1
Xnetwork.neuron_hid1.IF0.ref_counter\[0\]$_SDFFE_PP0P_ clknet_leaf_74_clk_net
+ _01693_ VSS VSS VDD VDD network.neuron_hid1.IF0.ref_counter\[0\]
+ sky130_fd_sc_hd__dfxtp_1
Xnetwork.neuron_hid1.IF0.ref_counter\[1\]$_SDFFE_PP0P_ clknet_leaf_74_clk_net
+ _01912_ VSS VSS VDD VDD network.neuron_hid1.IF0.ref_counter\[1\]
+ sky130_fd_sc_hd__dfxtp_1
Xnetwork.neuron_hid1.IF_in\[0\]$_SDFF_PP0_ clknet_leaf_72_clk_net
+ _01506_ VSS VSS VDD VDD network.neuron_hid1.IF0.input_current\[0\]
+ sky130_fd_sc_hd__dfxtp_1
Xnetwork.neuron_hid1.IF_in\[1\]$_SDFF_PP0_ clknet_leaf_72_clk_net
+ _01508_ VSS VSS VDD VDD network.neuron_hid1.IF0.input_current\[1\]
+ sky130_fd_sc_hd__dfxtp_1
Xnetwork.neuron_hid1.IF_in\[2\]$_SDFF_PP0_ clknet_leaf_72_clk_net
+ _01507_ VSS VSS VDD VDD network.neuron_hid1.IF0.input_current\[2\]
+ sky130_fd_sc_hd__dfxtp_1
Xnetwork.neuron_hid1.IF_in\[3\]$_SDFF_PP0_ clknet_leaf_71_clk_net
+ _01505_ VSS VSS VDD VDD network.neuron_hid1.IF0.input_current\[3\]
+ sky130_fd_sc_hd__dfxtp_1
Xnetwork.neuron_hid1.IF_in\[4\]$_SDFF_PP0_ clknet_leaf_71_clk_net
+ _01764_ VSS VSS VDD VDD network.neuron_hid1.IF0.input_current\[4\]
+ sky130_fd_sc_hd__dfxtp_1
Xnetwork.neuron_hid1.spike_out$_SDFFE_PP0P_ clknet_leaf_80_clk_net
+ _01915_ VSS VSS VDD VDD network.hid_spk1 sky130_fd_sc_hd__dfxtp_1
Xnetwork.neuron_hid2.IF0.membrane_potential\[0\]$_SDFF_PP0_
+ clknet_leaf_82_clk_net _01692_ VSS VSS VDD VDD network.neuron_hid2.IF0.membrane_potential\[0\]
+ sky130_fd_sc_hd__dfxtp_1
Xnetwork.neuron_hid2.IF0.membrane_potential\[10\]$_SDFF_PP0_
+ clknet_leaf_79_clk_net _01917_ VSS VSS VDD VDD network.neuron_hid2.IF0.membrane_potential\[10\]
+ sky130_fd_sc_hd__dfxtp_1
Xnetwork.neuron_hid2.IF0.membrane_potential\[1\]$_SDFF_PP0_
+ clknet_leaf_82_clk_net _01691_ VSS VSS VDD VDD network.neuron_hid2.IF0.membrane_potential\[1\]
+ sky130_fd_sc_hd__dfxtp_1
Xnetwork.neuron_hid2.IF0.membrane_potential\[2\]$_SDFF_PP0_
+ clknet_leaf_83_clk_net _01690_ VSS VSS VDD VDD network.neuron_hid2.IF0.membrane_potential\[2\]
+ sky130_fd_sc_hd__dfxtp_1
Xnetwork.neuron_hid2.IF0.membrane_potential\[3\]$_SDFF_PP0_
+ clknet_leaf_83_clk_net _01689_ VSS VSS VDD VDD network.neuron_hid2.IF0.membrane_potential\[3\]
+ sky130_fd_sc_hd__dfxtp_1
Xnetwork.neuron_hid2.IF0.membrane_potential\[4\]$_SDFF_PP0_
+ clknet_leaf_83_clk_net _01688_ VSS VSS VDD VDD network.neuron_hid2.IF0.membrane_potential\[4\]
+ sky130_fd_sc_hd__dfxtp_1
Xnetwork.neuron_hid2.IF0.membrane_potential\[5\]$_SDFF_PP0_
+ clknet_leaf_81_clk_net _01687_ VSS VSS VDD VDD network.neuron_hid2.IF0.membrane_potential\[5\]
+ sky130_fd_sc_hd__dfxtp_1
Xnetwork.neuron_hid2.IF0.membrane_potential\[6\]$_SDFF_PP0_
+ clknet_leaf_83_clk_net _01686_ VSS VSS VDD VDD network.neuron_hid2.IF0.membrane_potential\[6\]
+ sky130_fd_sc_hd__dfxtp_1
Xnetwork.neuron_hid2.IF0.membrane_potential\[7\]$_SDFF_PP0_
+ clknet_leaf_83_clk_net _01685_ VSS VSS VDD VDD network.neuron_hid2.IF0.membrane_potential\[7\]
+ sky130_fd_sc_hd__dfxtp_1
Xnetwork.neuron_hid2.IF0.membrane_potential\[8\]$_SDFF_PP0_
+ clknet_leaf_79_clk_net _01684_ VSS VSS VDD VDD network.neuron_hid2.IF0.membrane_potential\[8\]
+ sky130_fd_sc_hd__dfxtp_1
Xnetwork.neuron_hid2.IF0.membrane_potential\[9\]$_SDFF_PP0_
+ clknet_leaf_79_clk_net _01683_ VSS VSS VDD VDD network.neuron_hid2.IF0.membrane_potential\[9\]
+ sky130_fd_sc_hd__dfxtp_1
Xnetwork.neuron_hid2.IF0.ref_counter\[0\]$_SDFFE_PP0P_ clknet_leaf_83_clk_net
+ _01682_ VSS VSS VDD VDD network.neuron_hid2.IF0.ref_counter\[0\]
+ sky130_fd_sc_hd__dfxtp_1
Xnetwork.neuron_hid2.IF0.ref_counter\[1\]$_SDFFE_PP0P_ clknet_leaf_83_clk_net
+ _01916_ VSS VSS VDD VDD network.neuron_hid2.IF0.ref_counter\[1\]
+ sky130_fd_sc_hd__dfxtp_1
Xnetwork.neuron_hid2.IF_in\[0\]$_SDFF_PP0_ clknet_leaf_82_clk_net
+ _01749_ VSS VSS VDD VDD network.neuron_hid2.IF0.input_current\[0\]
+ sky130_fd_sc_hd__dfxtp_1
Xnetwork.neuron_hid2.IF_in\[1\]$_SDFF_PP0_ clknet_leaf_82_clk_net
+ _01748_ VSS VSS VDD VDD network.neuron_hid2.IF0.input_current\[1\]
+ sky130_fd_sc_hd__dfxtp_1
Xnetwork.neuron_hid2.IF_in\[2\]$_SDFF_PP0_ clknet_leaf_82_clk_net
+ _01747_ VSS VSS VDD VDD network.neuron_hid2.IF0.input_current\[2\]
+ sky130_fd_sc_hd__dfxtp_1
Xnetwork.neuron_hid2.IF_in\[3\]$_SDFF_PP0_ clknet_leaf_96_clk_net
+ _01746_ VSS VSS VDD VDD network.neuron_hid2.IF0.input_current\[3\]
+ sky130_fd_sc_hd__dfxtp_1
Xnetwork.neuron_hid2.IF_in\[4\]$_SDFF_PP0_ clknet_leaf_68_clk_net
+ _01759_ VSS VSS VDD VDD network.neuron_hid2.IF0.input_current\[4\]
+ sky130_fd_sc_hd__dfxtp_1
Xnetwork.neuron_hid2.spike_out$_SDFFE_PP0P_ clknet_leaf_81_clk_net
+ _01920_ VSS VSS VDD VDD network.hid_spk2 sky130_fd_sc_hd__dfxtp_1
Xnetwork.neuron_hid3.IF0.membrane_potential\[0\]$_SDFF_PP0_
+ clknet_leaf_68_clk_net _01681_ VSS VSS VDD VDD network.neuron_hid3.IF0.membrane_potential\[0\]
+ sky130_fd_sc_hd__dfxtp_1
Xnetwork.neuron_hid3.IF0.membrane_potential\[10\]$_SDFF_PP0_
+ clknet_leaf_69_clk_net _01918_ VSS VSS VDD VDD network.neuron_hid3.IF0.membrane_potential\[10\]
+ sky130_fd_sc_hd__dfxtp_1
Xnetwork.neuron_hid3.IF0.membrane_potential\[1\]$_SDFF_PP0_
+ clknet_leaf_68_clk_net _01680_ VSS VSS VDD VDD network.neuron_hid3.IF0.membrane_potential\[1\]
+ sky130_fd_sc_hd__dfxtp_1
Xnetwork.neuron_hid3.IF0.membrane_potential\[2\]$_SDFF_PP0_
+ clknet_leaf_82_clk_net _01679_ VSS VSS VDD VDD network.neuron_hid3.IF0.membrane_potential\[2\]
+ sky130_fd_sc_hd__dfxtp_1
Xnetwork.neuron_hid3.IF0.membrane_potential\[3\]$_SDFF_PP0_
+ clknet_leaf_82_clk_net _01678_ VSS VSS VDD VDD network.neuron_hid3.IF0.membrane_potential\[3\]
+ sky130_fd_sc_hd__dfxtp_1
Xnetwork.neuron_hid3.IF0.membrane_potential\[4\]$_SDFF_PP0_
+ clknet_leaf_82_clk_net _01677_ VSS VSS VDD VDD network.neuron_hid3.IF0.membrane_potential\[4\]
+ sky130_fd_sc_hd__dfxtp_1
Xnetwork.neuron_hid3.IF0.membrane_potential\[5\]$_SDFF_PP0_
+ clknet_leaf_81_clk_net _01676_ VSS VSS VDD VDD network.neuron_hid3.IF0.membrane_potential\[5\]
+ sky130_fd_sc_hd__dfxtp_1
Xnetwork.neuron_hid3.IF0.membrane_potential\[6\]$_SDFF_PP0_
+ clknet_leaf_81_clk_net _01675_ VSS VSS VDD VDD network.neuron_hid3.IF0.membrane_potential\[6\]
+ sky130_fd_sc_hd__dfxtp_1
Xnetwork.neuron_hid3.IF0.membrane_potential\[7\]$_SDFF_PP0_
+ clknet_leaf_81_clk_net _01674_ VSS VSS VDD VDD network.neuron_hid3.IF0.membrane_potential\[7\]
+ sky130_fd_sc_hd__dfxtp_1
Xnetwork.neuron_hid3.IF0.membrane_potential\[8\]$_SDFF_PP0_
+ clknet_leaf_68_clk_net _01673_ VSS VSS VDD VDD network.neuron_hid3.IF0.membrane_potential\[8\]
+ sky130_fd_sc_hd__dfxtp_1
Xnetwork.neuron_hid3.IF0.membrane_potential\[9\]$_SDFF_PP0_
+ clknet_leaf_81_clk_net _01672_ VSS VSS VDD VDD network.neuron_hid3.IF0.membrane_potential\[9\]
+ sky130_fd_sc_hd__dfxtp_1
Xnetwork.neuron_hid3.IF0.ref_counter\[0\]$_SDFFE_PP0P_ clknet_leaf_69_clk_net
+ _01671_ VSS VSS VDD VDD network.neuron_hid3.IF0.ref_counter\[0\]
+ sky130_fd_sc_hd__dfxtp_1
Xnetwork.neuron_hid3.IF0.ref_counter\[1\]$_SDFFE_PP0P_ clknet_leaf_80_clk_net
+ _01922_ VSS VSS VDD VDD network.neuron_hid3.IF0.ref_counter\[1\]
+ sky130_fd_sc_hd__dfxtp_1
Xnetwork.neuron_hid3.IF_in\[0\]$_SDFF_PP0_ clknet_leaf_82_clk_net
+ _01752_ VSS VSS VDD VDD network.neuron_hid3.IF0.input_current\[0\]
+ sky130_fd_sc_hd__dfxtp_1
Xnetwork.neuron_hid3.IF_in\[1\]$_SDFF_PP0_ clknet_leaf_68_clk_net
+ _01751_ VSS VSS VDD VDD network.neuron_hid3.IF0.input_current\[1\]
+ sky130_fd_sc_hd__dfxtp_1
Xnetwork.neuron_hid3.IF_in\[2\]$_SDFF_PP0_ clknet_leaf_82_clk_net
+ _01750_ VSS VSS VDD VDD network.neuron_hid3.IF0.input_current\[2\]
+ sky130_fd_sc_hd__dfxtp_1
Xnetwork.neuron_hid3.IF_in\[5\]$_SDFF_PP0_ clknet_leaf_96_clk_net
+ _01756_ VSS VSS VDD VDD network.neuron_hid2.IF0.input_current\[5\]
+ sky130_fd_sc_hd__dfxtp_1
Xnetwork.neuron_hid3.spike_out$_SDFFE_PP0P_ clknet_leaf_81_clk_net
+ _01921_ VSS VSS VDD VDD network.hid_spk3 sky130_fd_sc_hd__dfxtp_1
Xnetwork.neuron_hid4.IF0.membrane_potential\[0\]$_SDFF_PP0_
+ clknet_leaf_76_clk_net _01670_ VSS VSS VDD VDD network.neuron_hid4.IF0.membrane_potential\[0\]
+ sky130_fd_sc_hd__dfxtp_1
Xnetwork.neuron_hid4.IF0.membrane_potential\[10\]$_SDFF_PP0_
+ clknet_leaf_74_clk_net _01925_ VSS VSS VDD VDD network.neuron_hid4.IF0.membrane_potential\[10\]
+ sky130_fd_sc_hd__dfxtp_1
Xnetwork.neuron_hid4.IF0.membrane_potential\[1\]$_SDFF_PP0_
+ clknet_leaf_76_clk_net _01669_ VSS VSS VDD VDD network.neuron_hid4.IF0.membrane_potential\[1\]
+ sky130_fd_sc_hd__dfxtp_1
Xnetwork.neuron_hid4.IF0.membrane_potential\[2\]$_SDFF_PP0_
+ clknet_leaf_73_clk_net _01668_ VSS VSS VDD VDD network.neuron_hid4.IF0.membrane_potential\[2\]
+ sky130_fd_sc_hd__dfxtp_1
Xnetwork.neuron_hid4.IF0.membrane_potential\[3\]$_SDFF_PP0_
+ clknet_leaf_73_clk_net _01667_ VSS VSS VDD VDD network.neuron_hid4.IF0.membrane_potential\[3\]
+ sky130_fd_sc_hd__dfxtp_1
Xnetwork.neuron_hid4.IF0.membrane_potential\[4\]$_SDFF_PP0_
+ clknet_leaf_73_clk_net _01666_ VSS VSS VDD VDD network.neuron_hid4.IF0.membrane_potential\[4\]
+ sky130_fd_sc_hd__dfxtp_1
Xnetwork.neuron_hid4.IF0.membrane_potential\[5\]$_SDFF_PP0_
+ clknet_leaf_73_clk_net _01665_ VSS VSS VDD VDD network.neuron_hid4.IF0.membrane_potential\[5\]
+ sky130_fd_sc_hd__dfxtp_1
Xnetwork.neuron_hid4.IF0.membrane_potential\[6\]$_SDFF_PP0_
+ clknet_leaf_75_clk_net _01664_ VSS VSS VDD VDD network.neuron_hid4.IF0.membrane_potential\[6\]
+ sky130_fd_sc_hd__dfxtp_1
Xnetwork.neuron_hid4.IF0.membrane_potential\[7\]$_SDFF_PP0_
+ clknet_leaf_75_clk_net _01663_ VSS VSS VDD VDD network.neuron_hid4.IF0.membrane_potential\[7\]
+ sky130_fd_sc_hd__dfxtp_1
Xnetwork.neuron_hid4.IF0.membrane_potential\[8\]$_SDFF_PP0_
+ clknet_leaf_75_clk_net _01662_ VSS VSS VDD VDD network.neuron_hid4.IF0.membrane_potential\[8\]
+ sky130_fd_sc_hd__dfxtp_1
Xnetwork.neuron_hid4.IF0.membrane_potential\[9\]$_SDFF_PP0_
+ clknet_leaf_74_clk_net _01661_ VSS VSS VDD VDD network.neuron_hid4.IF0.membrane_potential\[9\]
+ sky130_fd_sc_hd__dfxtp_1
Xnetwork.neuron_hid4.IF0.ref_counter\[0\]$_SDFFE_PP0P_ clknet_leaf_74_clk_net
+ _01660_ VSS VSS VDD VDD network.neuron_hid4.IF0.ref_counter\[0\]
+ sky130_fd_sc_hd__dfxtp_1
Xnetwork.neuron_hid4.IF0.ref_counter\[1\]$_SDFFE_PP0P_ clknet_leaf_74_clk_net
+ _01923_ VSS VSS VDD VDD network.neuron_hid4.IF0.ref_counter\[1\]
+ sky130_fd_sc_hd__dfxtp_1
Xnetwork.neuron_hid4.IF_in\[0\]$_SDFF_PP0_ clknet_leaf_80_clk_net
+ _01516_ VSS VSS VDD VDD network.neuron_hid4.IF0.input_current\[0\]
+ sky130_fd_sc_hd__dfxtp_1
Xnetwork.neuron_hid4.IF_in\[1\]$_SDFF_PP0_ clknet_leaf_73_clk_net
+ _01515_ VSS VSS VDD VDD network.neuron_hid4.IF0.input_current\[1\]
+ sky130_fd_sc_hd__dfxtp_1
Xnetwork.neuron_hid4.IF_in\[2\]$_SDFF_PP0_ clknet_leaf_70_clk_net
+ _01514_ VSS VSS VDD VDD network.neuron_hid4.IF0.input_current\[2\]
+ sky130_fd_sc_hd__dfxtp_1
Xnetwork.neuron_hid4.IF_in\[3\]$_SDFF_PP0_ clknet_leaf_72_clk_net
+ _01513_ VSS VSS VDD VDD network.neuron_hid4.IF0.input_current\[3\]
+ sky130_fd_sc_hd__dfxtp_1
Xnetwork.neuron_hid4.IF_in\[4\]$_SDFF_PP0_ clknet_leaf_72_clk_net
+ _01755_ VSS VSS VDD VDD network.neuron_hid4.IF0.input_current\[4\]
+ sky130_fd_sc_hd__dfxtp_1
Xnetwork.neuron_hid4.spike_out$_SDFFE_PP0P_ clknet_leaf_80_clk_net
+ _01927_ VSS VSS VDD VDD network.hid_spk4 sky130_fd_sc_hd__dfxtp_1
Xnetwork.neuron_hid5.IF0.membrane_potential\[0\]$_SDFF_PP0_
+ clknet_leaf_95_clk_net _01659_ VSS VSS VDD VDD network.neuron_hid5.IF0.membrane_potential\[0\]
+ sky130_fd_sc_hd__dfxtp_1
Xnetwork.neuron_hid5.IF0.membrane_potential\[10\]$_SDFF_PP0_
+ clknet_leaf_95_clk_net _01930_ VSS VSS VDD VDD network.neuron_hid5.IF0.membrane_potential\[10\]
+ sky130_fd_sc_hd__dfxtp_1
Xnetwork.neuron_hid5.IF0.membrane_potential\[1\]$_SDFF_PP0_
+ clknet_leaf_95_clk_net _01658_ VSS VSS VDD VDD network.neuron_hid5.IF0.membrane_potential\[1\]
+ sky130_fd_sc_hd__dfxtp_1
Xnetwork.neuron_hid5.IF0.membrane_potential\[2\]$_SDFF_PP0_
+ clknet_leaf_95_clk_net _01657_ VSS VSS VDD VDD network.neuron_hid5.IF0.membrane_potential\[2\]
+ sky130_fd_sc_hd__dfxtp_1
Xnetwork.neuron_hid5.IF0.membrane_potential\[3\]$_SDFF_PP0_
+ clknet_leaf_95_clk_net _01656_ VSS VSS VDD VDD network.neuron_hid5.IF0.membrane_potential\[3\]
+ sky130_fd_sc_hd__dfxtp_1
Xnetwork.neuron_hid5.IF0.membrane_potential\[4\]$_SDFF_PP0_
+ clknet_leaf_95_clk_net _01655_ VSS VSS VDD VDD network.neuron_hid5.IF0.membrane_potential\[4\]
+ sky130_fd_sc_hd__dfxtp_1
Xnetwork.neuron_hid5.IF0.membrane_potential\[5\]$_SDFF_PP0_
+ clknet_leaf_95_clk_net _01654_ VSS VSS VDD VDD network.neuron_hid5.IF0.membrane_potential\[5\]
+ sky130_fd_sc_hd__dfxtp_1
Xnetwork.neuron_hid5.IF0.membrane_potential\[6\]$_SDFF_PP0_
+ clknet_leaf_94_clk_net _01653_ VSS VSS VDD VDD network.neuron_hid5.IF0.membrane_potential\[6\]
+ sky130_fd_sc_hd__dfxtp_1
Xnetwork.neuron_hid5.IF0.membrane_potential\[7\]$_SDFF_PP0_
+ clknet_leaf_93_clk_net _01652_ VSS VSS VDD VDD network.neuron_hid5.IF0.membrane_potential\[7\]
+ sky130_fd_sc_hd__dfxtp_1
Xnetwork.neuron_hid5.IF0.membrane_potential\[8\]$_SDFF_PP0_
+ clknet_leaf_92_clk_net _01651_ VSS VSS VDD VDD network.neuron_hid5.IF0.membrane_potential\[8\]
+ sky130_fd_sc_hd__dfxtp_1
Xnetwork.neuron_hid5.IF0.membrane_potential\[9\]$_SDFF_PP0_
+ clknet_leaf_94_clk_net _01650_ VSS VSS VDD VDD network.neuron_hid5.IF0.membrane_potential\[9\]
+ sky130_fd_sc_hd__dfxtp_1
Xnetwork.neuron_hid5.IF0.ref_counter\[0\]$_SDFFE_PP0P_ clknet_leaf_94_clk_net
+ _01649_ VSS VSS VDD VDD network.neuron_hid5.IF0.ref_counter\[0\]
+ sky130_fd_sc_hd__dfxtp_1
Xnetwork.neuron_hid5.IF0.ref_counter\[1\]$_SDFFE_PP0P_ clknet_leaf_94_clk_net
+ _01928_ VSS VSS VDD VDD network.neuron_hid5.IF0.ref_counter\[1\]
+ sky130_fd_sc_hd__dfxtp_1
Xnetwork.neuron_hid5.IF_in\[0\]$_SDFF_PP0_ clknet_leaf_96_clk_net
+ _01512_ VSS VSS VDD VDD network.neuron_hid5.IF0.input_current\[0\]
+ sky130_fd_sc_hd__dfxtp_1
Xnetwork.neuron_hid5.IF_in\[1\]$_SDFF_PP0_ clknet_leaf_96_clk_net
+ _01511_ VSS VSS VDD VDD network.neuron_hid5.IF0.input_current\[1\]
+ sky130_fd_sc_hd__dfxtp_1
Xnetwork.neuron_hid5.IF_in\[2\]$_SDFF_PP0_ clknet_leaf_96_clk_net
+ _01510_ VSS VSS VDD VDD network.neuron_hid5.IF0.input_current\[2\]
+ sky130_fd_sc_hd__dfxtp_1
Xnetwork.neuron_hid5.IF_in\[3\]$_SDFF_PP0_ clknet_leaf_96_clk_net
+ _01509_ VSS VSS VDD VDD network.neuron_hid5.IF0.input_current\[3\]
+ sky130_fd_sc_hd__dfxtp_1
Xnetwork.neuron_hid5.IF_in\[4\]$_SDFF_PP0_ clknet_leaf_96_clk_net
+ _01753_ VSS VSS VDD VDD network.neuron_hid5.IF0.input_current\[4\]
+ sky130_fd_sc_hd__dfxtp_1
Xnetwork.neuron_hid5.spike_out$_SDFFE_PP0P_ clknet_leaf_81_clk_net
+ _01931_ VSS VSS VDD VDD network.hid_spk5 sky130_fd_sc_hd__dfxtp_1
Xnetwork.neuron_hid6.IF0.membrane_potential\[0\]$_SDFF_PP0_
+ clknet_leaf_69_clk_net _01648_ VSS VSS VDD VDD network.neuron_hid6.IF0.membrane_potential\[0\]
+ sky130_fd_sc_hd__dfxtp_1
Xnetwork.neuron_hid6.IF0.membrane_potential\[10\]$_SDFF_PP0_
+ clknet_leaf_69_clk_net _01934_ VSS VSS VDD VDD network.neuron_hid6.IF0.membrane_potential\[10\]
+ sky130_fd_sc_hd__dfxtp_1
Xnetwork.neuron_hid6.IF0.membrane_potential\[1\]$_SDFF_PP0_
+ clknet_leaf_69_clk_net _01647_ VSS VSS VDD VDD network.neuron_hid6.IF0.membrane_potential\[1\]
+ sky130_fd_sc_hd__dfxtp_1
Xnetwork.neuron_hid6.IF0.membrane_potential\[2\]$_SDFF_PP0_
+ clknet_leaf_68_clk_net _01646_ VSS VSS VDD VDD network.neuron_hid6.IF0.membrane_potential\[2\]
+ sky130_fd_sc_hd__dfxtp_1
Xnetwork.neuron_hid6.IF0.membrane_potential\[3\]$_SDFF_PP0_
+ clknet_leaf_69_clk_net _01645_ VSS VSS VDD VDD network.neuron_hid6.IF0.membrane_potential\[3\]
+ sky130_fd_sc_hd__dfxtp_1
Xnetwork.neuron_hid6.IF0.membrane_potential\[4\]$_SDFF_PP0_
+ clknet_leaf_69_clk_net _01644_ VSS VSS VDD VDD network.neuron_hid6.IF0.membrane_potential\[4\]
+ sky130_fd_sc_hd__dfxtp_1
Xnetwork.neuron_hid6.IF0.membrane_potential\[5\]$_SDFF_PP0_
+ clknet_leaf_72_clk_net _01643_ VSS VSS VDD VDD network.neuron_hid6.IF0.membrane_potential\[5\]
+ sky130_fd_sc_hd__dfxtp_1
Xnetwork.neuron_hid6.IF0.membrane_potential\[6\]$_SDFF_PP0_
+ clknet_leaf_73_clk_net _01642_ VSS VSS VDD VDD network.neuron_hid6.IF0.membrane_potential\[6\]
+ sky130_fd_sc_hd__dfxtp_1
Xnetwork.neuron_hid6.IF0.membrane_potential\[7\]$_SDFF_PP0_
+ clknet_leaf_73_clk_net _01641_ VSS VSS VDD VDD network.neuron_hid6.IF0.membrane_potential\[7\]
+ sky130_fd_sc_hd__dfxtp_1
Xnetwork.neuron_hid6.IF0.membrane_potential\[8\]$_SDFF_PP0_
+ clknet_leaf_73_clk_net _01640_ VSS VSS VDD VDD network.neuron_hid6.IF0.membrane_potential\[8\]
+ sky130_fd_sc_hd__dfxtp_1
Xnetwork.neuron_hid6.IF0.membrane_potential\[9\]$_SDFF_PP0_
+ clknet_leaf_76_clk_net _01639_ VSS VSS VDD VDD network.neuron_hid6.IF0.membrane_potential\[9\]
+ sky130_fd_sc_hd__dfxtp_1
Xnetwork.neuron_hid6.IF0.ref_counter\[0\]$_SDFFE_PP0P_ clknet_leaf_73_clk_net
+ _01638_ VSS VSS VDD VDD network.neuron_hid6.IF0.ref_counter\[0\]
+ sky130_fd_sc_hd__dfxtp_1
Xnetwork.neuron_hid6.IF0.ref_counter\[1\]$_SDFFE_PP0P_ clknet_leaf_80_clk_net
+ _01932_ VSS VSS VDD VDD network.neuron_hid6.IF0.ref_counter\[1\]
+ sky130_fd_sc_hd__dfxtp_1
Xnetwork.neuron_hid6.IF_in\[0\]$_SDFF_PP0_ clknet_leaf_68_clk_net
+ _01520_ VSS VSS VDD VDD network.neuron_hid6.IF0.input_current\[0\]
+ sky130_fd_sc_hd__dfxtp_1
Xnetwork.neuron_hid6.IF_in\[1\]$_SDFF_PP0_ clknet_leaf_68_clk_net
+ _01519_ VSS VSS VDD VDD network.neuron_hid6.IF0.input_current\[1\]
+ sky130_fd_sc_hd__dfxtp_1
Xnetwork.neuron_hid6.IF_in\[2\]$_SDFF_PP0_ clknet_leaf_68_clk_net
+ _01518_ VSS VSS VDD VDD network.neuron_hid6.IF0.input_current\[2\]
+ sky130_fd_sc_hd__dfxtp_1
Xnetwork.neuron_hid6.IF_in\[3\]$_SDFF_PP0_ clknet_leaf_70_clk_net
+ _01517_ VSS VSS VDD VDD network.neuron_hid6.IF0.input_current\[3\]
+ sky130_fd_sc_hd__dfxtp_1
Xnetwork.neuron_hid6.IF_in\[4\]$_SDFF_PP0_ clknet_leaf_70_clk_net
+ _01757_ VSS VSS VDD VDD network.neuron_hid6.IF0.input_current\[4\]
+ sky130_fd_sc_hd__dfxtp_1
Xnetwork.neuron_hid6.spike_out$_SDFFE_PP0P_ clknet_leaf_80_clk_net
+ _01936_ VSS VSS VDD VDD network.hid_spk6 sky130_fd_sc_hd__dfxtp_1
Xnetwork.neuron_hid7.IF0.membrane_potential\[0\]$_SDFF_PP0_
+ clknet_leaf_83_clk_net _01637_ VSS VSS VDD VDD network.neuron_hid7.IF0.membrane_potential\[0\]
+ sky130_fd_sc_hd__dfxtp_1
Xnetwork.neuron_hid7.IF0.membrane_potential\[10\]$_SDFF_PP0_
+ clknet_leaf_85_clk_net _01939_ VSS VSS VDD VDD network.neuron_hid7.IF0.membrane_potential\[10\]
+ sky130_fd_sc_hd__dfxtp_1
Xnetwork.neuron_hid7.IF0.membrane_potential\[1\]$_SDFF_PP0_
+ clknet_leaf_83_clk_net _01636_ VSS VSS VDD VDD network.neuron_hid7.IF0.membrane_potential\[1\]
+ sky130_fd_sc_hd__dfxtp_1
Xnetwork.neuron_hid7.IF0.membrane_potential\[2\]$_SDFF_PP0_
+ clknet_leaf_95_clk_net _01635_ VSS VSS VDD VDD network.neuron_hid7.IF0.membrane_potential\[2\]
+ sky130_fd_sc_hd__dfxtp_1
Xnetwork.neuron_hid7.IF0.membrane_potential\[3\]$_SDFF_PP0_
+ clknet_leaf_94_clk_net _01634_ VSS VSS VDD VDD network.neuron_hid7.IF0.membrane_potential\[3\]
+ sky130_fd_sc_hd__dfxtp_1
Xnetwork.neuron_hid7.IF0.membrane_potential\[4\]$_SDFF_PP0_
+ clknet_leaf_94_clk_net _01633_ VSS VSS VDD VDD network.neuron_hid7.IF0.membrane_potential\[4\]
+ sky130_fd_sc_hd__dfxtp_1
Xnetwork.neuron_hid7.IF0.membrane_potential\[5\]$_SDFF_PP0_
+ clknet_leaf_84_clk_net _01632_ VSS VSS VDD VDD network.neuron_hid7.IF0.membrane_potential\[5\]
+ sky130_fd_sc_hd__dfxtp_1
Xnetwork.neuron_hid7.IF0.membrane_potential\[6\]$_SDFF_PP0_
+ clknet_leaf_83_clk_net _01631_ VSS VSS VDD VDD network.neuron_hid7.IF0.membrane_potential\[6\]
+ sky130_fd_sc_hd__dfxtp_1
Xnetwork.neuron_hid7.IF0.membrane_potential\[7\]$_SDFF_PP0_
+ clknet_leaf_83_clk_net _01630_ VSS VSS VDD VDD network.neuron_hid7.IF0.membrane_potential\[7\]
+ sky130_fd_sc_hd__dfxtp_1
Xnetwork.neuron_hid7.IF0.membrane_potential\[8\]$_SDFF_PP0_
+ clknet_leaf_84_clk_net _01629_ VSS VSS VDD VDD network.neuron_hid7.IF0.membrane_potential\[8\]
+ sky130_fd_sc_hd__dfxtp_1
Xnetwork.neuron_hid7.IF0.membrane_potential\[9\]$_SDFF_PP0_
+ clknet_leaf_85_clk_net _01628_ VSS VSS VDD VDD network.neuron_hid7.IF0.membrane_potential\[9\]
+ sky130_fd_sc_hd__dfxtp_1
Xnetwork.neuron_hid7.IF0.ref_counter\[0\]$_SDFFE_PP0P_ clknet_leaf_84_clk_net
+ _01627_ VSS VSS VDD VDD network.neuron_hid7.IF0.ref_counter\[0\]
+ sky130_fd_sc_hd__dfxtp_1
Xnetwork.neuron_hid7.IF0.ref_counter\[1\]$_SDFFE_PP0P_ clknet_leaf_84_clk_net
+ _01937_ VSS VSS VDD VDD network.neuron_hid7.IF0.ref_counter\[1\]
+ sky130_fd_sc_hd__dfxtp_1
Xnetwork.neuron_hid7.IF_in\[0\]$_SDFF_PP0_ clknet_leaf_96_clk_net
+ _01745_ VSS VSS VDD VDD network.neuron_hid7.IF0.input_current\[0\]
+ sky130_fd_sc_hd__dfxtp_1
Xnetwork.neuron_hid7.IF_in\[1\]$_SDFF_PP0_ clknet_leaf_96_clk_net
+ _01744_ VSS VSS VDD VDD network.neuron_hid7.IF0.input_current\[1\]
+ sky130_fd_sc_hd__dfxtp_1
Xnetwork.neuron_hid7.IF_in\[2\]$_SDFF_PP0_ clknet_leaf_95_clk_net
+ _01743_ VSS VSS VDD VDD network.neuron_hid7.IF0.input_current\[2\]
+ sky130_fd_sc_hd__dfxtp_1
Xnetwork.neuron_hid7.IF_in\[3\]$_SDFF_PP0_ clknet_leaf_95_clk_net
+ _01742_ VSS VSS VDD VDD network.neuron_hid7.IF0.input_current\[3\]
+ sky130_fd_sc_hd__dfxtp_1
Xnetwork.neuron_hid7.IF_in\[6\]$_SDFF_PP0_ clknet_leaf_95_clk_net
+ _01760_ VSS VSS VDD VDD network.neuron_hid2.IF0.input_current\[6\]
+ sky130_fd_sc_hd__dfxtp_1
Xnetwork.neuron_hid7.IF_in\[7\]$_SDFF_PP0_ clknet_leaf_68_clk_net
+ _01754_ VSS VSS VDD VDD network.neuron_hid2.IF0.input_current\[7\]
+ sky130_fd_sc_hd__dfxtp_1
Xnetwork.neuron_hid7.spike_out$_SDFFE_PP0P_ clknet_leaf_79_clk_net
+ _01941_ VSS VSS VDD VDD network.hid_spk7 sky130_fd_sc_hd__dfxtp_1
Xnetwork.neuron_in000.counter\[0\]$_DFFE_PP_ clknet_leaf_58_clk_net
+ _02063_ _01504_ VSS VSS VDD VDD network.neuron_in000.counter\[0\]
+ sky130_fd_sc_hd__edfxtp_1
Xnetwork.neuron_in000.counter\[1\]$_DFFE_PP_ clknet_leaf_57_clk_net
+ _02064_ _01504_ VSS VSS VDD VDD network.neuron_in000.counter\[1\]
+ sky130_fd_sc_hd__edfxtp_1
Xnetwork.neuron_in000.counter\[2\]$_DFFE_PP_ clknet_leaf_57_clk_net
+ _02065_ _01504_ VSS VSS VDD VDD network.neuron_in000.counter\[2\]
+ sky130_fd_sc_hd__edfxtp_1
Xnetwork.neuron_in000.counter\[3\]$_DFFE_PP_ clknet_leaf_57_clk_net
+ _02066_ _01504_ VSS VSS VDD VDD network.neuron_in000.counter\[3\]
+ sky130_fd_sc_hd__edfxtp_1
Xnetwork.neuron_in000.spike$_SDFFE_PP0P_ clknet_leaf_52_clk_net
+ _01865_ VSS VSS VDD VDD network.in_spk00_00 sky130_fd_sc_hd__dfxtp_1
Xnetwork.neuron_in001.counter\[0\]$_DFFE_PP_ clknet_leaf_56_clk_net
+ _02067_ _01503_ VSS VSS VDD VDD network.neuron_in001.counter\[0\]
+ sky130_fd_sc_hd__edfxtp_1
Xnetwork.neuron_in001.counter\[1\]$_DFFE_PP_ clknet_leaf_56_clk_net
+ _02068_ _01503_ VSS VSS VDD VDD network.neuron_in001.counter\[1\]
+ sky130_fd_sc_hd__edfxtp_1
Xnetwork.neuron_in001.counter\[2\]$_DFFE_PP_ clknet_leaf_56_clk_net
+ _02069_ _01503_ VSS VSS VDD VDD network.neuron_in001.counter\[2\]
+ sky130_fd_sc_hd__edfxtp_1
Xnetwork.neuron_in001.counter\[3\]$_DFFE_PP_ clknet_leaf_56_clk_net
+ _02070_ _01503_ VSS VSS VDD VDD network.neuron_in001.counter\[3\]
+ sky130_fd_sc_hd__edfxtp_1
Xnetwork.neuron_in001.spike$_SDFFE_PP0P_ clknet_leaf_54_clk_net
+ _01864_ VSS VSS VDD VDD network.in_spk01_00 sky130_fd_sc_hd__dfxtp_1
Xnetwork.neuron_in002.counter\[0\]$_DFFE_PP_ clknet_leaf_56_clk_net
+ _02071_ _01502_ VSS VSS VDD VDD network.neuron_in002.counter\[0\]
+ sky130_fd_sc_hd__edfxtp_1
Xnetwork.neuron_in002.counter\[1\]$_DFFE_PP_ clknet_leaf_56_clk_net
+ _02072_ _01502_ VSS VSS VDD VDD network.neuron_in002.counter\[1\]
+ sky130_fd_sc_hd__edfxtp_1
Xnetwork.neuron_in002.counter\[2\]$_DFFE_PP_ clknet_leaf_54_clk_net
+ _02073_ _01502_ VSS VSS VDD VDD network.neuron_in002.counter\[2\]
+ sky130_fd_sc_hd__edfxtp_1
Xnetwork.neuron_in002.counter\[3\]$_DFFE_PP_ clknet_leaf_54_clk_net
+ _02074_ _01502_ VSS VSS VDD VDD network.neuron_in002.counter\[3\]
+ sky130_fd_sc_hd__edfxtp_1
Xnetwork.neuron_in002.spike$_SDFFE_PP0P_ clknet_leaf_55_clk_net
+ _01863_ VSS VSS VDD VDD network.in_spk02_00 sky130_fd_sc_hd__dfxtp_1
Xnetwork.neuron_in003.counter\[0\]$_DFFE_PP_ clknet_leaf_53_clk_net
+ _02075_ _01501_ VSS VSS VDD VDD network.neuron_in003.counter\[0\]
+ sky130_fd_sc_hd__edfxtp_1
Xnetwork.neuron_in003.counter\[1\]$_DFFE_PP_ clknet_leaf_53_clk_net
+ _02076_ _01501_ VSS VSS VDD VDD network.neuron_in003.counter\[1\]
+ sky130_fd_sc_hd__edfxtp_1
Xnetwork.neuron_in003.counter\[2\]$_DFFE_PP_ clknet_leaf_53_clk_net
+ _02077_ _01501_ VSS VSS VDD VDD network.neuron_in003.counter\[2\]
+ sky130_fd_sc_hd__edfxtp_1
Xnetwork.neuron_in003.counter\[3\]$_DFFE_PP_ clknet_leaf_53_clk_net
+ _02078_ _01501_ VSS VSS VDD VDD network.neuron_in003.counter\[3\]
+ sky130_fd_sc_hd__edfxtp_1
Xnetwork.neuron_in003.spike$_SDFFE_PP0P_ clknet_leaf_54_clk_net
+ _01862_ VSS VSS VDD VDD network.in_spk03_00 sky130_fd_sc_hd__dfxtp_1
Xnetwork.neuron_in004.counter\[0\]$_DFFE_PP_ clknet_leaf_54_clk_net
+ _02079_ _01500_ VSS VSS VDD VDD network.neuron_in004.counter\[0\]
+ sky130_fd_sc_hd__edfxtp_1
Xnetwork.neuron_in004.counter\[1\]$_DFFE_PP_ clknet_leaf_54_clk_net
+ _02080_ _01500_ VSS VSS VDD VDD network.neuron_in004.counter\[1\]
+ sky130_fd_sc_hd__edfxtp_1
Xnetwork.neuron_in004.counter\[2\]$_DFFE_PP_ clknet_leaf_54_clk_net
+ _02081_ _01500_ VSS VSS VDD VDD network.neuron_in004.counter\[2\]
+ sky130_fd_sc_hd__edfxtp_1
Xnetwork.neuron_in004.counter\[3\]$_DFFE_PP_ clknet_leaf_54_clk_net
+ _02082_ _01500_ VSS VSS VDD VDD network.neuron_in004.counter\[3\]
+ sky130_fd_sc_hd__edfxtp_1
Xnetwork.neuron_in004.spike$_SDFFE_PP0P_ clknet_leaf_54_clk_net
+ _01861_ VSS VSS VDD VDD network.in_spk04_00 sky130_fd_sc_hd__dfxtp_1
Xnetwork.neuron_in005.counter\[0\]$_DFFE_PP_ clknet_leaf_55_clk_net
+ _02083_ _01499_ VSS VSS VDD VDD network.neuron_in005.counter\[0\]
+ sky130_fd_sc_hd__edfxtp_1
Xnetwork.neuron_in005.counter\[1\]$_DFFE_PP_ clknet_leaf_55_clk_net
+ _02084_ _01499_ VSS VSS VDD VDD network.neuron_in005.counter\[1\]
+ sky130_fd_sc_hd__edfxtp_1
Xnetwork.neuron_in005.counter\[2\]$_DFFE_PP_ clknet_leaf_57_clk_net
+ _02085_ _01499_ VSS VSS VDD VDD network.neuron_in005.counter\[2\]
+ sky130_fd_sc_hd__edfxtp_1
Xnetwork.neuron_in005.counter\[3\]$_DFFE_PP_ clknet_leaf_55_clk_net
+ _02086_ _01499_ VSS VSS VDD VDD network.neuron_in005.counter\[3\]
+ sky130_fd_sc_hd__edfxtp_1
Xnetwork.neuron_in005.spike$_SDFFE_PP0P_ clknet_leaf_54_clk_net
+ _01860_ VSS VSS VDD VDD network.in_spk05_00 sky130_fd_sc_hd__dfxtp_1
Xnetwork.neuron_in006.counter\[0\]$_DFFE_PP_ clknet_leaf_48_clk_net
+ _02087_ _01498_ VSS VSS VDD VDD network.neuron_in006.counter\[0\]
+ sky130_fd_sc_hd__edfxtp_1
Xnetwork.neuron_in006.counter\[1\]$_DFFE_PP_ clknet_leaf_48_clk_net
+ _02088_ _01498_ VSS VSS VDD VDD network.neuron_in006.counter\[1\]
+ sky130_fd_sc_hd__edfxtp_1
Xnetwork.neuron_in006.counter\[2\]$_DFFE_PP_ clknet_leaf_53_clk_net
+ _02089_ _01498_ VSS VSS VDD VDD network.neuron_in006.counter\[2\]
+ sky130_fd_sc_hd__edfxtp_1
Xnetwork.neuron_in006.counter\[3\]$_DFFE_PP_ clknet_leaf_48_clk_net
+ _02090_ _01498_ VSS VSS VDD VDD network.neuron_in006.counter\[3\]
+ sky130_fd_sc_hd__edfxtp_1
Xnetwork.neuron_in006.spike$_SDFFE_PP0P_ clknet_leaf_52_clk_net
+ _01859_ VSS VSS VDD VDD network.in_spk06_00 sky130_fd_sc_hd__dfxtp_1
Xnetwork.neuron_in007.counter\[0\]$_DFFE_PP_ clknet_leaf_53_clk_net
+ _02091_ _01497_ VSS VSS VDD VDD network.neuron_in007.counter\[0\]
+ sky130_fd_sc_hd__edfxtp_1
Xnetwork.neuron_in007.counter\[1\]$_DFFE_PP_ clknet_leaf_53_clk_net
+ _02092_ _01497_ VSS VSS VDD VDD network.neuron_in007.counter\[1\]
+ sky130_fd_sc_hd__edfxtp_1
Xnetwork.neuron_in007.counter\[2\]$_DFFE_PP_ clknet_leaf_53_clk_net
+ _02093_ _01497_ VSS VSS VDD VDD network.neuron_in007.counter\[2\]
+ sky130_fd_sc_hd__edfxtp_1
Xnetwork.neuron_in007.counter\[3\]$_DFFE_PP_ clknet_leaf_52_clk_net
+ _02094_ _01497_ VSS VSS VDD VDD network.neuron_in007.counter\[3\]
+ sky130_fd_sc_hd__edfxtp_1
Xnetwork.neuron_in007.spike$_SDFFE_PP0P_ clknet_leaf_52_clk_net
+ _01858_ VSS VSS VDD VDD network.in_spk07_00 sky130_fd_sc_hd__dfxtp_1
Xnetwork.neuron_in008.counter\[0\]$_DFFE_PP_ clknet_leaf_59_clk_net
+ _02095_ _01496_ VSS VSS VDD VDD network.neuron_in008.counter\[0\]
+ sky130_fd_sc_hd__edfxtp_1
Xnetwork.neuron_in008.counter\[1\]$_DFFE_PP_ clknet_leaf_59_clk_net
+ _02096_ _01496_ VSS VSS VDD VDD network.neuron_in008.counter\[1\]
+ sky130_fd_sc_hd__edfxtp_1
Xnetwork.neuron_in008.counter\[2\]$_DFFE_PP_ clknet_leaf_58_clk_net
+ _02097_ _01496_ VSS VSS VDD VDD network.neuron_in008.counter\[2\]
+ sky130_fd_sc_hd__edfxtp_1
Xnetwork.neuron_in008.counter\[3\]$_DFFE_PP_ clknet_leaf_58_clk_net
+ _02098_ _01496_ VSS VSS VDD VDD network.neuron_in008.counter\[3\]
+ sky130_fd_sc_hd__edfxtp_1
Xnetwork.neuron_in008.spike$_SDFFE_PP0P_ clknet_leaf_52_clk_net
+ _01857_ VSS VSS VDD VDD network.in_spk08_00 sky130_fd_sc_hd__dfxtp_1
Xnetwork.neuron_in009.counter\[0\]$_DFFE_PP_ clknet_leaf_51_clk_net
+ _02099_ _01495_ VSS VSS VDD VDD network.neuron_in009.counter\[0\]
+ sky130_fd_sc_hd__edfxtp_1
Xnetwork.neuron_in009.counter\[1\]$_DFFE_PP_ clknet_leaf_51_clk_net
+ _02100_ _01495_ VSS VSS VDD VDD network.neuron_in009.counter\[1\]
+ sky130_fd_sc_hd__edfxtp_1
Xnetwork.neuron_in009.counter\[2\]$_DFFE_PP_ clknet_leaf_51_clk_net
+ _02101_ _01495_ VSS VSS VDD VDD network.neuron_in009.counter\[2\]
+ sky130_fd_sc_hd__edfxtp_1
Xnetwork.neuron_in009.counter\[3\]$_DFFE_PP_ clknet_leaf_51_clk_net
+ _02102_ _01495_ VSS VSS VDD VDD network.neuron_in009.counter\[3\]
+ sky130_fd_sc_hd__edfxtp_1
Xnetwork.neuron_in009.spike$_SDFFE_PP0P_ clknet_leaf_52_clk_net
+ _01856_ VSS VSS VDD VDD network.in_spk09_00 sky130_fd_sc_hd__dfxtp_1
Xnetwork.neuron_in010.counter\[0\]$_DFFE_PP_ clknet_leaf_50_clk_net
+ _02103_ _01494_ VSS VSS VDD VDD network.neuron_in010.counter\[0\]
+ sky130_fd_sc_hd__edfxtp_1
Xnetwork.neuron_in010.counter\[1\]$_DFFE_PP_ clknet_leaf_49_clk_net
+ _02104_ _01494_ VSS VSS VDD VDD network.neuron_in010.counter\[1\]
+ sky130_fd_sc_hd__edfxtp_1
Xnetwork.neuron_in010.counter\[2\]$_DFFE_PP_ clknet_leaf_50_clk_net
+ _02105_ _01494_ VSS VSS VDD VDD network.neuron_in010.counter\[2\]
+ sky130_fd_sc_hd__edfxtp_1
Xnetwork.neuron_in010.counter\[3\]$_DFFE_PP_ clknet_leaf_50_clk_net
+ _02106_ _01494_ VSS VSS VDD VDD network.neuron_in010.counter\[3\]
+ sky130_fd_sc_hd__edfxtp_1
Xnetwork.neuron_in010.spike$_SDFFE_PP0P_ clknet_leaf_52_clk_net
+ _01855_ VSS VSS VDD VDD network.in_spk10_00 sky130_fd_sc_hd__dfxtp_1
Xnetwork.neuron_in011.counter\[0\]$_DFFE_PP_ clknet_leaf_51_clk_net
+ _02107_ _01493_ VSS VSS VDD VDD network.neuron_in011.counter\[0\]
+ sky130_fd_sc_hd__edfxtp_1
Xnetwork.neuron_in011.counter\[1\]$_DFFE_PP_ clknet_leaf_51_clk_net
+ _02108_ _01493_ VSS VSS VDD VDD network.neuron_in011.counter\[1\]
+ sky130_fd_sc_hd__edfxtp_1
Xnetwork.neuron_in011.counter\[2\]$_DFFE_PP_ clknet_leaf_53_clk_net
+ _02109_ _01493_ VSS VSS VDD VDD network.neuron_in011.counter\[2\]
+ sky130_fd_sc_hd__edfxtp_1
Xnetwork.neuron_in011.counter\[3\]$_DFFE_PP_ clknet_leaf_52_clk_net
+ _02110_ _01493_ VSS VSS VDD VDD network.neuron_in011.counter\[3\]
+ sky130_fd_sc_hd__edfxtp_1
Xnetwork.neuron_in011.spike$_SDFFE_PP0P_ clknet_leaf_52_clk_net
+ _01854_ VSS VSS VDD VDD network.in_spk11_00 sky130_fd_sc_hd__dfxtp_1
Xnetwork.neuron_in012.counter\[0\]$_DFFE_PP_ clknet_leaf_57_clk_net
+ _02111_ _01492_ VSS VSS VDD VDD network.neuron_in012.counter\[0\]
+ sky130_fd_sc_hd__edfxtp_1
Xnetwork.neuron_in012.counter\[1\]$_DFFE_PP_ clknet_leaf_61_clk_net
+ _02112_ _01492_ VSS VSS VDD VDD network.neuron_in012.counter\[1\]
+ sky130_fd_sc_hd__edfxtp_1
Xnetwork.neuron_in012.counter\[2\]$_DFFE_PP_ clknet_leaf_57_clk_net
+ _02113_ _01492_ VSS VSS VDD VDD network.neuron_in012.counter\[2\]
+ sky130_fd_sc_hd__edfxtp_1
Xnetwork.neuron_in012.counter\[3\]$_DFFE_PP_ clknet_leaf_57_clk_net
+ _02114_ _01492_ VSS VSS VDD VDD network.neuron_in012.counter\[3\]
+ sky130_fd_sc_hd__edfxtp_1
Xnetwork.neuron_in012.spike$_SDFFE_PP0P_ clknet_leaf_58_clk_net
+ _01853_ VSS VSS VDD VDD network.in_spk12_00 sky130_fd_sc_hd__dfxtp_1
Xnetwork.neuron_in013.counter\[0\]$_DFFE_PP_ clknet_leaf_58_clk_net
+ _02115_ _01491_ VSS VSS VDD VDD network.neuron_in013.counter\[0\]
+ sky130_fd_sc_hd__edfxtp_1
Xnetwork.neuron_in013.counter\[1\]$_DFFE_PP_ clknet_leaf_58_clk_net
+ _02116_ _01491_ VSS VSS VDD VDD network.neuron_in013.counter\[1\]
+ sky130_fd_sc_hd__edfxtp_1
Xnetwork.neuron_in013.counter\[2\]$_DFFE_PP_ clknet_leaf_58_clk_net
+ _02117_ _01491_ VSS VSS VDD VDD network.neuron_in013.counter\[2\]
+ sky130_fd_sc_hd__edfxtp_1
Xnetwork.neuron_in013.counter\[3\]$_DFFE_PP_ clknet_leaf_58_clk_net
+ _02118_ _01491_ VSS VSS VDD VDD network.neuron_in013.counter\[3\]
+ sky130_fd_sc_hd__edfxtp_1
Xnetwork.neuron_in013.spike$_SDFFE_PP0P_ clknet_leaf_52_clk_net
+ _01852_ VSS VSS VDD VDD network.in_spk13_00 sky130_fd_sc_hd__dfxtp_1
Xnetwork.neuron_in014.counter\[0\]$_DFFE_PP_ clknet_leaf_57_clk_net
+ _02119_ _01490_ VSS VSS VDD VDD network.neuron_in014.counter\[0\]
+ sky130_fd_sc_hd__edfxtp_1
Xnetwork.neuron_in014.counter\[1\]$_DFFE_PP_ clknet_leaf_57_clk_net
+ _02120_ _01490_ VSS VSS VDD VDD network.neuron_in014.counter\[1\]
+ sky130_fd_sc_hd__edfxtp_1
Xnetwork.neuron_in014.counter\[2\]$_DFFE_PP_ clknet_leaf_57_clk_net
+ _02121_ _01490_ VSS VSS VDD VDD network.neuron_in014.counter\[2\]
+ sky130_fd_sc_hd__edfxtp_1
Xnetwork.neuron_in014.counter\[3\]$_DFFE_PP_ clknet_leaf_58_clk_net
+ _02122_ _01490_ VSS VSS VDD VDD network.neuron_in014.counter\[3\]
+ sky130_fd_sc_hd__edfxtp_1
Xnetwork.neuron_in014.spike$_SDFFE_PP0P_ clknet_leaf_58_clk_net
+ _01851_ VSS VSS VDD VDD network.in_spk14_00 sky130_fd_sc_hd__dfxtp_1
Xnetwork.neuron_in015.counter\[0\]$_DFFE_PP_ clknet_leaf_55_clk_net
+ _02123_ _01489_ VSS VSS VDD VDD network.neuron_in015.counter\[0\]
+ sky130_fd_sc_hd__edfxtp_1
Xnetwork.neuron_in015.counter\[1\]$_DFFE_PP_ clknet_leaf_55_clk_net
+ _02124_ _01489_ VSS VSS VDD VDD network.neuron_in015.counter\[1\]
+ sky130_fd_sc_hd__edfxtp_1
Xnetwork.neuron_in015.counter\[2\]$_DFFE_PP_ clknet_leaf_55_clk_net
+ _02125_ _01489_ VSS VSS VDD VDD network.neuron_in015.counter\[2\]
+ sky130_fd_sc_hd__edfxtp_1
Xnetwork.neuron_in015.counter\[3\]$_DFFE_PP_ clknet_leaf_56_clk_net
+ _02126_ _01489_ VSS VSS VDD VDD network.neuron_in015.counter\[3\]
+ sky130_fd_sc_hd__edfxtp_1
Xnetwork.neuron_in015.spike$_SDFFE_PP0P_ clknet_leaf_52_clk_net
+ _01850_ VSS VSS VDD VDD network.in_spk15_00 sky130_fd_sc_hd__dfxtp_1
Xnetwork.neuron_in016.counter\[0\]$_DFFE_PP_ clknet_leaf_47_clk_net
+ _02127_ _01488_ VSS VSS VDD VDD network.neuron_in016.counter\[0\]
+ sky130_fd_sc_hd__edfxtp_1
Xnetwork.neuron_in016.counter\[1\]$_DFFE_PP_ clknet_leaf_47_clk_net
+ _02128_ _01488_ VSS VSS VDD VDD network.neuron_in016.counter\[1\]
+ sky130_fd_sc_hd__edfxtp_1
Xnetwork.neuron_in016.counter\[2\]$_DFFE_PP_ clknet_leaf_47_clk_net
+ _02129_ _01488_ VSS VSS VDD VDD network.neuron_in016.counter\[2\]
+ sky130_fd_sc_hd__edfxtp_1
Xnetwork.neuron_in016.counter\[3\]$_DFFE_PP_ clknet_leaf_49_clk_net
+ _02130_ _01488_ VSS VSS VDD VDD network.neuron_in016.counter\[3\]
+ sky130_fd_sc_hd__edfxtp_1
Xnetwork.neuron_in016.spike$_SDFFE_PP0P_ clknet_leaf_49_clk_net
+ _01849_ VSS VSS VDD VDD network.in_spk00_01 sky130_fd_sc_hd__dfxtp_1
Xnetwork.neuron_in017.counter\[0\]$_DFFE_PP_ clknet_leaf_48_clk_net
+ _02131_ _01487_ VSS VSS VDD VDD network.neuron_in017.counter\[0\]
+ sky130_fd_sc_hd__edfxtp_1
Xnetwork.neuron_in017.counter\[1\]$_DFFE_PP_ clknet_leaf_48_clk_net
+ _02132_ _01487_ VSS VSS VDD VDD network.neuron_in017.counter\[1\]
+ sky130_fd_sc_hd__edfxtp_1
Xnetwork.neuron_in017.counter\[2\]$_DFFE_PP_ clknet_leaf_48_clk_net
+ _02133_ _01487_ VSS VSS VDD VDD network.neuron_in017.counter\[2\]
+ sky130_fd_sc_hd__edfxtp_1
Xnetwork.neuron_in017.counter\[3\]$_DFFE_PP_ clknet_leaf_48_clk_net
+ _02134_ _01487_ VSS VSS VDD VDD network.neuron_in017.counter\[3\]
+ sky130_fd_sc_hd__edfxtp_1
Xnetwork.neuron_in017.spike$_SDFFE_PP0P_ clknet_leaf_50_clk_net
+ _01848_ VSS VSS VDD VDD network.in_spk01_01 sky130_fd_sc_hd__dfxtp_1
Xnetwork.neuron_in018.counter\[0\]$_DFFE_PP_ clknet_leaf_47_clk_net
+ _02135_ _01486_ VSS VSS VDD VDD network.neuron_in018.counter\[0\]
+ sky130_fd_sc_hd__edfxtp_1
Xnetwork.neuron_in018.counter\[1\]$_DFFE_PP_ clknet_leaf_47_clk_net
+ _02136_ _01486_ VSS VSS VDD VDD network.neuron_in018.counter\[1\]
+ sky130_fd_sc_hd__edfxtp_1
Xnetwork.neuron_in018.counter\[2\]$_DFFE_PP_ clknet_leaf_48_clk_net
+ _02137_ _01486_ VSS VSS VDD VDD network.neuron_in018.counter\[2\]
+ sky130_fd_sc_hd__edfxtp_1
Xnetwork.neuron_in018.counter\[3\]$_DFFE_PP_ clknet_leaf_48_clk_net
+ _02138_ _01486_ VSS VSS VDD VDD network.neuron_in018.counter\[3\]
+ sky130_fd_sc_hd__edfxtp_1
Xnetwork.neuron_in018.spike$_SDFFE_PP0P_ clknet_leaf_49_clk_net
+ _01847_ VSS VSS VDD VDD network.in_spk02_01 sky130_fd_sc_hd__dfxtp_1
Xnetwork.neuron_in019.counter\[0\]$_DFFE_PP_ clknet_leaf_49_clk_net
+ _02139_ _01485_ VSS VSS VDD VDD network.neuron_in019.counter\[0\]
+ sky130_fd_sc_hd__edfxtp_1
Xnetwork.neuron_in019.counter\[1\]$_DFFE_PP_ clknet_leaf_49_clk_net
+ _02140_ _01485_ VSS VSS VDD VDD network.neuron_in019.counter\[1\]
+ sky130_fd_sc_hd__edfxtp_1
Xnetwork.neuron_in019.counter\[2\]$_DFFE_PP_ clknet_leaf_48_clk_net
+ _02141_ _01485_ VSS VSS VDD VDD network.neuron_in019.counter\[2\]
+ sky130_fd_sc_hd__edfxtp_1
Xnetwork.neuron_in019.counter\[3\]$_DFFE_PP_ clknet_leaf_49_clk_net
+ _02142_ _01485_ VSS VSS VDD VDD network.neuron_in019.counter\[3\]
+ sky130_fd_sc_hd__edfxtp_1
Xnetwork.neuron_in019.spike$_SDFFE_PP0P_ clknet_leaf_49_clk_net
+ _01846_ VSS VSS VDD VDD network.in_spk03_01 sky130_fd_sc_hd__dfxtp_1
Xnetwork.neuron_in020.counter\[0\]$_DFFE_PP_ clknet_leaf_45_clk_net
+ _02143_ _01484_ VSS VSS VDD VDD network.neuron_in020.counter\[0\]
+ sky130_fd_sc_hd__edfxtp_1
Xnetwork.neuron_in020.counter\[1\]$_DFFE_PP_ clknet_leaf_45_clk_net
+ _02144_ _01484_ VSS VSS VDD VDD network.neuron_in020.counter\[1\]
+ sky130_fd_sc_hd__edfxtp_1
Xnetwork.neuron_in020.counter\[2\]$_DFFE_PP_ clknet_leaf_45_clk_net
+ _02145_ _01484_ VSS VSS VDD VDD network.neuron_in020.counter\[2\]
+ sky130_fd_sc_hd__edfxtp_1
Xnetwork.neuron_in020.counter\[3\]$_DFFE_PP_ clknet_leaf_45_clk_net
+ _02146_ _01484_ VSS VSS VDD VDD network.neuron_in020.counter\[3\]
+ sky130_fd_sc_hd__edfxtp_1
Xnetwork.neuron_in020.spike$_SDFFE_PP0P_ clknet_leaf_46_clk_net
+ _01845_ VSS VSS VDD VDD network.in_spk04_01 sky130_fd_sc_hd__dfxtp_1
Xnetwork.neuron_in021.counter\[0\]$_DFFE_PP_ clknet_leaf_44_clk_net
+ _02147_ _01483_ VSS VSS VDD VDD network.neuron_in021.counter\[0\]
+ sky130_fd_sc_hd__edfxtp_1
Xnetwork.neuron_in021.counter\[1\]$_DFFE_PP_ clknet_leaf_43_clk_net
+ _02148_ _01483_ VSS VSS VDD VDD network.neuron_in021.counter\[1\]
+ sky130_fd_sc_hd__edfxtp_1
Xnetwork.neuron_in021.counter\[2\]$_DFFE_PP_ clknet_leaf_44_clk_net
+ _02149_ _01483_ VSS VSS VDD VDD network.neuron_in021.counter\[2\]
+ sky130_fd_sc_hd__edfxtp_1
Xnetwork.neuron_in021.counter\[3\]$_DFFE_PP_ clknet_leaf_44_clk_net
+ _02150_ _01483_ VSS VSS VDD VDD network.neuron_in021.counter\[3\]
+ sky130_fd_sc_hd__edfxtp_1
Xnetwork.neuron_in021.spike$_SDFFE_PP0P_ clknet_leaf_46_clk_net
+ _01844_ VSS VSS VDD VDD network.in_spk05_01 sky130_fd_sc_hd__dfxtp_1
Xnetwork.neuron_in022.counter\[0\]$_DFFE_PP_ clknet_leaf_45_clk_net
+ _02151_ _01482_ VSS VSS VDD VDD network.neuron_in022.counter\[0\]
+ sky130_fd_sc_hd__edfxtp_1
Xnetwork.neuron_in022.counter\[1\]$_DFFE_PP_ clknet_leaf_45_clk_net
+ _02152_ _01482_ VSS VSS VDD VDD network.neuron_in022.counter\[1\]
+ sky130_fd_sc_hd__edfxtp_1
Xnetwork.neuron_in022.counter\[2\]$_DFFE_PP_ clknet_leaf_46_clk_net
+ _02153_ _01482_ VSS VSS VDD VDD network.neuron_in022.counter\[2\]
+ sky130_fd_sc_hd__edfxtp_1
Xnetwork.neuron_in022.counter\[3\]$_DFFE_PP_ clknet_leaf_45_clk_net
+ _02154_ _01482_ VSS VSS VDD VDD network.neuron_in022.counter\[3\]
+ sky130_fd_sc_hd__edfxtp_1
Xnetwork.neuron_in022.spike$_SDFFE_PP0P_ clknet_leaf_47_clk_net
+ _01843_ VSS VSS VDD VDD network.in_spk06_01 sky130_fd_sc_hd__dfxtp_1
Xnetwork.neuron_in023.counter\[0\]$_DFFE_PP_ clknet_leaf_44_clk_net
+ _02155_ _01481_ VSS VSS VDD VDD network.neuron_in023.counter\[0\]
+ sky130_fd_sc_hd__edfxtp_1
Xnetwork.neuron_in023.counter\[1\]$_DFFE_PP_ clknet_leaf_45_clk_net
+ _02156_ _01481_ VSS VSS VDD VDD network.neuron_in023.counter\[1\]
+ sky130_fd_sc_hd__edfxtp_1
Xnetwork.neuron_in023.counter\[2\]$_DFFE_PP_ clknet_leaf_45_clk_net
+ _02157_ _01481_ VSS VSS VDD VDD network.neuron_in023.counter\[2\]
+ sky130_fd_sc_hd__edfxtp_1
Xnetwork.neuron_in023.counter\[3\]$_DFFE_PP_ clknet_leaf_45_clk_net
+ _02158_ _01481_ VSS VSS VDD VDD network.neuron_in023.counter\[3\]
+ sky130_fd_sc_hd__edfxtp_1
Xnetwork.neuron_in023.spike$_SDFFE_PP0P_ clknet_leaf_49_clk_net
+ _01842_ VSS VSS VDD VDD network.in_spk07_01 sky130_fd_sc_hd__dfxtp_1
Xnetwork.neuron_in024.counter\[0\]$_DFFE_PP_ clknet_leaf_36_clk_net
+ _02159_ _01480_ VSS VSS VDD VDD network.neuron_in024.counter\[0\]
+ sky130_fd_sc_hd__edfxtp_1
Xnetwork.neuron_in024.counter\[1\]$_DFFE_PP_ clknet_leaf_42_clk_net
+ _02160_ _01480_ VSS VSS VDD VDD network.neuron_in024.counter\[1\]
+ sky130_fd_sc_hd__edfxtp_1
Xnetwork.neuron_in024.counter\[2\]$_DFFE_PP_ clknet_leaf_42_clk_net
+ _02161_ _01480_ VSS VSS VDD VDD network.neuron_in024.counter\[2\]
+ sky130_fd_sc_hd__edfxtp_1
Xnetwork.neuron_in024.counter\[3\]$_DFFE_PP_ clknet_leaf_42_clk_net
+ _02162_ _01480_ VSS VSS VDD VDD network.neuron_in024.counter\[3\]
+ sky130_fd_sc_hd__edfxtp_1
Xnetwork.neuron_in024.spike$_SDFFE_PP0P_ clknet_leaf_40_clk_net
+ _01841_ VSS VSS VDD VDD network.in_spk08_01 sky130_fd_sc_hd__dfxtp_1
Xnetwork.neuron_in025.counter\[0\]$_DFFE_PP_ clknet_leaf_43_clk_net
+ _02163_ _01479_ VSS VSS VDD VDD network.neuron_in025.counter\[0\]
+ sky130_fd_sc_hd__edfxtp_1
Xnetwork.neuron_in025.counter\[1\]$_DFFE_PP_ clknet_leaf_43_clk_net
+ _02164_ _01479_ VSS VSS VDD VDD network.neuron_in025.counter\[1\]
+ sky130_fd_sc_hd__edfxtp_1
Xnetwork.neuron_in025.counter\[2\]$_DFFE_PP_ clknet_leaf_42_clk_net
+ _02165_ _01479_ VSS VSS VDD VDD network.neuron_in025.counter\[2\]
+ sky130_fd_sc_hd__edfxtp_1
Xnetwork.neuron_in025.counter\[3\]$_DFFE_PP_ clknet_leaf_42_clk_net
+ _02166_ _01479_ VSS VSS VDD VDD network.neuron_in025.counter\[3\]
+ sky130_fd_sc_hd__edfxtp_1
Xnetwork.neuron_in025.spike$_SDFFE_PP0P_ clknet_leaf_40_clk_net
+ _01840_ VSS VSS VDD VDD network.in_spk09_01 sky130_fd_sc_hd__dfxtp_1
Xnetwork.neuron_in026.counter\[0\]$_DFFE_PP_ clknet_leaf_43_clk_net
+ _02167_ _01478_ VSS VSS VDD VDD network.neuron_in026.counter\[0\]
+ sky130_fd_sc_hd__edfxtp_1
Xnetwork.neuron_in026.counter\[1\]$_DFFE_PP_ clknet_leaf_43_clk_net
+ _02168_ _01478_ VSS VSS VDD VDD network.neuron_in026.counter\[1\]
+ sky130_fd_sc_hd__edfxtp_1
Xnetwork.neuron_in026.counter\[2\]$_DFFE_PP_ clknet_leaf_41_clk_net
+ _02169_ _01478_ VSS VSS VDD VDD network.neuron_in026.counter\[2\]
+ sky130_fd_sc_hd__edfxtp_1
Xnetwork.neuron_in026.counter\[3\]$_DFFE_PP_ clknet_leaf_41_clk_net
+ _02170_ _01478_ VSS VSS VDD VDD network.neuron_in026.counter\[3\]
+ sky130_fd_sc_hd__edfxtp_1
Xnetwork.neuron_in026.spike$_SDFFE_PP0P_ clknet_leaf_40_clk_net
+ _01839_ VSS VSS VDD VDD network.in_spk10_01 sky130_fd_sc_hd__dfxtp_1
Xnetwork.neuron_in027.counter\[0\]$_DFFE_PP_ clknet_leaf_44_clk_net
+ _02171_ _01477_ VSS VSS VDD VDD network.neuron_in027.counter\[0\]
+ sky130_fd_sc_hd__edfxtp_1
Xnetwork.neuron_in027.counter\[1\]$_DFFE_PP_ clknet_leaf_44_clk_net
+ _02172_ _01477_ VSS VSS VDD VDD network.neuron_in027.counter\[1\]
+ sky130_fd_sc_hd__edfxtp_1
Xnetwork.neuron_in027.counter\[2\]$_DFFE_PP_ clknet_leaf_43_clk_net
+ _02173_ _01477_ VSS VSS VDD VDD network.neuron_in027.counter\[2\]
+ sky130_fd_sc_hd__edfxtp_1
Xnetwork.neuron_in027.counter\[3\]$_DFFE_PP_ clknet_leaf_44_clk_net
+ _02174_ _01477_ VSS VSS VDD VDD network.neuron_in027.counter\[3\]
+ sky130_fd_sc_hd__edfxtp_1
Xnetwork.neuron_in027.spike$_SDFFE_PP0P_ clknet_leaf_40_clk_net
+ _01838_ VSS VSS VDD VDD network.in_spk11_01 sky130_fd_sc_hd__dfxtp_1
Xnetwork.neuron_in028.counter\[0\]$_DFFE_PP_ clknet_leaf_43_clk_net
+ _02175_ _01476_ VSS VSS VDD VDD network.neuron_in028.counter\[0\]
+ sky130_fd_sc_hd__edfxtp_1
Xnetwork.neuron_in028.counter\[1\]$_DFFE_PP_ clknet_leaf_43_clk_net
+ _02176_ _01476_ VSS VSS VDD VDD network.neuron_in028.counter\[1\]
+ sky130_fd_sc_hd__edfxtp_1
Xnetwork.neuron_in028.counter\[2\]$_DFFE_PP_ clknet_leaf_42_clk_net
+ _02177_ _01476_ VSS VSS VDD VDD network.neuron_in028.counter\[2\]
+ sky130_fd_sc_hd__edfxtp_1
Xnetwork.neuron_in028.counter\[3\]$_DFFE_PP_ clknet_leaf_43_clk_net
+ _02178_ _01476_ VSS VSS VDD VDD network.neuron_in028.counter\[3\]
+ sky130_fd_sc_hd__edfxtp_1
Xnetwork.neuron_in028.spike$_SDFFE_PP0P_ clknet_leaf_41_clk_net
+ _01837_ VSS VSS VDD VDD network.in_spk12_01 sky130_fd_sc_hd__dfxtp_1
Xnetwork.neuron_in029.counter\[0\]$_DFFE_PP_ clknet_leaf_46_clk_net
+ _02179_ _01475_ VSS VSS VDD VDD network.neuron_in029.counter\[0\]
+ sky130_fd_sc_hd__edfxtp_1
Xnetwork.neuron_in029.counter\[1\]$_DFFE_PP_ clknet_leaf_46_clk_net
+ _02180_ _01475_ VSS VSS VDD VDD network.neuron_in029.counter\[1\]
+ sky130_fd_sc_hd__edfxtp_1
Xnetwork.neuron_in029.counter\[2\]$_DFFE_PP_ clknet_leaf_46_clk_net
+ _02181_ _01475_ VSS VSS VDD VDD network.neuron_in029.counter\[2\]
+ sky130_fd_sc_hd__edfxtp_1
Xnetwork.neuron_in029.counter\[3\]$_DFFE_PP_ clknet_leaf_46_clk_net
+ _02182_ _01475_ VSS VSS VDD VDD network.neuron_in029.counter\[3\]
+ sky130_fd_sc_hd__edfxtp_1
Xnetwork.neuron_in029.spike$_SDFFE_PP0P_ clknet_leaf_46_clk_net
+ _01836_ VSS VSS VDD VDD network.in_spk13_01 sky130_fd_sc_hd__dfxtp_1
Xnetwork.neuron_in030.counter\[0\]$_DFFE_PP_ clknet_leaf_47_clk_net
+ _02183_ _01474_ VSS VSS VDD VDD network.neuron_in030.counter\[0\]
+ sky130_fd_sc_hd__edfxtp_1
Xnetwork.neuron_in030.counter\[1\]$_DFFE_PP_ clknet_leaf_46_clk_net
+ _02184_ _01474_ VSS VSS VDD VDD network.neuron_in030.counter\[1\]
+ sky130_fd_sc_hd__edfxtp_1
Xnetwork.neuron_in030.counter\[2\]$_DFFE_PP_ clknet_leaf_47_clk_net
+ _02185_ _01474_ VSS VSS VDD VDD network.neuron_in030.counter\[2\]
+ sky130_fd_sc_hd__edfxtp_1
Xnetwork.neuron_in030.counter\[3\]$_DFFE_PP_ clknet_leaf_47_clk_net
+ _02186_ _01474_ VSS VSS VDD VDD network.neuron_in030.counter\[3\]
+ sky130_fd_sc_hd__edfxtp_1
Xnetwork.neuron_in030.spike$_SDFFE_PP0P_ clknet_leaf_50_clk_net
+ _01835_ VSS VSS VDD VDD network.in_spk14_01 sky130_fd_sc_hd__dfxtp_1
Xnetwork.neuron_in031.counter\[0\]$_DFFE_PP_ clknet_leaf_42_clk_net
+ _02187_ _01473_ VSS VSS VDD VDD network.neuron_in031.counter\[0\]
+ sky130_fd_sc_hd__edfxtp_1
Xnetwork.neuron_in031.counter\[1\]$_DFFE_PP_ clknet_leaf_42_clk_net
+ _02188_ _01473_ VSS VSS VDD VDD network.neuron_in031.counter\[1\]
+ sky130_fd_sc_hd__edfxtp_1
Xnetwork.neuron_in031.counter\[2\]$_DFFE_PP_ clknet_leaf_41_clk_net
+ _02189_ _01473_ VSS VSS VDD VDD network.neuron_in031.counter\[2\]
+ sky130_fd_sc_hd__edfxtp_1
Xnetwork.neuron_in031.counter\[3\]$_DFFE_PP_ clknet_leaf_41_clk_net
+ _02190_ _01473_ VSS VSS VDD VDD network.neuron_in031.counter\[3\]
+ sky130_fd_sc_hd__edfxtp_1
Xnetwork.neuron_in031.spike$_SDFFE_PP0P_ clknet_leaf_41_clk_net
+ _01834_ VSS VSS VDD VDD network.in_spk15_01 sky130_fd_sc_hd__dfxtp_1
Xnetwork.neuron_in032.counter\[0\]$_DFFE_PP_ clknet_leaf_62_clk_net
+ _02191_ _01472_ VSS VSS VDD VDD network.neuron_in032.counter\[0\]
+ sky130_fd_sc_hd__edfxtp_1
Xnetwork.neuron_in032.counter\[1\]$_DFFE_PP_ clknet_leaf_62_clk_net
+ _02192_ _01472_ VSS VSS VDD VDD network.neuron_in032.counter\[1\]
+ sky130_fd_sc_hd__edfxtp_1
Xnetwork.neuron_in032.counter\[2\]$_DFFE_PP_ clknet_leaf_66_clk_net
+ _02193_ _01472_ VSS VSS VDD VDD network.neuron_in032.counter\[2\]
+ sky130_fd_sc_hd__edfxtp_1
Xnetwork.neuron_in032.counter\[3\]$_DFFE_PP_ clknet_leaf_66_clk_net
+ _02194_ _01472_ VSS VSS VDD VDD network.neuron_in032.counter\[3\]
+ sky130_fd_sc_hd__edfxtp_1
Xnetwork.neuron_in032.spike$_SDFFE_PP0P_ clknet_leaf_60_clk_net
+ _01833_ VSS VSS VDD VDD network.in_spk00_02 sky130_fd_sc_hd__dfxtp_1
Xnetwork.neuron_in033.counter\[0\]$_DFFE_PP_ clknet_leaf_22_clk_net
+ _02195_ _01471_ VSS VSS VDD VDD network.neuron_in033.counter\[0\]
+ sky130_fd_sc_hd__edfxtp_1
Xnetwork.neuron_in033.counter\[1\]$_DFFE_PP_ clknet_leaf_22_clk_net
+ _02196_ _01471_ VSS VSS VDD VDD network.neuron_in033.counter\[1\]
+ sky130_fd_sc_hd__edfxtp_1
Xnetwork.neuron_in033.counter\[2\]$_DFFE_PP_ clknet_leaf_22_clk_net
+ _02197_ _01471_ VSS VSS VDD VDD network.neuron_in033.counter\[2\]
+ sky130_fd_sc_hd__edfxtp_1
Xnetwork.neuron_in033.counter\[3\]$_DFFE_PP_ clknet_leaf_22_clk_net
+ _02198_ _01471_ VSS VSS VDD VDD network.neuron_in033.counter\[3\]
+ sky130_fd_sc_hd__edfxtp_1
Xnetwork.neuron_in033.spike$_SDFFE_PP0P_ clknet_leaf_60_clk_net
+ _01832_ VSS VSS VDD VDD network.in_spk01_02 sky130_fd_sc_hd__dfxtp_1
Xnetwork.neuron_in034.counter\[0\]$_DFFE_PP_ clknet_leaf_61_clk_net
+ _02199_ _01470_ VSS VSS VDD VDD network.neuron_in034.counter\[0\]
+ sky130_fd_sc_hd__edfxtp_1
Xnetwork.neuron_in034.counter\[1\]$_DFFE_PP_ clknet_leaf_61_clk_net
+ _02200_ _01470_ VSS VSS VDD VDD network.neuron_in034.counter\[1\]
+ sky130_fd_sc_hd__edfxtp_1
Xnetwork.neuron_in034.counter\[2\]$_DFFE_PP_ clknet_leaf_61_clk_net
+ _02201_ _01470_ VSS VSS VDD VDD network.neuron_in034.counter\[2\]
+ sky130_fd_sc_hd__edfxtp_1
Xnetwork.neuron_in034.counter\[3\]$_DFFE_PP_ clknet_leaf_61_clk_net
+ _02202_ _01470_ VSS VSS VDD VDD network.neuron_in034.counter\[3\]
+ sky130_fd_sc_hd__edfxtp_1
Xnetwork.neuron_in034.spike$_SDFFE_PP0P_ clknet_leaf_60_clk_net
+ _01831_ VSS VSS VDD VDD network.in_spk02_02 sky130_fd_sc_hd__dfxtp_1
Xnetwork.neuron_in035.counter\[0\]$_DFFE_PP_ clknet_leaf_60_clk_net
+ _02203_ _01469_ VSS VSS VDD VDD network.neuron_in035.counter\[0\]
+ sky130_fd_sc_hd__edfxtp_1
Xnetwork.neuron_in035.counter\[1\]$_DFFE_PP_ clknet_leaf_60_clk_net
+ _02204_ _01469_ VSS VSS VDD VDD network.neuron_in035.counter\[1\]
+ sky130_fd_sc_hd__edfxtp_1
Xnetwork.neuron_in035.counter\[2\]$_DFFE_PP_ clknet_leaf_59_clk_net
+ _02205_ _01469_ VSS VSS VDD VDD network.neuron_in035.counter\[2\]
+ sky130_fd_sc_hd__edfxtp_1
Xnetwork.neuron_in035.counter\[3\]$_DFFE_PP_ clknet_leaf_59_clk_net
+ _02206_ _01469_ VSS VSS VDD VDD network.neuron_in035.counter\[3\]
+ sky130_fd_sc_hd__edfxtp_1
Xnetwork.neuron_in035.spike$_SDFFE_PP0P_ clknet_leaf_60_clk_net
+ _01830_ VSS VSS VDD VDD network.in_spk03_02 sky130_fd_sc_hd__dfxtp_1
Xnetwork.neuron_in036.counter\[0\]$_DFFE_PP_ clknet_leaf_62_clk_net
+ _02207_ _01468_ VSS VSS VDD VDD network.neuron_in036.counter\[0\]
+ sky130_fd_sc_hd__edfxtp_1
Xnetwork.neuron_in036.counter\[1\]$_DFFE_PP_ clknet_leaf_62_clk_net
+ _02208_ _01468_ VSS VSS VDD VDD network.neuron_in036.counter\[1\]
+ sky130_fd_sc_hd__edfxtp_1
Xnetwork.neuron_in036.counter\[2\]$_DFFE_PP_ clknet_leaf_62_clk_net
+ _02209_ _01468_ VSS VSS VDD VDD network.neuron_in036.counter\[2\]
+ sky130_fd_sc_hd__edfxtp_1
Xnetwork.neuron_in036.counter\[3\]$_DFFE_PP_ clknet_leaf_62_clk_net
+ _02210_ _01468_ VSS VSS VDD VDD network.neuron_in036.counter\[3\]
+ sky130_fd_sc_hd__edfxtp_1
Xnetwork.neuron_in036.spike$_SDFFE_PP0P_ clknet_leaf_60_clk_net
+ _01829_ VSS VSS VDD VDD network.in_spk04_02 sky130_fd_sc_hd__dfxtp_1
Xnetwork.neuron_in037.counter\[0\]$_DFFE_PP_ clknet_leaf_63_clk_net
+ _02211_ _01467_ VSS VSS VDD VDD network.neuron_in037.counter\[0\]
+ sky130_fd_sc_hd__edfxtp_1
Xnetwork.neuron_in037.counter\[1\]$_DFFE_PP_ clknet_leaf_62_clk_net
+ _02212_ _01467_ VSS VSS VDD VDD network.neuron_in037.counter\[1\]
+ sky130_fd_sc_hd__edfxtp_1
Xnetwork.neuron_in037.counter\[2\]$_DFFE_PP_ clknet_leaf_61_clk_net
+ _02213_ _01467_ VSS VSS VDD VDD network.neuron_in037.counter\[2\]
+ sky130_fd_sc_hd__edfxtp_1
Xnetwork.neuron_in037.counter\[3\]$_DFFE_PP_ clknet_leaf_63_clk_net
+ _02214_ _01467_ VSS VSS VDD VDD network.neuron_in037.counter\[3\]
+ sky130_fd_sc_hd__edfxtp_1
Xnetwork.neuron_in037.spike$_SDFFE_PP0P_ clknet_leaf_63_clk_net
+ _01828_ VSS VSS VDD VDD network.in_spk05_02 sky130_fd_sc_hd__dfxtp_1
Xnetwork.neuron_in038.counter\[0\]$_DFFE_PP_ clknet_leaf_65_clk_net
+ _02215_ _01466_ VSS VSS VDD VDD network.neuron_in038.counter\[0\]
+ sky130_fd_sc_hd__edfxtp_1
Xnetwork.neuron_in038.counter\[1\]$_DFFE_PP_ clknet_leaf_65_clk_net
+ _02216_ _01466_ VSS VSS VDD VDD network.neuron_in038.counter\[1\]
+ sky130_fd_sc_hd__edfxtp_1
Xnetwork.neuron_in038.counter\[2\]$_DFFE_PP_ clknet_leaf_66_clk_net
+ _02217_ _01466_ VSS VSS VDD VDD network.neuron_in038.counter\[2\]
+ sky130_fd_sc_hd__edfxtp_1
Xnetwork.neuron_in038.counter\[3\]$_DFFE_PP_ clknet_leaf_66_clk_net
+ _02218_ _01466_ VSS VSS VDD VDD network.neuron_in038.counter\[3\]
+ sky130_fd_sc_hd__edfxtp_1
Xnetwork.neuron_in038.spike$_SDFFE_PP0P_ clknet_leaf_63_clk_net
+ _01827_ VSS VSS VDD VDD network.in_spk06_02 sky130_fd_sc_hd__dfxtp_1
Xnetwork.neuron_in039.counter\[0\]$_DFFE_PP_ clknet_leaf_64_clk_net
+ _02219_ _01465_ VSS VSS VDD VDD network.neuron_in039.counter\[0\]
+ sky130_fd_sc_hd__edfxtp_1
Xnetwork.neuron_in039.counter\[1\]$_DFFE_PP_ clknet_leaf_64_clk_net
+ _02220_ _01465_ VSS VSS VDD VDD network.neuron_in039.counter\[1\]
+ sky130_fd_sc_hd__edfxtp_1
Xnetwork.neuron_in039.counter\[2\]$_DFFE_PP_ clknet_leaf_64_clk_net
+ _02221_ _01465_ VSS VSS VDD VDD network.neuron_in039.counter\[2\]
+ sky130_fd_sc_hd__edfxtp_1
Xnetwork.neuron_in039.counter\[3\]$_DFFE_PP_ clknet_leaf_64_clk_net
+ _02222_ _01465_ VSS VSS VDD VDD network.neuron_in039.counter\[3\]
+ sky130_fd_sc_hd__edfxtp_1
Xnetwork.neuron_in039.spike$_SDFFE_PP0P_ clknet_leaf_63_clk_net
+ _01826_ VSS VSS VDD VDD network.in_spk07_02 sky130_fd_sc_hd__dfxtp_1
Xnetwork.neuron_in040.counter\[0\]$_DFFE_PP_ clknet_leaf_23_clk_net
+ _02223_ _01464_ VSS VSS VDD VDD network.neuron_in040.counter\[0\]
+ sky130_fd_sc_hd__edfxtp_1
Xnetwork.neuron_in040.counter\[1\]$_DFFE_PP_ clknet_leaf_23_clk_net
+ _02224_ _01464_ VSS VSS VDD VDD network.neuron_in040.counter\[1\]
+ sky130_fd_sc_hd__edfxtp_1
Xnetwork.neuron_in040.counter\[2\]$_DFFE_PP_ clknet_leaf_64_clk_net
+ _02225_ _01464_ VSS VSS VDD VDD network.neuron_in040.counter\[2\]
+ sky130_fd_sc_hd__edfxtp_1
Xnetwork.neuron_in040.counter\[3\]$_DFFE_PP_ clknet_leaf_64_clk_net
+ _02226_ _01464_ VSS VSS VDD VDD network.neuron_in040.counter\[3\]
+ sky130_fd_sc_hd__edfxtp_1
Xnetwork.neuron_in040.spike$_SDFFE_PP0P_ clknet_leaf_63_clk_net
+ _01825_ VSS VSS VDD VDD network.in_spk08_02 sky130_fd_sc_hd__dfxtp_1
Xnetwork.neuron_in041.counter\[0\]$_DFFE_PP_ clknet_leaf_62_clk_net
+ _02227_ _01463_ VSS VSS VDD VDD network.neuron_in041.counter\[0\]
+ sky130_fd_sc_hd__edfxtp_1
Xnetwork.neuron_in041.counter\[1\]$_DFFE_PP_ clknet_leaf_62_clk_net
+ _02228_ _01463_ VSS VSS VDD VDD network.neuron_in041.counter\[1\]
+ sky130_fd_sc_hd__edfxtp_1
Xnetwork.neuron_in041.counter\[2\]$_DFFE_PP_ clknet_leaf_64_clk_net
+ _02229_ _01463_ VSS VSS VDD VDD network.neuron_in041.counter\[2\]
+ sky130_fd_sc_hd__edfxtp_1
Xnetwork.neuron_in041.counter\[3\]$_DFFE_PP_ clknet_leaf_64_clk_net
+ _02230_ _01463_ VSS VSS VDD VDD network.neuron_in041.counter\[3\]
+ sky130_fd_sc_hd__edfxtp_1
Xnetwork.neuron_in041.spike$_SDFFE_PP0P_ clknet_leaf_63_clk_net
+ _01824_ VSS VSS VDD VDD network.in_spk09_02 sky130_fd_sc_hd__dfxtp_1
Xnetwork.neuron_in042.counter\[0\]$_DFFE_PP_ clknet_leaf_61_clk_net
+ _02231_ _01462_ VSS VSS VDD VDD network.neuron_in042.counter\[0\]
+ sky130_fd_sc_hd__edfxtp_1
Xnetwork.neuron_in042.counter\[1\]$_DFFE_PP_ clknet_leaf_61_clk_net
+ _02232_ _01462_ VSS VSS VDD VDD network.neuron_in042.counter\[1\]
+ sky130_fd_sc_hd__edfxtp_1
Xnetwork.neuron_in042.counter\[2\]$_DFFE_PP_ clknet_leaf_60_clk_net
+ _02233_ _01462_ VSS VSS VDD VDD network.neuron_in042.counter\[2\]
+ sky130_fd_sc_hd__edfxtp_1
Xnetwork.neuron_in042.counter\[3\]$_DFFE_PP_ clknet_leaf_61_clk_net
+ _02234_ _01462_ VSS VSS VDD VDD network.neuron_in042.counter\[3\]
+ sky130_fd_sc_hd__edfxtp_1
Xnetwork.neuron_in042.spike$_SDFFE_PP0P_ clknet_leaf_60_clk_net
+ _01823_ VSS VSS VDD VDD network.in_spk10_02 sky130_fd_sc_hd__dfxtp_1
Xnetwork.neuron_in043.counter\[0\]$_DFFE_PP_ clknet_leaf_23_clk_net
+ _02235_ _01461_ VSS VSS VDD VDD network.neuron_in043.counter\[0\]
+ sky130_fd_sc_hd__edfxtp_1
Xnetwork.neuron_in043.counter\[1\]$_DFFE_PP_ clknet_leaf_23_clk_net
+ _02236_ _01461_ VSS VSS VDD VDD network.neuron_in043.counter\[1\]
+ sky130_fd_sc_hd__edfxtp_1
Xnetwork.neuron_in043.counter\[2\]$_DFFE_PP_ clknet_leaf_23_clk_net
+ _02237_ _01461_ VSS VSS VDD VDD network.neuron_in043.counter\[2\]
+ sky130_fd_sc_hd__edfxtp_1
Xnetwork.neuron_in043.counter\[3\]$_DFFE_PP_ clknet_leaf_23_clk_net
+ _02238_ _01461_ VSS VSS VDD VDD network.neuron_in043.counter\[3\]
+ sky130_fd_sc_hd__edfxtp_1
Xnetwork.neuron_in043.spike$_SDFFE_PP0P_ clknet_leaf_63_clk_net
+ _01822_ VSS VSS VDD VDD network.in_spk11_02 sky130_fd_sc_hd__dfxtp_1
Xnetwork.neuron_in044.counter\[0\]$_DFFE_PP_ clknet_leaf_23_clk_net
+ _02239_ _01460_ VSS VSS VDD VDD network.neuron_in044.counter\[0\]
+ sky130_fd_sc_hd__edfxtp_1
Xnetwork.neuron_in044.counter\[1\]$_DFFE_PP_ clknet_leaf_23_clk_net
+ _02240_ _01460_ VSS VSS VDD VDD network.neuron_in044.counter\[1\]
+ sky130_fd_sc_hd__edfxtp_1
Xnetwork.neuron_in044.counter\[2\]$_DFFE_PP_ clknet_leaf_23_clk_net
+ _02241_ _01460_ VSS VSS VDD VDD network.neuron_in044.counter\[2\]
+ sky130_fd_sc_hd__edfxtp_1
Xnetwork.neuron_in044.counter\[3\]$_DFFE_PP_ clknet_leaf_23_clk_net
+ _02242_ _01460_ VSS VSS VDD VDD network.neuron_in044.counter\[3\]
+ sky130_fd_sc_hd__edfxtp_1
Xnetwork.neuron_in044.spike$_SDFFE_PP0P_ clknet_leaf_24_clk_net
+ _01821_ VSS VSS VDD VDD network.in_spk12_02 sky130_fd_sc_hd__dfxtp_1
Xnetwork.neuron_in045.counter\[0\]$_DFFE_PP_ clknet_leaf_26_clk_net
+ _02243_ _01459_ VSS VSS VDD VDD network.neuron_in045.counter\[0\]
+ sky130_fd_sc_hd__edfxtp_1
Xnetwork.neuron_in045.counter\[1\]$_DFFE_PP_ clknet_leaf_25_clk_net
+ _02244_ _01459_ VSS VSS VDD VDD network.neuron_in045.counter\[1\]
+ sky130_fd_sc_hd__edfxtp_1
Xnetwork.neuron_in045.counter\[2\]$_DFFE_PP_ clknet_leaf_26_clk_net
+ _02245_ _01459_ VSS VSS VDD VDD network.neuron_in045.counter\[2\]
+ sky130_fd_sc_hd__edfxtp_1
Xnetwork.neuron_in045.counter\[3\]$_DFFE_PP_ clknet_leaf_25_clk_net
+ _02246_ _01459_ VSS VSS VDD VDD network.neuron_in045.counter\[3\]
+ sky130_fd_sc_hd__edfxtp_1
Xnetwork.neuron_in045.spike$_SDFFE_PP0P_ clknet_leaf_26_clk_net
+ _01820_ VSS VSS VDD VDD network.in_spk13_02 sky130_fd_sc_hd__dfxtp_1
Xnetwork.neuron_in046.counter\[0\]$_DFFE_PP_ clknet_leaf_21_clk_net
+ _02247_ _01458_ VSS VSS VDD VDD network.neuron_in046.counter\[0\]
+ sky130_fd_sc_hd__edfxtp_1
Xnetwork.neuron_in046.counter\[1\]$_DFFE_PP_ clknet_leaf_22_clk_net
+ _02248_ _01458_ VSS VSS VDD VDD network.neuron_in046.counter\[1\]
+ sky130_fd_sc_hd__edfxtp_1
Xnetwork.neuron_in046.counter\[2\]$_DFFE_PP_ clknet_leaf_22_clk_net
+ _02249_ _01458_ VSS VSS VDD VDD network.neuron_in046.counter\[2\]
+ sky130_fd_sc_hd__edfxtp_1
Xnetwork.neuron_in046.counter\[3\]$_DFFE_PP_ clknet_leaf_22_clk_net
+ _02250_ _01458_ VSS VSS VDD VDD network.neuron_in046.counter\[3\]
+ sky130_fd_sc_hd__edfxtp_1
Xnetwork.neuron_in046.spike$_SDFFE_PP0P_ clknet_leaf_24_clk_net
+ _01819_ VSS VSS VDD VDD network.in_spk14_02 sky130_fd_sc_hd__dfxtp_1
Xnetwork.neuron_in047.counter\[0\]$_DFFE_PP_ clknet_leaf_20_clk_net
+ _02251_ _01457_ VSS VSS VDD VDD network.neuron_in047.counter\[0\]
+ sky130_fd_sc_hd__edfxtp_1
Xnetwork.neuron_in047.counter\[1\]$_DFFE_PP_ clknet_leaf_24_clk_net
+ _02252_ _01457_ VSS VSS VDD VDD network.neuron_in047.counter\[1\]
+ sky130_fd_sc_hd__edfxtp_1
Xnetwork.neuron_in047.counter\[2\]$_DFFE_PP_ clknet_leaf_24_clk_net
+ _02253_ _01457_ VSS VSS VDD VDD network.neuron_in047.counter\[2\]
+ sky130_fd_sc_hd__edfxtp_1
Xnetwork.neuron_in047.counter\[3\]$_DFFE_PP_ clknet_leaf_24_clk_net
+ _02254_ _01457_ VSS VSS VDD VDD network.neuron_in047.counter\[3\]
+ sky130_fd_sc_hd__edfxtp_1
Xnetwork.neuron_in047.spike$_SDFFE_PP0P_ clknet_leaf_26_clk_net
+ _01818_ VSS VSS VDD VDD network.in_spk15_02 sky130_fd_sc_hd__dfxtp_1
Xnetwork.neuron_in048.counter\[0\]$_DFFE_PP_ clknet_leaf_41_clk_net
+ _02255_ _01456_ VSS VSS VDD VDD network.neuron_in048.counter\[0\]
+ sky130_fd_sc_hd__edfxtp_1
Xnetwork.neuron_in048.counter\[1\]$_DFFE_PP_ clknet_leaf_42_clk_net
+ _02256_ _01456_ VSS VSS VDD VDD network.neuron_in048.counter\[1\]
+ sky130_fd_sc_hd__edfxtp_1
Xnetwork.neuron_in048.counter\[2\]$_DFFE_PP_ clknet_leaf_36_clk_net
+ _02257_ _01456_ VSS VSS VDD VDD network.neuron_in048.counter\[2\]
+ sky130_fd_sc_hd__edfxtp_1
Xnetwork.neuron_in048.counter\[3\]$_DFFE_PP_ clknet_leaf_36_clk_net
+ _02258_ _01456_ VSS VSS VDD VDD network.neuron_in048.counter\[3\]
+ sky130_fd_sc_hd__edfxtp_1
Xnetwork.neuron_in048.spike$_SDFFE_PP0P_ clknet_leaf_38_clk_net
+ _01817_ VSS VSS VDD VDD network.in_spk00_03 sky130_fd_sc_hd__dfxtp_1
Xnetwork.neuron_in049.counter\[0\]$_DFFE_PP_ clknet_leaf_37_clk_net
+ _02259_ _01455_ VSS VSS VDD VDD network.neuron_in049.counter\[0\]
+ sky130_fd_sc_hd__edfxtp_1
Xnetwork.neuron_in049.counter\[1\]$_DFFE_PP_ clknet_leaf_37_clk_net
+ _02260_ _01455_ VSS VSS VDD VDD network.neuron_in049.counter\[1\]
+ sky130_fd_sc_hd__edfxtp_1
Xnetwork.neuron_in049.counter\[2\]$_DFFE_PP_ clknet_leaf_37_clk_net
+ _02261_ _01455_ VSS VSS VDD VDD network.neuron_in049.counter\[2\]
+ sky130_fd_sc_hd__edfxtp_1
Xnetwork.neuron_in049.counter\[3\]$_DFFE_PP_ clknet_leaf_37_clk_net
+ _02262_ _01455_ VSS VSS VDD VDD network.neuron_in049.counter\[3\]
+ sky130_fd_sc_hd__edfxtp_1
Xnetwork.neuron_in049.spike$_SDFFE_PP0P_ clknet_leaf_38_clk_net
+ _01816_ VSS VSS VDD VDD network.in_spk01_03 sky130_fd_sc_hd__dfxtp_1
Xnetwork.neuron_in050.counter\[0\]$_DFFE_PP_ clknet_leaf_39_clk_net
+ _02263_ _01454_ VSS VSS VDD VDD network.neuron_in050.counter\[0\]
+ sky130_fd_sc_hd__edfxtp_1
Xnetwork.neuron_in050.counter\[1\]$_DFFE_PP_ clknet_leaf_39_clk_net
+ _02264_ _01454_ VSS VSS VDD VDD network.neuron_in050.counter\[1\]
+ sky130_fd_sc_hd__edfxtp_1
Xnetwork.neuron_in050.counter\[2\]$_DFFE_PP_ clknet_leaf_39_clk_net
+ _02265_ _01454_ VSS VSS VDD VDD network.neuron_in050.counter\[2\]
+ sky130_fd_sc_hd__edfxtp_1
Xnetwork.neuron_in050.counter\[3\]$_DFFE_PP_ clknet_leaf_39_clk_net
+ _02266_ _01454_ VSS VSS VDD VDD network.neuron_in050.counter\[3\]
+ sky130_fd_sc_hd__edfxtp_1
Xnetwork.neuron_in050.spike$_SDFFE_PP0P_ clknet_leaf_28_clk_net
+ _01815_ VSS VSS VDD VDD network.in_spk02_03 sky130_fd_sc_hd__dfxtp_1
Xnetwork.neuron_in051.counter\[0\]$_DFFE_PP_ clknet_leaf_59_clk_net
+ _02267_ _01453_ VSS VSS VDD VDD network.neuron_in051.counter\[0\]
+ sky130_fd_sc_hd__edfxtp_1
Xnetwork.neuron_in051.counter\[1\]$_DFFE_PP_ clknet_leaf_59_clk_net
+ _02268_ _01453_ VSS VSS VDD VDD network.neuron_in051.counter\[1\]
+ sky130_fd_sc_hd__edfxtp_1
Xnetwork.neuron_in051.counter\[2\]$_DFFE_PP_ clknet_leaf_59_clk_net
+ _02269_ _01453_ VSS VSS VDD VDD network.neuron_in051.counter\[2\]
+ sky130_fd_sc_hd__edfxtp_1
Xnetwork.neuron_in051.counter\[3\]$_DFFE_PP_ clknet_leaf_59_clk_net
+ _02270_ _01453_ VSS VSS VDD VDD network.neuron_in051.counter\[3\]
+ sky130_fd_sc_hd__edfxtp_1
Xnetwork.neuron_in051.spike$_SDFFE_PP0P_ clknet_leaf_27_clk_net
+ _01814_ VSS VSS VDD VDD network.in_spk03_03 sky130_fd_sc_hd__dfxtp_1
Xnetwork.neuron_in052.counter\[0\]$_DFFE_PP_ clknet_leaf_39_clk_net
+ _02271_ _01452_ VSS VSS VDD VDD network.neuron_in052.counter\[0\]
+ sky130_fd_sc_hd__edfxtp_1
Xnetwork.neuron_in052.counter\[1\]$_DFFE_PP_ clknet_leaf_40_clk_net
+ _02272_ _01452_ VSS VSS VDD VDD network.neuron_in052.counter\[1\]
+ sky130_fd_sc_hd__edfxtp_1
Xnetwork.neuron_in052.counter\[2\]$_DFFE_PP_ clknet_leaf_39_clk_net
+ _02273_ _01452_ VSS VSS VDD VDD network.neuron_in052.counter\[2\]
+ sky130_fd_sc_hd__edfxtp_1
Xnetwork.neuron_in052.counter\[3\]$_DFFE_PP_ clknet_leaf_40_clk_net
+ _02274_ _01452_ VSS VSS VDD VDD network.neuron_in052.counter\[3\]
+ sky130_fd_sc_hd__edfxtp_1
Xnetwork.neuron_in052.spike$_SDFFE_PP0P_ clknet_leaf_38_clk_net
+ _01813_ VSS VSS VDD VDD network.in_spk04_03 sky130_fd_sc_hd__dfxtp_1
Xnetwork.neuron_in053.counter\[0\]$_DFFE_PP_ clknet_leaf_40_clk_net
+ _02275_ _01451_ VSS VSS VDD VDD network.neuron_in053.counter\[0\]
+ sky130_fd_sc_hd__edfxtp_1
Xnetwork.neuron_in053.counter\[1\]$_DFFE_PP_ clknet_leaf_40_clk_net
+ _02276_ _01451_ VSS VSS VDD VDD network.neuron_in053.counter\[1\]
+ sky130_fd_sc_hd__edfxtp_1
Xnetwork.neuron_in053.counter\[2\]$_DFFE_PP_ clknet_leaf_50_clk_net
+ _02277_ _01451_ VSS VSS VDD VDD network.neuron_in053.counter\[2\]
+ sky130_fd_sc_hd__edfxtp_1
Xnetwork.neuron_in053.counter\[3\]$_DFFE_PP_ clknet_leaf_40_clk_net
+ _02278_ _01451_ VSS VSS VDD VDD network.neuron_in053.counter\[3\]
+ sky130_fd_sc_hd__edfxtp_1
Xnetwork.neuron_in053.spike$_SDFFE_PP0P_ clknet_leaf_38_clk_net
+ _01812_ VSS VSS VDD VDD network.in_spk05_03 sky130_fd_sc_hd__dfxtp_1
Xnetwork.neuron_in054.counter\[0\]$_DFFE_PP_ clknet_leaf_51_clk_net
+ _02279_ _01450_ VSS VSS VDD VDD network.neuron_in054.counter\[0\]
+ sky130_fd_sc_hd__edfxtp_1
Xnetwork.neuron_in054.counter\[1\]$_DFFE_PP_ clknet_leaf_51_clk_net
+ _02280_ _01450_ VSS VSS VDD VDD network.neuron_in054.counter\[1\]
+ sky130_fd_sc_hd__edfxtp_1
Xnetwork.neuron_in054.counter\[2\]$_DFFE_PP_ clknet_leaf_51_clk_net
+ _02281_ _01450_ VSS VSS VDD VDD network.neuron_in054.counter\[2\]
+ sky130_fd_sc_hd__edfxtp_1
Xnetwork.neuron_in054.counter\[3\]$_DFFE_PP_ clknet_leaf_59_clk_net
+ _02282_ _01450_ VSS VSS VDD VDD network.neuron_in054.counter\[3\]
+ sky130_fd_sc_hd__edfxtp_1
Xnetwork.neuron_in054.spike$_SDFFE_PP0P_ clknet_leaf_27_clk_net
+ _01811_ VSS VSS VDD VDD network.in_spk06_03 sky130_fd_sc_hd__dfxtp_1
Xnetwork.neuron_in055.counter\[0\]$_DFFE_PP_ clknet_leaf_50_clk_net
+ _02283_ _01449_ VSS VSS VDD VDD network.neuron_in055.counter\[0\]
+ sky130_fd_sc_hd__edfxtp_1
Xnetwork.neuron_in055.counter\[1\]$_DFFE_PP_ clknet_leaf_50_clk_net
+ _02284_ _01449_ VSS VSS VDD VDD network.neuron_in055.counter\[1\]
+ sky130_fd_sc_hd__edfxtp_1
Xnetwork.neuron_in055.counter\[2\]$_DFFE_PP_ clknet_leaf_39_clk_net
+ _02285_ _01449_ VSS VSS VDD VDD network.neuron_in055.counter\[2\]
+ sky130_fd_sc_hd__edfxtp_1
Xnetwork.neuron_in055.counter\[3\]$_DFFE_PP_ clknet_leaf_50_clk_net
+ _02286_ _01449_ VSS VSS VDD VDD network.neuron_in055.counter\[3\]
+ sky130_fd_sc_hd__edfxtp_1
Xnetwork.neuron_in055.spike$_SDFFE_PP0P_ clknet_leaf_39_clk_net
+ _01810_ VSS VSS VDD VDD network.in_spk07_03 sky130_fd_sc_hd__dfxtp_1
Xnetwork.neuron_in056.counter\[0\]$_DFFE_PP_ clknet_leaf_38_clk_net
+ _02287_ _01448_ VSS VSS VDD VDD network.neuron_in056.counter\[0\]
+ sky130_fd_sc_hd__edfxtp_1
Xnetwork.neuron_in056.counter\[1\]$_DFFE_PP_ clknet_leaf_38_clk_net
+ _02288_ _01448_ VSS VSS VDD VDD network.neuron_in056.counter\[1\]
+ sky130_fd_sc_hd__edfxtp_1
Xnetwork.neuron_in056.counter\[2\]$_DFFE_PP_ clknet_leaf_38_clk_net
+ _02289_ _01448_ VSS VSS VDD VDD network.neuron_in056.counter\[2\]
+ sky130_fd_sc_hd__edfxtp_1
Xnetwork.neuron_in056.counter\[3\]$_DFFE_PP_ clknet_leaf_38_clk_net
+ _02290_ _01448_ VSS VSS VDD VDD network.neuron_in056.counter\[3\]
+ sky130_fd_sc_hd__edfxtp_1
Xnetwork.neuron_in056.spike$_SDFFE_PP0P_ clknet_leaf_38_clk_net
+ _01809_ VSS VSS VDD VDD network.in_spk08_03 sky130_fd_sc_hd__dfxtp_1
Xnetwork.neuron_in057.counter\[0\]$_DFFE_PP_ clknet_leaf_27_clk_net
+ _02291_ _01447_ VSS VSS VDD VDD network.neuron_in057.counter\[0\]
+ sky130_fd_sc_hd__edfxtp_1
Xnetwork.neuron_in057.counter\[1\]$_DFFE_PP_ clknet_leaf_27_clk_net
+ _02292_ _01447_ VSS VSS VDD VDD network.neuron_in057.counter\[1\]
+ sky130_fd_sc_hd__edfxtp_1
Xnetwork.neuron_in057.counter\[2\]$_DFFE_PP_ clknet_leaf_59_clk_net
+ _02293_ _01447_ VSS VSS VDD VDD network.neuron_in057.counter\[2\]
+ sky130_fd_sc_hd__edfxtp_1
Xnetwork.neuron_in057.counter\[3\]$_DFFE_PP_ clknet_leaf_59_clk_net
+ _02294_ _01447_ VSS VSS VDD VDD network.neuron_in057.counter\[3\]
+ sky130_fd_sc_hd__edfxtp_1
Xnetwork.neuron_in057.spike$_SDFFE_PP0P_ clknet_leaf_27_clk_net
+ _01808_ VSS VSS VDD VDD network.in_spk09_03 sky130_fd_sc_hd__dfxtp_1
Xnetwork.neuron_in058.counter\[0\]$_DFFE_PP_ clknet_leaf_25_clk_net
+ _02295_ _01446_ VSS VSS VDD VDD network.neuron_in058.counter\[0\]
+ sky130_fd_sc_hd__edfxtp_1
Xnetwork.neuron_in058.counter\[1\]$_DFFE_PP_ clknet_leaf_25_clk_net
+ _02296_ _01446_ VSS VSS VDD VDD network.neuron_in058.counter\[1\]
+ sky130_fd_sc_hd__edfxtp_1
Xnetwork.neuron_in058.counter\[2\]$_DFFE_PP_ clknet_leaf_25_clk_net
+ _02297_ _01446_ VSS VSS VDD VDD network.neuron_in058.counter\[2\]
+ sky130_fd_sc_hd__edfxtp_1
Xnetwork.neuron_in058.counter\[3\]$_DFFE_PP_ clknet_leaf_25_clk_net
+ _02298_ _01446_ VSS VSS VDD VDD network.neuron_in058.counter\[3\]
+ sky130_fd_sc_hd__edfxtp_1
Xnetwork.neuron_in058.spike$_SDFFE_PP0P_ clknet_leaf_27_clk_net
+ _01807_ VSS VSS VDD VDD network.in_spk10_03 sky130_fd_sc_hd__dfxtp_1
Xnetwork.neuron_in059.counter\[0\]$_DFFE_PP_ clknet_leaf_27_clk_net
+ _02299_ _01445_ VSS VSS VDD VDD network.neuron_in059.counter\[0\]
+ sky130_fd_sc_hd__edfxtp_1
Xnetwork.neuron_in059.counter\[1\]$_DFFE_PP_ clknet_leaf_27_clk_net
+ _02300_ _01445_ VSS VSS VDD VDD network.neuron_in059.counter\[1\]
+ sky130_fd_sc_hd__edfxtp_1
Xnetwork.neuron_in059.counter\[2\]$_DFFE_PP_ clknet_leaf_28_clk_net
+ _02301_ _01445_ VSS VSS VDD VDD network.neuron_in059.counter\[2\]
+ sky130_fd_sc_hd__edfxtp_1
Xnetwork.neuron_in059.counter\[3\]$_DFFE_PP_ clknet_leaf_27_clk_net
+ _02302_ _01445_ VSS VSS VDD VDD network.neuron_in059.counter\[3\]
+ sky130_fd_sc_hd__edfxtp_1
Xnetwork.neuron_in059.spike$_SDFFE_PP0P_ clknet_leaf_27_clk_net
+ _01806_ VSS VSS VDD VDD network.in_spk11_03 sky130_fd_sc_hd__dfxtp_1
Xnetwork.neuron_in060.counter\[0\]$_DFFE_PP_ clknet_leaf_37_clk_net
+ _02303_ _01444_ VSS VSS VDD VDD network.neuron_in060.counter\[0\]
+ sky130_fd_sc_hd__edfxtp_1
Xnetwork.neuron_in060.counter\[1\]$_DFFE_PP_ clknet_leaf_37_clk_net
+ _02304_ _01444_ VSS VSS VDD VDD network.neuron_in060.counter\[1\]
+ sky130_fd_sc_hd__edfxtp_1
Xnetwork.neuron_in060.counter\[2\]$_DFFE_PP_ clknet_leaf_38_clk_net
+ _02305_ _01444_ VSS VSS VDD VDD network.neuron_in060.counter\[2\]
+ sky130_fd_sc_hd__edfxtp_1
Xnetwork.neuron_in060.counter\[3\]$_DFFE_PP_ clknet_leaf_28_clk_net
+ _02306_ _01444_ VSS VSS VDD VDD network.neuron_in060.counter\[3\]
+ sky130_fd_sc_hd__edfxtp_1
Xnetwork.neuron_in060.spike$_SDFFE_PP0P_ clknet_leaf_28_clk_net
+ _01805_ VSS VSS VDD VDD network.in_spk12_03 sky130_fd_sc_hd__dfxtp_1
Xnetwork.neuron_in061.counter\[0\]$_DFFE_PP_ clknet_leaf_28_clk_net
+ _02307_ _01443_ VSS VSS VDD VDD network.neuron_in061.counter\[0\]
+ sky130_fd_sc_hd__edfxtp_1
Xnetwork.neuron_in061.counter\[1\]$_DFFE_PP_ clknet_leaf_29_clk_net
+ _02308_ _01443_ VSS VSS VDD VDD network.neuron_in061.counter\[1\]
+ sky130_fd_sc_hd__edfxtp_1
Xnetwork.neuron_in061.counter\[2\]$_DFFE_PP_ clknet_leaf_28_clk_net
+ _02309_ _01443_ VSS VSS VDD VDD network.neuron_in061.counter\[2\]
+ sky130_fd_sc_hd__edfxtp_1
Xnetwork.neuron_in061.counter\[3\]$_DFFE_PP_ clknet_leaf_28_clk_net
+ _02310_ _01443_ VSS VSS VDD VDD network.neuron_in061.counter\[3\]
+ sky130_fd_sc_hd__edfxtp_1
Xnetwork.neuron_in061.spike$_SDFFE_PP0P_ clknet_leaf_28_clk_net
+ _01804_ VSS VSS VDD VDD network.in_spk13_03 sky130_fd_sc_hd__dfxtp_1
Xnetwork.neuron_in062.counter\[0\]$_DFFE_PP_ clknet_leaf_26_clk_net
+ _02311_ _01442_ VSS VSS VDD VDD network.neuron_in062.counter\[0\]
+ sky130_fd_sc_hd__edfxtp_1
Xnetwork.neuron_in062.counter\[1\]$_DFFE_PP_ clknet_leaf_26_clk_net
+ _02312_ _01442_ VSS VSS VDD VDD network.neuron_in062.counter\[1\]
+ sky130_fd_sc_hd__edfxtp_1
Xnetwork.neuron_in062.counter\[2\]$_DFFE_PP_ clknet_leaf_26_clk_net
+ _02313_ _01442_ VSS VSS VDD VDD network.neuron_in062.counter\[2\]
+ sky130_fd_sc_hd__edfxtp_1
Xnetwork.neuron_in062.counter\[3\]$_DFFE_PP_ clknet_leaf_26_clk_net
+ _02314_ _01442_ VSS VSS VDD VDD network.neuron_in062.counter\[3\]
+ sky130_fd_sc_hd__edfxtp_1
Xnetwork.neuron_in062.spike$_SDFFE_PP0P_ clknet_leaf_28_clk_net
+ _01803_ VSS VSS VDD VDD network.in_spk14_03 sky130_fd_sc_hd__dfxtp_1
Xnetwork.neuron_in063.counter\[0\]$_DFFE_PP_ clknet_leaf_29_clk_net
+ _02315_ _01441_ VSS VSS VDD VDD network.neuron_in063.counter\[0\]
+ sky130_fd_sc_hd__edfxtp_1
Xnetwork.neuron_in063.counter\[1\]$_DFFE_PP_ clknet_leaf_29_clk_net
+ _02316_ _01441_ VSS VSS VDD VDD network.neuron_in063.counter\[1\]
+ sky130_fd_sc_hd__edfxtp_1
Xnetwork.neuron_in063.counter\[2\]$_DFFE_PP_ clknet_leaf_29_clk_net
+ _02317_ _01441_ VSS VSS VDD VDD network.neuron_in063.counter\[2\]
+ sky130_fd_sc_hd__edfxtp_1
Xnetwork.neuron_in063.counter\[3\]$_DFFE_PP_ clknet_leaf_29_clk_net
+ _02318_ _01441_ VSS VSS VDD VDD network.neuron_in063.counter\[3\]
+ sky130_fd_sc_hd__edfxtp_1
Xnetwork.neuron_in063.spike$_SDFFE_PP0P_ clknet_leaf_28_clk_net
+ _01802_ VSS VSS VDD VDD network.in_spk15_03 sky130_fd_sc_hd__dfxtp_1
Xnetwork.neuron_in064.counter\[0\]$_DFFE_PP_ clknet_leaf_19_clk_net
+ _02319_ _01440_ VSS VSS VDD VDD network.neuron_in064.counter\[0\]
+ sky130_fd_sc_hd__edfxtp_1
Xnetwork.neuron_in064.counter\[1\]$_DFFE_PP_ clknet_leaf_20_clk_net
+ _02320_ _01440_ VSS VSS VDD VDD network.neuron_in064.counter\[1\]
+ sky130_fd_sc_hd__edfxtp_1
Xnetwork.neuron_in064.counter\[2\]$_DFFE_PP_ clknet_leaf_20_clk_net
+ _02321_ _01440_ VSS VSS VDD VDD network.neuron_in064.counter\[2\]
+ sky130_fd_sc_hd__edfxtp_1
Xnetwork.neuron_in064.counter\[3\]$_DFFE_PP_ clknet_leaf_20_clk_net
+ _02322_ _01440_ VSS VSS VDD VDD network.neuron_in064.counter\[3\]
+ sky130_fd_sc_hd__edfxtp_1
Xnetwork.neuron_in064.spike$_SDFFE_PP0P_ clknet_leaf_25_clk_net
+ _01801_ VSS VSS VDD VDD network.in_spk00_04 sky130_fd_sc_hd__dfxtp_1
Xnetwork.neuron_in065.counter\[0\]$_DFFE_PP_ clknet_leaf_31_clk_net
+ _02323_ _01439_ VSS VSS VDD VDD network.neuron_in065.counter\[0\]
+ sky130_fd_sc_hd__edfxtp_1
Xnetwork.neuron_in065.counter\[1\]$_DFFE_PP_ clknet_leaf_31_clk_net
+ _02324_ _01439_ VSS VSS VDD VDD network.neuron_in065.counter\[1\]
+ sky130_fd_sc_hd__edfxtp_1
Xnetwork.neuron_in065.counter\[2\]$_DFFE_PP_ clknet_leaf_31_clk_net
+ _02325_ _01439_ VSS VSS VDD VDD network.neuron_in065.counter\[2\]
+ sky130_fd_sc_hd__edfxtp_1
Xnetwork.neuron_in065.counter\[3\]$_DFFE_PP_ clknet_leaf_31_clk_net
+ _02326_ _01439_ VSS VSS VDD VDD network.neuron_in065.counter\[3\]
+ sky130_fd_sc_hd__edfxtp_1
Xnetwork.neuron_in065.spike$_SDFFE_PP0P_ clknet_leaf_30_clk_net
+ _01800_ VSS VSS VDD VDD network.in_spk01_04 sky130_fd_sc_hd__dfxtp_1
Xnetwork.neuron_in066.counter\[0\]$_DFFE_PP_ clknet_leaf_29_clk_net
+ _02327_ _01438_ VSS VSS VDD VDD network.neuron_in066.counter\[0\]
+ sky130_fd_sc_hd__edfxtp_1
Xnetwork.neuron_in066.counter\[1\]$_DFFE_PP_ clknet_leaf_29_clk_net
+ _02328_ _01438_ VSS VSS VDD VDD network.neuron_in066.counter\[1\]
+ sky130_fd_sc_hd__edfxtp_1
Xnetwork.neuron_in066.counter\[2\]$_DFFE_PP_ clknet_leaf_25_clk_net
+ _02329_ _01438_ VSS VSS VDD VDD network.neuron_in066.counter\[2\]
+ sky130_fd_sc_hd__edfxtp_1
Xnetwork.neuron_in066.counter\[3\]$_DFFE_PP_ clknet_leaf_25_clk_net
+ _02330_ _01438_ VSS VSS VDD VDD network.neuron_in066.counter\[3\]
+ sky130_fd_sc_hd__edfxtp_1
Xnetwork.neuron_in066.spike$_SDFFE_PP0P_ clknet_leaf_25_clk_net
+ _01799_ VSS VSS VDD VDD network.in_spk02_04 sky130_fd_sc_hd__dfxtp_1
Xnetwork.neuron_in067.counter\[0\]$_DFFE_PP_ clknet_leaf_30_clk_net
+ _02331_ _01437_ VSS VSS VDD VDD network.neuron_in067.counter\[0\]
+ sky130_fd_sc_hd__edfxtp_1
Xnetwork.neuron_in067.counter\[1\]$_DFFE_PP_ clknet_leaf_31_clk_net
+ _02332_ _01437_ VSS VSS VDD VDD network.neuron_in067.counter\[1\]
+ sky130_fd_sc_hd__edfxtp_1
Xnetwork.neuron_in067.counter\[2\]$_DFFE_PP_ clknet_leaf_29_clk_net
+ _02333_ _01437_ VSS VSS VDD VDD network.neuron_in067.counter\[2\]
+ sky130_fd_sc_hd__edfxtp_1
Xnetwork.neuron_in067.counter\[3\]$_DFFE_PP_ clknet_leaf_30_clk_net
+ _02334_ _01437_ VSS VSS VDD VDD network.neuron_in067.counter\[3\]
+ sky130_fd_sc_hd__edfxtp_1
Xnetwork.neuron_in067.spike$_SDFFE_PP0P_ clknet_leaf_30_clk_net
+ _01798_ VSS VSS VDD VDD network.in_spk03_04 sky130_fd_sc_hd__dfxtp_1
Xnetwork.neuron_in068.counter\[0\]$_DFFE_PP_ clknet_leaf_31_clk_net
+ _02335_ _01436_ VSS VSS VDD VDD network.neuron_in068.counter\[0\]
+ sky130_fd_sc_hd__edfxtp_1
Xnetwork.neuron_in068.counter\[1\]$_DFFE_PP_ clknet_leaf_31_clk_net
+ _02336_ _01436_ VSS VSS VDD VDD network.neuron_in068.counter\[1\]
+ sky130_fd_sc_hd__edfxtp_1
Xnetwork.neuron_in068.counter\[2\]$_DFFE_PP_ clknet_leaf_32_clk_net
+ _02337_ _01436_ VSS VSS VDD VDD network.neuron_in068.counter\[2\]
+ sky130_fd_sc_hd__edfxtp_1
Xnetwork.neuron_in068.counter\[3\]$_DFFE_PP_ clknet_leaf_29_clk_net
+ _02338_ _01436_ VSS VSS VDD VDD network.neuron_in068.counter\[3\]
+ sky130_fd_sc_hd__edfxtp_1
Xnetwork.neuron_in068.spike$_SDFFE_PP0P_ clknet_leaf_30_clk_net
+ _01797_ VSS VSS VDD VDD network.in_spk04_04 sky130_fd_sc_hd__dfxtp_1
Xnetwork.neuron_in069.counter\[0\]$_DFFE_PP_ clknet_leaf_24_clk_net
+ _02339_ _01435_ VSS VSS VDD VDD network.neuron_in069.counter\[0\]
+ sky130_fd_sc_hd__edfxtp_1
Xnetwork.neuron_in069.counter\[1\]$_DFFE_PP_ clknet_leaf_24_clk_net
+ _02340_ _01435_ VSS VSS VDD VDD network.neuron_in069.counter\[1\]
+ sky130_fd_sc_hd__edfxtp_1
Xnetwork.neuron_in069.counter\[2\]$_DFFE_PP_ clknet_leaf_25_clk_net
+ _02341_ _01435_ VSS VSS VDD VDD network.neuron_in069.counter\[2\]
+ sky130_fd_sc_hd__edfxtp_1
Xnetwork.neuron_in069.counter\[3\]$_DFFE_PP_ clknet_leaf_25_clk_net
+ _02342_ _01435_ VSS VSS VDD VDD network.neuron_in069.counter\[3\]
+ sky130_fd_sc_hd__edfxtp_1
Xnetwork.neuron_in069.spike$_SDFFE_PP0P_ clknet_leaf_30_clk_net
+ _01796_ VSS VSS VDD VDD network.in_spk05_04 sky130_fd_sc_hd__dfxtp_1
Xnetwork.neuron_in070.counter\[0\]$_DFFE_PP_ clknet_leaf_14_clk_net
+ _02343_ _01434_ VSS VSS VDD VDD network.neuron_in070.counter\[0\]
+ sky130_fd_sc_hd__edfxtp_1
Xnetwork.neuron_in070.counter\[1\]$_DFFE_PP_ clknet_leaf_14_clk_net
+ _02344_ _01434_ VSS VSS VDD VDD network.neuron_in070.counter\[1\]
+ sky130_fd_sc_hd__edfxtp_1
Xnetwork.neuron_in070.counter\[2\]$_DFFE_PP_ clknet_leaf_30_clk_net
+ _02345_ _01434_ VSS VSS VDD VDD network.neuron_in070.counter\[2\]
+ sky130_fd_sc_hd__edfxtp_1
Xnetwork.neuron_in070.counter\[3\]$_DFFE_PP_ clknet_leaf_30_clk_net
+ _02346_ _01434_ VSS VSS VDD VDD network.neuron_in070.counter\[3\]
+ sky130_fd_sc_hd__edfxtp_1
Xnetwork.neuron_in070.spike$_SDFFE_PP0P_ clknet_leaf_30_clk_net
+ _01795_ VSS VSS VDD VDD network.in_spk06_04 sky130_fd_sc_hd__dfxtp_1
Xnetwork.neuron_in071.counter\[0\]$_DFFE_PP_ clknet_leaf_13_clk_net
+ _02347_ _01433_ VSS VSS VDD VDD network.neuron_in071.counter\[0\]
+ sky130_fd_sc_hd__edfxtp_1
Xnetwork.neuron_in071.counter\[1\]$_DFFE_PP_ clknet_leaf_13_clk_net
+ _02348_ _01433_ VSS VSS VDD VDD network.neuron_in071.counter\[1\]
+ sky130_fd_sc_hd__edfxtp_1
Xnetwork.neuron_in071.counter\[2\]$_DFFE_PP_ clknet_leaf_30_clk_net
+ _02349_ _01433_ VSS VSS VDD VDD network.neuron_in071.counter\[2\]
+ sky130_fd_sc_hd__edfxtp_1
Xnetwork.neuron_in071.counter\[3\]$_DFFE_PP_ clknet_leaf_31_clk_net
+ _02350_ _01433_ VSS VSS VDD VDD network.neuron_in071.counter\[3\]
+ sky130_fd_sc_hd__edfxtp_1
Xnetwork.neuron_in071.spike$_SDFFE_PP0P_ clknet_leaf_14_clk_net
+ _01794_ VSS VSS VDD VDD network.in_spk07_04 sky130_fd_sc_hd__dfxtp_1
Xnetwork.neuron_in072.counter\[0\]$_DFFE_PP_ clknet_leaf_17_clk_net
+ _02351_ _01432_ VSS VSS VDD VDD network.neuron_in072.counter\[0\]
+ sky130_fd_sc_hd__edfxtp_1
Xnetwork.neuron_in072.counter\[1\]$_DFFE_PP_ clknet_leaf_17_clk_net
+ _02352_ _01432_ VSS VSS VDD VDD network.neuron_in072.counter\[1\]
+ sky130_fd_sc_hd__edfxtp_1
Xnetwork.neuron_in072.counter\[2\]$_DFFE_PP_ clknet_leaf_19_clk_net
+ _02353_ _01432_ VSS VSS VDD VDD network.neuron_in072.counter\[2\]
+ sky130_fd_sc_hd__edfxtp_1
Xnetwork.neuron_in072.counter\[3\]$_DFFE_PP_ clknet_leaf_19_clk_net
+ _02354_ _01432_ VSS VSS VDD VDD network.neuron_in072.counter\[3\]
+ sky130_fd_sc_hd__edfxtp_1
Xnetwork.neuron_in072.spike$_SDFFE_PP0P_ clknet_leaf_14_clk_net
+ _01793_ VSS VSS VDD VDD network.in_spk08_04 sky130_fd_sc_hd__dfxtp_1
Xnetwork.neuron_in073.counter\[0\]$_DFFE_PP_ clknet_leaf_13_clk_net
+ _02355_ _01431_ VSS VSS VDD VDD network.neuron_in073.counter\[0\]
+ sky130_fd_sc_hd__edfxtp_1
Xnetwork.neuron_in073.counter\[1\]$_DFFE_PP_ clknet_leaf_13_clk_net
+ _02356_ _01431_ VSS VSS VDD VDD network.neuron_in073.counter\[1\]
+ sky130_fd_sc_hd__edfxtp_1
Xnetwork.neuron_in073.counter\[2\]$_DFFE_PP_ clknet_leaf_13_clk_net
+ _02357_ _01431_ VSS VSS VDD VDD network.neuron_in073.counter\[2\]
+ sky130_fd_sc_hd__edfxtp_1
Xnetwork.neuron_in073.counter\[3\]$_DFFE_PP_ clknet_leaf_13_clk_net
+ _02358_ _01431_ VSS VSS VDD VDD network.neuron_in073.counter\[3\]
+ sky130_fd_sc_hd__edfxtp_1
Xnetwork.neuron_in073.spike$_SDFFE_PP0P_ clknet_leaf_14_clk_net
+ _01792_ VSS VSS VDD VDD network.in_spk09_04 sky130_fd_sc_hd__dfxtp_1
Xnetwork.neuron_in074.counter\[0\]$_DFFE_PP_ clknet_leaf_14_clk_net
+ _02359_ _01430_ VSS VSS VDD VDD network.neuron_in074.counter\[0\]
+ sky130_fd_sc_hd__edfxtp_1
Xnetwork.neuron_in074.counter\[1\]$_DFFE_PP_ clknet_leaf_15_clk_net
+ _02360_ _01430_ VSS VSS VDD VDD network.neuron_in074.counter\[1\]
+ sky130_fd_sc_hd__edfxtp_1
Xnetwork.neuron_in074.counter\[2\]$_DFFE_PP_ clknet_leaf_19_clk_net
+ _02361_ _01430_ VSS VSS VDD VDD network.neuron_in074.counter\[2\]
+ sky130_fd_sc_hd__edfxtp_1
Xnetwork.neuron_in074.counter\[3\]$_DFFE_PP_ clknet_leaf_14_clk_net
+ _02362_ _01430_ VSS VSS VDD VDD network.neuron_in074.counter\[3\]
+ sky130_fd_sc_hd__edfxtp_1
Xnetwork.neuron_in074.spike$_SDFFE_PP0P_ clknet_leaf_14_clk_net
+ _01791_ VSS VSS VDD VDD network.in_spk10_04 sky130_fd_sc_hd__dfxtp_1
Xnetwork.neuron_in075.counter\[0\]$_DFFE_PP_ clknet_leaf_15_clk_net
+ _02363_ _01429_ VSS VSS VDD VDD network.neuron_in075.counter\[0\]
+ sky130_fd_sc_hd__edfxtp_1
Xnetwork.neuron_in075.counter\[1\]$_DFFE_PP_ clknet_leaf_15_clk_net
+ _02364_ _01429_ VSS VSS VDD VDD network.neuron_in075.counter\[1\]
+ sky130_fd_sc_hd__edfxtp_1
Xnetwork.neuron_in075.counter\[2\]$_DFFE_PP_ clknet_leaf_15_clk_net
+ _02365_ _01429_ VSS VSS VDD VDD network.neuron_in075.counter\[2\]
+ sky130_fd_sc_hd__edfxtp_1
Xnetwork.neuron_in075.counter\[3\]$_DFFE_PP_ clknet_leaf_15_clk_net
+ _02366_ _01429_ VSS VSS VDD VDD network.neuron_in075.counter\[3\]
+ sky130_fd_sc_hd__edfxtp_1
Xnetwork.neuron_in075.spike$_SDFFE_PP0P_ clknet_leaf_14_clk_net
+ _01790_ VSS VSS VDD VDD network.in_spk11_04 sky130_fd_sc_hd__dfxtp_1
Xnetwork.neuron_in076.counter\[0\]$_DFFE_PP_ clknet_leaf_18_clk_net
+ _02367_ _01428_ VSS VSS VDD VDD network.neuron_in076.counter\[0\]
+ sky130_fd_sc_hd__edfxtp_1
Xnetwork.neuron_in076.counter\[1\]$_DFFE_PP_ clknet_leaf_17_clk_net
+ _02368_ _01428_ VSS VSS VDD VDD network.neuron_in076.counter\[1\]
+ sky130_fd_sc_hd__edfxtp_1
Xnetwork.neuron_in076.counter\[2\]$_DFFE_PP_ clknet_leaf_18_clk_net
+ _02369_ _01428_ VSS VSS VDD VDD network.neuron_in076.counter\[2\]
+ sky130_fd_sc_hd__edfxtp_1
Xnetwork.neuron_in076.counter\[3\]$_DFFE_PP_ clknet_leaf_18_clk_net
+ _02370_ _01428_ VSS VSS VDD VDD network.neuron_in076.counter\[3\]
+ sky130_fd_sc_hd__edfxtp_1
Xnetwork.neuron_in076.spike$_SDFFE_PP0P_ clknet_leaf_20_clk_net
+ _01789_ VSS VSS VDD VDD network.in_spk12_04 sky130_fd_sc_hd__dfxtp_1
Xnetwork.neuron_in077.counter\[0\]$_DFFE_PP_ clknet_leaf_20_clk_net
+ _02371_ _01427_ VSS VSS VDD VDD network.neuron_in077.counter\[0\]
+ sky130_fd_sc_hd__edfxtp_1
Xnetwork.neuron_in077.counter\[1\]$_DFFE_PP_ clknet_leaf_20_clk_net
+ _02372_ _01427_ VSS VSS VDD VDD network.neuron_in077.counter\[1\]
+ sky130_fd_sc_hd__edfxtp_1
Xnetwork.neuron_in077.counter\[2\]$_DFFE_PP_ clknet_leaf_20_clk_net
+ _02373_ _01427_ VSS VSS VDD VDD network.neuron_in077.counter\[2\]
+ sky130_fd_sc_hd__edfxtp_1
Xnetwork.neuron_in077.counter\[3\]$_DFFE_PP_ clknet_leaf_20_clk_net
+ _02374_ _01427_ VSS VSS VDD VDD network.neuron_in077.counter\[3\]
+ sky130_fd_sc_hd__edfxtp_1
Xnetwork.neuron_in077.spike$_SDFFE_PP0P_ clknet_leaf_19_clk_net
+ _01788_ VSS VSS VDD VDD network.in_spk13_04 sky130_fd_sc_hd__dfxtp_1
Xnetwork.neuron_in078.counter\[0\]$_DFFE_PP_ clknet_leaf_20_clk_net
+ _02375_ _01426_ VSS VSS VDD VDD network.neuron_in078.counter\[0\]
+ sky130_fd_sc_hd__edfxtp_1
Xnetwork.neuron_in078.counter\[1\]$_DFFE_PP_ clknet_leaf_19_clk_net
+ _02376_ _01426_ VSS VSS VDD VDD network.neuron_in078.counter\[1\]
+ sky130_fd_sc_hd__edfxtp_1
Xnetwork.neuron_in078.counter\[2\]$_DFFE_PP_ clknet_leaf_18_clk_net
+ _02377_ _01426_ VSS VSS VDD VDD network.neuron_in078.counter\[2\]
+ sky130_fd_sc_hd__edfxtp_1
Xnetwork.neuron_in078.counter\[3\]$_DFFE_PP_ clknet_leaf_18_clk_net
+ _02378_ _01426_ VSS VSS VDD VDD network.neuron_in078.counter\[3\]
+ sky130_fd_sc_hd__edfxtp_1
Xnetwork.neuron_in078.spike$_SDFFE_PP0P_ clknet_leaf_19_clk_net
+ _01787_ VSS VSS VDD VDD network.in_spk14_04 sky130_fd_sc_hd__dfxtp_1
Xnetwork.neuron_in079.counter\[0\]$_DFFE_PP_ clknet_leaf_18_clk_net
+ _02379_ _01425_ VSS VSS VDD VDD network.neuron_in079.counter\[0\]
+ sky130_fd_sc_hd__edfxtp_1
Xnetwork.neuron_in079.counter\[1\]$_DFFE_PP_ clknet_leaf_21_clk_net
+ _02380_ _01425_ VSS VSS VDD VDD network.neuron_in079.counter\[1\]
+ sky130_fd_sc_hd__edfxtp_1
Xnetwork.neuron_in079.counter\[2\]$_DFFE_PP_ clknet_leaf_20_clk_net
+ _02381_ _01425_ VSS VSS VDD VDD network.neuron_in079.counter\[2\]
+ sky130_fd_sc_hd__edfxtp_1
Xnetwork.neuron_in079.counter\[3\]$_DFFE_PP_ clknet_leaf_21_clk_net
+ _02382_ _01425_ VSS VSS VDD VDD network.neuron_in079.counter\[3\]
+ sky130_fd_sc_hd__edfxtp_1
Xnetwork.neuron_in079.spike$_SDFFE_PP0P_ clknet_leaf_19_clk_net
+ _01786_ VSS VSS VDD VDD network.in_spk15_04 sky130_fd_sc_hd__dfxtp_1
Xnetwork.neuron_in080.counter\[0\]$_DFFE_PP_ clknet_leaf_163_clk_net
+ _02383_ _01424_ VSS VSS VDD VDD network.neuron_in080.counter\[0\]
+ sky130_fd_sc_hd__edfxtp_1
Xnetwork.neuron_in080.counter\[1\]$_DFFE_PP_ clknet_leaf_163_clk_net
+ _02384_ _01424_ VSS VSS VDD VDD network.neuron_in080.counter\[1\]
+ sky130_fd_sc_hd__edfxtp_1
Xnetwork.neuron_in080.counter\[2\]$_DFFE_PP_ clknet_leaf_165_clk_net
+ _02385_ _01424_ VSS VSS VDD VDD network.neuron_in080.counter\[2\]
+ sky130_fd_sc_hd__edfxtp_1
Xnetwork.neuron_in080.counter\[3\]$_DFFE_PP_ clknet_leaf_165_clk_net
+ _02386_ _01424_ VSS VSS VDD VDD network.neuron_in080.counter\[3\]
+ sky130_fd_sc_hd__edfxtp_1
Xnetwork.neuron_in080.spike$_SDFFE_PP0P_ clknet_leaf_163_clk_net
+ _01785_ VSS VSS VDD VDD network.in_spk00_05 sky130_fd_sc_hd__dfxtp_1
Xnetwork.neuron_in081.counter\[0\]$_DFFE_PP_ clknet_leaf_162_clk_net
+ _02387_ _01423_ VSS VSS VDD VDD network.neuron_in081.counter\[0\]
+ sky130_fd_sc_hd__edfxtp_1
Xnetwork.neuron_in081.counter\[1\]$_DFFE_PP_ clknet_leaf_5_clk_net
+ _02388_ _01423_ VSS VSS VDD VDD network.neuron_in081.counter\[1\]
+ sky130_fd_sc_hd__edfxtp_1
Xnetwork.neuron_in081.counter\[2\]$_DFFE_PP_ clknet_leaf_162_clk_net
+ _02389_ _01423_ VSS VSS VDD VDD network.neuron_in081.counter\[2\]
+ sky130_fd_sc_hd__edfxtp_1
Xnetwork.neuron_in081.counter\[3\]$_DFFE_PP_ clknet_leaf_162_clk_net
+ _02390_ _01423_ VSS VSS VDD VDD network.neuron_in081.counter\[3\]
+ sky130_fd_sc_hd__edfxtp_1
Xnetwork.neuron_in081.spike$_SDFFE_PP0P_ clknet_leaf_162_clk_net
+ _01784_ VSS VSS VDD VDD network.in_spk01_05 sky130_fd_sc_hd__dfxtp_1
Xnetwork.neuron_in082.counter\[0\]$_DFFE_PP_ clknet_leaf_3_clk_net
+ _02391_ _01422_ VSS VSS VDD VDD network.neuron_in082.counter\[0\]
+ sky130_fd_sc_hd__edfxtp_1
Xnetwork.neuron_in082.counter\[1\]$_DFFE_PP_ clknet_leaf_3_clk_net
+ _02392_ _01422_ VSS VSS VDD VDD network.neuron_in082.counter\[1\]
+ sky130_fd_sc_hd__edfxtp_1
Xnetwork.neuron_in082.counter\[2\]$_DFFE_PP_ clknet_leaf_4_clk_net
+ _02393_ _01422_ VSS VSS VDD VDD network.neuron_in082.counter\[2\]
+ sky130_fd_sc_hd__edfxtp_1
Xnetwork.neuron_in082.counter\[3\]$_DFFE_PP_ clknet_leaf_4_clk_net
+ _02394_ _01422_ VSS VSS VDD VDD network.neuron_in082.counter\[3\]
+ sky130_fd_sc_hd__edfxtp_1
Xnetwork.neuron_in082.spike$_SDFFE_PP0P_ clknet_leaf_163_clk_net
+ _01783_ VSS VSS VDD VDD network.in_spk02_05 sky130_fd_sc_hd__dfxtp_1
Xnetwork.neuron_in083.counter\[0\]$_DFFE_PP_ clknet_leaf_165_clk_net
+ _02395_ _01421_ VSS VSS VDD VDD network.neuron_in083.counter\[0\]
+ sky130_fd_sc_hd__edfxtp_1
Xnetwork.neuron_in083.counter\[1\]$_DFFE_PP_ clknet_leaf_165_clk_net
+ _02396_ _01421_ VSS VSS VDD VDD network.neuron_in083.counter\[1\]
+ sky130_fd_sc_hd__edfxtp_1
Xnetwork.neuron_in083.counter\[2\]$_DFFE_PP_ clknet_leaf_165_clk_net
+ _02397_ _01421_ VSS VSS VDD VDD network.neuron_in083.counter\[2\]
+ sky130_fd_sc_hd__edfxtp_1
Xnetwork.neuron_in083.counter\[3\]$_DFFE_PP_ clknet_leaf_165_clk_net
+ _02398_ _01421_ VSS VSS VDD VDD network.neuron_in083.counter\[3\]
+ sky130_fd_sc_hd__edfxtp_1
Xnetwork.neuron_in083.spike$_SDFFE_PP0P_ clknet_leaf_163_clk_net
+ _01782_ VSS VSS VDD VDD network.in_spk03_05 sky130_fd_sc_hd__dfxtp_1
Xnetwork.neuron_in084.counter\[0\]$_DFFE_PP_ clknet_leaf_167_clk_net
+ _02399_ _01420_ VSS VSS VDD VDD network.neuron_in084.counter\[0\]
+ sky130_fd_sc_hd__edfxtp_1
Xnetwork.neuron_in084.counter\[1\]$_DFFE_PP_ clknet_leaf_167_clk_net
+ _02400_ _01420_ VSS VSS VDD VDD network.neuron_in084.counter\[1\]
+ sky130_fd_sc_hd__edfxtp_1
Xnetwork.neuron_in084.counter\[2\]$_DFFE_PP_ clknet_leaf_164_clk_net
+ _02401_ _01420_ VSS VSS VDD VDD network.neuron_in084.counter\[2\]
+ sky130_fd_sc_hd__edfxtp_1
Xnetwork.neuron_in084.counter\[3\]$_DFFE_PP_ clknet_leaf_164_clk_net
+ _02402_ _01420_ VSS VSS VDD VDD network.neuron_in084.counter\[3\]
+ sky130_fd_sc_hd__edfxtp_1
Xnetwork.neuron_in084.spike$_SDFFE_PP0P_ clknet_leaf_164_clk_net
+ _01781_ VSS VSS VDD VDD network.in_spk04_05 sky130_fd_sc_hd__dfxtp_1
Xnetwork.neuron_in085.counter\[0\]$_DFFE_PP_ clknet_leaf_166_clk_net
+ _02403_ _01419_ VSS VSS VDD VDD network.neuron_in085.counter\[0\]
+ sky130_fd_sc_hd__edfxtp_1
Xnetwork.neuron_in085.counter\[1\]$_DFFE_PP_ clknet_leaf_164_clk_net
+ _02404_ _01419_ VSS VSS VDD VDD network.neuron_in085.counter\[1\]
+ sky130_fd_sc_hd__edfxtp_1
Xnetwork.neuron_in085.counter\[2\]$_DFFE_PP_ clknet_leaf_164_clk_net
+ _02405_ _01419_ VSS VSS VDD VDD network.neuron_in085.counter\[2\]
+ sky130_fd_sc_hd__edfxtp_1
Xnetwork.neuron_in085.counter\[3\]$_DFFE_PP_ clknet_leaf_166_clk_net
+ _02406_ _01419_ VSS VSS VDD VDD network.neuron_in085.counter\[3\]
+ sky130_fd_sc_hd__edfxtp_1
Xnetwork.neuron_in085.spike$_SDFFE_PP0P_ clknet_leaf_164_clk_net
+ _01780_ VSS VSS VDD VDD network.in_spk05_05 sky130_fd_sc_hd__dfxtp_1
Xnetwork.neuron_in086.counter\[0\]$_DFFE_PP_ clknet_leaf_166_clk_net
+ _02407_ _01418_ VSS VSS VDD VDD network.neuron_in086.counter\[0\]
+ sky130_fd_sc_hd__edfxtp_1
Xnetwork.neuron_in086.counter\[1\]$_DFFE_PP_ clknet_leaf_165_clk_net
+ _02408_ _01418_ VSS VSS VDD VDD network.neuron_in086.counter\[1\]
+ sky130_fd_sc_hd__edfxtp_1
Xnetwork.neuron_in086.counter\[2\]$_DFFE_PP_ clknet_leaf_165_clk_net
+ _02409_ _01418_ VSS VSS VDD VDD network.neuron_in086.counter\[2\]
+ sky130_fd_sc_hd__edfxtp_1
Xnetwork.neuron_in086.counter\[3\]$_DFFE_PP_ clknet_leaf_166_clk_net
+ _02410_ _01418_ VSS VSS VDD VDD network.neuron_in086.counter\[3\]
+ sky130_fd_sc_hd__edfxtp_1
Xnetwork.neuron_in086.spike$_SDFFE_PP0P_ clknet_leaf_163_clk_net
+ _01779_ VSS VSS VDD VDD network.in_spk06_05 sky130_fd_sc_hd__dfxtp_1
Xnetwork.neuron_in087.counter\[0\]$_DFFE_PP_ clknet_leaf_0_clk_net
+ _02411_ _01417_ VSS VSS VDD VDD network.neuron_in087.counter\[0\]
+ sky130_fd_sc_hd__edfxtp_1
Xnetwork.neuron_in087.counter\[1\]$_DFFE_PP_ clknet_leaf_0_clk_net
+ _02412_ _01417_ VSS VSS VDD VDD network.neuron_in087.counter\[1\]
+ sky130_fd_sc_hd__edfxtp_1
Xnetwork.neuron_in087.counter\[2\]$_DFFE_PP_ clknet_leaf_4_clk_net
+ _02413_ _01417_ VSS VSS VDD VDD network.neuron_in087.counter\[2\]
+ sky130_fd_sc_hd__edfxtp_1
Xnetwork.neuron_in087.counter\[3\]$_DFFE_PP_ clknet_leaf_1_clk_net
+ _02414_ _01417_ VSS VSS VDD VDD network.neuron_in087.counter\[3\]
+ sky130_fd_sc_hd__edfxtp_1
Xnetwork.neuron_in087.spike$_SDFFE_PP0P_ clknet_leaf_163_clk_net
+ _01778_ VSS VSS VDD VDD network.in_spk07_05 sky130_fd_sc_hd__dfxtp_1
Xnetwork.neuron_in088.counter\[0\]$_DFFE_PP_ clknet_leaf_0_clk_net
+ _02415_ _01416_ VSS VSS VDD VDD network.neuron_in088.counter\[0\]
+ sky130_fd_sc_hd__edfxtp_1
Xnetwork.neuron_in088.counter\[1\]$_DFFE_PP_ clknet_leaf_168_clk_net
+ _02416_ _01416_ VSS VSS VDD VDD network.neuron_in088.counter\[1\]
+ sky130_fd_sc_hd__edfxtp_1
Xnetwork.neuron_in088.counter\[2\]$_DFFE_PP_ clknet_leaf_0_clk_net
+ _02417_ _01416_ VSS VSS VDD VDD network.neuron_in088.counter\[2\]
+ sky130_fd_sc_hd__edfxtp_1
Xnetwork.neuron_in088.counter\[3\]$_DFFE_PP_ clknet_leaf_0_clk_net
+ _02418_ _01416_ VSS VSS VDD VDD network.neuron_in088.counter\[3\]
+ sky130_fd_sc_hd__edfxtp_1
Xnetwork.neuron_in088.spike$_SDFFE_PP0P_ clknet_leaf_1_clk_net
+ _01777_ VSS VSS VDD VDD network.in_spk08_05 sky130_fd_sc_hd__dfxtp_1
Xnetwork.neuron_in089.counter\[0\]$_DFFE_PP_ clknet_leaf_0_clk_net
+ _02419_ _01415_ VSS VSS VDD VDD network.neuron_in089.counter\[0\]
+ sky130_fd_sc_hd__edfxtp_1
Xnetwork.neuron_in089.counter\[1\]$_DFFE_PP_ clknet_leaf_0_clk_net
+ _02420_ _01415_ VSS VSS VDD VDD network.neuron_in089.counter\[1\]
+ sky130_fd_sc_hd__edfxtp_1
Xnetwork.neuron_in089.counter\[2\]$_DFFE_PP_ clknet_leaf_0_clk_net
+ _02421_ _01415_ VSS VSS VDD VDD network.neuron_in089.counter\[2\]
+ sky130_fd_sc_hd__edfxtp_1
Xnetwork.neuron_in089.counter\[3\]$_DFFE_PP_ clknet_leaf_1_clk_net
+ _02422_ _01415_ VSS VSS VDD VDD network.neuron_in089.counter\[3\]
+ sky130_fd_sc_hd__edfxtp_1
Xnetwork.neuron_in089.spike$_SDFFE_PP0P_ clknet_leaf_1_clk_net
+ _01776_ VSS VSS VDD VDD network.in_spk09_05 sky130_fd_sc_hd__dfxtp_1
Xnetwork.neuron_in090.counter\[0\]$_DFFE_PP_ clknet_leaf_2_clk_net
+ _02423_ _01414_ VSS VSS VDD VDD network.neuron_in090.counter\[0\]
+ sky130_fd_sc_hd__edfxtp_1
Xnetwork.neuron_in090.counter\[1\]$_DFFE_PP_ clknet_leaf_1_clk_net
+ _02424_ _01414_ VSS VSS VDD VDD network.neuron_in090.counter\[1\]
+ sky130_fd_sc_hd__edfxtp_1
Xnetwork.neuron_in090.counter\[2\]$_DFFE_PP_ clknet_leaf_1_clk_net
+ _02425_ _01414_ VSS VSS VDD VDD network.neuron_in090.counter\[2\]
+ sky130_fd_sc_hd__edfxtp_1
Xnetwork.neuron_in090.counter\[3\]$_DFFE_PP_ clknet_leaf_2_clk_net
+ _02426_ _01414_ VSS VSS VDD VDD network.neuron_in090.counter\[3\]
+ sky130_fd_sc_hd__edfxtp_1
Xnetwork.neuron_in090.spike$_SDFFE_PP0P_ clknet_leaf_1_clk_net
+ _01775_ VSS VSS VDD VDD network.in_spk10_05 sky130_fd_sc_hd__dfxtp_1
Xnetwork.neuron_in091.counter\[0\]$_DFFE_PP_ clknet_leaf_168_clk_net
+ _02427_ _01413_ VSS VSS VDD VDD network.neuron_in091.counter\[0\]
+ sky130_fd_sc_hd__edfxtp_1
Xnetwork.neuron_in091.counter\[1\]$_DFFE_PP_ clknet_leaf_168_clk_net
+ _02428_ _01413_ VSS VSS VDD VDD network.neuron_in091.counter\[1\]
+ sky130_fd_sc_hd__edfxtp_1
Xnetwork.neuron_in091.counter\[2\]$_DFFE_PP_ clknet_leaf_168_clk_net
+ _02429_ _01413_ VSS VSS VDD VDD network.neuron_in091.counter\[2\]
+ sky130_fd_sc_hd__edfxtp_1
Xnetwork.neuron_in091.counter\[3\]$_DFFE_PP_ clknet_leaf_168_clk_net
+ _02430_ _01413_ VSS VSS VDD VDD network.neuron_in091.counter\[3\]
+ sky130_fd_sc_hd__edfxtp_1
Xnetwork.neuron_in091.spike$_SDFFE_PP0P_ clknet_leaf_1_clk_net
+ _01774_ VSS VSS VDD VDD network.in_spk11_05 sky130_fd_sc_hd__dfxtp_1
Xnetwork.neuron_in092.counter\[0\]$_DFFE_PP_ clknet_leaf_0_clk_net
+ _02431_ _01412_ VSS VSS VDD VDD network.neuron_in092.counter\[0\]
+ sky130_fd_sc_hd__edfxtp_1
Xnetwork.neuron_in092.counter\[1\]$_DFFE_PP_ clknet_leaf_167_clk_net
+ _02432_ _01412_ VSS VSS VDD VDD network.neuron_in092.counter\[1\]
+ sky130_fd_sc_hd__edfxtp_1
Xnetwork.neuron_in092.counter\[2\]$_DFFE_PP_ clknet_leaf_167_clk_net
+ _02433_ _01412_ VSS VSS VDD VDD network.neuron_in092.counter\[2\]
+ sky130_fd_sc_hd__edfxtp_1
Xnetwork.neuron_in092.counter\[3\]$_DFFE_PP_ clknet_leaf_167_clk_net
+ _02434_ _01412_ VSS VSS VDD VDD network.neuron_in092.counter\[3\]
+ sky130_fd_sc_hd__edfxtp_1
Xnetwork.neuron_in092.spike$_SDFFE_PP0P_ clknet_leaf_164_clk_net
+ _01773_ VSS VSS VDD VDD network.in_spk12_05 sky130_fd_sc_hd__dfxtp_1
Xnetwork.neuron_in093.counter\[0\]$_DFFE_PP_ clknet_leaf_167_clk_net
+ _02435_ _01411_ VSS VSS VDD VDD network.neuron_in093.counter\[0\]
+ sky130_fd_sc_hd__edfxtp_1
Xnetwork.neuron_in093.counter\[1\]$_DFFE_PP_ clknet_leaf_167_clk_net
+ _02436_ _01411_ VSS VSS VDD VDD network.neuron_in093.counter\[1\]
+ sky130_fd_sc_hd__edfxtp_1
Xnetwork.neuron_in093.counter\[2\]$_DFFE_PP_ clknet_leaf_166_clk_net
+ _02437_ _01411_ VSS VSS VDD VDD network.neuron_in093.counter\[2\]
+ sky130_fd_sc_hd__edfxtp_1
Xnetwork.neuron_in093.counter\[3\]$_DFFE_PP_ clknet_leaf_166_clk_net
+ _02438_ _01411_ VSS VSS VDD VDD network.neuron_in093.counter\[3\]
+ sky130_fd_sc_hd__edfxtp_1
Xnetwork.neuron_in093.spike$_SDFFE_PP0P_ clknet_leaf_164_clk_net
+ _01772_ VSS VSS VDD VDD network.in_spk13_05 sky130_fd_sc_hd__dfxtp_1
Xnetwork.neuron_in094.counter\[0\]$_DFFE_PP_ clknet_leaf_166_clk_net
+ _02439_ _01410_ VSS VSS VDD VDD network.neuron_in094.counter\[0\]
+ sky130_fd_sc_hd__edfxtp_1
Xnetwork.neuron_in094.counter\[1\]$_DFFE_PP_ clknet_leaf_166_clk_net
+ _02440_ _01410_ VSS VSS VDD VDD network.neuron_in094.counter\[1\]
+ sky130_fd_sc_hd__edfxtp_1
Xnetwork.neuron_in094.counter\[2\]$_DFFE_PP_ clknet_leaf_166_clk_net
+ _02441_ _01410_ VSS VSS VDD VDD network.neuron_in094.counter\[2\]
+ sky130_fd_sc_hd__edfxtp_1
Xnetwork.neuron_in094.counter\[3\]$_DFFE_PP_ clknet_leaf_166_clk_net
+ _02442_ _01410_ VSS VSS VDD VDD network.neuron_in094.counter\[3\]
+ sky130_fd_sc_hd__edfxtp_1
Xnetwork.neuron_in094.spike$_SDFFE_PP0P_ clknet_leaf_164_clk_net
+ _01771_ VSS VSS VDD VDD network.in_spk14_05 sky130_fd_sc_hd__dfxtp_1
Xnetwork.neuron_in095.counter\[0\]$_DFFE_PP_ clknet_leaf_168_clk_net
+ _02443_ _01409_ VSS VSS VDD VDD network.neuron_in095.counter\[0\]
+ sky130_fd_sc_hd__edfxtp_1
Xnetwork.neuron_in095.counter\[1\]$_DFFE_PP_ clknet_leaf_168_clk_net
+ _02444_ _01409_ VSS VSS VDD VDD network.neuron_in095.counter\[1\]
+ sky130_fd_sc_hd__edfxtp_1
Xnetwork.neuron_in095.counter\[2\]$_DFFE_PP_ clknet_leaf_168_clk_net
+ _02445_ _01409_ VSS VSS VDD VDD network.neuron_in095.counter\[2\]
+ sky130_fd_sc_hd__edfxtp_1
Xnetwork.neuron_in095.counter\[3\]$_DFFE_PP_ clknet_leaf_167_clk_net
+ _02446_ _01409_ VSS VSS VDD VDD network.neuron_in095.counter\[3\]
+ sky130_fd_sc_hd__edfxtp_1
Xnetwork.neuron_in095.spike$_SDFFE_PP0P_ clknet_leaf_4_clk_net
+ _01770_ VSS VSS VDD VDD network.in_spk15_05 sky130_fd_sc_hd__dfxtp_1
Xnetwork.neuron_in096.counter\[0\]$_DFFE_PP_ clknet_leaf_35_clk_net
+ _02447_ _01408_ VSS VSS VDD VDD network.neuron_in096.counter\[0\]
+ sky130_fd_sc_hd__edfxtp_1
Xnetwork.neuron_in096.counter\[1\]$_DFFE_PP_ clknet_leaf_35_clk_net
+ _02448_ _01408_ VSS VSS VDD VDD network.neuron_in096.counter\[1\]
+ sky130_fd_sc_hd__edfxtp_1
Xnetwork.neuron_in096.counter\[2\]$_DFFE_PP_ clknet_leaf_35_clk_net
+ _02449_ _01408_ VSS VSS VDD VDD network.neuron_in096.counter\[2\]
+ sky130_fd_sc_hd__edfxtp_1
Xnetwork.neuron_in096.counter\[3\]$_DFFE_PP_ clknet_leaf_35_clk_net
+ _02450_ _01408_ VSS VSS VDD VDD network.neuron_in096.counter\[3\]
+ sky130_fd_sc_hd__edfxtp_1
Xnetwork.neuron_in096.spike$_SDFFE_PP0P_ clknet_leaf_32_clk_net
+ _01769_ VSS VSS VDD VDD network.in_spk00_06 sky130_fd_sc_hd__dfxtp_1
Xnetwork.neuron_in097.counter\[0\]$_DFFE_PP_ clknet_leaf_37_clk_net
+ _02451_ _01407_ VSS VSS VDD VDD network.neuron_in097.counter\[0\]
+ sky130_fd_sc_hd__edfxtp_1
Xnetwork.neuron_in097.counter\[1\]$_DFFE_PP_ clknet_leaf_34_clk_net
+ _02452_ _01407_ VSS VSS VDD VDD network.neuron_in097.counter\[1\]
+ sky130_fd_sc_hd__edfxtp_1
Xnetwork.neuron_in097.counter\[2\]$_DFFE_PP_ clknet_leaf_37_clk_net
+ _02453_ _01407_ VSS VSS VDD VDD network.neuron_in097.counter\[2\]
+ sky130_fd_sc_hd__edfxtp_1
Xnetwork.neuron_in097.counter\[3\]$_DFFE_PP_ clknet_leaf_37_clk_net
+ _02454_ _01407_ VSS VSS VDD VDD network.neuron_in097.counter\[3\]
+ sky130_fd_sc_hd__edfxtp_1
Xnetwork.neuron_in097.spike$_SDFFE_PP0P_ clknet_leaf_32_clk_net
+ _01768_ VSS VSS VDD VDD network.in_spk01_06 sky130_fd_sc_hd__dfxtp_1
Xnetwork.neuron_in098.counter\[0\]$_DFFE_PP_ clknet_leaf_36_clk_net
+ _02455_ _01406_ VSS VSS VDD VDD network.neuron_in098.counter\[0\]
+ sky130_fd_sc_hd__edfxtp_1
Xnetwork.neuron_in098.counter\[1\]$_DFFE_PP_ clknet_leaf_36_clk_net
+ _02456_ _01406_ VSS VSS VDD VDD network.neuron_in098.counter\[1\]
+ sky130_fd_sc_hd__edfxtp_1
Xnetwork.neuron_in098.counter\[2\]$_DFFE_PP_ clknet_leaf_36_clk_net
+ _02457_ _01406_ VSS VSS VDD VDD network.neuron_in098.counter\[2\]
+ sky130_fd_sc_hd__edfxtp_1
Xnetwork.neuron_in098.counter\[3\]$_DFFE_PP_ clknet_leaf_36_clk_net
+ _02458_ _01406_ VSS VSS VDD VDD network.neuron_in098.counter\[3\]
+ sky130_fd_sc_hd__edfxtp_1
Xnetwork.neuron_in098.spike$_SDFFE_PP0P_ clknet_leaf_32_clk_net
+ _02062_ VSS VSS VDD VDD network.in_spk02_06 sky130_fd_sc_hd__dfxtp_1
Xnetwork.neuron_in099.counter\[0\]$_DFFE_PP_ clknet_leaf_35_clk_net
+ _02459_ _01405_ VSS VSS VDD VDD network.neuron_in099.counter\[0\]
+ sky130_fd_sc_hd__edfxtp_1
Xnetwork.neuron_in099.counter\[1\]$_DFFE_PP_ clknet_leaf_35_clk_net
+ _02460_ _01405_ VSS VSS VDD VDD network.neuron_in099.counter\[1\]
+ sky130_fd_sc_hd__edfxtp_1
Xnetwork.neuron_in099.counter\[2\]$_DFFE_PP_ clknet_leaf_36_clk_net
+ _02461_ _01405_ VSS VSS VDD VDD network.neuron_in099.counter\[2\]
+ sky130_fd_sc_hd__edfxtp_1
Xnetwork.neuron_in099.counter\[3\]$_DFFE_PP_ clknet_leaf_36_clk_net
+ _02462_ _01405_ VSS VSS VDD VDD network.neuron_in099.counter\[3\]
+ sky130_fd_sc_hd__edfxtp_1
Xnetwork.neuron_in099.spike$_SDFFE_PP0P_ clknet_leaf_32_clk_net
+ _02061_ VSS VSS VDD VDD network.in_spk03_06 sky130_fd_sc_hd__dfxtp_1
Xnetwork.neuron_in100.counter\[0\]$_DFFE_PP_ clknet_leaf_34_clk_net
+ _02463_ _01404_ VSS VSS VDD VDD network.neuron_in100.counter\[0\]
+ sky130_fd_sc_hd__edfxtp_1
Xnetwork.neuron_in100.counter\[1\]$_DFFE_PP_ clknet_leaf_34_clk_net
+ _02464_ _01404_ VSS VSS VDD VDD network.neuron_in100.counter\[1\]
+ sky130_fd_sc_hd__edfxtp_1
Xnetwork.neuron_in100.counter\[2\]$_DFFE_PP_ clknet_leaf_34_clk_net
+ _02465_ _01404_ VSS VSS VDD VDD network.neuron_in100.counter\[2\]
+ sky130_fd_sc_hd__edfxtp_1
Xnetwork.neuron_in100.counter\[3\]$_DFFE_PP_ clknet_leaf_34_clk_net
+ _02466_ _01404_ VSS VSS VDD VDD network.neuron_in100.counter\[3\]
+ sky130_fd_sc_hd__edfxtp_1
Xnetwork.neuron_in100.spike$_SDFFE_PP0P_ clknet_leaf_32_clk_net
+ _02060_ VSS VSS VDD VDD network.in_spk04_06 sky130_fd_sc_hd__dfxtp_1
Xnetwork.neuron_in101.counter\[0\]$_DFFE_PP_ clknet_leaf_33_clk_net
+ _02467_ _01403_ VSS VSS VDD VDD network.neuron_in101.counter\[0\]
+ sky130_fd_sc_hd__edfxtp_1
Xnetwork.neuron_in101.counter\[1\]$_DFFE_PP_ clknet_leaf_33_clk_net
+ _02468_ _01403_ VSS VSS VDD VDD network.neuron_in101.counter\[1\]
+ sky130_fd_sc_hd__edfxtp_1
Xnetwork.neuron_in101.counter\[2\]$_DFFE_PP_ clknet_leaf_33_clk_net
+ _02469_ _01403_ VSS VSS VDD VDD network.neuron_in101.counter\[2\]
+ sky130_fd_sc_hd__edfxtp_1
Xnetwork.neuron_in101.counter\[3\]$_DFFE_PP_ clknet_leaf_33_clk_net
+ _02470_ _01403_ VSS VSS VDD VDD network.neuron_in101.counter\[3\]
+ sky130_fd_sc_hd__edfxtp_1
Xnetwork.neuron_in101.spike$_SDFFE_PP0P_ clknet_leaf_32_clk_net
+ _02059_ VSS VSS VDD VDD network.in_spk05_06 sky130_fd_sc_hd__dfxtp_1
Xnetwork.neuron_in102.counter\[0\]$_DFFE_PP_ clknet_leaf_32_clk_net
+ _02471_ _01402_ VSS VSS VDD VDD network.neuron_in102.counter\[0\]
+ sky130_fd_sc_hd__edfxtp_1
Xnetwork.neuron_in102.counter\[1\]$_DFFE_PP_ clknet_leaf_32_clk_net
+ _02472_ _01402_ VSS VSS VDD VDD network.neuron_in102.counter\[1\]
+ sky130_fd_sc_hd__edfxtp_1
Xnetwork.neuron_in102.counter\[2\]$_DFFE_PP_ clknet_leaf_32_clk_net
+ _02473_ _01402_ VSS VSS VDD VDD network.neuron_in102.counter\[2\]
+ sky130_fd_sc_hd__edfxtp_1
Xnetwork.neuron_in102.counter\[3\]$_DFFE_PP_ clknet_leaf_32_clk_net
+ _02474_ _01402_ VSS VSS VDD VDD network.neuron_in102.counter\[3\]
+ sky130_fd_sc_hd__edfxtp_1
Xnetwork.neuron_in102.spike$_SDFFE_PP0P_ clknet_leaf_32_clk_net
+ _02058_ VSS VSS VDD VDD network.in_spk06_06 sky130_fd_sc_hd__dfxtp_1
Xnetwork.neuron_in103.counter\[0\]$_DFFE_PP_ clknet_leaf_34_clk_net
+ _02475_ _01401_ VSS VSS VDD VDD network.neuron_in103.counter\[0\]
+ sky130_fd_sc_hd__edfxtp_1
Xnetwork.neuron_in103.counter\[1\]$_DFFE_PP_ clknet_leaf_34_clk_net
+ _02476_ _01401_ VSS VSS VDD VDD network.neuron_in103.counter\[1\]
+ sky130_fd_sc_hd__edfxtp_1
Xnetwork.neuron_in103.counter\[2\]$_DFFE_PP_ clknet_leaf_35_clk_net
+ _02477_ _01401_ VSS VSS VDD VDD network.neuron_in103.counter\[2\]
+ sky130_fd_sc_hd__edfxtp_1
Xnetwork.neuron_in103.counter\[3\]$_DFFE_PP_ clknet_leaf_34_clk_net
+ _02478_ _01401_ VSS VSS VDD VDD network.neuron_in103.counter\[3\]
+ sky130_fd_sc_hd__edfxtp_1
Xnetwork.neuron_in103.spike$_SDFFE_PP0P_ clknet_leaf_12_clk_net
+ _02057_ VSS VSS VDD VDD network.in_spk07_06 sky130_fd_sc_hd__dfxtp_1
Xnetwork.neuron_in104.counter\[0\]$_DFFE_PP_ clknet_leaf_11_clk_net
+ _02479_ _01400_ VSS VSS VDD VDD network.neuron_in104.counter\[0\]
+ sky130_fd_sc_hd__edfxtp_1
Xnetwork.neuron_in104.counter\[1\]$_DFFE_PP_ clknet_leaf_11_clk_net
+ _02480_ _01400_ VSS VSS VDD VDD network.neuron_in104.counter\[1\]
+ sky130_fd_sc_hd__edfxtp_1
Xnetwork.neuron_in104.counter\[2\]$_DFFE_PP_ clknet_leaf_33_clk_net
+ _02481_ _01400_ VSS VSS VDD VDD network.neuron_in104.counter\[2\]
+ sky130_fd_sc_hd__edfxtp_1
Xnetwork.neuron_in104.counter\[3\]$_DFFE_PP_ clknet_leaf_11_clk_net
+ _02482_ _01400_ VSS VSS VDD VDD network.neuron_in104.counter\[3\]
+ sky130_fd_sc_hd__edfxtp_1
Xnetwork.neuron_in104.spike$_SDFFE_PP0P_ clknet_leaf_12_clk_net
+ _02056_ VSS VSS VDD VDD network.in_spk08_06 sky130_fd_sc_hd__dfxtp_1
Xnetwork.neuron_in105.counter\[0\]$_DFFE_PP_ clknet_leaf_11_clk_net
+ _02483_ _01399_ VSS VSS VDD VDD network.neuron_in105.counter\[0\]
+ sky130_fd_sc_hd__edfxtp_1
Xnetwork.neuron_in105.counter\[1\]$_DFFE_PP_ clknet_leaf_11_clk_net
+ _02484_ _01399_ VSS VSS VDD VDD network.neuron_in105.counter\[1\]
+ sky130_fd_sc_hd__edfxtp_1
Xnetwork.neuron_in105.counter\[2\]$_DFFE_PP_ clknet_leaf_11_clk_net
+ _02485_ _01399_ VSS VSS VDD VDD network.neuron_in105.counter\[2\]
+ sky130_fd_sc_hd__edfxtp_1
Xnetwork.neuron_in105.counter\[3\]$_DFFE_PP_ clknet_leaf_33_clk_net
+ _02486_ _01399_ VSS VSS VDD VDD network.neuron_in105.counter\[3\]
+ sky130_fd_sc_hd__edfxtp_1
Xnetwork.neuron_in105.spike$_SDFFE_PP0P_ clknet_leaf_12_clk_net
+ _02055_ VSS VSS VDD VDD network.in_spk09_06 sky130_fd_sc_hd__dfxtp_1
Xnetwork.neuron_in106.counter\[0\]$_DFFE_PP_ clknet_leaf_10_clk_net
+ _02487_ _01398_ VSS VSS VDD VDD network.neuron_in106.counter\[0\]
+ sky130_fd_sc_hd__edfxtp_1
Xnetwork.neuron_in106.counter\[1\]$_DFFE_PP_ clknet_leaf_10_clk_net
+ _02488_ _01398_ VSS VSS VDD VDD network.neuron_in106.counter\[1\]
+ sky130_fd_sc_hd__edfxtp_1
Xnetwork.neuron_in106.counter\[2\]$_DFFE_PP_ clknet_leaf_10_clk_net
+ _02489_ _01398_ VSS VSS VDD VDD network.neuron_in106.counter\[2\]
+ sky130_fd_sc_hd__edfxtp_1
Xnetwork.neuron_in106.counter\[3\]$_DFFE_PP_ clknet_leaf_10_clk_net
+ _02490_ _01398_ VSS VSS VDD VDD network.neuron_in106.counter\[3\]
+ sky130_fd_sc_hd__edfxtp_1
Xnetwork.neuron_in106.spike$_SDFFE_PP0P_ clknet_leaf_12_clk_net
+ _02054_ VSS VSS VDD VDD network.in_spk10_06 sky130_fd_sc_hd__dfxtp_1
Xnetwork.neuron_in107.counter\[0\]$_DFFE_PP_ clknet_leaf_9_clk_net
+ _02491_ _01397_ VSS VSS VDD VDD network.neuron_in107.counter\[0\]
+ sky130_fd_sc_hd__edfxtp_1
Xnetwork.neuron_in107.counter\[1\]$_DFFE_PP_ clknet_leaf_7_clk_net
+ _02492_ _01397_ VSS VSS VDD VDD network.neuron_in107.counter\[1\]
+ sky130_fd_sc_hd__edfxtp_1
Xnetwork.neuron_in107.counter\[2\]$_DFFE_PP_ clknet_leaf_13_clk_net
+ _02493_ _01397_ VSS VSS VDD VDD network.neuron_in107.counter\[2\]
+ sky130_fd_sc_hd__edfxtp_1
Xnetwork.neuron_in107.counter\[3\]$_DFFE_PP_ clknet_leaf_9_clk_net
+ _02494_ _01397_ VSS VSS VDD VDD network.neuron_in107.counter\[3\]
+ sky130_fd_sc_hd__edfxtp_1
Xnetwork.neuron_in107.spike$_SDFFE_PP0P_ clknet_leaf_12_clk_net
+ _02053_ VSS VSS VDD VDD network.in_spk11_06 sky130_fd_sc_hd__dfxtp_1
Xnetwork.neuron_in108.counter\[0\]$_DFFE_PP_ clknet_leaf_33_clk_net
+ _02495_ _01396_ VSS VSS VDD VDD network.neuron_in108.counter\[0\]
+ sky130_fd_sc_hd__edfxtp_1
Xnetwork.neuron_in108.counter\[1\]$_DFFE_PP_ clknet_leaf_33_clk_net
+ _02496_ _01396_ VSS VSS VDD VDD network.neuron_in108.counter\[1\]
+ sky130_fd_sc_hd__edfxtp_1
Xnetwork.neuron_in108.counter\[2\]$_DFFE_PP_ clknet_leaf_33_clk_net
+ _02497_ _01396_ VSS VSS VDD VDD network.neuron_in108.counter\[2\]
+ sky130_fd_sc_hd__edfxtp_1
Xnetwork.neuron_in108.counter\[3\]$_DFFE_PP_ clknet_leaf_33_clk_net
+ _02498_ _01396_ VSS VSS VDD VDD network.neuron_in108.counter\[3\]
+ sky130_fd_sc_hd__edfxtp_1
Xnetwork.neuron_in108.spike$_SDFFE_PP0P_ clknet_leaf_11_clk_net
+ _02052_ VSS VSS VDD VDD network.in_spk12_06 sky130_fd_sc_hd__dfxtp_1
Xnetwork.neuron_in109.counter\[0\]$_DFFE_PP_ clknet_leaf_11_clk_net
+ _02499_ _01395_ VSS VSS VDD VDD network.neuron_in109.counter\[0\]
+ sky130_fd_sc_hd__edfxtp_1
Xnetwork.neuron_in109.counter\[1\]$_DFFE_PP_ clknet_leaf_11_clk_net
+ _02500_ _01395_ VSS VSS VDD VDD network.neuron_in109.counter\[1\]
+ sky130_fd_sc_hd__edfxtp_1
Xnetwork.neuron_in109.counter\[2\]$_DFFE_PP_ clknet_leaf_10_clk_net
+ _02501_ _01395_ VSS VSS VDD VDD network.neuron_in109.counter\[2\]
+ sky130_fd_sc_hd__edfxtp_1
Xnetwork.neuron_in109.counter\[3\]$_DFFE_PP_ clknet_leaf_10_clk_net
+ _02502_ _01395_ VSS VSS VDD VDD network.neuron_in109.counter\[3\]
+ sky130_fd_sc_hd__edfxtp_1
Xnetwork.neuron_in109.spike$_SDFFE_PP0P_ clknet_leaf_12_clk_net
+ _02051_ VSS VSS VDD VDD network.in_spk13_06 sky130_fd_sc_hd__dfxtp_1
Xnetwork.neuron_in110.counter\[0\]$_DFFE_PP_ clknet_leaf_10_clk_net
+ _02503_ _01394_ VSS VSS VDD VDD network.neuron_in110.counter\[0\]
+ sky130_fd_sc_hd__edfxtp_1
Xnetwork.neuron_in110.counter\[1\]$_DFFE_PP_ clknet_leaf_10_clk_net
+ _02504_ _01394_ VSS VSS VDD VDD network.neuron_in110.counter\[1\]
+ sky130_fd_sc_hd__edfxtp_1
Xnetwork.neuron_in110.counter\[2\]$_DFFE_PP_ clknet_leaf_9_clk_net
+ _02505_ _01394_ VSS VSS VDD VDD network.neuron_in110.counter\[2\]
+ sky130_fd_sc_hd__edfxtp_1
Xnetwork.neuron_in110.counter\[3\]$_DFFE_PP_ clknet_leaf_9_clk_net
+ _02506_ _01394_ VSS VSS VDD VDD network.neuron_in110.counter\[3\]
+ sky130_fd_sc_hd__edfxtp_1
Xnetwork.neuron_in110.spike$_SDFFE_PP0P_ clknet_leaf_12_clk_net
+ _02050_ VSS VSS VDD VDD network.in_spk14_06 sky130_fd_sc_hd__dfxtp_1
Xnetwork.neuron_in111.counter\[0\]$_DFFE_PP_ clknet_leaf_15_clk_net
+ _02507_ _01393_ VSS VSS VDD VDD network.neuron_in111.counter\[0\]
+ sky130_fd_sc_hd__edfxtp_1
Xnetwork.neuron_in111.counter\[1\]$_DFFE_PP_ clknet_leaf_15_clk_net
+ _02508_ _01393_ VSS VSS VDD VDD network.neuron_in111.counter\[1\]
+ sky130_fd_sc_hd__edfxtp_1
Xnetwork.neuron_in111.counter\[2\]$_DFFE_PP_ clknet_leaf_13_clk_net
+ _02509_ _01393_ VSS VSS VDD VDD network.neuron_in111.counter\[2\]
+ sky130_fd_sc_hd__edfxtp_1
Xnetwork.neuron_in111.counter\[3\]$_DFFE_PP_ clknet_leaf_13_clk_net
+ _02510_ _01393_ VSS VSS VDD VDD network.neuron_in111.counter\[3\]
+ sky130_fd_sc_hd__edfxtp_1
Xnetwork.neuron_in111.spike$_SDFFE_PP0P_ clknet_leaf_12_clk_net
+ _02049_ VSS VSS VDD VDD network.in_spk15_06 sky130_fd_sc_hd__dfxtp_1
Xnetwork.neuron_in112.counter\[0\]$_DFFE_PP_ clknet_leaf_9_clk_net
+ _02511_ _01392_ VSS VSS VDD VDD network.neuron_in112.counter\[0\]
+ sky130_fd_sc_hd__edfxtp_1
Xnetwork.neuron_in112.counter\[1\]$_DFFE_PP_ clknet_leaf_9_clk_net
+ _02512_ _01392_ VSS VSS VDD VDD network.neuron_in112.counter\[1\]
+ sky130_fd_sc_hd__edfxtp_1
Xnetwork.neuron_in112.counter\[2\]$_DFFE_PP_ clknet_leaf_8_clk_net
+ _02513_ _01392_ VSS VSS VDD VDD network.neuron_in112.counter\[2\]
+ sky130_fd_sc_hd__edfxtp_1
Xnetwork.neuron_in112.counter\[3\]$_DFFE_PP_ clknet_leaf_9_clk_net
+ _02514_ _01392_ VSS VSS VDD VDD network.neuron_in112.counter\[3\]
+ sky130_fd_sc_hd__edfxtp_1
Xnetwork.neuron_in112.spike$_SDFFE_PP0P_ clknet_leaf_6_clk_net
+ _02048_ VSS VSS VDD VDD network.in_spk00_07 sky130_fd_sc_hd__dfxtp_1
Xnetwork.neuron_in113.counter\[0\]$_DFFE_PP_ clknet_leaf_15_clk_net
+ _02515_ _01391_ VSS VSS VDD VDD network.neuron_in113.counter\[0\]
+ sky130_fd_sc_hd__edfxtp_1
Xnetwork.neuron_in113.counter\[1\]$_DFFE_PP_ clknet_leaf_15_clk_net
+ _02516_ _01391_ VSS VSS VDD VDD network.neuron_in113.counter\[1\]
+ sky130_fd_sc_hd__edfxtp_1
Xnetwork.neuron_in113.counter\[2\]$_DFFE_PP_ clknet_leaf_6_clk_net
+ _02517_ _01391_ VSS VSS VDD VDD network.neuron_in113.counter\[2\]
+ sky130_fd_sc_hd__edfxtp_1
Xnetwork.neuron_in113.counter\[3\]$_DFFE_PP_ clknet_leaf_15_clk_net
+ _02518_ _01391_ VSS VSS VDD VDD network.neuron_in113.counter\[3\]
+ sky130_fd_sc_hd__edfxtp_1
Xnetwork.neuron_in113.spike$_SDFFE_PP0P_ clknet_leaf_15_clk_net
+ _02047_ VSS VSS VDD VDD network.in_spk01_07 sky130_fd_sc_hd__dfxtp_1
Xnetwork.neuron_in114.counter\[0\]$_DFFE_PP_ clknet_leaf_17_clk_net
+ _02519_ _01390_ VSS VSS VDD VDD network.neuron_in114.counter\[0\]
+ sky130_fd_sc_hd__edfxtp_1
Xnetwork.neuron_in114.counter\[1\]$_DFFE_PP_ clknet_leaf_17_clk_net
+ _02520_ _01390_ VSS VSS VDD VDD network.neuron_in114.counter\[1\]
+ sky130_fd_sc_hd__edfxtp_1
Xnetwork.neuron_in114.counter\[2\]$_DFFE_PP_ clknet_leaf_17_clk_net
+ _02521_ _01390_ VSS VSS VDD VDD network.neuron_in114.counter\[2\]
+ sky130_fd_sc_hd__edfxtp_1
Xnetwork.neuron_in114.counter\[3\]$_DFFE_PP_ clknet_leaf_17_clk_net
+ _02522_ _01390_ VSS VSS VDD VDD network.neuron_in114.counter\[3\]
+ sky130_fd_sc_hd__edfxtp_1
Xnetwork.neuron_in114.spike$_SDFFE_PP0P_ clknet_leaf_16_clk_net
+ _02046_ VSS VSS VDD VDD network.in_spk02_07 sky130_fd_sc_hd__dfxtp_1
Xnetwork.neuron_in115.counter\[0\]$_DFFE_PP_ clknet_leaf_16_clk_net
+ _02523_ _01389_ VSS VSS VDD VDD network.neuron_in115.counter\[0\]
+ sky130_fd_sc_hd__edfxtp_1
Xnetwork.neuron_in115.counter\[1\]$_DFFE_PP_ clknet_leaf_16_clk_net
+ _02524_ _01389_ VSS VSS VDD VDD network.neuron_in115.counter\[1\]
+ sky130_fd_sc_hd__edfxtp_1
Xnetwork.neuron_in115.counter\[2\]$_DFFE_PP_ clknet_leaf_16_clk_net
+ _02525_ _01389_ VSS VSS VDD VDD network.neuron_in115.counter\[2\]
+ sky130_fd_sc_hd__edfxtp_1
Xnetwork.neuron_in115.counter\[3\]$_DFFE_PP_ clknet_leaf_16_clk_net
+ _02526_ _01389_ VSS VSS VDD VDD network.neuron_in115.counter\[3\]
+ sky130_fd_sc_hd__edfxtp_1
Xnetwork.neuron_in115.spike$_SDFFE_PP0P_ clknet_leaf_16_clk_net
+ _02045_ VSS VSS VDD VDD network.in_spk03_07 sky130_fd_sc_hd__dfxtp_1
Xnetwork.neuron_in116.counter\[0\]$_DFFE_PP_ clknet_leaf_9_clk_net
+ _02527_ _01388_ VSS VSS VDD VDD network.neuron_in116.counter\[0\]
+ sky130_fd_sc_hd__edfxtp_1
Xnetwork.neuron_in116.counter\[1\]$_DFFE_PP_ clknet_leaf_9_clk_net
+ _02528_ _01388_ VSS VSS VDD VDD network.neuron_in116.counter\[1\]
+ sky130_fd_sc_hd__edfxtp_1
Xnetwork.neuron_in116.counter\[2\]$_DFFE_PP_ clknet_leaf_7_clk_net
+ _02529_ _01388_ VSS VSS VDD VDD network.neuron_in116.counter\[2\]
+ sky130_fd_sc_hd__edfxtp_1
Xnetwork.neuron_in116.counter\[3\]$_DFFE_PP_ clknet_leaf_7_clk_net
+ _02530_ _01388_ VSS VSS VDD VDD network.neuron_in116.counter\[3\]
+ sky130_fd_sc_hd__edfxtp_1
Xnetwork.neuron_in116.spike$_SDFFE_PP0P_ clknet_leaf_6_clk_net
+ _02044_ VSS VSS VDD VDD network.in_spk04_07 sky130_fd_sc_hd__dfxtp_1
Xnetwork.neuron_in117.counter\[0\]$_DFFE_PP_ clknet_leaf_8_clk_net
+ _02531_ _01387_ VSS VSS VDD VDD network.neuron_in117.counter\[0\]
+ sky130_fd_sc_hd__edfxtp_1
Xnetwork.neuron_in117.counter\[1\]$_DFFE_PP_ clknet_leaf_8_clk_net
+ _02532_ _01387_ VSS VSS VDD VDD network.neuron_in117.counter\[1\]
+ sky130_fd_sc_hd__edfxtp_1
Xnetwork.neuron_in117.counter\[2\]$_DFFE_PP_ clknet_leaf_7_clk_net
+ _02533_ _01387_ VSS VSS VDD VDD network.neuron_in117.counter\[2\]
+ sky130_fd_sc_hd__edfxtp_1
Xnetwork.neuron_in117.counter\[3\]$_DFFE_PP_ clknet_leaf_8_clk_net
+ _02534_ _01387_ VSS VSS VDD VDD network.neuron_in117.counter\[3\]
+ sky130_fd_sc_hd__edfxtp_1
Xnetwork.neuron_in117.spike$_SDFFE_PP0P_ clknet_leaf_6_clk_net
+ _02043_ VSS VSS VDD VDD network.in_spk05_07 sky130_fd_sc_hd__dfxtp_1
Xnetwork.neuron_in118.counter\[0\]$_DFFE_PP_ clknet_leaf_151_clk_net
+ _02535_ _01386_ VSS VSS VDD VDD network.neuron_in118.counter\[0\]
+ sky130_fd_sc_hd__edfxtp_1
Xnetwork.neuron_in118.counter\[1\]$_DFFE_PP_ clknet_leaf_16_clk_net
+ _02536_ _01386_ VSS VSS VDD VDD network.neuron_in118.counter\[1\]
+ sky130_fd_sc_hd__edfxtp_1
Xnetwork.neuron_in118.counter\[2\]$_DFFE_PP_ clknet_leaf_16_clk_net
+ _02537_ _01386_ VSS VSS VDD VDD network.neuron_in118.counter\[2\]
+ sky130_fd_sc_hd__edfxtp_1
Xnetwork.neuron_in118.counter\[3\]$_DFFE_PP_ clknet_leaf_16_clk_net
+ _02538_ _01386_ VSS VSS VDD VDD network.neuron_in118.counter\[3\]
+ sky130_fd_sc_hd__edfxtp_1
Xnetwork.neuron_in118.spike$_SDFFE_PP0P_ clknet_leaf_16_clk_net
+ _02042_ VSS VSS VDD VDD network.in_spk06_07 sky130_fd_sc_hd__dfxtp_1
Xnetwork.neuron_in119.counter\[0\]$_DFFE_PP_ clknet_leaf_7_clk_net
+ _02539_ _01385_ VSS VSS VDD VDD network.neuron_in119.counter\[0\]
+ sky130_fd_sc_hd__edfxtp_1
Xnetwork.neuron_in119.counter\[1\]$_DFFE_PP_ clknet_leaf_7_clk_net
+ _02540_ _01385_ VSS VSS VDD VDD network.neuron_in119.counter\[1\]
+ sky130_fd_sc_hd__edfxtp_1
Xnetwork.neuron_in119.counter\[2\]$_DFFE_PP_ clknet_leaf_7_clk_net
+ _02541_ _01385_ VSS VSS VDD VDD network.neuron_in119.counter\[2\]
+ sky130_fd_sc_hd__edfxtp_1
Xnetwork.neuron_in119.counter\[3\]$_DFFE_PP_ clknet_leaf_7_clk_net
+ _02542_ _01385_ VSS VSS VDD VDD network.neuron_in119.counter\[3\]
+ sky130_fd_sc_hd__edfxtp_1
Xnetwork.neuron_in119.spike$_SDFFE_PP0P_ clknet_leaf_6_clk_net
+ _02041_ VSS VSS VDD VDD network.in_spk07_07 sky130_fd_sc_hd__dfxtp_1
Xnetwork.neuron_in120.counter\[0\]$_DFFE_PP_ clknet_leaf_8_clk_net
+ _02543_ _01384_ VSS VSS VDD VDD network.neuron_in120.counter\[0\]
+ sky130_fd_sc_hd__edfxtp_1
Xnetwork.neuron_in120.counter\[1\]$_DFFE_PP_ clknet_leaf_8_clk_net
+ _02544_ _01384_ VSS VSS VDD VDD network.neuron_in120.counter\[1\]
+ sky130_fd_sc_hd__edfxtp_1
Xnetwork.neuron_in120.counter\[2\]$_DFFE_PP_ clknet_leaf_8_clk_net
+ _02545_ _01384_ VSS VSS VDD VDD network.neuron_in120.counter\[2\]
+ sky130_fd_sc_hd__edfxtp_1
Xnetwork.neuron_in120.counter\[3\]$_DFFE_PP_ clknet_leaf_8_clk_net
+ _02546_ _01384_ VSS VSS VDD VDD network.neuron_in120.counter\[3\]
+ sky130_fd_sc_hd__edfxtp_1
Xnetwork.neuron_in120.spike$_SDFFE_PP0P_ clknet_leaf_6_clk_net
+ _02040_ VSS VSS VDD VDD network.in_spk08_07 sky130_fd_sc_hd__dfxtp_1
Xnetwork.neuron_in121.counter\[0\]$_DFFE_PP_ clknet_leaf_4_clk_net
+ _02547_ _01383_ VSS VSS VDD VDD network.neuron_in121.counter\[0\]
+ sky130_fd_sc_hd__edfxtp_1
Xnetwork.neuron_in121.counter\[1\]$_DFFE_PP_ clknet_leaf_4_clk_net
+ _02548_ _01383_ VSS VSS VDD VDD network.neuron_in121.counter\[1\]
+ sky130_fd_sc_hd__edfxtp_1
Xnetwork.neuron_in121.counter\[2\]$_DFFE_PP_ clknet_leaf_5_clk_net
+ _02549_ _01383_ VSS VSS VDD VDD network.neuron_in121.counter\[2\]
+ sky130_fd_sc_hd__edfxtp_1
Xnetwork.neuron_in121.counter\[3\]$_DFFE_PP_ clknet_leaf_5_clk_net
+ _02550_ _01383_ VSS VSS VDD VDD network.neuron_in121.counter\[3\]
+ sky130_fd_sc_hd__edfxtp_1
Xnetwork.neuron_in121.spike$_SDFFE_PP0P_ clknet_leaf_5_clk_net
+ _02039_ VSS VSS VDD VDD network.in_spk09_07 sky130_fd_sc_hd__dfxtp_1
Xnetwork.neuron_in122.counter\[0\]$_DFFE_PP_ clknet_leaf_3_clk_net
+ _02551_ _01382_ VSS VSS VDD VDD network.neuron_in122.counter\[0\]
+ sky130_fd_sc_hd__edfxtp_1
Xnetwork.neuron_in122.counter\[1\]$_DFFE_PP_ clknet_leaf_3_clk_net
+ _02552_ _01382_ VSS VSS VDD VDD network.neuron_in122.counter\[1\]
+ sky130_fd_sc_hd__edfxtp_1
Xnetwork.neuron_in122.counter\[2\]$_DFFE_PP_ clknet_leaf_7_clk_net
+ _02553_ _01382_ VSS VSS VDD VDD network.neuron_in122.counter\[2\]
+ sky130_fd_sc_hd__edfxtp_1
Xnetwork.neuron_in122.counter\[3\]$_DFFE_PP_ clknet_leaf_3_clk_net
+ _02554_ _01382_ VSS VSS VDD VDD network.neuron_in122.counter\[3\]
+ sky130_fd_sc_hd__edfxtp_1
Xnetwork.neuron_in122.spike$_SDFFE_PP0P_ clknet_leaf_5_clk_net
+ _02038_ VSS VSS VDD VDD network.in_spk10_07 sky130_fd_sc_hd__dfxtp_1
Xnetwork.neuron_in123.counter\[0\]$_DFFE_PP_ clknet_leaf_5_clk_net
+ _02555_ _01381_ VSS VSS VDD VDD network.neuron_in123.counter\[0\]
+ sky130_fd_sc_hd__edfxtp_1
Xnetwork.neuron_in123.counter\[1\]$_DFFE_PP_ clknet_leaf_5_clk_net
+ _02556_ _01381_ VSS VSS VDD VDD network.neuron_in123.counter\[1\]
+ sky130_fd_sc_hd__edfxtp_1
Xnetwork.neuron_in123.counter\[2\]$_DFFE_PP_ clknet_leaf_162_clk_net
+ _02557_ _01381_ VSS VSS VDD VDD network.neuron_in123.counter\[2\]
+ sky130_fd_sc_hd__edfxtp_1
Xnetwork.neuron_in123.counter\[3\]$_DFFE_PP_ clknet_leaf_162_clk_net
+ _02558_ _01381_ VSS VSS VDD VDD network.neuron_in123.counter\[3\]
+ sky130_fd_sc_hd__edfxtp_1
Xnetwork.neuron_in123.spike$_SDFFE_PP0P_ clknet_leaf_5_clk_net
+ _02037_ VSS VSS VDD VDD network.in_spk11_07 sky130_fd_sc_hd__dfxtp_1
Xnetwork.neuron_in124.counter\[0\]$_DFFE_PP_ clknet_leaf_8_clk_net
+ _02559_ _01380_ VSS VSS VDD VDD network.neuron_in124.counter\[0\]
+ sky130_fd_sc_hd__edfxtp_1
Xnetwork.neuron_in124.counter\[1\]$_DFFE_PP_ clknet_leaf_2_clk_net
+ _02560_ _01380_ VSS VSS VDD VDD network.neuron_in124.counter\[1\]
+ sky130_fd_sc_hd__edfxtp_1
Xnetwork.neuron_in124.counter\[2\]$_DFFE_PP_ clknet_leaf_2_clk_net
+ _02561_ _01380_ VSS VSS VDD VDD network.neuron_in124.counter\[2\]
+ sky130_fd_sc_hd__edfxtp_1
Xnetwork.neuron_in124.counter\[3\]$_DFFE_PP_ clknet_leaf_2_clk_net
+ _02562_ _01380_ VSS VSS VDD VDD network.neuron_in124.counter\[3\]
+ sky130_fd_sc_hd__edfxtp_1
Xnetwork.neuron_in124.spike$_SDFFE_PP0P_ clknet_leaf_6_clk_net
+ _02036_ VSS VSS VDD VDD network.in_spk12_07 sky130_fd_sc_hd__dfxtp_1
Xnetwork.neuron_in125.counter\[0\]$_DFFE_PP_ clknet_leaf_2_clk_net
+ _02563_ _01379_ VSS VSS VDD VDD network.neuron_in125.counter\[0\]
+ sky130_fd_sc_hd__edfxtp_1
Xnetwork.neuron_in125.counter\[1\]$_DFFE_PP_ clknet_leaf_2_clk_net
+ _02564_ _01379_ VSS VSS VDD VDD network.neuron_in125.counter\[1\]
+ sky130_fd_sc_hd__edfxtp_1
Xnetwork.neuron_in125.counter\[2\]$_DFFE_PP_ clknet_leaf_2_clk_net
+ _02565_ _01379_ VSS VSS VDD VDD network.neuron_in125.counter\[2\]
+ sky130_fd_sc_hd__edfxtp_1
Xnetwork.neuron_in125.counter\[3\]$_DFFE_PP_ clknet_leaf_2_clk_net
+ _02566_ _01379_ VSS VSS VDD VDD network.neuron_in125.counter\[3\]
+ sky130_fd_sc_hd__edfxtp_1
Xnetwork.neuron_in125.spike$_SDFFE_PP0P_ clknet_leaf_6_clk_net
+ _02035_ VSS VSS VDD VDD network.in_spk13_07 sky130_fd_sc_hd__dfxtp_1
Xnetwork.neuron_in126.counter\[0\]$_DFFE_PP_ clknet_leaf_3_clk_net
+ _02567_ _01378_ VSS VSS VDD VDD network.neuron_in126.counter\[0\]
+ sky130_fd_sc_hd__edfxtp_1
Xnetwork.neuron_in126.counter\[1\]$_DFFE_PP_ clknet_leaf_3_clk_net
+ _02568_ _01378_ VSS VSS VDD VDD network.neuron_in126.counter\[1\]
+ sky130_fd_sc_hd__edfxtp_1
Xnetwork.neuron_in126.counter\[2\]$_DFFE_PP_ clknet_leaf_1_clk_net
+ _02569_ _01378_ VSS VSS VDD VDD network.neuron_in126.counter\[2\]
+ sky130_fd_sc_hd__edfxtp_1
Xnetwork.neuron_in126.counter\[3\]$_DFFE_PP_ clknet_leaf_3_clk_net
+ _02570_ _01378_ VSS VSS VDD VDD network.neuron_in126.counter\[3\]
+ sky130_fd_sc_hd__edfxtp_1
Xnetwork.neuron_in126.spike$_SDFFE_PP0P_ clknet_leaf_4_clk_net
+ _02034_ VSS VSS VDD VDD network.in_spk14_07 sky130_fd_sc_hd__dfxtp_1
Xnetwork.neuron_in127.counter\[0\]$_DFFE_PP_ clknet_leaf_3_clk_net
+ _02571_ _01377_ VSS VSS VDD VDD network.neuron_in127.counter\[0\]
+ sky130_fd_sc_hd__edfxtp_1
Xnetwork.neuron_in127.counter\[1\]$_DFFE_PP_ clknet_leaf_3_clk_net
+ _02572_ _01377_ VSS VSS VDD VDD network.neuron_in127.counter\[1\]
+ sky130_fd_sc_hd__edfxtp_1
Xnetwork.neuron_in127.counter\[2\]$_DFFE_PP_ clknet_leaf_4_clk_net
+ _02573_ _01377_ VSS VSS VDD VDD network.neuron_in127.counter\[2\]
+ sky130_fd_sc_hd__edfxtp_1
Xnetwork.neuron_in127.counter\[3\]$_DFFE_PP_ clknet_leaf_4_clk_net
+ _02574_ _01377_ VSS VSS VDD VDD network.neuron_in127.counter\[3\]
+ sky130_fd_sc_hd__edfxtp_1
Xnetwork.neuron_in127.spike$_SDFFE_PP0P_ clknet_leaf_6_clk_net
+ _02033_ VSS VSS VDD VDD network.in_spk15_07 sky130_fd_sc_hd__dfxtp_1
Xnetwork.neuron_in128.counter\[0\]$_DFFE_PP_ clknet_leaf_162_clk_net
+ _02575_ _01376_ VSS VSS VDD VDD network.neuron_in128.counter\[0\]
+ sky130_fd_sc_hd__edfxtp_1
Xnetwork.neuron_in128.counter\[1\]$_DFFE_PP_ clknet_leaf_162_clk_net
+ _02576_ _01376_ VSS VSS VDD VDD network.neuron_in128.counter\[1\]
+ sky130_fd_sc_hd__edfxtp_1
Xnetwork.neuron_in128.counter\[2\]$_DFFE_PP_ clknet_leaf_161_clk_net
+ _02577_ _01376_ VSS VSS VDD VDD network.neuron_in128.counter\[2\]
+ sky130_fd_sc_hd__edfxtp_1
Xnetwork.neuron_in128.counter\[3\]$_DFFE_PP_ clknet_leaf_162_clk_net
+ _02578_ _01376_ VSS VSS VDD VDD network.neuron_in128.counter\[3\]
+ sky130_fd_sc_hd__edfxtp_1
Xnetwork.neuron_in128.spike$_SDFFE_PP0P_ clknet_leaf_161_clk_net
+ _02032_ VSS VSS VDD VDD network.in_spk00_08 sky130_fd_sc_hd__dfxtp_1
Xnetwork.neuron_in129.counter\[0\]$_DFFE_PP_ clknet_leaf_151_clk_net
+ _02579_ _01375_ VSS VSS VDD VDD network.neuron_in129.counter\[0\]
+ sky130_fd_sc_hd__edfxtp_1
Xnetwork.neuron_in129.counter\[1\]$_DFFE_PP_ clknet_leaf_151_clk_net
+ _02580_ _01375_ VSS VSS VDD VDD network.neuron_in129.counter\[1\]
+ sky130_fd_sc_hd__edfxtp_1
Xnetwork.neuron_in129.counter\[2\]$_DFFE_PP_ clknet_leaf_151_clk_net
+ _02581_ _01375_ VSS VSS VDD VDD network.neuron_in129.counter\[2\]
+ sky130_fd_sc_hd__edfxtp_1
Xnetwork.neuron_in129.counter\[3\]$_DFFE_PP_ clknet_leaf_150_clk_net
+ _02582_ _01375_ VSS VSS VDD VDD network.neuron_in129.counter\[3\]
+ sky130_fd_sc_hd__edfxtp_1
Xnetwork.neuron_in129.spike$_SDFFE_PP0P_ clknet_leaf_151_clk_net
+ _02031_ VSS VSS VDD VDD network.in_spk01_08 sky130_fd_sc_hd__dfxtp_1
Xnetwork.neuron_in130.counter\[0\]$_DFFE_PP_ clknet_leaf_160_clk_net
+ _02583_ _01374_ VSS VSS VDD VDD network.neuron_in130.counter\[0\]
+ sky130_fd_sc_hd__edfxtp_1
Xnetwork.neuron_in130.counter\[1\]$_DFFE_PP_ clknet_leaf_160_clk_net
+ _02584_ _01374_ VSS VSS VDD VDD network.neuron_in130.counter\[1\]
+ sky130_fd_sc_hd__edfxtp_1
Xnetwork.neuron_in130.counter\[2\]$_DFFE_PP_ clknet_leaf_158_clk_net
+ _02585_ _01374_ VSS VSS VDD VDD network.neuron_in130.counter\[2\]
+ sky130_fd_sc_hd__edfxtp_1
Xnetwork.neuron_in130.counter\[3\]$_DFFE_PP_ clknet_leaf_160_clk_net
+ _02586_ _01374_ VSS VSS VDD VDD network.neuron_in130.counter\[3\]
+ sky130_fd_sc_hd__edfxtp_1
Xnetwork.neuron_in130.spike$_SDFFE_PP0P_ clknet_leaf_161_clk_net
+ _02030_ VSS VSS VDD VDD network.in_spk02_08 sky130_fd_sc_hd__dfxtp_1
Xnetwork.neuron_in131.counter\[0\]$_DFFE_PP_ clknet_leaf_151_clk_net
+ _02587_ _01373_ VSS VSS VDD VDD network.neuron_in131.counter\[0\]
+ sky130_fd_sc_hd__edfxtp_1
Xnetwork.neuron_in131.counter\[1\]$_DFFE_PP_ clknet_leaf_151_clk_net
+ _02588_ _01373_ VSS VSS VDD VDD network.neuron_in131.counter\[1\]
+ sky130_fd_sc_hd__edfxtp_1
Xnetwork.neuron_in131.counter\[2\]$_DFFE_PP_ clknet_leaf_162_clk_net
+ _02589_ _01373_ VSS VSS VDD VDD network.neuron_in131.counter\[2\]
+ sky130_fd_sc_hd__edfxtp_1
Xnetwork.neuron_in131.counter\[3\]$_DFFE_PP_ clknet_leaf_151_clk_net
+ _02590_ _01373_ VSS VSS VDD VDD network.neuron_in131.counter\[3\]
+ sky130_fd_sc_hd__edfxtp_1
Xnetwork.neuron_in131.spike$_SDFFE_PP0P_ clknet_leaf_161_clk_net
+ _02029_ VSS VSS VDD VDD network.in_spk03_08 sky130_fd_sc_hd__dfxtp_1
Xnetwork.neuron_in132.counter\[0\]$_DFFE_PP_ clknet_leaf_161_clk_net
+ _02591_ _01372_ VSS VSS VDD VDD network.neuron_in132.counter\[0\]
+ sky130_fd_sc_hd__edfxtp_1
Xnetwork.neuron_in132.counter\[1\]$_DFFE_PP_ clknet_leaf_161_clk_net
+ _02592_ _01372_ VSS VSS VDD VDD network.neuron_in132.counter\[1\]
+ sky130_fd_sc_hd__edfxtp_1
Xnetwork.neuron_in132.counter\[2\]$_DFFE_PP_ clknet_leaf_161_clk_net
+ _02593_ _01372_ VSS VSS VDD VDD network.neuron_in132.counter\[2\]
+ sky130_fd_sc_hd__edfxtp_1
Xnetwork.neuron_in132.counter\[3\]$_DFFE_PP_ clknet_leaf_161_clk_net
+ _02594_ _01372_ VSS VSS VDD VDD network.neuron_in132.counter\[3\]
+ sky130_fd_sc_hd__edfxtp_1
Xnetwork.neuron_in132.spike$_SDFFE_PP0P_ clknet_leaf_161_clk_net
+ _02028_ VSS VSS VDD VDD network.in_spk04_08 sky130_fd_sc_hd__dfxtp_1
Xnetwork.neuron_in133.counter\[0\]$_DFFE_PP_ clknet_leaf_152_clk_net
+ _02595_ _01371_ VSS VSS VDD VDD network.neuron_in133.counter\[0\]
+ sky130_fd_sc_hd__edfxtp_1
Xnetwork.neuron_in133.counter\[1\]$_DFFE_PP_ clknet_leaf_152_clk_net
+ _02596_ _01371_ VSS VSS VDD VDD network.neuron_in133.counter\[1\]
+ sky130_fd_sc_hd__edfxtp_1
Xnetwork.neuron_in133.counter\[2\]$_DFFE_PP_ clknet_leaf_153_clk_net
+ _02597_ _01371_ VSS VSS VDD VDD network.neuron_in133.counter\[2\]
+ sky130_fd_sc_hd__edfxtp_1
Xnetwork.neuron_in133.counter\[3\]$_DFFE_PP_ clknet_leaf_152_clk_net
+ _02598_ _01371_ VSS VSS VDD VDD network.neuron_in133.counter\[3\]
+ sky130_fd_sc_hd__edfxtp_1
Xnetwork.neuron_in133.spike$_SDFFE_PP0P_ clknet_leaf_152_clk_net
+ _02027_ VSS VSS VDD VDD network.in_spk05_08 sky130_fd_sc_hd__dfxtp_1
Xnetwork.neuron_in134.counter\[0\]$_DFFE_PP_ clknet_leaf_154_clk_net
+ _02599_ _01370_ VSS VSS VDD VDD network.neuron_in134.counter\[0\]
+ sky130_fd_sc_hd__edfxtp_1
Xnetwork.neuron_in134.counter\[1\]$_DFFE_PP_ clknet_leaf_154_clk_net
+ _02600_ _01370_ VSS VSS VDD VDD network.neuron_in134.counter\[1\]
+ sky130_fd_sc_hd__edfxtp_1
Xnetwork.neuron_in134.counter\[2\]$_DFFE_PP_ clknet_leaf_154_clk_net
+ _02601_ _01370_ VSS VSS VDD VDD network.neuron_in134.counter\[2\]
+ sky130_fd_sc_hd__edfxtp_1
Xnetwork.neuron_in134.counter\[3\]$_DFFE_PP_ clknet_leaf_154_clk_net
+ _02602_ _01370_ VSS VSS VDD VDD network.neuron_in134.counter\[3\]
+ sky130_fd_sc_hd__edfxtp_1
Xnetwork.neuron_in134.spike$_SDFFE_PP0P_ clknet_leaf_152_clk_net
+ _02026_ VSS VSS VDD VDD network.in_spk06_08 sky130_fd_sc_hd__dfxtp_1
Xnetwork.neuron_in135.counter\[0\]$_DFFE_PP_ clknet_leaf_152_clk_net
+ _02603_ _01369_ VSS VSS VDD VDD network.neuron_in135.counter\[0\]
+ sky130_fd_sc_hd__edfxtp_1
Xnetwork.neuron_in135.counter\[1\]$_DFFE_PP_ clknet_leaf_152_clk_net
+ _02604_ _01369_ VSS VSS VDD VDD network.neuron_in135.counter\[1\]
+ sky130_fd_sc_hd__edfxtp_1
Xnetwork.neuron_in135.counter\[2\]$_DFFE_PP_ clknet_leaf_151_clk_net
+ _02605_ _01369_ VSS VSS VDD VDD network.neuron_in135.counter\[2\]
+ sky130_fd_sc_hd__edfxtp_1
Xnetwork.neuron_in135.counter\[3\]$_DFFE_PP_ clknet_leaf_152_clk_net
+ _02606_ _01369_ VSS VSS VDD VDD network.neuron_in135.counter\[3\]
+ sky130_fd_sc_hd__edfxtp_1
Xnetwork.neuron_in135.spike$_SDFFE_PP0P_ clknet_leaf_152_clk_net
+ _02025_ VSS VSS VDD VDD network.in_spk07_08 sky130_fd_sc_hd__dfxtp_1
Xnetwork.neuron_in136.counter\[0\]$_DFFE_PP_ clknet_leaf_160_clk_net
+ _02607_ _01368_ VSS VSS VDD VDD network.neuron_in136.counter\[0\]
+ sky130_fd_sc_hd__edfxtp_1
Xnetwork.neuron_in136.counter\[1\]$_DFFE_PP_ clknet_leaf_160_clk_net
+ _02608_ _01368_ VSS VSS VDD VDD network.neuron_in136.counter\[1\]
+ sky130_fd_sc_hd__edfxtp_1
Xnetwork.neuron_in136.counter\[2\]$_DFFE_PP_ clknet_leaf_160_clk_net
+ _02609_ _01368_ VSS VSS VDD VDD network.neuron_in136.counter\[2\]
+ sky130_fd_sc_hd__edfxtp_1
Xnetwork.neuron_in136.counter\[3\]$_DFFE_PP_ clknet_leaf_160_clk_net
+ _02610_ _01368_ VSS VSS VDD VDD network.neuron_in136.counter\[3\]
+ sky130_fd_sc_hd__edfxtp_1
Xnetwork.neuron_in136.spike$_SDFFE_PP0P_ clknet_leaf_160_clk_net
+ _02024_ VSS VSS VDD VDD network.in_spk08_08 sky130_fd_sc_hd__dfxtp_1
Xnetwork.neuron_in137.counter\[0\]$_DFFE_PP_ clknet_leaf_159_clk_net
+ _02611_ _01367_ VSS VSS VDD VDD network.neuron_in137.counter\[0\]
+ sky130_fd_sc_hd__edfxtp_1
Xnetwork.neuron_in137.counter\[1\]$_DFFE_PP_ clknet_leaf_159_clk_net
+ _02612_ _01367_ VSS VSS VDD VDD network.neuron_in137.counter\[1\]
+ sky130_fd_sc_hd__edfxtp_1
Xnetwork.neuron_in137.counter\[2\]$_DFFE_PP_ clknet_leaf_159_clk_net
+ _02613_ _01367_ VSS VSS VDD VDD network.neuron_in137.counter\[2\]
+ sky130_fd_sc_hd__edfxtp_1
Xnetwork.neuron_in137.counter\[3\]$_DFFE_PP_ clknet_leaf_159_clk_net
+ _02614_ _01367_ VSS VSS VDD VDD network.neuron_in137.counter\[3\]
+ sky130_fd_sc_hd__edfxtp_1
Xnetwork.neuron_in137.spike$_SDFFE_PP0P_ clknet_leaf_161_clk_net
+ _02023_ VSS VSS VDD VDD network.in_spk09_08 sky130_fd_sc_hd__dfxtp_1
Xnetwork.neuron_in138.counter\[0\]$_DFFE_PP_ clknet_leaf_158_clk_net
+ _02615_ _01366_ VSS VSS VDD VDD network.neuron_in138.counter\[0\]
+ sky130_fd_sc_hd__edfxtp_1
Xnetwork.neuron_in138.counter\[1\]$_DFFE_PP_ clknet_leaf_158_clk_net
+ _02616_ _01366_ VSS VSS VDD VDD network.neuron_in138.counter\[1\]
+ sky130_fd_sc_hd__edfxtp_1
Xnetwork.neuron_in138.counter\[2\]$_DFFE_PP_ clknet_leaf_158_clk_net
+ _02617_ _01366_ VSS VSS VDD VDD network.neuron_in138.counter\[2\]
+ sky130_fd_sc_hd__edfxtp_1
Xnetwork.neuron_in138.counter\[3\]$_DFFE_PP_ clknet_leaf_158_clk_net
+ _02618_ _01366_ VSS VSS VDD VDD network.neuron_in138.counter\[3\]
+ sky130_fd_sc_hd__edfxtp_1
Xnetwork.neuron_in138.spike$_SDFFE_PP0P_ clknet_leaf_160_clk_net
+ _02022_ VSS VSS VDD VDD network.in_spk10_08 sky130_fd_sc_hd__dfxtp_1
Xnetwork.neuron_in139.counter\[0\]$_DFFE_PP_ clknet_leaf_159_clk_net
+ _02619_ _01365_ VSS VSS VDD VDD network.neuron_in139.counter\[0\]
+ sky130_fd_sc_hd__edfxtp_1
Xnetwork.neuron_in139.counter\[1\]$_DFFE_PP_ clknet_leaf_159_clk_net
+ _02620_ _01365_ VSS VSS VDD VDD network.neuron_in139.counter\[1\]
+ sky130_fd_sc_hd__edfxtp_1
Xnetwork.neuron_in139.counter\[2\]$_DFFE_PP_ clknet_leaf_159_clk_net
+ _02621_ _01365_ VSS VSS VDD VDD network.neuron_in139.counter\[2\]
+ sky130_fd_sc_hd__edfxtp_1
Xnetwork.neuron_in139.counter\[3\]$_DFFE_PP_ clknet_leaf_159_clk_net
+ _02622_ _01365_ VSS VSS VDD VDD network.neuron_in139.counter\[3\]
+ sky130_fd_sc_hd__edfxtp_1
Xnetwork.neuron_in139.spike$_SDFFE_PP0P_ clknet_leaf_160_clk_net
+ _02021_ VSS VSS VDD VDD network.in_spk11_08 sky130_fd_sc_hd__dfxtp_1
Xnetwork.neuron_in140.counter\[0\]$_DFFE_PP_ clknet_leaf_155_clk_net
+ _02623_ _01364_ VSS VSS VDD VDD network.neuron_in140.counter\[0\]
+ sky130_fd_sc_hd__edfxtp_1
Xnetwork.neuron_in140.counter\[1\]$_DFFE_PP_ clknet_leaf_155_clk_net
+ _02624_ _01364_ VSS VSS VDD VDD network.neuron_in140.counter\[1\]
+ sky130_fd_sc_hd__edfxtp_1
Xnetwork.neuron_in140.counter\[2\]$_DFFE_PP_ clknet_leaf_155_clk_net
+ _02625_ _01364_ VSS VSS VDD VDD network.neuron_in140.counter\[2\]
+ sky130_fd_sc_hd__edfxtp_1
Xnetwork.neuron_in140.counter\[3\]$_DFFE_PP_ clknet_leaf_155_clk_net
+ _02626_ _01364_ VSS VSS VDD VDD network.neuron_in140.counter\[3\]
+ sky130_fd_sc_hd__edfxtp_1
Xnetwork.neuron_in140.spike$_SDFFE_PP0P_ clknet_leaf_155_clk_net
+ _02020_ VSS VSS VDD VDD network.in_spk12_08 sky130_fd_sc_hd__dfxtp_1
Xnetwork.neuron_in141.counter\[0\]$_DFFE_PP_ clknet_leaf_157_clk_net
+ _02627_ _01363_ VSS VSS VDD VDD network.neuron_in141.counter\[0\]
+ sky130_fd_sc_hd__edfxtp_1
Xnetwork.neuron_in141.counter\[1\]$_DFFE_PP_ clknet_leaf_157_clk_net
+ _02628_ _01363_ VSS VSS VDD VDD network.neuron_in141.counter\[1\]
+ sky130_fd_sc_hd__edfxtp_1
Xnetwork.neuron_in141.counter\[2\]$_DFFE_PP_ clknet_leaf_157_clk_net
+ _02629_ _01363_ VSS VSS VDD VDD network.neuron_in141.counter\[2\]
+ sky130_fd_sc_hd__edfxtp_1
Xnetwork.neuron_in141.counter\[3\]$_DFFE_PP_ clknet_leaf_157_clk_net
+ _02630_ _01363_ VSS VSS VDD VDD network.neuron_in141.counter\[3\]
+ sky130_fd_sc_hd__edfxtp_1
Xnetwork.neuron_in141.spike$_SDFFE_PP0P_ clknet_leaf_155_clk_net
+ _02019_ VSS VSS VDD VDD network.in_spk13_08 sky130_fd_sc_hd__dfxtp_1
Xnetwork.neuron_in142.counter\[0\]$_DFFE_PP_ clknet_leaf_158_clk_net
+ _02631_ _01362_ VSS VSS VDD VDD network.neuron_in142.counter\[0\]
+ sky130_fd_sc_hd__edfxtp_1
Xnetwork.neuron_in142.counter\[1\]$_DFFE_PP_ clknet_leaf_158_clk_net
+ _02632_ _01362_ VSS VSS VDD VDD network.neuron_in142.counter\[1\]
+ sky130_fd_sc_hd__edfxtp_1
Xnetwork.neuron_in142.counter\[2\]$_DFFE_PP_ clknet_leaf_158_clk_net
+ _02633_ _01362_ VSS VSS VDD VDD network.neuron_in142.counter\[2\]
+ sky130_fd_sc_hd__edfxtp_1
Xnetwork.neuron_in142.counter\[3\]$_DFFE_PP_ clknet_leaf_158_clk_net
+ _02634_ _01362_ VSS VSS VDD VDD network.neuron_in142.counter\[3\]
+ sky130_fd_sc_hd__edfxtp_1
Xnetwork.neuron_in142.spike$_SDFFE_PP0P_ clknet_leaf_160_clk_net
+ _02018_ VSS VSS VDD VDD network.in_spk14_08 sky130_fd_sc_hd__dfxtp_1
Xnetwork.neuron_in143.counter\[0\]$_DFFE_PP_ clknet_leaf_157_clk_net
+ _02635_ _01361_ VSS VSS VDD VDD network.neuron_in143.counter\[0\]
+ sky130_fd_sc_hd__edfxtp_1
Xnetwork.neuron_in143.counter\[1\]$_DFFE_PP_ clknet_leaf_157_clk_net
+ _02636_ _01361_ VSS VSS VDD VDD network.neuron_in143.counter\[1\]
+ sky130_fd_sc_hd__edfxtp_1
Xnetwork.neuron_in143.counter\[2\]$_DFFE_PP_ clknet_leaf_157_clk_net
+ _02637_ _01361_ VSS VSS VDD VDD network.neuron_in143.counter\[2\]
+ sky130_fd_sc_hd__edfxtp_1
Xnetwork.neuron_in143.counter\[3\]$_DFFE_PP_ clknet_leaf_157_clk_net
+ _02638_ _01361_ VSS VSS VDD VDD network.neuron_in143.counter\[3\]
+ sky130_fd_sc_hd__edfxtp_1
Xnetwork.neuron_in143.spike$_SDFFE_PP0P_ clknet_leaf_158_clk_net
+ _02017_ VSS VSS VDD VDD network.in_spk15_08 sky130_fd_sc_hd__dfxtp_1
Xnetwork.neuron_in144.counter\[0\]$_DFFE_PP_ clknet_leaf_149_clk_net
+ _02639_ _01360_ VSS VSS VDD VDD network.neuron_in144.counter\[0\]
+ sky130_fd_sc_hd__edfxtp_1
Xnetwork.neuron_in144.counter\[1\]$_DFFE_PP_ clknet_leaf_149_clk_net
+ _02640_ _01360_ VSS VSS VDD VDD network.neuron_in144.counter\[1\]
+ sky130_fd_sc_hd__edfxtp_1
Xnetwork.neuron_in144.counter\[2\]$_DFFE_PP_ clknet_leaf_149_clk_net
+ _02641_ _01360_ VSS VSS VDD VDD network.neuron_in144.counter\[2\]
+ sky130_fd_sc_hd__edfxtp_1
Xnetwork.neuron_in144.counter\[3\]$_DFFE_PP_ clknet_leaf_149_clk_net
+ _02642_ _01360_ VSS VSS VDD VDD network.neuron_in144.counter\[3\]
+ sky130_fd_sc_hd__edfxtp_1
Xnetwork.neuron_in144.spike$_SDFFE_PP0P_ clknet_leaf_149_clk_net
+ _02016_ VSS VSS VDD VDD network.in_spk00_09 sky130_fd_sc_hd__dfxtp_1
Xnetwork.neuron_in145.counter\[0\]$_DFFE_PP_ clknet_leaf_21_clk_net
+ _02643_ _01359_ VSS VSS VDD VDD network.neuron_in145.counter\[0\]
+ sky130_fd_sc_hd__edfxtp_1
Xnetwork.neuron_in145.counter\[1\]$_DFFE_PP_ clknet_leaf_21_clk_net
+ _02644_ _01359_ VSS VSS VDD VDD network.neuron_in145.counter\[1\]
+ sky130_fd_sc_hd__edfxtp_1
Xnetwork.neuron_in145.counter\[2\]$_DFFE_PP_ clknet_leaf_21_clk_net
+ _02645_ _01359_ VSS VSS VDD VDD network.neuron_in145.counter\[2\]
+ sky130_fd_sc_hd__edfxtp_1
Xnetwork.neuron_in145.counter\[3\]$_DFFE_PP_ clknet_leaf_21_clk_net
+ _02646_ _01359_ VSS VSS VDD VDD network.neuron_in145.counter\[3\]
+ sky130_fd_sc_hd__edfxtp_1
Xnetwork.neuron_in145.spike$_SDFFE_PP0P_ clknet_leaf_147_clk_net
+ _02015_ VSS VSS VDD VDD network.in_spk01_09 sky130_fd_sc_hd__dfxtp_1
Xnetwork.neuron_in146.counter\[0\]$_DFFE_PP_ clknet_leaf_22_clk_net
+ _02647_ _01358_ VSS VSS VDD VDD network.neuron_in146.counter\[0\]
+ sky130_fd_sc_hd__edfxtp_1
Xnetwork.neuron_in146.counter\[1\]$_DFFE_PP_ clknet_leaf_22_clk_net
+ _02648_ _01358_ VSS VSS VDD VDD network.neuron_in146.counter\[1\]
+ sky130_fd_sc_hd__edfxtp_1
Xnetwork.neuron_in146.counter\[2\]$_DFFE_PP_ clknet_leaf_146_clk_net
+ _02649_ _01358_ VSS VSS VDD VDD network.neuron_in146.counter\[2\]
+ sky130_fd_sc_hd__edfxtp_1
Xnetwork.neuron_in146.counter\[3\]$_DFFE_PP_ clknet_leaf_146_clk_net
+ _02650_ _01358_ VSS VSS VDD VDD network.neuron_in146.counter\[3\]
+ sky130_fd_sc_hd__edfxtp_1
Xnetwork.neuron_in146.spike$_SDFFE_PP0P_ clknet_leaf_147_clk_net
+ _02014_ VSS VSS VDD VDD network.in_spk02_09 sky130_fd_sc_hd__dfxtp_1
Xnetwork.neuron_in147.counter\[0\]$_DFFE_PP_ clknet_leaf_148_clk_net
+ _02651_ _01357_ VSS VSS VDD VDD network.neuron_in147.counter\[0\]
+ sky130_fd_sc_hd__edfxtp_1
Xnetwork.neuron_in147.counter\[1\]$_DFFE_PP_ clknet_leaf_148_clk_net
+ _02652_ _01357_ VSS VSS VDD VDD network.neuron_in147.counter\[1\]
+ sky130_fd_sc_hd__edfxtp_1
Xnetwork.neuron_in147.counter\[2\]$_DFFE_PP_ clknet_leaf_144_clk_net
+ _02653_ _01357_ VSS VSS VDD VDD network.neuron_in147.counter\[2\]
+ sky130_fd_sc_hd__edfxtp_1
Xnetwork.neuron_in147.counter\[3\]$_DFFE_PP_ clknet_leaf_144_clk_net
+ _02654_ _01357_ VSS VSS VDD VDD network.neuron_in147.counter\[3\]
+ sky130_fd_sc_hd__edfxtp_1
Xnetwork.neuron_in147.spike$_SDFFE_PP0P_ clknet_leaf_148_clk_net
+ _02013_ VSS VSS VDD VDD network.in_spk03_09 sky130_fd_sc_hd__dfxtp_1
Xnetwork.neuron_in148.counter\[0\]$_DFFE_PP_ clknet_leaf_18_clk_net
+ _02655_ _01356_ VSS VSS VDD VDD network.neuron_in148.counter\[0\]
+ sky130_fd_sc_hd__edfxtp_1
Xnetwork.neuron_in148.counter\[1\]$_DFFE_PP_ clknet_leaf_18_clk_net
+ _02656_ _01356_ VSS VSS VDD VDD network.neuron_in148.counter\[1\]
+ sky130_fd_sc_hd__edfxtp_1
Xnetwork.neuron_in148.counter\[2\]$_DFFE_PP_ clknet_leaf_21_clk_net
+ _02657_ _01356_ VSS VSS VDD VDD network.neuron_in148.counter\[2\]
+ sky130_fd_sc_hd__edfxtp_1
Xnetwork.neuron_in148.counter\[3\]$_DFFE_PP_ clknet_leaf_150_clk_net
+ _02658_ _01356_ VSS VSS VDD VDD network.neuron_in148.counter\[3\]
+ sky130_fd_sc_hd__edfxtp_1
Xnetwork.neuron_in148.spike$_SDFFE_PP0P_ clknet_leaf_147_clk_net
+ _02012_ VSS VSS VDD VDD network.in_spk04_09 sky130_fd_sc_hd__dfxtp_1
Xnetwork.neuron_in149.counter\[0\]$_DFFE_PP_ clknet_leaf_149_clk_net
+ _02659_ _01355_ VSS VSS VDD VDD network.neuron_in149.counter\[0\]
+ sky130_fd_sc_hd__edfxtp_1
Xnetwork.neuron_in149.counter\[1\]$_DFFE_PP_ clknet_leaf_149_clk_net
+ _02660_ _01355_ VSS VSS VDD VDD network.neuron_in149.counter\[1\]
+ sky130_fd_sc_hd__edfxtp_1
Xnetwork.neuron_in149.counter\[2\]$_DFFE_PP_ clknet_leaf_149_clk_net
+ _02661_ _01355_ VSS VSS VDD VDD network.neuron_in149.counter\[2\]
+ sky130_fd_sc_hd__edfxtp_1
Xnetwork.neuron_in149.counter\[3\]$_DFFE_PP_ clknet_leaf_149_clk_net
+ _02662_ _01355_ VSS VSS VDD VDD network.neuron_in149.counter\[3\]
+ sky130_fd_sc_hd__edfxtp_1
Xnetwork.neuron_in149.spike$_SDFFE_PP0P_ clknet_leaf_147_clk_net
+ _02011_ VSS VSS VDD VDD network.in_spk05_09 sky130_fd_sc_hd__dfxtp_1
Xnetwork.neuron_in150.counter\[0\]$_DFFE_PP_ clknet_leaf_145_clk_net
+ _02663_ _01354_ VSS VSS VDD VDD network.neuron_in150.counter\[0\]
+ sky130_fd_sc_hd__edfxtp_1
Xnetwork.neuron_in150.counter\[1\]$_DFFE_PP_ clknet_leaf_145_clk_net
+ _02664_ _01354_ VSS VSS VDD VDD network.neuron_in150.counter\[1\]
+ sky130_fd_sc_hd__edfxtp_1
Xnetwork.neuron_in150.counter\[2\]$_DFFE_PP_ clknet_leaf_145_clk_net
+ _02665_ _01354_ VSS VSS VDD VDD network.neuron_in150.counter\[2\]
+ sky130_fd_sc_hd__edfxtp_1
Xnetwork.neuron_in150.counter\[3\]$_DFFE_PP_ clknet_leaf_145_clk_net
+ _02666_ _01354_ VSS VSS VDD VDD network.neuron_in150.counter\[3\]
+ sky130_fd_sc_hd__edfxtp_1
Xnetwork.neuron_in150.spike$_SDFFE_PP0P_ clknet_leaf_147_clk_net
+ _02010_ VSS VSS VDD VDD network.in_spk06_09 sky130_fd_sc_hd__dfxtp_1
Xnetwork.neuron_in151.counter\[0\]$_DFFE_PP_ clknet_leaf_146_clk_net
+ _02667_ _01353_ VSS VSS VDD VDD network.neuron_in151.counter\[0\]
+ sky130_fd_sc_hd__edfxtp_1
Xnetwork.neuron_in151.counter\[1\]$_DFFE_PP_ clknet_leaf_146_clk_net
+ _02668_ _01353_ VSS VSS VDD VDD network.neuron_in151.counter\[1\]
+ sky130_fd_sc_hd__edfxtp_1
Xnetwork.neuron_in151.counter\[2\]$_DFFE_PP_ clknet_leaf_146_clk_net
+ _02669_ _01353_ VSS VSS VDD VDD network.neuron_in151.counter\[2\]
+ sky130_fd_sc_hd__edfxtp_1
Xnetwork.neuron_in151.counter\[3\]$_DFFE_PP_ clknet_leaf_146_clk_net
+ _02670_ _01353_ VSS VSS VDD VDD network.neuron_in151.counter\[3\]
+ sky130_fd_sc_hd__edfxtp_1
Xnetwork.neuron_in151.spike$_SDFFE_PP0P_ clknet_leaf_147_clk_net
+ _02009_ VSS VSS VDD VDD network.in_spk07_09 sky130_fd_sc_hd__dfxtp_1
Xnetwork.neuron_in152.counter\[0\]$_DFFE_PP_ clknet_leaf_17_clk_net
+ _02671_ _01352_ VSS VSS VDD VDD network.neuron_in152.counter\[0\]
+ sky130_fd_sc_hd__edfxtp_1
Xnetwork.neuron_in152.counter\[1\]$_DFFE_PP_ clknet_leaf_17_clk_net
+ _02672_ _01352_ VSS VSS VDD VDD network.neuron_in152.counter\[1\]
+ sky130_fd_sc_hd__edfxtp_1
Xnetwork.neuron_in152.counter\[2\]$_DFFE_PP_ clknet_leaf_150_clk_net
+ _02673_ _01352_ VSS VSS VDD VDD network.neuron_in152.counter\[2\]
+ sky130_fd_sc_hd__edfxtp_1
Xnetwork.neuron_in152.counter\[3\]$_DFFE_PP_ clknet_leaf_150_clk_net
+ _02674_ _01352_ VSS VSS VDD VDD network.neuron_in152.counter\[3\]
+ sky130_fd_sc_hd__edfxtp_1
Xnetwork.neuron_in152.spike$_SDFFE_PP0P_ clknet_leaf_149_clk_net
+ _02008_ VSS VSS VDD VDD network.in_spk08_09 sky130_fd_sc_hd__dfxtp_1
Xnetwork.neuron_in153.counter\[0\]$_DFFE_PP_ clknet_leaf_143_clk_net
+ _02675_ _01351_ VSS VSS VDD VDD network.neuron_in153.counter\[0\]
+ sky130_fd_sc_hd__edfxtp_1
Xnetwork.neuron_in153.counter\[1\]$_DFFE_PP_ clknet_leaf_143_clk_net
+ _02676_ _01351_ VSS VSS VDD VDD network.neuron_in153.counter\[1\]
+ sky130_fd_sc_hd__edfxtp_1
Xnetwork.neuron_in153.counter\[2\]$_DFFE_PP_ clknet_leaf_144_clk_net
+ _02677_ _01351_ VSS VSS VDD VDD network.neuron_in153.counter\[2\]
+ sky130_fd_sc_hd__edfxtp_1
Xnetwork.neuron_in153.counter\[3\]$_DFFE_PP_ clknet_leaf_144_clk_net
+ _02678_ _01351_ VSS VSS VDD VDD network.neuron_in153.counter\[3\]
+ sky130_fd_sc_hd__edfxtp_1
Xnetwork.neuron_in153.spike$_SDFFE_PP0P_ clknet_leaf_148_clk_net
+ _02007_ VSS VSS VDD VDD network.in_spk09_09 sky130_fd_sc_hd__dfxtp_1
Xnetwork.neuron_in154.counter\[0\]$_DFFE_PP_ clknet_leaf_147_clk_net
+ _02679_ _01350_ VSS VSS VDD VDD network.neuron_in154.counter\[0\]
+ sky130_fd_sc_hd__edfxtp_1
Xnetwork.neuron_in154.counter\[1\]$_DFFE_PP_ clknet_leaf_147_clk_net
+ _02680_ _01350_ VSS VSS VDD VDD network.neuron_in154.counter\[1\]
+ sky130_fd_sc_hd__edfxtp_1
Xnetwork.neuron_in154.counter\[2\]$_DFFE_PP_ clknet_leaf_21_clk_net
+ _02681_ _01350_ VSS VSS VDD VDD network.neuron_in154.counter\[2\]
+ sky130_fd_sc_hd__edfxtp_1
Xnetwork.neuron_in154.counter\[3\]$_DFFE_PP_ clknet_leaf_147_clk_net
+ _02682_ _01350_ VSS VSS VDD VDD network.neuron_in154.counter\[3\]
+ sky130_fd_sc_hd__edfxtp_1
Xnetwork.neuron_in154.spike$_SDFFE_PP0P_ clknet_leaf_149_clk_net
+ _02006_ VSS VSS VDD VDD network.in_spk10_09 sky130_fd_sc_hd__dfxtp_1
Xnetwork.neuron_in155.counter\[0\]$_DFFE_PP_ clknet_leaf_150_clk_net
+ _02683_ _01349_ VSS VSS VDD VDD network.neuron_in155.counter\[0\]
+ sky130_fd_sc_hd__edfxtp_1
Xnetwork.neuron_in155.counter\[1\]$_DFFE_PP_ clknet_leaf_150_clk_net
+ _02684_ _01349_ VSS VSS VDD VDD network.neuron_in155.counter\[1\]
+ sky130_fd_sc_hd__edfxtp_1
Xnetwork.neuron_in155.counter\[2\]$_DFFE_PP_ clknet_leaf_150_clk_net
+ _02685_ _01349_ VSS VSS VDD VDD network.neuron_in155.counter\[2\]
+ sky130_fd_sc_hd__edfxtp_1
Xnetwork.neuron_in155.counter\[3\]$_DFFE_PP_ clknet_leaf_150_clk_net
+ _02686_ _01349_ VSS VSS VDD VDD network.neuron_in155.counter\[3\]
+ sky130_fd_sc_hd__edfxtp_1
Xnetwork.neuron_in155.spike$_SDFFE_PP0P_ clknet_leaf_148_clk_net
+ _02005_ VSS VSS VDD VDD network.in_spk11_09 sky130_fd_sc_hd__dfxtp_1
Xnetwork.neuron_in156.counter\[0\]$_DFFE_PP_ clknet_leaf_137_clk_net
+ _02687_ _01348_ VSS VSS VDD VDD network.neuron_in156.counter\[0\]
+ sky130_fd_sc_hd__edfxtp_1
Xnetwork.neuron_in156.counter\[1\]$_DFFE_PP_ clknet_leaf_137_clk_net
+ _02688_ _01348_ VSS VSS VDD VDD network.neuron_in156.counter\[1\]
+ sky130_fd_sc_hd__edfxtp_1
Xnetwork.neuron_in156.counter\[2\]$_DFFE_PP_ clknet_leaf_137_clk_net
+ _02689_ _01348_ VSS VSS VDD VDD network.neuron_in156.counter\[2\]
+ sky130_fd_sc_hd__edfxtp_1
Xnetwork.neuron_in156.counter\[3\]$_DFFE_PP_ clknet_leaf_137_clk_net
+ _02690_ _01348_ VSS VSS VDD VDD network.neuron_in156.counter\[3\]
+ sky130_fd_sc_hd__edfxtp_1
Xnetwork.neuron_in156.spike$_SDFFE_PP0P_ clknet_leaf_148_clk_net
+ _02004_ VSS VSS VDD VDD network.in_spk12_09 sky130_fd_sc_hd__dfxtp_1
Xnetwork.neuron_in157.counter\[0\]$_DFFE_PP_ clknet_leaf_148_clk_net
+ _02691_ _01347_ VSS VSS VDD VDD network.neuron_in157.counter\[0\]
+ sky130_fd_sc_hd__edfxtp_1
Xnetwork.neuron_in157.counter\[1\]$_DFFE_PP_ clknet_leaf_153_clk_net
+ _02692_ _01347_ VSS VSS VDD VDD network.neuron_in157.counter\[1\]
+ sky130_fd_sc_hd__edfxtp_1
Xnetwork.neuron_in157.counter\[2\]$_DFFE_PP_ clknet_leaf_153_clk_net
+ _02693_ _01347_ VSS VSS VDD VDD network.neuron_in157.counter\[2\]
+ sky130_fd_sc_hd__edfxtp_1
Xnetwork.neuron_in157.counter\[3\]$_DFFE_PP_ clknet_leaf_153_clk_net
+ _02694_ _01347_ VSS VSS VDD VDD network.neuron_in157.counter\[3\]
+ sky130_fd_sc_hd__edfxtp_1
Xnetwork.neuron_in157.spike$_SDFFE_PP0P_ clknet_leaf_148_clk_net
+ _02003_ VSS VSS VDD VDD network.in_spk13_09 sky130_fd_sc_hd__dfxtp_1
Xnetwork.neuron_in158.counter\[0\]$_DFFE_PP_ clknet_leaf_153_clk_net
+ _02695_ _01346_ VSS VSS VDD VDD network.neuron_in158.counter\[0\]
+ sky130_fd_sc_hd__edfxtp_1
Xnetwork.neuron_in158.counter\[1\]$_DFFE_PP_ clknet_leaf_153_clk_net
+ _02696_ _01346_ VSS VSS VDD VDD network.neuron_in158.counter\[1\]
+ sky130_fd_sc_hd__edfxtp_1
Xnetwork.neuron_in158.counter\[2\]$_DFFE_PP_ clknet_leaf_153_clk_net
+ _02697_ _01346_ VSS VSS VDD VDD network.neuron_in158.counter\[2\]
+ sky130_fd_sc_hd__edfxtp_1
Xnetwork.neuron_in158.counter\[3\]$_DFFE_PP_ clknet_leaf_153_clk_net
+ _02698_ _01346_ VSS VSS VDD VDD network.neuron_in158.counter\[3\]
+ sky130_fd_sc_hd__edfxtp_1
Xnetwork.neuron_in158.spike$_SDFFE_PP0P_ clknet_leaf_148_clk_net
+ _02002_ VSS VSS VDD VDD network.in_spk14_09 sky130_fd_sc_hd__dfxtp_1
Xnetwork.neuron_in159.counter\[0\]$_DFFE_PP_ clknet_leaf_143_clk_net
+ _02699_ _01345_ VSS VSS VDD VDD network.neuron_in159.counter\[0\]
+ sky130_fd_sc_hd__edfxtp_1
Xnetwork.neuron_in159.counter\[1\]$_DFFE_PP_ clknet_leaf_143_clk_net
+ _02700_ _01345_ VSS VSS VDD VDD network.neuron_in159.counter\[1\]
+ sky130_fd_sc_hd__edfxtp_1
Xnetwork.neuron_in159.counter\[2\]$_DFFE_PP_ clknet_leaf_143_clk_net
+ _02701_ _01345_ VSS VSS VDD VDD network.neuron_in159.counter\[2\]
+ sky130_fd_sc_hd__edfxtp_1
Xnetwork.neuron_in159.counter\[3\]$_DFFE_PP_ clknet_leaf_143_clk_net
+ _02702_ _01345_ VSS VSS VDD VDD network.neuron_in159.counter\[3\]
+ sky130_fd_sc_hd__edfxtp_1
Xnetwork.neuron_in159.spike$_SDFFE_PP0P_ clknet_leaf_148_clk_net
+ _02001_ VSS VSS VDD VDD network.in_spk15_09 sky130_fd_sc_hd__dfxtp_1
Xnetwork.neuron_in160.counter\[0\]$_DFFE_PP_ clknet_leaf_136_clk_net
+ _02703_ _01344_ VSS VSS VDD VDD network.neuron_in160.counter\[0\]
+ sky130_fd_sc_hd__edfxtp_1
Xnetwork.neuron_in160.counter\[1\]$_DFFE_PP_ clknet_leaf_136_clk_net
+ _02704_ _01344_ VSS VSS VDD VDD network.neuron_in160.counter\[1\]
+ sky130_fd_sc_hd__edfxtp_1
Xnetwork.neuron_in160.counter\[2\]$_DFFE_PP_ clknet_leaf_137_clk_net
+ _02705_ _01344_ VSS VSS VDD VDD network.neuron_in160.counter\[2\]
+ sky130_fd_sc_hd__edfxtp_1
Xnetwork.neuron_in160.counter\[3\]$_DFFE_PP_ clknet_leaf_137_clk_net
+ _02706_ _01344_ VSS VSS VDD VDD network.neuron_in160.counter\[3\]
+ sky130_fd_sc_hd__edfxtp_1
Xnetwork.neuron_in160.spike$_SDFFE_PP0P_ clknet_leaf_135_clk_net
+ _02000_ VSS VSS VDD VDD network.in_spk00_10 sky130_fd_sc_hd__dfxtp_1
Xnetwork.neuron_in161.counter\[0\]$_DFFE_PP_ clknet_leaf_129_clk_net
+ _02707_ _01343_ VSS VSS VDD VDD network.neuron_in161.counter\[0\]
+ sky130_fd_sc_hd__edfxtp_1
Xnetwork.neuron_in161.counter\[1\]$_DFFE_PP_ clknet_leaf_129_clk_net
+ _02708_ _01343_ VSS VSS VDD VDD network.neuron_in161.counter\[1\]
+ sky130_fd_sc_hd__edfxtp_1
Xnetwork.neuron_in161.counter\[2\]$_DFFE_PP_ clknet_leaf_129_clk_net
+ _02709_ _01343_ VSS VSS VDD VDD network.neuron_in161.counter\[2\]
+ sky130_fd_sc_hd__edfxtp_1
Xnetwork.neuron_in161.counter\[3\]$_DFFE_PP_ clknet_leaf_129_clk_net
+ _02710_ _01343_ VSS VSS VDD VDD network.neuron_in161.counter\[3\]
+ sky130_fd_sc_hd__edfxtp_1
Xnetwork.neuron_in161.spike$_SDFFE_PP0P_ clknet_leaf_138_clk_net
+ _01999_ VSS VSS VDD VDD network.in_spk01_10 sky130_fd_sc_hd__dfxtp_1
Xnetwork.neuron_in162.counter\[0\]$_DFFE_PP_ clknet_leaf_132_clk_net
+ _02711_ _01342_ VSS VSS VDD VDD network.neuron_in162.counter\[0\]
+ sky130_fd_sc_hd__edfxtp_1
Xnetwork.neuron_in162.counter\[1\]$_DFFE_PP_ clknet_leaf_132_clk_net
+ _02712_ _01342_ VSS VSS VDD VDD network.neuron_in162.counter\[1\]
+ sky130_fd_sc_hd__edfxtp_1
Xnetwork.neuron_in162.counter\[2\]$_DFFE_PP_ clknet_leaf_132_clk_net
+ _02713_ _01342_ VSS VSS VDD VDD network.neuron_in162.counter\[2\]
+ sky130_fd_sc_hd__edfxtp_1
Xnetwork.neuron_in162.counter\[3\]$_DFFE_PP_ clknet_leaf_132_clk_net
+ _02714_ _01342_ VSS VSS VDD VDD network.neuron_in162.counter\[3\]
+ sky130_fd_sc_hd__edfxtp_1
Xnetwork.neuron_in162.spike$_SDFFE_PP0P_ clknet_leaf_135_clk_net
+ _01998_ VSS VSS VDD VDD network.in_spk02_10 sky130_fd_sc_hd__dfxtp_1
Xnetwork.neuron_in163.counter\[0\]$_DFFE_PP_ clknet_leaf_134_clk_net
+ _02715_ _01341_ VSS VSS VDD VDD network.neuron_in163.counter\[0\]
+ sky130_fd_sc_hd__edfxtp_1
Xnetwork.neuron_in163.counter\[1\]$_DFFE_PP_ clknet_leaf_134_clk_net
+ _02716_ _01341_ VSS VSS VDD VDD network.neuron_in163.counter\[1\]
+ sky130_fd_sc_hd__edfxtp_1
Xnetwork.neuron_in163.counter\[2\]$_DFFE_PP_ clknet_leaf_135_clk_net
+ _02717_ _01341_ VSS VSS VDD VDD network.neuron_in163.counter\[2\]
+ sky130_fd_sc_hd__edfxtp_1
Xnetwork.neuron_in163.counter\[3\]$_DFFE_PP_ clknet_leaf_135_clk_net
+ _02718_ _01341_ VSS VSS VDD VDD network.neuron_in163.counter\[3\]
+ sky130_fd_sc_hd__edfxtp_1
Xnetwork.neuron_in163.spike$_SDFFE_PP0P_ clknet_leaf_135_clk_net
+ _01997_ VSS VSS VDD VDD network.in_spk03_10 sky130_fd_sc_hd__dfxtp_1
Xnetwork.neuron_in164.counter\[0\]$_DFFE_PP_ clknet_leaf_131_clk_net
+ _02719_ _01340_ VSS VSS VDD VDD network.neuron_in164.counter\[0\]
+ sky130_fd_sc_hd__edfxtp_1
Xnetwork.neuron_in164.counter\[1\]$_DFFE_PP_ clknet_leaf_131_clk_net
+ _02720_ _01340_ VSS VSS VDD VDD network.neuron_in164.counter\[1\]
+ sky130_fd_sc_hd__edfxtp_1
Xnetwork.neuron_in164.counter\[2\]$_DFFE_PP_ clknet_leaf_131_clk_net
+ _02721_ _01340_ VSS VSS VDD VDD network.neuron_in164.counter\[2\]
+ sky130_fd_sc_hd__edfxtp_1
Xnetwork.neuron_in164.counter\[3\]$_DFFE_PP_ clknet_leaf_131_clk_net
+ _02722_ _01340_ VSS VSS VDD VDD network.neuron_in164.counter\[3\]
+ sky130_fd_sc_hd__edfxtp_1
Xnetwork.neuron_in164.spike$_SDFFE_PP0P_ clknet_leaf_132_clk_net
+ _01996_ VSS VSS VDD VDD network.in_spk04_10 sky130_fd_sc_hd__dfxtp_1
Xnetwork.neuron_in165.counter\[0\]$_DFFE_PP_ clknet_leaf_133_clk_net
+ _02723_ _01339_ VSS VSS VDD VDD network.neuron_in165.counter\[0\]
+ sky130_fd_sc_hd__edfxtp_1
Xnetwork.neuron_in165.counter\[1\]$_DFFE_PP_ clknet_leaf_132_clk_net
+ _02724_ _01339_ VSS VSS VDD VDD network.neuron_in165.counter\[1\]
+ sky130_fd_sc_hd__edfxtp_1
Xnetwork.neuron_in165.counter\[2\]$_DFFE_PP_ clknet_leaf_132_clk_net
+ _02725_ _01339_ VSS VSS VDD VDD network.neuron_in165.counter\[2\]
+ sky130_fd_sc_hd__edfxtp_1
Xnetwork.neuron_in165.counter\[3\]$_DFFE_PP_ clknet_leaf_132_clk_net
+ _02726_ _01339_ VSS VSS VDD VDD network.neuron_in165.counter\[3\]
+ sky130_fd_sc_hd__edfxtp_1
Xnetwork.neuron_in165.spike$_SDFFE_PP0P_ clknet_leaf_135_clk_net
+ _01995_ VSS VSS VDD VDD network.in_spk05_10 sky130_fd_sc_hd__dfxtp_1
Xnetwork.neuron_in166.counter\[0\]$_DFFE_PP_ clknet_leaf_133_clk_net
+ _02727_ _01338_ VSS VSS VDD VDD network.neuron_in166.counter\[0\]
+ sky130_fd_sc_hd__edfxtp_1
Xnetwork.neuron_in166.counter\[1\]$_DFFE_PP_ clknet_leaf_133_clk_net
+ _02728_ _01338_ VSS VSS VDD VDD network.neuron_in166.counter\[1\]
+ sky130_fd_sc_hd__edfxtp_1
Xnetwork.neuron_in166.counter\[2\]$_DFFE_PP_ clknet_leaf_132_clk_net
+ _02729_ _01338_ VSS VSS VDD VDD network.neuron_in166.counter\[2\]
+ sky130_fd_sc_hd__edfxtp_1
Xnetwork.neuron_in166.counter\[3\]$_DFFE_PP_ clknet_leaf_133_clk_net
+ _02730_ _01338_ VSS VSS VDD VDD network.neuron_in166.counter\[3\]
+ sky130_fd_sc_hd__edfxtp_1
Xnetwork.neuron_in166.spike$_SDFFE_PP0P_ clknet_leaf_135_clk_net
+ _01994_ VSS VSS VDD VDD network.in_spk06_10 sky130_fd_sc_hd__dfxtp_1
Xnetwork.neuron_in167.counter\[0\]$_DFFE_PP_ clknet_leaf_129_clk_net
+ _02731_ _01337_ VSS VSS VDD VDD network.neuron_in167.counter\[0\]
+ sky130_fd_sc_hd__edfxtp_1
Xnetwork.neuron_in167.counter\[1\]$_DFFE_PP_ clknet_leaf_130_clk_net
+ _02732_ _01337_ VSS VSS VDD VDD network.neuron_in167.counter\[1\]
+ sky130_fd_sc_hd__edfxtp_1
Xnetwork.neuron_in167.counter\[2\]$_DFFE_PP_ clknet_leaf_129_clk_net
+ _02733_ _01337_ VSS VSS VDD VDD network.neuron_in167.counter\[2\]
+ sky130_fd_sc_hd__edfxtp_1
Xnetwork.neuron_in167.counter\[3\]$_DFFE_PP_ clknet_leaf_132_clk_net
+ _02734_ _01337_ VSS VSS VDD VDD network.neuron_in167.counter\[3\]
+ sky130_fd_sc_hd__edfxtp_1
Xnetwork.neuron_in167.spike$_SDFFE_PP0P_ clknet_leaf_135_clk_net
+ _01993_ VSS VSS VDD VDD network.in_spk07_10 sky130_fd_sc_hd__dfxtp_1
Xnetwork.neuron_in168.counter\[0\]$_DFFE_PP_ clknet_leaf_154_clk_net
+ _02735_ _01336_ VSS VSS VDD VDD network.neuron_in168.counter\[0\]
+ sky130_fd_sc_hd__edfxtp_1
Xnetwork.neuron_in168.counter\[1\]$_DFFE_PP_ clknet_leaf_154_clk_net
+ _02736_ _01336_ VSS VSS VDD VDD network.neuron_in168.counter\[1\]
+ sky130_fd_sc_hd__edfxtp_1
Xnetwork.neuron_in168.counter\[2\]$_DFFE_PP_ clknet_leaf_154_clk_net
+ _02737_ _01336_ VSS VSS VDD VDD network.neuron_in168.counter\[2\]
+ sky130_fd_sc_hd__edfxtp_1
Xnetwork.neuron_in168.counter\[3\]$_DFFE_PP_ clknet_leaf_154_clk_net
+ _02738_ _01336_ VSS VSS VDD VDD network.neuron_in168.counter\[3\]
+ sky130_fd_sc_hd__edfxtp_1
Xnetwork.neuron_in168.spike$_SDFFE_PP0P_ clknet_leaf_136_clk_net
+ _01992_ VSS VSS VDD VDD network.in_spk08_10 sky130_fd_sc_hd__dfxtp_1
Xnetwork.neuron_in169.counter\[0\]$_DFFE_PP_ clknet_leaf_134_clk_net
+ _02739_ _01335_ VSS VSS VDD VDD network.neuron_in169.counter\[0\]
+ sky130_fd_sc_hd__edfxtp_1
Xnetwork.neuron_in169.counter\[1\]$_DFFE_PP_ clknet_leaf_134_clk_net
+ _02740_ _01335_ VSS VSS VDD VDD network.neuron_in169.counter\[1\]
+ sky130_fd_sc_hd__edfxtp_1
Xnetwork.neuron_in169.counter\[2\]$_DFFE_PP_ clknet_leaf_136_clk_net
+ _02741_ _01335_ VSS VSS VDD VDD network.neuron_in169.counter\[2\]
+ sky130_fd_sc_hd__edfxtp_1
Xnetwork.neuron_in169.counter\[3\]$_DFFE_PP_ clknet_leaf_136_clk_net
+ _02742_ _01335_ VSS VSS VDD VDD network.neuron_in169.counter\[3\]
+ sky130_fd_sc_hd__edfxtp_1
Xnetwork.neuron_in169.spike$_SDFFE_PP0P_ clknet_leaf_136_clk_net
+ _01991_ VSS VSS VDD VDD network.in_spk09_10 sky130_fd_sc_hd__dfxtp_1
Xnetwork.neuron_in170.counter\[0\]$_DFFE_PP_ clknet_leaf_153_clk_net
+ _02743_ _01334_ VSS VSS VDD VDD network.neuron_in170.counter\[0\]
+ sky130_fd_sc_hd__edfxtp_1
Xnetwork.neuron_in170.counter\[1\]$_DFFE_PP_ clknet_leaf_153_clk_net
+ _02744_ _01334_ VSS VSS VDD VDD network.neuron_in170.counter\[1\]
+ sky130_fd_sc_hd__edfxtp_1
Xnetwork.neuron_in170.counter\[2\]$_DFFE_PP_ clknet_leaf_154_clk_net
+ _02745_ _01334_ VSS VSS VDD VDD network.neuron_in170.counter\[2\]
+ sky130_fd_sc_hd__edfxtp_1
Xnetwork.neuron_in170.counter\[3\]$_DFFE_PP_ clknet_leaf_154_clk_net
+ _02746_ _01334_ VSS VSS VDD VDD network.neuron_in170.counter\[3\]
+ sky130_fd_sc_hd__edfxtp_1
Xnetwork.neuron_in170.spike$_SDFFE_PP0P_ clknet_leaf_136_clk_net
+ _01990_ VSS VSS VDD VDD network.in_spk10_10 sky130_fd_sc_hd__dfxtp_1
Xnetwork.neuron_in171.counter\[0\]$_DFFE_PP_ clknet_leaf_156_clk_net
+ _02747_ _01333_ VSS VSS VDD VDD network.neuron_in171.counter\[0\]
+ sky130_fd_sc_hd__edfxtp_1
Xnetwork.neuron_in171.counter\[1\]$_DFFE_PP_ clknet_leaf_156_clk_net
+ _02748_ _01333_ VSS VSS VDD VDD network.neuron_in171.counter\[1\]
+ sky130_fd_sc_hd__edfxtp_1
Xnetwork.neuron_in171.counter\[2\]$_DFFE_PP_ clknet_leaf_155_clk_net
+ _02749_ _01333_ VSS VSS VDD VDD network.neuron_in171.counter\[2\]
+ sky130_fd_sc_hd__edfxtp_1
Xnetwork.neuron_in171.counter\[3\]$_DFFE_PP_ clknet_leaf_155_clk_net
+ _02750_ _01333_ VSS VSS VDD VDD network.neuron_in171.counter\[3\]
+ sky130_fd_sc_hd__edfxtp_1
Xnetwork.neuron_in171.spike$_SDFFE_PP0P_ clknet_leaf_136_clk_net
+ _01989_ VSS VSS VDD VDD network.in_spk11_10 sky130_fd_sc_hd__dfxtp_1
Xnetwork.neuron_in172.counter\[0\]$_DFFE_PP_ clknet_leaf_156_clk_net
+ _02751_ _01332_ VSS VSS VDD VDD network.neuron_in172.counter\[0\]
+ sky130_fd_sc_hd__edfxtp_1
Xnetwork.neuron_in172.counter\[1\]$_DFFE_PP_ clknet_leaf_156_clk_net
+ _02752_ _01332_ VSS VSS VDD VDD network.neuron_in172.counter\[1\]
+ sky130_fd_sc_hd__edfxtp_1
Xnetwork.neuron_in172.counter\[2\]$_DFFE_PP_ clknet_leaf_156_clk_net
+ _02753_ _01332_ VSS VSS VDD VDD network.neuron_in172.counter\[2\]
+ sky130_fd_sc_hd__edfxtp_1
Xnetwork.neuron_in172.counter\[3\]$_DFFE_PP_ clknet_leaf_156_clk_net
+ _02754_ _01332_ VSS VSS VDD VDD network.neuron_in172.counter\[3\]
+ sky130_fd_sc_hd__edfxtp_1
Xnetwork.neuron_in172.spike$_SDFFE_PP0P_ clknet_leaf_136_clk_net
+ _01988_ VSS VSS VDD VDD network.in_spk12_10 sky130_fd_sc_hd__dfxtp_1
Xnetwork.neuron_in173.counter\[0\]$_DFFE_PP_ clknet_leaf_134_clk_net
+ _02755_ _01331_ VSS VSS VDD VDD network.neuron_in173.counter\[0\]
+ sky130_fd_sc_hd__edfxtp_1
Xnetwork.neuron_in173.counter\[1\]$_DFFE_PP_ clknet_leaf_134_clk_net
+ _02756_ _01331_ VSS VSS VDD VDD network.neuron_in173.counter\[1\]
+ sky130_fd_sc_hd__edfxtp_1
Xnetwork.neuron_in173.counter\[2\]$_DFFE_PP_ clknet_leaf_134_clk_net
+ _02757_ _01331_ VSS VSS VDD VDD network.neuron_in173.counter\[2\]
+ sky130_fd_sc_hd__edfxtp_1
Xnetwork.neuron_in173.counter\[3\]$_DFFE_PP_ clknet_leaf_134_clk_net
+ _02758_ _01331_ VSS VSS VDD VDD network.neuron_in173.counter\[3\]
+ sky130_fd_sc_hd__edfxtp_1
Xnetwork.neuron_in173.spike$_SDFFE_PP0P_ clknet_leaf_136_clk_net
+ _01987_ VSS VSS VDD VDD network.in_spk13_10 sky130_fd_sc_hd__dfxtp_1
Xnetwork.neuron_in174.counter\[0\]$_DFFE_PP_ clknet_leaf_133_clk_net
+ _02759_ _01330_ VSS VSS VDD VDD network.neuron_in174.counter\[0\]
+ sky130_fd_sc_hd__edfxtp_1
Xnetwork.neuron_in174.counter\[1\]$_DFFE_PP_ clknet_leaf_133_clk_net
+ _02760_ _01330_ VSS VSS VDD VDD network.neuron_in174.counter\[1\]
+ sky130_fd_sc_hd__edfxtp_1
Xnetwork.neuron_in174.counter\[2\]$_DFFE_PP_ clknet_leaf_133_clk_net
+ _02761_ _01330_ VSS VSS VDD VDD network.neuron_in174.counter\[2\]
+ sky130_fd_sc_hd__edfxtp_1
Xnetwork.neuron_in174.counter\[3\]$_DFFE_PP_ clknet_leaf_133_clk_net
+ _02762_ _01330_ VSS VSS VDD VDD network.neuron_in174.counter\[3\]
+ sky130_fd_sc_hd__edfxtp_1
Xnetwork.neuron_in174.spike$_SDFFE_PP0P_ clknet_leaf_135_clk_net
+ _01986_ VSS VSS VDD VDD network.in_spk14_10 sky130_fd_sc_hd__dfxtp_1
Xnetwork.neuron_in175.counter\[0\]$_DFFE_PP_ clknet_leaf_156_clk_net
+ _02763_ _01329_ VSS VSS VDD VDD network.neuron_in175.counter\[0\]
+ sky130_fd_sc_hd__edfxtp_1
Xnetwork.neuron_in175.counter\[1\]$_DFFE_PP_ clknet_leaf_156_clk_net
+ _02764_ _01329_ VSS VSS VDD VDD network.neuron_in175.counter\[1\]
+ sky130_fd_sc_hd__edfxtp_1
Xnetwork.neuron_in175.counter\[2\]$_DFFE_PP_ clknet_leaf_134_clk_net
+ _02765_ _01329_ VSS VSS VDD VDD network.neuron_in175.counter\[2\]
+ sky130_fd_sc_hd__edfxtp_1
Xnetwork.neuron_in175.counter\[3\]$_DFFE_PP_ clknet_leaf_156_clk_net
+ _02766_ _01329_ VSS VSS VDD VDD network.neuron_in175.counter\[3\]
+ sky130_fd_sc_hd__edfxtp_1
Xnetwork.neuron_in175.spike$_SDFFE_PP0P_ clknet_leaf_136_clk_net
+ _01985_ VSS VSS VDD VDD network.in_spk15_10 sky130_fd_sc_hd__dfxtp_1
Xnetwork.neuron_in176.counter\[0\]$_DFFE_PP_ clknet_leaf_119_clk_net
+ _02767_ _01328_ VSS VSS VDD VDD network.neuron_in176.counter\[0\]
+ sky130_fd_sc_hd__edfxtp_1
Xnetwork.neuron_in176.counter\[1\]$_DFFE_PP_ clknet_leaf_119_clk_net
+ _02768_ _01328_ VSS VSS VDD VDD network.neuron_in176.counter\[1\]
+ sky130_fd_sc_hd__edfxtp_1
Xnetwork.neuron_in176.counter\[2\]$_DFFE_PP_ clknet_leaf_119_clk_net
+ _02769_ _01328_ VSS VSS VDD VDD network.neuron_in176.counter\[2\]
+ sky130_fd_sc_hd__edfxtp_1
Xnetwork.neuron_in176.counter\[3\]$_DFFE_PP_ clknet_leaf_119_clk_net
+ _02770_ _01328_ VSS VSS VDD VDD network.neuron_in176.counter\[3\]
+ sky130_fd_sc_hd__edfxtp_1
Xnetwork.neuron_in176.spike$_SDFFE_PP0P_ clknet_leaf_127_clk_net
+ _01984_ VSS VSS VDD VDD network.in_spk00_11 sky130_fd_sc_hd__dfxtp_1
Xnetwork.neuron_in177.counter\[0\]$_DFFE_PP_ clknet_leaf_128_clk_net
+ _02771_ _01327_ VSS VSS VDD VDD network.neuron_in177.counter\[0\]
+ sky130_fd_sc_hd__edfxtp_1
Xnetwork.neuron_in177.counter\[1\]$_DFFE_PP_ clknet_leaf_128_clk_net
+ _02772_ _01327_ VSS VSS VDD VDD network.neuron_in177.counter\[1\]
+ sky130_fd_sc_hd__edfxtp_1
Xnetwork.neuron_in177.counter\[2\]$_DFFE_PP_ clknet_leaf_127_clk_net
+ _02773_ _01327_ VSS VSS VDD VDD network.neuron_in177.counter\[2\]
+ sky130_fd_sc_hd__edfxtp_1
Xnetwork.neuron_in177.counter\[3\]$_DFFE_PP_ clknet_leaf_128_clk_net
+ _02774_ _01327_ VSS VSS VDD VDD network.neuron_in177.counter\[3\]
+ sky130_fd_sc_hd__edfxtp_1
Xnetwork.neuron_in177.spike$_SDFFE_PP0P_ clknet_leaf_126_clk_net
+ _01983_ VSS VSS VDD VDD network.in_spk01_11 sky130_fd_sc_hd__dfxtp_1
Xnetwork.neuron_in178.counter\[0\]$_DFFE_PP_ clknet_leaf_121_clk_net
+ _02775_ _01326_ VSS VSS VDD VDD network.neuron_in178.counter\[0\]
+ sky130_fd_sc_hd__edfxtp_1
Xnetwork.neuron_in178.counter\[1\]$_DFFE_PP_ clknet_leaf_121_clk_net
+ _02776_ _01326_ VSS VSS VDD VDD network.neuron_in178.counter\[1\]
+ sky130_fd_sc_hd__edfxtp_1
Xnetwork.neuron_in178.counter\[2\]$_DFFE_PP_ clknet_leaf_120_clk_net
+ _02777_ _01326_ VSS VSS VDD VDD network.neuron_in178.counter\[2\]
+ sky130_fd_sc_hd__edfxtp_1
Xnetwork.neuron_in178.counter\[3\]$_DFFE_PP_ clknet_leaf_120_clk_net
+ _02778_ _01326_ VSS VSS VDD VDD network.neuron_in178.counter\[3\]
+ sky130_fd_sc_hd__edfxtp_1
Xnetwork.neuron_in178.spike$_SDFFE_PP0P_ clknet_leaf_127_clk_net
+ _01982_ VSS VSS VDD VDD network.in_spk02_11 sky130_fd_sc_hd__dfxtp_1
Xnetwork.neuron_in179.counter\[0\]$_DFFE_PP_ clknet_leaf_121_clk_net
+ _02779_ _01325_ VSS VSS VDD VDD network.neuron_in179.counter\[0\]
+ sky130_fd_sc_hd__edfxtp_1
Xnetwork.neuron_in179.counter\[1\]$_DFFE_PP_ clknet_leaf_121_clk_net
+ _02780_ _01325_ VSS VSS VDD VDD network.neuron_in179.counter\[1\]
+ sky130_fd_sc_hd__edfxtp_1
Xnetwork.neuron_in179.counter\[2\]$_DFFE_PP_ clknet_leaf_121_clk_net
+ _02781_ _01325_ VSS VSS VDD VDD network.neuron_in179.counter\[2\]
+ sky130_fd_sc_hd__edfxtp_1
Xnetwork.neuron_in179.counter\[3\]$_DFFE_PP_ clknet_leaf_121_clk_net
+ _02782_ _01325_ VSS VSS VDD VDD network.neuron_in179.counter\[3\]
+ sky130_fd_sc_hd__edfxtp_1
Xnetwork.neuron_in179.spike$_SDFFE_PP0P_ clknet_leaf_127_clk_net
+ _01981_ VSS VSS VDD VDD network.in_spk03_11 sky130_fd_sc_hd__dfxtp_1
Xnetwork.neuron_in180.counter\[0\]$_DFFE_PP_ clknet_leaf_122_clk_net
+ _02783_ _01324_ VSS VSS VDD VDD network.neuron_in180.counter\[0\]
+ sky130_fd_sc_hd__edfxtp_1
Xnetwork.neuron_in180.counter\[1\]$_DFFE_PP_ clknet_leaf_122_clk_net
+ _02784_ _01324_ VSS VSS VDD VDD network.neuron_in180.counter\[1\]
+ sky130_fd_sc_hd__edfxtp_1
Xnetwork.neuron_in180.counter\[2\]$_DFFE_PP_ clknet_leaf_122_clk_net
+ _02785_ _01324_ VSS VSS VDD VDD network.neuron_in180.counter\[2\]
+ sky130_fd_sc_hd__edfxtp_1
Xnetwork.neuron_in180.counter\[3\]$_DFFE_PP_ clknet_leaf_122_clk_net
+ _02786_ _01324_ VSS VSS VDD VDD network.neuron_in180.counter\[3\]
+ sky130_fd_sc_hd__edfxtp_1
Xnetwork.neuron_in180.spike$_SDFFE_PP0P_ clknet_leaf_127_clk_net
+ _01980_ VSS VSS VDD VDD network.in_spk04_11 sky130_fd_sc_hd__dfxtp_1
Xnetwork.neuron_in181.counter\[0\]$_DFFE_PP_ clknet_leaf_122_clk_net
+ _02787_ _01323_ VSS VSS VDD VDD network.neuron_in181.counter\[0\]
+ sky130_fd_sc_hd__edfxtp_1
Xnetwork.neuron_in181.counter\[1\]$_DFFE_PP_ clknet_leaf_122_clk_net
+ _02788_ _01323_ VSS VSS VDD VDD network.neuron_in181.counter\[1\]
+ sky130_fd_sc_hd__edfxtp_1
Xnetwork.neuron_in181.counter\[2\]$_DFFE_PP_ clknet_leaf_122_clk_net
+ _02789_ _01323_ VSS VSS VDD VDD network.neuron_in181.counter\[2\]
+ sky130_fd_sc_hd__edfxtp_1
Xnetwork.neuron_in181.counter\[3\]$_DFFE_PP_ clknet_leaf_122_clk_net
+ _02790_ _01323_ VSS VSS VDD VDD network.neuron_in181.counter\[3\]
+ sky130_fd_sc_hd__edfxtp_1
Xnetwork.neuron_in181.spike$_SDFFE_PP0P_ clknet_leaf_127_clk_net
+ _01979_ VSS VSS VDD VDD network.in_spk05_11 sky130_fd_sc_hd__dfxtp_1
Xnetwork.neuron_in182.counter\[0\]$_DFFE_PP_ clknet_leaf_124_clk_net
+ _02791_ _01322_ VSS VSS VDD VDD network.neuron_in182.counter\[0\]
+ sky130_fd_sc_hd__edfxtp_1
Xnetwork.neuron_in182.counter\[1\]$_DFFE_PP_ clknet_leaf_124_clk_net
+ _02792_ _01322_ VSS VSS VDD VDD network.neuron_in182.counter\[1\]
+ sky130_fd_sc_hd__edfxtp_1
Xnetwork.neuron_in182.counter\[2\]$_DFFE_PP_ clknet_leaf_119_clk_net
+ _02793_ _01322_ VSS VSS VDD VDD network.neuron_in182.counter\[2\]
+ sky130_fd_sc_hd__edfxtp_1
Xnetwork.neuron_in182.counter\[3\]$_DFFE_PP_ clknet_leaf_127_clk_net
+ _02794_ _01322_ VSS VSS VDD VDD network.neuron_in182.counter\[3\]
+ sky130_fd_sc_hd__edfxtp_1
Xnetwork.neuron_in182.spike$_SDFFE_PP0P_ clknet_leaf_127_clk_net
+ _01978_ VSS VSS VDD VDD network.in_spk06_11 sky130_fd_sc_hd__dfxtp_1
Xnetwork.neuron_in183.counter\[0\]$_DFFE_PP_ clknet_leaf_126_clk_net
+ _02795_ _01321_ VSS VSS VDD VDD network.neuron_in183.counter\[0\]
+ sky130_fd_sc_hd__edfxtp_1
Xnetwork.neuron_in183.counter\[1\]$_DFFE_PP_ clknet_leaf_126_clk_net
+ _02796_ _01321_ VSS VSS VDD VDD network.neuron_in183.counter\[1\]
+ sky130_fd_sc_hd__edfxtp_1
Xnetwork.neuron_in183.counter\[2\]$_DFFE_PP_ clknet_leaf_126_clk_net
+ _02797_ _01321_ VSS VSS VDD VDD network.neuron_in183.counter\[2\]
+ sky130_fd_sc_hd__edfxtp_1
Xnetwork.neuron_in183.counter\[3\]$_DFFE_PP_ clknet_leaf_126_clk_net
+ _02798_ _01321_ VSS VSS VDD VDD network.neuron_in183.counter\[3\]
+ sky130_fd_sc_hd__edfxtp_1
Xnetwork.neuron_in183.spike$_SDFFE_PP0P_ clknet_leaf_126_clk_net
+ _01977_ VSS VSS VDD VDD network.in_spk07_11 sky130_fd_sc_hd__dfxtp_1
Xnetwork.neuron_in184.counter\[0\]$_DFFE_PP_ clknet_leaf_131_clk_net
+ _02799_ _01320_ VSS VSS VDD VDD network.neuron_in184.counter\[0\]
+ sky130_fd_sc_hd__edfxtp_1
Xnetwork.neuron_in184.counter\[1\]$_DFFE_PP_ clknet_leaf_131_clk_net
+ _02800_ _01320_ VSS VSS VDD VDD network.neuron_in184.counter\[1\]
+ sky130_fd_sc_hd__edfxtp_1
Xnetwork.neuron_in184.counter\[2\]$_DFFE_PP_ clknet_leaf_131_clk_net
+ _02801_ _01320_ VSS VSS VDD VDD network.neuron_in184.counter\[2\]
+ sky130_fd_sc_hd__edfxtp_1
Xnetwork.neuron_in184.counter\[3\]$_DFFE_PP_ clknet_leaf_131_clk_net
+ _02802_ _01320_ VSS VSS VDD VDD network.neuron_in184.counter\[3\]
+ sky130_fd_sc_hd__edfxtp_1
Xnetwork.neuron_in184.spike$_SDFFE_PP0P_ clknet_leaf_130_clk_net
+ _01976_ VSS VSS VDD VDD network.in_spk08_11 sky130_fd_sc_hd__dfxtp_1
Xnetwork.neuron_in185.counter\[0\]$_DFFE_PP_ clknet_leaf_130_clk_net
+ _02803_ _01319_ VSS VSS VDD VDD network.neuron_in185.counter\[0\]
+ sky130_fd_sc_hd__edfxtp_1
Xnetwork.neuron_in185.counter\[1\]$_DFFE_PP_ clknet_leaf_130_clk_net
+ _02804_ _01319_ VSS VSS VDD VDD network.neuron_in185.counter\[1\]
+ sky130_fd_sc_hd__edfxtp_1
Xnetwork.neuron_in185.counter\[2\]$_DFFE_PP_ clknet_leaf_130_clk_net
+ _02805_ _01319_ VSS VSS VDD VDD network.neuron_in185.counter\[2\]
+ sky130_fd_sc_hd__edfxtp_1
Xnetwork.neuron_in185.counter\[3\]$_DFFE_PP_ clknet_leaf_130_clk_net
+ _02806_ _01319_ VSS VSS VDD VDD network.neuron_in185.counter\[3\]
+ sky130_fd_sc_hd__edfxtp_1
Xnetwork.neuron_in185.spike$_SDFFE_PP0P_ clknet_leaf_126_clk_net
+ _01975_ VSS VSS VDD VDD network.in_spk09_11 sky130_fd_sc_hd__dfxtp_1
Xnetwork.neuron_in186.counter\[0\]$_DFFE_PP_ clknet_leaf_130_clk_net
+ _02807_ _01318_ VSS VSS VDD VDD network.neuron_in186.counter\[0\]
+ sky130_fd_sc_hd__edfxtp_1
Xnetwork.neuron_in186.counter\[1\]$_DFFE_PP_ clknet_leaf_129_clk_net
+ _02808_ _01318_ VSS VSS VDD VDD network.neuron_in186.counter\[1\]
+ sky130_fd_sc_hd__edfxtp_1
Xnetwork.neuron_in186.counter\[2\]$_DFFE_PP_ clknet_leaf_130_clk_net
+ _02809_ _01318_ VSS VSS VDD VDD network.neuron_in186.counter\[2\]
+ sky130_fd_sc_hd__edfxtp_1
Xnetwork.neuron_in186.counter\[3\]$_DFFE_PP_ clknet_leaf_129_clk_net
+ _02810_ _01318_ VSS VSS VDD VDD network.neuron_in186.counter\[3\]
+ sky130_fd_sc_hd__edfxtp_1
Xnetwork.neuron_in186.spike$_SDFFE_PP0P_ clknet_leaf_130_clk_net
+ _01974_ VSS VSS VDD VDD network.in_spk10_11 sky130_fd_sc_hd__dfxtp_1
Xnetwork.neuron_in187.counter\[0\]$_DFFE_PP_ clknet_leaf_125_clk_net
+ _02811_ _01317_ VSS VSS VDD VDD network.neuron_in187.counter\[0\]
+ sky130_fd_sc_hd__edfxtp_1
Xnetwork.neuron_in187.counter\[1\]$_DFFE_PP_ clknet_leaf_125_clk_net
+ _02812_ _01317_ VSS VSS VDD VDD network.neuron_in187.counter\[1\]
+ sky130_fd_sc_hd__edfxtp_1
Xnetwork.neuron_in187.counter\[2\]$_DFFE_PP_ clknet_leaf_125_clk_net
+ _02813_ _01317_ VSS VSS VDD VDD network.neuron_in187.counter\[2\]
+ sky130_fd_sc_hd__edfxtp_1
Xnetwork.neuron_in187.counter\[3\]$_DFFE_PP_ clknet_leaf_125_clk_net
+ _02814_ _01317_ VSS VSS VDD VDD network.neuron_in187.counter\[3\]
+ sky130_fd_sc_hd__edfxtp_1
Xnetwork.neuron_in187.spike$_SDFFE_PP0P_ clknet_leaf_126_clk_net
+ _01973_ VSS VSS VDD VDD network.in_spk11_11 sky130_fd_sc_hd__dfxtp_1
Xnetwork.neuron_in188.counter\[0\]$_DFFE_PP_ clknet_leaf_123_clk_net
+ _02815_ _01316_ VSS VSS VDD VDD network.neuron_in188.counter\[0\]
+ sky130_fd_sc_hd__edfxtp_1
Xnetwork.neuron_in188.counter\[1\]$_DFFE_PP_ clknet_leaf_123_clk_net
+ _02816_ _01316_ VSS VSS VDD VDD network.neuron_in188.counter\[1\]
+ sky130_fd_sc_hd__edfxtp_1
Xnetwork.neuron_in188.counter\[2\]$_DFFE_PP_ clknet_leaf_122_clk_net
+ _02817_ _01316_ VSS VSS VDD VDD network.neuron_in188.counter\[2\]
+ sky130_fd_sc_hd__edfxtp_1
Xnetwork.neuron_in188.counter\[3\]$_DFFE_PP_ clknet_leaf_123_clk_net
+ _02818_ _01316_ VSS VSS VDD VDD network.neuron_in188.counter\[3\]
+ sky130_fd_sc_hd__edfxtp_1
Xnetwork.neuron_in188.spike$_SDFFE_PP0P_ clknet_leaf_126_clk_net
+ _01972_ VSS VSS VDD VDD network.in_spk12_11 sky130_fd_sc_hd__dfxtp_1
Xnetwork.neuron_in189.counter\[0\]$_DFFE_PP_ clknet_leaf_124_clk_net
+ _02819_ _01315_ VSS VSS VDD VDD network.neuron_in189.counter\[0\]
+ sky130_fd_sc_hd__edfxtp_1
Xnetwork.neuron_in189.counter\[1\]$_DFFE_PP_ clknet_leaf_124_clk_net
+ _02820_ _01315_ VSS VSS VDD VDD network.neuron_in189.counter\[1\]
+ sky130_fd_sc_hd__edfxtp_1
Xnetwork.neuron_in189.counter\[2\]$_DFFE_PP_ clknet_leaf_124_clk_net
+ _02821_ _01315_ VSS VSS VDD VDD network.neuron_in189.counter\[2\]
+ sky130_fd_sc_hd__edfxtp_1
Xnetwork.neuron_in189.counter\[3\]$_DFFE_PP_ clknet_leaf_123_clk_net
+ _02822_ _01315_ VSS VSS VDD VDD network.neuron_in189.counter\[3\]
+ sky130_fd_sc_hd__edfxtp_1
Xnetwork.neuron_in189.spike$_SDFFE_PP0P_ clknet_leaf_124_clk_net
+ _01971_ VSS VSS VDD VDD network.in_spk13_11 sky130_fd_sc_hd__dfxtp_1
Xnetwork.neuron_in190.counter\[0\]$_DFFE_PP_ clknet_leaf_125_clk_net
+ _02823_ _01314_ VSS VSS VDD VDD network.neuron_in190.counter\[0\]
+ sky130_fd_sc_hd__edfxtp_1
Xnetwork.neuron_in190.counter\[1\]$_DFFE_PP_ clknet_leaf_123_clk_net
+ _02824_ _01314_ VSS VSS VDD VDD network.neuron_in190.counter\[1\]
+ sky130_fd_sc_hd__edfxtp_1
Xnetwork.neuron_in190.counter\[2\]$_DFFE_PP_ clknet_leaf_123_clk_net
+ _02825_ _01314_ VSS VSS VDD VDD network.neuron_in190.counter\[2\]
+ sky130_fd_sc_hd__edfxtp_1
Xnetwork.neuron_in190.counter\[3\]$_DFFE_PP_ clknet_leaf_124_clk_net
+ _02826_ _01314_ VSS VSS VDD VDD network.neuron_in190.counter\[3\]
+ sky130_fd_sc_hd__edfxtp_1
Xnetwork.neuron_in190.spike$_SDFFE_PP0P_ clknet_leaf_124_clk_net
+ _01970_ VSS VSS VDD VDD network.in_spk14_11 sky130_fd_sc_hd__dfxtp_1
Xnetwork.neuron_in191.counter\[0\]$_DFFE_PP_ clknet_leaf_125_clk_net
+ _02827_ _01313_ VSS VSS VDD VDD network.neuron_in191.counter\[0\]
+ sky130_fd_sc_hd__edfxtp_1
Xnetwork.neuron_in191.counter\[1\]$_DFFE_PP_ clknet_leaf_125_clk_net
+ _02828_ _01313_ VSS VSS VDD VDD network.neuron_in191.counter\[1\]
+ sky130_fd_sc_hd__edfxtp_1
Xnetwork.neuron_in191.counter\[2\]$_DFFE_PP_ clknet_leaf_125_clk_net
+ _02829_ _01313_ VSS VSS VDD VDD network.neuron_in191.counter\[2\]
+ sky130_fd_sc_hd__edfxtp_1
Xnetwork.neuron_in191.counter\[3\]$_DFFE_PP_ clknet_leaf_125_clk_net
+ _02830_ _01313_ VSS VSS VDD VDD network.neuron_in191.counter\[3\]
+ sky130_fd_sc_hd__edfxtp_1
Xnetwork.neuron_in191.spike$_SDFFE_PP0P_ clknet_leaf_124_clk_net
+ _01969_ VSS VSS VDD VDD network.in_spk15_11 sky130_fd_sc_hd__dfxtp_1
Xnetwork.neuron_in192.counter\[0\]$_DFFE_PP_ clknet_leaf_102_clk_net
+ _02831_ _01312_ VSS VSS VDD VDD network.neuron_in192.counter\[0\]
+ sky130_fd_sc_hd__edfxtp_1
Xnetwork.neuron_in192.counter\[1\]$_DFFE_PP_ clknet_leaf_102_clk_net
+ _02832_ _01312_ VSS VSS VDD VDD network.neuron_in192.counter\[1\]
+ sky130_fd_sc_hd__edfxtp_1
Xnetwork.neuron_in192.counter\[2\]$_DFFE_PP_ clknet_leaf_101_clk_net
+ _02833_ _01312_ VSS VSS VDD VDD network.neuron_in192.counter\[2\]
+ sky130_fd_sc_hd__edfxtp_1
Xnetwork.neuron_in192.counter\[3\]$_DFFE_PP_ clknet_leaf_101_clk_net
+ _02834_ _01312_ VSS VSS VDD VDD network.neuron_in192.counter\[3\]
+ sky130_fd_sc_hd__edfxtp_1
Xnetwork.neuron_in192.spike$_SDFFE_PP0P_ clknet_leaf_100_clk_net
+ _01968_ VSS VSS VDD VDD network.in_spk00_12 sky130_fd_sc_hd__dfxtp_1
Xnetwork.neuron_in193.counter\[0\]$_DFFE_PP_ clknet_leaf_66_clk_net
+ _02835_ _01311_ VSS VSS VDD VDD network.neuron_in193.counter\[0\]
+ sky130_fd_sc_hd__edfxtp_1
Xnetwork.neuron_in193.counter\[1\]$_DFFE_PP_ clknet_leaf_66_clk_net
+ _02836_ _01311_ VSS VSS VDD VDD network.neuron_in193.counter\[1\]
+ sky130_fd_sc_hd__edfxtp_1
Xnetwork.neuron_in193.counter\[2\]$_DFFE_PP_ clknet_leaf_66_clk_net
+ _02837_ _01311_ VSS VSS VDD VDD network.neuron_in193.counter\[2\]
+ sky130_fd_sc_hd__edfxtp_1
Xnetwork.neuron_in193.counter\[3\]$_DFFE_PP_ clknet_leaf_66_clk_net
+ _02838_ _01311_ VSS VSS VDD VDD network.neuron_in193.counter\[3\]
+ sky130_fd_sc_hd__edfxtp_1
Xnetwork.neuron_in193.spike$_SDFFE_PP0P_ clknet_leaf_100_clk_net
+ _01967_ VSS VSS VDD VDD network.in_spk01_12 sky130_fd_sc_hd__dfxtp_1
Xnetwork.neuron_in194.counter\[0\]$_DFFE_PP_ clknet_leaf_67_clk_net
+ _02839_ _01310_ VSS VSS VDD VDD network.neuron_in194.counter\[0\]
+ sky130_fd_sc_hd__edfxtp_1
Xnetwork.neuron_in194.counter\[1\]$_DFFE_PP_ clknet_leaf_67_clk_net
+ _02840_ _01310_ VSS VSS VDD VDD network.neuron_in194.counter\[1\]
+ sky130_fd_sc_hd__edfxtp_1
Xnetwork.neuron_in194.counter\[2\]$_DFFE_PP_ clknet_leaf_101_clk_net
+ _02841_ _01310_ VSS VSS VDD VDD network.neuron_in194.counter\[2\]
+ sky130_fd_sc_hd__edfxtp_1
Xnetwork.neuron_in194.counter\[3\]$_DFFE_PP_ clknet_leaf_101_clk_net
+ _02842_ _01310_ VSS VSS VDD VDD network.neuron_in194.counter\[3\]
+ sky130_fd_sc_hd__edfxtp_1
Xnetwork.neuron_in194.spike$_SDFFE_PP0P_ clknet_leaf_100_clk_net
+ _01966_ VSS VSS VDD VDD network.in_spk02_12 sky130_fd_sc_hd__dfxtp_1
Xnetwork.neuron_in195.counter\[0\]$_DFFE_PP_ clknet_leaf_101_clk_net
+ _02843_ _01309_ VSS VSS VDD VDD network.neuron_in195.counter\[0\]
+ sky130_fd_sc_hd__edfxtp_1
Xnetwork.neuron_in195.counter\[1\]$_DFFE_PP_ clknet_leaf_101_clk_net
+ _02844_ _01309_ VSS VSS VDD VDD network.neuron_in195.counter\[1\]
+ sky130_fd_sc_hd__edfxtp_1
Xnetwork.neuron_in195.counter\[2\]$_DFFE_PP_ clknet_leaf_101_clk_net
+ _02845_ _01309_ VSS VSS VDD VDD network.neuron_in195.counter\[2\]
+ sky130_fd_sc_hd__edfxtp_1
Xnetwork.neuron_in195.counter\[3\]$_DFFE_PP_ clknet_leaf_101_clk_net
+ _02846_ _01309_ VSS VSS VDD VDD network.neuron_in195.counter\[3\]
+ sky130_fd_sc_hd__edfxtp_1
Xnetwork.neuron_in195.spike$_SDFFE_PP0P_ clknet_leaf_100_clk_net
+ _01965_ VSS VSS VDD VDD network.in_spk03_12 sky130_fd_sc_hd__dfxtp_1
Xnetwork.neuron_in196.counter\[0\]$_DFFE_PP_ clknet_leaf_98_clk_net
+ _02847_ _01308_ VSS VSS VDD VDD network.neuron_in196.counter\[0\]
+ sky130_fd_sc_hd__edfxtp_1
Xnetwork.neuron_in196.counter\[1\]$_DFFE_PP_ clknet_leaf_97_clk_net
+ _02848_ _01308_ VSS VSS VDD VDD network.neuron_in196.counter\[1\]
+ sky130_fd_sc_hd__edfxtp_1
Xnetwork.neuron_in196.counter\[2\]$_DFFE_PP_ clknet_leaf_98_clk_net
+ _02849_ _01308_ VSS VSS VDD VDD network.neuron_in196.counter\[2\]
+ sky130_fd_sc_hd__edfxtp_1
Xnetwork.neuron_in196.counter\[3\]$_DFFE_PP_ clknet_leaf_98_clk_net
+ _02850_ _01308_ VSS VSS VDD VDD network.neuron_in196.counter\[3\]
+ sky130_fd_sc_hd__edfxtp_1
Xnetwork.neuron_in196.spike$_SDFFE_PP0P_ clknet_leaf_98_clk_net
+ _01964_ VSS VSS VDD VDD network.in_spk04_12 sky130_fd_sc_hd__dfxtp_1
Xnetwork.neuron_in197.counter\[0\]$_DFFE_PP_ clknet_leaf_92_clk_net
+ _02851_ _01307_ VSS VSS VDD VDD network.neuron_in197.counter\[0\]
+ sky130_fd_sc_hd__edfxtp_1
Xnetwork.neuron_in197.counter\[1\]$_DFFE_PP_ clknet_leaf_92_clk_net
+ _02852_ _01307_ VSS VSS VDD VDD network.neuron_in197.counter\[1\]
+ sky130_fd_sc_hd__edfxtp_1
Xnetwork.neuron_in197.counter\[2\]$_DFFE_PP_ clknet_leaf_92_clk_net
+ _02853_ _01307_ VSS VSS VDD VDD network.neuron_in197.counter\[2\]
+ sky130_fd_sc_hd__edfxtp_1
Xnetwork.neuron_in197.counter\[3\]$_DFFE_PP_ clknet_leaf_92_clk_net
+ _02854_ _01307_ VSS VSS VDD VDD network.neuron_in197.counter\[3\]
+ sky130_fd_sc_hd__edfxtp_1
Xnetwork.neuron_in197.spike$_SDFFE_PP0P_ clknet_leaf_98_clk_net
+ _01963_ VSS VSS VDD VDD network.in_spk05_12 sky130_fd_sc_hd__dfxtp_1
Xnetwork.neuron_in198.counter\[0\]$_DFFE_PP_ clknet_leaf_91_clk_net
+ _02855_ _01306_ VSS VSS VDD VDD network.neuron_in198.counter\[0\]
+ sky130_fd_sc_hd__edfxtp_1
Xnetwork.neuron_in198.counter\[1\]$_DFFE_PP_ clknet_leaf_91_clk_net
+ _02856_ _01306_ VSS VSS VDD VDD network.neuron_in198.counter\[1\]
+ sky130_fd_sc_hd__edfxtp_1
Xnetwork.neuron_in198.counter\[2\]$_DFFE_PP_ clknet_leaf_93_clk_net
+ _02857_ _01306_ VSS VSS VDD VDD network.neuron_in198.counter\[2\]
+ sky130_fd_sc_hd__edfxtp_1
Xnetwork.neuron_in198.counter\[3\]$_DFFE_PP_ clknet_leaf_93_clk_net
+ _02858_ _01306_ VSS VSS VDD VDD network.neuron_in198.counter\[3\]
+ sky130_fd_sc_hd__edfxtp_1
Xnetwork.neuron_in198.spike$_SDFFE_PP0P_ clknet_leaf_98_clk_net
+ _01962_ VSS VSS VDD VDD network.in_spk06_12 sky130_fd_sc_hd__dfxtp_1
Xnetwork.neuron_in199.counter\[0\]$_DFFE_PP_ clknet_leaf_97_clk_net
+ _02859_ _01305_ VSS VSS VDD VDD network.neuron_in199.counter\[0\]
+ sky130_fd_sc_hd__edfxtp_1
Xnetwork.neuron_in199.counter\[1\]$_DFFE_PP_ clknet_leaf_97_clk_net
+ _02860_ _01305_ VSS VSS VDD VDD network.neuron_in199.counter\[1\]
+ sky130_fd_sc_hd__edfxtp_1
Xnetwork.neuron_in199.counter\[2\]$_DFFE_PP_ clknet_leaf_98_clk_net
+ _02861_ _01305_ VSS VSS VDD VDD network.neuron_in199.counter\[2\]
+ sky130_fd_sc_hd__edfxtp_1
Xnetwork.neuron_in199.counter\[3\]$_DFFE_PP_ clknet_leaf_97_clk_net
+ _02862_ _01305_ VSS VSS VDD VDD network.neuron_in199.counter\[3\]
+ sky130_fd_sc_hd__edfxtp_1
Xnetwork.neuron_in199.spike$_SDFFE_PP0P_ clknet_leaf_98_clk_net
+ _01961_ VSS VSS VDD VDD network.in_spk07_12 sky130_fd_sc_hd__dfxtp_1
Xnetwork.neuron_in200.counter\[0\]$_DFFE_PP_ clknet_leaf_65_clk_net
+ _02863_ _01304_ VSS VSS VDD VDD network.neuron_in200.counter\[0\]
+ sky130_fd_sc_hd__edfxtp_1
Xnetwork.neuron_in200.counter\[1\]$_DFFE_PP_ clknet_leaf_65_clk_net
+ _02864_ _01304_ VSS VSS VDD VDD network.neuron_in200.counter\[1\]
+ sky130_fd_sc_hd__edfxtp_1
Xnetwork.neuron_in200.counter\[2\]$_DFFE_PP_ clknet_leaf_65_clk_net
+ _02865_ _01304_ VSS VSS VDD VDD network.neuron_in200.counter\[2\]
+ sky130_fd_sc_hd__edfxtp_1
Xnetwork.neuron_in200.counter\[3\]$_DFFE_PP_ clknet_leaf_65_clk_net
+ _02866_ _01304_ VSS VSS VDD VDD network.neuron_in200.counter\[3\]
+ sky130_fd_sc_hd__edfxtp_1
Xnetwork.neuron_in200.spike$_SDFFE_PP0P_ clknet_leaf_102_clk_net
+ _01960_ VSS VSS VDD VDD network.in_spk08_12 sky130_fd_sc_hd__dfxtp_1
Xnetwork.neuron_in201.counter\[0\]$_DFFE_PP_ clknet_leaf_100_clk_net
+ _02867_ _01303_ VSS VSS VDD VDD network.neuron_in201.counter\[0\]
+ sky130_fd_sc_hd__edfxtp_1
Xnetwork.neuron_in201.counter\[1\]$_DFFE_PP_ clknet_leaf_100_clk_net
+ _02868_ _01303_ VSS VSS VDD VDD network.neuron_in201.counter\[1\]
+ sky130_fd_sc_hd__edfxtp_1
Xnetwork.neuron_in201.counter\[2\]$_DFFE_PP_ clknet_leaf_98_clk_net
+ _02869_ _01303_ VSS VSS VDD VDD network.neuron_in201.counter\[2\]
+ sky130_fd_sc_hd__edfxtp_1
Xnetwork.neuron_in201.counter\[3\]$_DFFE_PP_ clknet_leaf_98_clk_net
+ _02870_ _01303_ VSS VSS VDD VDD network.neuron_in201.counter\[3\]
+ sky130_fd_sc_hd__edfxtp_1
Xnetwork.neuron_in201.spike$_SDFFE_PP0P_ clknet_leaf_99_clk_net
+ _01959_ VSS VSS VDD VDD network.in_spk09_12 sky130_fd_sc_hd__dfxtp_1
Xnetwork.neuron_in202.counter\[0\]$_DFFE_PP_ clknet_leaf_91_clk_net
+ _02871_ _01302_ VSS VSS VDD VDD network.neuron_in202.counter\[0\]
+ sky130_fd_sc_hd__edfxtp_1
Xnetwork.neuron_in202.counter\[1\]$_DFFE_PP_ clknet_leaf_91_clk_net
+ _02872_ _01302_ VSS VSS VDD VDD network.neuron_in202.counter\[1\]
+ sky130_fd_sc_hd__edfxtp_1
Xnetwork.neuron_in202.counter\[2\]$_DFFE_PP_ clknet_leaf_91_clk_net
+ _02873_ _01302_ VSS VSS VDD VDD network.neuron_in202.counter\[2\]
+ sky130_fd_sc_hd__edfxtp_1
Xnetwork.neuron_in202.counter\[3\]$_DFFE_PP_ clknet_leaf_91_clk_net
+ _02874_ _01302_ VSS VSS VDD VDD network.neuron_in202.counter\[3\]
+ sky130_fd_sc_hd__edfxtp_1
Xnetwork.neuron_in202.spike$_SDFFE_PP0P_ clknet_leaf_99_clk_net
+ _01957_ VSS VSS VDD VDD network.in_spk10_12 sky130_fd_sc_hd__dfxtp_1
Xnetwork.neuron_in203.counter\[0\]$_DFFE_PP_ clknet_leaf_110_clk_net
+ _02875_ _01301_ VSS VSS VDD VDD network.neuron_in203.counter\[0\]
+ sky130_fd_sc_hd__edfxtp_1
Xnetwork.neuron_in203.counter\[1\]$_DFFE_PP_ clknet_leaf_110_clk_net
+ _02876_ _01301_ VSS VSS VDD VDD network.neuron_in203.counter\[1\]
+ sky130_fd_sc_hd__edfxtp_1
Xnetwork.neuron_in203.counter\[2\]$_DFFE_PP_ clknet_leaf_91_clk_net
+ _02877_ _01301_ VSS VSS VDD VDD network.neuron_in203.counter\[2\]
+ sky130_fd_sc_hd__edfxtp_1
Xnetwork.neuron_in203.counter\[3\]$_DFFE_PP_ clknet_leaf_91_clk_net
+ _02878_ _01301_ VSS VSS VDD VDD network.neuron_in203.counter\[3\]
+ sky130_fd_sc_hd__edfxtp_1
Xnetwork.neuron_in203.spike$_SDFFE_PP0P_ clknet_leaf_110_clk_net
+ _01953_ VSS VSS VDD VDD network.in_spk11_12 sky130_fd_sc_hd__dfxtp_1
Xnetwork.neuron_in204.counter\[0\]$_DFFE_PP_ clknet_leaf_92_clk_net
+ _02879_ _01300_ VSS VSS VDD VDD network.neuron_in204.counter\[0\]
+ sky130_fd_sc_hd__edfxtp_1
Xnetwork.neuron_in204.counter\[1\]$_DFFE_PP_ clknet_leaf_92_clk_net
+ _02880_ _01300_ VSS VSS VDD VDD network.neuron_in204.counter\[1\]
+ sky130_fd_sc_hd__edfxtp_1
Xnetwork.neuron_in204.counter\[2\]$_DFFE_PP_ clknet_leaf_92_clk_net
+ _02881_ _01300_ VSS VSS VDD VDD network.neuron_in204.counter\[2\]
+ sky130_fd_sc_hd__edfxtp_1
Xnetwork.neuron_in204.counter\[3\]$_DFFE_PP_ clknet_leaf_92_clk_net
+ _02882_ _01300_ VSS VSS VDD VDD network.neuron_in204.counter\[3\]
+ sky130_fd_sc_hd__edfxtp_1
Xnetwork.neuron_in204.spike$_SDFFE_PP0P_ clknet_leaf_99_clk_net
+ _01949_ VSS VSS VDD VDD network.in_spk12_12 sky130_fd_sc_hd__dfxtp_1
Xnetwork.neuron_in205.counter\[0\]$_DFFE_PP_ clknet_leaf_90_clk_net
+ _02883_ _01299_ VSS VSS VDD VDD network.neuron_in205.counter\[0\]
+ sky130_fd_sc_hd__edfxtp_1
Xnetwork.neuron_in205.counter\[1\]$_DFFE_PP_ clknet_leaf_90_clk_net
+ _02884_ _01299_ VSS VSS VDD VDD network.neuron_in205.counter\[1\]
+ sky130_fd_sc_hd__edfxtp_1
Xnetwork.neuron_in205.counter\[2\]$_DFFE_PP_ clknet_leaf_90_clk_net
+ _02885_ _01299_ VSS VSS VDD VDD network.neuron_in205.counter\[2\]
+ sky130_fd_sc_hd__edfxtp_1
Xnetwork.neuron_in205.counter\[3\]$_DFFE_PP_ clknet_leaf_90_clk_net
+ _02886_ _01299_ VSS VSS VDD VDD network.neuron_in205.counter\[3\]
+ sky130_fd_sc_hd__edfxtp_1
Xnetwork.neuron_in205.spike$_SDFFE_PP0P_ clknet_leaf_99_clk_net
+ _01946_ VSS VSS VDD VDD network.in_spk13_12 sky130_fd_sc_hd__dfxtp_1
Xnetwork.neuron_in206.counter\[0\]$_DFFE_PP_ clknet_leaf_112_clk_net
+ _02887_ _01298_ VSS VSS VDD VDD network.neuron_in206.counter\[0\]
+ sky130_fd_sc_hd__edfxtp_1
Xnetwork.neuron_in206.counter\[1\]$_DFFE_PP_ clknet_leaf_112_clk_net
+ _02888_ _01298_ VSS VSS VDD VDD network.neuron_in206.counter\[1\]
+ sky130_fd_sc_hd__edfxtp_1
Xnetwork.neuron_in206.counter\[2\]$_DFFE_PP_ clknet_leaf_112_clk_net
+ _02889_ _01298_ VSS VSS VDD VDD network.neuron_in206.counter\[2\]
+ sky130_fd_sc_hd__edfxtp_1
Xnetwork.neuron_in206.counter\[3\]$_DFFE_PP_ clknet_leaf_112_clk_net
+ _02890_ _01298_ VSS VSS VDD VDD network.neuron_in206.counter\[3\]
+ sky130_fd_sc_hd__edfxtp_1
Xnetwork.neuron_in206.spike$_SDFFE_PP0P_ clknet_leaf_99_clk_net
+ _01944_ VSS VSS VDD VDD network.in_spk14_12 sky130_fd_sc_hd__dfxtp_1
Xnetwork.neuron_in207.counter\[0\]$_DFFE_PP_ clknet_leaf_111_clk_net
+ _02891_ _01297_ VSS VSS VDD VDD network.neuron_in207.counter\[0\]
+ sky130_fd_sc_hd__edfxtp_1
Xnetwork.neuron_in207.counter\[1\]$_DFFE_PP_ clknet_leaf_111_clk_net
+ _02892_ _01297_ VSS VSS VDD VDD network.neuron_in207.counter\[1\]
+ sky130_fd_sc_hd__edfxtp_1
Xnetwork.neuron_in207.counter\[2\]$_DFFE_PP_ clknet_leaf_111_clk_net
+ _02893_ _01297_ VSS VSS VDD VDD network.neuron_in207.counter\[2\]
+ sky130_fd_sc_hd__edfxtp_1
Xnetwork.neuron_in207.counter\[3\]$_DFFE_PP_ clknet_leaf_111_clk_net
+ _02894_ _01297_ VSS VSS VDD VDD network.neuron_in207.counter\[3\]
+ sky130_fd_sc_hd__edfxtp_1
Xnetwork.neuron_in207.spike$_SDFFE_PP0P_ clknet_leaf_105_clk_net
+ _01942_ VSS VSS VDD VDD network.in_spk15_12 sky130_fd_sc_hd__dfxtp_1
Xnetwork.neuron_in208.counter\[0\]$_DFFE_PP_ clknet_leaf_113_clk_net
+ _02895_ _01296_ VSS VSS VDD VDD network.neuron_in208.counter\[0\]
+ sky130_fd_sc_hd__edfxtp_1
Xnetwork.neuron_in208.counter\[1\]$_DFFE_PP_ clknet_leaf_113_clk_net
+ _02896_ _01296_ VSS VSS VDD VDD network.neuron_in208.counter\[1\]
+ sky130_fd_sc_hd__edfxtp_1
Xnetwork.neuron_in208.counter\[2\]$_DFFE_PP_ clknet_leaf_113_clk_net
+ _02897_ _01296_ VSS VSS VDD VDD network.neuron_in208.counter\[2\]
+ sky130_fd_sc_hd__edfxtp_1
Xnetwork.neuron_in208.counter\[3\]$_DFFE_PP_ clknet_leaf_113_clk_net
+ _02898_ _01296_ VSS VSS VDD VDD network.neuron_in208.counter\[3\]
+ sky130_fd_sc_hd__edfxtp_1
Xnetwork.neuron_in208.spike$_SDFFE_PP0P_ clknet_leaf_114_clk_net
+ _01938_ VSS VSS VDD VDD network.in_spk00_13 sky130_fd_sc_hd__dfxtp_1
Xnetwork.neuron_in209.counter\[0\]$_DFFE_PP_ clknet_leaf_112_clk_net
+ _02899_ _01295_ VSS VSS VDD VDD network.neuron_in209.counter\[0\]
+ sky130_fd_sc_hd__edfxtp_1
Xnetwork.neuron_in209.counter\[1\]$_DFFE_PP_ clknet_leaf_112_clk_net
+ _02900_ _01295_ VSS VSS VDD VDD network.neuron_in209.counter\[1\]
+ sky130_fd_sc_hd__edfxtp_1
Xnetwork.neuron_in209.counter\[2\]$_DFFE_PP_ clknet_leaf_113_clk_net
+ _02901_ _01295_ VSS VSS VDD VDD network.neuron_in209.counter\[2\]
+ sky130_fd_sc_hd__edfxtp_1
Xnetwork.neuron_in209.counter\[3\]$_DFFE_PP_ clknet_leaf_113_clk_net
+ _02902_ _01295_ VSS VSS VDD VDD network.neuron_in209.counter\[3\]
+ sky130_fd_sc_hd__edfxtp_1
Xnetwork.neuron_in209.spike$_SDFFE_PP0P_ clknet_leaf_114_clk_net
+ _01933_ VSS VSS VDD VDD network.in_spk01_13 sky130_fd_sc_hd__dfxtp_1
Xnetwork.neuron_in210.counter\[0\]$_DFFE_PP_ clknet_leaf_113_clk_net
+ _02903_ _01294_ VSS VSS VDD VDD network.neuron_in210.counter\[0\]
+ sky130_fd_sc_hd__edfxtp_1
Xnetwork.neuron_in210.counter\[1\]$_DFFE_PP_ clknet_leaf_113_clk_net
+ _02904_ _01294_ VSS VSS VDD VDD network.neuron_in210.counter\[1\]
+ sky130_fd_sc_hd__edfxtp_1
Xnetwork.neuron_in210.counter\[2\]$_DFFE_PP_ clknet_leaf_113_clk_net
+ _02905_ _01294_ VSS VSS VDD VDD network.neuron_in210.counter\[2\]
+ sky130_fd_sc_hd__edfxtp_1
Xnetwork.neuron_in210.counter\[3\]$_DFFE_PP_ clknet_leaf_113_clk_net
+ _02906_ _01294_ VSS VSS VDD VDD network.neuron_in210.counter\[3\]
+ sky130_fd_sc_hd__edfxtp_1
Xnetwork.neuron_in210.spike$_SDFFE_PP0P_ clknet_leaf_114_clk_net
+ _01929_ VSS VSS VDD VDD network.in_spk02_13 sky130_fd_sc_hd__dfxtp_1
Xnetwork.neuron_in211.counter\[0\]$_DFFE_PP_ clknet_leaf_111_clk_net
+ _02907_ _01293_ VSS VSS VDD VDD network.neuron_in211.counter\[0\]
+ sky130_fd_sc_hd__edfxtp_1
Xnetwork.neuron_in211.counter\[1\]$_DFFE_PP_ clknet_leaf_111_clk_net
+ _02908_ _01293_ VSS VSS VDD VDD network.neuron_in211.counter\[1\]
+ sky130_fd_sc_hd__edfxtp_1
Xnetwork.neuron_in211.counter\[2\]$_DFFE_PP_ clknet_leaf_112_clk_net
+ _02909_ _01293_ VSS VSS VDD VDD network.neuron_in211.counter\[2\]
+ sky130_fd_sc_hd__edfxtp_1
Xnetwork.neuron_in211.counter\[3\]$_DFFE_PP_ clknet_leaf_112_clk_net
+ _02910_ _01293_ VSS VSS VDD VDD network.neuron_in211.counter\[3\]
+ sky130_fd_sc_hd__edfxtp_1
Xnetwork.neuron_in211.spike$_SDFFE_PP0P_ clknet_leaf_114_clk_net
+ _01924_ VSS VSS VDD VDD network.in_spk03_13 sky130_fd_sc_hd__dfxtp_1
Xnetwork.neuron_in212.counter\[0\]$_DFFE_PP_ clknet_leaf_108_clk_net
+ _02911_ _01292_ VSS VSS VDD VDD network.neuron_in212.counter\[0\]
+ sky130_fd_sc_hd__edfxtp_1
Xnetwork.neuron_in212.counter\[1\]$_DFFE_PP_ clknet_leaf_109_clk_net
+ _02912_ _01292_ VSS VSS VDD VDD network.neuron_in212.counter\[1\]
+ sky130_fd_sc_hd__edfxtp_1
Xnetwork.neuron_in212.counter\[2\]$_DFFE_PP_ clknet_leaf_112_clk_net
+ _02913_ _01292_ VSS VSS VDD VDD network.neuron_in212.counter\[2\]
+ sky130_fd_sc_hd__edfxtp_1
Xnetwork.neuron_in212.counter\[3\]$_DFFE_PP_ clknet_leaf_112_clk_net
+ _02914_ _01292_ VSS VSS VDD VDD network.neuron_in212.counter\[3\]
+ sky130_fd_sc_hd__edfxtp_1
Xnetwork.neuron_in212.spike$_SDFFE_PP0P_ clknet_leaf_114_clk_net
+ _01919_ VSS VSS VDD VDD network.in_spk04_13 sky130_fd_sc_hd__dfxtp_1
Xnetwork.neuron_in213.counter\[0\]$_DFFE_PP_ clknet_leaf_114_clk_net
+ _02915_ _01291_ VSS VSS VDD VDD network.neuron_in213.counter\[0\]
+ sky130_fd_sc_hd__edfxtp_1
Xnetwork.neuron_in213.counter\[1\]$_DFFE_PP_ clknet_leaf_114_clk_net
+ _02916_ _01291_ VSS VSS VDD VDD network.neuron_in213.counter\[1\]
+ sky130_fd_sc_hd__edfxtp_1
Xnetwork.neuron_in213.counter\[2\]$_DFFE_PP_ clknet_leaf_115_clk_net
+ _02917_ _01291_ VSS VSS VDD VDD network.neuron_in213.counter\[2\]
+ sky130_fd_sc_hd__edfxtp_1
Xnetwork.neuron_in213.counter\[3\]$_DFFE_PP_ clknet_leaf_115_clk_net
+ _02918_ _01291_ VSS VSS VDD VDD network.neuron_in213.counter\[3\]
+ sky130_fd_sc_hd__edfxtp_1
Xnetwork.neuron_in213.spike$_SDFFE_PP0P_ clknet_leaf_114_clk_net
+ _01914_ VSS VSS VDD VDD network.in_spk05_13 sky130_fd_sc_hd__dfxtp_1
Xnetwork.neuron_in214.counter\[0\]$_DFFE_PP_ clknet_leaf_115_clk_net
+ _02919_ _01290_ VSS VSS VDD VDD network.neuron_in214.counter\[0\]
+ sky130_fd_sc_hd__edfxtp_1
Xnetwork.neuron_in214.counter\[1\]$_DFFE_PP_ clknet_leaf_115_clk_net
+ _02920_ _01290_ VSS VSS VDD VDD network.neuron_in214.counter\[1\]
+ sky130_fd_sc_hd__edfxtp_1
Xnetwork.neuron_in214.counter\[2\]$_DFFE_PP_ clknet_leaf_115_clk_net
+ _02921_ _01290_ VSS VSS VDD VDD network.neuron_in214.counter\[2\]
+ sky130_fd_sc_hd__edfxtp_1
Xnetwork.neuron_in214.counter\[3\]$_DFFE_PP_ clknet_leaf_115_clk_net
+ _02922_ _01290_ VSS VSS VDD VDD network.neuron_in214.counter\[3\]
+ sky130_fd_sc_hd__edfxtp_1
Xnetwork.neuron_in214.spike$_SDFFE_PP0P_ clknet_leaf_114_clk_net
+ _01910_ VSS VSS VDD VDD network.in_spk06_13 sky130_fd_sc_hd__dfxtp_1
Xnetwork.neuron_in215.counter\[0\]$_DFFE_PP_ clknet_leaf_120_clk_net
+ _02923_ _01289_ VSS VSS VDD VDD network.neuron_in215.counter\[0\]
+ sky130_fd_sc_hd__edfxtp_1
Xnetwork.neuron_in215.counter\[1\]$_DFFE_PP_ clknet_leaf_120_clk_net
+ _02924_ _01289_ VSS VSS VDD VDD network.neuron_in215.counter\[1\]
+ sky130_fd_sc_hd__edfxtp_1
Xnetwork.neuron_in215.counter\[2\]$_DFFE_PP_ clknet_leaf_115_clk_net
+ _02925_ _01289_ VSS VSS VDD VDD network.neuron_in215.counter\[2\]
+ sky130_fd_sc_hd__edfxtp_1
Xnetwork.neuron_in215.counter\[3\]$_DFFE_PP_ clknet_leaf_115_clk_net
+ _02926_ _01289_ VSS VSS VDD VDD network.neuron_in215.counter\[3\]
+ sky130_fd_sc_hd__edfxtp_1
Xnetwork.neuron_in215.spike$_SDFFE_PP0P_ clknet_leaf_116_clk_net
+ _01905_ VSS VSS VDD VDD network.in_spk07_13 sky130_fd_sc_hd__dfxtp_1
Xnetwork.neuron_in216.counter\[0\]$_DFFE_PP_ clknet_leaf_117_clk_net
+ _02927_ _01288_ VSS VSS VDD VDD network.neuron_in216.counter\[0\]
+ sky130_fd_sc_hd__edfxtp_1
Xnetwork.neuron_in216.counter\[1\]$_DFFE_PP_ clknet_leaf_117_clk_net
+ _02928_ _01288_ VSS VSS VDD VDD network.neuron_in216.counter\[1\]
+ sky130_fd_sc_hd__edfxtp_1
Xnetwork.neuron_in216.counter\[2\]$_DFFE_PP_ clknet_leaf_117_clk_net
+ _02929_ _01288_ VSS VSS VDD VDD network.neuron_in216.counter\[2\]
+ sky130_fd_sc_hd__edfxtp_1
Xnetwork.neuron_in216.counter\[3\]$_DFFE_PP_ clknet_leaf_117_clk_net
+ _02930_ _01288_ VSS VSS VDD VDD network.neuron_in216.counter\[3\]
+ sky130_fd_sc_hd__edfxtp_1
Xnetwork.neuron_in216.spike$_SDFFE_PP0P_ clknet_leaf_117_clk_net
+ _01901_ VSS VSS VDD VDD network.in_spk08_13 sky130_fd_sc_hd__dfxtp_1
Xnetwork.neuron_in217.counter\[0\]$_DFFE_PP_ clknet_leaf_108_clk_net
+ _02931_ _01287_ VSS VSS VDD VDD network.neuron_in217.counter\[0\]
+ sky130_fd_sc_hd__edfxtp_1
Xnetwork.neuron_in217.counter\[1\]$_DFFE_PP_ clknet_leaf_109_clk_net
+ _02932_ _01287_ VSS VSS VDD VDD network.neuron_in217.counter\[1\]
+ sky130_fd_sc_hd__edfxtp_1
Xnetwork.neuron_in217.counter\[2\]$_DFFE_PP_ clknet_leaf_108_clk_net
+ _02933_ _01287_ VSS VSS VDD VDD network.neuron_in217.counter\[2\]
+ sky130_fd_sc_hd__edfxtp_1
Xnetwork.neuron_in217.counter\[3\]$_DFFE_PP_ clknet_leaf_108_clk_net
+ _02934_ _01287_ VSS VSS VDD VDD network.neuron_in217.counter\[3\]
+ sky130_fd_sc_hd__edfxtp_1
Xnetwork.neuron_in217.spike$_SDFFE_PP0P_ clknet_leaf_117_clk_net
+ _01898_ VSS VSS VDD VDD network.in_spk09_13 sky130_fd_sc_hd__dfxtp_1
Xnetwork.neuron_in218.counter\[0\]$_DFFE_PP_ clknet_leaf_115_clk_net
+ _02935_ _01286_ VSS VSS VDD VDD network.neuron_in218.counter\[0\]
+ sky130_fd_sc_hd__edfxtp_1
Xnetwork.neuron_in218.counter\[1\]$_DFFE_PP_ clknet_leaf_114_clk_net
+ _02936_ _01286_ VSS VSS VDD VDD network.neuron_in218.counter\[1\]
+ sky130_fd_sc_hd__edfxtp_1
Xnetwork.neuron_in218.counter\[2\]$_DFFE_PP_ clknet_leaf_115_clk_net
+ _02937_ _01286_ VSS VSS VDD VDD network.neuron_in218.counter\[2\]
+ sky130_fd_sc_hd__edfxtp_1
Xnetwork.neuron_in218.counter\[3\]$_DFFE_PP_ clknet_leaf_115_clk_net
+ _02938_ _01286_ VSS VSS VDD VDD network.neuron_in218.counter\[3\]
+ sky130_fd_sc_hd__edfxtp_1
Xnetwork.neuron_in218.spike$_SDFFE_PP0P_ clknet_leaf_117_clk_net
+ _01895_ VSS VSS VDD VDD network.in_spk10_13 sky130_fd_sc_hd__dfxtp_1
Xnetwork.neuron_in219.counter\[0\]$_DFFE_PP_ clknet_leaf_117_clk_net
+ _02939_ _01285_ VSS VSS VDD VDD network.neuron_in219.counter\[0\]
+ sky130_fd_sc_hd__edfxtp_1
Xnetwork.neuron_in219.counter\[1\]$_DFFE_PP_ clknet_leaf_117_clk_net
+ _02940_ _01285_ VSS VSS VDD VDD network.neuron_in219.counter\[1\]
+ sky130_fd_sc_hd__edfxtp_1
Xnetwork.neuron_in219.counter\[2\]$_DFFE_PP_ clknet_leaf_117_clk_net
+ _02941_ _01285_ VSS VSS VDD VDD network.neuron_in219.counter\[2\]
+ sky130_fd_sc_hd__edfxtp_1
Xnetwork.neuron_in219.counter\[3\]$_DFFE_PP_ clknet_leaf_117_clk_net
+ _02942_ _01285_ VSS VSS VDD VDD network.neuron_in219.counter\[3\]
+ sky130_fd_sc_hd__edfxtp_1
Xnetwork.neuron_in219.spike$_SDFFE_PP0P_ clknet_leaf_117_clk_net
+ _01892_ VSS VSS VDD VDD network.in_spk11_13 sky130_fd_sc_hd__dfxtp_1
Xnetwork.neuron_in220.counter\[0\]$_DFFE_PP_ clknet_leaf_119_clk_net
+ _02943_ _01284_ VSS VSS VDD VDD network.neuron_in220.counter\[0\]
+ sky130_fd_sc_hd__edfxtp_1
Xnetwork.neuron_in220.counter\[1\]$_DFFE_PP_ clknet_leaf_119_clk_net
+ _02944_ _01284_ VSS VSS VDD VDD network.neuron_in220.counter\[1\]
+ sky130_fd_sc_hd__edfxtp_1
Xnetwork.neuron_in220.counter\[2\]$_DFFE_PP_ clknet_leaf_120_clk_net
+ _02945_ _01284_ VSS VSS VDD VDD network.neuron_in220.counter\[2\]
+ sky130_fd_sc_hd__edfxtp_1
Xnetwork.neuron_in220.counter\[3\]$_DFFE_PP_ clknet_leaf_120_clk_net
+ _02946_ _01284_ VSS VSS VDD VDD network.neuron_in220.counter\[3\]
+ sky130_fd_sc_hd__edfxtp_1
Xnetwork.neuron_in220.spike$_SDFFE_PP0P_ clknet_leaf_116_clk_net
+ _01889_ VSS VSS VDD VDD network.in_spk12_13 sky130_fd_sc_hd__dfxtp_1
Xnetwork.neuron_in221.counter\[0\]$_DFFE_PP_ clknet_leaf_121_clk_net
+ _02947_ _01283_ VSS VSS VDD VDD network.neuron_in221.counter\[0\]
+ sky130_fd_sc_hd__edfxtp_1
Xnetwork.neuron_in221.counter\[1\]$_DFFE_PP_ clknet_leaf_121_clk_net
+ _02948_ _01283_ VSS VSS VDD VDD network.neuron_in221.counter\[1\]
+ sky130_fd_sc_hd__edfxtp_1
Xnetwork.neuron_in221.counter\[2\]$_DFFE_PP_ clknet_leaf_120_clk_net
+ _02949_ _01283_ VSS VSS VDD VDD network.neuron_in221.counter\[2\]
+ sky130_fd_sc_hd__edfxtp_1
Xnetwork.neuron_in221.counter\[3\]$_DFFE_PP_ clknet_leaf_120_clk_net
+ _02950_ _01283_ VSS VSS VDD VDD network.neuron_in221.counter\[3\]
+ sky130_fd_sc_hd__edfxtp_1
Xnetwork.neuron_in221.spike$_SDFFE_PP0P_ clknet_leaf_116_clk_net
+ _01886_ VSS VSS VDD VDD network.in_spk13_13 sky130_fd_sc_hd__dfxtp_1
Xnetwork.neuron_in222.counter\[0\]$_DFFE_PP_ clknet_leaf_116_clk_net
+ _02951_ _01282_ VSS VSS VDD VDD network.neuron_in222.counter\[0\]
+ sky130_fd_sc_hd__edfxtp_1
Xnetwork.neuron_in222.counter\[1\]$_DFFE_PP_ clknet_leaf_116_clk_net
+ _02952_ _01282_ VSS VSS VDD VDD network.neuron_in222.counter\[1\]
+ sky130_fd_sc_hd__edfxtp_1
Xnetwork.neuron_in222.counter\[2\]$_DFFE_PP_ clknet_leaf_120_clk_net
+ _02953_ _01282_ VSS VSS VDD VDD network.neuron_in222.counter\[2\]
+ sky130_fd_sc_hd__edfxtp_1
Xnetwork.neuron_in222.counter\[3\]$_DFFE_PP_ clknet_leaf_120_clk_net
+ _02954_ _01282_ VSS VSS VDD VDD network.neuron_in222.counter\[3\]
+ sky130_fd_sc_hd__edfxtp_1
Xnetwork.neuron_in222.spike$_SDFFE_PP0P_ clknet_leaf_116_clk_net
+ _01883_ VSS VSS VDD VDD network.in_spk14_13 sky130_fd_sc_hd__dfxtp_1
Xnetwork.neuron_in223.counter\[0\]$_DFFE_PP_ clknet_leaf_119_clk_net
+ _02955_ _01281_ VSS VSS VDD VDD network.neuron_in223.counter\[0\]
+ sky130_fd_sc_hd__edfxtp_1
Xnetwork.neuron_in223.counter\[1\]$_DFFE_PP_ clknet_leaf_119_clk_net
+ _02956_ _01281_ VSS VSS VDD VDD network.neuron_in223.counter\[1\]
+ sky130_fd_sc_hd__edfxtp_1
Xnetwork.neuron_in223.counter\[2\]$_DFFE_PP_ clknet_leaf_118_clk_net
+ _02957_ _01281_ VSS VSS VDD VDD network.neuron_in223.counter\[2\]
+ sky130_fd_sc_hd__edfxtp_1
Xnetwork.neuron_in223.counter\[3\]$_DFFE_PP_ clknet_leaf_118_clk_net
+ _02958_ _01281_ VSS VSS VDD VDD network.neuron_in223.counter\[3\]
+ sky130_fd_sc_hd__edfxtp_1
Xnetwork.neuron_in223.spike$_SDFFE_PP0P_ clknet_leaf_116_clk_net
+ _01880_ VSS VSS VDD VDD network.in_spk15_13 sky130_fd_sc_hd__dfxtp_1
Xnetwork.neuron_in224.counter\[0\]$_DFFE_PP_ clknet_leaf_103_clk_net
+ _02959_ _01280_ VSS VSS VDD VDD network.neuron_in224.counter\[0\]
+ sky130_fd_sc_hd__edfxtp_1
Xnetwork.neuron_in224.counter\[1\]$_DFFE_PP_ clknet_leaf_103_clk_net
+ _02960_ _01280_ VSS VSS VDD VDD network.neuron_in224.counter\[1\]
+ sky130_fd_sc_hd__edfxtp_1
Xnetwork.neuron_in224.counter\[2\]$_DFFE_PP_ clknet_leaf_103_clk_net
+ _02961_ _01280_ VSS VSS VDD VDD network.neuron_in224.counter\[2\]
+ sky130_fd_sc_hd__edfxtp_1
Xnetwork.neuron_in224.counter\[3\]$_DFFE_PP_ clknet_leaf_103_clk_net
+ _02962_ _01280_ VSS VSS VDD VDD network.neuron_in224.counter\[3\]
+ sky130_fd_sc_hd__edfxtp_1
Xnetwork.neuron_in224.spike$_SDFFE_PP0P_ clknet_leaf_103_clk_net
+ _01877_ VSS VSS VDD VDD network.in_spk00_14 sky130_fd_sc_hd__dfxtp_1
Xnetwork.neuron_in225.counter\[0\]$_DFFE_PP_ clknet_leaf_101_clk_net
+ _02963_ _01279_ VSS VSS VDD VDD network.neuron_in225.counter\[0\]
+ sky130_fd_sc_hd__edfxtp_1
Xnetwork.neuron_in225.counter\[1\]$_DFFE_PP_ clknet_leaf_99_clk_net
+ _02964_ _01279_ VSS VSS VDD VDD network.neuron_in225.counter\[1\]
+ sky130_fd_sc_hd__edfxtp_1
Xnetwork.neuron_in225.counter\[2\]$_DFFE_PP_ clknet_leaf_99_clk_net
+ _02965_ _01279_ VSS VSS VDD VDD network.neuron_in225.counter\[2\]
+ sky130_fd_sc_hd__edfxtp_1
Xnetwork.neuron_in225.counter\[3\]$_DFFE_PP_ clknet_leaf_99_clk_net
+ _02966_ _01279_ VSS VSS VDD VDD network.neuron_in225.counter\[3\]
+ sky130_fd_sc_hd__edfxtp_1
Xnetwork.neuron_in225.spike$_SDFFE_PP0P_ clknet_leaf_103_clk_net
+ _01874_ VSS VSS VDD VDD network.in_spk01_14 sky130_fd_sc_hd__dfxtp_1
Xnetwork.neuron_in226.counter\[0\]$_DFFE_PP_ clknet_leaf_104_clk_net
+ _02967_ _01278_ VSS VSS VDD VDD network.neuron_in226.counter\[0\]
+ sky130_fd_sc_hd__edfxtp_1
Xnetwork.neuron_in226.counter\[1\]$_DFFE_PP_ clknet_leaf_104_clk_net
+ _02968_ _01278_ VSS VSS VDD VDD network.neuron_in226.counter\[1\]
+ sky130_fd_sc_hd__edfxtp_1
Xnetwork.neuron_in226.counter\[2\]$_DFFE_PP_ clknet_leaf_104_clk_net
+ _02969_ _01278_ VSS VSS VDD VDD network.neuron_in226.counter\[2\]
+ sky130_fd_sc_hd__edfxtp_1
Xnetwork.neuron_in226.counter\[3\]$_DFFE_PP_ clknet_leaf_104_clk_net
+ _02970_ _01278_ VSS VSS VDD VDD network.neuron_in226.counter\[3\]
+ sky130_fd_sc_hd__edfxtp_1
Xnetwork.neuron_in226.spike$_SDFFE_PP0P_ clknet_leaf_104_clk_net
+ _01945_ VSS VSS VDD VDD network.in_spk02_14 sky130_fd_sc_hd__dfxtp_1
Xnetwork.neuron_in227.counter\[0\]$_DFFE_PP_ clknet_leaf_102_clk_net
+ _02971_ _01277_ VSS VSS VDD VDD network.neuron_in227.counter\[0\]
+ sky130_fd_sc_hd__edfxtp_1
Xnetwork.neuron_in227.counter\[1\]$_DFFE_PP_ clknet_leaf_102_clk_net
+ _02972_ _01277_ VSS VSS VDD VDD network.neuron_in227.counter\[1\]
+ sky130_fd_sc_hd__edfxtp_1
Xnetwork.neuron_in227.counter\[2\]$_DFFE_PP_ clknet_leaf_65_clk_net
+ _02973_ _01277_ VSS VSS VDD VDD network.neuron_in227.counter\[2\]
+ sky130_fd_sc_hd__edfxtp_1
Xnetwork.neuron_in227.counter\[3\]$_DFFE_PP_ clknet_leaf_65_clk_net
+ _02974_ _01277_ VSS VSS VDD VDD network.neuron_in227.counter\[3\]
+ sky130_fd_sc_hd__edfxtp_1
Xnetwork.neuron_in227.spike$_SDFFE_PP0P_ clknet_leaf_103_clk_net
+ _01907_ VSS VSS VDD VDD network.in_spk03_14 sky130_fd_sc_hd__dfxtp_1
Xnetwork.neuron_in228.counter\[0\]$_DFFE_PP_ clknet_leaf_145_clk_net
+ _02975_ _01276_ VSS VSS VDD VDD network.neuron_in228.counter\[0\]
+ sky130_fd_sc_hd__edfxtp_1
Xnetwork.neuron_in228.counter\[1\]$_DFFE_PP_ clknet_leaf_145_clk_net
+ _02976_ _01276_ VSS VSS VDD VDD network.neuron_in228.counter\[1\]
+ sky130_fd_sc_hd__edfxtp_1
Xnetwork.neuron_in228.counter\[2\]$_DFFE_PP_ clknet_leaf_103_clk_net
+ _02977_ _01276_ VSS VSS VDD VDD network.neuron_in228.counter\[2\]
+ sky130_fd_sc_hd__edfxtp_1
Xnetwork.neuron_in228.counter\[3\]$_DFFE_PP_ clknet_leaf_145_clk_net
+ _02978_ _01276_ VSS VSS VDD VDD network.neuron_in228.counter\[3\]
+ sky130_fd_sc_hd__edfxtp_1
Xnetwork.neuron_in228.spike$_SDFFE_PP0P_ clknet_leaf_103_clk_net
+ _01947_ VSS VSS VDD VDD network.in_spk04_14 sky130_fd_sc_hd__dfxtp_1
Xnetwork.neuron_in229.counter\[0\]$_DFFE_PP_ clknet_leaf_144_clk_net
+ _02979_ _01275_ VSS VSS VDD VDD network.neuron_in229.counter\[0\]
+ sky130_fd_sc_hd__edfxtp_1
Xnetwork.neuron_in229.counter\[1\]$_DFFE_PP_ clknet_leaf_144_clk_net
+ _02980_ _01275_ VSS VSS VDD VDD network.neuron_in229.counter\[1\]
+ sky130_fd_sc_hd__edfxtp_1
Xnetwork.neuron_in229.counter\[2\]$_DFFE_PP_ clknet_leaf_144_clk_net
+ _02981_ _01275_ VSS VSS VDD VDD network.neuron_in229.counter\[2\]
+ sky130_fd_sc_hd__edfxtp_1
Xnetwork.neuron_in229.counter\[3\]$_DFFE_PP_ clknet_leaf_144_clk_net
+ _02982_ _01275_ VSS VSS VDD VDD network.neuron_in229.counter\[3\]
+ sky130_fd_sc_hd__edfxtp_1
Xnetwork.neuron_in229.spike$_SDFFE_PP0P_ clknet_leaf_106_clk_net
+ _01935_ VSS VSS VDD VDD network.in_spk05_14 sky130_fd_sc_hd__dfxtp_1
Xnetwork.neuron_in230.counter\[0\]$_DFFE_PP_ clknet_leaf_108_clk_net
+ _02983_ _01274_ VSS VSS VDD VDD network.neuron_in230.counter\[0\]
+ sky130_fd_sc_hd__edfxtp_1
Xnetwork.neuron_in230.counter\[1\]$_DFFE_PP_ clknet_leaf_108_clk_net
+ _02984_ _01274_ VSS VSS VDD VDD network.neuron_in230.counter\[1\]
+ sky130_fd_sc_hd__edfxtp_1
Xnetwork.neuron_in230.counter\[2\]$_DFFE_PP_ clknet_leaf_109_clk_net
+ _02985_ _01274_ VSS VSS VDD VDD network.neuron_in230.counter\[2\]
+ sky130_fd_sc_hd__edfxtp_1
Xnetwork.neuron_in230.counter\[3\]$_DFFE_PP_ clknet_leaf_109_clk_net
+ _02986_ _01274_ VSS VSS VDD VDD network.neuron_in230.counter\[3\]
+ sky130_fd_sc_hd__edfxtp_1
Xnetwork.neuron_in230.spike$_SDFFE_PP0P_ clknet_leaf_106_clk_net
+ _01926_ VSS VSS VDD VDD network.in_spk06_14 sky130_fd_sc_hd__dfxtp_1
Xnetwork.neuron_in231.counter\[0\]$_DFFE_PP_ clknet_leaf_145_clk_net
+ _02987_ _01273_ VSS VSS VDD VDD network.neuron_in231.counter\[0\]
+ sky130_fd_sc_hd__edfxtp_1
Xnetwork.neuron_in231.counter\[1\]$_DFFE_PP_ clknet_leaf_145_clk_net
+ _02988_ _01273_ VSS VSS VDD VDD network.neuron_in231.counter\[1\]
+ sky130_fd_sc_hd__edfxtp_1
Xnetwork.neuron_in231.counter\[2\]$_DFFE_PP_ clknet_leaf_146_clk_net
+ _02989_ _01273_ VSS VSS VDD VDD network.neuron_in231.counter\[2\]
+ sky130_fd_sc_hd__edfxtp_1
Xnetwork.neuron_in231.counter\[3\]$_DFFE_PP_ clknet_leaf_146_clk_net
+ _02990_ _01273_ VSS VSS VDD VDD network.neuron_in231.counter\[3\]
+ sky130_fd_sc_hd__edfxtp_1
Xnetwork.neuron_in231.spike$_SDFFE_PP0P_ clknet_leaf_103_clk_net
+ _01869_ VSS VSS VDD VDD network.in_spk07_14 sky130_fd_sc_hd__dfxtp_1
Xnetwork.neuron_in232.counter\[0\]$_DFFE_PP_ clknet_leaf_102_clk_net
+ _02991_ _01272_ VSS VSS VDD VDD network.neuron_in232.counter\[0\]
+ sky130_fd_sc_hd__edfxtp_1
Xnetwork.neuron_in232.counter\[1\]$_DFFE_PP_ clknet_leaf_102_clk_net
+ _02992_ _01272_ VSS VSS VDD VDD network.neuron_in232.counter\[1\]
+ sky130_fd_sc_hd__edfxtp_1
Xnetwork.neuron_in232.counter\[2\]$_DFFE_PP_ clknet_leaf_102_clk_net
+ _02993_ _01272_ VSS VSS VDD VDD network.neuron_in232.counter\[2\]
+ sky130_fd_sc_hd__edfxtp_1
Xnetwork.neuron_in232.counter\[3\]$_DFFE_PP_ clknet_leaf_102_clk_net
+ _02994_ _01272_ VSS VSS VDD VDD network.neuron_in232.counter\[3\]
+ sky130_fd_sc_hd__edfxtp_1
Xnetwork.neuron_in232.spike$_SDFFE_PP0P_ clknet_leaf_104_clk_net
+ _01870_ VSS VSS VDD VDD network.in_spk08_14 sky130_fd_sc_hd__dfxtp_1
Xnetwork.neuron_in233.counter\[0\]$_DFFE_PP_ clknet_leaf_65_clk_net
+ _02995_ _01271_ VSS VSS VDD VDD network.neuron_in233.counter\[0\]
+ sky130_fd_sc_hd__edfxtp_1
Xnetwork.neuron_in233.counter\[1\]$_DFFE_PP_ clknet_leaf_22_clk_net
+ _02996_ _01271_ VSS VSS VDD VDD network.neuron_in233.counter\[1\]
+ sky130_fd_sc_hd__edfxtp_1
Xnetwork.neuron_in233.counter\[2\]$_DFFE_PP_ clknet_leaf_65_clk_net
+ _02997_ _01271_ VSS VSS VDD VDD network.neuron_in233.counter\[2\]
+ sky130_fd_sc_hd__edfxtp_1
Xnetwork.neuron_in233.counter\[3\]$_DFFE_PP_ clknet_leaf_64_clk_net
+ _02998_ _01271_ VSS VSS VDD VDD network.neuron_in233.counter\[3\]
+ sky130_fd_sc_hd__edfxtp_1
Xnetwork.neuron_in233.spike$_SDFFE_PP0P_ clknet_leaf_104_clk_net
+ _01871_ VSS VSS VDD VDD network.in_spk09_14 sky130_fd_sc_hd__dfxtp_1
Xnetwork.neuron_in234.counter\[0\]$_DFFE_PP_ clknet_leaf_110_clk_net
+ _02999_ _01270_ VSS VSS VDD VDD network.neuron_in234.counter\[0\]
+ sky130_fd_sc_hd__edfxtp_1
Xnetwork.neuron_in234.counter\[1\]$_DFFE_PP_ clknet_leaf_110_clk_net
+ _03000_ _01270_ VSS VSS VDD VDD network.neuron_in234.counter\[1\]
+ sky130_fd_sc_hd__edfxtp_1
Xnetwork.neuron_in234.counter\[2\]$_DFFE_PP_ clknet_leaf_110_clk_net
+ _03001_ _01270_ VSS VSS VDD VDD network.neuron_in234.counter\[2\]
+ sky130_fd_sc_hd__edfxtp_1
Xnetwork.neuron_in234.counter\[3\]$_DFFE_PP_ clknet_leaf_110_clk_net
+ _03002_ _01270_ VSS VSS VDD VDD network.neuron_in234.counter\[3\]
+ sky130_fd_sc_hd__edfxtp_1
Xnetwork.neuron_in234.spike$_SDFFE_PP0P_ clknet_leaf_105_clk_net
+ _01872_ VSS VSS VDD VDD network.in_spk10_14 sky130_fd_sc_hd__dfxtp_1
Xnetwork.neuron_in235.counter\[0\]$_DFFE_PP_ clknet_leaf_109_clk_net
+ _03003_ _01269_ VSS VSS VDD VDD network.neuron_in235.counter\[0\]
+ sky130_fd_sc_hd__edfxtp_1
Xnetwork.neuron_in235.counter\[1\]$_DFFE_PP_ clknet_leaf_109_clk_net
+ _03004_ _01269_ VSS VSS VDD VDD network.neuron_in235.counter\[1\]
+ sky130_fd_sc_hd__edfxtp_1
Xnetwork.neuron_in235.counter\[2\]$_DFFE_PP_ clknet_leaf_110_clk_net
+ _03005_ _01269_ VSS VSS VDD VDD network.neuron_in235.counter\[2\]
+ sky130_fd_sc_hd__edfxtp_1
Xnetwork.neuron_in235.counter\[3\]$_DFFE_PP_ clknet_leaf_111_clk_net
+ _03006_ _01269_ VSS VSS VDD VDD network.neuron_in235.counter\[3\]
+ sky130_fd_sc_hd__edfxtp_1
Xnetwork.neuron_in235.spike$_SDFFE_PP0P_ clknet_leaf_105_clk_net
+ _01867_ VSS VSS VDD VDD network.in_spk11_14 sky130_fd_sc_hd__dfxtp_1
Xnetwork.neuron_in236.counter\[0\]$_DFFE_PP_ clknet_leaf_142_clk_net
+ _03007_ _01268_ VSS VSS VDD VDD network.neuron_in236.counter\[0\]
+ sky130_fd_sc_hd__edfxtp_1
Xnetwork.neuron_in236.counter\[1\]$_DFFE_PP_ clknet_leaf_145_clk_net
+ _03008_ _01268_ VSS VSS VDD VDD network.neuron_in236.counter\[1\]
+ sky130_fd_sc_hd__edfxtp_1
Xnetwork.neuron_in236.counter\[2\]$_DFFE_PP_ clknet_leaf_103_clk_net
+ _03009_ _01268_ VSS VSS VDD VDD network.neuron_in236.counter\[2\]
+ sky130_fd_sc_hd__edfxtp_1
Xnetwork.neuron_in236.counter\[3\]$_DFFE_PP_ clknet_leaf_103_clk_net
+ _03010_ _01268_ VSS VSS VDD VDD network.neuron_in236.counter\[3\]
+ sky130_fd_sc_hd__edfxtp_1
Xnetwork.neuron_in236.spike$_SDFFE_PP0P_ clknet_leaf_106_clk_net
+ _01868_ VSS VSS VDD VDD network.in_spk12_14 sky130_fd_sc_hd__dfxtp_1
Xnetwork.neuron_in237.counter\[0\]$_DFFE_PP_ clknet_leaf_110_clk_net
+ _03011_ _01267_ VSS VSS VDD VDD network.neuron_in237.counter\[0\]
+ sky130_fd_sc_hd__edfxtp_1
Xnetwork.neuron_in237.counter\[1\]$_DFFE_PP_ clknet_leaf_105_clk_net
+ _03012_ _01267_ VSS VSS VDD VDD network.neuron_in237.counter\[1\]
+ sky130_fd_sc_hd__edfxtp_1
Xnetwork.neuron_in237.counter\[2\]$_DFFE_PP_ clknet_leaf_105_clk_net
+ _03013_ _01267_ VSS VSS VDD VDD network.neuron_in237.counter\[2\]
+ sky130_fd_sc_hd__edfxtp_1
Xnetwork.neuron_in237.counter\[3\]$_DFFE_PP_ clknet_leaf_104_clk_net
+ _03014_ _01267_ VSS VSS VDD VDD network.neuron_in237.counter\[3\]
+ sky130_fd_sc_hd__edfxtp_1
Xnetwork.neuron_in237.spike$_SDFFE_PP0P_ clknet_leaf_105_clk_net
+ _01873_ VSS VSS VDD VDD network.in_spk13_14 sky130_fd_sc_hd__dfxtp_1
Xnetwork.neuron_in238.counter\[0\]$_DFFE_PP_ clknet_leaf_106_clk_net
+ _03015_ _01266_ VSS VSS VDD VDD network.neuron_in238.counter\[0\]
+ sky130_fd_sc_hd__edfxtp_1
Xnetwork.neuron_in238.counter\[1\]$_DFFE_PP_ clknet_leaf_106_clk_net
+ _03016_ _01266_ VSS VSS VDD VDD network.neuron_in238.counter\[1\]
+ sky130_fd_sc_hd__edfxtp_1
Xnetwork.neuron_in238.counter\[2\]$_DFFE_PP_ clknet_leaf_108_clk_net
+ _03017_ _01266_ VSS VSS VDD VDD network.neuron_in238.counter\[2\]
+ sky130_fd_sc_hd__edfxtp_1
Xnetwork.neuron_in238.counter\[3\]$_DFFE_PP_ clknet_leaf_106_clk_net
+ _03018_ _01266_ VSS VSS VDD VDD network.neuron_in238.counter\[3\]
+ sky130_fd_sc_hd__edfxtp_1
Xnetwork.neuron_in238.spike$_SDFFE_PP0P_ clknet_leaf_105_clk_net
+ _01875_ VSS VSS VDD VDD network.in_spk14_14 sky130_fd_sc_hd__dfxtp_1
Xnetwork.neuron_in239.counter\[0\]$_DFFE_PP_ clknet_leaf_106_clk_net
+ _03019_ _01265_ VSS VSS VDD VDD network.neuron_in239.counter\[0\]
+ sky130_fd_sc_hd__edfxtp_1
Xnetwork.neuron_in239.counter\[1\]$_DFFE_PP_ clknet_leaf_105_clk_net
+ _03020_ _01265_ VSS VSS VDD VDD network.neuron_in239.counter\[1\]
+ sky130_fd_sc_hd__edfxtp_1
Xnetwork.neuron_in239.counter\[2\]$_DFFE_PP_ clknet_leaf_109_clk_net
+ _03021_ _01265_ VSS VSS VDD VDD network.neuron_in239.counter\[2\]
+ sky130_fd_sc_hd__edfxtp_1
Xnetwork.neuron_in239.counter\[3\]$_DFFE_PP_ clknet_leaf_110_clk_net
+ _03022_ _01265_ VSS VSS VDD VDD network.neuron_in239.counter\[3\]
+ sky130_fd_sc_hd__edfxtp_1
Xnetwork.neuron_in239.spike$_SDFFE_PP0P_ clknet_leaf_105_clk_net
+ _01876_ VSS VSS VDD VDD network.in_spk15_14 sky130_fd_sc_hd__dfxtp_1
Xnetwork.neuron_in240.counter\[0\]$_DFFE_PP_ clknet_leaf_140_clk_net
+ _03023_ _01264_ VSS VSS VDD VDD network.neuron_in240.counter\[0\]
+ sky130_fd_sc_hd__edfxtp_1
Xnetwork.neuron_in240.counter\[1\]$_DFFE_PP_ clknet_leaf_140_clk_net
+ _03024_ _01264_ VSS VSS VDD VDD network.neuron_in240.counter\[1\]
+ sky130_fd_sc_hd__edfxtp_1
Xnetwork.neuron_in240.counter\[2\]$_DFFE_PP_ clknet_leaf_107_clk_net
+ _03025_ _01264_ VSS VSS VDD VDD network.neuron_in240.counter\[2\]
+ sky130_fd_sc_hd__edfxtp_1
Xnetwork.neuron_in240.counter\[3\]$_DFFE_PP_ clknet_leaf_140_clk_net
+ _03026_ _01264_ VSS VSS VDD VDD network.neuron_in240.counter\[3\]
+ sky130_fd_sc_hd__edfxtp_1
Xnetwork.neuron_in240.spike$_SDFFE_PP0P_ clknet_leaf_107_clk_net
+ _01878_ VSS VSS VDD VDD network.in_spk00_15 sky130_fd_sc_hd__dfxtp_1
Xnetwork.neuron_in241.counter\[0\]$_DFFE_PP_ clknet_leaf_137_clk_net
+ _03027_ _01263_ VSS VSS VDD VDD network.neuron_in241.counter\[0\]
+ sky130_fd_sc_hd__edfxtp_1
Xnetwork.neuron_in241.counter\[1\]$_DFFE_PP_ clknet_leaf_143_clk_net
+ _03028_ _01263_ VSS VSS VDD VDD network.neuron_in241.counter\[1\]
+ sky130_fd_sc_hd__edfxtp_1
Xnetwork.neuron_in241.counter\[2\]$_DFFE_PP_ clknet_leaf_143_clk_net
+ _03029_ _01263_ VSS VSS VDD VDD network.neuron_in241.counter\[2\]
+ sky130_fd_sc_hd__edfxtp_1
Xnetwork.neuron_in241.counter\[3\]$_DFFE_PP_ clknet_leaf_143_clk_net
+ _03030_ _01263_ VSS VSS VDD VDD network.neuron_in241.counter\[3\]
+ sky130_fd_sc_hd__edfxtp_1
Xnetwork.neuron_in241.spike$_SDFFE_PP0P_ clknet_leaf_141_clk_net
+ _01879_ VSS VSS VDD VDD network.in_spk01_15 sky130_fd_sc_hd__dfxtp_1
Xnetwork.neuron_in242.counter\[0\]$_DFFE_PP_ clknet_leaf_143_clk_net
+ _03031_ _01262_ VSS VSS VDD VDD network.neuron_in242.counter\[0\]
+ sky130_fd_sc_hd__edfxtp_1
Xnetwork.neuron_in242.counter\[1\]$_DFFE_PP_ clknet_leaf_144_clk_net
+ _03032_ _01262_ VSS VSS VDD VDD network.neuron_in242.counter\[1\]
+ sky130_fd_sc_hd__edfxtp_1
Xnetwork.neuron_in242.counter\[2\]$_DFFE_PP_ clknet_leaf_144_clk_net
+ _03033_ _01262_ VSS VSS VDD VDD network.neuron_in242.counter\[2\]
+ sky130_fd_sc_hd__edfxtp_1
Xnetwork.neuron_in242.counter\[3\]$_DFFE_PP_ clknet_leaf_144_clk_net
+ _03034_ _01262_ VSS VSS VDD VDD network.neuron_in242.counter\[3\]
+ sky130_fd_sc_hd__edfxtp_1
Xnetwork.neuron_in242.spike$_SDFFE_PP0P_ clknet_leaf_106_clk_net
+ _01881_ VSS VSS VDD VDD network.in_spk02_15 sky130_fd_sc_hd__dfxtp_1
Xnetwork.neuron_in243.counter\[0\]$_DFFE_PP_ clknet_leaf_107_clk_net
+ _03035_ _01261_ VSS VSS VDD VDD network.neuron_in243.counter\[0\]
+ sky130_fd_sc_hd__edfxtp_1
Xnetwork.neuron_in243.counter\[1\]$_DFFE_PP_ clknet_leaf_108_clk_net
+ _03036_ _01261_ VSS VSS VDD VDD network.neuron_in243.counter\[1\]
+ sky130_fd_sc_hd__edfxtp_1
Xnetwork.neuron_in243.counter\[2\]$_DFFE_PP_ clknet_leaf_107_clk_net
+ _03037_ _01261_ VSS VSS VDD VDD network.neuron_in243.counter\[2\]
+ sky130_fd_sc_hd__edfxtp_1
Xnetwork.neuron_in243.counter\[3\]$_DFFE_PP_ clknet_leaf_108_clk_net
+ _03038_ _01261_ VSS VSS VDD VDD network.neuron_in243.counter\[3\]
+ sky130_fd_sc_hd__edfxtp_1
Xnetwork.neuron_in243.spike$_SDFFE_PP0P_ clknet_leaf_107_clk_net
+ _01882_ VSS VSS VDD VDD network.in_spk03_15 sky130_fd_sc_hd__dfxtp_1
Xnetwork.neuron_in244.counter\[0\]$_DFFE_PP_ clknet_leaf_138_clk_net
+ _03039_ _01260_ VSS VSS VDD VDD network.neuron_in244.counter\[0\]
+ sky130_fd_sc_hd__edfxtp_1
Xnetwork.neuron_in244.counter\[1\]$_DFFE_PP_ clknet_leaf_138_clk_net
+ _03040_ _01260_ VSS VSS VDD VDD network.neuron_in244.counter\[1\]
+ sky130_fd_sc_hd__edfxtp_1
Xnetwork.neuron_in244.counter\[2\]$_DFFE_PP_ clknet_leaf_141_clk_net
+ _03041_ _01260_ VSS VSS VDD VDD network.neuron_in244.counter\[2\]
+ sky130_fd_sc_hd__edfxtp_1
Xnetwork.neuron_in244.counter\[3\]$_DFFE_PP_ clknet_leaf_142_clk_net
+ _03042_ _01260_ VSS VSS VDD VDD network.neuron_in244.counter\[3\]
+ sky130_fd_sc_hd__edfxtp_1
Xnetwork.neuron_in244.spike$_SDFFE_PP0P_ clknet_leaf_141_clk_net
+ _01884_ VSS VSS VDD VDD network.in_spk04_15 sky130_fd_sc_hd__dfxtp_1
Xnetwork.neuron_in245.counter\[0\]$_DFFE_PP_ clknet_leaf_129_clk_net
+ _03043_ _01259_ VSS VSS VDD VDD network.neuron_in245.counter\[0\]
+ sky130_fd_sc_hd__edfxtp_1
Xnetwork.neuron_in245.counter\[1\]$_DFFE_PP_ clknet_leaf_128_clk_net
+ _03044_ _01259_ VSS VSS VDD VDD network.neuron_in245.counter\[1\]
+ sky130_fd_sc_hd__edfxtp_1
Xnetwork.neuron_in245.counter\[2\]$_DFFE_PP_ clknet_leaf_128_clk_net
+ _03045_ _01259_ VSS VSS VDD VDD network.neuron_in245.counter\[2\]
+ sky130_fd_sc_hd__edfxtp_1
Xnetwork.neuron_in245.counter\[3\]$_DFFE_PP_ clknet_leaf_128_clk_net
+ _03046_ _01259_ VSS VSS VDD VDD network.neuron_in245.counter\[3\]
+ sky130_fd_sc_hd__edfxtp_1
Xnetwork.neuron_in245.spike$_SDFFE_PP0P_ clknet_leaf_140_clk_net
+ _01885_ VSS VSS VDD VDD network.in_spk05_15 sky130_fd_sc_hd__dfxtp_1
Xnetwork.neuron_in246.counter\[0\]$_DFFE_PP_ clknet_leaf_107_clk_net
+ _03047_ _01258_ VSS VSS VDD VDD network.neuron_in246.counter\[0\]
+ sky130_fd_sc_hd__edfxtp_1
Xnetwork.neuron_in246.counter\[1\]$_DFFE_PP_ clknet_leaf_107_clk_net
+ _03048_ _01258_ VSS VSS VDD VDD network.neuron_in246.counter\[1\]
+ sky130_fd_sc_hd__edfxtp_1
Xnetwork.neuron_in246.counter\[2\]$_DFFE_PP_ clknet_leaf_107_clk_net
+ _03049_ _01258_ VSS VSS VDD VDD network.neuron_in246.counter\[2\]
+ sky130_fd_sc_hd__edfxtp_1
Xnetwork.neuron_in246.counter\[3\]$_DFFE_PP_ clknet_leaf_107_clk_net
+ _03050_ _01258_ VSS VSS VDD VDD network.neuron_in246.counter\[3\]
+ sky130_fd_sc_hd__edfxtp_1
Xnetwork.neuron_in246.spike$_SDFFE_PP0P_ clknet_leaf_107_clk_net
+ _01887_ VSS VSS VDD VDD network.in_spk06_15 sky130_fd_sc_hd__dfxtp_1
Xnetwork.neuron_in247.counter\[0\]$_DFFE_PP_ clknet_leaf_139_clk_net
+ _03051_ _01257_ VSS VSS VDD VDD network.neuron_in247.counter\[0\]
+ sky130_fd_sc_hd__edfxtp_1
Xnetwork.neuron_in247.counter\[1\]$_DFFE_PP_ clknet_leaf_139_clk_net
+ _03052_ _01257_ VSS VSS VDD VDD network.neuron_in247.counter\[1\]
+ sky130_fd_sc_hd__edfxtp_1
Xnetwork.neuron_in247.counter\[2\]$_DFFE_PP_ clknet_leaf_139_clk_net
+ _03053_ _01257_ VSS VSS VDD VDD network.neuron_in247.counter\[2\]
+ sky130_fd_sc_hd__edfxtp_1
Xnetwork.neuron_in247.counter\[3\]$_DFFE_PP_ clknet_leaf_139_clk_net
+ _03054_ _01257_ VSS VSS VDD VDD network.neuron_in247.counter\[3\]
+ sky130_fd_sc_hd__edfxtp_1
Xnetwork.neuron_in247.spike$_SDFFE_PP0P_ clknet_leaf_141_clk_net
+ _01888_ VSS VSS VDD VDD network.in_spk07_15 sky130_fd_sc_hd__dfxtp_1
Xnetwork.neuron_in248.counter\[0\]$_DFFE_PP_ clknet_leaf_142_clk_net
+ _03055_ _01256_ VSS VSS VDD VDD network.neuron_in248.counter\[0\]
+ sky130_fd_sc_hd__edfxtp_1
Xnetwork.neuron_in248.counter\[1\]$_DFFE_PP_ clknet_leaf_142_clk_net
+ _03056_ _01256_ VSS VSS VDD VDD network.neuron_in248.counter\[1\]
+ sky130_fd_sc_hd__edfxtp_1
Xnetwork.neuron_in248.counter\[2\]$_DFFE_PP_ clknet_leaf_141_clk_net
+ _03057_ _01256_ VSS VSS VDD VDD network.neuron_in248.counter\[2\]
+ sky130_fd_sc_hd__edfxtp_1
Xnetwork.neuron_in248.counter\[3\]$_DFFE_PP_ clknet_leaf_141_clk_net
+ _03058_ _01256_ VSS VSS VDD VDD network.neuron_in248.counter\[3\]
+ sky130_fd_sc_hd__edfxtp_1
Xnetwork.neuron_in248.spike$_SDFFE_PP0P_ clknet_leaf_141_clk_net
+ _01890_ VSS VSS VDD VDD network.in_spk08_15 sky130_fd_sc_hd__dfxtp_1
Xnetwork.neuron_in249.counter\[0\]$_DFFE_PP_ clknet_leaf_142_clk_net
+ _03059_ _01255_ VSS VSS VDD VDD network.neuron_in249.counter\[0\]
+ sky130_fd_sc_hd__edfxtp_1
Xnetwork.neuron_in249.counter\[1\]$_DFFE_PP_ clknet_leaf_142_clk_net
+ _03060_ _01255_ VSS VSS VDD VDD network.neuron_in249.counter\[1\]
+ sky130_fd_sc_hd__edfxtp_1
Xnetwork.neuron_in249.counter\[2\]$_DFFE_PP_ clknet_leaf_142_clk_net
+ _03061_ _01255_ VSS VSS VDD VDD network.neuron_in249.counter\[2\]
+ sky130_fd_sc_hd__edfxtp_1
Xnetwork.neuron_in249.counter\[3\]$_DFFE_PP_ clknet_leaf_142_clk_net
+ _03062_ _01255_ VSS VSS VDD VDD network.neuron_in249.counter\[3\]
+ sky130_fd_sc_hd__edfxtp_1
Xnetwork.neuron_in249.spike$_SDFFE_PP0P_ clknet_leaf_141_clk_net
+ _01891_ VSS VSS VDD VDD network.in_spk09_15 sky130_fd_sc_hd__dfxtp_1
Xnetwork.neuron_in250.counter\[0\]$_DFFE_PP_ clknet_leaf_118_clk_net
+ _03063_ _01254_ VSS VSS VDD VDD network.neuron_in250.counter\[0\]
+ sky130_fd_sc_hd__edfxtp_1
Xnetwork.neuron_in250.counter\[1\]$_DFFE_PP_ clknet_leaf_118_clk_net
+ _03064_ _01254_ VSS VSS VDD VDD network.neuron_in250.counter\[1\]
+ sky130_fd_sc_hd__edfxtp_1
Xnetwork.neuron_in250.counter\[2\]$_DFFE_PP_ clknet_leaf_118_clk_net
+ _03065_ _01254_ VSS VSS VDD VDD network.neuron_in250.counter\[2\]
+ sky130_fd_sc_hd__edfxtp_1
Xnetwork.neuron_in250.counter\[3\]$_DFFE_PP_ clknet_leaf_118_clk_net
+ _03066_ _01254_ VSS VSS VDD VDD network.neuron_in250.counter\[3\]
+ sky130_fd_sc_hd__edfxtp_1
Xnetwork.neuron_in250.spike$_SDFFE_PP0P_ clknet_leaf_140_clk_net
+ _01893_ VSS VSS VDD VDD network.in_spk10_15 sky130_fd_sc_hd__dfxtp_1
Xnetwork.neuron_in251.counter\[0\]$_DFFE_PP_ clknet_leaf_139_clk_net
+ _03067_ _01253_ VSS VSS VDD VDD network.neuron_in251.counter\[0\]
+ sky130_fd_sc_hd__edfxtp_1
Xnetwork.neuron_in251.counter\[1\]$_DFFE_PP_ clknet_leaf_139_clk_net
+ _03068_ _01253_ VSS VSS VDD VDD network.neuron_in251.counter\[1\]
+ sky130_fd_sc_hd__edfxtp_1
Xnetwork.neuron_in251.counter\[2\]$_DFFE_PP_ clknet_leaf_140_clk_net
+ _03069_ _01253_ VSS VSS VDD VDD network.neuron_in251.counter\[2\]
+ sky130_fd_sc_hd__edfxtp_1
Xnetwork.neuron_in251.counter\[3\]$_DFFE_PP_ clknet_leaf_140_clk_net
+ _03070_ _01253_ VSS VSS VDD VDD network.neuron_in251.counter\[3\]
+ sky130_fd_sc_hd__edfxtp_1
Xnetwork.neuron_in251.spike$_SDFFE_PP0P_ clknet_leaf_140_clk_net
+ _01894_ VSS VSS VDD VDD network.in_spk11_15 sky130_fd_sc_hd__dfxtp_1
Xnetwork.neuron_in252.counter\[0\]$_DFFE_PP_ clknet_leaf_128_clk_net
+ _03071_ _01252_ VSS VSS VDD VDD network.neuron_in252.counter\[0\]
+ sky130_fd_sc_hd__edfxtp_1
Xnetwork.neuron_in252.counter\[1\]$_DFFE_PP_ clknet_leaf_127_clk_net
+ _03072_ _01252_ VSS VSS VDD VDD network.neuron_in252.counter\[1\]
+ sky130_fd_sc_hd__edfxtp_1
Xnetwork.neuron_in252.counter\[2\]$_DFFE_PP_ clknet_leaf_127_clk_net
+ _03073_ _01252_ VSS VSS VDD VDD network.neuron_in252.counter\[2\]
+ sky130_fd_sc_hd__edfxtp_1
Xnetwork.neuron_in252.counter\[3\]$_DFFE_PP_ clknet_leaf_118_clk_net
+ _03074_ _01252_ VSS VSS VDD VDD network.neuron_in252.counter\[3\]
+ sky130_fd_sc_hd__edfxtp_1
Xnetwork.neuron_in252.spike$_SDFFE_PP0P_ clknet_leaf_140_clk_net
+ _01896_ VSS VSS VDD VDD network.in_spk12_15 sky130_fd_sc_hd__dfxtp_1
Xnetwork.neuron_in253.counter\[0\]$_DFFE_PP_ clknet_leaf_128_clk_net
+ _03075_ _01251_ VSS VSS VDD VDD network.neuron_in253.counter\[0\]
+ sky130_fd_sc_hd__edfxtp_1
Xnetwork.neuron_in253.counter\[1\]$_DFFE_PP_ clknet_leaf_118_clk_net
+ _03076_ _01251_ VSS VSS VDD VDD network.neuron_in253.counter\[1\]
+ sky130_fd_sc_hd__edfxtp_1
Xnetwork.neuron_in253.counter\[2\]$_DFFE_PP_ clknet_leaf_128_clk_net
+ _03077_ _01251_ VSS VSS VDD VDD network.neuron_in253.counter\[2\]
+ sky130_fd_sc_hd__edfxtp_1
Xnetwork.neuron_in253.counter\[3\]$_DFFE_PP_ clknet_leaf_118_clk_net
+ _03078_ _01251_ VSS VSS VDD VDD network.neuron_in253.counter\[3\]
+ sky130_fd_sc_hd__edfxtp_1
Xnetwork.neuron_in253.spike$_SDFFE_PP0P_ clknet_leaf_140_clk_net
+ _01897_ VSS VSS VDD VDD network.in_spk13_15 sky130_fd_sc_hd__dfxtp_1
Xnetwork.neuron_in254.counter\[0\]$_DFFE_PP_ clknet_leaf_139_clk_net
+ _03079_ _01250_ VSS VSS VDD VDD network.neuron_in254.counter\[0\]
+ sky130_fd_sc_hd__edfxtp_1
Xnetwork.neuron_in254.counter\[1\]$_DFFE_PP_ clknet_leaf_139_clk_net
+ _03080_ _01250_ VSS VSS VDD VDD network.neuron_in254.counter\[1\]
+ sky130_fd_sc_hd__edfxtp_1
Xnetwork.neuron_in254.counter\[2\]$_DFFE_PP_ clknet_leaf_129_clk_net
+ _03081_ _01250_ VSS VSS VDD VDD network.neuron_in254.counter\[2\]
+ sky130_fd_sc_hd__edfxtp_1
Xnetwork.neuron_in254.counter\[3\]$_DFFE_PP_ clknet_leaf_139_clk_net
+ _03082_ _01250_ VSS VSS VDD VDD network.neuron_in254.counter\[3\]
+ sky130_fd_sc_hd__edfxtp_1
Xnetwork.neuron_in254.spike$_SDFFE_PP0P_ clknet_leaf_140_clk_net
+ _01899_ VSS VSS VDD VDD network.in_spk14_15 sky130_fd_sc_hd__dfxtp_1
Xnetwork.neuron_in255.counter\[0\]$_DFFE_PP_ clknet_leaf_138_clk_net
+ _03083_ _01249_ VSS VSS VDD VDD network.neuron_in255.counter\[0\]
+ sky130_fd_sc_hd__edfxtp_1
Xnetwork.neuron_in255.counter\[1\]$_DFFE_PP_ clknet_leaf_138_clk_net
+ _03084_ _01249_ VSS VSS VDD VDD network.neuron_in255.counter\[1\]
+ sky130_fd_sc_hd__edfxtp_1
Xnetwork.neuron_in255.counter\[2\]$_DFFE_PP_ clknet_leaf_138_clk_net
+ _03085_ _01249_ VSS VSS VDD VDD network.neuron_in255.counter\[2\]
+ sky130_fd_sc_hd__edfxtp_1
Xnetwork.neuron_in255.counter\[3\]$_DFFE_PP_ clknet_leaf_138_clk_net
+ _03086_ _01249_ VSS VSS VDD VDD network.neuron_in255.counter\[3\]
+ sky130_fd_sc_hd__edfxtp_1
Xnetwork.neuron_in255.spike$_SDFFE_PP0P_ clknet_leaf_141_clk_net
+ _01900_ VSS VSS VDD VDD network.in_spk15_15 sky130_fd_sc_hd__dfxtp_1
Xnetwork.neuron_out0.IF0.membrane_potential\[0\]$_SDFF_PP0_
+ clknet_leaf_77_clk_net _01624_ VSS VSS VDD VDD network.neuron_out0.IF0.membrane_potential\[0\]
+ sky130_fd_sc_hd__dfxtp_1
Xnetwork.neuron_out0.IF0.membrane_potential\[10\]$_SDFF_PP0_
+ clknet_leaf_75_clk_net net VSS VSS VDD VDD network.neuron_out0.IF0.membrane_potential\[10\]
+ sky130_fd_sc_hd__dfxtp_1
Xnetwork.neuron_out0.IF0.membrane_potential\[1\]$_SDFF_PP0_
+ clknet_leaf_77_clk_net _01623_ VSS VSS VDD VDD network.neuron_out0.IF0.membrane_potential\[1\]
+ sky130_fd_sc_hd__dfxtp_1
Xnetwork.neuron_out0.IF0.membrane_potential\[2\]$_SDFF_PP0_
+ clknet_leaf_77_clk_net _01622_ VSS VSS VDD VDD network.neuron_out0.IF0.membrane_potential\[2\]
+ sky130_fd_sc_hd__dfxtp_1
Xnetwork.neuron_out0.IF0.membrane_potential\[3\]$_SDFF_PP0_
+ clknet_leaf_77_clk_net _01621_ VSS VSS VDD VDD network.neuron_out0.IF0.membrane_potential\[3\]
+ sky130_fd_sc_hd__dfxtp_1
Xnetwork.neuron_out0.IF0.membrane_potential\[4\]$_SDFF_PP0_
+ clknet_leaf_75_clk_net _01620_ VSS VSS VDD VDD network.neuron_out0.IF0.membrane_potential\[4\]
+ sky130_fd_sc_hd__dfxtp_1
Xnetwork.neuron_out0.IF0.membrane_potential\[5\]$_SDFF_PP0_
+ clknet_leaf_77_clk_net _01619_ VSS VSS VDD VDD network.neuron_out0.IF0.membrane_potential\[5\]
+ sky130_fd_sc_hd__dfxtp_1
Xnetwork.neuron_out0.IF0.membrane_potential\[6\]$_SDFF_PP0_
+ clknet_leaf_75_clk_net _01618_ VSS VSS VDD VDD network.neuron_out0.IF0.membrane_potential\[6\]
+ sky130_fd_sc_hd__dfxtp_1
Xnetwork.neuron_out0.IF0.membrane_potential\[7\]$_SDFF_PP0_
+ clknet_leaf_75_clk_net _01617_ VSS VSS VDD VDD network.neuron_out0.IF0.membrane_potential\[7\]
+ sky130_fd_sc_hd__dfxtp_1
Xnetwork.neuron_out0.IF0.membrane_potential\[8\]$_SDFF_PP0_
+ clknet_leaf_75_clk_net net1 VSS VSS VDD VDD network.neuron_out0.IF0.membrane_potential\[8\]
+ sky130_fd_sc_hd__dfxtp_1
Xnetwork.neuron_out0.IF0.membrane_potential\[9\]$_SDFF_PP0_
+ clknet_leaf_75_clk_net net2 VSS VSS VDD VDD network.neuron_out0.IF0.membrane_potential\[9\]
+ sky130_fd_sc_hd__dfxtp_1
Xnetwork.neuron_out0.IF_in\[0\]$_SDFF_PP0_ clknet_leaf_76_clk_net
+ _01525_ VSS VSS VDD VDD network.neuron_out0.IF0.input_current\[0\]
+ sky130_fd_sc_hd__dfxtp_1
Xnetwork.neuron_out0.IF_in\[1\]$_SDFF_PP0_ clknet_leaf_77_clk_net
+ _01524_ VSS VSS VDD VDD network.neuron_out0.IF0.input_current\[1\]
+ sky130_fd_sc_hd__dfxtp_1
Xnetwork.neuron_out0.IF_in\[2\]$_SDFF_PP0_ clknet_leaf_76_clk_net
+ _01523_ VSS VSS VDD VDD network.neuron_out0.IF0.input_current\[2\]
+ sky130_fd_sc_hd__dfxtp_1
Xnetwork.neuron_out0.IF_in\[3\]$_SDFF_PP0_ clknet_leaf_77_clk_net
+ _01522_ VSS VSS VDD VDD network.neuron_out0.IF0.input_current\[3\]
+ sky130_fd_sc_hd__dfxtp_1
Xnetwork.neuron_out0.IF_in\[4\]$_SDFF_PP0_ clknet_leaf_77_clk_net
+ _01521_ VSS VSS VDD VDD network.neuron_out0.IF0.input_current\[4\]
+ sky130_fd_sc_hd__dfxtp_1
Xnetwork.neuron_out0.IF_in\[5\]$_SDFF_PP0_ clknet_leaf_77_clk_net
+ _01766_ VSS VSS VDD VDD network.neuron_out0.IF0.input_current\[5\]
+ sky130_fd_sc_hd__dfxtp_1
Xnetwork.neuron_out1.IF0.membrane_potential\[0\]$_SDFF_PP0_
+ clknet_leaf_87_clk_net _01616_ VSS VSS VDD VDD network.neuron_out1.IF0.membrane_potential\[0\]
+ sky130_fd_sc_hd__dfxtp_1
Xnetwork.neuron_out1.IF0.membrane_potential\[10\]$_SDFF_PP0_
+ clknet_leaf_89_clk_net net3 VSS VSS VDD VDD network.neuron_out1.IF0.membrane_potential\[10\]
+ sky130_fd_sc_hd__dfxtp_1
Xnetwork.neuron_out1.IF0.membrane_potential\[1\]$_SDFF_PP0_
+ clknet_leaf_87_clk_net _01615_ VSS VSS VDD VDD network.neuron_out1.IF0.membrane_potential\[1\]
+ sky130_fd_sc_hd__dfxtp_1
Xnetwork.neuron_out1.IF0.membrane_potential\[2\]$_SDFF_PP0_
+ clknet_leaf_87_clk_net _01614_ VSS VSS VDD VDD network.neuron_out1.IF0.membrane_potential\[2\]
+ sky130_fd_sc_hd__dfxtp_1
Xnetwork.neuron_out1.IF0.membrane_potential\[3\]$_SDFF_PP0_
+ clknet_leaf_87_clk_net _01613_ VSS VSS VDD VDD network.neuron_out1.IF0.membrane_potential\[3\]
+ sky130_fd_sc_hd__dfxtp_1
Xnetwork.neuron_out1.IF0.membrane_potential\[4\]$_SDFF_PP0_
+ clknet_leaf_88_clk_net _01612_ VSS VSS VDD VDD network.neuron_out1.IF0.membrane_potential\[4\]
+ sky130_fd_sc_hd__dfxtp_1
Xnetwork.neuron_out1.IF0.membrane_potential\[5\]$_SDFF_PP0_
+ clknet_leaf_88_clk_net _01611_ VSS VSS VDD VDD network.neuron_out1.IF0.membrane_potential\[5\]
+ sky130_fd_sc_hd__dfxtp_1
Xnetwork.neuron_out1.IF0.membrane_potential\[6\]$_SDFF_PP0_
+ clknet_leaf_89_clk_net _01610_ VSS VSS VDD VDD network.neuron_out1.IF0.membrane_potential\[6\]
+ sky130_fd_sc_hd__dfxtp_1
Xnetwork.neuron_out1.IF0.membrane_potential\[7\]$_SDFF_PP0_
+ clknet_leaf_89_clk_net _01609_ VSS VSS VDD VDD network.neuron_out1.IF0.membrane_potential\[7\]
+ sky130_fd_sc_hd__dfxtp_1
Xnetwork.neuron_out1.IF0.membrane_potential\[8\]$_SDFF_PP0_
+ clknet_leaf_89_clk_net net4 VSS VSS VDD VDD network.neuron_out1.IF0.membrane_potential\[8\]
+ sky130_fd_sc_hd__dfxtp_1
Xnetwork.neuron_out1.IF0.membrane_potential\[9\]$_SDFF_PP0_
+ clknet_leaf_89_clk_net net5 VSS VSS VDD VDD network.neuron_out1.IF0.membrane_potential\[9\]
+ sky130_fd_sc_hd__dfxtp_1
Xnetwork.neuron_out1.IF_in\[0\]$_SDFF_PP0_ clknet_leaf_87_clk_net
+ _01529_ VSS VSS VDD VDD network.neuron_out1.IF0.input_current\[0\]
+ sky130_fd_sc_hd__dfxtp_1
Xnetwork.neuron_out1.IF_in\[1\]$_SDFF_PP0_ clknet_leaf_87_clk_net
+ _01528_ VSS VSS VDD VDD network.neuron_out1.IF0.input_current\[1\]
+ sky130_fd_sc_hd__dfxtp_1
Xnetwork.neuron_out1.IF_in\[2\]$_SDFF_PP0_ clknet_leaf_85_clk_net
+ _01527_ VSS VSS VDD VDD network.neuron_out1.IF0.input_current\[2\]
+ sky130_fd_sc_hd__dfxtp_1
Xnetwork.neuron_out1.IF_in\[3\]$_SDFF_PP0_ clknet_leaf_87_clk_net
+ _01526_ VSS VSS VDD VDD network.neuron_out1.IF0.input_current\[3\]
+ sky130_fd_sc_hd__dfxtp_1
Xnetwork.neuron_out1.IF_in\[4\]$_SDFF_PP0_ clknet_leaf_88_clk_net
+ _01765_ VSS VSS VDD VDD network.neuron_out1.IF0.input_current\[4\]
+ sky130_fd_sc_hd__dfxtp_1
Xnetwork.neuron_out2.IF0.membrane_potential\[0\]$_SDFF_PP0_
+ clknet_leaf_86_clk_net _01608_ VSS VSS VDD VDD network.neuron_out2.IF0.membrane_potential\[0\]
+ sky130_fd_sc_hd__dfxtp_1
Xnetwork.neuron_out2.IF0.membrane_potential\[10\]$_SDFF_PP0_
+ clknet_leaf_87_clk_net net6 VSS VSS VDD VDD network.neuron_out2.IF0.membrane_potential\[10\]
+ sky130_fd_sc_hd__dfxtp_1
Xnetwork.neuron_out2.IF0.membrane_potential\[1\]$_SDFF_PP0_
+ clknet_leaf_86_clk_net _01607_ VSS VSS VDD VDD network.neuron_out2.IF0.membrane_potential\[1\]
+ sky130_fd_sc_hd__dfxtp_1
Xnetwork.neuron_out2.IF0.membrane_potential\[2\]$_SDFF_PP0_
+ clknet_leaf_86_clk_net _01606_ VSS VSS VDD VDD network.neuron_out2.IF0.membrane_potential\[2\]
+ sky130_fd_sc_hd__dfxtp_1
Xnetwork.neuron_out2.IF0.membrane_potential\[3\]$_SDFF_PP0_
+ clknet_leaf_86_clk_net _01605_ VSS VSS VDD VDD network.neuron_out2.IF0.membrane_potential\[3\]
+ sky130_fd_sc_hd__dfxtp_1
Xnetwork.neuron_out2.IF0.membrane_potential\[4\]$_SDFF_PP0_
+ clknet_leaf_86_clk_net _01604_ VSS VSS VDD VDD network.neuron_out2.IF0.membrane_potential\[4\]
+ sky130_fd_sc_hd__dfxtp_1
Xnetwork.neuron_out2.IF0.membrane_potential\[5\]$_SDFF_PP0_
+ clknet_leaf_86_clk_net _01603_ VSS VSS VDD VDD network.neuron_out2.IF0.membrane_potential\[5\]
+ sky130_fd_sc_hd__dfxtp_1
Xnetwork.neuron_out2.IF0.membrane_potential\[6\]$_SDFF_PP0_
+ clknet_leaf_86_clk_net _01602_ VSS VSS VDD VDD network.neuron_out2.IF0.membrane_potential\[6\]
+ sky130_fd_sc_hd__dfxtp_1
Xnetwork.neuron_out2.IF0.membrane_potential\[7\]$_SDFF_PP0_
+ clknet_leaf_86_clk_net _01601_ VSS VSS VDD VDD network.neuron_out2.IF0.membrane_potential\[7\]
+ sky130_fd_sc_hd__dfxtp_1
Xnetwork.neuron_out2.IF0.membrane_potential\[8\]$_SDFF_PP0_
+ clknet_leaf_87_clk_net net7 VSS VSS VDD VDD network.neuron_out2.IF0.membrane_potential\[8\]
+ sky130_fd_sc_hd__dfxtp_1
Xnetwork.neuron_out2.IF0.membrane_potential\[9\]$_SDFF_PP0_
+ clknet_leaf_86_clk_net net8 VSS VSS VDD VDD network.neuron_out2.IF0.membrane_potential\[9\]
+ sky130_fd_sc_hd__dfxtp_1
Xnetwork.neuron_out2.IF_in\[0\]$_SDFF_PP0_ clknet_leaf_86_clk_net
+ _01533_ VSS VSS VDD VDD network.neuron_out2.IF0.input_current\[0\]
+ sky130_fd_sc_hd__dfxtp_1
Xnetwork.neuron_out2.IF_in\[1\]$_SDFF_PP0_ clknet_leaf_86_clk_net
+ _01532_ VSS VSS VDD VDD network.neuron_out2.IF0.input_current\[1\]
+ sky130_fd_sc_hd__dfxtp_1
Xnetwork.neuron_out2.IF_in\[2\]$_SDFF_PP0_ clknet_leaf_85_clk_net
+ _01531_ VSS VSS VDD VDD network.neuron_out2.IF0.input_current\[2\]
+ sky130_fd_sc_hd__dfxtp_1
Xnetwork.neuron_out2.IF_in\[3\]$_SDFF_PP0_ clknet_leaf_85_clk_net
+ _01530_ VSS VSS VDD VDD network.neuron_out2.IF0.input_current\[3\]
+ sky130_fd_sc_hd__dfxtp_1
Xnetwork.neuron_out2.IF_in\[4\]$_SDFF_PP0_ clknet_leaf_85_clk_net
+ _01763_ VSS VSS VDD VDD network.neuron_out2.IF0.input_current\[4\]
+ sky130_fd_sc_hd__dfxtp_1
Xnetwork.neuron_out3.IF0.membrane_potential\[0\]$_SDFF_PP0_
+ clknet_leaf_80_clk_net _01600_ VSS VSS VDD VDD network.neuron_out3.IF0.membrane_potential\[0\]
+ sky130_fd_sc_hd__dfxtp_1
Xnetwork.neuron_out3.IF0.membrane_potential\[10\]$_SDFF_PP0_
+ clknet_leaf_75_clk_net net9 VSS VSS VDD VDD network.neuron_out3.IF0.membrane_potential\[10\]
+ sky130_fd_sc_hd__dfxtp_1
Xnetwork.neuron_out3.IF0.membrane_potential\[1\]$_SDFF_PP0_
+ clknet_leaf_76_clk_net _01599_ VSS VSS VDD VDD network.neuron_out3.IF0.membrane_potential\[1\]
+ sky130_fd_sc_hd__dfxtp_1
Xnetwork.neuron_out3.IF0.membrane_potential\[2\]$_SDFF_PP0_
+ clknet_leaf_80_clk_net _01598_ VSS VSS VDD VDD network.neuron_out3.IF0.membrane_potential\[2\]
+ sky130_fd_sc_hd__dfxtp_1
Xnetwork.neuron_out3.IF0.membrane_potential\[3\]$_SDFF_PP0_
+ clknet_leaf_76_clk_net _01597_ VSS VSS VDD VDD network.neuron_out3.IF0.membrane_potential\[3\]
+ sky130_fd_sc_hd__dfxtp_1
Xnetwork.neuron_out3.IF0.membrane_potential\[4\]$_SDFF_PP0_
+ clknet_leaf_76_clk_net _01596_ VSS VSS VDD VDD network.neuron_out3.IF0.membrane_potential\[4\]
+ sky130_fd_sc_hd__dfxtp_1
Xnetwork.neuron_out3.IF0.membrane_potential\[5\]$_SDFF_PP0_
+ clknet_leaf_75_clk_net _01595_ VSS VSS VDD VDD network.neuron_out3.IF0.membrane_potential\[5\]
+ sky130_fd_sc_hd__dfxtp_1
Xnetwork.neuron_out3.IF0.membrane_potential\[6\]$_SDFF_PP0_
+ clknet_leaf_75_clk_net _01594_ VSS VSS VDD VDD network.neuron_out3.IF0.membrane_potential\[6\]
+ sky130_fd_sc_hd__dfxtp_1
Xnetwork.neuron_out3.IF0.membrane_potential\[7\]$_SDFF_PP0_
+ clknet_leaf_75_clk_net _01593_ VSS VSS VDD VDD network.neuron_out3.IF0.membrane_potential\[7\]
+ sky130_fd_sc_hd__dfxtp_1
Xnetwork.neuron_out3.IF0.membrane_potential\[8\]$_SDFF_PP0_
+ clknet_leaf_75_clk_net net10 VSS VSS VDD VDD network.neuron_out3.IF0.membrane_potential\[8\]
+ sky130_fd_sc_hd__dfxtp_1
Xnetwork.neuron_out3.IF0.membrane_potential\[9\]$_SDFF_PP0_
+ clknet_leaf_75_clk_net net11 VSS VSS VDD VDD network.neuron_out3.IF0.membrane_potential\[9\]
+ sky130_fd_sc_hd__dfxtp_1
Xnetwork.neuron_out3.IF_in\[0\]$_SDFF_PP0_ clknet_leaf_80_clk_net
+ _01537_ VSS VSS VDD VDD network.neuron_out3.IF0.input_current\[0\]
+ sky130_fd_sc_hd__dfxtp_1
Xnetwork.neuron_out3.IF_in\[1\]$_SDFF_PP0_ clknet_leaf_80_clk_net
+ _01536_ VSS VSS VDD VDD network.neuron_out3.IF0.input_current\[1\]
+ sky130_fd_sc_hd__dfxtp_1
Xnetwork.neuron_out3.IF_in\[2\]$_SDFF_PP0_ clknet_leaf_80_clk_net
+ _01535_ VSS VSS VDD VDD network.neuron_out3.IF0.input_current\[2\]
+ sky130_fd_sc_hd__dfxtp_1
Xnetwork.neuron_out3.IF_in\[3\]$_SDFF_PP0_ clknet_leaf_80_clk_net
+ _01534_ VSS VSS VDD VDD network.neuron_out3.IF0.input_current\[3\]
+ sky130_fd_sc_hd__dfxtp_1
Xnetwork.neuron_out3.IF_in\[4\]$_SDFF_PP0_ clknet_leaf_76_clk_net
+ _01762_ VSS VSS VDD VDD network.neuron_out3.IF0.input_current\[4\]
+ sky130_fd_sc_hd__dfxtp_1
Xnetwork.neuron_out4.IF0.membrane_potential\[0\]$_SDFF_PP0_
+ clknet_leaf_85_clk_net _01592_ VSS VSS VDD VDD network.neuron_out4.IF0.membrane_potential\[0\]
+ sky130_fd_sc_hd__dfxtp_1
Xnetwork.neuron_out4.IF0.membrane_potential\[10\]$_SDFF_PP0_
+ clknet_leaf_88_clk_net net12 VSS VSS VDD VDD network.neuron_out4.IF0.membrane_potential\[10\]
+ sky130_fd_sc_hd__dfxtp_1
Xnetwork.neuron_out4.IF0.membrane_potential\[1\]$_SDFF_PP0_
+ clknet_leaf_85_clk_net _01591_ VSS VSS VDD VDD network.neuron_out4.IF0.membrane_potential\[1\]
+ sky130_fd_sc_hd__dfxtp_1
Xnetwork.neuron_out4.IF0.membrane_potential\[2\]$_SDFF_PP0_
+ clknet_leaf_85_clk_net _01590_ VSS VSS VDD VDD network.neuron_out4.IF0.membrane_potential\[2\]
+ sky130_fd_sc_hd__dfxtp_1
Xnetwork.neuron_out4.IF0.membrane_potential\[3\]$_SDFF_PP0_
+ clknet_leaf_85_clk_net _01589_ VSS VSS VDD VDD network.neuron_out4.IF0.membrane_potential\[3\]
+ sky130_fd_sc_hd__dfxtp_1
Xnetwork.neuron_out4.IF0.membrane_potential\[4\]$_SDFF_PP0_
+ clknet_leaf_84_clk_net _01588_ VSS VSS VDD VDD network.neuron_out4.IF0.membrane_potential\[4\]
+ sky130_fd_sc_hd__dfxtp_1
Xnetwork.neuron_out4.IF0.membrane_potential\[5\]$_SDFF_PP0_
+ clknet_leaf_84_clk_net _01587_ VSS VSS VDD VDD network.neuron_out4.IF0.membrane_potential\[5\]
+ sky130_fd_sc_hd__dfxtp_1
Xnetwork.neuron_out4.IF0.membrane_potential\[6\]$_SDFF_PP0_
+ clknet_leaf_84_clk_net _01586_ VSS VSS VDD VDD network.neuron_out4.IF0.membrane_potential\[6\]
+ sky130_fd_sc_hd__dfxtp_1
Xnetwork.neuron_out4.IF0.membrane_potential\[7\]$_SDFF_PP0_
+ clknet_leaf_87_clk_net _01585_ VSS VSS VDD VDD network.neuron_out4.IF0.membrane_potential\[7\]
+ sky130_fd_sc_hd__dfxtp_1
Xnetwork.neuron_out4.IF0.membrane_potential\[8\]$_SDFF_PP0_
+ clknet_leaf_88_clk_net net13 VSS VSS VDD VDD network.neuron_out4.IF0.membrane_potential\[8\]
+ sky130_fd_sc_hd__dfxtp_1
Xnetwork.neuron_out4.IF0.membrane_potential\[9\]$_SDFF_PP0_
+ clknet_leaf_88_clk_net net14 VSS VSS VDD VDD network.neuron_out4.IF0.membrane_potential\[9\]
+ sky130_fd_sc_hd__dfxtp_1
Xnetwork.neuron_out4.IF_in\[1\]$_SDFF_PP0_ clknet_leaf_85_clk_net
+ _01539_ VSS VSS VDD VDD network.neuron_out4.IF0.input_current\[1\]
+ sky130_fd_sc_hd__dfxtp_1
Xnetwork.neuron_out4.IF_in\[3\]$_SDFF_PP0_ clknet_leaf_85_clk_net
+ _01538_ VSS VSS VDD VDD network.neuron_out4.IF0.input_current\[0\]
+ sky130_fd_sc_hd__dfxtp_1
Xnetwork.neuron_out4.IF_in\[4\]$_SDFF_PP0_ clknet_leaf_85_clk_net
+ _01761_ VSS VSS VDD VDD network.neuron_out4.IF0.input_current\[4\]
+ sky130_fd_sc_hd__dfxtp_1
Xnetwork.neuron_out5.IF0.membrane_potential\[0\]$_SDFF_PP0_
+ clknet_leaf_78_clk_net _01584_ VSS VSS VDD VDD network.neuron_out5.IF0.membrane_potential\[0\]
+ sky130_fd_sc_hd__dfxtp_1
Xnetwork.neuron_out5.IF0.membrane_potential\[10\]$_SDFF_PP0_
+ clknet_leaf_78_clk_net net15 VSS VSS VDD VDD network.neuron_out5.IF0.membrane_potential\[10\]
+ sky130_fd_sc_hd__dfxtp_1
Xnetwork.neuron_out5.IF0.membrane_potential\[1\]$_SDFF_PP0_
+ clknet_leaf_78_clk_net _01583_ VSS VSS VDD VDD network.neuron_out5.IF0.membrane_potential\[1\]
+ sky130_fd_sc_hd__dfxtp_1
Xnetwork.neuron_out5.IF0.membrane_potential\[2\]$_SDFF_PP0_
+ clknet_leaf_78_clk_net _01582_ VSS VSS VDD VDD network.neuron_out5.IF0.membrane_potential\[2\]
+ sky130_fd_sc_hd__dfxtp_1
Xnetwork.neuron_out5.IF0.membrane_potential\[3\]$_SDFF_PP0_
+ clknet_leaf_77_clk_net _01581_ VSS VSS VDD VDD network.neuron_out5.IF0.membrane_potential\[3\]
+ sky130_fd_sc_hd__dfxtp_1
Xnetwork.neuron_out5.IF0.membrane_potential\[4\]$_SDFF_PP0_
+ clknet_leaf_77_clk_net _01580_ VSS VSS VDD VDD network.neuron_out5.IF0.membrane_potential\[4\]
+ sky130_fd_sc_hd__dfxtp_1
Xnetwork.neuron_out5.IF0.membrane_potential\[5\]$_SDFF_PP0_
+ clknet_leaf_78_clk_net _01579_ VSS VSS VDD VDD network.neuron_out5.IF0.membrane_potential\[5\]
+ sky130_fd_sc_hd__dfxtp_1
Xnetwork.neuron_out5.IF0.membrane_potential\[6\]$_SDFF_PP0_
+ clknet_leaf_78_clk_net _01578_ VSS VSS VDD VDD network.neuron_out5.IF0.membrane_potential\[6\]
+ sky130_fd_sc_hd__dfxtp_1
Xnetwork.neuron_out5.IF0.membrane_potential\[7\]$_SDFF_PP0_
+ clknet_leaf_78_clk_net _01577_ VSS VSS VDD VDD network.neuron_out5.IF0.membrane_potential\[7\]
+ sky130_fd_sc_hd__dfxtp_1
Xnetwork.neuron_out5.IF0.membrane_potential\[8\]$_SDFF_PP0_
+ clknet_leaf_78_clk_net net16 VSS VSS VDD VDD network.neuron_out5.IF0.membrane_potential\[8\]
+ sky130_fd_sc_hd__dfxtp_1
Xnetwork.neuron_out5.IF0.membrane_potential\[9\]$_SDFF_PP0_
+ clknet_leaf_78_clk_net net17 VSS VSS VDD VDD network.neuron_out5.IF0.membrane_potential\[9\]
+ sky130_fd_sc_hd__dfxtp_1
Xnetwork.neuron_out5.IF_in\[0\]$_SDFF_PP0_ clknet_leaf_78_clk_net
+ _01547_ VSS VSS VDD VDD network.neuron_out5.IF0.input_current\[0\]
+ sky130_fd_sc_hd__dfxtp_1
Xnetwork.neuron_out5.IF_in\[1\]$_SDFF_PP0_ clknet_leaf_78_clk_net
+ _01546_ VSS VSS VDD VDD network.neuron_out5.IF0.input_current\[1\]
+ sky130_fd_sc_hd__dfxtp_1
Xnetwork.neuron_out5.IF_in\[3\]$_SDFF_PP0_ clknet_leaf_79_clk_net
+ _01545_ VSS VSS VDD VDD network.neuron_out5.IF0.input_current\[3\]
+ sky130_fd_sc_hd__dfxtp_1
Xnetwork.neuron_out5.IF_in\[4\]$_SDFF_PP0_ clknet_leaf_78_clk_net
+ _01544_ VSS VSS VDD VDD network.neuron_out5.IF0.input_current\[4\]
+ sky130_fd_sc_hd__dfxtp_1
Xnetwork.neuron_out5.IF_in\[5\]$_SDFF_PP0_ clknet_leaf_79_clk_net
+ _01543_ VSS VSS VDD VDD network.neuron_out5.IF0.input_current\[5\]
+ sky130_fd_sc_hd__dfxtp_1
Xnetwork.neuron_out5.IF_in\[6\]$_SDFF_PP0_ clknet_leaf_79_clk_net
+ _01758_ VSS VSS VDD VDD network.neuron_out5.IF0.input_current\[6\]
+ sky130_fd_sc_hd__dfxtp_1
Xnetwork.out_controller.addr_out\[0\]$_SDFF_PP0_ clknet_leaf_79_clk_net
+ _01626_ VSS VSS VDD VDD network.neuron_out0.ROM0.address\[0\]
+ sky130_fd_sc_hd__dfxtp_1
Xnetwork.out_controller.addr_out\[1\]$_SDFF_PP0_ clknet_leaf_79_clk_net
+ _01625_ VSS VSS VDD VDD network.neuron_out0.ROM0.address\[1\]
+ sky130_fd_sc_hd__dfxtp_1
Xnetwork.out_controller.addr_out\[2\]$_SDFF_PP0_ clknet_leaf_79_clk_net
+ _01940_ VSS VSS VDD VDD network.neuron_out0.ROM0.address\[2\]
+ sky130_fd_sc_hd__dfxtp_1
Xnetwork.out_controller.spike_out$_SDFF_PP0_ clknet_leaf_79_clk_net
+ _01943_ VSS VSS VDD VDD network.neuron_out0.ROM0.read_en sky130_fd_sc_hd__dfxtp_1
Xno_spike$_SDFFE_PP0P_ clknet_2_3__leaf_clk_root_regs _01952_
+ VSS VSS VDD VDD net45 sky130_fd_sc_hd__dfxtp_1
Xresult_class\[0\]$_SDFFE_PP1P_ clknet_2_3__leaf_clk_root_regs
+ _01549_ VSS VSS VDD VDD net46 sky130_fd_sc_hd__dfxtp_1
Xresult_class\[1\]$_SDFFE_PP1P_ clknet_2_3__leaf_clk_root_regs
+ _01956_ VSS VSS VDD VDD net47 sky130_fd_sc_hd__dfxtp_1
Xstate\[0\]$_SDFFE_PP0P_ clknet_2_2__leaf_clk_root_regs _01573_
+ VSS VSS VDD VDD state\[0\] sky130_fd_sc_hd__dfxtp_1
Xstate\[1\]$_SDFFE_PP0P_ clknet_2_2__leaf_clk_root_regs _01951_
+ VSS VSS VDD VDD state\[1\] sky130_fd_sc_hd__dfxtp_1
Xnetwork.neuron_out0.IF0.membrane_potential\[10\]$_SDFF_PP0__1
+ VSS VSS VDD VDD _unconnected_67 net sky130_fd_sc_hd__conb_1
Xnetwork.neuron_out0.IF0.membrane_potential\[8\]$_SDFF_PP0__2
+ VSS VSS VDD VDD _unconnected_68 net1 sky130_fd_sc_hd__conb_1
Xnetwork.neuron_out0.IF0.membrane_potential\[9\]$_SDFF_PP0__3
+ VSS VSS VDD VDD _unconnected_69 net2 sky130_fd_sc_hd__conb_1
Xnetwork.neuron_out1.IF0.membrane_potential\[10\]$_SDFF_PP0__4
+ VSS VSS VDD VDD _unconnected_70 net3 sky130_fd_sc_hd__conb_1
Xnetwork.neuron_out1.IF0.membrane_potential\[8\]$_SDFF_PP0__5
+ VSS VSS VDD VDD _unconnected_71 net4 sky130_fd_sc_hd__conb_1
Xnetwork.neuron_out1.IF0.membrane_potential\[9\]$_SDFF_PP0__6
+ VSS VSS VDD VDD _unconnected_72 net5 sky130_fd_sc_hd__conb_1
Xnetwork.neuron_out2.IF0.membrane_potential\[10\]$_SDFF_PP0__7
+ VSS VSS VDD VDD _unconnected_73 net6 sky130_fd_sc_hd__conb_1
Xnetwork.neuron_out2.IF0.membrane_potential\[8\]$_SDFF_PP0__8
+ VSS VSS VDD VDD _unconnected_74 net7 sky130_fd_sc_hd__conb_1
Xnetwork.neuron_out2.IF0.membrane_potential\[9\]$_SDFF_PP0__9
+ VSS VSS VDD VDD _unconnected_75 net8 sky130_fd_sc_hd__conb_1
Xnetwork.neuron_out3.IF0.membrane_potential\[10\]$_SDFF_PP0__10
+ VSS VSS VDD VDD _unconnected_76 net9 sky130_fd_sc_hd__conb_1
Xnetwork.neuron_out3.IF0.membrane_potential\[8\]$_SDFF_PP0__11
+ VSS VSS VDD VDD _unconnected_77 net10 sky130_fd_sc_hd__conb_1
Xnetwork.neuron_out3.IF0.membrane_potential\[9\]$_SDFF_PP0__12
+ VSS VSS VDD VDD _unconnected_78 net11 sky130_fd_sc_hd__conb_1
Xnetwork.neuron_out4.IF0.membrane_potential\[10\]$_SDFF_PP0__13
+ VSS VSS VDD VDD _unconnected_79 net12 sky130_fd_sc_hd__conb_1
Xnetwork.neuron_out4.IF0.membrane_potential\[8\]$_SDFF_PP0__14
+ VSS VSS VDD VDD _unconnected_80 net13 sky130_fd_sc_hd__conb_1
Xnetwork.neuron_out4.IF0.membrane_potential\[9\]$_SDFF_PP0__15
+ VSS VSS VDD VDD _unconnected_81 net14 sky130_fd_sc_hd__conb_1
Xnetwork.neuron_out5.IF0.membrane_potential\[10\]$_SDFF_PP0__16
+ VSS VSS VDD VDD _unconnected_82 net15 sky130_fd_sc_hd__conb_1
Xnetwork.neuron_out5.IF0.membrane_potential\[8\]$_SDFF_PP0__17
+ VSS VSS VDD VDD _unconnected_83 net16 sky130_fd_sc_hd__conb_1
Xnetwork.neuron_out5.IF0.membrane_potential\[9\]$_SDFF_PP0__18
+ VSS VSS VDD VDD _unconnected_84 net17 sky130_fd_sc_hd__conb_1
XTAP_TAPCELL_ROW_0_1 VSS VDD sky130_fd_sc_hd__tapvpwrvgnd_1
XTAP_TAPCELL_ROW_0_2 VSS VDD sky130_fd_sc_hd__tapvpwrvgnd_1
XTAP_TAPCELL_ROW_0_3 VSS VDD sky130_fd_sc_hd__tapvpwrvgnd_1
XTAP_TAPCELL_ROW_0_4 VSS VDD sky130_fd_sc_hd__tapvpwrvgnd_1
XTAP_TAPCELL_ROW_0_5 VSS VDD sky130_fd_sc_hd__tapvpwrvgnd_1
XTAP_TAPCELL_ROW_0_6 VSS VDD sky130_fd_sc_hd__tapvpwrvgnd_1
XTAP_TAPCELL_ROW_0_7 VSS VDD sky130_fd_sc_hd__tapvpwrvgnd_1
XTAP_TAPCELL_ROW_0_8 VSS VDD sky130_fd_sc_hd__tapvpwrvgnd_1
XTAP_TAPCELL_ROW_0_9 VSS VDD sky130_fd_sc_hd__tapvpwrvgnd_1
XTAP_TAPCELL_ROW_0_10 VSS VDD sky130_fd_sc_hd__tapvpwrvgnd_1
XTAP_TAPCELL_ROW_0_11 VSS VDD sky130_fd_sc_hd__tapvpwrvgnd_1
XTAP_TAPCELL_ROW_0_12 VSS VDD sky130_fd_sc_hd__tapvpwrvgnd_1
XTAP_TAPCELL_ROW_0_13 VSS VDD sky130_fd_sc_hd__tapvpwrvgnd_1
XTAP_TAPCELL_ROW_0_14 VSS VDD sky130_fd_sc_hd__tapvpwrvgnd_1
XTAP_TAPCELL_ROW_0_15 VSS VDD sky130_fd_sc_hd__tapvpwrvgnd_1
XTAP_TAPCELL_ROW_0_16 VSS VDD sky130_fd_sc_hd__tapvpwrvgnd_1
XTAP_TAPCELL_ROW_0_17 VSS VDD sky130_fd_sc_hd__tapvpwrvgnd_1
XTAP_TAPCELL_ROW_0_18 VSS VDD sky130_fd_sc_hd__tapvpwrvgnd_1
XTAP_TAPCELL_ROW_0_19 VSS VDD sky130_fd_sc_hd__tapvpwrvgnd_1
XTAP_TAPCELL_ROW_0_20 VSS VDD sky130_fd_sc_hd__tapvpwrvgnd_1
XTAP_TAPCELL_ROW_0_21 VSS VDD sky130_fd_sc_hd__tapvpwrvgnd_1
XTAP_TAPCELL_ROW_0_22 VSS VDD sky130_fd_sc_hd__tapvpwrvgnd_1
XTAP_TAPCELL_ROW_0_23 VSS VDD sky130_fd_sc_hd__tapvpwrvgnd_1
XTAP_TAPCELL_ROW_0_24 VSS VDD sky130_fd_sc_hd__tapvpwrvgnd_1
XTAP_TAPCELL_ROW_0_25 VSS VDD sky130_fd_sc_hd__tapvpwrvgnd_1
XTAP_TAPCELL_ROW_0_26 VSS VDD sky130_fd_sc_hd__tapvpwrvgnd_1
XTAP_TAPCELL_ROW_0_27 VSS VDD sky130_fd_sc_hd__tapvpwrvgnd_1
XTAP_TAPCELL_ROW_0_28 VSS VDD sky130_fd_sc_hd__tapvpwrvgnd_1
XTAP_TAPCELL_ROW_0_29 VSS VDD sky130_fd_sc_hd__tapvpwrvgnd_1
XTAP_TAPCELL_ROW_0_30 VSS VDD sky130_fd_sc_hd__tapvpwrvgnd_1
XTAP_TAPCELL_ROW_0_31 VSS VDD sky130_fd_sc_hd__tapvpwrvgnd_1
XTAP_TAPCELL_ROW_0_32 VSS VDD sky130_fd_sc_hd__tapvpwrvgnd_1
XTAP_TAPCELL_ROW_0_33 VSS VDD sky130_fd_sc_hd__tapvpwrvgnd_1
XTAP_TAPCELL_ROW_1_34 VSS VDD sky130_fd_sc_hd__tapvpwrvgnd_1
XTAP_TAPCELL_ROW_1_35 VSS VDD sky130_fd_sc_hd__tapvpwrvgnd_1
XTAP_TAPCELL_ROW_1_36 VSS VDD sky130_fd_sc_hd__tapvpwrvgnd_1
XTAP_TAPCELL_ROW_1_37 VSS VDD sky130_fd_sc_hd__tapvpwrvgnd_1
XTAP_TAPCELL_ROW_1_38 VSS VDD sky130_fd_sc_hd__tapvpwrvgnd_1
XTAP_TAPCELL_ROW_1_39 VSS VDD sky130_fd_sc_hd__tapvpwrvgnd_1
XTAP_TAPCELL_ROW_1_40 VSS VDD sky130_fd_sc_hd__tapvpwrvgnd_1
XTAP_TAPCELL_ROW_1_41 VSS VDD sky130_fd_sc_hd__tapvpwrvgnd_1
XTAP_TAPCELL_ROW_1_42 VSS VDD sky130_fd_sc_hd__tapvpwrvgnd_1
XTAP_TAPCELL_ROW_1_43 VSS VDD sky130_fd_sc_hd__tapvpwrvgnd_1
XTAP_TAPCELL_ROW_1_44 VSS VDD sky130_fd_sc_hd__tapvpwrvgnd_1
XTAP_TAPCELL_ROW_1_45 VSS VDD sky130_fd_sc_hd__tapvpwrvgnd_1
XTAP_TAPCELL_ROW_1_46 VSS VDD sky130_fd_sc_hd__tapvpwrvgnd_1
XTAP_TAPCELL_ROW_1_47 VSS VDD sky130_fd_sc_hd__tapvpwrvgnd_1
XTAP_TAPCELL_ROW_1_48 VSS VDD sky130_fd_sc_hd__tapvpwrvgnd_1
XTAP_TAPCELL_ROW_1_49 VSS VDD sky130_fd_sc_hd__tapvpwrvgnd_1
XTAP_TAPCELL_ROW_1_50 VSS VDD sky130_fd_sc_hd__tapvpwrvgnd_1
XTAP_TAPCELL_ROW_2_51 VSS VDD sky130_fd_sc_hd__tapvpwrvgnd_1
XTAP_TAPCELL_ROW_2_52 VSS VDD sky130_fd_sc_hd__tapvpwrvgnd_1
XTAP_TAPCELL_ROW_2_53 VSS VDD sky130_fd_sc_hd__tapvpwrvgnd_1
XTAP_TAPCELL_ROW_2_54 VSS VDD sky130_fd_sc_hd__tapvpwrvgnd_1
XTAP_TAPCELL_ROW_2_55 VSS VDD sky130_fd_sc_hd__tapvpwrvgnd_1
XTAP_TAPCELL_ROW_2_56 VSS VDD sky130_fd_sc_hd__tapvpwrvgnd_1
XTAP_TAPCELL_ROW_2_57 VSS VDD sky130_fd_sc_hd__tapvpwrvgnd_1
XTAP_TAPCELL_ROW_2_58 VSS VDD sky130_fd_sc_hd__tapvpwrvgnd_1
XTAP_TAPCELL_ROW_2_59 VSS VDD sky130_fd_sc_hd__tapvpwrvgnd_1
XTAP_TAPCELL_ROW_2_60 VSS VDD sky130_fd_sc_hd__tapvpwrvgnd_1
XTAP_TAPCELL_ROW_2_61 VSS VDD sky130_fd_sc_hd__tapvpwrvgnd_1
XTAP_TAPCELL_ROW_2_62 VSS VDD sky130_fd_sc_hd__tapvpwrvgnd_1
XTAP_TAPCELL_ROW_2_63 VSS VDD sky130_fd_sc_hd__tapvpwrvgnd_1
XTAP_TAPCELL_ROW_2_64 VSS VDD sky130_fd_sc_hd__tapvpwrvgnd_1
XTAP_TAPCELL_ROW_2_65 VSS VDD sky130_fd_sc_hd__tapvpwrvgnd_1
XTAP_TAPCELL_ROW_2_66 VSS VDD sky130_fd_sc_hd__tapvpwrvgnd_1
XTAP_TAPCELL_ROW_2_67 VSS VDD sky130_fd_sc_hd__tapvpwrvgnd_1
XTAP_TAPCELL_ROW_3_68 VSS VDD sky130_fd_sc_hd__tapvpwrvgnd_1
XTAP_TAPCELL_ROW_3_69 VSS VDD sky130_fd_sc_hd__tapvpwrvgnd_1
XTAP_TAPCELL_ROW_3_70 VSS VDD sky130_fd_sc_hd__tapvpwrvgnd_1
XTAP_TAPCELL_ROW_3_71 VSS VDD sky130_fd_sc_hd__tapvpwrvgnd_1
XTAP_TAPCELL_ROW_3_72 VSS VDD sky130_fd_sc_hd__tapvpwrvgnd_1
XTAP_TAPCELL_ROW_3_73 VSS VDD sky130_fd_sc_hd__tapvpwrvgnd_1
XTAP_TAPCELL_ROW_3_74 VSS VDD sky130_fd_sc_hd__tapvpwrvgnd_1
XTAP_TAPCELL_ROW_3_75 VSS VDD sky130_fd_sc_hd__tapvpwrvgnd_1
XTAP_TAPCELL_ROW_3_76 VSS VDD sky130_fd_sc_hd__tapvpwrvgnd_1
XTAP_TAPCELL_ROW_3_77 VSS VDD sky130_fd_sc_hd__tapvpwrvgnd_1
XTAP_TAPCELL_ROW_3_78 VSS VDD sky130_fd_sc_hd__tapvpwrvgnd_1
XTAP_TAPCELL_ROW_3_79 VSS VDD sky130_fd_sc_hd__tapvpwrvgnd_1
XTAP_TAPCELL_ROW_3_80 VSS VDD sky130_fd_sc_hd__tapvpwrvgnd_1
XTAP_TAPCELL_ROW_3_81 VSS VDD sky130_fd_sc_hd__tapvpwrvgnd_1
XTAP_TAPCELL_ROW_3_82 VSS VDD sky130_fd_sc_hd__tapvpwrvgnd_1
XTAP_TAPCELL_ROW_3_83 VSS VDD sky130_fd_sc_hd__tapvpwrvgnd_1
XTAP_TAPCELL_ROW_3_84 VSS VDD sky130_fd_sc_hd__tapvpwrvgnd_1
XTAP_TAPCELL_ROW_4_85 VSS VDD sky130_fd_sc_hd__tapvpwrvgnd_1
XTAP_TAPCELL_ROW_4_86 VSS VDD sky130_fd_sc_hd__tapvpwrvgnd_1
XTAP_TAPCELL_ROW_4_87 VSS VDD sky130_fd_sc_hd__tapvpwrvgnd_1
XTAP_TAPCELL_ROW_4_88 VSS VDD sky130_fd_sc_hd__tapvpwrvgnd_1
XTAP_TAPCELL_ROW_4_89 VSS VDD sky130_fd_sc_hd__tapvpwrvgnd_1
XTAP_TAPCELL_ROW_4_90 VSS VDD sky130_fd_sc_hd__tapvpwrvgnd_1
XTAP_TAPCELL_ROW_4_91 VSS VDD sky130_fd_sc_hd__tapvpwrvgnd_1
XTAP_TAPCELL_ROW_4_92 VSS VDD sky130_fd_sc_hd__tapvpwrvgnd_1
XTAP_TAPCELL_ROW_4_93 VSS VDD sky130_fd_sc_hd__tapvpwrvgnd_1
XTAP_TAPCELL_ROW_4_94 VSS VDD sky130_fd_sc_hd__tapvpwrvgnd_1
XTAP_TAPCELL_ROW_4_95 VSS VDD sky130_fd_sc_hd__tapvpwrvgnd_1
XTAP_TAPCELL_ROW_4_96 VSS VDD sky130_fd_sc_hd__tapvpwrvgnd_1
XTAP_TAPCELL_ROW_4_97 VSS VDD sky130_fd_sc_hd__tapvpwrvgnd_1
XTAP_TAPCELL_ROW_4_98 VSS VDD sky130_fd_sc_hd__tapvpwrvgnd_1
XTAP_TAPCELL_ROW_4_99 VSS VDD sky130_fd_sc_hd__tapvpwrvgnd_1
XTAP_TAPCELL_ROW_4_100 VSS VDD sky130_fd_sc_hd__tapvpwrvgnd_1
XTAP_TAPCELL_ROW_4_101 VSS VDD sky130_fd_sc_hd__tapvpwrvgnd_1
XTAP_TAPCELL_ROW_5_102 VSS VDD sky130_fd_sc_hd__tapvpwrvgnd_1
XTAP_TAPCELL_ROW_5_103 VSS VDD sky130_fd_sc_hd__tapvpwrvgnd_1
XTAP_TAPCELL_ROW_5_104 VSS VDD sky130_fd_sc_hd__tapvpwrvgnd_1
XTAP_TAPCELL_ROW_5_105 VSS VDD sky130_fd_sc_hd__tapvpwrvgnd_1
XTAP_TAPCELL_ROW_5_106 VSS VDD sky130_fd_sc_hd__tapvpwrvgnd_1
XTAP_TAPCELL_ROW_5_107 VSS VDD sky130_fd_sc_hd__tapvpwrvgnd_1
XTAP_TAPCELL_ROW_5_108 VSS VDD sky130_fd_sc_hd__tapvpwrvgnd_1
XTAP_TAPCELL_ROW_5_109 VSS VDD sky130_fd_sc_hd__tapvpwrvgnd_1
XTAP_TAPCELL_ROW_5_110 VSS VDD sky130_fd_sc_hd__tapvpwrvgnd_1
XTAP_TAPCELL_ROW_5_111 VSS VDD sky130_fd_sc_hd__tapvpwrvgnd_1
XTAP_TAPCELL_ROW_5_112 VSS VDD sky130_fd_sc_hd__tapvpwrvgnd_1
XTAP_TAPCELL_ROW_5_113 VSS VDD sky130_fd_sc_hd__tapvpwrvgnd_1
XTAP_TAPCELL_ROW_5_114 VSS VDD sky130_fd_sc_hd__tapvpwrvgnd_1
XTAP_TAPCELL_ROW_5_115 VSS VDD sky130_fd_sc_hd__tapvpwrvgnd_1
XTAP_TAPCELL_ROW_5_116 VSS VDD sky130_fd_sc_hd__tapvpwrvgnd_1
XTAP_TAPCELL_ROW_5_117 VSS VDD sky130_fd_sc_hd__tapvpwrvgnd_1
XTAP_TAPCELL_ROW_5_118 VSS VDD sky130_fd_sc_hd__tapvpwrvgnd_1
XTAP_TAPCELL_ROW_6_119 VSS VDD sky130_fd_sc_hd__tapvpwrvgnd_1
XTAP_TAPCELL_ROW_6_120 VSS VDD sky130_fd_sc_hd__tapvpwrvgnd_1
XTAP_TAPCELL_ROW_6_121 VSS VDD sky130_fd_sc_hd__tapvpwrvgnd_1
XTAP_TAPCELL_ROW_6_122 VSS VDD sky130_fd_sc_hd__tapvpwrvgnd_1
XTAP_TAPCELL_ROW_6_123 VSS VDD sky130_fd_sc_hd__tapvpwrvgnd_1
XTAP_TAPCELL_ROW_6_124 VSS VDD sky130_fd_sc_hd__tapvpwrvgnd_1
XTAP_TAPCELL_ROW_6_125 VSS VDD sky130_fd_sc_hd__tapvpwrvgnd_1
XTAP_TAPCELL_ROW_6_126 VSS VDD sky130_fd_sc_hd__tapvpwrvgnd_1
XTAP_TAPCELL_ROW_6_127 VSS VDD sky130_fd_sc_hd__tapvpwrvgnd_1
XTAP_TAPCELL_ROW_6_128 VSS VDD sky130_fd_sc_hd__tapvpwrvgnd_1
XTAP_TAPCELL_ROW_6_129 VSS VDD sky130_fd_sc_hd__tapvpwrvgnd_1
XTAP_TAPCELL_ROW_6_130 VSS VDD sky130_fd_sc_hd__tapvpwrvgnd_1
XTAP_TAPCELL_ROW_6_131 VSS VDD sky130_fd_sc_hd__tapvpwrvgnd_1
XTAP_TAPCELL_ROW_6_132 VSS VDD sky130_fd_sc_hd__tapvpwrvgnd_1
XTAP_TAPCELL_ROW_6_133 VSS VDD sky130_fd_sc_hd__tapvpwrvgnd_1
XTAP_TAPCELL_ROW_6_134 VSS VDD sky130_fd_sc_hd__tapvpwrvgnd_1
XTAP_TAPCELL_ROW_6_135 VSS VDD sky130_fd_sc_hd__tapvpwrvgnd_1
XTAP_TAPCELL_ROW_7_136 VSS VDD sky130_fd_sc_hd__tapvpwrvgnd_1
XTAP_TAPCELL_ROW_7_137 VSS VDD sky130_fd_sc_hd__tapvpwrvgnd_1
XTAP_TAPCELL_ROW_7_138 VSS VDD sky130_fd_sc_hd__tapvpwrvgnd_1
XTAP_TAPCELL_ROW_7_139 VSS VDD sky130_fd_sc_hd__tapvpwrvgnd_1
XTAP_TAPCELL_ROW_7_140 VSS VDD sky130_fd_sc_hd__tapvpwrvgnd_1
XTAP_TAPCELL_ROW_7_141 VSS VDD sky130_fd_sc_hd__tapvpwrvgnd_1
XTAP_TAPCELL_ROW_7_142 VSS VDD sky130_fd_sc_hd__tapvpwrvgnd_1
XTAP_TAPCELL_ROW_7_143 VSS VDD sky130_fd_sc_hd__tapvpwrvgnd_1
XTAP_TAPCELL_ROW_7_144 VSS VDD sky130_fd_sc_hd__tapvpwrvgnd_1
XTAP_TAPCELL_ROW_7_145 VSS VDD sky130_fd_sc_hd__tapvpwrvgnd_1
XTAP_TAPCELL_ROW_7_146 VSS VDD sky130_fd_sc_hd__tapvpwrvgnd_1
XTAP_TAPCELL_ROW_7_147 VSS VDD sky130_fd_sc_hd__tapvpwrvgnd_1
XTAP_TAPCELL_ROW_7_148 VSS VDD sky130_fd_sc_hd__tapvpwrvgnd_1
XTAP_TAPCELL_ROW_7_149 VSS VDD sky130_fd_sc_hd__tapvpwrvgnd_1
XTAP_TAPCELL_ROW_7_150 VSS VDD sky130_fd_sc_hd__tapvpwrvgnd_1
XTAP_TAPCELL_ROW_7_151 VSS VDD sky130_fd_sc_hd__tapvpwrvgnd_1
XTAP_TAPCELL_ROW_7_152 VSS VDD sky130_fd_sc_hd__tapvpwrvgnd_1
XTAP_TAPCELL_ROW_8_153 VSS VDD sky130_fd_sc_hd__tapvpwrvgnd_1
XTAP_TAPCELL_ROW_8_154 VSS VDD sky130_fd_sc_hd__tapvpwrvgnd_1
XTAP_TAPCELL_ROW_8_155 VSS VDD sky130_fd_sc_hd__tapvpwrvgnd_1
XTAP_TAPCELL_ROW_8_156 VSS VDD sky130_fd_sc_hd__tapvpwrvgnd_1
XTAP_TAPCELL_ROW_8_157 VSS VDD sky130_fd_sc_hd__tapvpwrvgnd_1
XTAP_TAPCELL_ROW_8_158 VSS VDD sky130_fd_sc_hd__tapvpwrvgnd_1
XTAP_TAPCELL_ROW_8_159 VSS VDD sky130_fd_sc_hd__tapvpwrvgnd_1
XTAP_TAPCELL_ROW_8_160 VSS VDD sky130_fd_sc_hd__tapvpwrvgnd_1
XTAP_TAPCELL_ROW_8_161 VSS VDD sky130_fd_sc_hd__tapvpwrvgnd_1
XTAP_TAPCELL_ROW_8_162 VSS VDD sky130_fd_sc_hd__tapvpwrvgnd_1
XTAP_TAPCELL_ROW_8_163 VSS VDD sky130_fd_sc_hd__tapvpwrvgnd_1
XTAP_TAPCELL_ROW_8_164 VSS VDD sky130_fd_sc_hd__tapvpwrvgnd_1
XTAP_TAPCELL_ROW_8_165 VSS VDD sky130_fd_sc_hd__tapvpwrvgnd_1
XTAP_TAPCELL_ROW_8_166 VSS VDD sky130_fd_sc_hd__tapvpwrvgnd_1
XTAP_TAPCELL_ROW_8_167 VSS VDD sky130_fd_sc_hd__tapvpwrvgnd_1
XTAP_TAPCELL_ROW_8_168 VSS VDD sky130_fd_sc_hd__tapvpwrvgnd_1
XTAP_TAPCELL_ROW_8_169 VSS VDD sky130_fd_sc_hd__tapvpwrvgnd_1
XTAP_TAPCELL_ROW_9_170 VSS VDD sky130_fd_sc_hd__tapvpwrvgnd_1
XTAP_TAPCELL_ROW_9_171 VSS VDD sky130_fd_sc_hd__tapvpwrvgnd_1
XTAP_TAPCELL_ROW_9_172 VSS VDD sky130_fd_sc_hd__tapvpwrvgnd_1
XTAP_TAPCELL_ROW_9_173 VSS VDD sky130_fd_sc_hd__tapvpwrvgnd_1
XTAP_TAPCELL_ROW_9_174 VSS VDD sky130_fd_sc_hd__tapvpwrvgnd_1
XTAP_TAPCELL_ROW_9_175 VSS VDD sky130_fd_sc_hd__tapvpwrvgnd_1
XTAP_TAPCELL_ROW_9_176 VSS VDD sky130_fd_sc_hd__tapvpwrvgnd_1
XTAP_TAPCELL_ROW_9_177 VSS VDD sky130_fd_sc_hd__tapvpwrvgnd_1
XTAP_TAPCELL_ROW_9_178 VSS VDD sky130_fd_sc_hd__tapvpwrvgnd_1
XTAP_TAPCELL_ROW_9_179 VSS VDD sky130_fd_sc_hd__tapvpwrvgnd_1
XTAP_TAPCELL_ROW_9_180 VSS VDD sky130_fd_sc_hd__tapvpwrvgnd_1
XTAP_TAPCELL_ROW_9_181 VSS VDD sky130_fd_sc_hd__tapvpwrvgnd_1
XTAP_TAPCELL_ROW_9_182 VSS VDD sky130_fd_sc_hd__tapvpwrvgnd_1
XTAP_TAPCELL_ROW_9_183 VSS VDD sky130_fd_sc_hd__tapvpwrvgnd_1
XTAP_TAPCELL_ROW_9_184 VSS VDD sky130_fd_sc_hd__tapvpwrvgnd_1
XTAP_TAPCELL_ROW_9_185 VSS VDD sky130_fd_sc_hd__tapvpwrvgnd_1
XTAP_TAPCELL_ROW_9_186 VSS VDD sky130_fd_sc_hd__tapvpwrvgnd_1
XTAP_TAPCELL_ROW_10_187 VSS VDD sky130_fd_sc_hd__tapvpwrvgnd_1
XTAP_TAPCELL_ROW_10_188 VSS VDD sky130_fd_sc_hd__tapvpwrvgnd_1
XTAP_TAPCELL_ROW_10_189 VSS VDD sky130_fd_sc_hd__tapvpwrvgnd_1
XTAP_TAPCELL_ROW_10_190 VSS VDD sky130_fd_sc_hd__tapvpwrvgnd_1
XTAP_TAPCELL_ROW_10_191 VSS VDD sky130_fd_sc_hd__tapvpwrvgnd_1
XTAP_TAPCELL_ROW_10_192 VSS VDD sky130_fd_sc_hd__tapvpwrvgnd_1
XTAP_TAPCELL_ROW_10_193 VSS VDD sky130_fd_sc_hd__tapvpwrvgnd_1
XTAP_TAPCELL_ROW_10_194 VSS VDD sky130_fd_sc_hd__tapvpwrvgnd_1
XTAP_TAPCELL_ROW_10_195 VSS VDD sky130_fd_sc_hd__tapvpwrvgnd_1
XTAP_TAPCELL_ROW_10_196 VSS VDD sky130_fd_sc_hd__tapvpwrvgnd_1
XTAP_TAPCELL_ROW_10_197 VSS VDD sky130_fd_sc_hd__tapvpwrvgnd_1
XTAP_TAPCELL_ROW_10_198 VSS VDD sky130_fd_sc_hd__tapvpwrvgnd_1
XTAP_TAPCELL_ROW_10_199 VSS VDD sky130_fd_sc_hd__tapvpwrvgnd_1
XTAP_TAPCELL_ROW_10_200 VSS VDD sky130_fd_sc_hd__tapvpwrvgnd_1
XTAP_TAPCELL_ROW_10_201 VSS VDD sky130_fd_sc_hd__tapvpwrvgnd_1
XTAP_TAPCELL_ROW_10_202 VSS VDD sky130_fd_sc_hd__tapvpwrvgnd_1
XTAP_TAPCELL_ROW_10_203 VSS VDD sky130_fd_sc_hd__tapvpwrvgnd_1
XTAP_TAPCELL_ROW_11_204 VSS VDD sky130_fd_sc_hd__tapvpwrvgnd_1
XTAP_TAPCELL_ROW_11_205 VSS VDD sky130_fd_sc_hd__tapvpwrvgnd_1
XTAP_TAPCELL_ROW_11_206 VSS VDD sky130_fd_sc_hd__tapvpwrvgnd_1
XTAP_TAPCELL_ROW_11_207 VSS VDD sky130_fd_sc_hd__tapvpwrvgnd_1
XTAP_TAPCELL_ROW_11_208 VSS VDD sky130_fd_sc_hd__tapvpwrvgnd_1
XTAP_TAPCELL_ROW_11_209 VSS VDD sky130_fd_sc_hd__tapvpwrvgnd_1
XTAP_TAPCELL_ROW_11_210 VSS VDD sky130_fd_sc_hd__tapvpwrvgnd_1
XTAP_TAPCELL_ROW_11_211 VSS VDD sky130_fd_sc_hd__tapvpwrvgnd_1
XTAP_TAPCELL_ROW_11_212 VSS VDD sky130_fd_sc_hd__tapvpwrvgnd_1
XTAP_TAPCELL_ROW_11_213 VSS VDD sky130_fd_sc_hd__tapvpwrvgnd_1
XTAP_TAPCELL_ROW_11_214 VSS VDD sky130_fd_sc_hd__tapvpwrvgnd_1
XTAP_TAPCELL_ROW_11_215 VSS VDD sky130_fd_sc_hd__tapvpwrvgnd_1
XTAP_TAPCELL_ROW_11_216 VSS VDD sky130_fd_sc_hd__tapvpwrvgnd_1
XTAP_TAPCELL_ROW_11_217 VSS VDD sky130_fd_sc_hd__tapvpwrvgnd_1
XTAP_TAPCELL_ROW_11_218 VSS VDD sky130_fd_sc_hd__tapvpwrvgnd_1
XTAP_TAPCELL_ROW_11_219 VSS VDD sky130_fd_sc_hd__tapvpwrvgnd_1
XTAP_TAPCELL_ROW_11_220 VSS VDD sky130_fd_sc_hd__tapvpwrvgnd_1
XTAP_TAPCELL_ROW_12_221 VSS VDD sky130_fd_sc_hd__tapvpwrvgnd_1
XTAP_TAPCELL_ROW_12_222 VSS VDD sky130_fd_sc_hd__tapvpwrvgnd_1
XTAP_TAPCELL_ROW_12_223 VSS VDD sky130_fd_sc_hd__tapvpwrvgnd_1
XTAP_TAPCELL_ROW_12_224 VSS VDD sky130_fd_sc_hd__tapvpwrvgnd_1
XTAP_TAPCELL_ROW_12_225 VSS VDD sky130_fd_sc_hd__tapvpwrvgnd_1
XTAP_TAPCELL_ROW_12_226 VSS VDD sky130_fd_sc_hd__tapvpwrvgnd_1
XTAP_TAPCELL_ROW_12_227 VSS VDD sky130_fd_sc_hd__tapvpwrvgnd_1
XTAP_TAPCELL_ROW_12_228 VSS VDD sky130_fd_sc_hd__tapvpwrvgnd_1
XTAP_TAPCELL_ROW_12_229 VSS VDD sky130_fd_sc_hd__tapvpwrvgnd_1
XTAP_TAPCELL_ROW_12_230 VSS VDD sky130_fd_sc_hd__tapvpwrvgnd_1
XTAP_TAPCELL_ROW_12_231 VSS VDD sky130_fd_sc_hd__tapvpwrvgnd_1
XTAP_TAPCELL_ROW_12_232 VSS VDD sky130_fd_sc_hd__tapvpwrvgnd_1
XTAP_TAPCELL_ROW_12_233 VSS VDD sky130_fd_sc_hd__tapvpwrvgnd_1
XTAP_TAPCELL_ROW_12_234 VSS VDD sky130_fd_sc_hd__tapvpwrvgnd_1
XTAP_TAPCELL_ROW_12_235 VSS VDD sky130_fd_sc_hd__tapvpwrvgnd_1
XTAP_TAPCELL_ROW_12_236 VSS VDD sky130_fd_sc_hd__tapvpwrvgnd_1
XTAP_TAPCELL_ROW_12_237 VSS VDD sky130_fd_sc_hd__tapvpwrvgnd_1
XTAP_TAPCELL_ROW_13_238 VSS VDD sky130_fd_sc_hd__tapvpwrvgnd_1
XTAP_TAPCELL_ROW_13_239 VSS VDD sky130_fd_sc_hd__tapvpwrvgnd_1
XTAP_TAPCELL_ROW_13_240 VSS VDD sky130_fd_sc_hd__tapvpwrvgnd_1
XTAP_TAPCELL_ROW_13_241 VSS VDD sky130_fd_sc_hd__tapvpwrvgnd_1
XTAP_TAPCELL_ROW_13_242 VSS VDD sky130_fd_sc_hd__tapvpwrvgnd_1
XTAP_TAPCELL_ROW_13_243 VSS VDD sky130_fd_sc_hd__tapvpwrvgnd_1
XTAP_TAPCELL_ROW_13_244 VSS VDD sky130_fd_sc_hd__tapvpwrvgnd_1
XTAP_TAPCELL_ROW_13_245 VSS VDD sky130_fd_sc_hd__tapvpwrvgnd_1
XTAP_TAPCELL_ROW_13_246 VSS VDD sky130_fd_sc_hd__tapvpwrvgnd_1
XTAP_TAPCELL_ROW_13_247 VSS VDD sky130_fd_sc_hd__tapvpwrvgnd_1
XTAP_TAPCELL_ROW_13_248 VSS VDD sky130_fd_sc_hd__tapvpwrvgnd_1
XTAP_TAPCELL_ROW_13_249 VSS VDD sky130_fd_sc_hd__tapvpwrvgnd_1
XTAP_TAPCELL_ROW_13_250 VSS VDD sky130_fd_sc_hd__tapvpwrvgnd_1
XTAP_TAPCELL_ROW_13_251 VSS VDD sky130_fd_sc_hd__tapvpwrvgnd_1
XTAP_TAPCELL_ROW_13_252 VSS VDD sky130_fd_sc_hd__tapvpwrvgnd_1
XTAP_TAPCELL_ROW_13_253 VSS VDD sky130_fd_sc_hd__tapvpwrvgnd_1
XTAP_TAPCELL_ROW_13_254 VSS VDD sky130_fd_sc_hd__tapvpwrvgnd_1
XTAP_TAPCELL_ROW_14_255 VSS VDD sky130_fd_sc_hd__tapvpwrvgnd_1
XTAP_TAPCELL_ROW_14_256 VSS VDD sky130_fd_sc_hd__tapvpwrvgnd_1
XTAP_TAPCELL_ROW_14_257 VSS VDD sky130_fd_sc_hd__tapvpwrvgnd_1
XTAP_TAPCELL_ROW_14_258 VSS VDD sky130_fd_sc_hd__tapvpwrvgnd_1
XTAP_TAPCELL_ROW_14_259 VSS VDD sky130_fd_sc_hd__tapvpwrvgnd_1
XTAP_TAPCELL_ROW_14_260 VSS VDD sky130_fd_sc_hd__tapvpwrvgnd_1
XTAP_TAPCELL_ROW_14_261 VSS VDD sky130_fd_sc_hd__tapvpwrvgnd_1
XTAP_TAPCELL_ROW_14_262 VSS VDD sky130_fd_sc_hd__tapvpwrvgnd_1
XTAP_TAPCELL_ROW_14_263 VSS VDD sky130_fd_sc_hd__tapvpwrvgnd_1
XTAP_TAPCELL_ROW_14_264 VSS VDD sky130_fd_sc_hd__tapvpwrvgnd_1
XTAP_TAPCELL_ROW_14_265 VSS VDD sky130_fd_sc_hd__tapvpwrvgnd_1
XTAP_TAPCELL_ROW_14_266 VSS VDD sky130_fd_sc_hd__tapvpwrvgnd_1
XTAP_TAPCELL_ROW_14_267 VSS VDD sky130_fd_sc_hd__tapvpwrvgnd_1
XTAP_TAPCELL_ROW_14_268 VSS VDD sky130_fd_sc_hd__tapvpwrvgnd_1
XTAP_TAPCELL_ROW_14_269 VSS VDD sky130_fd_sc_hd__tapvpwrvgnd_1
XTAP_TAPCELL_ROW_14_270 VSS VDD sky130_fd_sc_hd__tapvpwrvgnd_1
XTAP_TAPCELL_ROW_14_271 VSS VDD sky130_fd_sc_hd__tapvpwrvgnd_1
XTAP_TAPCELL_ROW_15_272 VSS VDD sky130_fd_sc_hd__tapvpwrvgnd_1
XTAP_TAPCELL_ROW_15_273 VSS VDD sky130_fd_sc_hd__tapvpwrvgnd_1
XTAP_TAPCELL_ROW_15_274 VSS VDD sky130_fd_sc_hd__tapvpwrvgnd_1
XTAP_TAPCELL_ROW_15_275 VSS VDD sky130_fd_sc_hd__tapvpwrvgnd_1
XTAP_TAPCELL_ROW_15_276 VSS VDD sky130_fd_sc_hd__tapvpwrvgnd_1
XTAP_TAPCELL_ROW_15_277 VSS VDD sky130_fd_sc_hd__tapvpwrvgnd_1
XTAP_TAPCELL_ROW_15_278 VSS VDD sky130_fd_sc_hd__tapvpwrvgnd_1
XTAP_TAPCELL_ROW_15_279 VSS VDD sky130_fd_sc_hd__tapvpwrvgnd_1
XTAP_TAPCELL_ROW_15_280 VSS VDD sky130_fd_sc_hd__tapvpwrvgnd_1
XTAP_TAPCELL_ROW_15_281 VSS VDD sky130_fd_sc_hd__tapvpwrvgnd_1
XTAP_TAPCELL_ROW_15_282 VSS VDD sky130_fd_sc_hd__tapvpwrvgnd_1
XTAP_TAPCELL_ROW_15_283 VSS VDD sky130_fd_sc_hd__tapvpwrvgnd_1
XTAP_TAPCELL_ROW_15_284 VSS VDD sky130_fd_sc_hd__tapvpwrvgnd_1
XTAP_TAPCELL_ROW_15_285 VSS VDD sky130_fd_sc_hd__tapvpwrvgnd_1
XTAP_TAPCELL_ROW_15_286 VSS VDD sky130_fd_sc_hd__tapvpwrvgnd_1
XTAP_TAPCELL_ROW_15_287 VSS VDD sky130_fd_sc_hd__tapvpwrvgnd_1
XTAP_TAPCELL_ROW_15_288 VSS VDD sky130_fd_sc_hd__tapvpwrvgnd_1
XTAP_TAPCELL_ROW_16_289 VSS VDD sky130_fd_sc_hd__tapvpwrvgnd_1
XTAP_TAPCELL_ROW_16_290 VSS VDD sky130_fd_sc_hd__tapvpwrvgnd_1
XTAP_TAPCELL_ROW_16_291 VSS VDD sky130_fd_sc_hd__tapvpwrvgnd_1
XTAP_TAPCELL_ROW_16_292 VSS VDD sky130_fd_sc_hd__tapvpwrvgnd_1
XTAP_TAPCELL_ROW_16_293 VSS VDD sky130_fd_sc_hd__tapvpwrvgnd_1
XTAP_TAPCELL_ROW_16_294 VSS VDD sky130_fd_sc_hd__tapvpwrvgnd_1
XTAP_TAPCELL_ROW_16_295 VSS VDD sky130_fd_sc_hd__tapvpwrvgnd_1
XTAP_TAPCELL_ROW_16_296 VSS VDD sky130_fd_sc_hd__tapvpwrvgnd_1
XTAP_TAPCELL_ROW_16_297 VSS VDD sky130_fd_sc_hd__tapvpwrvgnd_1
XTAP_TAPCELL_ROW_16_298 VSS VDD sky130_fd_sc_hd__tapvpwrvgnd_1
XTAP_TAPCELL_ROW_16_299 VSS VDD sky130_fd_sc_hd__tapvpwrvgnd_1
XTAP_TAPCELL_ROW_16_300 VSS VDD sky130_fd_sc_hd__tapvpwrvgnd_1
XTAP_TAPCELL_ROW_16_301 VSS VDD sky130_fd_sc_hd__tapvpwrvgnd_1
XTAP_TAPCELL_ROW_16_302 VSS VDD sky130_fd_sc_hd__tapvpwrvgnd_1
XTAP_TAPCELL_ROW_16_303 VSS VDD sky130_fd_sc_hd__tapvpwrvgnd_1
XTAP_TAPCELL_ROW_16_304 VSS VDD sky130_fd_sc_hd__tapvpwrvgnd_1
XTAP_TAPCELL_ROW_16_305 VSS VDD sky130_fd_sc_hd__tapvpwrvgnd_1
XTAP_TAPCELL_ROW_17_306 VSS VDD sky130_fd_sc_hd__tapvpwrvgnd_1
XTAP_TAPCELL_ROW_17_307 VSS VDD sky130_fd_sc_hd__tapvpwrvgnd_1
XTAP_TAPCELL_ROW_17_308 VSS VDD sky130_fd_sc_hd__tapvpwrvgnd_1
XTAP_TAPCELL_ROW_17_309 VSS VDD sky130_fd_sc_hd__tapvpwrvgnd_1
XTAP_TAPCELL_ROW_17_310 VSS VDD sky130_fd_sc_hd__tapvpwrvgnd_1
XTAP_TAPCELL_ROW_17_311 VSS VDD sky130_fd_sc_hd__tapvpwrvgnd_1
XTAP_TAPCELL_ROW_17_312 VSS VDD sky130_fd_sc_hd__tapvpwrvgnd_1
XTAP_TAPCELL_ROW_17_313 VSS VDD sky130_fd_sc_hd__tapvpwrvgnd_1
XTAP_TAPCELL_ROW_17_314 VSS VDD sky130_fd_sc_hd__tapvpwrvgnd_1
XTAP_TAPCELL_ROW_17_315 VSS VDD sky130_fd_sc_hd__tapvpwrvgnd_1
XTAP_TAPCELL_ROW_17_316 VSS VDD sky130_fd_sc_hd__tapvpwrvgnd_1
XTAP_TAPCELL_ROW_17_317 VSS VDD sky130_fd_sc_hd__tapvpwrvgnd_1
XTAP_TAPCELL_ROW_17_318 VSS VDD sky130_fd_sc_hd__tapvpwrvgnd_1
XTAP_TAPCELL_ROW_17_319 VSS VDD sky130_fd_sc_hd__tapvpwrvgnd_1
XTAP_TAPCELL_ROW_17_320 VSS VDD sky130_fd_sc_hd__tapvpwrvgnd_1
XTAP_TAPCELL_ROW_17_321 VSS VDD sky130_fd_sc_hd__tapvpwrvgnd_1
XTAP_TAPCELL_ROW_17_322 VSS VDD sky130_fd_sc_hd__tapvpwrvgnd_1
XTAP_TAPCELL_ROW_18_323 VSS VDD sky130_fd_sc_hd__tapvpwrvgnd_1
XTAP_TAPCELL_ROW_18_324 VSS VDD sky130_fd_sc_hd__tapvpwrvgnd_1
XTAP_TAPCELL_ROW_18_325 VSS VDD sky130_fd_sc_hd__tapvpwrvgnd_1
XTAP_TAPCELL_ROW_18_326 VSS VDD sky130_fd_sc_hd__tapvpwrvgnd_1
XTAP_TAPCELL_ROW_18_327 VSS VDD sky130_fd_sc_hd__tapvpwrvgnd_1
XTAP_TAPCELL_ROW_18_328 VSS VDD sky130_fd_sc_hd__tapvpwrvgnd_1
XTAP_TAPCELL_ROW_18_329 VSS VDD sky130_fd_sc_hd__tapvpwrvgnd_1
XTAP_TAPCELL_ROW_18_330 VSS VDD sky130_fd_sc_hd__tapvpwrvgnd_1
XTAP_TAPCELL_ROW_18_331 VSS VDD sky130_fd_sc_hd__tapvpwrvgnd_1
XTAP_TAPCELL_ROW_18_332 VSS VDD sky130_fd_sc_hd__tapvpwrvgnd_1
XTAP_TAPCELL_ROW_18_333 VSS VDD sky130_fd_sc_hd__tapvpwrvgnd_1
XTAP_TAPCELL_ROW_18_334 VSS VDD sky130_fd_sc_hd__tapvpwrvgnd_1
XTAP_TAPCELL_ROW_18_335 VSS VDD sky130_fd_sc_hd__tapvpwrvgnd_1
XTAP_TAPCELL_ROW_18_336 VSS VDD sky130_fd_sc_hd__tapvpwrvgnd_1
XTAP_TAPCELL_ROW_18_337 VSS VDD sky130_fd_sc_hd__tapvpwrvgnd_1
XTAP_TAPCELL_ROW_18_338 VSS VDD sky130_fd_sc_hd__tapvpwrvgnd_1
XTAP_TAPCELL_ROW_18_339 VSS VDD sky130_fd_sc_hd__tapvpwrvgnd_1
XTAP_TAPCELL_ROW_19_340 VSS VDD sky130_fd_sc_hd__tapvpwrvgnd_1
XTAP_TAPCELL_ROW_19_341 VSS VDD sky130_fd_sc_hd__tapvpwrvgnd_1
XTAP_TAPCELL_ROW_19_342 VSS VDD sky130_fd_sc_hd__tapvpwrvgnd_1
XTAP_TAPCELL_ROW_19_343 VSS VDD sky130_fd_sc_hd__tapvpwrvgnd_1
XTAP_TAPCELL_ROW_19_344 VSS VDD sky130_fd_sc_hd__tapvpwrvgnd_1
XTAP_TAPCELL_ROW_19_345 VSS VDD sky130_fd_sc_hd__tapvpwrvgnd_1
XTAP_TAPCELL_ROW_19_346 VSS VDD sky130_fd_sc_hd__tapvpwrvgnd_1
XTAP_TAPCELL_ROW_19_347 VSS VDD sky130_fd_sc_hd__tapvpwrvgnd_1
XTAP_TAPCELL_ROW_19_348 VSS VDD sky130_fd_sc_hd__tapvpwrvgnd_1
XTAP_TAPCELL_ROW_19_349 VSS VDD sky130_fd_sc_hd__tapvpwrvgnd_1
XTAP_TAPCELL_ROW_19_350 VSS VDD sky130_fd_sc_hd__tapvpwrvgnd_1
XTAP_TAPCELL_ROW_19_351 VSS VDD sky130_fd_sc_hd__tapvpwrvgnd_1
XTAP_TAPCELL_ROW_19_352 VSS VDD sky130_fd_sc_hd__tapvpwrvgnd_1
XTAP_TAPCELL_ROW_19_353 VSS VDD sky130_fd_sc_hd__tapvpwrvgnd_1
XTAP_TAPCELL_ROW_19_354 VSS VDD sky130_fd_sc_hd__tapvpwrvgnd_1
XTAP_TAPCELL_ROW_19_355 VSS VDD sky130_fd_sc_hd__tapvpwrvgnd_1
XTAP_TAPCELL_ROW_19_356 VSS VDD sky130_fd_sc_hd__tapvpwrvgnd_1
XTAP_TAPCELL_ROW_20_357 VSS VDD sky130_fd_sc_hd__tapvpwrvgnd_1
XTAP_TAPCELL_ROW_20_358 VSS VDD sky130_fd_sc_hd__tapvpwrvgnd_1
XTAP_TAPCELL_ROW_20_359 VSS VDD sky130_fd_sc_hd__tapvpwrvgnd_1
XTAP_TAPCELL_ROW_20_360 VSS VDD sky130_fd_sc_hd__tapvpwrvgnd_1
XTAP_TAPCELL_ROW_20_361 VSS VDD sky130_fd_sc_hd__tapvpwrvgnd_1
XTAP_TAPCELL_ROW_20_362 VSS VDD sky130_fd_sc_hd__tapvpwrvgnd_1
XTAP_TAPCELL_ROW_20_363 VSS VDD sky130_fd_sc_hd__tapvpwrvgnd_1
XTAP_TAPCELL_ROW_20_364 VSS VDD sky130_fd_sc_hd__tapvpwrvgnd_1
XTAP_TAPCELL_ROW_20_365 VSS VDD sky130_fd_sc_hd__tapvpwrvgnd_1
XTAP_TAPCELL_ROW_20_366 VSS VDD sky130_fd_sc_hd__tapvpwrvgnd_1
XTAP_TAPCELL_ROW_20_367 VSS VDD sky130_fd_sc_hd__tapvpwrvgnd_1
XTAP_TAPCELL_ROW_20_368 VSS VDD sky130_fd_sc_hd__tapvpwrvgnd_1
XTAP_TAPCELL_ROW_20_369 VSS VDD sky130_fd_sc_hd__tapvpwrvgnd_1
XTAP_TAPCELL_ROW_20_370 VSS VDD sky130_fd_sc_hd__tapvpwrvgnd_1
XTAP_TAPCELL_ROW_20_371 VSS VDD sky130_fd_sc_hd__tapvpwrvgnd_1
XTAP_TAPCELL_ROW_20_372 VSS VDD sky130_fd_sc_hd__tapvpwrvgnd_1
XTAP_TAPCELL_ROW_20_373 VSS VDD sky130_fd_sc_hd__tapvpwrvgnd_1
XTAP_TAPCELL_ROW_21_374 VSS VDD sky130_fd_sc_hd__tapvpwrvgnd_1
XTAP_TAPCELL_ROW_21_375 VSS VDD sky130_fd_sc_hd__tapvpwrvgnd_1
XTAP_TAPCELL_ROW_21_376 VSS VDD sky130_fd_sc_hd__tapvpwrvgnd_1
XTAP_TAPCELL_ROW_21_377 VSS VDD sky130_fd_sc_hd__tapvpwrvgnd_1
XTAP_TAPCELL_ROW_21_378 VSS VDD sky130_fd_sc_hd__tapvpwrvgnd_1
XTAP_TAPCELL_ROW_21_379 VSS VDD sky130_fd_sc_hd__tapvpwrvgnd_1
XTAP_TAPCELL_ROW_21_380 VSS VDD sky130_fd_sc_hd__tapvpwrvgnd_1
XTAP_TAPCELL_ROW_21_381 VSS VDD sky130_fd_sc_hd__tapvpwrvgnd_1
XTAP_TAPCELL_ROW_21_382 VSS VDD sky130_fd_sc_hd__tapvpwrvgnd_1
XTAP_TAPCELL_ROW_21_383 VSS VDD sky130_fd_sc_hd__tapvpwrvgnd_1
XTAP_TAPCELL_ROW_21_384 VSS VDD sky130_fd_sc_hd__tapvpwrvgnd_1
XTAP_TAPCELL_ROW_21_385 VSS VDD sky130_fd_sc_hd__tapvpwrvgnd_1
XTAP_TAPCELL_ROW_21_386 VSS VDD sky130_fd_sc_hd__tapvpwrvgnd_1
XTAP_TAPCELL_ROW_21_387 VSS VDD sky130_fd_sc_hd__tapvpwrvgnd_1
XTAP_TAPCELL_ROW_21_388 VSS VDD sky130_fd_sc_hd__tapvpwrvgnd_1
XTAP_TAPCELL_ROW_21_389 VSS VDD sky130_fd_sc_hd__tapvpwrvgnd_1
XTAP_TAPCELL_ROW_21_390 VSS VDD sky130_fd_sc_hd__tapvpwrvgnd_1
XTAP_TAPCELL_ROW_22_391 VSS VDD sky130_fd_sc_hd__tapvpwrvgnd_1
XTAP_TAPCELL_ROW_22_392 VSS VDD sky130_fd_sc_hd__tapvpwrvgnd_1
XTAP_TAPCELL_ROW_22_393 VSS VDD sky130_fd_sc_hd__tapvpwrvgnd_1
XTAP_TAPCELL_ROW_22_394 VSS VDD sky130_fd_sc_hd__tapvpwrvgnd_1
XTAP_TAPCELL_ROW_22_395 VSS VDD sky130_fd_sc_hd__tapvpwrvgnd_1
XTAP_TAPCELL_ROW_22_396 VSS VDD sky130_fd_sc_hd__tapvpwrvgnd_1
XTAP_TAPCELL_ROW_22_397 VSS VDD sky130_fd_sc_hd__tapvpwrvgnd_1
XTAP_TAPCELL_ROW_22_398 VSS VDD sky130_fd_sc_hd__tapvpwrvgnd_1
XTAP_TAPCELL_ROW_22_399 VSS VDD sky130_fd_sc_hd__tapvpwrvgnd_1
XTAP_TAPCELL_ROW_22_400 VSS VDD sky130_fd_sc_hd__tapvpwrvgnd_1
XTAP_TAPCELL_ROW_22_401 VSS VDD sky130_fd_sc_hd__tapvpwrvgnd_1
XTAP_TAPCELL_ROW_22_402 VSS VDD sky130_fd_sc_hd__tapvpwrvgnd_1
XTAP_TAPCELL_ROW_22_403 VSS VDD sky130_fd_sc_hd__tapvpwrvgnd_1
XTAP_TAPCELL_ROW_22_404 VSS VDD sky130_fd_sc_hd__tapvpwrvgnd_1
XTAP_TAPCELL_ROW_22_405 VSS VDD sky130_fd_sc_hd__tapvpwrvgnd_1
XTAP_TAPCELL_ROW_22_406 VSS VDD sky130_fd_sc_hd__tapvpwrvgnd_1
XTAP_TAPCELL_ROW_22_407 VSS VDD sky130_fd_sc_hd__tapvpwrvgnd_1
XTAP_TAPCELL_ROW_23_408 VSS VDD sky130_fd_sc_hd__tapvpwrvgnd_1
XTAP_TAPCELL_ROW_23_409 VSS VDD sky130_fd_sc_hd__tapvpwrvgnd_1
XTAP_TAPCELL_ROW_23_410 VSS VDD sky130_fd_sc_hd__tapvpwrvgnd_1
XTAP_TAPCELL_ROW_23_411 VSS VDD sky130_fd_sc_hd__tapvpwrvgnd_1
XTAP_TAPCELL_ROW_23_412 VSS VDD sky130_fd_sc_hd__tapvpwrvgnd_1
XTAP_TAPCELL_ROW_23_413 VSS VDD sky130_fd_sc_hd__tapvpwrvgnd_1
XTAP_TAPCELL_ROW_23_414 VSS VDD sky130_fd_sc_hd__tapvpwrvgnd_1
XTAP_TAPCELL_ROW_23_415 VSS VDD sky130_fd_sc_hd__tapvpwrvgnd_1
XTAP_TAPCELL_ROW_23_416 VSS VDD sky130_fd_sc_hd__tapvpwrvgnd_1
XTAP_TAPCELL_ROW_23_417 VSS VDD sky130_fd_sc_hd__tapvpwrvgnd_1
XTAP_TAPCELL_ROW_23_418 VSS VDD sky130_fd_sc_hd__tapvpwrvgnd_1
XTAP_TAPCELL_ROW_23_419 VSS VDD sky130_fd_sc_hd__tapvpwrvgnd_1
XTAP_TAPCELL_ROW_23_420 VSS VDD sky130_fd_sc_hd__tapvpwrvgnd_1
XTAP_TAPCELL_ROW_23_421 VSS VDD sky130_fd_sc_hd__tapvpwrvgnd_1
XTAP_TAPCELL_ROW_23_422 VSS VDD sky130_fd_sc_hd__tapvpwrvgnd_1
XTAP_TAPCELL_ROW_23_423 VSS VDD sky130_fd_sc_hd__tapvpwrvgnd_1
XTAP_TAPCELL_ROW_23_424 VSS VDD sky130_fd_sc_hd__tapvpwrvgnd_1
XTAP_TAPCELL_ROW_24_425 VSS VDD sky130_fd_sc_hd__tapvpwrvgnd_1
XTAP_TAPCELL_ROW_24_426 VSS VDD sky130_fd_sc_hd__tapvpwrvgnd_1
XTAP_TAPCELL_ROW_24_427 VSS VDD sky130_fd_sc_hd__tapvpwrvgnd_1
XTAP_TAPCELL_ROW_24_428 VSS VDD sky130_fd_sc_hd__tapvpwrvgnd_1
XTAP_TAPCELL_ROW_24_429 VSS VDD sky130_fd_sc_hd__tapvpwrvgnd_1
XTAP_TAPCELL_ROW_24_430 VSS VDD sky130_fd_sc_hd__tapvpwrvgnd_1
XTAP_TAPCELL_ROW_24_431 VSS VDD sky130_fd_sc_hd__tapvpwrvgnd_1
XTAP_TAPCELL_ROW_24_432 VSS VDD sky130_fd_sc_hd__tapvpwrvgnd_1
XTAP_TAPCELL_ROW_24_433 VSS VDD sky130_fd_sc_hd__tapvpwrvgnd_1
XTAP_TAPCELL_ROW_24_434 VSS VDD sky130_fd_sc_hd__tapvpwrvgnd_1
XTAP_TAPCELL_ROW_24_435 VSS VDD sky130_fd_sc_hd__tapvpwrvgnd_1
XTAP_TAPCELL_ROW_24_436 VSS VDD sky130_fd_sc_hd__tapvpwrvgnd_1
XTAP_TAPCELL_ROW_24_437 VSS VDD sky130_fd_sc_hd__tapvpwrvgnd_1
XTAP_TAPCELL_ROW_24_438 VSS VDD sky130_fd_sc_hd__tapvpwrvgnd_1
XTAP_TAPCELL_ROW_24_439 VSS VDD sky130_fd_sc_hd__tapvpwrvgnd_1
XTAP_TAPCELL_ROW_24_440 VSS VDD sky130_fd_sc_hd__tapvpwrvgnd_1
XTAP_TAPCELL_ROW_24_441 VSS VDD sky130_fd_sc_hd__tapvpwrvgnd_1
XTAP_TAPCELL_ROW_25_442 VSS VDD sky130_fd_sc_hd__tapvpwrvgnd_1
XTAP_TAPCELL_ROW_25_443 VSS VDD sky130_fd_sc_hd__tapvpwrvgnd_1
XTAP_TAPCELL_ROW_25_444 VSS VDD sky130_fd_sc_hd__tapvpwrvgnd_1
XTAP_TAPCELL_ROW_25_445 VSS VDD sky130_fd_sc_hd__tapvpwrvgnd_1
XTAP_TAPCELL_ROW_25_446 VSS VDD sky130_fd_sc_hd__tapvpwrvgnd_1
XTAP_TAPCELL_ROW_25_447 VSS VDD sky130_fd_sc_hd__tapvpwrvgnd_1
XTAP_TAPCELL_ROW_25_448 VSS VDD sky130_fd_sc_hd__tapvpwrvgnd_1
XTAP_TAPCELL_ROW_25_449 VSS VDD sky130_fd_sc_hd__tapvpwrvgnd_1
XTAP_TAPCELL_ROW_25_450 VSS VDD sky130_fd_sc_hd__tapvpwrvgnd_1
XTAP_TAPCELL_ROW_25_451 VSS VDD sky130_fd_sc_hd__tapvpwrvgnd_1
XTAP_TAPCELL_ROW_25_452 VSS VDD sky130_fd_sc_hd__tapvpwrvgnd_1
XTAP_TAPCELL_ROW_25_453 VSS VDD sky130_fd_sc_hd__tapvpwrvgnd_1
XTAP_TAPCELL_ROW_25_454 VSS VDD sky130_fd_sc_hd__tapvpwrvgnd_1
XTAP_TAPCELL_ROW_25_455 VSS VDD sky130_fd_sc_hd__tapvpwrvgnd_1
XTAP_TAPCELL_ROW_25_456 VSS VDD sky130_fd_sc_hd__tapvpwrvgnd_1
XTAP_TAPCELL_ROW_25_457 VSS VDD sky130_fd_sc_hd__tapvpwrvgnd_1
XTAP_TAPCELL_ROW_25_458 VSS VDD sky130_fd_sc_hd__tapvpwrvgnd_1
XTAP_TAPCELL_ROW_26_459 VSS VDD sky130_fd_sc_hd__tapvpwrvgnd_1
XTAP_TAPCELL_ROW_26_460 VSS VDD sky130_fd_sc_hd__tapvpwrvgnd_1
XTAP_TAPCELL_ROW_26_461 VSS VDD sky130_fd_sc_hd__tapvpwrvgnd_1
XTAP_TAPCELL_ROW_26_462 VSS VDD sky130_fd_sc_hd__tapvpwrvgnd_1
XTAP_TAPCELL_ROW_26_463 VSS VDD sky130_fd_sc_hd__tapvpwrvgnd_1
XTAP_TAPCELL_ROW_26_464 VSS VDD sky130_fd_sc_hd__tapvpwrvgnd_1
XTAP_TAPCELL_ROW_26_465 VSS VDD sky130_fd_sc_hd__tapvpwrvgnd_1
XTAP_TAPCELL_ROW_26_466 VSS VDD sky130_fd_sc_hd__tapvpwrvgnd_1
XTAP_TAPCELL_ROW_26_467 VSS VDD sky130_fd_sc_hd__tapvpwrvgnd_1
XTAP_TAPCELL_ROW_26_468 VSS VDD sky130_fd_sc_hd__tapvpwrvgnd_1
XTAP_TAPCELL_ROW_26_469 VSS VDD sky130_fd_sc_hd__tapvpwrvgnd_1
XTAP_TAPCELL_ROW_26_470 VSS VDD sky130_fd_sc_hd__tapvpwrvgnd_1
XTAP_TAPCELL_ROW_26_471 VSS VDD sky130_fd_sc_hd__tapvpwrvgnd_1
XTAP_TAPCELL_ROW_26_472 VSS VDD sky130_fd_sc_hd__tapvpwrvgnd_1
XTAP_TAPCELL_ROW_26_473 VSS VDD sky130_fd_sc_hd__tapvpwrvgnd_1
XTAP_TAPCELL_ROW_26_474 VSS VDD sky130_fd_sc_hd__tapvpwrvgnd_1
XTAP_TAPCELL_ROW_26_475 VSS VDD sky130_fd_sc_hd__tapvpwrvgnd_1
XTAP_TAPCELL_ROW_27_476 VSS VDD sky130_fd_sc_hd__tapvpwrvgnd_1
XTAP_TAPCELL_ROW_27_477 VSS VDD sky130_fd_sc_hd__tapvpwrvgnd_1
XTAP_TAPCELL_ROW_27_478 VSS VDD sky130_fd_sc_hd__tapvpwrvgnd_1
XTAP_TAPCELL_ROW_27_479 VSS VDD sky130_fd_sc_hd__tapvpwrvgnd_1
XTAP_TAPCELL_ROW_27_480 VSS VDD sky130_fd_sc_hd__tapvpwrvgnd_1
XTAP_TAPCELL_ROW_27_481 VSS VDD sky130_fd_sc_hd__tapvpwrvgnd_1
XTAP_TAPCELL_ROW_27_482 VSS VDD sky130_fd_sc_hd__tapvpwrvgnd_1
XTAP_TAPCELL_ROW_27_483 VSS VDD sky130_fd_sc_hd__tapvpwrvgnd_1
XTAP_TAPCELL_ROW_27_484 VSS VDD sky130_fd_sc_hd__tapvpwrvgnd_1
XTAP_TAPCELL_ROW_27_485 VSS VDD sky130_fd_sc_hd__tapvpwrvgnd_1
XTAP_TAPCELL_ROW_27_486 VSS VDD sky130_fd_sc_hd__tapvpwrvgnd_1
XTAP_TAPCELL_ROW_27_487 VSS VDD sky130_fd_sc_hd__tapvpwrvgnd_1
XTAP_TAPCELL_ROW_27_488 VSS VDD sky130_fd_sc_hd__tapvpwrvgnd_1
XTAP_TAPCELL_ROW_27_489 VSS VDD sky130_fd_sc_hd__tapvpwrvgnd_1
XTAP_TAPCELL_ROW_27_490 VSS VDD sky130_fd_sc_hd__tapvpwrvgnd_1
XTAP_TAPCELL_ROW_27_491 VSS VDD sky130_fd_sc_hd__tapvpwrvgnd_1
XTAP_TAPCELL_ROW_27_492 VSS VDD sky130_fd_sc_hd__tapvpwrvgnd_1
XTAP_TAPCELL_ROW_28_493 VSS VDD sky130_fd_sc_hd__tapvpwrvgnd_1
XTAP_TAPCELL_ROW_28_494 VSS VDD sky130_fd_sc_hd__tapvpwrvgnd_1
XTAP_TAPCELL_ROW_28_495 VSS VDD sky130_fd_sc_hd__tapvpwrvgnd_1
XTAP_TAPCELL_ROW_28_496 VSS VDD sky130_fd_sc_hd__tapvpwrvgnd_1
XTAP_TAPCELL_ROW_28_497 VSS VDD sky130_fd_sc_hd__tapvpwrvgnd_1
XTAP_TAPCELL_ROW_28_498 VSS VDD sky130_fd_sc_hd__tapvpwrvgnd_1
XTAP_TAPCELL_ROW_28_499 VSS VDD sky130_fd_sc_hd__tapvpwrvgnd_1
XTAP_TAPCELL_ROW_28_500 VSS VDD sky130_fd_sc_hd__tapvpwrvgnd_1
XTAP_TAPCELL_ROW_28_501 VSS VDD sky130_fd_sc_hd__tapvpwrvgnd_1
XTAP_TAPCELL_ROW_28_502 VSS VDD sky130_fd_sc_hd__tapvpwrvgnd_1
XTAP_TAPCELL_ROW_28_503 VSS VDD sky130_fd_sc_hd__tapvpwrvgnd_1
XTAP_TAPCELL_ROW_28_504 VSS VDD sky130_fd_sc_hd__tapvpwrvgnd_1
XTAP_TAPCELL_ROW_28_505 VSS VDD sky130_fd_sc_hd__tapvpwrvgnd_1
XTAP_TAPCELL_ROW_28_506 VSS VDD sky130_fd_sc_hd__tapvpwrvgnd_1
XTAP_TAPCELL_ROW_28_507 VSS VDD sky130_fd_sc_hd__tapvpwrvgnd_1
XTAP_TAPCELL_ROW_28_508 VSS VDD sky130_fd_sc_hd__tapvpwrvgnd_1
XTAP_TAPCELL_ROW_28_509 VSS VDD sky130_fd_sc_hd__tapvpwrvgnd_1
XTAP_TAPCELL_ROW_29_510 VSS VDD sky130_fd_sc_hd__tapvpwrvgnd_1
XTAP_TAPCELL_ROW_29_511 VSS VDD sky130_fd_sc_hd__tapvpwrvgnd_1
XTAP_TAPCELL_ROW_29_512 VSS VDD sky130_fd_sc_hd__tapvpwrvgnd_1
XTAP_TAPCELL_ROW_29_513 VSS VDD sky130_fd_sc_hd__tapvpwrvgnd_1
XTAP_TAPCELL_ROW_29_514 VSS VDD sky130_fd_sc_hd__tapvpwrvgnd_1
XTAP_TAPCELL_ROW_29_515 VSS VDD sky130_fd_sc_hd__tapvpwrvgnd_1
XTAP_TAPCELL_ROW_29_516 VSS VDD sky130_fd_sc_hd__tapvpwrvgnd_1
XTAP_TAPCELL_ROW_29_517 VSS VDD sky130_fd_sc_hd__tapvpwrvgnd_1
XTAP_TAPCELL_ROW_29_518 VSS VDD sky130_fd_sc_hd__tapvpwrvgnd_1
XTAP_TAPCELL_ROW_29_519 VSS VDD sky130_fd_sc_hd__tapvpwrvgnd_1
XTAP_TAPCELL_ROW_29_520 VSS VDD sky130_fd_sc_hd__tapvpwrvgnd_1
XTAP_TAPCELL_ROW_29_521 VSS VDD sky130_fd_sc_hd__tapvpwrvgnd_1
XTAP_TAPCELL_ROW_29_522 VSS VDD sky130_fd_sc_hd__tapvpwrvgnd_1
XTAP_TAPCELL_ROW_29_523 VSS VDD sky130_fd_sc_hd__tapvpwrvgnd_1
XTAP_TAPCELL_ROW_29_524 VSS VDD sky130_fd_sc_hd__tapvpwrvgnd_1
XTAP_TAPCELL_ROW_29_525 VSS VDD sky130_fd_sc_hd__tapvpwrvgnd_1
XTAP_TAPCELL_ROW_29_526 VSS VDD sky130_fd_sc_hd__tapvpwrvgnd_1
XTAP_TAPCELL_ROW_30_527 VSS VDD sky130_fd_sc_hd__tapvpwrvgnd_1
XTAP_TAPCELL_ROW_30_528 VSS VDD sky130_fd_sc_hd__tapvpwrvgnd_1
XTAP_TAPCELL_ROW_30_529 VSS VDD sky130_fd_sc_hd__tapvpwrvgnd_1
XTAP_TAPCELL_ROW_30_530 VSS VDD sky130_fd_sc_hd__tapvpwrvgnd_1
XTAP_TAPCELL_ROW_30_531 VSS VDD sky130_fd_sc_hd__tapvpwrvgnd_1
XTAP_TAPCELL_ROW_30_532 VSS VDD sky130_fd_sc_hd__tapvpwrvgnd_1
XTAP_TAPCELL_ROW_30_533 VSS VDD sky130_fd_sc_hd__tapvpwrvgnd_1
XTAP_TAPCELL_ROW_30_534 VSS VDD sky130_fd_sc_hd__tapvpwrvgnd_1
XTAP_TAPCELL_ROW_30_535 VSS VDD sky130_fd_sc_hd__tapvpwrvgnd_1
XTAP_TAPCELL_ROW_30_536 VSS VDD sky130_fd_sc_hd__tapvpwrvgnd_1
XTAP_TAPCELL_ROW_30_537 VSS VDD sky130_fd_sc_hd__tapvpwrvgnd_1
XTAP_TAPCELL_ROW_30_538 VSS VDD sky130_fd_sc_hd__tapvpwrvgnd_1
XTAP_TAPCELL_ROW_30_539 VSS VDD sky130_fd_sc_hd__tapvpwrvgnd_1
XTAP_TAPCELL_ROW_30_540 VSS VDD sky130_fd_sc_hd__tapvpwrvgnd_1
XTAP_TAPCELL_ROW_30_541 VSS VDD sky130_fd_sc_hd__tapvpwrvgnd_1
XTAP_TAPCELL_ROW_30_542 VSS VDD sky130_fd_sc_hd__tapvpwrvgnd_1
XTAP_TAPCELL_ROW_30_543 VSS VDD sky130_fd_sc_hd__tapvpwrvgnd_1
XTAP_TAPCELL_ROW_31_544 VSS VDD sky130_fd_sc_hd__tapvpwrvgnd_1
XTAP_TAPCELL_ROW_31_545 VSS VDD sky130_fd_sc_hd__tapvpwrvgnd_1
XTAP_TAPCELL_ROW_31_546 VSS VDD sky130_fd_sc_hd__tapvpwrvgnd_1
XTAP_TAPCELL_ROW_31_547 VSS VDD sky130_fd_sc_hd__tapvpwrvgnd_1
XTAP_TAPCELL_ROW_31_548 VSS VDD sky130_fd_sc_hd__tapvpwrvgnd_1
XTAP_TAPCELL_ROW_31_549 VSS VDD sky130_fd_sc_hd__tapvpwrvgnd_1
XTAP_TAPCELL_ROW_31_550 VSS VDD sky130_fd_sc_hd__tapvpwrvgnd_1
XTAP_TAPCELL_ROW_31_551 VSS VDD sky130_fd_sc_hd__tapvpwrvgnd_1
XTAP_TAPCELL_ROW_31_552 VSS VDD sky130_fd_sc_hd__tapvpwrvgnd_1
XTAP_TAPCELL_ROW_31_553 VSS VDD sky130_fd_sc_hd__tapvpwrvgnd_1
XTAP_TAPCELL_ROW_31_554 VSS VDD sky130_fd_sc_hd__tapvpwrvgnd_1
XTAP_TAPCELL_ROW_31_555 VSS VDD sky130_fd_sc_hd__tapvpwrvgnd_1
XTAP_TAPCELL_ROW_31_556 VSS VDD sky130_fd_sc_hd__tapvpwrvgnd_1
XTAP_TAPCELL_ROW_31_557 VSS VDD sky130_fd_sc_hd__tapvpwrvgnd_1
XTAP_TAPCELL_ROW_31_558 VSS VDD sky130_fd_sc_hd__tapvpwrvgnd_1
XTAP_TAPCELL_ROW_31_559 VSS VDD sky130_fd_sc_hd__tapvpwrvgnd_1
XTAP_TAPCELL_ROW_31_560 VSS VDD sky130_fd_sc_hd__tapvpwrvgnd_1
XTAP_TAPCELL_ROW_32_561 VSS VDD sky130_fd_sc_hd__tapvpwrvgnd_1
XTAP_TAPCELL_ROW_32_562 VSS VDD sky130_fd_sc_hd__tapvpwrvgnd_1
XTAP_TAPCELL_ROW_32_563 VSS VDD sky130_fd_sc_hd__tapvpwrvgnd_1
XTAP_TAPCELL_ROW_32_564 VSS VDD sky130_fd_sc_hd__tapvpwrvgnd_1
XTAP_TAPCELL_ROW_32_565 VSS VDD sky130_fd_sc_hd__tapvpwrvgnd_1
XTAP_TAPCELL_ROW_32_566 VSS VDD sky130_fd_sc_hd__tapvpwrvgnd_1
XTAP_TAPCELL_ROW_32_567 VSS VDD sky130_fd_sc_hd__tapvpwrvgnd_1
XTAP_TAPCELL_ROW_32_568 VSS VDD sky130_fd_sc_hd__tapvpwrvgnd_1
XTAP_TAPCELL_ROW_32_569 VSS VDD sky130_fd_sc_hd__tapvpwrvgnd_1
XTAP_TAPCELL_ROW_32_570 VSS VDD sky130_fd_sc_hd__tapvpwrvgnd_1
XTAP_TAPCELL_ROW_32_571 VSS VDD sky130_fd_sc_hd__tapvpwrvgnd_1
XTAP_TAPCELL_ROW_32_572 VSS VDD sky130_fd_sc_hd__tapvpwrvgnd_1
XTAP_TAPCELL_ROW_32_573 VSS VDD sky130_fd_sc_hd__tapvpwrvgnd_1
XTAP_TAPCELL_ROW_32_574 VSS VDD sky130_fd_sc_hd__tapvpwrvgnd_1
XTAP_TAPCELL_ROW_32_575 VSS VDD sky130_fd_sc_hd__tapvpwrvgnd_1
XTAP_TAPCELL_ROW_32_576 VSS VDD sky130_fd_sc_hd__tapvpwrvgnd_1
XTAP_TAPCELL_ROW_32_577 VSS VDD sky130_fd_sc_hd__tapvpwrvgnd_1
XTAP_TAPCELL_ROW_33_578 VSS VDD sky130_fd_sc_hd__tapvpwrvgnd_1
XTAP_TAPCELL_ROW_33_579 VSS VDD sky130_fd_sc_hd__tapvpwrvgnd_1
XTAP_TAPCELL_ROW_33_580 VSS VDD sky130_fd_sc_hd__tapvpwrvgnd_1
XTAP_TAPCELL_ROW_33_581 VSS VDD sky130_fd_sc_hd__tapvpwrvgnd_1
XTAP_TAPCELL_ROW_33_582 VSS VDD sky130_fd_sc_hd__tapvpwrvgnd_1
XTAP_TAPCELL_ROW_33_583 VSS VDD sky130_fd_sc_hd__tapvpwrvgnd_1
XTAP_TAPCELL_ROW_33_584 VSS VDD sky130_fd_sc_hd__tapvpwrvgnd_1
XTAP_TAPCELL_ROW_33_585 VSS VDD sky130_fd_sc_hd__tapvpwrvgnd_1
XTAP_TAPCELL_ROW_33_586 VSS VDD sky130_fd_sc_hd__tapvpwrvgnd_1
XTAP_TAPCELL_ROW_33_587 VSS VDD sky130_fd_sc_hd__tapvpwrvgnd_1
XTAP_TAPCELL_ROW_33_588 VSS VDD sky130_fd_sc_hd__tapvpwrvgnd_1
XTAP_TAPCELL_ROW_33_589 VSS VDD sky130_fd_sc_hd__tapvpwrvgnd_1
XTAP_TAPCELL_ROW_33_590 VSS VDD sky130_fd_sc_hd__tapvpwrvgnd_1
XTAP_TAPCELL_ROW_33_591 VSS VDD sky130_fd_sc_hd__tapvpwrvgnd_1
XTAP_TAPCELL_ROW_33_592 VSS VDD sky130_fd_sc_hd__tapvpwrvgnd_1
XTAP_TAPCELL_ROW_33_593 VSS VDD sky130_fd_sc_hd__tapvpwrvgnd_1
XTAP_TAPCELL_ROW_33_594 VSS VDD sky130_fd_sc_hd__tapvpwrvgnd_1
XTAP_TAPCELL_ROW_34_595 VSS VDD sky130_fd_sc_hd__tapvpwrvgnd_1
XTAP_TAPCELL_ROW_34_596 VSS VDD sky130_fd_sc_hd__tapvpwrvgnd_1
XTAP_TAPCELL_ROW_34_597 VSS VDD sky130_fd_sc_hd__tapvpwrvgnd_1
XTAP_TAPCELL_ROW_34_598 VSS VDD sky130_fd_sc_hd__tapvpwrvgnd_1
XTAP_TAPCELL_ROW_34_599 VSS VDD sky130_fd_sc_hd__tapvpwrvgnd_1
XTAP_TAPCELL_ROW_34_600 VSS VDD sky130_fd_sc_hd__tapvpwrvgnd_1
XTAP_TAPCELL_ROW_34_601 VSS VDD sky130_fd_sc_hd__tapvpwrvgnd_1
XTAP_TAPCELL_ROW_34_602 VSS VDD sky130_fd_sc_hd__tapvpwrvgnd_1
XTAP_TAPCELL_ROW_34_603 VSS VDD sky130_fd_sc_hd__tapvpwrvgnd_1
XTAP_TAPCELL_ROW_34_604 VSS VDD sky130_fd_sc_hd__tapvpwrvgnd_1
XTAP_TAPCELL_ROW_34_605 VSS VDD sky130_fd_sc_hd__tapvpwrvgnd_1
XTAP_TAPCELL_ROW_34_606 VSS VDD sky130_fd_sc_hd__tapvpwrvgnd_1
XTAP_TAPCELL_ROW_34_607 VSS VDD sky130_fd_sc_hd__tapvpwrvgnd_1
XTAP_TAPCELL_ROW_34_608 VSS VDD sky130_fd_sc_hd__tapvpwrvgnd_1
XTAP_TAPCELL_ROW_34_609 VSS VDD sky130_fd_sc_hd__tapvpwrvgnd_1
XTAP_TAPCELL_ROW_34_610 VSS VDD sky130_fd_sc_hd__tapvpwrvgnd_1
XTAP_TAPCELL_ROW_34_611 VSS VDD sky130_fd_sc_hd__tapvpwrvgnd_1
XTAP_TAPCELL_ROW_35_612 VSS VDD sky130_fd_sc_hd__tapvpwrvgnd_1
XTAP_TAPCELL_ROW_35_613 VSS VDD sky130_fd_sc_hd__tapvpwrvgnd_1
XTAP_TAPCELL_ROW_35_614 VSS VDD sky130_fd_sc_hd__tapvpwrvgnd_1
XTAP_TAPCELL_ROW_35_615 VSS VDD sky130_fd_sc_hd__tapvpwrvgnd_1
XTAP_TAPCELL_ROW_35_616 VSS VDD sky130_fd_sc_hd__tapvpwrvgnd_1
XTAP_TAPCELL_ROW_35_617 VSS VDD sky130_fd_sc_hd__tapvpwrvgnd_1
XTAP_TAPCELL_ROW_35_618 VSS VDD sky130_fd_sc_hd__tapvpwrvgnd_1
XTAP_TAPCELL_ROW_35_619 VSS VDD sky130_fd_sc_hd__tapvpwrvgnd_1
XTAP_TAPCELL_ROW_35_620 VSS VDD sky130_fd_sc_hd__tapvpwrvgnd_1
XTAP_TAPCELL_ROW_35_621 VSS VDD sky130_fd_sc_hd__tapvpwrvgnd_1
XTAP_TAPCELL_ROW_35_622 VSS VDD sky130_fd_sc_hd__tapvpwrvgnd_1
XTAP_TAPCELL_ROW_35_623 VSS VDD sky130_fd_sc_hd__tapvpwrvgnd_1
XTAP_TAPCELL_ROW_35_624 VSS VDD sky130_fd_sc_hd__tapvpwrvgnd_1
XTAP_TAPCELL_ROW_35_625 VSS VDD sky130_fd_sc_hd__tapvpwrvgnd_1
XTAP_TAPCELL_ROW_35_626 VSS VDD sky130_fd_sc_hd__tapvpwrvgnd_1
XTAP_TAPCELL_ROW_35_627 VSS VDD sky130_fd_sc_hd__tapvpwrvgnd_1
XTAP_TAPCELL_ROW_35_628 VSS VDD sky130_fd_sc_hd__tapvpwrvgnd_1
XTAP_TAPCELL_ROW_36_629 VSS VDD sky130_fd_sc_hd__tapvpwrvgnd_1
XTAP_TAPCELL_ROW_36_630 VSS VDD sky130_fd_sc_hd__tapvpwrvgnd_1
XTAP_TAPCELL_ROW_36_631 VSS VDD sky130_fd_sc_hd__tapvpwrvgnd_1
XTAP_TAPCELL_ROW_36_632 VSS VDD sky130_fd_sc_hd__tapvpwrvgnd_1
XTAP_TAPCELL_ROW_36_633 VSS VDD sky130_fd_sc_hd__tapvpwrvgnd_1
XTAP_TAPCELL_ROW_36_634 VSS VDD sky130_fd_sc_hd__tapvpwrvgnd_1
XTAP_TAPCELL_ROW_36_635 VSS VDD sky130_fd_sc_hd__tapvpwrvgnd_1
XTAP_TAPCELL_ROW_36_636 VSS VDD sky130_fd_sc_hd__tapvpwrvgnd_1
XTAP_TAPCELL_ROW_36_637 VSS VDD sky130_fd_sc_hd__tapvpwrvgnd_1
XTAP_TAPCELL_ROW_36_638 VSS VDD sky130_fd_sc_hd__tapvpwrvgnd_1
XTAP_TAPCELL_ROW_36_639 VSS VDD sky130_fd_sc_hd__tapvpwrvgnd_1
XTAP_TAPCELL_ROW_36_640 VSS VDD sky130_fd_sc_hd__tapvpwrvgnd_1
XTAP_TAPCELL_ROW_36_641 VSS VDD sky130_fd_sc_hd__tapvpwrvgnd_1
XTAP_TAPCELL_ROW_36_642 VSS VDD sky130_fd_sc_hd__tapvpwrvgnd_1
XTAP_TAPCELL_ROW_36_643 VSS VDD sky130_fd_sc_hd__tapvpwrvgnd_1
XTAP_TAPCELL_ROW_36_644 VSS VDD sky130_fd_sc_hd__tapvpwrvgnd_1
XTAP_TAPCELL_ROW_36_645 VSS VDD sky130_fd_sc_hd__tapvpwrvgnd_1
XTAP_TAPCELL_ROW_37_646 VSS VDD sky130_fd_sc_hd__tapvpwrvgnd_1
XTAP_TAPCELL_ROW_37_647 VSS VDD sky130_fd_sc_hd__tapvpwrvgnd_1
XTAP_TAPCELL_ROW_37_648 VSS VDD sky130_fd_sc_hd__tapvpwrvgnd_1
XTAP_TAPCELL_ROW_37_649 VSS VDD sky130_fd_sc_hd__tapvpwrvgnd_1
XTAP_TAPCELL_ROW_37_650 VSS VDD sky130_fd_sc_hd__tapvpwrvgnd_1
XTAP_TAPCELL_ROW_37_651 VSS VDD sky130_fd_sc_hd__tapvpwrvgnd_1
XTAP_TAPCELL_ROW_37_652 VSS VDD sky130_fd_sc_hd__tapvpwrvgnd_1
XTAP_TAPCELL_ROW_37_653 VSS VDD sky130_fd_sc_hd__tapvpwrvgnd_1
XTAP_TAPCELL_ROW_37_654 VSS VDD sky130_fd_sc_hd__tapvpwrvgnd_1
XTAP_TAPCELL_ROW_37_655 VSS VDD sky130_fd_sc_hd__tapvpwrvgnd_1
XTAP_TAPCELL_ROW_37_656 VSS VDD sky130_fd_sc_hd__tapvpwrvgnd_1
XTAP_TAPCELL_ROW_37_657 VSS VDD sky130_fd_sc_hd__tapvpwrvgnd_1
XTAP_TAPCELL_ROW_37_658 VSS VDD sky130_fd_sc_hd__tapvpwrvgnd_1
XTAP_TAPCELL_ROW_37_659 VSS VDD sky130_fd_sc_hd__tapvpwrvgnd_1
XTAP_TAPCELL_ROW_37_660 VSS VDD sky130_fd_sc_hd__tapvpwrvgnd_1
XTAP_TAPCELL_ROW_37_661 VSS VDD sky130_fd_sc_hd__tapvpwrvgnd_1
XTAP_TAPCELL_ROW_37_662 VSS VDD sky130_fd_sc_hd__tapvpwrvgnd_1
XTAP_TAPCELL_ROW_38_663 VSS VDD sky130_fd_sc_hd__tapvpwrvgnd_1
XTAP_TAPCELL_ROW_38_664 VSS VDD sky130_fd_sc_hd__tapvpwrvgnd_1
XTAP_TAPCELL_ROW_38_665 VSS VDD sky130_fd_sc_hd__tapvpwrvgnd_1
XTAP_TAPCELL_ROW_38_666 VSS VDD sky130_fd_sc_hd__tapvpwrvgnd_1
XTAP_TAPCELL_ROW_38_667 VSS VDD sky130_fd_sc_hd__tapvpwrvgnd_1
XTAP_TAPCELL_ROW_38_668 VSS VDD sky130_fd_sc_hd__tapvpwrvgnd_1
XTAP_TAPCELL_ROW_38_669 VSS VDD sky130_fd_sc_hd__tapvpwrvgnd_1
XTAP_TAPCELL_ROW_38_670 VSS VDD sky130_fd_sc_hd__tapvpwrvgnd_1
XTAP_TAPCELL_ROW_38_671 VSS VDD sky130_fd_sc_hd__tapvpwrvgnd_1
XTAP_TAPCELL_ROW_38_672 VSS VDD sky130_fd_sc_hd__tapvpwrvgnd_1
XTAP_TAPCELL_ROW_38_673 VSS VDD sky130_fd_sc_hd__tapvpwrvgnd_1
XTAP_TAPCELL_ROW_38_674 VSS VDD sky130_fd_sc_hd__tapvpwrvgnd_1
XTAP_TAPCELL_ROW_38_675 VSS VDD sky130_fd_sc_hd__tapvpwrvgnd_1
XTAP_TAPCELL_ROW_38_676 VSS VDD sky130_fd_sc_hd__tapvpwrvgnd_1
XTAP_TAPCELL_ROW_38_677 VSS VDD sky130_fd_sc_hd__tapvpwrvgnd_1
XTAP_TAPCELL_ROW_38_678 VSS VDD sky130_fd_sc_hd__tapvpwrvgnd_1
XTAP_TAPCELL_ROW_38_679 VSS VDD sky130_fd_sc_hd__tapvpwrvgnd_1
XTAP_TAPCELL_ROW_39_680 VSS VDD sky130_fd_sc_hd__tapvpwrvgnd_1
XTAP_TAPCELL_ROW_39_681 VSS VDD sky130_fd_sc_hd__tapvpwrvgnd_1
XTAP_TAPCELL_ROW_39_682 VSS VDD sky130_fd_sc_hd__tapvpwrvgnd_1
XTAP_TAPCELL_ROW_39_683 VSS VDD sky130_fd_sc_hd__tapvpwrvgnd_1
XTAP_TAPCELL_ROW_39_684 VSS VDD sky130_fd_sc_hd__tapvpwrvgnd_1
XTAP_TAPCELL_ROW_39_685 VSS VDD sky130_fd_sc_hd__tapvpwrvgnd_1
XTAP_TAPCELL_ROW_39_686 VSS VDD sky130_fd_sc_hd__tapvpwrvgnd_1
XTAP_TAPCELL_ROW_39_687 VSS VDD sky130_fd_sc_hd__tapvpwrvgnd_1
XTAP_TAPCELL_ROW_39_688 VSS VDD sky130_fd_sc_hd__tapvpwrvgnd_1
XTAP_TAPCELL_ROW_39_689 VSS VDD sky130_fd_sc_hd__tapvpwrvgnd_1
XTAP_TAPCELL_ROW_39_690 VSS VDD sky130_fd_sc_hd__tapvpwrvgnd_1
XTAP_TAPCELL_ROW_39_691 VSS VDD sky130_fd_sc_hd__tapvpwrvgnd_1
XTAP_TAPCELL_ROW_39_692 VSS VDD sky130_fd_sc_hd__tapvpwrvgnd_1
XTAP_TAPCELL_ROW_39_693 VSS VDD sky130_fd_sc_hd__tapvpwrvgnd_1
XTAP_TAPCELL_ROW_39_694 VSS VDD sky130_fd_sc_hd__tapvpwrvgnd_1
XTAP_TAPCELL_ROW_39_695 VSS VDD sky130_fd_sc_hd__tapvpwrvgnd_1
XTAP_TAPCELL_ROW_39_696 VSS VDD sky130_fd_sc_hd__tapvpwrvgnd_1
XTAP_TAPCELL_ROW_40_697 VSS VDD sky130_fd_sc_hd__tapvpwrvgnd_1
XTAP_TAPCELL_ROW_40_698 VSS VDD sky130_fd_sc_hd__tapvpwrvgnd_1
XTAP_TAPCELL_ROW_40_699 VSS VDD sky130_fd_sc_hd__tapvpwrvgnd_1
XTAP_TAPCELL_ROW_40_700 VSS VDD sky130_fd_sc_hd__tapvpwrvgnd_1
XTAP_TAPCELL_ROW_40_701 VSS VDD sky130_fd_sc_hd__tapvpwrvgnd_1
XTAP_TAPCELL_ROW_40_702 VSS VDD sky130_fd_sc_hd__tapvpwrvgnd_1
XTAP_TAPCELL_ROW_40_703 VSS VDD sky130_fd_sc_hd__tapvpwrvgnd_1
XTAP_TAPCELL_ROW_40_704 VSS VDD sky130_fd_sc_hd__tapvpwrvgnd_1
XTAP_TAPCELL_ROW_40_705 VSS VDD sky130_fd_sc_hd__tapvpwrvgnd_1
XTAP_TAPCELL_ROW_40_706 VSS VDD sky130_fd_sc_hd__tapvpwrvgnd_1
XTAP_TAPCELL_ROW_40_707 VSS VDD sky130_fd_sc_hd__tapvpwrvgnd_1
XTAP_TAPCELL_ROW_40_708 VSS VDD sky130_fd_sc_hd__tapvpwrvgnd_1
XTAP_TAPCELL_ROW_40_709 VSS VDD sky130_fd_sc_hd__tapvpwrvgnd_1
XTAP_TAPCELL_ROW_40_710 VSS VDD sky130_fd_sc_hd__tapvpwrvgnd_1
XTAP_TAPCELL_ROW_40_711 VSS VDD sky130_fd_sc_hd__tapvpwrvgnd_1
XTAP_TAPCELL_ROW_40_712 VSS VDD sky130_fd_sc_hd__tapvpwrvgnd_1
XTAP_TAPCELL_ROW_40_713 VSS VDD sky130_fd_sc_hd__tapvpwrvgnd_1
XTAP_TAPCELL_ROW_41_714 VSS VDD sky130_fd_sc_hd__tapvpwrvgnd_1
XTAP_TAPCELL_ROW_41_715 VSS VDD sky130_fd_sc_hd__tapvpwrvgnd_1
XTAP_TAPCELL_ROW_41_716 VSS VDD sky130_fd_sc_hd__tapvpwrvgnd_1
XTAP_TAPCELL_ROW_41_717 VSS VDD sky130_fd_sc_hd__tapvpwrvgnd_1
XTAP_TAPCELL_ROW_41_718 VSS VDD sky130_fd_sc_hd__tapvpwrvgnd_1
XTAP_TAPCELL_ROW_41_719 VSS VDD sky130_fd_sc_hd__tapvpwrvgnd_1
XTAP_TAPCELL_ROW_41_720 VSS VDD sky130_fd_sc_hd__tapvpwrvgnd_1
XTAP_TAPCELL_ROW_41_721 VSS VDD sky130_fd_sc_hd__tapvpwrvgnd_1
XTAP_TAPCELL_ROW_41_722 VSS VDD sky130_fd_sc_hd__tapvpwrvgnd_1
XTAP_TAPCELL_ROW_41_723 VSS VDD sky130_fd_sc_hd__tapvpwrvgnd_1
XTAP_TAPCELL_ROW_41_724 VSS VDD sky130_fd_sc_hd__tapvpwrvgnd_1
XTAP_TAPCELL_ROW_41_725 VSS VDD sky130_fd_sc_hd__tapvpwrvgnd_1
XTAP_TAPCELL_ROW_41_726 VSS VDD sky130_fd_sc_hd__tapvpwrvgnd_1
XTAP_TAPCELL_ROW_41_727 VSS VDD sky130_fd_sc_hd__tapvpwrvgnd_1
XTAP_TAPCELL_ROW_41_728 VSS VDD sky130_fd_sc_hd__tapvpwrvgnd_1
XTAP_TAPCELL_ROW_41_729 VSS VDD sky130_fd_sc_hd__tapvpwrvgnd_1
XTAP_TAPCELL_ROW_41_730 VSS VDD sky130_fd_sc_hd__tapvpwrvgnd_1
XTAP_TAPCELL_ROW_42_731 VSS VDD sky130_fd_sc_hd__tapvpwrvgnd_1
XTAP_TAPCELL_ROW_42_732 VSS VDD sky130_fd_sc_hd__tapvpwrvgnd_1
XTAP_TAPCELL_ROW_42_733 VSS VDD sky130_fd_sc_hd__tapvpwrvgnd_1
XTAP_TAPCELL_ROW_42_734 VSS VDD sky130_fd_sc_hd__tapvpwrvgnd_1
XTAP_TAPCELL_ROW_42_735 VSS VDD sky130_fd_sc_hd__tapvpwrvgnd_1
XTAP_TAPCELL_ROW_42_736 VSS VDD sky130_fd_sc_hd__tapvpwrvgnd_1
XTAP_TAPCELL_ROW_42_737 VSS VDD sky130_fd_sc_hd__tapvpwrvgnd_1
XTAP_TAPCELL_ROW_42_738 VSS VDD sky130_fd_sc_hd__tapvpwrvgnd_1
XTAP_TAPCELL_ROW_42_739 VSS VDD sky130_fd_sc_hd__tapvpwrvgnd_1
XTAP_TAPCELL_ROW_42_740 VSS VDD sky130_fd_sc_hd__tapvpwrvgnd_1
XTAP_TAPCELL_ROW_42_741 VSS VDD sky130_fd_sc_hd__tapvpwrvgnd_1
XTAP_TAPCELL_ROW_42_742 VSS VDD sky130_fd_sc_hd__tapvpwrvgnd_1
XTAP_TAPCELL_ROW_42_743 VSS VDD sky130_fd_sc_hd__tapvpwrvgnd_1
XTAP_TAPCELL_ROW_42_744 VSS VDD sky130_fd_sc_hd__tapvpwrvgnd_1
XTAP_TAPCELL_ROW_42_745 VSS VDD sky130_fd_sc_hd__tapvpwrvgnd_1
XTAP_TAPCELL_ROW_42_746 VSS VDD sky130_fd_sc_hd__tapvpwrvgnd_1
XTAP_TAPCELL_ROW_42_747 VSS VDD sky130_fd_sc_hd__tapvpwrvgnd_1
XTAP_TAPCELL_ROW_43_748 VSS VDD sky130_fd_sc_hd__tapvpwrvgnd_1
XTAP_TAPCELL_ROW_43_749 VSS VDD sky130_fd_sc_hd__tapvpwrvgnd_1
XTAP_TAPCELL_ROW_43_750 VSS VDD sky130_fd_sc_hd__tapvpwrvgnd_1
XTAP_TAPCELL_ROW_43_751 VSS VDD sky130_fd_sc_hd__tapvpwrvgnd_1
XTAP_TAPCELL_ROW_43_752 VSS VDD sky130_fd_sc_hd__tapvpwrvgnd_1
XTAP_TAPCELL_ROW_43_753 VSS VDD sky130_fd_sc_hd__tapvpwrvgnd_1
XTAP_TAPCELL_ROW_43_754 VSS VDD sky130_fd_sc_hd__tapvpwrvgnd_1
XTAP_TAPCELL_ROW_43_755 VSS VDD sky130_fd_sc_hd__tapvpwrvgnd_1
XTAP_TAPCELL_ROW_43_756 VSS VDD sky130_fd_sc_hd__tapvpwrvgnd_1
XTAP_TAPCELL_ROW_43_757 VSS VDD sky130_fd_sc_hd__tapvpwrvgnd_1
XTAP_TAPCELL_ROW_43_758 VSS VDD sky130_fd_sc_hd__tapvpwrvgnd_1
XTAP_TAPCELL_ROW_43_759 VSS VDD sky130_fd_sc_hd__tapvpwrvgnd_1
XTAP_TAPCELL_ROW_43_760 VSS VDD sky130_fd_sc_hd__tapvpwrvgnd_1
XTAP_TAPCELL_ROW_43_761 VSS VDD sky130_fd_sc_hd__tapvpwrvgnd_1
XTAP_TAPCELL_ROW_43_762 VSS VDD sky130_fd_sc_hd__tapvpwrvgnd_1
XTAP_TAPCELL_ROW_43_763 VSS VDD sky130_fd_sc_hd__tapvpwrvgnd_1
XTAP_TAPCELL_ROW_43_764 VSS VDD sky130_fd_sc_hd__tapvpwrvgnd_1
XTAP_TAPCELL_ROW_44_765 VSS VDD sky130_fd_sc_hd__tapvpwrvgnd_1
XTAP_TAPCELL_ROW_44_766 VSS VDD sky130_fd_sc_hd__tapvpwrvgnd_1
XTAP_TAPCELL_ROW_44_767 VSS VDD sky130_fd_sc_hd__tapvpwrvgnd_1
XTAP_TAPCELL_ROW_44_768 VSS VDD sky130_fd_sc_hd__tapvpwrvgnd_1
XTAP_TAPCELL_ROW_44_769 VSS VDD sky130_fd_sc_hd__tapvpwrvgnd_1
XTAP_TAPCELL_ROW_44_770 VSS VDD sky130_fd_sc_hd__tapvpwrvgnd_1
XTAP_TAPCELL_ROW_44_771 VSS VDD sky130_fd_sc_hd__tapvpwrvgnd_1
XTAP_TAPCELL_ROW_44_772 VSS VDD sky130_fd_sc_hd__tapvpwrvgnd_1
XTAP_TAPCELL_ROW_44_773 VSS VDD sky130_fd_sc_hd__tapvpwrvgnd_1
XTAP_TAPCELL_ROW_44_774 VSS VDD sky130_fd_sc_hd__tapvpwrvgnd_1
XTAP_TAPCELL_ROW_44_775 VSS VDD sky130_fd_sc_hd__tapvpwrvgnd_1
XTAP_TAPCELL_ROW_44_776 VSS VDD sky130_fd_sc_hd__tapvpwrvgnd_1
XTAP_TAPCELL_ROW_44_777 VSS VDD sky130_fd_sc_hd__tapvpwrvgnd_1
XTAP_TAPCELL_ROW_44_778 VSS VDD sky130_fd_sc_hd__tapvpwrvgnd_1
XTAP_TAPCELL_ROW_44_779 VSS VDD sky130_fd_sc_hd__tapvpwrvgnd_1
XTAP_TAPCELL_ROW_44_780 VSS VDD sky130_fd_sc_hd__tapvpwrvgnd_1
XTAP_TAPCELL_ROW_44_781 VSS VDD sky130_fd_sc_hd__tapvpwrvgnd_1
XTAP_TAPCELL_ROW_45_782 VSS VDD sky130_fd_sc_hd__tapvpwrvgnd_1
XTAP_TAPCELL_ROW_45_783 VSS VDD sky130_fd_sc_hd__tapvpwrvgnd_1
XTAP_TAPCELL_ROW_45_784 VSS VDD sky130_fd_sc_hd__tapvpwrvgnd_1
XTAP_TAPCELL_ROW_45_785 VSS VDD sky130_fd_sc_hd__tapvpwrvgnd_1
XTAP_TAPCELL_ROW_45_786 VSS VDD sky130_fd_sc_hd__tapvpwrvgnd_1
XTAP_TAPCELL_ROW_45_787 VSS VDD sky130_fd_sc_hd__tapvpwrvgnd_1
XTAP_TAPCELL_ROW_45_788 VSS VDD sky130_fd_sc_hd__tapvpwrvgnd_1
XTAP_TAPCELL_ROW_45_789 VSS VDD sky130_fd_sc_hd__tapvpwrvgnd_1
XTAP_TAPCELL_ROW_45_790 VSS VDD sky130_fd_sc_hd__tapvpwrvgnd_1
XTAP_TAPCELL_ROW_45_791 VSS VDD sky130_fd_sc_hd__tapvpwrvgnd_1
XTAP_TAPCELL_ROW_45_792 VSS VDD sky130_fd_sc_hd__tapvpwrvgnd_1
XTAP_TAPCELL_ROW_45_793 VSS VDD sky130_fd_sc_hd__tapvpwrvgnd_1
XTAP_TAPCELL_ROW_45_794 VSS VDD sky130_fd_sc_hd__tapvpwrvgnd_1
XTAP_TAPCELL_ROW_45_795 VSS VDD sky130_fd_sc_hd__tapvpwrvgnd_1
XTAP_TAPCELL_ROW_45_796 VSS VDD sky130_fd_sc_hd__tapvpwrvgnd_1
XTAP_TAPCELL_ROW_45_797 VSS VDD sky130_fd_sc_hd__tapvpwrvgnd_1
XTAP_TAPCELL_ROW_45_798 VSS VDD sky130_fd_sc_hd__tapvpwrvgnd_1
XTAP_TAPCELL_ROW_46_799 VSS VDD sky130_fd_sc_hd__tapvpwrvgnd_1
XTAP_TAPCELL_ROW_46_800 VSS VDD sky130_fd_sc_hd__tapvpwrvgnd_1
XTAP_TAPCELL_ROW_46_801 VSS VDD sky130_fd_sc_hd__tapvpwrvgnd_1
XTAP_TAPCELL_ROW_46_802 VSS VDD sky130_fd_sc_hd__tapvpwrvgnd_1
XTAP_TAPCELL_ROW_46_803 VSS VDD sky130_fd_sc_hd__tapvpwrvgnd_1
XTAP_TAPCELL_ROW_46_804 VSS VDD sky130_fd_sc_hd__tapvpwrvgnd_1
XTAP_TAPCELL_ROW_46_805 VSS VDD sky130_fd_sc_hd__tapvpwrvgnd_1
XTAP_TAPCELL_ROW_46_806 VSS VDD sky130_fd_sc_hd__tapvpwrvgnd_1
XTAP_TAPCELL_ROW_46_807 VSS VDD sky130_fd_sc_hd__tapvpwrvgnd_1
XTAP_TAPCELL_ROW_46_808 VSS VDD sky130_fd_sc_hd__tapvpwrvgnd_1
XTAP_TAPCELL_ROW_46_809 VSS VDD sky130_fd_sc_hd__tapvpwrvgnd_1
XTAP_TAPCELL_ROW_46_810 VSS VDD sky130_fd_sc_hd__tapvpwrvgnd_1
XTAP_TAPCELL_ROW_46_811 VSS VDD sky130_fd_sc_hd__tapvpwrvgnd_1
XTAP_TAPCELL_ROW_46_812 VSS VDD sky130_fd_sc_hd__tapvpwrvgnd_1
XTAP_TAPCELL_ROW_46_813 VSS VDD sky130_fd_sc_hd__tapvpwrvgnd_1
XTAP_TAPCELL_ROW_46_814 VSS VDD sky130_fd_sc_hd__tapvpwrvgnd_1
XTAP_TAPCELL_ROW_46_815 VSS VDD sky130_fd_sc_hd__tapvpwrvgnd_1
XTAP_TAPCELL_ROW_47_816 VSS VDD sky130_fd_sc_hd__tapvpwrvgnd_1
XTAP_TAPCELL_ROW_47_817 VSS VDD sky130_fd_sc_hd__tapvpwrvgnd_1
XTAP_TAPCELL_ROW_47_818 VSS VDD sky130_fd_sc_hd__tapvpwrvgnd_1
XTAP_TAPCELL_ROW_47_819 VSS VDD sky130_fd_sc_hd__tapvpwrvgnd_1
XTAP_TAPCELL_ROW_47_820 VSS VDD sky130_fd_sc_hd__tapvpwrvgnd_1
XTAP_TAPCELL_ROW_47_821 VSS VDD sky130_fd_sc_hd__tapvpwrvgnd_1
XTAP_TAPCELL_ROW_47_822 VSS VDD sky130_fd_sc_hd__tapvpwrvgnd_1
XTAP_TAPCELL_ROW_47_823 VSS VDD sky130_fd_sc_hd__tapvpwrvgnd_1
XTAP_TAPCELL_ROW_47_824 VSS VDD sky130_fd_sc_hd__tapvpwrvgnd_1
XTAP_TAPCELL_ROW_47_825 VSS VDD sky130_fd_sc_hd__tapvpwrvgnd_1
XTAP_TAPCELL_ROW_47_826 VSS VDD sky130_fd_sc_hd__tapvpwrvgnd_1
XTAP_TAPCELL_ROW_47_827 VSS VDD sky130_fd_sc_hd__tapvpwrvgnd_1
XTAP_TAPCELL_ROW_47_828 VSS VDD sky130_fd_sc_hd__tapvpwrvgnd_1
XTAP_TAPCELL_ROW_47_829 VSS VDD sky130_fd_sc_hd__tapvpwrvgnd_1
XTAP_TAPCELL_ROW_47_830 VSS VDD sky130_fd_sc_hd__tapvpwrvgnd_1
XTAP_TAPCELL_ROW_47_831 VSS VDD sky130_fd_sc_hd__tapvpwrvgnd_1
XTAP_TAPCELL_ROW_47_832 VSS VDD sky130_fd_sc_hd__tapvpwrvgnd_1
XTAP_TAPCELL_ROW_48_833 VSS VDD sky130_fd_sc_hd__tapvpwrvgnd_1
XTAP_TAPCELL_ROW_48_834 VSS VDD sky130_fd_sc_hd__tapvpwrvgnd_1
XTAP_TAPCELL_ROW_48_835 VSS VDD sky130_fd_sc_hd__tapvpwrvgnd_1
XTAP_TAPCELL_ROW_48_836 VSS VDD sky130_fd_sc_hd__tapvpwrvgnd_1
XTAP_TAPCELL_ROW_48_837 VSS VDD sky130_fd_sc_hd__tapvpwrvgnd_1
XTAP_TAPCELL_ROW_48_838 VSS VDD sky130_fd_sc_hd__tapvpwrvgnd_1
XTAP_TAPCELL_ROW_48_839 VSS VDD sky130_fd_sc_hd__tapvpwrvgnd_1
XTAP_TAPCELL_ROW_48_840 VSS VDD sky130_fd_sc_hd__tapvpwrvgnd_1
XTAP_TAPCELL_ROW_48_841 VSS VDD sky130_fd_sc_hd__tapvpwrvgnd_1
XTAP_TAPCELL_ROW_48_842 VSS VDD sky130_fd_sc_hd__tapvpwrvgnd_1
XTAP_TAPCELL_ROW_48_843 VSS VDD sky130_fd_sc_hd__tapvpwrvgnd_1
XTAP_TAPCELL_ROW_48_844 VSS VDD sky130_fd_sc_hd__tapvpwrvgnd_1
XTAP_TAPCELL_ROW_48_845 VSS VDD sky130_fd_sc_hd__tapvpwrvgnd_1
XTAP_TAPCELL_ROW_48_846 VSS VDD sky130_fd_sc_hd__tapvpwrvgnd_1
XTAP_TAPCELL_ROW_48_847 VSS VDD sky130_fd_sc_hd__tapvpwrvgnd_1
XTAP_TAPCELL_ROW_48_848 VSS VDD sky130_fd_sc_hd__tapvpwrvgnd_1
XTAP_TAPCELL_ROW_48_849 VSS VDD sky130_fd_sc_hd__tapvpwrvgnd_1
XTAP_TAPCELL_ROW_49_850 VSS VDD sky130_fd_sc_hd__tapvpwrvgnd_1
XTAP_TAPCELL_ROW_49_851 VSS VDD sky130_fd_sc_hd__tapvpwrvgnd_1
XTAP_TAPCELL_ROW_49_852 VSS VDD sky130_fd_sc_hd__tapvpwrvgnd_1
XTAP_TAPCELL_ROW_49_853 VSS VDD sky130_fd_sc_hd__tapvpwrvgnd_1
XTAP_TAPCELL_ROW_49_854 VSS VDD sky130_fd_sc_hd__tapvpwrvgnd_1
XTAP_TAPCELL_ROW_49_855 VSS VDD sky130_fd_sc_hd__tapvpwrvgnd_1
XTAP_TAPCELL_ROW_49_856 VSS VDD sky130_fd_sc_hd__tapvpwrvgnd_1
XTAP_TAPCELL_ROW_49_857 VSS VDD sky130_fd_sc_hd__tapvpwrvgnd_1
XTAP_TAPCELL_ROW_49_858 VSS VDD sky130_fd_sc_hd__tapvpwrvgnd_1
XTAP_TAPCELL_ROW_49_859 VSS VDD sky130_fd_sc_hd__tapvpwrvgnd_1
XTAP_TAPCELL_ROW_49_860 VSS VDD sky130_fd_sc_hd__tapvpwrvgnd_1
XTAP_TAPCELL_ROW_49_861 VSS VDD sky130_fd_sc_hd__tapvpwrvgnd_1
XTAP_TAPCELL_ROW_49_862 VSS VDD sky130_fd_sc_hd__tapvpwrvgnd_1
XTAP_TAPCELL_ROW_49_863 VSS VDD sky130_fd_sc_hd__tapvpwrvgnd_1
XTAP_TAPCELL_ROW_49_864 VSS VDD sky130_fd_sc_hd__tapvpwrvgnd_1
XTAP_TAPCELL_ROW_49_865 VSS VDD sky130_fd_sc_hd__tapvpwrvgnd_1
XTAP_TAPCELL_ROW_49_866 VSS VDD sky130_fd_sc_hd__tapvpwrvgnd_1
XTAP_TAPCELL_ROW_50_867 VSS VDD sky130_fd_sc_hd__tapvpwrvgnd_1
XTAP_TAPCELL_ROW_50_868 VSS VDD sky130_fd_sc_hd__tapvpwrvgnd_1
XTAP_TAPCELL_ROW_50_869 VSS VDD sky130_fd_sc_hd__tapvpwrvgnd_1
XTAP_TAPCELL_ROW_50_870 VSS VDD sky130_fd_sc_hd__tapvpwrvgnd_1
XTAP_TAPCELL_ROW_50_871 VSS VDD sky130_fd_sc_hd__tapvpwrvgnd_1
XTAP_TAPCELL_ROW_50_872 VSS VDD sky130_fd_sc_hd__tapvpwrvgnd_1
XTAP_TAPCELL_ROW_50_873 VSS VDD sky130_fd_sc_hd__tapvpwrvgnd_1
XTAP_TAPCELL_ROW_50_874 VSS VDD sky130_fd_sc_hd__tapvpwrvgnd_1
XTAP_TAPCELL_ROW_50_875 VSS VDD sky130_fd_sc_hd__tapvpwrvgnd_1
XTAP_TAPCELL_ROW_50_876 VSS VDD sky130_fd_sc_hd__tapvpwrvgnd_1
XTAP_TAPCELL_ROW_50_877 VSS VDD sky130_fd_sc_hd__tapvpwrvgnd_1
XTAP_TAPCELL_ROW_50_878 VSS VDD sky130_fd_sc_hd__tapvpwrvgnd_1
XTAP_TAPCELL_ROW_50_879 VSS VDD sky130_fd_sc_hd__tapvpwrvgnd_1
XTAP_TAPCELL_ROW_50_880 VSS VDD sky130_fd_sc_hd__tapvpwrvgnd_1
XTAP_TAPCELL_ROW_50_881 VSS VDD sky130_fd_sc_hd__tapvpwrvgnd_1
XTAP_TAPCELL_ROW_50_882 VSS VDD sky130_fd_sc_hd__tapvpwrvgnd_1
XTAP_TAPCELL_ROW_50_883 VSS VDD sky130_fd_sc_hd__tapvpwrvgnd_1
XTAP_TAPCELL_ROW_51_884 VSS VDD sky130_fd_sc_hd__tapvpwrvgnd_1
XTAP_TAPCELL_ROW_51_885 VSS VDD sky130_fd_sc_hd__tapvpwrvgnd_1
XTAP_TAPCELL_ROW_51_886 VSS VDD sky130_fd_sc_hd__tapvpwrvgnd_1
XTAP_TAPCELL_ROW_51_887 VSS VDD sky130_fd_sc_hd__tapvpwrvgnd_1
XTAP_TAPCELL_ROW_51_888 VSS VDD sky130_fd_sc_hd__tapvpwrvgnd_1
XTAP_TAPCELL_ROW_51_889 VSS VDD sky130_fd_sc_hd__tapvpwrvgnd_1
XTAP_TAPCELL_ROW_51_890 VSS VDD sky130_fd_sc_hd__tapvpwrvgnd_1
XTAP_TAPCELL_ROW_51_891 VSS VDD sky130_fd_sc_hd__tapvpwrvgnd_1
XTAP_TAPCELL_ROW_51_892 VSS VDD sky130_fd_sc_hd__tapvpwrvgnd_1
XTAP_TAPCELL_ROW_51_893 VSS VDD sky130_fd_sc_hd__tapvpwrvgnd_1
XTAP_TAPCELL_ROW_51_894 VSS VDD sky130_fd_sc_hd__tapvpwrvgnd_1
XTAP_TAPCELL_ROW_51_895 VSS VDD sky130_fd_sc_hd__tapvpwrvgnd_1
XTAP_TAPCELL_ROW_51_896 VSS VDD sky130_fd_sc_hd__tapvpwrvgnd_1
XTAP_TAPCELL_ROW_51_897 VSS VDD sky130_fd_sc_hd__tapvpwrvgnd_1
XTAP_TAPCELL_ROW_51_898 VSS VDD sky130_fd_sc_hd__tapvpwrvgnd_1
XTAP_TAPCELL_ROW_51_899 VSS VDD sky130_fd_sc_hd__tapvpwrvgnd_1
XTAP_TAPCELL_ROW_51_900 VSS VDD sky130_fd_sc_hd__tapvpwrvgnd_1
XTAP_TAPCELL_ROW_52_901 VSS VDD sky130_fd_sc_hd__tapvpwrvgnd_1
XTAP_TAPCELL_ROW_52_902 VSS VDD sky130_fd_sc_hd__tapvpwrvgnd_1
XTAP_TAPCELL_ROW_52_903 VSS VDD sky130_fd_sc_hd__tapvpwrvgnd_1
XTAP_TAPCELL_ROW_52_904 VSS VDD sky130_fd_sc_hd__tapvpwrvgnd_1
XTAP_TAPCELL_ROW_52_905 VSS VDD sky130_fd_sc_hd__tapvpwrvgnd_1
XTAP_TAPCELL_ROW_52_906 VSS VDD sky130_fd_sc_hd__tapvpwrvgnd_1
XTAP_TAPCELL_ROW_52_907 VSS VDD sky130_fd_sc_hd__tapvpwrvgnd_1
XTAP_TAPCELL_ROW_52_908 VSS VDD sky130_fd_sc_hd__tapvpwrvgnd_1
XTAP_TAPCELL_ROW_52_909 VSS VDD sky130_fd_sc_hd__tapvpwrvgnd_1
XTAP_TAPCELL_ROW_52_910 VSS VDD sky130_fd_sc_hd__tapvpwrvgnd_1
XTAP_TAPCELL_ROW_52_911 VSS VDD sky130_fd_sc_hd__tapvpwrvgnd_1
XTAP_TAPCELL_ROW_52_912 VSS VDD sky130_fd_sc_hd__tapvpwrvgnd_1
XTAP_TAPCELL_ROW_52_913 VSS VDD sky130_fd_sc_hd__tapvpwrvgnd_1
XTAP_TAPCELL_ROW_52_914 VSS VDD sky130_fd_sc_hd__tapvpwrvgnd_1
XTAP_TAPCELL_ROW_52_915 VSS VDD sky130_fd_sc_hd__tapvpwrvgnd_1
XTAP_TAPCELL_ROW_52_916 VSS VDD sky130_fd_sc_hd__tapvpwrvgnd_1
XTAP_TAPCELL_ROW_52_917 VSS VDD sky130_fd_sc_hd__tapvpwrvgnd_1
XTAP_TAPCELL_ROW_53_918 VSS VDD sky130_fd_sc_hd__tapvpwrvgnd_1
XTAP_TAPCELL_ROW_53_919 VSS VDD sky130_fd_sc_hd__tapvpwrvgnd_1
XTAP_TAPCELL_ROW_53_920 VSS VDD sky130_fd_sc_hd__tapvpwrvgnd_1
XTAP_TAPCELL_ROW_53_921 VSS VDD sky130_fd_sc_hd__tapvpwrvgnd_1
XTAP_TAPCELL_ROW_53_922 VSS VDD sky130_fd_sc_hd__tapvpwrvgnd_1
XTAP_TAPCELL_ROW_53_923 VSS VDD sky130_fd_sc_hd__tapvpwrvgnd_1
XTAP_TAPCELL_ROW_53_924 VSS VDD sky130_fd_sc_hd__tapvpwrvgnd_1
XTAP_TAPCELL_ROW_53_925 VSS VDD sky130_fd_sc_hd__tapvpwrvgnd_1
XTAP_TAPCELL_ROW_53_926 VSS VDD sky130_fd_sc_hd__tapvpwrvgnd_1
XTAP_TAPCELL_ROW_53_927 VSS VDD sky130_fd_sc_hd__tapvpwrvgnd_1
XTAP_TAPCELL_ROW_53_928 VSS VDD sky130_fd_sc_hd__tapvpwrvgnd_1
XTAP_TAPCELL_ROW_53_929 VSS VDD sky130_fd_sc_hd__tapvpwrvgnd_1
XTAP_TAPCELL_ROW_53_930 VSS VDD sky130_fd_sc_hd__tapvpwrvgnd_1
XTAP_TAPCELL_ROW_53_931 VSS VDD sky130_fd_sc_hd__tapvpwrvgnd_1
XTAP_TAPCELL_ROW_53_932 VSS VDD sky130_fd_sc_hd__tapvpwrvgnd_1
XTAP_TAPCELL_ROW_53_933 VSS VDD sky130_fd_sc_hd__tapvpwrvgnd_1
XTAP_TAPCELL_ROW_53_934 VSS VDD sky130_fd_sc_hd__tapvpwrvgnd_1
XTAP_TAPCELL_ROW_54_935 VSS VDD sky130_fd_sc_hd__tapvpwrvgnd_1
XTAP_TAPCELL_ROW_54_936 VSS VDD sky130_fd_sc_hd__tapvpwrvgnd_1
XTAP_TAPCELL_ROW_54_937 VSS VDD sky130_fd_sc_hd__tapvpwrvgnd_1
XTAP_TAPCELL_ROW_54_938 VSS VDD sky130_fd_sc_hd__tapvpwrvgnd_1
XTAP_TAPCELL_ROW_54_939 VSS VDD sky130_fd_sc_hd__tapvpwrvgnd_1
XTAP_TAPCELL_ROW_54_940 VSS VDD sky130_fd_sc_hd__tapvpwrvgnd_1
XTAP_TAPCELL_ROW_54_941 VSS VDD sky130_fd_sc_hd__tapvpwrvgnd_1
XTAP_TAPCELL_ROW_54_942 VSS VDD sky130_fd_sc_hd__tapvpwrvgnd_1
XTAP_TAPCELL_ROW_54_943 VSS VDD sky130_fd_sc_hd__tapvpwrvgnd_1
XTAP_TAPCELL_ROW_54_944 VSS VDD sky130_fd_sc_hd__tapvpwrvgnd_1
XTAP_TAPCELL_ROW_54_945 VSS VDD sky130_fd_sc_hd__tapvpwrvgnd_1
XTAP_TAPCELL_ROW_54_946 VSS VDD sky130_fd_sc_hd__tapvpwrvgnd_1
XTAP_TAPCELL_ROW_54_947 VSS VDD sky130_fd_sc_hd__tapvpwrvgnd_1
XTAP_TAPCELL_ROW_54_948 VSS VDD sky130_fd_sc_hd__tapvpwrvgnd_1
XTAP_TAPCELL_ROW_54_949 VSS VDD sky130_fd_sc_hd__tapvpwrvgnd_1
XTAP_TAPCELL_ROW_54_950 VSS VDD sky130_fd_sc_hd__tapvpwrvgnd_1
XTAP_TAPCELL_ROW_54_951 VSS VDD sky130_fd_sc_hd__tapvpwrvgnd_1
XTAP_TAPCELL_ROW_55_952 VSS VDD sky130_fd_sc_hd__tapvpwrvgnd_1
XTAP_TAPCELL_ROW_55_953 VSS VDD sky130_fd_sc_hd__tapvpwrvgnd_1
XTAP_TAPCELL_ROW_55_954 VSS VDD sky130_fd_sc_hd__tapvpwrvgnd_1
XTAP_TAPCELL_ROW_55_955 VSS VDD sky130_fd_sc_hd__tapvpwrvgnd_1
XTAP_TAPCELL_ROW_55_956 VSS VDD sky130_fd_sc_hd__tapvpwrvgnd_1
XTAP_TAPCELL_ROW_55_957 VSS VDD sky130_fd_sc_hd__tapvpwrvgnd_1
XTAP_TAPCELL_ROW_55_958 VSS VDD sky130_fd_sc_hd__tapvpwrvgnd_1
XTAP_TAPCELL_ROW_55_959 VSS VDD sky130_fd_sc_hd__tapvpwrvgnd_1
XTAP_TAPCELL_ROW_55_960 VSS VDD sky130_fd_sc_hd__tapvpwrvgnd_1
XTAP_TAPCELL_ROW_55_961 VSS VDD sky130_fd_sc_hd__tapvpwrvgnd_1
XTAP_TAPCELL_ROW_55_962 VSS VDD sky130_fd_sc_hd__tapvpwrvgnd_1
XTAP_TAPCELL_ROW_55_963 VSS VDD sky130_fd_sc_hd__tapvpwrvgnd_1
XTAP_TAPCELL_ROW_55_964 VSS VDD sky130_fd_sc_hd__tapvpwrvgnd_1
XTAP_TAPCELL_ROW_55_965 VSS VDD sky130_fd_sc_hd__tapvpwrvgnd_1
XTAP_TAPCELL_ROW_55_966 VSS VDD sky130_fd_sc_hd__tapvpwrvgnd_1
XTAP_TAPCELL_ROW_55_967 VSS VDD sky130_fd_sc_hd__tapvpwrvgnd_1
XTAP_TAPCELL_ROW_55_968 VSS VDD sky130_fd_sc_hd__tapvpwrvgnd_1
XTAP_TAPCELL_ROW_56_969 VSS VDD sky130_fd_sc_hd__tapvpwrvgnd_1
XTAP_TAPCELL_ROW_56_970 VSS VDD sky130_fd_sc_hd__tapvpwrvgnd_1
XTAP_TAPCELL_ROW_56_971 VSS VDD sky130_fd_sc_hd__tapvpwrvgnd_1
XTAP_TAPCELL_ROW_56_972 VSS VDD sky130_fd_sc_hd__tapvpwrvgnd_1
XTAP_TAPCELL_ROW_56_973 VSS VDD sky130_fd_sc_hd__tapvpwrvgnd_1
XTAP_TAPCELL_ROW_56_974 VSS VDD sky130_fd_sc_hd__tapvpwrvgnd_1
XTAP_TAPCELL_ROW_56_975 VSS VDD sky130_fd_sc_hd__tapvpwrvgnd_1
XTAP_TAPCELL_ROW_56_976 VSS VDD sky130_fd_sc_hd__tapvpwrvgnd_1
XTAP_TAPCELL_ROW_56_977 VSS VDD sky130_fd_sc_hd__tapvpwrvgnd_1
XTAP_TAPCELL_ROW_56_978 VSS VDD sky130_fd_sc_hd__tapvpwrvgnd_1
XTAP_TAPCELL_ROW_56_979 VSS VDD sky130_fd_sc_hd__tapvpwrvgnd_1
XTAP_TAPCELL_ROW_56_980 VSS VDD sky130_fd_sc_hd__tapvpwrvgnd_1
XTAP_TAPCELL_ROW_56_981 VSS VDD sky130_fd_sc_hd__tapvpwrvgnd_1
XTAP_TAPCELL_ROW_56_982 VSS VDD sky130_fd_sc_hd__tapvpwrvgnd_1
XTAP_TAPCELL_ROW_56_983 VSS VDD sky130_fd_sc_hd__tapvpwrvgnd_1
XTAP_TAPCELL_ROW_56_984 VSS VDD sky130_fd_sc_hd__tapvpwrvgnd_1
XTAP_TAPCELL_ROW_56_985 VSS VDD sky130_fd_sc_hd__tapvpwrvgnd_1
XTAP_TAPCELL_ROW_57_986 VSS VDD sky130_fd_sc_hd__tapvpwrvgnd_1
XTAP_TAPCELL_ROW_57_987 VSS VDD sky130_fd_sc_hd__tapvpwrvgnd_1
XTAP_TAPCELL_ROW_57_988 VSS VDD sky130_fd_sc_hd__tapvpwrvgnd_1
XTAP_TAPCELL_ROW_57_989 VSS VDD sky130_fd_sc_hd__tapvpwrvgnd_1
XTAP_TAPCELL_ROW_57_990 VSS VDD sky130_fd_sc_hd__tapvpwrvgnd_1
XTAP_TAPCELL_ROW_57_991 VSS VDD sky130_fd_sc_hd__tapvpwrvgnd_1
XTAP_TAPCELL_ROW_57_992 VSS VDD sky130_fd_sc_hd__tapvpwrvgnd_1
XTAP_TAPCELL_ROW_57_993 VSS VDD sky130_fd_sc_hd__tapvpwrvgnd_1
XTAP_TAPCELL_ROW_57_994 VSS VDD sky130_fd_sc_hd__tapvpwrvgnd_1
XTAP_TAPCELL_ROW_57_995 VSS VDD sky130_fd_sc_hd__tapvpwrvgnd_1
XTAP_TAPCELL_ROW_57_996 VSS VDD sky130_fd_sc_hd__tapvpwrvgnd_1
XTAP_TAPCELL_ROW_57_997 VSS VDD sky130_fd_sc_hd__tapvpwrvgnd_1
XTAP_TAPCELL_ROW_57_998 VSS VDD sky130_fd_sc_hd__tapvpwrvgnd_1
XTAP_TAPCELL_ROW_57_999 VSS VDD sky130_fd_sc_hd__tapvpwrvgnd_1
XTAP_TAPCELL_ROW_57_1000 VSS VDD sky130_fd_sc_hd__tapvpwrvgnd_1
XTAP_TAPCELL_ROW_57_1001 VSS VDD sky130_fd_sc_hd__tapvpwrvgnd_1
XTAP_TAPCELL_ROW_57_1002 VSS VDD sky130_fd_sc_hd__tapvpwrvgnd_1
XTAP_TAPCELL_ROW_58_1003 VSS VDD sky130_fd_sc_hd__tapvpwrvgnd_1
XTAP_TAPCELL_ROW_58_1004 VSS VDD sky130_fd_sc_hd__tapvpwrvgnd_1
XTAP_TAPCELL_ROW_58_1005 VSS VDD sky130_fd_sc_hd__tapvpwrvgnd_1
XTAP_TAPCELL_ROW_58_1006 VSS VDD sky130_fd_sc_hd__tapvpwrvgnd_1
XTAP_TAPCELL_ROW_58_1007 VSS VDD sky130_fd_sc_hd__tapvpwrvgnd_1
XTAP_TAPCELL_ROW_58_1008 VSS VDD sky130_fd_sc_hd__tapvpwrvgnd_1
XTAP_TAPCELL_ROW_58_1009 VSS VDD sky130_fd_sc_hd__tapvpwrvgnd_1
XTAP_TAPCELL_ROW_58_1010 VSS VDD sky130_fd_sc_hd__tapvpwrvgnd_1
XTAP_TAPCELL_ROW_58_1011 VSS VDD sky130_fd_sc_hd__tapvpwrvgnd_1
XTAP_TAPCELL_ROW_58_1012 VSS VDD sky130_fd_sc_hd__tapvpwrvgnd_1
XTAP_TAPCELL_ROW_58_1013 VSS VDD sky130_fd_sc_hd__tapvpwrvgnd_1
XTAP_TAPCELL_ROW_58_1014 VSS VDD sky130_fd_sc_hd__tapvpwrvgnd_1
XTAP_TAPCELL_ROW_58_1015 VSS VDD sky130_fd_sc_hd__tapvpwrvgnd_1
XTAP_TAPCELL_ROW_58_1016 VSS VDD sky130_fd_sc_hd__tapvpwrvgnd_1
XTAP_TAPCELL_ROW_58_1017 VSS VDD sky130_fd_sc_hd__tapvpwrvgnd_1
XTAP_TAPCELL_ROW_58_1018 VSS VDD sky130_fd_sc_hd__tapvpwrvgnd_1
XTAP_TAPCELL_ROW_58_1019 VSS VDD sky130_fd_sc_hd__tapvpwrvgnd_1
XTAP_TAPCELL_ROW_59_1020 VSS VDD sky130_fd_sc_hd__tapvpwrvgnd_1
XTAP_TAPCELL_ROW_59_1021 VSS VDD sky130_fd_sc_hd__tapvpwrvgnd_1
XTAP_TAPCELL_ROW_59_1022 VSS VDD sky130_fd_sc_hd__tapvpwrvgnd_1
XTAP_TAPCELL_ROW_59_1023 VSS VDD sky130_fd_sc_hd__tapvpwrvgnd_1
XTAP_TAPCELL_ROW_59_1024 VSS VDD sky130_fd_sc_hd__tapvpwrvgnd_1
XTAP_TAPCELL_ROW_59_1025 VSS VDD sky130_fd_sc_hd__tapvpwrvgnd_1
XTAP_TAPCELL_ROW_59_1026 VSS VDD sky130_fd_sc_hd__tapvpwrvgnd_1
XTAP_TAPCELL_ROW_59_1027 VSS VDD sky130_fd_sc_hd__tapvpwrvgnd_1
XTAP_TAPCELL_ROW_59_1028 VSS VDD sky130_fd_sc_hd__tapvpwrvgnd_1
XTAP_TAPCELL_ROW_59_1029 VSS VDD sky130_fd_sc_hd__tapvpwrvgnd_1
XTAP_TAPCELL_ROW_59_1030 VSS VDD sky130_fd_sc_hd__tapvpwrvgnd_1
XTAP_TAPCELL_ROW_59_1031 VSS VDD sky130_fd_sc_hd__tapvpwrvgnd_1
XTAP_TAPCELL_ROW_59_1032 VSS VDD sky130_fd_sc_hd__tapvpwrvgnd_1
XTAP_TAPCELL_ROW_59_1033 VSS VDD sky130_fd_sc_hd__tapvpwrvgnd_1
XTAP_TAPCELL_ROW_59_1034 VSS VDD sky130_fd_sc_hd__tapvpwrvgnd_1
XTAP_TAPCELL_ROW_59_1035 VSS VDD sky130_fd_sc_hd__tapvpwrvgnd_1
XTAP_TAPCELL_ROW_59_1036 VSS VDD sky130_fd_sc_hd__tapvpwrvgnd_1
XTAP_TAPCELL_ROW_60_1037 VSS VDD sky130_fd_sc_hd__tapvpwrvgnd_1
XTAP_TAPCELL_ROW_60_1038 VSS VDD sky130_fd_sc_hd__tapvpwrvgnd_1
XTAP_TAPCELL_ROW_60_1039 VSS VDD sky130_fd_sc_hd__tapvpwrvgnd_1
XTAP_TAPCELL_ROW_60_1040 VSS VDD sky130_fd_sc_hd__tapvpwrvgnd_1
XTAP_TAPCELL_ROW_60_1041 VSS VDD sky130_fd_sc_hd__tapvpwrvgnd_1
XTAP_TAPCELL_ROW_60_1042 VSS VDD sky130_fd_sc_hd__tapvpwrvgnd_1
XTAP_TAPCELL_ROW_60_1043 VSS VDD sky130_fd_sc_hd__tapvpwrvgnd_1
XTAP_TAPCELL_ROW_60_1044 VSS VDD sky130_fd_sc_hd__tapvpwrvgnd_1
XTAP_TAPCELL_ROW_60_1045 VSS VDD sky130_fd_sc_hd__tapvpwrvgnd_1
XTAP_TAPCELL_ROW_60_1046 VSS VDD sky130_fd_sc_hd__tapvpwrvgnd_1
XTAP_TAPCELL_ROW_60_1047 VSS VDD sky130_fd_sc_hd__tapvpwrvgnd_1
XTAP_TAPCELL_ROW_60_1048 VSS VDD sky130_fd_sc_hd__tapvpwrvgnd_1
XTAP_TAPCELL_ROW_60_1049 VSS VDD sky130_fd_sc_hd__tapvpwrvgnd_1
XTAP_TAPCELL_ROW_60_1050 VSS VDD sky130_fd_sc_hd__tapvpwrvgnd_1
XTAP_TAPCELL_ROW_60_1051 VSS VDD sky130_fd_sc_hd__tapvpwrvgnd_1
XTAP_TAPCELL_ROW_60_1052 VSS VDD sky130_fd_sc_hd__tapvpwrvgnd_1
XTAP_TAPCELL_ROW_60_1053 VSS VDD sky130_fd_sc_hd__tapvpwrvgnd_1
XTAP_TAPCELL_ROW_61_1054 VSS VDD sky130_fd_sc_hd__tapvpwrvgnd_1
XTAP_TAPCELL_ROW_61_1055 VSS VDD sky130_fd_sc_hd__tapvpwrvgnd_1
XTAP_TAPCELL_ROW_61_1056 VSS VDD sky130_fd_sc_hd__tapvpwrvgnd_1
XTAP_TAPCELL_ROW_61_1057 VSS VDD sky130_fd_sc_hd__tapvpwrvgnd_1
XTAP_TAPCELL_ROW_61_1058 VSS VDD sky130_fd_sc_hd__tapvpwrvgnd_1
XTAP_TAPCELL_ROW_61_1059 VSS VDD sky130_fd_sc_hd__tapvpwrvgnd_1
XTAP_TAPCELL_ROW_61_1060 VSS VDD sky130_fd_sc_hd__tapvpwrvgnd_1
XTAP_TAPCELL_ROW_61_1061 VSS VDD sky130_fd_sc_hd__tapvpwrvgnd_1
XTAP_TAPCELL_ROW_61_1062 VSS VDD sky130_fd_sc_hd__tapvpwrvgnd_1
XTAP_TAPCELL_ROW_61_1063 VSS VDD sky130_fd_sc_hd__tapvpwrvgnd_1
XTAP_TAPCELL_ROW_61_1064 VSS VDD sky130_fd_sc_hd__tapvpwrvgnd_1
XTAP_TAPCELL_ROW_61_1065 VSS VDD sky130_fd_sc_hd__tapvpwrvgnd_1
XTAP_TAPCELL_ROW_61_1066 VSS VDD sky130_fd_sc_hd__tapvpwrvgnd_1
XTAP_TAPCELL_ROW_61_1067 VSS VDD sky130_fd_sc_hd__tapvpwrvgnd_1
XTAP_TAPCELL_ROW_61_1068 VSS VDD sky130_fd_sc_hd__tapvpwrvgnd_1
XTAP_TAPCELL_ROW_61_1069 VSS VDD sky130_fd_sc_hd__tapvpwrvgnd_1
XTAP_TAPCELL_ROW_61_1070 VSS VDD sky130_fd_sc_hd__tapvpwrvgnd_1
XTAP_TAPCELL_ROW_62_1071 VSS VDD sky130_fd_sc_hd__tapvpwrvgnd_1
XTAP_TAPCELL_ROW_62_1072 VSS VDD sky130_fd_sc_hd__tapvpwrvgnd_1
XTAP_TAPCELL_ROW_62_1073 VSS VDD sky130_fd_sc_hd__tapvpwrvgnd_1
XTAP_TAPCELL_ROW_62_1074 VSS VDD sky130_fd_sc_hd__tapvpwrvgnd_1
XTAP_TAPCELL_ROW_62_1075 VSS VDD sky130_fd_sc_hd__tapvpwrvgnd_1
XTAP_TAPCELL_ROW_62_1076 VSS VDD sky130_fd_sc_hd__tapvpwrvgnd_1
XTAP_TAPCELL_ROW_62_1077 VSS VDD sky130_fd_sc_hd__tapvpwrvgnd_1
XTAP_TAPCELL_ROW_62_1078 VSS VDD sky130_fd_sc_hd__tapvpwrvgnd_1
XTAP_TAPCELL_ROW_62_1079 VSS VDD sky130_fd_sc_hd__tapvpwrvgnd_1
XTAP_TAPCELL_ROW_62_1080 VSS VDD sky130_fd_sc_hd__tapvpwrvgnd_1
XTAP_TAPCELL_ROW_62_1081 VSS VDD sky130_fd_sc_hd__tapvpwrvgnd_1
XTAP_TAPCELL_ROW_62_1082 VSS VDD sky130_fd_sc_hd__tapvpwrvgnd_1
XTAP_TAPCELL_ROW_62_1083 VSS VDD sky130_fd_sc_hd__tapvpwrvgnd_1
XTAP_TAPCELL_ROW_62_1084 VSS VDD sky130_fd_sc_hd__tapvpwrvgnd_1
XTAP_TAPCELL_ROW_62_1085 VSS VDD sky130_fd_sc_hd__tapvpwrvgnd_1
XTAP_TAPCELL_ROW_62_1086 VSS VDD sky130_fd_sc_hd__tapvpwrvgnd_1
XTAP_TAPCELL_ROW_62_1087 VSS VDD sky130_fd_sc_hd__tapvpwrvgnd_1
XTAP_TAPCELL_ROW_63_1088 VSS VDD sky130_fd_sc_hd__tapvpwrvgnd_1
XTAP_TAPCELL_ROW_63_1089 VSS VDD sky130_fd_sc_hd__tapvpwrvgnd_1
XTAP_TAPCELL_ROW_63_1090 VSS VDD sky130_fd_sc_hd__tapvpwrvgnd_1
XTAP_TAPCELL_ROW_63_1091 VSS VDD sky130_fd_sc_hd__tapvpwrvgnd_1
XTAP_TAPCELL_ROW_63_1092 VSS VDD sky130_fd_sc_hd__tapvpwrvgnd_1
XTAP_TAPCELL_ROW_63_1093 VSS VDD sky130_fd_sc_hd__tapvpwrvgnd_1
XTAP_TAPCELL_ROW_63_1094 VSS VDD sky130_fd_sc_hd__tapvpwrvgnd_1
XTAP_TAPCELL_ROW_63_1095 VSS VDD sky130_fd_sc_hd__tapvpwrvgnd_1
XTAP_TAPCELL_ROW_63_1096 VSS VDD sky130_fd_sc_hd__tapvpwrvgnd_1
XTAP_TAPCELL_ROW_63_1097 VSS VDD sky130_fd_sc_hd__tapvpwrvgnd_1
XTAP_TAPCELL_ROW_63_1098 VSS VDD sky130_fd_sc_hd__tapvpwrvgnd_1
XTAP_TAPCELL_ROW_63_1099 VSS VDD sky130_fd_sc_hd__tapvpwrvgnd_1
XTAP_TAPCELL_ROW_63_1100 VSS VDD sky130_fd_sc_hd__tapvpwrvgnd_1
XTAP_TAPCELL_ROW_63_1101 VSS VDD sky130_fd_sc_hd__tapvpwrvgnd_1
XTAP_TAPCELL_ROW_63_1102 VSS VDD sky130_fd_sc_hd__tapvpwrvgnd_1
XTAP_TAPCELL_ROW_63_1103 VSS VDD sky130_fd_sc_hd__tapvpwrvgnd_1
XTAP_TAPCELL_ROW_63_1104 VSS VDD sky130_fd_sc_hd__tapvpwrvgnd_1
XTAP_TAPCELL_ROW_64_1105 VSS VDD sky130_fd_sc_hd__tapvpwrvgnd_1
XTAP_TAPCELL_ROW_64_1106 VSS VDD sky130_fd_sc_hd__tapvpwrvgnd_1
XTAP_TAPCELL_ROW_64_1107 VSS VDD sky130_fd_sc_hd__tapvpwrvgnd_1
XTAP_TAPCELL_ROW_64_1108 VSS VDD sky130_fd_sc_hd__tapvpwrvgnd_1
XTAP_TAPCELL_ROW_64_1109 VSS VDD sky130_fd_sc_hd__tapvpwrvgnd_1
XTAP_TAPCELL_ROW_64_1110 VSS VDD sky130_fd_sc_hd__tapvpwrvgnd_1
XTAP_TAPCELL_ROW_64_1111 VSS VDD sky130_fd_sc_hd__tapvpwrvgnd_1
XTAP_TAPCELL_ROW_64_1112 VSS VDD sky130_fd_sc_hd__tapvpwrvgnd_1
XTAP_TAPCELL_ROW_64_1113 VSS VDD sky130_fd_sc_hd__tapvpwrvgnd_1
XTAP_TAPCELL_ROW_64_1114 VSS VDD sky130_fd_sc_hd__tapvpwrvgnd_1
XTAP_TAPCELL_ROW_64_1115 VSS VDD sky130_fd_sc_hd__tapvpwrvgnd_1
XTAP_TAPCELL_ROW_64_1116 VSS VDD sky130_fd_sc_hd__tapvpwrvgnd_1
XTAP_TAPCELL_ROW_64_1117 VSS VDD sky130_fd_sc_hd__tapvpwrvgnd_1
XTAP_TAPCELL_ROW_64_1118 VSS VDD sky130_fd_sc_hd__tapvpwrvgnd_1
XTAP_TAPCELL_ROW_64_1119 VSS VDD sky130_fd_sc_hd__tapvpwrvgnd_1
XTAP_TAPCELL_ROW_64_1120 VSS VDD sky130_fd_sc_hd__tapvpwrvgnd_1
XTAP_TAPCELL_ROW_64_1121 VSS VDD sky130_fd_sc_hd__tapvpwrvgnd_1
XTAP_TAPCELL_ROW_65_1122 VSS VDD sky130_fd_sc_hd__tapvpwrvgnd_1
XTAP_TAPCELL_ROW_65_1123 VSS VDD sky130_fd_sc_hd__tapvpwrvgnd_1
XTAP_TAPCELL_ROW_65_1124 VSS VDD sky130_fd_sc_hd__tapvpwrvgnd_1
XTAP_TAPCELL_ROW_65_1125 VSS VDD sky130_fd_sc_hd__tapvpwrvgnd_1
XTAP_TAPCELL_ROW_65_1126 VSS VDD sky130_fd_sc_hd__tapvpwrvgnd_1
XTAP_TAPCELL_ROW_65_1127 VSS VDD sky130_fd_sc_hd__tapvpwrvgnd_1
XTAP_TAPCELL_ROW_65_1128 VSS VDD sky130_fd_sc_hd__tapvpwrvgnd_1
XTAP_TAPCELL_ROW_65_1129 VSS VDD sky130_fd_sc_hd__tapvpwrvgnd_1
XTAP_TAPCELL_ROW_65_1130 VSS VDD sky130_fd_sc_hd__tapvpwrvgnd_1
XTAP_TAPCELL_ROW_65_1131 VSS VDD sky130_fd_sc_hd__tapvpwrvgnd_1
XTAP_TAPCELL_ROW_65_1132 VSS VDD sky130_fd_sc_hd__tapvpwrvgnd_1
XTAP_TAPCELL_ROW_65_1133 VSS VDD sky130_fd_sc_hd__tapvpwrvgnd_1
XTAP_TAPCELL_ROW_65_1134 VSS VDD sky130_fd_sc_hd__tapvpwrvgnd_1
XTAP_TAPCELL_ROW_65_1135 VSS VDD sky130_fd_sc_hd__tapvpwrvgnd_1
XTAP_TAPCELL_ROW_65_1136 VSS VDD sky130_fd_sc_hd__tapvpwrvgnd_1
XTAP_TAPCELL_ROW_65_1137 VSS VDD sky130_fd_sc_hd__tapvpwrvgnd_1
XTAP_TAPCELL_ROW_65_1138 VSS VDD sky130_fd_sc_hd__tapvpwrvgnd_1
XTAP_TAPCELL_ROW_66_1139 VSS VDD sky130_fd_sc_hd__tapvpwrvgnd_1
XTAP_TAPCELL_ROW_66_1140 VSS VDD sky130_fd_sc_hd__tapvpwrvgnd_1
XTAP_TAPCELL_ROW_66_1141 VSS VDD sky130_fd_sc_hd__tapvpwrvgnd_1
XTAP_TAPCELL_ROW_66_1142 VSS VDD sky130_fd_sc_hd__tapvpwrvgnd_1
XTAP_TAPCELL_ROW_66_1143 VSS VDD sky130_fd_sc_hd__tapvpwrvgnd_1
XTAP_TAPCELL_ROW_66_1144 VSS VDD sky130_fd_sc_hd__tapvpwrvgnd_1
XTAP_TAPCELL_ROW_66_1145 VSS VDD sky130_fd_sc_hd__tapvpwrvgnd_1
XTAP_TAPCELL_ROW_66_1146 VSS VDD sky130_fd_sc_hd__tapvpwrvgnd_1
XTAP_TAPCELL_ROW_66_1147 VSS VDD sky130_fd_sc_hd__tapvpwrvgnd_1
XTAP_TAPCELL_ROW_66_1148 VSS VDD sky130_fd_sc_hd__tapvpwrvgnd_1
XTAP_TAPCELL_ROW_66_1149 VSS VDD sky130_fd_sc_hd__tapvpwrvgnd_1
XTAP_TAPCELL_ROW_66_1150 VSS VDD sky130_fd_sc_hd__tapvpwrvgnd_1
XTAP_TAPCELL_ROW_66_1151 VSS VDD sky130_fd_sc_hd__tapvpwrvgnd_1
XTAP_TAPCELL_ROW_66_1152 VSS VDD sky130_fd_sc_hd__tapvpwrvgnd_1
XTAP_TAPCELL_ROW_66_1153 VSS VDD sky130_fd_sc_hd__tapvpwrvgnd_1
XTAP_TAPCELL_ROW_66_1154 VSS VDD sky130_fd_sc_hd__tapvpwrvgnd_1
XTAP_TAPCELL_ROW_66_1155 VSS VDD sky130_fd_sc_hd__tapvpwrvgnd_1
XTAP_TAPCELL_ROW_67_1156 VSS VDD sky130_fd_sc_hd__tapvpwrvgnd_1
XTAP_TAPCELL_ROW_67_1157 VSS VDD sky130_fd_sc_hd__tapvpwrvgnd_1
XTAP_TAPCELL_ROW_67_1158 VSS VDD sky130_fd_sc_hd__tapvpwrvgnd_1
XTAP_TAPCELL_ROW_67_1159 VSS VDD sky130_fd_sc_hd__tapvpwrvgnd_1
XTAP_TAPCELL_ROW_67_1160 VSS VDD sky130_fd_sc_hd__tapvpwrvgnd_1
XTAP_TAPCELL_ROW_67_1161 VSS VDD sky130_fd_sc_hd__tapvpwrvgnd_1
XTAP_TAPCELL_ROW_67_1162 VSS VDD sky130_fd_sc_hd__tapvpwrvgnd_1
XTAP_TAPCELL_ROW_67_1163 VSS VDD sky130_fd_sc_hd__tapvpwrvgnd_1
XTAP_TAPCELL_ROW_67_1164 VSS VDD sky130_fd_sc_hd__tapvpwrvgnd_1
XTAP_TAPCELL_ROW_67_1165 VSS VDD sky130_fd_sc_hd__tapvpwrvgnd_1
XTAP_TAPCELL_ROW_67_1166 VSS VDD sky130_fd_sc_hd__tapvpwrvgnd_1
XTAP_TAPCELL_ROW_67_1167 VSS VDD sky130_fd_sc_hd__tapvpwrvgnd_1
XTAP_TAPCELL_ROW_67_1168 VSS VDD sky130_fd_sc_hd__tapvpwrvgnd_1
XTAP_TAPCELL_ROW_67_1169 VSS VDD sky130_fd_sc_hd__tapvpwrvgnd_1
XTAP_TAPCELL_ROW_67_1170 VSS VDD sky130_fd_sc_hd__tapvpwrvgnd_1
XTAP_TAPCELL_ROW_67_1171 VSS VDD sky130_fd_sc_hd__tapvpwrvgnd_1
XTAP_TAPCELL_ROW_67_1172 VSS VDD sky130_fd_sc_hd__tapvpwrvgnd_1
XTAP_TAPCELL_ROW_68_1173 VSS VDD sky130_fd_sc_hd__tapvpwrvgnd_1
XTAP_TAPCELL_ROW_68_1174 VSS VDD sky130_fd_sc_hd__tapvpwrvgnd_1
XTAP_TAPCELL_ROW_68_1175 VSS VDD sky130_fd_sc_hd__tapvpwrvgnd_1
XTAP_TAPCELL_ROW_68_1176 VSS VDD sky130_fd_sc_hd__tapvpwrvgnd_1
XTAP_TAPCELL_ROW_68_1177 VSS VDD sky130_fd_sc_hd__tapvpwrvgnd_1
XTAP_TAPCELL_ROW_68_1178 VSS VDD sky130_fd_sc_hd__tapvpwrvgnd_1
XTAP_TAPCELL_ROW_68_1179 VSS VDD sky130_fd_sc_hd__tapvpwrvgnd_1
XTAP_TAPCELL_ROW_68_1180 VSS VDD sky130_fd_sc_hd__tapvpwrvgnd_1
XTAP_TAPCELL_ROW_68_1181 VSS VDD sky130_fd_sc_hd__tapvpwrvgnd_1
XTAP_TAPCELL_ROW_68_1182 VSS VDD sky130_fd_sc_hd__tapvpwrvgnd_1
XTAP_TAPCELL_ROW_68_1183 VSS VDD sky130_fd_sc_hd__tapvpwrvgnd_1
XTAP_TAPCELL_ROW_68_1184 VSS VDD sky130_fd_sc_hd__tapvpwrvgnd_1
XTAP_TAPCELL_ROW_68_1185 VSS VDD sky130_fd_sc_hd__tapvpwrvgnd_1
XTAP_TAPCELL_ROW_68_1186 VSS VDD sky130_fd_sc_hd__tapvpwrvgnd_1
XTAP_TAPCELL_ROW_68_1187 VSS VDD sky130_fd_sc_hd__tapvpwrvgnd_1
XTAP_TAPCELL_ROW_68_1188 VSS VDD sky130_fd_sc_hd__tapvpwrvgnd_1
XTAP_TAPCELL_ROW_68_1189 VSS VDD sky130_fd_sc_hd__tapvpwrvgnd_1
XTAP_TAPCELL_ROW_69_1190 VSS VDD sky130_fd_sc_hd__tapvpwrvgnd_1
XTAP_TAPCELL_ROW_69_1191 VSS VDD sky130_fd_sc_hd__tapvpwrvgnd_1
XTAP_TAPCELL_ROW_69_1192 VSS VDD sky130_fd_sc_hd__tapvpwrvgnd_1
XTAP_TAPCELL_ROW_69_1193 VSS VDD sky130_fd_sc_hd__tapvpwrvgnd_1
XTAP_TAPCELL_ROW_69_1194 VSS VDD sky130_fd_sc_hd__tapvpwrvgnd_1
XTAP_TAPCELL_ROW_69_1195 VSS VDD sky130_fd_sc_hd__tapvpwrvgnd_1
XTAP_TAPCELL_ROW_69_1196 VSS VDD sky130_fd_sc_hd__tapvpwrvgnd_1
XTAP_TAPCELL_ROW_69_1197 VSS VDD sky130_fd_sc_hd__tapvpwrvgnd_1
XTAP_TAPCELL_ROW_69_1198 VSS VDD sky130_fd_sc_hd__tapvpwrvgnd_1
XTAP_TAPCELL_ROW_69_1199 VSS VDD sky130_fd_sc_hd__tapvpwrvgnd_1
XTAP_TAPCELL_ROW_69_1200 VSS VDD sky130_fd_sc_hd__tapvpwrvgnd_1
XTAP_TAPCELL_ROW_69_1201 VSS VDD sky130_fd_sc_hd__tapvpwrvgnd_1
XTAP_TAPCELL_ROW_69_1202 VSS VDD sky130_fd_sc_hd__tapvpwrvgnd_1
XTAP_TAPCELL_ROW_69_1203 VSS VDD sky130_fd_sc_hd__tapvpwrvgnd_1
XTAP_TAPCELL_ROW_69_1204 VSS VDD sky130_fd_sc_hd__tapvpwrvgnd_1
XTAP_TAPCELL_ROW_69_1205 VSS VDD sky130_fd_sc_hd__tapvpwrvgnd_1
XTAP_TAPCELL_ROW_69_1206 VSS VDD sky130_fd_sc_hd__tapvpwrvgnd_1
XTAP_TAPCELL_ROW_70_1207 VSS VDD sky130_fd_sc_hd__tapvpwrvgnd_1
XTAP_TAPCELL_ROW_70_1208 VSS VDD sky130_fd_sc_hd__tapvpwrvgnd_1
XTAP_TAPCELL_ROW_70_1209 VSS VDD sky130_fd_sc_hd__tapvpwrvgnd_1
XTAP_TAPCELL_ROW_70_1210 VSS VDD sky130_fd_sc_hd__tapvpwrvgnd_1
XTAP_TAPCELL_ROW_70_1211 VSS VDD sky130_fd_sc_hd__tapvpwrvgnd_1
XTAP_TAPCELL_ROW_70_1212 VSS VDD sky130_fd_sc_hd__tapvpwrvgnd_1
XTAP_TAPCELL_ROW_70_1213 VSS VDD sky130_fd_sc_hd__tapvpwrvgnd_1
XTAP_TAPCELL_ROW_70_1214 VSS VDD sky130_fd_sc_hd__tapvpwrvgnd_1
XTAP_TAPCELL_ROW_70_1215 VSS VDD sky130_fd_sc_hd__tapvpwrvgnd_1
XTAP_TAPCELL_ROW_70_1216 VSS VDD sky130_fd_sc_hd__tapvpwrvgnd_1
XTAP_TAPCELL_ROW_70_1217 VSS VDD sky130_fd_sc_hd__tapvpwrvgnd_1
XTAP_TAPCELL_ROW_70_1218 VSS VDD sky130_fd_sc_hd__tapvpwrvgnd_1
XTAP_TAPCELL_ROW_70_1219 VSS VDD sky130_fd_sc_hd__tapvpwrvgnd_1
XTAP_TAPCELL_ROW_70_1220 VSS VDD sky130_fd_sc_hd__tapvpwrvgnd_1
XTAP_TAPCELL_ROW_70_1221 VSS VDD sky130_fd_sc_hd__tapvpwrvgnd_1
XTAP_TAPCELL_ROW_70_1222 VSS VDD sky130_fd_sc_hd__tapvpwrvgnd_1
XTAP_TAPCELL_ROW_70_1223 VSS VDD sky130_fd_sc_hd__tapvpwrvgnd_1
XTAP_TAPCELL_ROW_71_1224 VSS VDD sky130_fd_sc_hd__tapvpwrvgnd_1
XTAP_TAPCELL_ROW_71_1225 VSS VDD sky130_fd_sc_hd__tapvpwrvgnd_1
XTAP_TAPCELL_ROW_71_1226 VSS VDD sky130_fd_sc_hd__tapvpwrvgnd_1
XTAP_TAPCELL_ROW_71_1227 VSS VDD sky130_fd_sc_hd__tapvpwrvgnd_1
XTAP_TAPCELL_ROW_71_1228 VSS VDD sky130_fd_sc_hd__tapvpwrvgnd_1
XTAP_TAPCELL_ROW_71_1229 VSS VDD sky130_fd_sc_hd__tapvpwrvgnd_1
XTAP_TAPCELL_ROW_71_1230 VSS VDD sky130_fd_sc_hd__tapvpwrvgnd_1
XTAP_TAPCELL_ROW_71_1231 VSS VDD sky130_fd_sc_hd__tapvpwrvgnd_1
XTAP_TAPCELL_ROW_71_1232 VSS VDD sky130_fd_sc_hd__tapvpwrvgnd_1
XTAP_TAPCELL_ROW_71_1233 VSS VDD sky130_fd_sc_hd__tapvpwrvgnd_1
XTAP_TAPCELL_ROW_71_1234 VSS VDD sky130_fd_sc_hd__tapvpwrvgnd_1
XTAP_TAPCELL_ROW_71_1235 VSS VDD sky130_fd_sc_hd__tapvpwrvgnd_1
XTAP_TAPCELL_ROW_71_1236 VSS VDD sky130_fd_sc_hd__tapvpwrvgnd_1
XTAP_TAPCELL_ROW_71_1237 VSS VDD sky130_fd_sc_hd__tapvpwrvgnd_1
XTAP_TAPCELL_ROW_71_1238 VSS VDD sky130_fd_sc_hd__tapvpwrvgnd_1
XTAP_TAPCELL_ROW_71_1239 VSS VDD sky130_fd_sc_hd__tapvpwrvgnd_1
XTAP_TAPCELL_ROW_71_1240 VSS VDD sky130_fd_sc_hd__tapvpwrvgnd_1
XTAP_TAPCELL_ROW_72_1241 VSS VDD sky130_fd_sc_hd__tapvpwrvgnd_1
XTAP_TAPCELL_ROW_72_1242 VSS VDD sky130_fd_sc_hd__tapvpwrvgnd_1
XTAP_TAPCELL_ROW_72_1243 VSS VDD sky130_fd_sc_hd__tapvpwrvgnd_1
XTAP_TAPCELL_ROW_72_1244 VSS VDD sky130_fd_sc_hd__tapvpwrvgnd_1
XTAP_TAPCELL_ROW_72_1245 VSS VDD sky130_fd_sc_hd__tapvpwrvgnd_1
XTAP_TAPCELL_ROW_72_1246 VSS VDD sky130_fd_sc_hd__tapvpwrvgnd_1
XTAP_TAPCELL_ROW_72_1247 VSS VDD sky130_fd_sc_hd__tapvpwrvgnd_1
XTAP_TAPCELL_ROW_72_1248 VSS VDD sky130_fd_sc_hd__tapvpwrvgnd_1
XTAP_TAPCELL_ROW_72_1249 VSS VDD sky130_fd_sc_hd__tapvpwrvgnd_1
XTAP_TAPCELL_ROW_72_1250 VSS VDD sky130_fd_sc_hd__tapvpwrvgnd_1
XTAP_TAPCELL_ROW_72_1251 VSS VDD sky130_fd_sc_hd__tapvpwrvgnd_1
XTAP_TAPCELL_ROW_72_1252 VSS VDD sky130_fd_sc_hd__tapvpwrvgnd_1
XTAP_TAPCELL_ROW_72_1253 VSS VDD sky130_fd_sc_hd__tapvpwrvgnd_1
XTAP_TAPCELL_ROW_72_1254 VSS VDD sky130_fd_sc_hd__tapvpwrvgnd_1
XTAP_TAPCELL_ROW_72_1255 VSS VDD sky130_fd_sc_hd__tapvpwrvgnd_1
XTAP_TAPCELL_ROW_72_1256 VSS VDD sky130_fd_sc_hd__tapvpwrvgnd_1
XTAP_TAPCELL_ROW_72_1257 VSS VDD sky130_fd_sc_hd__tapvpwrvgnd_1
XTAP_TAPCELL_ROW_73_1258 VSS VDD sky130_fd_sc_hd__tapvpwrvgnd_1
XTAP_TAPCELL_ROW_73_1259 VSS VDD sky130_fd_sc_hd__tapvpwrvgnd_1
XTAP_TAPCELL_ROW_73_1260 VSS VDD sky130_fd_sc_hd__tapvpwrvgnd_1
XTAP_TAPCELL_ROW_73_1261 VSS VDD sky130_fd_sc_hd__tapvpwrvgnd_1
XTAP_TAPCELL_ROW_73_1262 VSS VDD sky130_fd_sc_hd__tapvpwrvgnd_1
XTAP_TAPCELL_ROW_73_1263 VSS VDD sky130_fd_sc_hd__tapvpwrvgnd_1
XTAP_TAPCELL_ROW_73_1264 VSS VDD sky130_fd_sc_hd__tapvpwrvgnd_1
XTAP_TAPCELL_ROW_73_1265 VSS VDD sky130_fd_sc_hd__tapvpwrvgnd_1
XTAP_TAPCELL_ROW_73_1266 VSS VDD sky130_fd_sc_hd__tapvpwrvgnd_1
XTAP_TAPCELL_ROW_73_1267 VSS VDD sky130_fd_sc_hd__tapvpwrvgnd_1
XTAP_TAPCELL_ROW_73_1268 VSS VDD sky130_fd_sc_hd__tapvpwrvgnd_1
XTAP_TAPCELL_ROW_73_1269 VSS VDD sky130_fd_sc_hd__tapvpwrvgnd_1
XTAP_TAPCELL_ROW_73_1270 VSS VDD sky130_fd_sc_hd__tapvpwrvgnd_1
XTAP_TAPCELL_ROW_73_1271 VSS VDD sky130_fd_sc_hd__tapvpwrvgnd_1
XTAP_TAPCELL_ROW_73_1272 VSS VDD sky130_fd_sc_hd__tapvpwrvgnd_1
XTAP_TAPCELL_ROW_73_1273 VSS VDD sky130_fd_sc_hd__tapvpwrvgnd_1
XTAP_TAPCELL_ROW_73_1274 VSS VDD sky130_fd_sc_hd__tapvpwrvgnd_1
XTAP_TAPCELL_ROW_74_1275 VSS VDD sky130_fd_sc_hd__tapvpwrvgnd_1
XTAP_TAPCELL_ROW_74_1276 VSS VDD sky130_fd_sc_hd__tapvpwrvgnd_1
XTAP_TAPCELL_ROW_74_1277 VSS VDD sky130_fd_sc_hd__tapvpwrvgnd_1
XTAP_TAPCELL_ROW_74_1278 VSS VDD sky130_fd_sc_hd__tapvpwrvgnd_1
XTAP_TAPCELL_ROW_74_1279 VSS VDD sky130_fd_sc_hd__tapvpwrvgnd_1
XTAP_TAPCELL_ROW_74_1280 VSS VDD sky130_fd_sc_hd__tapvpwrvgnd_1
XTAP_TAPCELL_ROW_74_1281 VSS VDD sky130_fd_sc_hd__tapvpwrvgnd_1
XTAP_TAPCELL_ROW_74_1282 VSS VDD sky130_fd_sc_hd__tapvpwrvgnd_1
XTAP_TAPCELL_ROW_74_1283 VSS VDD sky130_fd_sc_hd__tapvpwrvgnd_1
XTAP_TAPCELL_ROW_74_1284 VSS VDD sky130_fd_sc_hd__tapvpwrvgnd_1
XTAP_TAPCELL_ROW_74_1285 VSS VDD sky130_fd_sc_hd__tapvpwrvgnd_1
XTAP_TAPCELL_ROW_74_1286 VSS VDD sky130_fd_sc_hd__tapvpwrvgnd_1
XTAP_TAPCELL_ROW_74_1287 VSS VDD sky130_fd_sc_hd__tapvpwrvgnd_1
XTAP_TAPCELL_ROW_74_1288 VSS VDD sky130_fd_sc_hd__tapvpwrvgnd_1
XTAP_TAPCELL_ROW_74_1289 VSS VDD sky130_fd_sc_hd__tapvpwrvgnd_1
XTAP_TAPCELL_ROW_74_1290 VSS VDD sky130_fd_sc_hd__tapvpwrvgnd_1
XTAP_TAPCELL_ROW_74_1291 VSS VDD sky130_fd_sc_hd__tapvpwrvgnd_1
XTAP_TAPCELL_ROW_75_1292 VSS VDD sky130_fd_sc_hd__tapvpwrvgnd_1
XTAP_TAPCELL_ROW_75_1293 VSS VDD sky130_fd_sc_hd__tapvpwrvgnd_1
XTAP_TAPCELL_ROW_75_1294 VSS VDD sky130_fd_sc_hd__tapvpwrvgnd_1
XTAP_TAPCELL_ROW_75_1295 VSS VDD sky130_fd_sc_hd__tapvpwrvgnd_1
XTAP_TAPCELL_ROW_75_1296 VSS VDD sky130_fd_sc_hd__tapvpwrvgnd_1
XTAP_TAPCELL_ROW_75_1297 VSS VDD sky130_fd_sc_hd__tapvpwrvgnd_1
XTAP_TAPCELL_ROW_75_1298 VSS VDD sky130_fd_sc_hd__tapvpwrvgnd_1
XTAP_TAPCELL_ROW_75_1299 VSS VDD sky130_fd_sc_hd__tapvpwrvgnd_1
XTAP_TAPCELL_ROW_75_1300 VSS VDD sky130_fd_sc_hd__tapvpwrvgnd_1
XTAP_TAPCELL_ROW_75_1301 VSS VDD sky130_fd_sc_hd__tapvpwrvgnd_1
XTAP_TAPCELL_ROW_75_1302 VSS VDD sky130_fd_sc_hd__tapvpwrvgnd_1
XTAP_TAPCELL_ROW_75_1303 VSS VDD sky130_fd_sc_hd__tapvpwrvgnd_1
XTAP_TAPCELL_ROW_75_1304 VSS VDD sky130_fd_sc_hd__tapvpwrvgnd_1
XTAP_TAPCELL_ROW_75_1305 VSS VDD sky130_fd_sc_hd__tapvpwrvgnd_1
XTAP_TAPCELL_ROW_75_1306 VSS VDD sky130_fd_sc_hd__tapvpwrvgnd_1
XTAP_TAPCELL_ROW_75_1307 VSS VDD sky130_fd_sc_hd__tapvpwrvgnd_1
XTAP_TAPCELL_ROW_75_1308 VSS VDD sky130_fd_sc_hd__tapvpwrvgnd_1
XTAP_TAPCELL_ROW_76_1309 VSS VDD sky130_fd_sc_hd__tapvpwrvgnd_1
XTAP_TAPCELL_ROW_76_1310 VSS VDD sky130_fd_sc_hd__tapvpwrvgnd_1
XTAP_TAPCELL_ROW_76_1311 VSS VDD sky130_fd_sc_hd__tapvpwrvgnd_1
XTAP_TAPCELL_ROW_76_1312 VSS VDD sky130_fd_sc_hd__tapvpwrvgnd_1
XTAP_TAPCELL_ROW_76_1313 VSS VDD sky130_fd_sc_hd__tapvpwrvgnd_1
XTAP_TAPCELL_ROW_76_1314 VSS VDD sky130_fd_sc_hd__tapvpwrvgnd_1
XTAP_TAPCELL_ROW_76_1315 VSS VDD sky130_fd_sc_hd__tapvpwrvgnd_1
XTAP_TAPCELL_ROW_76_1316 VSS VDD sky130_fd_sc_hd__tapvpwrvgnd_1
XTAP_TAPCELL_ROW_76_1317 VSS VDD sky130_fd_sc_hd__tapvpwrvgnd_1
XTAP_TAPCELL_ROW_76_1318 VSS VDD sky130_fd_sc_hd__tapvpwrvgnd_1
XTAP_TAPCELL_ROW_76_1319 VSS VDD sky130_fd_sc_hd__tapvpwrvgnd_1
XTAP_TAPCELL_ROW_76_1320 VSS VDD sky130_fd_sc_hd__tapvpwrvgnd_1
XTAP_TAPCELL_ROW_76_1321 VSS VDD sky130_fd_sc_hd__tapvpwrvgnd_1
XTAP_TAPCELL_ROW_76_1322 VSS VDD sky130_fd_sc_hd__tapvpwrvgnd_1
XTAP_TAPCELL_ROW_76_1323 VSS VDD sky130_fd_sc_hd__tapvpwrvgnd_1
XTAP_TAPCELL_ROW_76_1324 VSS VDD sky130_fd_sc_hd__tapvpwrvgnd_1
XTAP_TAPCELL_ROW_76_1325 VSS VDD sky130_fd_sc_hd__tapvpwrvgnd_1
XTAP_TAPCELL_ROW_77_1326 VSS VDD sky130_fd_sc_hd__tapvpwrvgnd_1
XTAP_TAPCELL_ROW_77_1327 VSS VDD sky130_fd_sc_hd__tapvpwrvgnd_1
XTAP_TAPCELL_ROW_77_1328 VSS VDD sky130_fd_sc_hd__tapvpwrvgnd_1
XTAP_TAPCELL_ROW_77_1329 VSS VDD sky130_fd_sc_hd__tapvpwrvgnd_1
XTAP_TAPCELL_ROW_77_1330 VSS VDD sky130_fd_sc_hd__tapvpwrvgnd_1
XTAP_TAPCELL_ROW_77_1331 VSS VDD sky130_fd_sc_hd__tapvpwrvgnd_1
XTAP_TAPCELL_ROW_77_1332 VSS VDD sky130_fd_sc_hd__tapvpwrvgnd_1
XTAP_TAPCELL_ROW_77_1333 VSS VDD sky130_fd_sc_hd__tapvpwrvgnd_1
XTAP_TAPCELL_ROW_77_1334 VSS VDD sky130_fd_sc_hd__tapvpwrvgnd_1
XTAP_TAPCELL_ROW_77_1335 VSS VDD sky130_fd_sc_hd__tapvpwrvgnd_1
XTAP_TAPCELL_ROW_77_1336 VSS VDD sky130_fd_sc_hd__tapvpwrvgnd_1
XTAP_TAPCELL_ROW_77_1337 VSS VDD sky130_fd_sc_hd__tapvpwrvgnd_1
XTAP_TAPCELL_ROW_77_1338 VSS VDD sky130_fd_sc_hd__tapvpwrvgnd_1
XTAP_TAPCELL_ROW_77_1339 VSS VDD sky130_fd_sc_hd__tapvpwrvgnd_1
XTAP_TAPCELL_ROW_77_1340 VSS VDD sky130_fd_sc_hd__tapvpwrvgnd_1
XTAP_TAPCELL_ROW_77_1341 VSS VDD sky130_fd_sc_hd__tapvpwrvgnd_1
XTAP_TAPCELL_ROW_77_1342 VSS VDD sky130_fd_sc_hd__tapvpwrvgnd_1
XTAP_TAPCELL_ROW_78_1343 VSS VDD sky130_fd_sc_hd__tapvpwrvgnd_1
XTAP_TAPCELL_ROW_78_1344 VSS VDD sky130_fd_sc_hd__tapvpwrvgnd_1
XTAP_TAPCELL_ROW_78_1345 VSS VDD sky130_fd_sc_hd__tapvpwrvgnd_1
XTAP_TAPCELL_ROW_78_1346 VSS VDD sky130_fd_sc_hd__tapvpwrvgnd_1
XTAP_TAPCELL_ROW_78_1347 VSS VDD sky130_fd_sc_hd__tapvpwrvgnd_1
XTAP_TAPCELL_ROW_78_1348 VSS VDD sky130_fd_sc_hd__tapvpwrvgnd_1
XTAP_TAPCELL_ROW_78_1349 VSS VDD sky130_fd_sc_hd__tapvpwrvgnd_1
XTAP_TAPCELL_ROW_78_1350 VSS VDD sky130_fd_sc_hd__tapvpwrvgnd_1
XTAP_TAPCELL_ROW_78_1351 VSS VDD sky130_fd_sc_hd__tapvpwrvgnd_1
XTAP_TAPCELL_ROW_78_1352 VSS VDD sky130_fd_sc_hd__tapvpwrvgnd_1
XTAP_TAPCELL_ROW_78_1353 VSS VDD sky130_fd_sc_hd__tapvpwrvgnd_1
XTAP_TAPCELL_ROW_78_1354 VSS VDD sky130_fd_sc_hd__tapvpwrvgnd_1
XTAP_TAPCELL_ROW_78_1355 VSS VDD sky130_fd_sc_hd__tapvpwrvgnd_1
XTAP_TAPCELL_ROW_78_1356 VSS VDD sky130_fd_sc_hd__tapvpwrvgnd_1
XTAP_TAPCELL_ROW_78_1357 VSS VDD sky130_fd_sc_hd__tapvpwrvgnd_1
XTAP_TAPCELL_ROW_78_1358 VSS VDD sky130_fd_sc_hd__tapvpwrvgnd_1
XTAP_TAPCELL_ROW_78_1359 VSS VDD sky130_fd_sc_hd__tapvpwrvgnd_1
XTAP_TAPCELL_ROW_79_1360 VSS VDD sky130_fd_sc_hd__tapvpwrvgnd_1
XTAP_TAPCELL_ROW_79_1361 VSS VDD sky130_fd_sc_hd__tapvpwrvgnd_1
XTAP_TAPCELL_ROW_79_1362 VSS VDD sky130_fd_sc_hd__tapvpwrvgnd_1
XTAP_TAPCELL_ROW_79_1363 VSS VDD sky130_fd_sc_hd__tapvpwrvgnd_1
XTAP_TAPCELL_ROW_79_1364 VSS VDD sky130_fd_sc_hd__tapvpwrvgnd_1
XTAP_TAPCELL_ROW_79_1365 VSS VDD sky130_fd_sc_hd__tapvpwrvgnd_1
XTAP_TAPCELL_ROW_79_1366 VSS VDD sky130_fd_sc_hd__tapvpwrvgnd_1
XTAP_TAPCELL_ROW_79_1367 VSS VDD sky130_fd_sc_hd__tapvpwrvgnd_1
XTAP_TAPCELL_ROW_79_1368 VSS VDD sky130_fd_sc_hd__tapvpwrvgnd_1
XTAP_TAPCELL_ROW_79_1369 VSS VDD sky130_fd_sc_hd__tapvpwrvgnd_1
XTAP_TAPCELL_ROW_79_1370 VSS VDD sky130_fd_sc_hd__tapvpwrvgnd_1
XTAP_TAPCELL_ROW_79_1371 VSS VDD sky130_fd_sc_hd__tapvpwrvgnd_1
XTAP_TAPCELL_ROW_79_1372 VSS VDD sky130_fd_sc_hd__tapvpwrvgnd_1
XTAP_TAPCELL_ROW_79_1373 VSS VDD sky130_fd_sc_hd__tapvpwrvgnd_1
XTAP_TAPCELL_ROW_79_1374 VSS VDD sky130_fd_sc_hd__tapvpwrvgnd_1
XTAP_TAPCELL_ROW_79_1375 VSS VDD sky130_fd_sc_hd__tapvpwrvgnd_1
XTAP_TAPCELL_ROW_79_1376 VSS VDD sky130_fd_sc_hd__tapvpwrvgnd_1
XTAP_TAPCELL_ROW_80_1377 VSS VDD sky130_fd_sc_hd__tapvpwrvgnd_1
XTAP_TAPCELL_ROW_80_1378 VSS VDD sky130_fd_sc_hd__tapvpwrvgnd_1
XTAP_TAPCELL_ROW_80_1379 VSS VDD sky130_fd_sc_hd__tapvpwrvgnd_1
XTAP_TAPCELL_ROW_80_1380 VSS VDD sky130_fd_sc_hd__tapvpwrvgnd_1
XTAP_TAPCELL_ROW_80_1381 VSS VDD sky130_fd_sc_hd__tapvpwrvgnd_1
XTAP_TAPCELL_ROW_80_1382 VSS VDD sky130_fd_sc_hd__tapvpwrvgnd_1
XTAP_TAPCELL_ROW_80_1383 VSS VDD sky130_fd_sc_hd__tapvpwrvgnd_1
XTAP_TAPCELL_ROW_80_1384 VSS VDD sky130_fd_sc_hd__tapvpwrvgnd_1
XTAP_TAPCELL_ROW_80_1385 VSS VDD sky130_fd_sc_hd__tapvpwrvgnd_1
XTAP_TAPCELL_ROW_80_1386 VSS VDD sky130_fd_sc_hd__tapvpwrvgnd_1
XTAP_TAPCELL_ROW_80_1387 VSS VDD sky130_fd_sc_hd__tapvpwrvgnd_1
XTAP_TAPCELL_ROW_80_1388 VSS VDD sky130_fd_sc_hd__tapvpwrvgnd_1
XTAP_TAPCELL_ROW_80_1389 VSS VDD sky130_fd_sc_hd__tapvpwrvgnd_1
XTAP_TAPCELL_ROW_80_1390 VSS VDD sky130_fd_sc_hd__tapvpwrvgnd_1
XTAP_TAPCELL_ROW_80_1391 VSS VDD sky130_fd_sc_hd__tapvpwrvgnd_1
XTAP_TAPCELL_ROW_80_1392 VSS VDD sky130_fd_sc_hd__tapvpwrvgnd_1
XTAP_TAPCELL_ROW_80_1393 VSS VDD sky130_fd_sc_hd__tapvpwrvgnd_1
XTAP_TAPCELL_ROW_81_1394 VSS VDD sky130_fd_sc_hd__tapvpwrvgnd_1
XTAP_TAPCELL_ROW_81_1395 VSS VDD sky130_fd_sc_hd__tapvpwrvgnd_1
XTAP_TAPCELL_ROW_81_1396 VSS VDD sky130_fd_sc_hd__tapvpwrvgnd_1
XTAP_TAPCELL_ROW_81_1397 VSS VDD sky130_fd_sc_hd__tapvpwrvgnd_1
XTAP_TAPCELL_ROW_81_1398 VSS VDD sky130_fd_sc_hd__tapvpwrvgnd_1
XTAP_TAPCELL_ROW_81_1399 VSS VDD sky130_fd_sc_hd__tapvpwrvgnd_1
XTAP_TAPCELL_ROW_81_1400 VSS VDD sky130_fd_sc_hd__tapvpwrvgnd_1
XTAP_TAPCELL_ROW_81_1401 VSS VDD sky130_fd_sc_hd__tapvpwrvgnd_1
XTAP_TAPCELL_ROW_81_1402 VSS VDD sky130_fd_sc_hd__tapvpwrvgnd_1
XTAP_TAPCELL_ROW_81_1403 VSS VDD sky130_fd_sc_hd__tapvpwrvgnd_1
XTAP_TAPCELL_ROW_81_1404 VSS VDD sky130_fd_sc_hd__tapvpwrvgnd_1
XTAP_TAPCELL_ROW_81_1405 VSS VDD sky130_fd_sc_hd__tapvpwrvgnd_1
XTAP_TAPCELL_ROW_81_1406 VSS VDD sky130_fd_sc_hd__tapvpwrvgnd_1
XTAP_TAPCELL_ROW_81_1407 VSS VDD sky130_fd_sc_hd__tapvpwrvgnd_1
XTAP_TAPCELL_ROW_81_1408 VSS VDD sky130_fd_sc_hd__tapvpwrvgnd_1
XTAP_TAPCELL_ROW_81_1409 VSS VDD sky130_fd_sc_hd__tapvpwrvgnd_1
XTAP_TAPCELL_ROW_81_1410 VSS VDD sky130_fd_sc_hd__tapvpwrvgnd_1
XTAP_TAPCELL_ROW_82_1411 VSS VDD sky130_fd_sc_hd__tapvpwrvgnd_1
XTAP_TAPCELL_ROW_82_1412 VSS VDD sky130_fd_sc_hd__tapvpwrvgnd_1
XTAP_TAPCELL_ROW_82_1413 VSS VDD sky130_fd_sc_hd__tapvpwrvgnd_1
XTAP_TAPCELL_ROW_82_1414 VSS VDD sky130_fd_sc_hd__tapvpwrvgnd_1
XTAP_TAPCELL_ROW_82_1415 VSS VDD sky130_fd_sc_hd__tapvpwrvgnd_1
XTAP_TAPCELL_ROW_82_1416 VSS VDD sky130_fd_sc_hd__tapvpwrvgnd_1
XTAP_TAPCELL_ROW_82_1417 VSS VDD sky130_fd_sc_hd__tapvpwrvgnd_1
XTAP_TAPCELL_ROW_82_1418 VSS VDD sky130_fd_sc_hd__tapvpwrvgnd_1
XTAP_TAPCELL_ROW_82_1419 VSS VDD sky130_fd_sc_hd__tapvpwrvgnd_1
XTAP_TAPCELL_ROW_82_1420 VSS VDD sky130_fd_sc_hd__tapvpwrvgnd_1
XTAP_TAPCELL_ROW_82_1421 VSS VDD sky130_fd_sc_hd__tapvpwrvgnd_1
XTAP_TAPCELL_ROW_82_1422 VSS VDD sky130_fd_sc_hd__tapvpwrvgnd_1
XTAP_TAPCELL_ROW_82_1423 VSS VDD sky130_fd_sc_hd__tapvpwrvgnd_1
XTAP_TAPCELL_ROW_82_1424 VSS VDD sky130_fd_sc_hd__tapvpwrvgnd_1
XTAP_TAPCELL_ROW_82_1425 VSS VDD sky130_fd_sc_hd__tapvpwrvgnd_1
XTAP_TAPCELL_ROW_82_1426 VSS VDD sky130_fd_sc_hd__tapvpwrvgnd_1
XTAP_TAPCELL_ROW_82_1427 VSS VDD sky130_fd_sc_hd__tapvpwrvgnd_1
XTAP_TAPCELL_ROW_83_1428 VSS VDD sky130_fd_sc_hd__tapvpwrvgnd_1
XTAP_TAPCELL_ROW_83_1429 VSS VDD sky130_fd_sc_hd__tapvpwrvgnd_1
XTAP_TAPCELL_ROW_83_1430 VSS VDD sky130_fd_sc_hd__tapvpwrvgnd_1
XTAP_TAPCELL_ROW_83_1431 VSS VDD sky130_fd_sc_hd__tapvpwrvgnd_1
XTAP_TAPCELL_ROW_83_1432 VSS VDD sky130_fd_sc_hd__tapvpwrvgnd_1
XTAP_TAPCELL_ROW_83_1433 VSS VDD sky130_fd_sc_hd__tapvpwrvgnd_1
XTAP_TAPCELL_ROW_83_1434 VSS VDD sky130_fd_sc_hd__tapvpwrvgnd_1
XTAP_TAPCELL_ROW_83_1435 VSS VDD sky130_fd_sc_hd__tapvpwrvgnd_1
XTAP_TAPCELL_ROW_83_1436 VSS VDD sky130_fd_sc_hd__tapvpwrvgnd_1
XTAP_TAPCELL_ROW_83_1437 VSS VDD sky130_fd_sc_hd__tapvpwrvgnd_1
XTAP_TAPCELL_ROW_83_1438 VSS VDD sky130_fd_sc_hd__tapvpwrvgnd_1
XTAP_TAPCELL_ROW_83_1439 VSS VDD sky130_fd_sc_hd__tapvpwrvgnd_1
XTAP_TAPCELL_ROW_83_1440 VSS VDD sky130_fd_sc_hd__tapvpwrvgnd_1
XTAP_TAPCELL_ROW_83_1441 VSS VDD sky130_fd_sc_hd__tapvpwrvgnd_1
XTAP_TAPCELL_ROW_83_1442 VSS VDD sky130_fd_sc_hd__tapvpwrvgnd_1
XTAP_TAPCELL_ROW_83_1443 VSS VDD sky130_fd_sc_hd__tapvpwrvgnd_1
XTAP_TAPCELL_ROW_83_1444 VSS VDD sky130_fd_sc_hd__tapvpwrvgnd_1
XTAP_TAPCELL_ROW_84_1445 VSS VDD sky130_fd_sc_hd__tapvpwrvgnd_1
XTAP_TAPCELL_ROW_84_1446 VSS VDD sky130_fd_sc_hd__tapvpwrvgnd_1
XTAP_TAPCELL_ROW_84_1447 VSS VDD sky130_fd_sc_hd__tapvpwrvgnd_1
XTAP_TAPCELL_ROW_84_1448 VSS VDD sky130_fd_sc_hd__tapvpwrvgnd_1
XTAP_TAPCELL_ROW_84_1449 VSS VDD sky130_fd_sc_hd__tapvpwrvgnd_1
XTAP_TAPCELL_ROW_84_1450 VSS VDD sky130_fd_sc_hd__tapvpwrvgnd_1
XTAP_TAPCELL_ROW_84_1451 VSS VDD sky130_fd_sc_hd__tapvpwrvgnd_1
XTAP_TAPCELL_ROW_84_1452 VSS VDD sky130_fd_sc_hd__tapvpwrvgnd_1
XTAP_TAPCELL_ROW_84_1453 VSS VDD sky130_fd_sc_hd__tapvpwrvgnd_1
XTAP_TAPCELL_ROW_84_1454 VSS VDD sky130_fd_sc_hd__tapvpwrvgnd_1
XTAP_TAPCELL_ROW_84_1455 VSS VDD sky130_fd_sc_hd__tapvpwrvgnd_1
XTAP_TAPCELL_ROW_84_1456 VSS VDD sky130_fd_sc_hd__tapvpwrvgnd_1
XTAP_TAPCELL_ROW_84_1457 VSS VDD sky130_fd_sc_hd__tapvpwrvgnd_1
XTAP_TAPCELL_ROW_84_1458 VSS VDD sky130_fd_sc_hd__tapvpwrvgnd_1
XTAP_TAPCELL_ROW_84_1459 VSS VDD sky130_fd_sc_hd__tapvpwrvgnd_1
XTAP_TAPCELL_ROW_84_1460 VSS VDD sky130_fd_sc_hd__tapvpwrvgnd_1
XTAP_TAPCELL_ROW_84_1461 VSS VDD sky130_fd_sc_hd__tapvpwrvgnd_1
XTAP_TAPCELL_ROW_85_1462 VSS VDD sky130_fd_sc_hd__tapvpwrvgnd_1
XTAP_TAPCELL_ROW_85_1463 VSS VDD sky130_fd_sc_hd__tapvpwrvgnd_1
XTAP_TAPCELL_ROW_85_1464 VSS VDD sky130_fd_sc_hd__tapvpwrvgnd_1
XTAP_TAPCELL_ROW_85_1465 VSS VDD sky130_fd_sc_hd__tapvpwrvgnd_1
XTAP_TAPCELL_ROW_85_1466 VSS VDD sky130_fd_sc_hd__tapvpwrvgnd_1
XTAP_TAPCELL_ROW_85_1467 VSS VDD sky130_fd_sc_hd__tapvpwrvgnd_1
XTAP_TAPCELL_ROW_85_1468 VSS VDD sky130_fd_sc_hd__tapvpwrvgnd_1
XTAP_TAPCELL_ROW_85_1469 VSS VDD sky130_fd_sc_hd__tapvpwrvgnd_1
XTAP_TAPCELL_ROW_85_1470 VSS VDD sky130_fd_sc_hd__tapvpwrvgnd_1
XTAP_TAPCELL_ROW_85_1471 VSS VDD sky130_fd_sc_hd__tapvpwrvgnd_1
XTAP_TAPCELL_ROW_85_1472 VSS VDD sky130_fd_sc_hd__tapvpwrvgnd_1
XTAP_TAPCELL_ROW_85_1473 VSS VDD sky130_fd_sc_hd__tapvpwrvgnd_1
XTAP_TAPCELL_ROW_85_1474 VSS VDD sky130_fd_sc_hd__tapvpwrvgnd_1
XTAP_TAPCELL_ROW_85_1475 VSS VDD sky130_fd_sc_hd__tapvpwrvgnd_1
XTAP_TAPCELL_ROW_85_1476 VSS VDD sky130_fd_sc_hd__tapvpwrvgnd_1
XTAP_TAPCELL_ROW_85_1477 VSS VDD sky130_fd_sc_hd__tapvpwrvgnd_1
XTAP_TAPCELL_ROW_85_1478 VSS VDD sky130_fd_sc_hd__tapvpwrvgnd_1
XTAP_TAPCELL_ROW_86_1479 VSS VDD sky130_fd_sc_hd__tapvpwrvgnd_1
XTAP_TAPCELL_ROW_86_1480 VSS VDD sky130_fd_sc_hd__tapvpwrvgnd_1
XTAP_TAPCELL_ROW_86_1481 VSS VDD sky130_fd_sc_hd__tapvpwrvgnd_1
XTAP_TAPCELL_ROW_86_1482 VSS VDD sky130_fd_sc_hd__tapvpwrvgnd_1
XTAP_TAPCELL_ROW_86_1483 VSS VDD sky130_fd_sc_hd__tapvpwrvgnd_1
XTAP_TAPCELL_ROW_86_1484 VSS VDD sky130_fd_sc_hd__tapvpwrvgnd_1
XTAP_TAPCELL_ROW_86_1485 VSS VDD sky130_fd_sc_hd__tapvpwrvgnd_1
XTAP_TAPCELL_ROW_86_1486 VSS VDD sky130_fd_sc_hd__tapvpwrvgnd_1
XTAP_TAPCELL_ROW_86_1487 VSS VDD sky130_fd_sc_hd__tapvpwrvgnd_1
XTAP_TAPCELL_ROW_86_1488 VSS VDD sky130_fd_sc_hd__tapvpwrvgnd_1
XTAP_TAPCELL_ROW_86_1489 VSS VDD sky130_fd_sc_hd__tapvpwrvgnd_1
XTAP_TAPCELL_ROW_86_1490 VSS VDD sky130_fd_sc_hd__tapvpwrvgnd_1
XTAP_TAPCELL_ROW_86_1491 VSS VDD sky130_fd_sc_hd__tapvpwrvgnd_1
XTAP_TAPCELL_ROW_86_1492 VSS VDD sky130_fd_sc_hd__tapvpwrvgnd_1
XTAP_TAPCELL_ROW_86_1493 VSS VDD sky130_fd_sc_hd__tapvpwrvgnd_1
XTAP_TAPCELL_ROW_86_1494 VSS VDD sky130_fd_sc_hd__tapvpwrvgnd_1
XTAP_TAPCELL_ROW_86_1495 VSS VDD sky130_fd_sc_hd__tapvpwrvgnd_1
XTAP_TAPCELL_ROW_87_1496 VSS VDD sky130_fd_sc_hd__tapvpwrvgnd_1
XTAP_TAPCELL_ROW_87_1497 VSS VDD sky130_fd_sc_hd__tapvpwrvgnd_1
XTAP_TAPCELL_ROW_87_1498 VSS VDD sky130_fd_sc_hd__tapvpwrvgnd_1
XTAP_TAPCELL_ROW_87_1499 VSS VDD sky130_fd_sc_hd__tapvpwrvgnd_1
XTAP_TAPCELL_ROW_87_1500 VSS VDD sky130_fd_sc_hd__tapvpwrvgnd_1
XTAP_TAPCELL_ROW_87_1501 VSS VDD sky130_fd_sc_hd__tapvpwrvgnd_1
XTAP_TAPCELL_ROW_87_1502 VSS VDD sky130_fd_sc_hd__tapvpwrvgnd_1
XTAP_TAPCELL_ROW_87_1503 VSS VDD sky130_fd_sc_hd__tapvpwrvgnd_1
XTAP_TAPCELL_ROW_87_1504 VSS VDD sky130_fd_sc_hd__tapvpwrvgnd_1
XTAP_TAPCELL_ROW_87_1505 VSS VDD sky130_fd_sc_hd__tapvpwrvgnd_1
XTAP_TAPCELL_ROW_87_1506 VSS VDD sky130_fd_sc_hd__tapvpwrvgnd_1
XTAP_TAPCELL_ROW_87_1507 VSS VDD sky130_fd_sc_hd__tapvpwrvgnd_1
XTAP_TAPCELL_ROW_87_1508 VSS VDD sky130_fd_sc_hd__tapvpwrvgnd_1
XTAP_TAPCELL_ROW_87_1509 VSS VDD sky130_fd_sc_hd__tapvpwrvgnd_1
XTAP_TAPCELL_ROW_87_1510 VSS VDD sky130_fd_sc_hd__tapvpwrvgnd_1
XTAP_TAPCELL_ROW_87_1511 VSS VDD sky130_fd_sc_hd__tapvpwrvgnd_1
XTAP_TAPCELL_ROW_87_1512 VSS VDD sky130_fd_sc_hd__tapvpwrvgnd_1
XTAP_TAPCELL_ROW_88_1513 VSS VDD sky130_fd_sc_hd__tapvpwrvgnd_1
XTAP_TAPCELL_ROW_88_1514 VSS VDD sky130_fd_sc_hd__tapvpwrvgnd_1
XTAP_TAPCELL_ROW_88_1515 VSS VDD sky130_fd_sc_hd__tapvpwrvgnd_1
XTAP_TAPCELL_ROW_88_1516 VSS VDD sky130_fd_sc_hd__tapvpwrvgnd_1
XTAP_TAPCELL_ROW_88_1517 VSS VDD sky130_fd_sc_hd__tapvpwrvgnd_1
XTAP_TAPCELL_ROW_88_1518 VSS VDD sky130_fd_sc_hd__tapvpwrvgnd_1
XTAP_TAPCELL_ROW_88_1519 VSS VDD sky130_fd_sc_hd__tapvpwrvgnd_1
XTAP_TAPCELL_ROW_88_1520 VSS VDD sky130_fd_sc_hd__tapvpwrvgnd_1
XTAP_TAPCELL_ROW_88_1521 VSS VDD sky130_fd_sc_hd__tapvpwrvgnd_1
XTAP_TAPCELL_ROW_88_1522 VSS VDD sky130_fd_sc_hd__tapvpwrvgnd_1
XTAP_TAPCELL_ROW_88_1523 VSS VDD sky130_fd_sc_hd__tapvpwrvgnd_1
XTAP_TAPCELL_ROW_88_1524 VSS VDD sky130_fd_sc_hd__tapvpwrvgnd_1
XTAP_TAPCELL_ROW_88_1525 VSS VDD sky130_fd_sc_hd__tapvpwrvgnd_1
XTAP_TAPCELL_ROW_88_1526 VSS VDD sky130_fd_sc_hd__tapvpwrvgnd_1
XTAP_TAPCELL_ROW_88_1527 VSS VDD sky130_fd_sc_hd__tapvpwrvgnd_1
XTAP_TAPCELL_ROW_88_1528 VSS VDD sky130_fd_sc_hd__tapvpwrvgnd_1
XTAP_TAPCELL_ROW_88_1529 VSS VDD sky130_fd_sc_hd__tapvpwrvgnd_1
XTAP_TAPCELL_ROW_89_1530 VSS VDD sky130_fd_sc_hd__tapvpwrvgnd_1
XTAP_TAPCELL_ROW_89_1531 VSS VDD sky130_fd_sc_hd__tapvpwrvgnd_1
XTAP_TAPCELL_ROW_89_1532 VSS VDD sky130_fd_sc_hd__tapvpwrvgnd_1
XTAP_TAPCELL_ROW_89_1533 VSS VDD sky130_fd_sc_hd__tapvpwrvgnd_1
XTAP_TAPCELL_ROW_89_1534 VSS VDD sky130_fd_sc_hd__tapvpwrvgnd_1
XTAP_TAPCELL_ROW_89_1535 VSS VDD sky130_fd_sc_hd__tapvpwrvgnd_1
XTAP_TAPCELL_ROW_89_1536 VSS VDD sky130_fd_sc_hd__tapvpwrvgnd_1
XTAP_TAPCELL_ROW_89_1537 VSS VDD sky130_fd_sc_hd__tapvpwrvgnd_1
XTAP_TAPCELL_ROW_89_1538 VSS VDD sky130_fd_sc_hd__tapvpwrvgnd_1
XTAP_TAPCELL_ROW_89_1539 VSS VDD sky130_fd_sc_hd__tapvpwrvgnd_1
XTAP_TAPCELL_ROW_89_1540 VSS VDD sky130_fd_sc_hd__tapvpwrvgnd_1
XTAP_TAPCELL_ROW_89_1541 VSS VDD sky130_fd_sc_hd__tapvpwrvgnd_1
XTAP_TAPCELL_ROW_89_1542 VSS VDD sky130_fd_sc_hd__tapvpwrvgnd_1
XTAP_TAPCELL_ROW_89_1543 VSS VDD sky130_fd_sc_hd__tapvpwrvgnd_1
XTAP_TAPCELL_ROW_89_1544 VSS VDD sky130_fd_sc_hd__tapvpwrvgnd_1
XTAP_TAPCELL_ROW_89_1545 VSS VDD sky130_fd_sc_hd__tapvpwrvgnd_1
XTAP_TAPCELL_ROW_89_1546 VSS VDD sky130_fd_sc_hd__tapvpwrvgnd_1
XTAP_TAPCELL_ROW_90_1547 VSS VDD sky130_fd_sc_hd__tapvpwrvgnd_1
XTAP_TAPCELL_ROW_90_1548 VSS VDD sky130_fd_sc_hd__tapvpwrvgnd_1
XTAP_TAPCELL_ROW_90_1549 VSS VDD sky130_fd_sc_hd__tapvpwrvgnd_1
XTAP_TAPCELL_ROW_90_1550 VSS VDD sky130_fd_sc_hd__tapvpwrvgnd_1
XTAP_TAPCELL_ROW_90_1551 VSS VDD sky130_fd_sc_hd__tapvpwrvgnd_1
XTAP_TAPCELL_ROW_90_1552 VSS VDD sky130_fd_sc_hd__tapvpwrvgnd_1
XTAP_TAPCELL_ROW_90_1553 VSS VDD sky130_fd_sc_hd__tapvpwrvgnd_1
XTAP_TAPCELL_ROW_90_1554 VSS VDD sky130_fd_sc_hd__tapvpwrvgnd_1
XTAP_TAPCELL_ROW_90_1555 VSS VDD sky130_fd_sc_hd__tapvpwrvgnd_1
XTAP_TAPCELL_ROW_90_1556 VSS VDD sky130_fd_sc_hd__tapvpwrvgnd_1
XTAP_TAPCELL_ROW_90_1557 VSS VDD sky130_fd_sc_hd__tapvpwrvgnd_1
XTAP_TAPCELL_ROW_90_1558 VSS VDD sky130_fd_sc_hd__tapvpwrvgnd_1
XTAP_TAPCELL_ROW_90_1559 VSS VDD sky130_fd_sc_hd__tapvpwrvgnd_1
XTAP_TAPCELL_ROW_90_1560 VSS VDD sky130_fd_sc_hd__tapvpwrvgnd_1
XTAP_TAPCELL_ROW_90_1561 VSS VDD sky130_fd_sc_hd__tapvpwrvgnd_1
XTAP_TAPCELL_ROW_90_1562 VSS VDD sky130_fd_sc_hd__tapvpwrvgnd_1
XTAP_TAPCELL_ROW_90_1563 VSS VDD sky130_fd_sc_hd__tapvpwrvgnd_1
XTAP_TAPCELL_ROW_91_1564 VSS VDD sky130_fd_sc_hd__tapvpwrvgnd_1
XTAP_TAPCELL_ROW_91_1565 VSS VDD sky130_fd_sc_hd__tapvpwrvgnd_1
XTAP_TAPCELL_ROW_91_1566 VSS VDD sky130_fd_sc_hd__tapvpwrvgnd_1
XTAP_TAPCELL_ROW_91_1567 VSS VDD sky130_fd_sc_hd__tapvpwrvgnd_1
XTAP_TAPCELL_ROW_91_1568 VSS VDD sky130_fd_sc_hd__tapvpwrvgnd_1
XTAP_TAPCELL_ROW_91_1569 VSS VDD sky130_fd_sc_hd__tapvpwrvgnd_1
XTAP_TAPCELL_ROW_91_1570 VSS VDD sky130_fd_sc_hd__tapvpwrvgnd_1
XTAP_TAPCELL_ROW_91_1571 VSS VDD sky130_fd_sc_hd__tapvpwrvgnd_1
XTAP_TAPCELL_ROW_91_1572 VSS VDD sky130_fd_sc_hd__tapvpwrvgnd_1
XTAP_TAPCELL_ROW_91_1573 VSS VDD sky130_fd_sc_hd__tapvpwrvgnd_1
XTAP_TAPCELL_ROW_91_1574 VSS VDD sky130_fd_sc_hd__tapvpwrvgnd_1
XTAP_TAPCELL_ROW_91_1575 VSS VDD sky130_fd_sc_hd__tapvpwrvgnd_1
XTAP_TAPCELL_ROW_91_1576 VSS VDD sky130_fd_sc_hd__tapvpwrvgnd_1
XTAP_TAPCELL_ROW_91_1577 VSS VDD sky130_fd_sc_hd__tapvpwrvgnd_1
XTAP_TAPCELL_ROW_91_1578 VSS VDD sky130_fd_sc_hd__tapvpwrvgnd_1
XTAP_TAPCELL_ROW_91_1579 VSS VDD sky130_fd_sc_hd__tapvpwrvgnd_1
XTAP_TAPCELL_ROW_91_1580 VSS VDD sky130_fd_sc_hd__tapvpwrvgnd_1
XTAP_TAPCELL_ROW_92_1581 VSS VDD sky130_fd_sc_hd__tapvpwrvgnd_1
XTAP_TAPCELL_ROW_92_1582 VSS VDD sky130_fd_sc_hd__tapvpwrvgnd_1
XTAP_TAPCELL_ROW_92_1583 VSS VDD sky130_fd_sc_hd__tapvpwrvgnd_1
XTAP_TAPCELL_ROW_92_1584 VSS VDD sky130_fd_sc_hd__tapvpwrvgnd_1
XTAP_TAPCELL_ROW_92_1585 VSS VDD sky130_fd_sc_hd__tapvpwrvgnd_1
XTAP_TAPCELL_ROW_92_1586 VSS VDD sky130_fd_sc_hd__tapvpwrvgnd_1
XTAP_TAPCELL_ROW_92_1587 VSS VDD sky130_fd_sc_hd__tapvpwrvgnd_1
XTAP_TAPCELL_ROW_92_1588 VSS VDD sky130_fd_sc_hd__tapvpwrvgnd_1
XTAP_TAPCELL_ROW_92_1589 VSS VDD sky130_fd_sc_hd__tapvpwrvgnd_1
XTAP_TAPCELL_ROW_92_1590 VSS VDD sky130_fd_sc_hd__tapvpwrvgnd_1
XTAP_TAPCELL_ROW_92_1591 VSS VDD sky130_fd_sc_hd__tapvpwrvgnd_1
XTAP_TAPCELL_ROW_92_1592 VSS VDD sky130_fd_sc_hd__tapvpwrvgnd_1
XTAP_TAPCELL_ROW_92_1593 VSS VDD sky130_fd_sc_hd__tapvpwrvgnd_1
XTAP_TAPCELL_ROW_92_1594 VSS VDD sky130_fd_sc_hd__tapvpwrvgnd_1
XTAP_TAPCELL_ROW_92_1595 VSS VDD sky130_fd_sc_hd__tapvpwrvgnd_1
XTAP_TAPCELL_ROW_92_1596 VSS VDD sky130_fd_sc_hd__tapvpwrvgnd_1
XTAP_TAPCELL_ROW_92_1597 VSS VDD sky130_fd_sc_hd__tapvpwrvgnd_1
XTAP_TAPCELL_ROW_93_1598 VSS VDD sky130_fd_sc_hd__tapvpwrvgnd_1
XTAP_TAPCELL_ROW_93_1599 VSS VDD sky130_fd_sc_hd__tapvpwrvgnd_1
XTAP_TAPCELL_ROW_93_1600 VSS VDD sky130_fd_sc_hd__tapvpwrvgnd_1
XTAP_TAPCELL_ROW_93_1601 VSS VDD sky130_fd_sc_hd__tapvpwrvgnd_1
XTAP_TAPCELL_ROW_93_1602 VSS VDD sky130_fd_sc_hd__tapvpwrvgnd_1
XTAP_TAPCELL_ROW_93_1603 VSS VDD sky130_fd_sc_hd__tapvpwrvgnd_1
XTAP_TAPCELL_ROW_93_1604 VSS VDD sky130_fd_sc_hd__tapvpwrvgnd_1
XTAP_TAPCELL_ROW_93_1605 VSS VDD sky130_fd_sc_hd__tapvpwrvgnd_1
XTAP_TAPCELL_ROW_93_1606 VSS VDD sky130_fd_sc_hd__tapvpwrvgnd_1
XTAP_TAPCELL_ROW_93_1607 VSS VDD sky130_fd_sc_hd__tapvpwrvgnd_1
XTAP_TAPCELL_ROW_93_1608 VSS VDD sky130_fd_sc_hd__tapvpwrvgnd_1
XTAP_TAPCELL_ROW_93_1609 VSS VDD sky130_fd_sc_hd__tapvpwrvgnd_1
XTAP_TAPCELL_ROW_93_1610 VSS VDD sky130_fd_sc_hd__tapvpwrvgnd_1
XTAP_TAPCELL_ROW_93_1611 VSS VDD sky130_fd_sc_hd__tapvpwrvgnd_1
XTAP_TAPCELL_ROW_93_1612 VSS VDD sky130_fd_sc_hd__tapvpwrvgnd_1
XTAP_TAPCELL_ROW_93_1613 VSS VDD sky130_fd_sc_hd__tapvpwrvgnd_1
XTAP_TAPCELL_ROW_93_1614 VSS VDD sky130_fd_sc_hd__tapvpwrvgnd_1
XTAP_TAPCELL_ROW_94_1615 VSS VDD sky130_fd_sc_hd__tapvpwrvgnd_1
XTAP_TAPCELL_ROW_94_1616 VSS VDD sky130_fd_sc_hd__tapvpwrvgnd_1
XTAP_TAPCELL_ROW_94_1617 VSS VDD sky130_fd_sc_hd__tapvpwrvgnd_1
XTAP_TAPCELL_ROW_94_1618 VSS VDD sky130_fd_sc_hd__tapvpwrvgnd_1
XTAP_TAPCELL_ROW_94_1619 VSS VDD sky130_fd_sc_hd__tapvpwrvgnd_1
XTAP_TAPCELL_ROW_94_1620 VSS VDD sky130_fd_sc_hd__tapvpwrvgnd_1
XTAP_TAPCELL_ROW_94_1621 VSS VDD sky130_fd_sc_hd__tapvpwrvgnd_1
XTAP_TAPCELL_ROW_94_1622 VSS VDD sky130_fd_sc_hd__tapvpwrvgnd_1
XTAP_TAPCELL_ROW_94_1623 VSS VDD sky130_fd_sc_hd__tapvpwrvgnd_1
XTAP_TAPCELL_ROW_94_1624 VSS VDD sky130_fd_sc_hd__tapvpwrvgnd_1
XTAP_TAPCELL_ROW_94_1625 VSS VDD sky130_fd_sc_hd__tapvpwrvgnd_1
XTAP_TAPCELL_ROW_94_1626 VSS VDD sky130_fd_sc_hd__tapvpwrvgnd_1
XTAP_TAPCELL_ROW_94_1627 VSS VDD sky130_fd_sc_hd__tapvpwrvgnd_1
XTAP_TAPCELL_ROW_94_1628 VSS VDD sky130_fd_sc_hd__tapvpwrvgnd_1
XTAP_TAPCELL_ROW_94_1629 VSS VDD sky130_fd_sc_hd__tapvpwrvgnd_1
XTAP_TAPCELL_ROW_94_1630 VSS VDD sky130_fd_sc_hd__tapvpwrvgnd_1
XTAP_TAPCELL_ROW_94_1631 VSS VDD sky130_fd_sc_hd__tapvpwrvgnd_1
XTAP_TAPCELL_ROW_95_1632 VSS VDD sky130_fd_sc_hd__tapvpwrvgnd_1
XTAP_TAPCELL_ROW_95_1633 VSS VDD sky130_fd_sc_hd__tapvpwrvgnd_1
XTAP_TAPCELL_ROW_95_1634 VSS VDD sky130_fd_sc_hd__tapvpwrvgnd_1
XTAP_TAPCELL_ROW_95_1635 VSS VDD sky130_fd_sc_hd__tapvpwrvgnd_1
XTAP_TAPCELL_ROW_95_1636 VSS VDD sky130_fd_sc_hd__tapvpwrvgnd_1
XTAP_TAPCELL_ROW_95_1637 VSS VDD sky130_fd_sc_hd__tapvpwrvgnd_1
XTAP_TAPCELL_ROW_95_1638 VSS VDD sky130_fd_sc_hd__tapvpwrvgnd_1
XTAP_TAPCELL_ROW_95_1639 VSS VDD sky130_fd_sc_hd__tapvpwrvgnd_1
XTAP_TAPCELL_ROW_95_1640 VSS VDD sky130_fd_sc_hd__tapvpwrvgnd_1
XTAP_TAPCELL_ROW_95_1641 VSS VDD sky130_fd_sc_hd__tapvpwrvgnd_1
XTAP_TAPCELL_ROW_95_1642 VSS VDD sky130_fd_sc_hd__tapvpwrvgnd_1
XTAP_TAPCELL_ROW_95_1643 VSS VDD sky130_fd_sc_hd__tapvpwrvgnd_1
XTAP_TAPCELL_ROW_95_1644 VSS VDD sky130_fd_sc_hd__tapvpwrvgnd_1
XTAP_TAPCELL_ROW_95_1645 VSS VDD sky130_fd_sc_hd__tapvpwrvgnd_1
XTAP_TAPCELL_ROW_95_1646 VSS VDD sky130_fd_sc_hd__tapvpwrvgnd_1
XTAP_TAPCELL_ROW_95_1647 VSS VDD sky130_fd_sc_hd__tapvpwrvgnd_1
XTAP_TAPCELL_ROW_95_1648 VSS VDD sky130_fd_sc_hd__tapvpwrvgnd_1
XTAP_TAPCELL_ROW_96_1649 VSS VDD sky130_fd_sc_hd__tapvpwrvgnd_1
XTAP_TAPCELL_ROW_96_1650 VSS VDD sky130_fd_sc_hd__tapvpwrvgnd_1
XTAP_TAPCELL_ROW_96_1651 VSS VDD sky130_fd_sc_hd__tapvpwrvgnd_1
XTAP_TAPCELL_ROW_96_1652 VSS VDD sky130_fd_sc_hd__tapvpwrvgnd_1
XTAP_TAPCELL_ROW_96_1653 VSS VDD sky130_fd_sc_hd__tapvpwrvgnd_1
XTAP_TAPCELL_ROW_96_1654 VSS VDD sky130_fd_sc_hd__tapvpwrvgnd_1
XTAP_TAPCELL_ROW_96_1655 VSS VDD sky130_fd_sc_hd__tapvpwrvgnd_1
XTAP_TAPCELL_ROW_96_1656 VSS VDD sky130_fd_sc_hd__tapvpwrvgnd_1
XTAP_TAPCELL_ROW_96_1657 VSS VDD sky130_fd_sc_hd__tapvpwrvgnd_1
XTAP_TAPCELL_ROW_96_1658 VSS VDD sky130_fd_sc_hd__tapvpwrvgnd_1
XTAP_TAPCELL_ROW_96_1659 VSS VDD sky130_fd_sc_hd__tapvpwrvgnd_1
XTAP_TAPCELL_ROW_96_1660 VSS VDD sky130_fd_sc_hd__tapvpwrvgnd_1
XTAP_TAPCELL_ROW_96_1661 VSS VDD sky130_fd_sc_hd__tapvpwrvgnd_1
XTAP_TAPCELL_ROW_96_1662 VSS VDD sky130_fd_sc_hd__tapvpwrvgnd_1
XTAP_TAPCELL_ROW_96_1663 VSS VDD sky130_fd_sc_hd__tapvpwrvgnd_1
XTAP_TAPCELL_ROW_96_1664 VSS VDD sky130_fd_sc_hd__tapvpwrvgnd_1
XTAP_TAPCELL_ROW_96_1665 VSS VDD sky130_fd_sc_hd__tapvpwrvgnd_1
XTAP_TAPCELL_ROW_97_1666 VSS VDD sky130_fd_sc_hd__tapvpwrvgnd_1
XTAP_TAPCELL_ROW_97_1667 VSS VDD sky130_fd_sc_hd__tapvpwrvgnd_1
XTAP_TAPCELL_ROW_97_1668 VSS VDD sky130_fd_sc_hd__tapvpwrvgnd_1
XTAP_TAPCELL_ROW_97_1669 VSS VDD sky130_fd_sc_hd__tapvpwrvgnd_1
XTAP_TAPCELL_ROW_97_1670 VSS VDD sky130_fd_sc_hd__tapvpwrvgnd_1
XTAP_TAPCELL_ROW_97_1671 VSS VDD sky130_fd_sc_hd__tapvpwrvgnd_1
XTAP_TAPCELL_ROW_97_1672 VSS VDD sky130_fd_sc_hd__tapvpwrvgnd_1
XTAP_TAPCELL_ROW_97_1673 VSS VDD sky130_fd_sc_hd__tapvpwrvgnd_1
XTAP_TAPCELL_ROW_97_1674 VSS VDD sky130_fd_sc_hd__tapvpwrvgnd_1
XTAP_TAPCELL_ROW_97_1675 VSS VDD sky130_fd_sc_hd__tapvpwrvgnd_1
XTAP_TAPCELL_ROW_97_1676 VSS VDD sky130_fd_sc_hd__tapvpwrvgnd_1
XTAP_TAPCELL_ROW_97_1677 VSS VDD sky130_fd_sc_hd__tapvpwrvgnd_1
XTAP_TAPCELL_ROW_97_1678 VSS VDD sky130_fd_sc_hd__tapvpwrvgnd_1
XTAP_TAPCELL_ROW_97_1679 VSS VDD sky130_fd_sc_hd__tapvpwrvgnd_1
XTAP_TAPCELL_ROW_97_1680 VSS VDD sky130_fd_sc_hd__tapvpwrvgnd_1
XTAP_TAPCELL_ROW_97_1681 VSS VDD sky130_fd_sc_hd__tapvpwrvgnd_1
XTAP_TAPCELL_ROW_97_1682 VSS VDD sky130_fd_sc_hd__tapvpwrvgnd_1
XTAP_TAPCELL_ROW_98_1683 VSS VDD sky130_fd_sc_hd__tapvpwrvgnd_1
XTAP_TAPCELL_ROW_98_1684 VSS VDD sky130_fd_sc_hd__tapvpwrvgnd_1
XTAP_TAPCELL_ROW_98_1685 VSS VDD sky130_fd_sc_hd__tapvpwrvgnd_1
XTAP_TAPCELL_ROW_98_1686 VSS VDD sky130_fd_sc_hd__tapvpwrvgnd_1
XTAP_TAPCELL_ROW_98_1687 VSS VDD sky130_fd_sc_hd__tapvpwrvgnd_1
XTAP_TAPCELL_ROW_98_1688 VSS VDD sky130_fd_sc_hd__tapvpwrvgnd_1
XTAP_TAPCELL_ROW_98_1689 VSS VDD sky130_fd_sc_hd__tapvpwrvgnd_1
XTAP_TAPCELL_ROW_98_1690 VSS VDD sky130_fd_sc_hd__tapvpwrvgnd_1
XTAP_TAPCELL_ROW_98_1691 VSS VDD sky130_fd_sc_hd__tapvpwrvgnd_1
XTAP_TAPCELL_ROW_98_1692 VSS VDD sky130_fd_sc_hd__tapvpwrvgnd_1
XTAP_TAPCELL_ROW_98_1693 VSS VDD sky130_fd_sc_hd__tapvpwrvgnd_1
XTAP_TAPCELL_ROW_98_1694 VSS VDD sky130_fd_sc_hd__tapvpwrvgnd_1
XTAP_TAPCELL_ROW_98_1695 VSS VDD sky130_fd_sc_hd__tapvpwrvgnd_1
XTAP_TAPCELL_ROW_98_1696 VSS VDD sky130_fd_sc_hd__tapvpwrvgnd_1
XTAP_TAPCELL_ROW_98_1697 VSS VDD sky130_fd_sc_hd__tapvpwrvgnd_1
XTAP_TAPCELL_ROW_98_1698 VSS VDD sky130_fd_sc_hd__tapvpwrvgnd_1
XTAP_TAPCELL_ROW_98_1699 VSS VDD sky130_fd_sc_hd__tapvpwrvgnd_1
XTAP_TAPCELL_ROW_99_1700 VSS VDD sky130_fd_sc_hd__tapvpwrvgnd_1
XTAP_TAPCELL_ROW_99_1701 VSS VDD sky130_fd_sc_hd__tapvpwrvgnd_1
XTAP_TAPCELL_ROW_99_1702 VSS VDD sky130_fd_sc_hd__tapvpwrvgnd_1
XTAP_TAPCELL_ROW_99_1703 VSS VDD sky130_fd_sc_hd__tapvpwrvgnd_1
XTAP_TAPCELL_ROW_99_1704 VSS VDD sky130_fd_sc_hd__tapvpwrvgnd_1
XTAP_TAPCELL_ROW_99_1705 VSS VDD sky130_fd_sc_hd__tapvpwrvgnd_1
XTAP_TAPCELL_ROW_99_1706 VSS VDD sky130_fd_sc_hd__tapvpwrvgnd_1
XTAP_TAPCELL_ROW_99_1707 VSS VDD sky130_fd_sc_hd__tapvpwrvgnd_1
XTAP_TAPCELL_ROW_99_1708 VSS VDD sky130_fd_sc_hd__tapvpwrvgnd_1
XTAP_TAPCELL_ROW_99_1709 VSS VDD sky130_fd_sc_hd__tapvpwrvgnd_1
XTAP_TAPCELL_ROW_99_1710 VSS VDD sky130_fd_sc_hd__tapvpwrvgnd_1
XTAP_TAPCELL_ROW_99_1711 VSS VDD sky130_fd_sc_hd__tapvpwrvgnd_1
XTAP_TAPCELL_ROW_99_1712 VSS VDD sky130_fd_sc_hd__tapvpwrvgnd_1
XTAP_TAPCELL_ROW_99_1713 VSS VDD sky130_fd_sc_hd__tapvpwrvgnd_1
XTAP_TAPCELL_ROW_99_1714 VSS VDD sky130_fd_sc_hd__tapvpwrvgnd_1
XTAP_TAPCELL_ROW_99_1715 VSS VDD sky130_fd_sc_hd__tapvpwrvgnd_1
XTAP_TAPCELL_ROW_99_1716 VSS VDD sky130_fd_sc_hd__tapvpwrvgnd_1
XTAP_TAPCELL_ROW_100_1717 VSS VDD sky130_fd_sc_hd__tapvpwrvgnd_1
XTAP_TAPCELL_ROW_100_1718 VSS VDD sky130_fd_sc_hd__tapvpwrvgnd_1
XTAP_TAPCELL_ROW_100_1719 VSS VDD sky130_fd_sc_hd__tapvpwrvgnd_1
XTAP_TAPCELL_ROW_100_1720 VSS VDD sky130_fd_sc_hd__tapvpwrvgnd_1
XTAP_TAPCELL_ROW_100_1721 VSS VDD sky130_fd_sc_hd__tapvpwrvgnd_1
XTAP_TAPCELL_ROW_100_1722 VSS VDD sky130_fd_sc_hd__tapvpwrvgnd_1
XTAP_TAPCELL_ROW_100_1723 VSS VDD sky130_fd_sc_hd__tapvpwrvgnd_1
XTAP_TAPCELL_ROW_100_1724 VSS VDD sky130_fd_sc_hd__tapvpwrvgnd_1
XTAP_TAPCELL_ROW_100_1725 VSS VDD sky130_fd_sc_hd__tapvpwrvgnd_1
XTAP_TAPCELL_ROW_100_1726 VSS VDD sky130_fd_sc_hd__tapvpwrvgnd_1
XTAP_TAPCELL_ROW_100_1727 VSS VDD sky130_fd_sc_hd__tapvpwrvgnd_1
XTAP_TAPCELL_ROW_100_1728 VSS VDD sky130_fd_sc_hd__tapvpwrvgnd_1
XTAP_TAPCELL_ROW_100_1729 VSS VDD sky130_fd_sc_hd__tapvpwrvgnd_1
XTAP_TAPCELL_ROW_100_1730 VSS VDD sky130_fd_sc_hd__tapvpwrvgnd_1
XTAP_TAPCELL_ROW_100_1731 VSS VDD sky130_fd_sc_hd__tapvpwrvgnd_1
XTAP_TAPCELL_ROW_100_1732 VSS VDD sky130_fd_sc_hd__tapvpwrvgnd_1
XTAP_TAPCELL_ROW_100_1733 VSS VDD sky130_fd_sc_hd__tapvpwrvgnd_1
XTAP_TAPCELL_ROW_101_1734 VSS VDD sky130_fd_sc_hd__tapvpwrvgnd_1
XTAP_TAPCELL_ROW_101_1735 VSS VDD sky130_fd_sc_hd__tapvpwrvgnd_1
XTAP_TAPCELL_ROW_101_1736 VSS VDD sky130_fd_sc_hd__tapvpwrvgnd_1
XTAP_TAPCELL_ROW_101_1737 VSS VDD sky130_fd_sc_hd__tapvpwrvgnd_1
XTAP_TAPCELL_ROW_101_1738 VSS VDD sky130_fd_sc_hd__tapvpwrvgnd_1
XTAP_TAPCELL_ROW_101_1739 VSS VDD sky130_fd_sc_hd__tapvpwrvgnd_1
XTAP_TAPCELL_ROW_101_1740 VSS VDD sky130_fd_sc_hd__tapvpwrvgnd_1
XTAP_TAPCELL_ROW_101_1741 VSS VDD sky130_fd_sc_hd__tapvpwrvgnd_1
XTAP_TAPCELL_ROW_101_1742 VSS VDD sky130_fd_sc_hd__tapvpwrvgnd_1
XTAP_TAPCELL_ROW_101_1743 VSS VDD sky130_fd_sc_hd__tapvpwrvgnd_1
XTAP_TAPCELL_ROW_101_1744 VSS VDD sky130_fd_sc_hd__tapvpwrvgnd_1
XTAP_TAPCELL_ROW_101_1745 VSS VDD sky130_fd_sc_hd__tapvpwrvgnd_1
XTAP_TAPCELL_ROW_101_1746 VSS VDD sky130_fd_sc_hd__tapvpwrvgnd_1
XTAP_TAPCELL_ROW_101_1747 VSS VDD sky130_fd_sc_hd__tapvpwrvgnd_1
XTAP_TAPCELL_ROW_101_1748 VSS VDD sky130_fd_sc_hd__tapvpwrvgnd_1
XTAP_TAPCELL_ROW_101_1749 VSS VDD sky130_fd_sc_hd__tapvpwrvgnd_1
XTAP_TAPCELL_ROW_101_1750 VSS VDD sky130_fd_sc_hd__tapvpwrvgnd_1
XTAP_TAPCELL_ROW_102_1751 VSS VDD sky130_fd_sc_hd__tapvpwrvgnd_1
XTAP_TAPCELL_ROW_102_1752 VSS VDD sky130_fd_sc_hd__tapvpwrvgnd_1
XTAP_TAPCELL_ROW_102_1753 VSS VDD sky130_fd_sc_hd__tapvpwrvgnd_1
XTAP_TAPCELL_ROW_102_1754 VSS VDD sky130_fd_sc_hd__tapvpwrvgnd_1
XTAP_TAPCELL_ROW_102_1755 VSS VDD sky130_fd_sc_hd__tapvpwrvgnd_1
XTAP_TAPCELL_ROW_102_1756 VSS VDD sky130_fd_sc_hd__tapvpwrvgnd_1
XTAP_TAPCELL_ROW_102_1757 VSS VDD sky130_fd_sc_hd__tapvpwrvgnd_1
XTAP_TAPCELL_ROW_102_1758 VSS VDD sky130_fd_sc_hd__tapvpwrvgnd_1
XTAP_TAPCELL_ROW_102_1759 VSS VDD sky130_fd_sc_hd__tapvpwrvgnd_1
XTAP_TAPCELL_ROW_102_1760 VSS VDD sky130_fd_sc_hd__tapvpwrvgnd_1
XTAP_TAPCELL_ROW_102_1761 VSS VDD sky130_fd_sc_hd__tapvpwrvgnd_1
XTAP_TAPCELL_ROW_102_1762 VSS VDD sky130_fd_sc_hd__tapvpwrvgnd_1
XTAP_TAPCELL_ROW_102_1763 VSS VDD sky130_fd_sc_hd__tapvpwrvgnd_1
XTAP_TAPCELL_ROW_102_1764 VSS VDD sky130_fd_sc_hd__tapvpwrvgnd_1
XTAP_TAPCELL_ROW_102_1765 VSS VDD sky130_fd_sc_hd__tapvpwrvgnd_1
XTAP_TAPCELL_ROW_102_1766 VSS VDD sky130_fd_sc_hd__tapvpwrvgnd_1
XTAP_TAPCELL_ROW_102_1767 VSS VDD sky130_fd_sc_hd__tapvpwrvgnd_1
XTAP_TAPCELL_ROW_103_1768 VSS VDD sky130_fd_sc_hd__tapvpwrvgnd_1
XTAP_TAPCELL_ROW_103_1769 VSS VDD sky130_fd_sc_hd__tapvpwrvgnd_1
XTAP_TAPCELL_ROW_103_1770 VSS VDD sky130_fd_sc_hd__tapvpwrvgnd_1
XTAP_TAPCELL_ROW_103_1771 VSS VDD sky130_fd_sc_hd__tapvpwrvgnd_1
XTAP_TAPCELL_ROW_103_1772 VSS VDD sky130_fd_sc_hd__tapvpwrvgnd_1
XTAP_TAPCELL_ROW_103_1773 VSS VDD sky130_fd_sc_hd__tapvpwrvgnd_1
XTAP_TAPCELL_ROW_103_1774 VSS VDD sky130_fd_sc_hd__tapvpwrvgnd_1
XTAP_TAPCELL_ROW_103_1775 VSS VDD sky130_fd_sc_hd__tapvpwrvgnd_1
XTAP_TAPCELL_ROW_103_1776 VSS VDD sky130_fd_sc_hd__tapvpwrvgnd_1
XTAP_TAPCELL_ROW_103_1777 VSS VDD sky130_fd_sc_hd__tapvpwrvgnd_1
XTAP_TAPCELL_ROW_103_1778 VSS VDD sky130_fd_sc_hd__tapvpwrvgnd_1
XTAP_TAPCELL_ROW_103_1779 VSS VDD sky130_fd_sc_hd__tapvpwrvgnd_1
XTAP_TAPCELL_ROW_103_1780 VSS VDD sky130_fd_sc_hd__tapvpwrvgnd_1
XTAP_TAPCELL_ROW_103_1781 VSS VDD sky130_fd_sc_hd__tapvpwrvgnd_1
XTAP_TAPCELL_ROW_103_1782 VSS VDD sky130_fd_sc_hd__tapvpwrvgnd_1
XTAP_TAPCELL_ROW_103_1783 VSS VDD sky130_fd_sc_hd__tapvpwrvgnd_1
XTAP_TAPCELL_ROW_103_1784 VSS VDD sky130_fd_sc_hd__tapvpwrvgnd_1
XTAP_TAPCELL_ROW_104_1785 VSS VDD sky130_fd_sc_hd__tapvpwrvgnd_1
XTAP_TAPCELL_ROW_104_1786 VSS VDD sky130_fd_sc_hd__tapvpwrvgnd_1
XTAP_TAPCELL_ROW_104_1787 VSS VDD sky130_fd_sc_hd__tapvpwrvgnd_1
XTAP_TAPCELL_ROW_104_1788 VSS VDD sky130_fd_sc_hd__tapvpwrvgnd_1
XTAP_TAPCELL_ROW_104_1789 VSS VDD sky130_fd_sc_hd__tapvpwrvgnd_1
XTAP_TAPCELL_ROW_104_1790 VSS VDD sky130_fd_sc_hd__tapvpwrvgnd_1
XTAP_TAPCELL_ROW_104_1791 VSS VDD sky130_fd_sc_hd__tapvpwrvgnd_1
XTAP_TAPCELL_ROW_104_1792 VSS VDD sky130_fd_sc_hd__tapvpwrvgnd_1
XTAP_TAPCELL_ROW_104_1793 VSS VDD sky130_fd_sc_hd__tapvpwrvgnd_1
XTAP_TAPCELL_ROW_104_1794 VSS VDD sky130_fd_sc_hd__tapvpwrvgnd_1
XTAP_TAPCELL_ROW_104_1795 VSS VDD sky130_fd_sc_hd__tapvpwrvgnd_1
XTAP_TAPCELL_ROW_104_1796 VSS VDD sky130_fd_sc_hd__tapvpwrvgnd_1
XTAP_TAPCELL_ROW_104_1797 VSS VDD sky130_fd_sc_hd__tapvpwrvgnd_1
XTAP_TAPCELL_ROW_104_1798 VSS VDD sky130_fd_sc_hd__tapvpwrvgnd_1
XTAP_TAPCELL_ROW_104_1799 VSS VDD sky130_fd_sc_hd__tapvpwrvgnd_1
XTAP_TAPCELL_ROW_104_1800 VSS VDD sky130_fd_sc_hd__tapvpwrvgnd_1
XTAP_TAPCELL_ROW_104_1801 VSS VDD sky130_fd_sc_hd__tapvpwrvgnd_1
XTAP_TAPCELL_ROW_105_1802 VSS VDD sky130_fd_sc_hd__tapvpwrvgnd_1
XTAP_TAPCELL_ROW_105_1803 VSS VDD sky130_fd_sc_hd__tapvpwrvgnd_1
XTAP_TAPCELL_ROW_105_1804 VSS VDD sky130_fd_sc_hd__tapvpwrvgnd_1
XTAP_TAPCELL_ROW_105_1805 VSS VDD sky130_fd_sc_hd__tapvpwrvgnd_1
XTAP_TAPCELL_ROW_105_1806 VSS VDD sky130_fd_sc_hd__tapvpwrvgnd_1
XTAP_TAPCELL_ROW_105_1807 VSS VDD sky130_fd_sc_hd__tapvpwrvgnd_1
XTAP_TAPCELL_ROW_105_1808 VSS VDD sky130_fd_sc_hd__tapvpwrvgnd_1
XTAP_TAPCELL_ROW_105_1809 VSS VDD sky130_fd_sc_hd__tapvpwrvgnd_1
XTAP_TAPCELL_ROW_105_1810 VSS VDD sky130_fd_sc_hd__tapvpwrvgnd_1
XTAP_TAPCELL_ROW_105_1811 VSS VDD sky130_fd_sc_hd__tapvpwrvgnd_1
XTAP_TAPCELL_ROW_105_1812 VSS VDD sky130_fd_sc_hd__tapvpwrvgnd_1
XTAP_TAPCELL_ROW_105_1813 VSS VDD sky130_fd_sc_hd__tapvpwrvgnd_1
XTAP_TAPCELL_ROW_105_1814 VSS VDD sky130_fd_sc_hd__tapvpwrvgnd_1
XTAP_TAPCELL_ROW_105_1815 VSS VDD sky130_fd_sc_hd__tapvpwrvgnd_1
XTAP_TAPCELL_ROW_105_1816 VSS VDD sky130_fd_sc_hd__tapvpwrvgnd_1
XTAP_TAPCELL_ROW_105_1817 VSS VDD sky130_fd_sc_hd__tapvpwrvgnd_1
XTAP_TAPCELL_ROW_105_1818 VSS VDD sky130_fd_sc_hd__tapvpwrvgnd_1
XTAP_TAPCELL_ROW_106_1819 VSS VDD sky130_fd_sc_hd__tapvpwrvgnd_1
XTAP_TAPCELL_ROW_106_1820 VSS VDD sky130_fd_sc_hd__tapvpwrvgnd_1
XTAP_TAPCELL_ROW_106_1821 VSS VDD sky130_fd_sc_hd__tapvpwrvgnd_1
XTAP_TAPCELL_ROW_106_1822 VSS VDD sky130_fd_sc_hd__tapvpwrvgnd_1
XTAP_TAPCELL_ROW_106_1823 VSS VDD sky130_fd_sc_hd__tapvpwrvgnd_1
XTAP_TAPCELL_ROW_106_1824 VSS VDD sky130_fd_sc_hd__tapvpwrvgnd_1
XTAP_TAPCELL_ROW_106_1825 VSS VDD sky130_fd_sc_hd__tapvpwrvgnd_1
XTAP_TAPCELL_ROW_106_1826 VSS VDD sky130_fd_sc_hd__tapvpwrvgnd_1
XTAP_TAPCELL_ROW_106_1827 VSS VDD sky130_fd_sc_hd__tapvpwrvgnd_1
XTAP_TAPCELL_ROW_106_1828 VSS VDD sky130_fd_sc_hd__tapvpwrvgnd_1
XTAP_TAPCELL_ROW_106_1829 VSS VDD sky130_fd_sc_hd__tapvpwrvgnd_1
XTAP_TAPCELL_ROW_106_1830 VSS VDD sky130_fd_sc_hd__tapvpwrvgnd_1
XTAP_TAPCELL_ROW_106_1831 VSS VDD sky130_fd_sc_hd__tapvpwrvgnd_1
XTAP_TAPCELL_ROW_106_1832 VSS VDD sky130_fd_sc_hd__tapvpwrvgnd_1
XTAP_TAPCELL_ROW_106_1833 VSS VDD sky130_fd_sc_hd__tapvpwrvgnd_1
XTAP_TAPCELL_ROW_106_1834 VSS VDD sky130_fd_sc_hd__tapvpwrvgnd_1
XTAP_TAPCELL_ROW_106_1835 VSS VDD sky130_fd_sc_hd__tapvpwrvgnd_1
XTAP_TAPCELL_ROW_107_1836 VSS VDD sky130_fd_sc_hd__tapvpwrvgnd_1
XTAP_TAPCELL_ROW_107_1837 VSS VDD sky130_fd_sc_hd__tapvpwrvgnd_1
XTAP_TAPCELL_ROW_107_1838 VSS VDD sky130_fd_sc_hd__tapvpwrvgnd_1
XTAP_TAPCELL_ROW_107_1839 VSS VDD sky130_fd_sc_hd__tapvpwrvgnd_1
XTAP_TAPCELL_ROW_107_1840 VSS VDD sky130_fd_sc_hd__tapvpwrvgnd_1
XTAP_TAPCELL_ROW_107_1841 VSS VDD sky130_fd_sc_hd__tapvpwrvgnd_1
XTAP_TAPCELL_ROW_107_1842 VSS VDD sky130_fd_sc_hd__tapvpwrvgnd_1
XTAP_TAPCELL_ROW_107_1843 VSS VDD sky130_fd_sc_hd__tapvpwrvgnd_1
XTAP_TAPCELL_ROW_107_1844 VSS VDD sky130_fd_sc_hd__tapvpwrvgnd_1
XTAP_TAPCELL_ROW_107_1845 VSS VDD sky130_fd_sc_hd__tapvpwrvgnd_1
XTAP_TAPCELL_ROW_107_1846 VSS VDD sky130_fd_sc_hd__tapvpwrvgnd_1
XTAP_TAPCELL_ROW_107_1847 VSS VDD sky130_fd_sc_hd__tapvpwrvgnd_1
XTAP_TAPCELL_ROW_107_1848 VSS VDD sky130_fd_sc_hd__tapvpwrvgnd_1
XTAP_TAPCELL_ROW_107_1849 VSS VDD sky130_fd_sc_hd__tapvpwrvgnd_1
XTAP_TAPCELL_ROW_107_1850 VSS VDD sky130_fd_sc_hd__tapvpwrvgnd_1
XTAP_TAPCELL_ROW_107_1851 VSS VDD sky130_fd_sc_hd__tapvpwrvgnd_1
XTAP_TAPCELL_ROW_107_1852 VSS VDD sky130_fd_sc_hd__tapvpwrvgnd_1
XTAP_TAPCELL_ROW_108_1853 VSS VDD sky130_fd_sc_hd__tapvpwrvgnd_1
XTAP_TAPCELL_ROW_108_1854 VSS VDD sky130_fd_sc_hd__tapvpwrvgnd_1
XTAP_TAPCELL_ROW_108_1855 VSS VDD sky130_fd_sc_hd__tapvpwrvgnd_1
XTAP_TAPCELL_ROW_108_1856 VSS VDD sky130_fd_sc_hd__tapvpwrvgnd_1
XTAP_TAPCELL_ROW_108_1857 VSS VDD sky130_fd_sc_hd__tapvpwrvgnd_1
XTAP_TAPCELL_ROW_108_1858 VSS VDD sky130_fd_sc_hd__tapvpwrvgnd_1
XTAP_TAPCELL_ROW_108_1859 VSS VDD sky130_fd_sc_hd__tapvpwrvgnd_1
XTAP_TAPCELL_ROW_108_1860 VSS VDD sky130_fd_sc_hd__tapvpwrvgnd_1
XTAP_TAPCELL_ROW_108_1861 VSS VDD sky130_fd_sc_hd__tapvpwrvgnd_1
XTAP_TAPCELL_ROW_108_1862 VSS VDD sky130_fd_sc_hd__tapvpwrvgnd_1
XTAP_TAPCELL_ROW_108_1863 VSS VDD sky130_fd_sc_hd__tapvpwrvgnd_1
XTAP_TAPCELL_ROW_108_1864 VSS VDD sky130_fd_sc_hd__tapvpwrvgnd_1
XTAP_TAPCELL_ROW_108_1865 VSS VDD sky130_fd_sc_hd__tapvpwrvgnd_1
XTAP_TAPCELL_ROW_108_1866 VSS VDD sky130_fd_sc_hd__tapvpwrvgnd_1
XTAP_TAPCELL_ROW_108_1867 VSS VDD sky130_fd_sc_hd__tapvpwrvgnd_1
XTAP_TAPCELL_ROW_108_1868 VSS VDD sky130_fd_sc_hd__tapvpwrvgnd_1
XTAP_TAPCELL_ROW_108_1869 VSS VDD sky130_fd_sc_hd__tapvpwrvgnd_1
XTAP_TAPCELL_ROW_109_1870 VSS VDD sky130_fd_sc_hd__tapvpwrvgnd_1
XTAP_TAPCELL_ROW_109_1871 VSS VDD sky130_fd_sc_hd__tapvpwrvgnd_1
XTAP_TAPCELL_ROW_109_1872 VSS VDD sky130_fd_sc_hd__tapvpwrvgnd_1
XTAP_TAPCELL_ROW_109_1873 VSS VDD sky130_fd_sc_hd__tapvpwrvgnd_1
XTAP_TAPCELL_ROW_109_1874 VSS VDD sky130_fd_sc_hd__tapvpwrvgnd_1
XTAP_TAPCELL_ROW_109_1875 VSS VDD sky130_fd_sc_hd__tapvpwrvgnd_1
XTAP_TAPCELL_ROW_109_1876 VSS VDD sky130_fd_sc_hd__tapvpwrvgnd_1
XTAP_TAPCELL_ROW_109_1877 VSS VDD sky130_fd_sc_hd__tapvpwrvgnd_1
XTAP_TAPCELL_ROW_109_1878 VSS VDD sky130_fd_sc_hd__tapvpwrvgnd_1
XTAP_TAPCELL_ROW_109_1879 VSS VDD sky130_fd_sc_hd__tapvpwrvgnd_1
XTAP_TAPCELL_ROW_109_1880 VSS VDD sky130_fd_sc_hd__tapvpwrvgnd_1
XTAP_TAPCELL_ROW_109_1881 VSS VDD sky130_fd_sc_hd__tapvpwrvgnd_1
XTAP_TAPCELL_ROW_109_1882 VSS VDD sky130_fd_sc_hd__tapvpwrvgnd_1
XTAP_TAPCELL_ROW_109_1883 VSS VDD sky130_fd_sc_hd__tapvpwrvgnd_1
XTAP_TAPCELL_ROW_109_1884 VSS VDD sky130_fd_sc_hd__tapvpwrvgnd_1
XTAP_TAPCELL_ROW_109_1885 VSS VDD sky130_fd_sc_hd__tapvpwrvgnd_1
XTAP_TAPCELL_ROW_109_1886 VSS VDD sky130_fd_sc_hd__tapvpwrvgnd_1
XTAP_TAPCELL_ROW_110_1887 VSS VDD sky130_fd_sc_hd__tapvpwrvgnd_1
XTAP_TAPCELL_ROW_110_1888 VSS VDD sky130_fd_sc_hd__tapvpwrvgnd_1
XTAP_TAPCELL_ROW_110_1889 VSS VDD sky130_fd_sc_hd__tapvpwrvgnd_1
XTAP_TAPCELL_ROW_110_1890 VSS VDD sky130_fd_sc_hd__tapvpwrvgnd_1
XTAP_TAPCELL_ROW_110_1891 VSS VDD sky130_fd_sc_hd__tapvpwrvgnd_1
XTAP_TAPCELL_ROW_110_1892 VSS VDD sky130_fd_sc_hd__tapvpwrvgnd_1
XTAP_TAPCELL_ROW_110_1893 VSS VDD sky130_fd_sc_hd__tapvpwrvgnd_1
XTAP_TAPCELL_ROW_110_1894 VSS VDD sky130_fd_sc_hd__tapvpwrvgnd_1
XTAP_TAPCELL_ROW_110_1895 VSS VDD sky130_fd_sc_hd__tapvpwrvgnd_1
XTAP_TAPCELL_ROW_110_1896 VSS VDD sky130_fd_sc_hd__tapvpwrvgnd_1
XTAP_TAPCELL_ROW_110_1897 VSS VDD sky130_fd_sc_hd__tapvpwrvgnd_1
XTAP_TAPCELL_ROW_110_1898 VSS VDD sky130_fd_sc_hd__tapvpwrvgnd_1
XTAP_TAPCELL_ROW_110_1899 VSS VDD sky130_fd_sc_hd__tapvpwrvgnd_1
XTAP_TAPCELL_ROW_110_1900 VSS VDD sky130_fd_sc_hd__tapvpwrvgnd_1
XTAP_TAPCELL_ROW_110_1901 VSS VDD sky130_fd_sc_hd__tapvpwrvgnd_1
XTAP_TAPCELL_ROW_110_1902 VSS VDD sky130_fd_sc_hd__tapvpwrvgnd_1
XTAP_TAPCELL_ROW_110_1903 VSS VDD sky130_fd_sc_hd__tapvpwrvgnd_1
XTAP_TAPCELL_ROW_111_1904 VSS VDD sky130_fd_sc_hd__tapvpwrvgnd_1
XTAP_TAPCELL_ROW_111_1905 VSS VDD sky130_fd_sc_hd__tapvpwrvgnd_1
XTAP_TAPCELL_ROW_111_1906 VSS VDD sky130_fd_sc_hd__tapvpwrvgnd_1
XTAP_TAPCELL_ROW_111_1907 VSS VDD sky130_fd_sc_hd__tapvpwrvgnd_1
XTAP_TAPCELL_ROW_111_1908 VSS VDD sky130_fd_sc_hd__tapvpwrvgnd_1
XTAP_TAPCELL_ROW_111_1909 VSS VDD sky130_fd_sc_hd__tapvpwrvgnd_1
XTAP_TAPCELL_ROW_111_1910 VSS VDD sky130_fd_sc_hd__tapvpwrvgnd_1
XTAP_TAPCELL_ROW_111_1911 VSS VDD sky130_fd_sc_hd__tapvpwrvgnd_1
XTAP_TAPCELL_ROW_111_1912 VSS VDD sky130_fd_sc_hd__tapvpwrvgnd_1
XTAP_TAPCELL_ROW_111_1913 VSS VDD sky130_fd_sc_hd__tapvpwrvgnd_1
XTAP_TAPCELL_ROW_111_1914 VSS VDD sky130_fd_sc_hd__tapvpwrvgnd_1
XTAP_TAPCELL_ROW_111_1915 VSS VDD sky130_fd_sc_hd__tapvpwrvgnd_1
XTAP_TAPCELL_ROW_111_1916 VSS VDD sky130_fd_sc_hd__tapvpwrvgnd_1
XTAP_TAPCELL_ROW_111_1917 VSS VDD sky130_fd_sc_hd__tapvpwrvgnd_1
XTAP_TAPCELL_ROW_111_1918 VSS VDD sky130_fd_sc_hd__tapvpwrvgnd_1
XTAP_TAPCELL_ROW_111_1919 VSS VDD sky130_fd_sc_hd__tapvpwrvgnd_1
XTAP_TAPCELL_ROW_111_1920 VSS VDD sky130_fd_sc_hd__tapvpwrvgnd_1
XTAP_TAPCELL_ROW_112_1921 VSS VDD sky130_fd_sc_hd__tapvpwrvgnd_1
XTAP_TAPCELL_ROW_112_1922 VSS VDD sky130_fd_sc_hd__tapvpwrvgnd_1
XTAP_TAPCELL_ROW_112_1923 VSS VDD sky130_fd_sc_hd__tapvpwrvgnd_1
XTAP_TAPCELL_ROW_112_1924 VSS VDD sky130_fd_sc_hd__tapvpwrvgnd_1
XTAP_TAPCELL_ROW_112_1925 VSS VDD sky130_fd_sc_hd__tapvpwrvgnd_1
XTAP_TAPCELL_ROW_112_1926 VSS VDD sky130_fd_sc_hd__tapvpwrvgnd_1
XTAP_TAPCELL_ROW_112_1927 VSS VDD sky130_fd_sc_hd__tapvpwrvgnd_1
XTAP_TAPCELL_ROW_112_1928 VSS VDD sky130_fd_sc_hd__tapvpwrvgnd_1
XTAP_TAPCELL_ROW_112_1929 VSS VDD sky130_fd_sc_hd__tapvpwrvgnd_1
XTAP_TAPCELL_ROW_112_1930 VSS VDD sky130_fd_sc_hd__tapvpwrvgnd_1
XTAP_TAPCELL_ROW_112_1931 VSS VDD sky130_fd_sc_hd__tapvpwrvgnd_1
XTAP_TAPCELL_ROW_112_1932 VSS VDD sky130_fd_sc_hd__tapvpwrvgnd_1
XTAP_TAPCELL_ROW_112_1933 VSS VDD sky130_fd_sc_hd__tapvpwrvgnd_1
XTAP_TAPCELL_ROW_112_1934 VSS VDD sky130_fd_sc_hd__tapvpwrvgnd_1
XTAP_TAPCELL_ROW_112_1935 VSS VDD sky130_fd_sc_hd__tapvpwrvgnd_1
XTAP_TAPCELL_ROW_112_1936 VSS VDD sky130_fd_sc_hd__tapvpwrvgnd_1
XTAP_TAPCELL_ROW_112_1937 VSS VDD sky130_fd_sc_hd__tapvpwrvgnd_1
XTAP_TAPCELL_ROW_113_1938 VSS VDD sky130_fd_sc_hd__tapvpwrvgnd_1
XTAP_TAPCELL_ROW_113_1939 VSS VDD sky130_fd_sc_hd__tapvpwrvgnd_1
XTAP_TAPCELL_ROW_113_1940 VSS VDD sky130_fd_sc_hd__tapvpwrvgnd_1
XTAP_TAPCELL_ROW_113_1941 VSS VDD sky130_fd_sc_hd__tapvpwrvgnd_1
XTAP_TAPCELL_ROW_113_1942 VSS VDD sky130_fd_sc_hd__tapvpwrvgnd_1
XTAP_TAPCELL_ROW_113_1943 VSS VDD sky130_fd_sc_hd__tapvpwrvgnd_1
XTAP_TAPCELL_ROW_113_1944 VSS VDD sky130_fd_sc_hd__tapvpwrvgnd_1
XTAP_TAPCELL_ROW_113_1945 VSS VDD sky130_fd_sc_hd__tapvpwrvgnd_1
XTAP_TAPCELL_ROW_113_1946 VSS VDD sky130_fd_sc_hd__tapvpwrvgnd_1
XTAP_TAPCELL_ROW_113_1947 VSS VDD sky130_fd_sc_hd__tapvpwrvgnd_1
XTAP_TAPCELL_ROW_113_1948 VSS VDD sky130_fd_sc_hd__tapvpwrvgnd_1
XTAP_TAPCELL_ROW_113_1949 VSS VDD sky130_fd_sc_hd__tapvpwrvgnd_1
XTAP_TAPCELL_ROW_113_1950 VSS VDD sky130_fd_sc_hd__tapvpwrvgnd_1
XTAP_TAPCELL_ROW_113_1951 VSS VDD sky130_fd_sc_hd__tapvpwrvgnd_1
XTAP_TAPCELL_ROW_113_1952 VSS VDD sky130_fd_sc_hd__tapvpwrvgnd_1
XTAP_TAPCELL_ROW_113_1953 VSS VDD sky130_fd_sc_hd__tapvpwrvgnd_1
XTAP_TAPCELL_ROW_113_1954 VSS VDD sky130_fd_sc_hd__tapvpwrvgnd_1
XTAP_TAPCELL_ROW_114_1955 VSS VDD sky130_fd_sc_hd__tapvpwrvgnd_1
XTAP_TAPCELL_ROW_114_1956 VSS VDD sky130_fd_sc_hd__tapvpwrvgnd_1
XTAP_TAPCELL_ROW_114_1957 VSS VDD sky130_fd_sc_hd__tapvpwrvgnd_1
XTAP_TAPCELL_ROW_114_1958 VSS VDD sky130_fd_sc_hd__tapvpwrvgnd_1
XTAP_TAPCELL_ROW_114_1959 VSS VDD sky130_fd_sc_hd__tapvpwrvgnd_1
XTAP_TAPCELL_ROW_114_1960 VSS VDD sky130_fd_sc_hd__tapvpwrvgnd_1
XTAP_TAPCELL_ROW_114_1961 VSS VDD sky130_fd_sc_hd__tapvpwrvgnd_1
XTAP_TAPCELL_ROW_114_1962 VSS VDD sky130_fd_sc_hd__tapvpwrvgnd_1
XTAP_TAPCELL_ROW_114_1963 VSS VDD sky130_fd_sc_hd__tapvpwrvgnd_1
XTAP_TAPCELL_ROW_114_1964 VSS VDD sky130_fd_sc_hd__tapvpwrvgnd_1
XTAP_TAPCELL_ROW_114_1965 VSS VDD sky130_fd_sc_hd__tapvpwrvgnd_1
XTAP_TAPCELL_ROW_114_1966 VSS VDD sky130_fd_sc_hd__tapvpwrvgnd_1
XTAP_TAPCELL_ROW_114_1967 VSS VDD sky130_fd_sc_hd__tapvpwrvgnd_1
XTAP_TAPCELL_ROW_114_1968 VSS VDD sky130_fd_sc_hd__tapvpwrvgnd_1
XTAP_TAPCELL_ROW_114_1969 VSS VDD sky130_fd_sc_hd__tapvpwrvgnd_1
XTAP_TAPCELL_ROW_114_1970 VSS VDD sky130_fd_sc_hd__tapvpwrvgnd_1
XTAP_TAPCELL_ROW_114_1971 VSS VDD sky130_fd_sc_hd__tapvpwrvgnd_1
XTAP_TAPCELL_ROW_115_1972 VSS VDD sky130_fd_sc_hd__tapvpwrvgnd_1
XTAP_TAPCELL_ROW_115_1973 VSS VDD sky130_fd_sc_hd__tapvpwrvgnd_1
XTAP_TAPCELL_ROW_115_1974 VSS VDD sky130_fd_sc_hd__tapvpwrvgnd_1
XTAP_TAPCELL_ROW_115_1975 VSS VDD sky130_fd_sc_hd__tapvpwrvgnd_1
XTAP_TAPCELL_ROW_115_1976 VSS VDD sky130_fd_sc_hd__tapvpwrvgnd_1
XTAP_TAPCELL_ROW_115_1977 VSS VDD sky130_fd_sc_hd__tapvpwrvgnd_1
XTAP_TAPCELL_ROW_115_1978 VSS VDD sky130_fd_sc_hd__tapvpwrvgnd_1
XTAP_TAPCELL_ROW_115_1979 VSS VDD sky130_fd_sc_hd__tapvpwrvgnd_1
XTAP_TAPCELL_ROW_115_1980 VSS VDD sky130_fd_sc_hd__tapvpwrvgnd_1
XTAP_TAPCELL_ROW_115_1981 VSS VDD sky130_fd_sc_hd__tapvpwrvgnd_1
XTAP_TAPCELL_ROW_115_1982 VSS VDD sky130_fd_sc_hd__tapvpwrvgnd_1
XTAP_TAPCELL_ROW_115_1983 VSS VDD sky130_fd_sc_hd__tapvpwrvgnd_1
XTAP_TAPCELL_ROW_115_1984 VSS VDD sky130_fd_sc_hd__tapvpwrvgnd_1
XTAP_TAPCELL_ROW_115_1985 VSS VDD sky130_fd_sc_hd__tapvpwrvgnd_1
XTAP_TAPCELL_ROW_115_1986 VSS VDD sky130_fd_sc_hd__tapvpwrvgnd_1
XTAP_TAPCELL_ROW_115_1987 VSS VDD sky130_fd_sc_hd__tapvpwrvgnd_1
XTAP_TAPCELL_ROW_115_1988 VSS VDD sky130_fd_sc_hd__tapvpwrvgnd_1
XTAP_TAPCELL_ROW_116_1989 VSS VDD sky130_fd_sc_hd__tapvpwrvgnd_1
XTAP_TAPCELL_ROW_116_1990 VSS VDD sky130_fd_sc_hd__tapvpwrvgnd_1
XTAP_TAPCELL_ROW_116_1991 VSS VDD sky130_fd_sc_hd__tapvpwrvgnd_1
XTAP_TAPCELL_ROW_116_1992 VSS VDD sky130_fd_sc_hd__tapvpwrvgnd_1
XTAP_TAPCELL_ROW_116_1993 VSS VDD sky130_fd_sc_hd__tapvpwrvgnd_1
XTAP_TAPCELL_ROW_116_1994 VSS VDD sky130_fd_sc_hd__tapvpwrvgnd_1
XTAP_TAPCELL_ROW_116_1995 VSS VDD sky130_fd_sc_hd__tapvpwrvgnd_1
XTAP_TAPCELL_ROW_116_1996 VSS VDD sky130_fd_sc_hd__tapvpwrvgnd_1
XTAP_TAPCELL_ROW_116_1997 VSS VDD sky130_fd_sc_hd__tapvpwrvgnd_1
XTAP_TAPCELL_ROW_116_1998 VSS VDD sky130_fd_sc_hd__tapvpwrvgnd_1
XTAP_TAPCELL_ROW_116_1999 VSS VDD sky130_fd_sc_hd__tapvpwrvgnd_1
XTAP_TAPCELL_ROW_116_2000 VSS VDD sky130_fd_sc_hd__tapvpwrvgnd_1
XTAP_TAPCELL_ROW_116_2001 VSS VDD sky130_fd_sc_hd__tapvpwrvgnd_1
XTAP_TAPCELL_ROW_116_2002 VSS VDD sky130_fd_sc_hd__tapvpwrvgnd_1
XTAP_TAPCELL_ROW_116_2003 VSS VDD sky130_fd_sc_hd__tapvpwrvgnd_1
XTAP_TAPCELL_ROW_116_2004 VSS VDD sky130_fd_sc_hd__tapvpwrvgnd_1
XTAP_TAPCELL_ROW_116_2005 VSS VDD sky130_fd_sc_hd__tapvpwrvgnd_1
XTAP_TAPCELL_ROW_117_2006 VSS VDD sky130_fd_sc_hd__tapvpwrvgnd_1
XTAP_TAPCELL_ROW_117_2007 VSS VDD sky130_fd_sc_hd__tapvpwrvgnd_1
XTAP_TAPCELL_ROW_117_2008 VSS VDD sky130_fd_sc_hd__tapvpwrvgnd_1
XTAP_TAPCELL_ROW_117_2009 VSS VDD sky130_fd_sc_hd__tapvpwrvgnd_1
XTAP_TAPCELL_ROW_117_2010 VSS VDD sky130_fd_sc_hd__tapvpwrvgnd_1
XTAP_TAPCELL_ROW_117_2011 VSS VDD sky130_fd_sc_hd__tapvpwrvgnd_1
XTAP_TAPCELL_ROW_117_2012 VSS VDD sky130_fd_sc_hd__tapvpwrvgnd_1
XTAP_TAPCELL_ROW_117_2013 VSS VDD sky130_fd_sc_hd__tapvpwrvgnd_1
XTAP_TAPCELL_ROW_117_2014 VSS VDD sky130_fd_sc_hd__tapvpwrvgnd_1
XTAP_TAPCELL_ROW_117_2015 VSS VDD sky130_fd_sc_hd__tapvpwrvgnd_1
XTAP_TAPCELL_ROW_117_2016 VSS VDD sky130_fd_sc_hd__tapvpwrvgnd_1
XTAP_TAPCELL_ROW_117_2017 VSS VDD sky130_fd_sc_hd__tapvpwrvgnd_1
XTAP_TAPCELL_ROW_117_2018 VSS VDD sky130_fd_sc_hd__tapvpwrvgnd_1
XTAP_TAPCELL_ROW_117_2019 VSS VDD sky130_fd_sc_hd__tapvpwrvgnd_1
XTAP_TAPCELL_ROW_117_2020 VSS VDD sky130_fd_sc_hd__tapvpwrvgnd_1
XTAP_TAPCELL_ROW_117_2021 VSS VDD sky130_fd_sc_hd__tapvpwrvgnd_1
XTAP_TAPCELL_ROW_117_2022 VSS VDD sky130_fd_sc_hd__tapvpwrvgnd_1
XTAP_TAPCELL_ROW_118_2023 VSS VDD sky130_fd_sc_hd__tapvpwrvgnd_1
XTAP_TAPCELL_ROW_118_2024 VSS VDD sky130_fd_sc_hd__tapvpwrvgnd_1
XTAP_TAPCELL_ROW_118_2025 VSS VDD sky130_fd_sc_hd__tapvpwrvgnd_1
XTAP_TAPCELL_ROW_118_2026 VSS VDD sky130_fd_sc_hd__tapvpwrvgnd_1
XTAP_TAPCELL_ROW_118_2027 VSS VDD sky130_fd_sc_hd__tapvpwrvgnd_1
XTAP_TAPCELL_ROW_118_2028 VSS VDD sky130_fd_sc_hd__tapvpwrvgnd_1
XTAP_TAPCELL_ROW_118_2029 VSS VDD sky130_fd_sc_hd__tapvpwrvgnd_1
XTAP_TAPCELL_ROW_118_2030 VSS VDD sky130_fd_sc_hd__tapvpwrvgnd_1
XTAP_TAPCELL_ROW_118_2031 VSS VDD sky130_fd_sc_hd__tapvpwrvgnd_1
XTAP_TAPCELL_ROW_118_2032 VSS VDD sky130_fd_sc_hd__tapvpwrvgnd_1
XTAP_TAPCELL_ROW_118_2033 VSS VDD sky130_fd_sc_hd__tapvpwrvgnd_1
XTAP_TAPCELL_ROW_118_2034 VSS VDD sky130_fd_sc_hd__tapvpwrvgnd_1
XTAP_TAPCELL_ROW_118_2035 VSS VDD sky130_fd_sc_hd__tapvpwrvgnd_1
XTAP_TAPCELL_ROW_118_2036 VSS VDD sky130_fd_sc_hd__tapvpwrvgnd_1
XTAP_TAPCELL_ROW_118_2037 VSS VDD sky130_fd_sc_hd__tapvpwrvgnd_1
XTAP_TAPCELL_ROW_118_2038 VSS VDD sky130_fd_sc_hd__tapvpwrvgnd_1
XTAP_TAPCELL_ROW_118_2039 VSS VDD sky130_fd_sc_hd__tapvpwrvgnd_1
XTAP_TAPCELL_ROW_119_2040 VSS VDD sky130_fd_sc_hd__tapvpwrvgnd_1
XTAP_TAPCELL_ROW_119_2041 VSS VDD sky130_fd_sc_hd__tapvpwrvgnd_1
XTAP_TAPCELL_ROW_119_2042 VSS VDD sky130_fd_sc_hd__tapvpwrvgnd_1
XTAP_TAPCELL_ROW_119_2043 VSS VDD sky130_fd_sc_hd__tapvpwrvgnd_1
XTAP_TAPCELL_ROW_119_2044 VSS VDD sky130_fd_sc_hd__tapvpwrvgnd_1
XTAP_TAPCELL_ROW_119_2045 VSS VDD sky130_fd_sc_hd__tapvpwrvgnd_1
XTAP_TAPCELL_ROW_119_2046 VSS VDD sky130_fd_sc_hd__tapvpwrvgnd_1
XTAP_TAPCELL_ROW_119_2047 VSS VDD sky130_fd_sc_hd__tapvpwrvgnd_1
XTAP_TAPCELL_ROW_119_2048 VSS VDD sky130_fd_sc_hd__tapvpwrvgnd_1
XTAP_TAPCELL_ROW_119_2049 VSS VDD sky130_fd_sc_hd__tapvpwrvgnd_1
XTAP_TAPCELL_ROW_119_2050 VSS VDD sky130_fd_sc_hd__tapvpwrvgnd_1
XTAP_TAPCELL_ROW_119_2051 VSS VDD sky130_fd_sc_hd__tapvpwrvgnd_1
XTAP_TAPCELL_ROW_119_2052 VSS VDD sky130_fd_sc_hd__tapvpwrvgnd_1
XTAP_TAPCELL_ROW_119_2053 VSS VDD sky130_fd_sc_hd__tapvpwrvgnd_1
XTAP_TAPCELL_ROW_119_2054 VSS VDD sky130_fd_sc_hd__tapvpwrvgnd_1
XTAP_TAPCELL_ROW_119_2055 VSS VDD sky130_fd_sc_hd__tapvpwrvgnd_1
XTAP_TAPCELL_ROW_119_2056 VSS VDD sky130_fd_sc_hd__tapvpwrvgnd_1
XTAP_TAPCELL_ROW_120_2057 VSS VDD sky130_fd_sc_hd__tapvpwrvgnd_1
XTAP_TAPCELL_ROW_120_2058 VSS VDD sky130_fd_sc_hd__tapvpwrvgnd_1
XTAP_TAPCELL_ROW_120_2059 VSS VDD sky130_fd_sc_hd__tapvpwrvgnd_1
XTAP_TAPCELL_ROW_120_2060 VSS VDD sky130_fd_sc_hd__tapvpwrvgnd_1
XTAP_TAPCELL_ROW_120_2061 VSS VDD sky130_fd_sc_hd__tapvpwrvgnd_1
XTAP_TAPCELL_ROW_120_2062 VSS VDD sky130_fd_sc_hd__tapvpwrvgnd_1
XTAP_TAPCELL_ROW_120_2063 VSS VDD sky130_fd_sc_hd__tapvpwrvgnd_1
XTAP_TAPCELL_ROW_120_2064 VSS VDD sky130_fd_sc_hd__tapvpwrvgnd_1
XTAP_TAPCELL_ROW_120_2065 VSS VDD sky130_fd_sc_hd__tapvpwrvgnd_1
XTAP_TAPCELL_ROW_120_2066 VSS VDD sky130_fd_sc_hd__tapvpwrvgnd_1
XTAP_TAPCELL_ROW_120_2067 VSS VDD sky130_fd_sc_hd__tapvpwrvgnd_1
XTAP_TAPCELL_ROW_120_2068 VSS VDD sky130_fd_sc_hd__tapvpwrvgnd_1
XTAP_TAPCELL_ROW_120_2069 VSS VDD sky130_fd_sc_hd__tapvpwrvgnd_1
XTAP_TAPCELL_ROW_120_2070 VSS VDD sky130_fd_sc_hd__tapvpwrvgnd_1
XTAP_TAPCELL_ROW_120_2071 VSS VDD sky130_fd_sc_hd__tapvpwrvgnd_1
XTAP_TAPCELL_ROW_120_2072 VSS VDD sky130_fd_sc_hd__tapvpwrvgnd_1
XTAP_TAPCELL_ROW_120_2073 VSS VDD sky130_fd_sc_hd__tapvpwrvgnd_1
XTAP_TAPCELL_ROW_121_2074 VSS VDD sky130_fd_sc_hd__tapvpwrvgnd_1
XTAP_TAPCELL_ROW_121_2075 VSS VDD sky130_fd_sc_hd__tapvpwrvgnd_1
XTAP_TAPCELL_ROW_121_2076 VSS VDD sky130_fd_sc_hd__tapvpwrvgnd_1
XTAP_TAPCELL_ROW_121_2077 VSS VDD sky130_fd_sc_hd__tapvpwrvgnd_1
XTAP_TAPCELL_ROW_121_2078 VSS VDD sky130_fd_sc_hd__tapvpwrvgnd_1
XTAP_TAPCELL_ROW_121_2079 VSS VDD sky130_fd_sc_hd__tapvpwrvgnd_1
XTAP_TAPCELL_ROW_121_2080 VSS VDD sky130_fd_sc_hd__tapvpwrvgnd_1
XTAP_TAPCELL_ROW_121_2081 VSS VDD sky130_fd_sc_hd__tapvpwrvgnd_1
XTAP_TAPCELL_ROW_121_2082 VSS VDD sky130_fd_sc_hd__tapvpwrvgnd_1
XTAP_TAPCELL_ROW_121_2083 VSS VDD sky130_fd_sc_hd__tapvpwrvgnd_1
XTAP_TAPCELL_ROW_121_2084 VSS VDD sky130_fd_sc_hd__tapvpwrvgnd_1
XTAP_TAPCELL_ROW_121_2085 VSS VDD sky130_fd_sc_hd__tapvpwrvgnd_1
XTAP_TAPCELL_ROW_121_2086 VSS VDD sky130_fd_sc_hd__tapvpwrvgnd_1
XTAP_TAPCELL_ROW_121_2087 VSS VDD sky130_fd_sc_hd__tapvpwrvgnd_1
XTAP_TAPCELL_ROW_121_2088 VSS VDD sky130_fd_sc_hd__tapvpwrvgnd_1
XTAP_TAPCELL_ROW_121_2089 VSS VDD sky130_fd_sc_hd__tapvpwrvgnd_1
XTAP_TAPCELL_ROW_121_2090 VSS VDD sky130_fd_sc_hd__tapvpwrvgnd_1
XTAP_TAPCELL_ROW_122_2091 VSS VDD sky130_fd_sc_hd__tapvpwrvgnd_1
XTAP_TAPCELL_ROW_122_2092 VSS VDD sky130_fd_sc_hd__tapvpwrvgnd_1
XTAP_TAPCELL_ROW_122_2093 VSS VDD sky130_fd_sc_hd__tapvpwrvgnd_1
XTAP_TAPCELL_ROW_122_2094 VSS VDD sky130_fd_sc_hd__tapvpwrvgnd_1
XTAP_TAPCELL_ROW_122_2095 VSS VDD sky130_fd_sc_hd__tapvpwrvgnd_1
XTAP_TAPCELL_ROW_122_2096 VSS VDD sky130_fd_sc_hd__tapvpwrvgnd_1
XTAP_TAPCELL_ROW_122_2097 VSS VDD sky130_fd_sc_hd__tapvpwrvgnd_1
XTAP_TAPCELL_ROW_122_2098 VSS VDD sky130_fd_sc_hd__tapvpwrvgnd_1
XTAP_TAPCELL_ROW_122_2099 VSS VDD sky130_fd_sc_hd__tapvpwrvgnd_1
XTAP_TAPCELL_ROW_122_2100 VSS VDD sky130_fd_sc_hd__tapvpwrvgnd_1
XTAP_TAPCELL_ROW_122_2101 VSS VDD sky130_fd_sc_hd__tapvpwrvgnd_1
XTAP_TAPCELL_ROW_122_2102 VSS VDD sky130_fd_sc_hd__tapvpwrvgnd_1
XTAP_TAPCELL_ROW_122_2103 VSS VDD sky130_fd_sc_hd__tapvpwrvgnd_1
XTAP_TAPCELL_ROW_122_2104 VSS VDD sky130_fd_sc_hd__tapvpwrvgnd_1
XTAP_TAPCELL_ROW_122_2105 VSS VDD sky130_fd_sc_hd__tapvpwrvgnd_1
XTAP_TAPCELL_ROW_122_2106 VSS VDD sky130_fd_sc_hd__tapvpwrvgnd_1
XTAP_TAPCELL_ROW_122_2107 VSS VDD sky130_fd_sc_hd__tapvpwrvgnd_1
XTAP_TAPCELL_ROW_123_2108 VSS VDD sky130_fd_sc_hd__tapvpwrvgnd_1
XTAP_TAPCELL_ROW_123_2109 VSS VDD sky130_fd_sc_hd__tapvpwrvgnd_1
XTAP_TAPCELL_ROW_123_2110 VSS VDD sky130_fd_sc_hd__tapvpwrvgnd_1
XTAP_TAPCELL_ROW_123_2111 VSS VDD sky130_fd_sc_hd__tapvpwrvgnd_1
XTAP_TAPCELL_ROW_123_2112 VSS VDD sky130_fd_sc_hd__tapvpwrvgnd_1
XTAP_TAPCELL_ROW_123_2113 VSS VDD sky130_fd_sc_hd__tapvpwrvgnd_1
XTAP_TAPCELL_ROW_123_2114 VSS VDD sky130_fd_sc_hd__tapvpwrvgnd_1
XTAP_TAPCELL_ROW_123_2115 VSS VDD sky130_fd_sc_hd__tapvpwrvgnd_1
XTAP_TAPCELL_ROW_123_2116 VSS VDD sky130_fd_sc_hd__tapvpwrvgnd_1
XTAP_TAPCELL_ROW_123_2117 VSS VDD sky130_fd_sc_hd__tapvpwrvgnd_1
XTAP_TAPCELL_ROW_123_2118 VSS VDD sky130_fd_sc_hd__tapvpwrvgnd_1
XTAP_TAPCELL_ROW_123_2119 VSS VDD sky130_fd_sc_hd__tapvpwrvgnd_1
XTAP_TAPCELL_ROW_123_2120 VSS VDD sky130_fd_sc_hd__tapvpwrvgnd_1
XTAP_TAPCELL_ROW_123_2121 VSS VDD sky130_fd_sc_hd__tapvpwrvgnd_1
XTAP_TAPCELL_ROW_123_2122 VSS VDD sky130_fd_sc_hd__tapvpwrvgnd_1
XTAP_TAPCELL_ROW_123_2123 VSS VDD sky130_fd_sc_hd__tapvpwrvgnd_1
XTAP_TAPCELL_ROW_123_2124 VSS VDD sky130_fd_sc_hd__tapvpwrvgnd_1
XTAP_TAPCELL_ROW_124_2125 VSS VDD sky130_fd_sc_hd__tapvpwrvgnd_1
XTAP_TAPCELL_ROW_124_2126 VSS VDD sky130_fd_sc_hd__tapvpwrvgnd_1
XTAP_TAPCELL_ROW_124_2127 VSS VDD sky130_fd_sc_hd__tapvpwrvgnd_1
XTAP_TAPCELL_ROW_124_2128 VSS VDD sky130_fd_sc_hd__tapvpwrvgnd_1
XTAP_TAPCELL_ROW_124_2129 VSS VDD sky130_fd_sc_hd__tapvpwrvgnd_1
XTAP_TAPCELL_ROW_124_2130 VSS VDD sky130_fd_sc_hd__tapvpwrvgnd_1
XTAP_TAPCELL_ROW_124_2131 VSS VDD sky130_fd_sc_hd__tapvpwrvgnd_1
XTAP_TAPCELL_ROW_124_2132 VSS VDD sky130_fd_sc_hd__tapvpwrvgnd_1
XTAP_TAPCELL_ROW_124_2133 VSS VDD sky130_fd_sc_hd__tapvpwrvgnd_1
XTAP_TAPCELL_ROW_124_2134 VSS VDD sky130_fd_sc_hd__tapvpwrvgnd_1
XTAP_TAPCELL_ROW_124_2135 VSS VDD sky130_fd_sc_hd__tapvpwrvgnd_1
XTAP_TAPCELL_ROW_124_2136 VSS VDD sky130_fd_sc_hd__tapvpwrvgnd_1
XTAP_TAPCELL_ROW_124_2137 VSS VDD sky130_fd_sc_hd__tapvpwrvgnd_1
XTAP_TAPCELL_ROW_124_2138 VSS VDD sky130_fd_sc_hd__tapvpwrvgnd_1
XTAP_TAPCELL_ROW_124_2139 VSS VDD sky130_fd_sc_hd__tapvpwrvgnd_1
XTAP_TAPCELL_ROW_124_2140 VSS VDD sky130_fd_sc_hd__tapvpwrvgnd_1
XTAP_TAPCELL_ROW_124_2141 VSS VDD sky130_fd_sc_hd__tapvpwrvgnd_1
XTAP_TAPCELL_ROW_125_2142 VSS VDD sky130_fd_sc_hd__tapvpwrvgnd_1
XTAP_TAPCELL_ROW_125_2143 VSS VDD sky130_fd_sc_hd__tapvpwrvgnd_1
XTAP_TAPCELL_ROW_125_2144 VSS VDD sky130_fd_sc_hd__tapvpwrvgnd_1
XTAP_TAPCELL_ROW_125_2145 VSS VDD sky130_fd_sc_hd__tapvpwrvgnd_1
XTAP_TAPCELL_ROW_125_2146 VSS VDD sky130_fd_sc_hd__tapvpwrvgnd_1
XTAP_TAPCELL_ROW_125_2147 VSS VDD sky130_fd_sc_hd__tapvpwrvgnd_1
XTAP_TAPCELL_ROW_125_2148 VSS VDD sky130_fd_sc_hd__tapvpwrvgnd_1
XTAP_TAPCELL_ROW_125_2149 VSS VDD sky130_fd_sc_hd__tapvpwrvgnd_1
XTAP_TAPCELL_ROW_125_2150 VSS VDD sky130_fd_sc_hd__tapvpwrvgnd_1
XTAP_TAPCELL_ROW_125_2151 VSS VDD sky130_fd_sc_hd__tapvpwrvgnd_1
XTAP_TAPCELL_ROW_125_2152 VSS VDD sky130_fd_sc_hd__tapvpwrvgnd_1
XTAP_TAPCELL_ROW_125_2153 VSS VDD sky130_fd_sc_hd__tapvpwrvgnd_1
XTAP_TAPCELL_ROW_125_2154 VSS VDD sky130_fd_sc_hd__tapvpwrvgnd_1
XTAP_TAPCELL_ROW_125_2155 VSS VDD sky130_fd_sc_hd__tapvpwrvgnd_1
XTAP_TAPCELL_ROW_125_2156 VSS VDD sky130_fd_sc_hd__tapvpwrvgnd_1
XTAP_TAPCELL_ROW_125_2157 VSS VDD sky130_fd_sc_hd__tapvpwrvgnd_1
XTAP_TAPCELL_ROW_125_2158 VSS VDD sky130_fd_sc_hd__tapvpwrvgnd_1
XTAP_TAPCELL_ROW_126_2159 VSS VDD sky130_fd_sc_hd__tapvpwrvgnd_1
XTAP_TAPCELL_ROW_126_2160 VSS VDD sky130_fd_sc_hd__tapvpwrvgnd_1
XTAP_TAPCELL_ROW_126_2161 VSS VDD sky130_fd_sc_hd__tapvpwrvgnd_1
XTAP_TAPCELL_ROW_126_2162 VSS VDD sky130_fd_sc_hd__tapvpwrvgnd_1
XTAP_TAPCELL_ROW_126_2163 VSS VDD sky130_fd_sc_hd__tapvpwrvgnd_1
XTAP_TAPCELL_ROW_126_2164 VSS VDD sky130_fd_sc_hd__tapvpwrvgnd_1
XTAP_TAPCELL_ROW_126_2165 VSS VDD sky130_fd_sc_hd__tapvpwrvgnd_1
XTAP_TAPCELL_ROW_126_2166 VSS VDD sky130_fd_sc_hd__tapvpwrvgnd_1
XTAP_TAPCELL_ROW_126_2167 VSS VDD sky130_fd_sc_hd__tapvpwrvgnd_1
XTAP_TAPCELL_ROW_126_2168 VSS VDD sky130_fd_sc_hd__tapvpwrvgnd_1
XTAP_TAPCELL_ROW_126_2169 VSS VDD sky130_fd_sc_hd__tapvpwrvgnd_1
XTAP_TAPCELL_ROW_126_2170 VSS VDD sky130_fd_sc_hd__tapvpwrvgnd_1
XTAP_TAPCELL_ROW_126_2171 VSS VDD sky130_fd_sc_hd__tapvpwrvgnd_1
XTAP_TAPCELL_ROW_126_2172 VSS VDD sky130_fd_sc_hd__tapvpwrvgnd_1
XTAP_TAPCELL_ROW_126_2173 VSS VDD sky130_fd_sc_hd__tapvpwrvgnd_1
XTAP_TAPCELL_ROW_126_2174 VSS VDD sky130_fd_sc_hd__tapvpwrvgnd_1
XTAP_TAPCELL_ROW_126_2175 VSS VDD sky130_fd_sc_hd__tapvpwrvgnd_1
XTAP_TAPCELL_ROW_127_2176 VSS VDD sky130_fd_sc_hd__tapvpwrvgnd_1
XTAP_TAPCELL_ROW_127_2177 VSS VDD sky130_fd_sc_hd__tapvpwrvgnd_1
XTAP_TAPCELL_ROW_127_2178 VSS VDD sky130_fd_sc_hd__tapvpwrvgnd_1
XTAP_TAPCELL_ROW_127_2179 VSS VDD sky130_fd_sc_hd__tapvpwrvgnd_1
XTAP_TAPCELL_ROW_127_2180 VSS VDD sky130_fd_sc_hd__tapvpwrvgnd_1
XTAP_TAPCELL_ROW_127_2181 VSS VDD sky130_fd_sc_hd__tapvpwrvgnd_1
XTAP_TAPCELL_ROW_127_2182 VSS VDD sky130_fd_sc_hd__tapvpwrvgnd_1
XTAP_TAPCELL_ROW_127_2183 VSS VDD sky130_fd_sc_hd__tapvpwrvgnd_1
XTAP_TAPCELL_ROW_127_2184 VSS VDD sky130_fd_sc_hd__tapvpwrvgnd_1
XTAP_TAPCELL_ROW_127_2185 VSS VDD sky130_fd_sc_hd__tapvpwrvgnd_1
XTAP_TAPCELL_ROW_127_2186 VSS VDD sky130_fd_sc_hd__tapvpwrvgnd_1
XTAP_TAPCELL_ROW_127_2187 VSS VDD sky130_fd_sc_hd__tapvpwrvgnd_1
XTAP_TAPCELL_ROW_127_2188 VSS VDD sky130_fd_sc_hd__tapvpwrvgnd_1
XTAP_TAPCELL_ROW_127_2189 VSS VDD sky130_fd_sc_hd__tapvpwrvgnd_1
XTAP_TAPCELL_ROW_127_2190 VSS VDD sky130_fd_sc_hd__tapvpwrvgnd_1
XTAP_TAPCELL_ROW_127_2191 VSS VDD sky130_fd_sc_hd__tapvpwrvgnd_1
XTAP_TAPCELL_ROW_127_2192 VSS VDD sky130_fd_sc_hd__tapvpwrvgnd_1
XTAP_TAPCELL_ROW_128_2193 VSS VDD sky130_fd_sc_hd__tapvpwrvgnd_1
XTAP_TAPCELL_ROW_128_2194 VSS VDD sky130_fd_sc_hd__tapvpwrvgnd_1
XTAP_TAPCELL_ROW_128_2195 VSS VDD sky130_fd_sc_hd__tapvpwrvgnd_1
XTAP_TAPCELL_ROW_128_2196 VSS VDD sky130_fd_sc_hd__tapvpwrvgnd_1
XTAP_TAPCELL_ROW_128_2197 VSS VDD sky130_fd_sc_hd__tapvpwrvgnd_1
XTAP_TAPCELL_ROW_128_2198 VSS VDD sky130_fd_sc_hd__tapvpwrvgnd_1
XTAP_TAPCELL_ROW_128_2199 VSS VDD sky130_fd_sc_hd__tapvpwrvgnd_1
XTAP_TAPCELL_ROW_128_2200 VSS VDD sky130_fd_sc_hd__tapvpwrvgnd_1
XTAP_TAPCELL_ROW_128_2201 VSS VDD sky130_fd_sc_hd__tapvpwrvgnd_1
XTAP_TAPCELL_ROW_128_2202 VSS VDD sky130_fd_sc_hd__tapvpwrvgnd_1
XTAP_TAPCELL_ROW_128_2203 VSS VDD sky130_fd_sc_hd__tapvpwrvgnd_1
XTAP_TAPCELL_ROW_128_2204 VSS VDD sky130_fd_sc_hd__tapvpwrvgnd_1
XTAP_TAPCELL_ROW_128_2205 VSS VDD sky130_fd_sc_hd__tapvpwrvgnd_1
XTAP_TAPCELL_ROW_128_2206 VSS VDD sky130_fd_sc_hd__tapvpwrvgnd_1
XTAP_TAPCELL_ROW_128_2207 VSS VDD sky130_fd_sc_hd__tapvpwrvgnd_1
XTAP_TAPCELL_ROW_128_2208 VSS VDD sky130_fd_sc_hd__tapvpwrvgnd_1
XTAP_TAPCELL_ROW_128_2209 VSS VDD sky130_fd_sc_hd__tapvpwrvgnd_1
XTAP_TAPCELL_ROW_129_2210 VSS VDD sky130_fd_sc_hd__tapvpwrvgnd_1
XTAP_TAPCELL_ROW_129_2211 VSS VDD sky130_fd_sc_hd__tapvpwrvgnd_1
XTAP_TAPCELL_ROW_129_2212 VSS VDD sky130_fd_sc_hd__tapvpwrvgnd_1
XTAP_TAPCELL_ROW_129_2213 VSS VDD sky130_fd_sc_hd__tapvpwrvgnd_1
XTAP_TAPCELL_ROW_129_2214 VSS VDD sky130_fd_sc_hd__tapvpwrvgnd_1
XTAP_TAPCELL_ROW_129_2215 VSS VDD sky130_fd_sc_hd__tapvpwrvgnd_1
XTAP_TAPCELL_ROW_129_2216 VSS VDD sky130_fd_sc_hd__tapvpwrvgnd_1
XTAP_TAPCELL_ROW_129_2217 VSS VDD sky130_fd_sc_hd__tapvpwrvgnd_1
XTAP_TAPCELL_ROW_129_2218 VSS VDD sky130_fd_sc_hd__tapvpwrvgnd_1
XTAP_TAPCELL_ROW_129_2219 VSS VDD sky130_fd_sc_hd__tapvpwrvgnd_1
XTAP_TAPCELL_ROW_129_2220 VSS VDD sky130_fd_sc_hd__tapvpwrvgnd_1
XTAP_TAPCELL_ROW_129_2221 VSS VDD sky130_fd_sc_hd__tapvpwrvgnd_1
XTAP_TAPCELL_ROW_129_2222 VSS VDD sky130_fd_sc_hd__tapvpwrvgnd_1
XTAP_TAPCELL_ROW_129_2223 VSS VDD sky130_fd_sc_hd__tapvpwrvgnd_1
XTAP_TAPCELL_ROW_129_2224 VSS VDD sky130_fd_sc_hd__tapvpwrvgnd_1
XTAP_TAPCELL_ROW_129_2225 VSS VDD sky130_fd_sc_hd__tapvpwrvgnd_1
XTAP_TAPCELL_ROW_129_2226 VSS VDD sky130_fd_sc_hd__tapvpwrvgnd_1
XTAP_TAPCELL_ROW_130_2227 VSS VDD sky130_fd_sc_hd__tapvpwrvgnd_1
XTAP_TAPCELL_ROW_130_2228 VSS VDD sky130_fd_sc_hd__tapvpwrvgnd_1
XTAP_TAPCELL_ROW_130_2229 VSS VDD sky130_fd_sc_hd__tapvpwrvgnd_1
XTAP_TAPCELL_ROW_130_2230 VSS VDD sky130_fd_sc_hd__tapvpwrvgnd_1
XTAP_TAPCELL_ROW_130_2231 VSS VDD sky130_fd_sc_hd__tapvpwrvgnd_1
XTAP_TAPCELL_ROW_130_2232 VSS VDD sky130_fd_sc_hd__tapvpwrvgnd_1
XTAP_TAPCELL_ROW_130_2233 VSS VDD sky130_fd_sc_hd__tapvpwrvgnd_1
XTAP_TAPCELL_ROW_130_2234 VSS VDD sky130_fd_sc_hd__tapvpwrvgnd_1
XTAP_TAPCELL_ROW_130_2235 VSS VDD sky130_fd_sc_hd__tapvpwrvgnd_1
XTAP_TAPCELL_ROW_130_2236 VSS VDD sky130_fd_sc_hd__tapvpwrvgnd_1
XTAP_TAPCELL_ROW_130_2237 VSS VDD sky130_fd_sc_hd__tapvpwrvgnd_1
XTAP_TAPCELL_ROW_130_2238 VSS VDD sky130_fd_sc_hd__tapvpwrvgnd_1
XTAP_TAPCELL_ROW_130_2239 VSS VDD sky130_fd_sc_hd__tapvpwrvgnd_1
XTAP_TAPCELL_ROW_130_2240 VSS VDD sky130_fd_sc_hd__tapvpwrvgnd_1
XTAP_TAPCELL_ROW_130_2241 VSS VDD sky130_fd_sc_hd__tapvpwrvgnd_1
XTAP_TAPCELL_ROW_130_2242 VSS VDD sky130_fd_sc_hd__tapvpwrvgnd_1
XTAP_TAPCELL_ROW_130_2243 VSS VDD sky130_fd_sc_hd__tapvpwrvgnd_1
XTAP_TAPCELL_ROW_131_2244 VSS VDD sky130_fd_sc_hd__tapvpwrvgnd_1
XTAP_TAPCELL_ROW_131_2245 VSS VDD sky130_fd_sc_hd__tapvpwrvgnd_1
XTAP_TAPCELL_ROW_131_2246 VSS VDD sky130_fd_sc_hd__tapvpwrvgnd_1
XTAP_TAPCELL_ROW_131_2247 VSS VDD sky130_fd_sc_hd__tapvpwrvgnd_1
XTAP_TAPCELL_ROW_131_2248 VSS VDD sky130_fd_sc_hd__tapvpwrvgnd_1
XTAP_TAPCELL_ROW_131_2249 VSS VDD sky130_fd_sc_hd__tapvpwrvgnd_1
XTAP_TAPCELL_ROW_131_2250 VSS VDD sky130_fd_sc_hd__tapvpwrvgnd_1
XTAP_TAPCELL_ROW_131_2251 VSS VDD sky130_fd_sc_hd__tapvpwrvgnd_1
XTAP_TAPCELL_ROW_131_2252 VSS VDD sky130_fd_sc_hd__tapvpwrvgnd_1
XTAP_TAPCELL_ROW_131_2253 VSS VDD sky130_fd_sc_hd__tapvpwrvgnd_1
XTAP_TAPCELL_ROW_131_2254 VSS VDD sky130_fd_sc_hd__tapvpwrvgnd_1
XTAP_TAPCELL_ROW_131_2255 VSS VDD sky130_fd_sc_hd__tapvpwrvgnd_1
XTAP_TAPCELL_ROW_131_2256 VSS VDD sky130_fd_sc_hd__tapvpwrvgnd_1
XTAP_TAPCELL_ROW_131_2257 VSS VDD sky130_fd_sc_hd__tapvpwrvgnd_1
XTAP_TAPCELL_ROW_131_2258 VSS VDD sky130_fd_sc_hd__tapvpwrvgnd_1
XTAP_TAPCELL_ROW_131_2259 VSS VDD sky130_fd_sc_hd__tapvpwrvgnd_1
XTAP_TAPCELL_ROW_131_2260 VSS VDD sky130_fd_sc_hd__tapvpwrvgnd_1
XTAP_TAPCELL_ROW_132_2261 VSS VDD sky130_fd_sc_hd__tapvpwrvgnd_1
XTAP_TAPCELL_ROW_132_2262 VSS VDD sky130_fd_sc_hd__tapvpwrvgnd_1
XTAP_TAPCELL_ROW_132_2263 VSS VDD sky130_fd_sc_hd__tapvpwrvgnd_1
XTAP_TAPCELL_ROW_132_2264 VSS VDD sky130_fd_sc_hd__tapvpwrvgnd_1
XTAP_TAPCELL_ROW_132_2265 VSS VDD sky130_fd_sc_hd__tapvpwrvgnd_1
XTAP_TAPCELL_ROW_132_2266 VSS VDD sky130_fd_sc_hd__tapvpwrvgnd_1
XTAP_TAPCELL_ROW_132_2267 VSS VDD sky130_fd_sc_hd__tapvpwrvgnd_1
XTAP_TAPCELL_ROW_132_2268 VSS VDD sky130_fd_sc_hd__tapvpwrvgnd_1
XTAP_TAPCELL_ROW_132_2269 VSS VDD sky130_fd_sc_hd__tapvpwrvgnd_1
XTAP_TAPCELL_ROW_132_2270 VSS VDD sky130_fd_sc_hd__tapvpwrvgnd_1
XTAP_TAPCELL_ROW_132_2271 VSS VDD sky130_fd_sc_hd__tapvpwrvgnd_1
XTAP_TAPCELL_ROW_132_2272 VSS VDD sky130_fd_sc_hd__tapvpwrvgnd_1
XTAP_TAPCELL_ROW_132_2273 VSS VDD sky130_fd_sc_hd__tapvpwrvgnd_1
XTAP_TAPCELL_ROW_132_2274 VSS VDD sky130_fd_sc_hd__tapvpwrvgnd_1
XTAP_TAPCELL_ROW_132_2275 VSS VDD sky130_fd_sc_hd__tapvpwrvgnd_1
XTAP_TAPCELL_ROW_132_2276 VSS VDD sky130_fd_sc_hd__tapvpwrvgnd_1
XTAP_TAPCELL_ROW_132_2277 VSS VDD sky130_fd_sc_hd__tapvpwrvgnd_1
XTAP_TAPCELL_ROW_133_2278 VSS VDD sky130_fd_sc_hd__tapvpwrvgnd_1
XTAP_TAPCELL_ROW_133_2279 VSS VDD sky130_fd_sc_hd__tapvpwrvgnd_1
XTAP_TAPCELL_ROW_133_2280 VSS VDD sky130_fd_sc_hd__tapvpwrvgnd_1
XTAP_TAPCELL_ROW_133_2281 VSS VDD sky130_fd_sc_hd__tapvpwrvgnd_1
XTAP_TAPCELL_ROW_133_2282 VSS VDD sky130_fd_sc_hd__tapvpwrvgnd_1
XTAP_TAPCELL_ROW_133_2283 VSS VDD sky130_fd_sc_hd__tapvpwrvgnd_1
XTAP_TAPCELL_ROW_133_2284 VSS VDD sky130_fd_sc_hd__tapvpwrvgnd_1
XTAP_TAPCELL_ROW_133_2285 VSS VDD sky130_fd_sc_hd__tapvpwrvgnd_1
XTAP_TAPCELL_ROW_133_2286 VSS VDD sky130_fd_sc_hd__tapvpwrvgnd_1
XTAP_TAPCELL_ROW_133_2287 VSS VDD sky130_fd_sc_hd__tapvpwrvgnd_1
XTAP_TAPCELL_ROW_133_2288 VSS VDD sky130_fd_sc_hd__tapvpwrvgnd_1
XTAP_TAPCELL_ROW_133_2289 VSS VDD sky130_fd_sc_hd__tapvpwrvgnd_1
XTAP_TAPCELL_ROW_133_2290 VSS VDD sky130_fd_sc_hd__tapvpwrvgnd_1
XTAP_TAPCELL_ROW_133_2291 VSS VDD sky130_fd_sc_hd__tapvpwrvgnd_1
XTAP_TAPCELL_ROW_133_2292 VSS VDD sky130_fd_sc_hd__tapvpwrvgnd_1
XTAP_TAPCELL_ROW_133_2293 VSS VDD sky130_fd_sc_hd__tapvpwrvgnd_1
XTAP_TAPCELL_ROW_133_2294 VSS VDD sky130_fd_sc_hd__tapvpwrvgnd_1
XTAP_TAPCELL_ROW_134_2295 VSS VDD sky130_fd_sc_hd__tapvpwrvgnd_1
XTAP_TAPCELL_ROW_134_2296 VSS VDD sky130_fd_sc_hd__tapvpwrvgnd_1
XTAP_TAPCELL_ROW_134_2297 VSS VDD sky130_fd_sc_hd__tapvpwrvgnd_1
XTAP_TAPCELL_ROW_134_2298 VSS VDD sky130_fd_sc_hd__tapvpwrvgnd_1
XTAP_TAPCELL_ROW_134_2299 VSS VDD sky130_fd_sc_hd__tapvpwrvgnd_1
XTAP_TAPCELL_ROW_134_2300 VSS VDD sky130_fd_sc_hd__tapvpwrvgnd_1
XTAP_TAPCELL_ROW_134_2301 VSS VDD sky130_fd_sc_hd__tapvpwrvgnd_1
XTAP_TAPCELL_ROW_134_2302 VSS VDD sky130_fd_sc_hd__tapvpwrvgnd_1
XTAP_TAPCELL_ROW_134_2303 VSS VDD sky130_fd_sc_hd__tapvpwrvgnd_1
XTAP_TAPCELL_ROW_134_2304 VSS VDD sky130_fd_sc_hd__tapvpwrvgnd_1
XTAP_TAPCELL_ROW_134_2305 VSS VDD sky130_fd_sc_hd__tapvpwrvgnd_1
XTAP_TAPCELL_ROW_134_2306 VSS VDD sky130_fd_sc_hd__tapvpwrvgnd_1
XTAP_TAPCELL_ROW_134_2307 VSS VDD sky130_fd_sc_hd__tapvpwrvgnd_1
XTAP_TAPCELL_ROW_134_2308 VSS VDD sky130_fd_sc_hd__tapvpwrvgnd_1
XTAP_TAPCELL_ROW_134_2309 VSS VDD sky130_fd_sc_hd__tapvpwrvgnd_1
XTAP_TAPCELL_ROW_134_2310 VSS VDD sky130_fd_sc_hd__tapvpwrvgnd_1
XTAP_TAPCELL_ROW_134_2311 VSS VDD sky130_fd_sc_hd__tapvpwrvgnd_1
XTAP_TAPCELL_ROW_135_2312 VSS VDD sky130_fd_sc_hd__tapvpwrvgnd_1
XTAP_TAPCELL_ROW_135_2313 VSS VDD sky130_fd_sc_hd__tapvpwrvgnd_1
XTAP_TAPCELL_ROW_135_2314 VSS VDD sky130_fd_sc_hd__tapvpwrvgnd_1
XTAP_TAPCELL_ROW_135_2315 VSS VDD sky130_fd_sc_hd__tapvpwrvgnd_1
XTAP_TAPCELL_ROW_135_2316 VSS VDD sky130_fd_sc_hd__tapvpwrvgnd_1
XTAP_TAPCELL_ROW_135_2317 VSS VDD sky130_fd_sc_hd__tapvpwrvgnd_1
XTAP_TAPCELL_ROW_135_2318 VSS VDD sky130_fd_sc_hd__tapvpwrvgnd_1
XTAP_TAPCELL_ROW_135_2319 VSS VDD sky130_fd_sc_hd__tapvpwrvgnd_1
XTAP_TAPCELL_ROW_135_2320 VSS VDD sky130_fd_sc_hd__tapvpwrvgnd_1
XTAP_TAPCELL_ROW_135_2321 VSS VDD sky130_fd_sc_hd__tapvpwrvgnd_1
XTAP_TAPCELL_ROW_135_2322 VSS VDD sky130_fd_sc_hd__tapvpwrvgnd_1
XTAP_TAPCELL_ROW_135_2323 VSS VDD sky130_fd_sc_hd__tapvpwrvgnd_1
XTAP_TAPCELL_ROW_135_2324 VSS VDD sky130_fd_sc_hd__tapvpwrvgnd_1
XTAP_TAPCELL_ROW_135_2325 VSS VDD sky130_fd_sc_hd__tapvpwrvgnd_1
XTAP_TAPCELL_ROW_135_2326 VSS VDD sky130_fd_sc_hd__tapvpwrvgnd_1
XTAP_TAPCELL_ROW_135_2327 VSS VDD sky130_fd_sc_hd__tapvpwrvgnd_1
XTAP_TAPCELL_ROW_135_2328 VSS VDD sky130_fd_sc_hd__tapvpwrvgnd_1
XTAP_TAPCELL_ROW_136_2329 VSS VDD sky130_fd_sc_hd__tapvpwrvgnd_1
XTAP_TAPCELL_ROW_136_2330 VSS VDD sky130_fd_sc_hd__tapvpwrvgnd_1
XTAP_TAPCELL_ROW_136_2331 VSS VDD sky130_fd_sc_hd__tapvpwrvgnd_1
XTAP_TAPCELL_ROW_136_2332 VSS VDD sky130_fd_sc_hd__tapvpwrvgnd_1
XTAP_TAPCELL_ROW_136_2333 VSS VDD sky130_fd_sc_hd__tapvpwrvgnd_1
XTAP_TAPCELL_ROW_136_2334 VSS VDD sky130_fd_sc_hd__tapvpwrvgnd_1
XTAP_TAPCELL_ROW_136_2335 VSS VDD sky130_fd_sc_hd__tapvpwrvgnd_1
XTAP_TAPCELL_ROW_136_2336 VSS VDD sky130_fd_sc_hd__tapvpwrvgnd_1
XTAP_TAPCELL_ROW_136_2337 VSS VDD sky130_fd_sc_hd__tapvpwrvgnd_1
XTAP_TAPCELL_ROW_136_2338 VSS VDD sky130_fd_sc_hd__tapvpwrvgnd_1
XTAP_TAPCELL_ROW_136_2339 VSS VDD sky130_fd_sc_hd__tapvpwrvgnd_1
XTAP_TAPCELL_ROW_136_2340 VSS VDD sky130_fd_sc_hd__tapvpwrvgnd_1
XTAP_TAPCELL_ROW_136_2341 VSS VDD sky130_fd_sc_hd__tapvpwrvgnd_1
XTAP_TAPCELL_ROW_136_2342 VSS VDD sky130_fd_sc_hd__tapvpwrvgnd_1
XTAP_TAPCELL_ROW_136_2343 VSS VDD sky130_fd_sc_hd__tapvpwrvgnd_1
XTAP_TAPCELL_ROW_136_2344 VSS VDD sky130_fd_sc_hd__tapvpwrvgnd_1
XTAP_TAPCELL_ROW_136_2345 VSS VDD sky130_fd_sc_hd__tapvpwrvgnd_1
XTAP_TAPCELL_ROW_137_2346 VSS VDD sky130_fd_sc_hd__tapvpwrvgnd_1
XTAP_TAPCELL_ROW_137_2347 VSS VDD sky130_fd_sc_hd__tapvpwrvgnd_1
XTAP_TAPCELL_ROW_137_2348 VSS VDD sky130_fd_sc_hd__tapvpwrvgnd_1
XTAP_TAPCELL_ROW_137_2349 VSS VDD sky130_fd_sc_hd__tapvpwrvgnd_1
XTAP_TAPCELL_ROW_137_2350 VSS VDD sky130_fd_sc_hd__tapvpwrvgnd_1
XTAP_TAPCELL_ROW_137_2351 VSS VDD sky130_fd_sc_hd__tapvpwrvgnd_1
XTAP_TAPCELL_ROW_137_2352 VSS VDD sky130_fd_sc_hd__tapvpwrvgnd_1
XTAP_TAPCELL_ROW_137_2353 VSS VDD sky130_fd_sc_hd__tapvpwrvgnd_1
XTAP_TAPCELL_ROW_137_2354 VSS VDD sky130_fd_sc_hd__tapvpwrvgnd_1
XTAP_TAPCELL_ROW_137_2355 VSS VDD sky130_fd_sc_hd__tapvpwrvgnd_1
XTAP_TAPCELL_ROW_137_2356 VSS VDD sky130_fd_sc_hd__tapvpwrvgnd_1
XTAP_TAPCELL_ROW_137_2357 VSS VDD sky130_fd_sc_hd__tapvpwrvgnd_1
XTAP_TAPCELL_ROW_137_2358 VSS VDD sky130_fd_sc_hd__tapvpwrvgnd_1
XTAP_TAPCELL_ROW_137_2359 VSS VDD sky130_fd_sc_hd__tapvpwrvgnd_1
XTAP_TAPCELL_ROW_137_2360 VSS VDD sky130_fd_sc_hd__tapvpwrvgnd_1
XTAP_TAPCELL_ROW_137_2361 VSS VDD sky130_fd_sc_hd__tapvpwrvgnd_1
XTAP_TAPCELL_ROW_137_2362 VSS VDD sky130_fd_sc_hd__tapvpwrvgnd_1
XTAP_TAPCELL_ROW_138_2363 VSS VDD sky130_fd_sc_hd__tapvpwrvgnd_1
XTAP_TAPCELL_ROW_138_2364 VSS VDD sky130_fd_sc_hd__tapvpwrvgnd_1
XTAP_TAPCELL_ROW_138_2365 VSS VDD sky130_fd_sc_hd__tapvpwrvgnd_1
XTAP_TAPCELL_ROW_138_2366 VSS VDD sky130_fd_sc_hd__tapvpwrvgnd_1
XTAP_TAPCELL_ROW_138_2367 VSS VDD sky130_fd_sc_hd__tapvpwrvgnd_1
XTAP_TAPCELL_ROW_138_2368 VSS VDD sky130_fd_sc_hd__tapvpwrvgnd_1
XTAP_TAPCELL_ROW_138_2369 VSS VDD sky130_fd_sc_hd__tapvpwrvgnd_1
XTAP_TAPCELL_ROW_138_2370 VSS VDD sky130_fd_sc_hd__tapvpwrvgnd_1
XTAP_TAPCELL_ROW_138_2371 VSS VDD sky130_fd_sc_hd__tapvpwrvgnd_1
XTAP_TAPCELL_ROW_138_2372 VSS VDD sky130_fd_sc_hd__tapvpwrvgnd_1
XTAP_TAPCELL_ROW_138_2373 VSS VDD sky130_fd_sc_hd__tapvpwrvgnd_1
XTAP_TAPCELL_ROW_138_2374 VSS VDD sky130_fd_sc_hd__tapvpwrvgnd_1
XTAP_TAPCELL_ROW_138_2375 VSS VDD sky130_fd_sc_hd__tapvpwrvgnd_1
XTAP_TAPCELL_ROW_138_2376 VSS VDD sky130_fd_sc_hd__tapvpwrvgnd_1
XTAP_TAPCELL_ROW_138_2377 VSS VDD sky130_fd_sc_hd__tapvpwrvgnd_1
XTAP_TAPCELL_ROW_138_2378 VSS VDD sky130_fd_sc_hd__tapvpwrvgnd_1
XTAP_TAPCELL_ROW_138_2379 VSS VDD sky130_fd_sc_hd__tapvpwrvgnd_1
XTAP_TAPCELL_ROW_139_2380 VSS VDD sky130_fd_sc_hd__tapvpwrvgnd_1
XTAP_TAPCELL_ROW_139_2381 VSS VDD sky130_fd_sc_hd__tapvpwrvgnd_1
XTAP_TAPCELL_ROW_139_2382 VSS VDD sky130_fd_sc_hd__tapvpwrvgnd_1
XTAP_TAPCELL_ROW_139_2383 VSS VDD sky130_fd_sc_hd__tapvpwrvgnd_1
XTAP_TAPCELL_ROW_139_2384 VSS VDD sky130_fd_sc_hd__tapvpwrvgnd_1
XTAP_TAPCELL_ROW_139_2385 VSS VDD sky130_fd_sc_hd__tapvpwrvgnd_1
XTAP_TAPCELL_ROW_139_2386 VSS VDD sky130_fd_sc_hd__tapvpwrvgnd_1
XTAP_TAPCELL_ROW_139_2387 VSS VDD sky130_fd_sc_hd__tapvpwrvgnd_1
XTAP_TAPCELL_ROW_139_2388 VSS VDD sky130_fd_sc_hd__tapvpwrvgnd_1
XTAP_TAPCELL_ROW_139_2389 VSS VDD sky130_fd_sc_hd__tapvpwrvgnd_1
XTAP_TAPCELL_ROW_139_2390 VSS VDD sky130_fd_sc_hd__tapvpwrvgnd_1
XTAP_TAPCELL_ROW_139_2391 VSS VDD sky130_fd_sc_hd__tapvpwrvgnd_1
XTAP_TAPCELL_ROW_139_2392 VSS VDD sky130_fd_sc_hd__tapvpwrvgnd_1
XTAP_TAPCELL_ROW_139_2393 VSS VDD sky130_fd_sc_hd__tapvpwrvgnd_1
XTAP_TAPCELL_ROW_139_2394 VSS VDD sky130_fd_sc_hd__tapvpwrvgnd_1
XTAP_TAPCELL_ROW_139_2395 VSS VDD sky130_fd_sc_hd__tapvpwrvgnd_1
XTAP_TAPCELL_ROW_139_2396 VSS VDD sky130_fd_sc_hd__tapvpwrvgnd_1
XTAP_TAPCELL_ROW_140_2397 VSS VDD sky130_fd_sc_hd__tapvpwrvgnd_1
XTAP_TAPCELL_ROW_140_2398 VSS VDD sky130_fd_sc_hd__tapvpwrvgnd_1
XTAP_TAPCELL_ROW_140_2399 VSS VDD sky130_fd_sc_hd__tapvpwrvgnd_1
XTAP_TAPCELL_ROW_140_2400 VSS VDD sky130_fd_sc_hd__tapvpwrvgnd_1
XTAP_TAPCELL_ROW_140_2401 VSS VDD sky130_fd_sc_hd__tapvpwrvgnd_1
XTAP_TAPCELL_ROW_140_2402 VSS VDD sky130_fd_sc_hd__tapvpwrvgnd_1
XTAP_TAPCELL_ROW_140_2403 VSS VDD sky130_fd_sc_hd__tapvpwrvgnd_1
XTAP_TAPCELL_ROW_140_2404 VSS VDD sky130_fd_sc_hd__tapvpwrvgnd_1
XTAP_TAPCELL_ROW_140_2405 VSS VDD sky130_fd_sc_hd__tapvpwrvgnd_1
XTAP_TAPCELL_ROW_140_2406 VSS VDD sky130_fd_sc_hd__tapvpwrvgnd_1
XTAP_TAPCELL_ROW_140_2407 VSS VDD sky130_fd_sc_hd__tapvpwrvgnd_1
XTAP_TAPCELL_ROW_140_2408 VSS VDD sky130_fd_sc_hd__tapvpwrvgnd_1
XTAP_TAPCELL_ROW_140_2409 VSS VDD sky130_fd_sc_hd__tapvpwrvgnd_1
XTAP_TAPCELL_ROW_140_2410 VSS VDD sky130_fd_sc_hd__tapvpwrvgnd_1
XTAP_TAPCELL_ROW_140_2411 VSS VDD sky130_fd_sc_hd__tapvpwrvgnd_1
XTAP_TAPCELL_ROW_140_2412 VSS VDD sky130_fd_sc_hd__tapvpwrvgnd_1
XTAP_TAPCELL_ROW_140_2413 VSS VDD sky130_fd_sc_hd__tapvpwrvgnd_1
XTAP_TAPCELL_ROW_141_2414 VSS VDD sky130_fd_sc_hd__tapvpwrvgnd_1
XTAP_TAPCELL_ROW_141_2415 VSS VDD sky130_fd_sc_hd__tapvpwrvgnd_1
XTAP_TAPCELL_ROW_141_2416 VSS VDD sky130_fd_sc_hd__tapvpwrvgnd_1
XTAP_TAPCELL_ROW_141_2417 VSS VDD sky130_fd_sc_hd__tapvpwrvgnd_1
XTAP_TAPCELL_ROW_141_2418 VSS VDD sky130_fd_sc_hd__tapvpwrvgnd_1
XTAP_TAPCELL_ROW_141_2419 VSS VDD sky130_fd_sc_hd__tapvpwrvgnd_1
XTAP_TAPCELL_ROW_141_2420 VSS VDD sky130_fd_sc_hd__tapvpwrvgnd_1
XTAP_TAPCELL_ROW_141_2421 VSS VDD sky130_fd_sc_hd__tapvpwrvgnd_1
XTAP_TAPCELL_ROW_141_2422 VSS VDD sky130_fd_sc_hd__tapvpwrvgnd_1
XTAP_TAPCELL_ROW_141_2423 VSS VDD sky130_fd_sc_hd__tapvpwrvgnd_1
XTAP_TAPCELL_ROW_141_2424 VSS VDD sky130_fd_sc_hd__tapvpwrvgnd_1
XTAP_TAPCELL_ROW_141_2425 VSS VDD sky130_fd_sc_hd__tapvpwrvgnd_1
XTAP_TAPCELL_ROW_141_2426 VSS VDD sky130_fd_sc_hd__tapvpwrvgnd_1
XTAP_TAPCELL_ROW_141_2427 VSS VDD sky130_fd_sc_hd__tapvpwrvgnd_1
XTAP_TAPCELL_ROW_141_2428 VSS VDD sky130_fd_sc_hd__tapvpwrvgnd_1
XTAP_TAPCELL_ROW_141_2429 VSS VDD sky130_fd_sc_hd__tapvpwrvgnd_1
XTAP_TAPCELL_ROW_141_2430 VSS VDD sky130_fd_sc_hd__tapvpwrvgnd_1
XTAP_TAPCELL_ROW_142_2431 VSS VDD sky130_fd_sc_hd__tapvpwrvgnd_1
XTAP_TAPCELL_ROW_142_2432 VSS VDD sky130_fd_sc_hd__tapvpwrvgnd_1
XTAP_TAPCELL_ROW_142_2433 VSS VDD sky130_fd_sc_hd__tapvpwrvgnd_1
XTAP_TAPCELL_ROW_142_2434 VSS VDD sky130_fd_sc_hd__tapvpwrvgnd_1
XTAP_TAPCELL_ROW_142_2435 VSS VDD sky130_fd_sc_hd__tapvpwrvgnd_1
XTAP_TAPCELL_ROW_142_2436 VSS VDD sky130_fd_sc_hd__tapvpwrvgnd_1
XTAP_TAPCELL_ROW_142_2437 VSS VDD sky130_fd_sc_hd__tapvpwrvgnd_1
XTAP_TAPCELL_ROW_142_2438 VSS VDD sky130_fd_sc_hd__tapvpwrvgnd_1
XTAP_TAPCELL_ROW_142_2439 VSS VDD sky130_fd_sc_hd__tapvpwrvgnd_1
XTAP_TAPCELL_ROW_142_2440 VSS VDD sky130_fd_sc_hd__tapvpwrvgnd_1
XTAP_TAPCELL_ROW_142_2441 VSS VDD sky130_fd_sc_hd__tapvpwrvgnd_1
XTAP_TAPCELL_ROW_142_2442 VSS VDD sky130_fd_sc_hd__tapvpwrvgnd_1
XTAP_TAPCELL_ROW_142_2443 VSS VDD sky130_fd_sc_hd__tapvpwrvgnd_1
XTAP_TAPCELL_ROW_142_2444 VSS VDD sky130_fd_sc_hd__tapvpwrvgnd_1
XTAP_TAPCELL_ROW_142_2445 VSS VDD sky130_fd_sc_hd__tapvpwrvgnd_1
XTAP_TAPCELL_ROW_142_2446 VSS VDD sky130_fd_sc_hd__tapvpwrvgnd_1
XTAP_TAPCELL_ROW_142_2447 VSS VDD sky130_fd_sc_hd__tapvpwrvgnd_1
XTAP_TAPCELL_ROW_143_2448 VSS VDD sky130_fd_sc_hd__tapvpwrvgnd_1
XTAP_TAPCELL_ROW_143_2449 VSS VDD sky130_fd_sc_hd__tapvpwrvgnd_1
XTAP_TAPCELL_ROW_143_2450 VSS VDD sky130_fd_sc_hd__tapvpwrvgnd_1
XTAP_TAPCELL_ROW_143_2451 VSS VDD sky130_fd_sc_hd__tapvpwrvgnd_1
XTAP_TAPCELL_ROW_143_2452 VSS VDD sky130_fd_sc_hd__tapvpwrvgnd_1
XTAP_TAPCELL_ROW_143_2453 VSS VDD sky130_fd_sc_hd__tapvpwrvgnd_1
XTAP_TAPCELL_ROW_143_2454 VSS VDD sky130_fd_sc_hd__tapvpwrvgnd_1
XTAP_TAPCELL_ROW_143_2455 VSS VDD sky130_fd_sc_hd__tapvpwrvgnd_1
XTAP_TAPCELL_ROW_143_2456 VSS VDD sky130_fd_sc_hd__tapvpwrvgnd_1
XTAP_TAPCELL_ROW_143_2457 VSS VDD sky130_fd_sc_hd__tapvpwrvgnd_1
XTAP_TAPCELL_ROW_143_2458 VSS VDD sky130_fd_sc_hd__tapvpwrvgnd_1
XTAP_TAPCELL_ROW_143_2459 VSS VDD sky130_fd_sc_hd__tapvpwrvgnd_1
XTAP_TAPCELL_ROW_143_2460 VSS VDD sky130_fd_sc_hd__tapvpwrvgnd_1
XTAP_TAPCELL_ROW_143_2461 VSS VDD sky130_fd_sc_hd__tapvpwrvgnd_1
XTAP_TAPCELL_ROW_143_2462 VSS VDD sky130_fd_sc_hd__tapvpwrvgnd_1
XTAP_TAPCELL_ROW_143_2463 VSS VDD sky130_fd_sc_hd__tapvpwrvgnd_1
XTAP_TAPCELL_ROW_143_2464 VSS VDD sky130_fd_sc_hd__tapvpwrvgnd_1
XTAP_TAPCELL_ROW_144_2465 VSS VDD sky130_fd_sc_hd__tapvpwrvgnd_1
XTAP_TAPCELL_ROW_144_2466 VSS VDD sky130_fd_sc_hd__tapvpwrvgnd_1
XTAP_TAPCELL_ROW_144_2467 VSS VDD sky130_fd_sc_hd__tapvpwrvgnd_1
XTAP_TAPCELL_ROW_144_2468 VSS VDD sky130_fd_sc_hd__tapvpwrvgnd_1
XTAP_TAPCELL_ROW_144_2469 VSS VDD sky130_fd_sc_hd__tapvpwrvgnd_1
XTAP_TAPCELL_ROW_144_2470 VSS VDD sky130_fd_sc_hd__tapvpwrvgnd_1
XTAP_TAPCELL_ROW_144_2471 VSS VDD sky130_fd_sc_hd__tapvpwrvgnd_1
XTAP_TAPCELL_ROW_144_2472 VSS VDD sky130_fd_sc_hd__tapvpwrvgnd_1
XTAP_TAPCELL_ROW_144_2473 VSS VDD sky130_fd_sc_hd__tapvpwrvgnd_1
XTAP_TAPCELL_ROW_144_2474 VSS VDD sky130_fd_sc_hd__tapvpwrvgnd_1
XTAP_TAPCELL_ROW_144_2475 VSS VDD sky130_fd_sc_hd__tapvpwrvgnd_1
XTAP_TAPCELL_ROW_144_2476 VSS VDD sky130_fd_sc_hd__tapvpwrvgnd_1
XTAP_TAPCELL_ROW_144_2477 VSS VDD sky130_fd_sc_hd__tapvpwrvgnd_1
XTAP_TAPCELL_ROW_144_2478 VSS VDD sky130_fd_sc_hd__tapvpwrvgnd_1
XTAP_TAPCELL_ROW_144_2479 VSS VDD sky130_fd_sc_hd__tapvpwrvgnd_1
XTAP_TAPCELL_ROW_144_2480 VSS VDD sky130_fd_sc_hd__tapvpwrvgnd_1
XTAP_TAPCELL_ROW_144_2481 VSS VDD sky130_fd_sc_hd__tapvpwrvgnd_1
XTAP_TAPCELL_ROW_145_2482 VSS VDD sky130_fd_sc_hd__tapvpwrvgnd_1
XTAP_TAPCELL_ROW_145_2483 VSS VDD sky130_fd_sc_hd__tapvpwrvgnd_1
XTAP_TAPCELL_ROW_145_2484 VSS VDD sky130_fd_sc_hd__tapvpwrvgnd_1
XTAP_TAPCELL_ROW_145_2485 VSS VDD sky130_fd_sc_hd__tapvpwrvgnd_1
XTAP_TAPCELL_ROW_145_2486 VSS VDD sky130_fd_sc_hd__tapvpwrvgnd_1
XTAP_TAPCELL_ROW_145_2487 VSS VDD sky130_fd_sc_hd__tapvpwrvgnd_1
XTAP_TAPCELL_ROW_145_2488 VSS VDD sky130_fd_sc_hd__tapvpwrvgnd_1
XTAP_TAPCELL_ROW_145_2489 VSS VDD sky130_fd_sc_hd__tapvpwrvgnd_1
XTAP_TAPCELL_ROW_145_2490 VSS VDD sky130_fd_sc_hd__tapvpwrvgnd_1
XTAP_TAPCELL_ROW_145_2491 VSS VDD sky130_fd_sc_hd__tapvpwrvgnd_1
XTAP_TAPCELL_ROW_145_2492 VSS VDD sky130_fd_sc_hd__tapvpwrvgnd_1
XTAP_TAPCELL_ROW_145_2493 VSS VDD sky130_fd_sc_hd__tapvpwrvgnd_1
XTAP_TAPCELL_ROW_145_2494 VSS VDD sky130_fd_sc_hd__tapvpwrvgnd_1
XTAP_TAPCELL_ROW_145_2495 VSS VDD sky130_fd_sc_hd__tapvpwrvgnd_1
XTAP_TAPCELL_ROW_145_2496 VSS VDD sky130_fd_sc_hd__tapvpwrvgnd_1
XTAP_TAPCELL_ROW_145_2497 VSS VDD sky130_fd_sc_hd__tapvpwrvgnd_1
XTAP_TAPCELL_ROW_145_2498 VSS VDD sky130_fd_sc_hd__tapvpwrvgnd_1
XTAP_TAPCELL_ROW_146_2499 VSS VDD sky130_fd_sc_hd__tapvpwrvgnd_1
XTAP_TAPCELL_ROW_146_2500 VSS VDD sky130_fd_sc_hd__tapvpwrvgnd_1
XTAP_TAPCELL_ROW_146_2501 VSS VDD sky130_fd_sc_hd__tapvpwrvgnd_1
XTAP_TAPCELL_ROW_146_2502 VSS VDD sky130_fd_sc_hd__tapvpwrvgnd_1
XTAP_TAPCELL_ROW_146_2503 VSS VDD sky130_fd_sc_hd__tapvpwrvgnd_1
XTAP_TAPCELL_ROW_146_2504 VSS VDD sky130_fd_sc_hd__tapvpwrvgnd_1
XTAP_TAPCELL_ROW_146_2505 VSS VDD sky130_fd_sc_hd__tapvpwrvgnd_1
XTAP_TAPCELL_ROW_146_2506 VSS VDD sky130_fd_sc_hd__tapvpwrvgnd_1
XTAP_TAPCELL_ROW_146_2507 VSS VDD sky130_fd_sc_hd__tapvpwrvgnd_1
XTAP_TAPCELL_ROW_146_2508 VSS VDD sky130_fd_sc_hd__tapvpwrvgnd_1
XTAP_TAPCELL_ROW_146_2509 VSS VDD sky130_fd_sc_hd__tapvpwrvgnd_1
XTAP_TAPCELL_ROW_146_2510 VSS VDD sky130_fd_sc_hd__tapvpwrvgnd_1
XTAP_TAPCELL_ROW_146_2511 VSS VDD sky130_fd_sc_hd__tapvpwrvgnd_1
XTAP_TAPCELL_ROW_146_2512 VSS VDD sky130_fd_sc_hd__tapvpwrvgnd_1
XTAP_TAPCELL_ROW_146_2513 VSS VDD sky130_fd_sc_hd__tapvpwrvgnd_1
XTAP_TAPCELL_ROW_146_2514 VSS VDD sky130_fd_sc_hd__tapvpwrvgnd_1
XTAP_TAPCELL_ROW_146_2515 VSS VDD sky130_fd_sc_hd__tapvpwrvgnd_1
XTAP_TAPCELL_ROW_147_2516 VSS VDD sky130_fd_sc_hd__tapvpwrvgnd_1
XTAP_TAPCELL_ROW_147_2517 VSS VDD sky130_fd_sc_hd__tapvpwrvgnd_1
XTAP_TAPCELL_ROW_147_2518 VSS VDD sky130_fd_sc_hd__tapvpwrvgnd_1
XTAP_TAPCELL_ROW_147_2519 VSS VDD sky130_fd_sc_hd__tapvpwrvgnd_1
XTAP_TAPCELL_ROW_147_2520 VSS VDD sky130_fd_sc_hd__tapvpwrvgnd_1
XTAP_TAPCELL_ROW_147_2521 VSS VDD sky130_fd_sc_hd__tapvpwrvgnd_1
XTAP_TAPCELL_ROW_147_2522 VSS VDD sky130_fd_sc_hd__tapvpwrvgnd_1
XTAP_TAPCELL_ROW_147_2523 VSS VDD sky130_fd_sc_hd__tapvpwrvgnd_1
XTAP_TAPCELL_ROW_147_2524 VSS VDD sky130_fd_sc_hd__tapvpwrvgnd_1
XTAP_TAPCELL_ROW_147_2525 VSS VDD sky130_fd_sc_hd__tapvpwrvgnd_1
XTAP_TAPCELL_ROW_147_2526 VSS VDD sky130_fd_sc_hd__tapvpwrvgnd_1
XTAP_TAPCELL_ROW_147_2527 VSS VDD sky130_fd_sc_hd__tapvpwrvgnd_1
XTAP_TAPCELL_ROW_147_2528 VSS VDD sky130_fd_sc_hd__tapvpwrvgnd_1
XTAP_TAPCELL_ROW_147_2529 VSS VDD sky130_fd_sc_hd__tapvpwrvgnd_1
XTAP_TAPCELL_ROW_147_2530 VSS VDD sky130_fd_sc_hd__tapvpwrvgnd_1
XTAP_TAPCELL_ROW_147_2531 VSS VDD sky130_fd_sc_hd__tapvpwrvgnd_1
XTAP_TAPCELL_ROW_147_2532 VSS VDD sky130_fd_sc_hd__tapvpwrvgnd_1
XTAP_TAPCELL_ROW_148_2533 VSS VDD sky130_fd_sc_hd__tapvpwrvgnd_1
XTAP_TAPCELL_ROW_148_2534 VSS VDD sky130_fd_sc_hd__tapvpwrvgnd_1
XTAP_TAPCELL_ROW_148_2535 VSS VDD sky130_fd_sc_hd__tapvpwrvgnd_1
XTAP_TAPCELL_ROW_148_2536 VSS VDD sky130_fd_sc_hd__tapvpwrvgnd_1
XTAP_TAPCELL_ROW_148_2537 VSS VDD sky130_fd_sc_hd__tapvpwrvgnd_1
XTAP_TAPCELL_ROW_148_2538 VSS VDD sky130_fd_sc_hd__tapvpwrvgnd_1
XTAP_TAPCELL_ROW_148_2539 VSS VDD sky130_fd_sc_hd__tapvpwrvgnd_1
XTAP_TAPCELL_ROW_148_2540 VSS VDD sky130_fd_sc_hd__tapvpwrvgnd_1
XTAP_TAPCELL_ROW_148_2541 VSS VDD sky130_fd_sc_hd__tapvpwrvgnd_1
XTAP_TAPCELL_ROW_148_2542 VSS VDD sky130_fd_sc_hd__tapvpwrvgnd_1
XTAP_TAPCELL_ROW_148_2543 VSS VDD sky130_fd_sc_hd__tapvpwrvgnd_1
XTAP_TAPCELL_ROW_148_2544 VSS VDD sky130_fd_sc_hd__tapvpwrvgnd_1
XTAP_TAPCELL_ROW_148_2545 VSS VDD sky130_fd_sc_hd__tapvpwrvgnd_1
XTAP_TAPCELL_ROW_148_2546 VSS VDD sky130_fd_sc_hd__tapvpwrvgnd_1
XTAP_TAPCELL_ROW_148_2547 VSS VDD sky130_fd_sc_hd__tapvpwrvgnd_1
XTAP_TAPCELL_ROW_148_2548 VSS VDD sky130_fd_sc_hd__tapvpwrvgnd_1
XTAP_TAPCELL_ROW_148_2549 VSS VDD sky130_fd_sc_hd__tapvpwrvgnd_1
XTAP_TAPCELL_ROW_149_2550 VSS VDD sky130_fd_sc_hd__tapvpwrvgnd_1
XTAP_TAPCELL_ROW_149_2551 VSS VDD sky130_fd_sc_hd__tapvpwrvgnd_1
XTAP_TAPCELL_ROW_149_2552 VSS VDD sky130_fd_sc_hd__tapvpwrvgnd_1
XTAP_TAPCELL_ROW_149_2553 VSS VDD sky130_fd_sc_hd__tapvpwrvgnd_1
XTAP_TAPCELL_ROW_149_2554 VSS VDD sky130_fd_sc_hd__tapvpwrvgnd_1
XTAP_TAPCELL_ROW_149_2555 VSS VDD sky130_fd_sc_hd__tapvpwrvgnd_1
XTAP_TAPCELL_ROW_149_2556 VSS VDD sky130_fd_sc_hd__tapvpwrvgnd_1
XTAP_TAPCELL_ROW_149_2557 VSS VDD sky130_fd_sc_hd__tapvpwrvgnd_1
XTAP_TAPCELL_ROW_149_2558 VSS VDD sky130_fd_sc_hd__tapvpwrvgnd_1
XTAP_TAPCELL_ROW_149_2559 VSS VDD sky130_fd_sc_hd__tapvpwrvgnd_1
XTAP_TAPCELL_ROW_149_2560 VSS VDD sky130_fd_sc_hd__tapvpwrvgnd_1
XTAP_TAPCELL_ROW_149_2561 VSS VDD sky130_fd_sc_hd__tapvpwrvgnd_1
XTAP_TAPCELL_ROW_149_2562 VSS VDD sky130_fd_sc_hd__tapvpwrvgnd_1
XTAP_TAPCELL_ROW_149_2563 VSS VDD sky130_fd_sc_hd__tapvpwrvgnd_1
XTAP_TAPCELL_ROW_149_2564 VSS VDD sky130_fd_sc_hd__tapvpwrvgnd_1
XTAP_TAPCELL_ROW_149_2565 VSS VDD sky130_fd_sc_hd__tapvpwrvgnd_1
XTAP_TAPCELL_ROW_149_2566 VSS VDD sky130_fd_sc_hd__tapvpwrvgnd_1
XTAP_TAPCELL_ROW_150_2567 VSS VDD sky130_fd_sc_hd__tapvpwrvgnd_1
XTAP_TAPCELL_ROW_150_2568 VSS VDD sky130_fd_sc_hd__tapvpwrvgnd_1
XTAP_TAPCELL_ROW_150_2569 VSS VDD sky130_fd_sc_hd__tapvpwrvgnd_1
XTAP_TAPCELL_ROW_150_2570 VSS VDD sky130_fd_sc_hd__tapvpwrvgnd_1
XTAP_TAPCELL_ROW_150_2571 VSS VDD sky130_fd_sc_hd__tapvpwrvgnd_1
XTAP_TAPCELL_ROW_150_2572 VSS VDD sky130_fd_sc_hd__tapvpwrvgnd_1
XTAP_TAPCELL_ROW_150_2573 VSS VDD sky130_fd_sc_hd__tapvpwrvgnd_1
XTAP_TAPCELL_ROW_150_2574 VSS VDD sky130_fd_sc_hd__tapvpwrvgnd_1
XTAP_TAPCELL_ROW_150_2575 VSS VDD sky130_fd_sc_hd__tapvpwrvgnd_1
XTAP_TAPCELL_ROW_150_2576 VSS VDD sky130_fd_sc_hd__tapvpwrvgnd_1
XTAP_TAPCELL_ROW_150_2577 VSS VDD sky130_fd_sc_hd__tapvpwrvgnd_1
XTAP_TAPCELL_ROW_150_2578 VSS VDD sky130_fd_sc_hd__tapvpwrvgnd_1
XTAP_TAPCELL_ROW_150_2579 VSS VDD sky130_fd_sc_hd__tapvpwrvgnd_1
XTAP_TAPCELL_ROW_150_2580 VSS VDD sky130_fd_sc_hd__tapvpwrvgnd_1
XTAP_TAPCELL_ROW_150_2581 VSS VDD sky130_fd_sc_hd__tapvpwrvgnd_1
XTAP_TAPCELL_ROW_150_2582 VSS VDD sky130_fd_sc_hd__tapvpwrvgnd_1
XTAP_TAPCELL_ROW_150_2583 VSS VDD sky130_fd_sc_hd__tapvpwrvgnd_1
XTAP_TAPCELL_ROW_151_2584 VSS VDD sky130_fd_sc_hd__tapvpwrvgnd_1
XTAP_TAPCELL_ROW_151_2585 VSS VDD sky130_fd_sc_hd__tapvpwrvgnd_1
XTAP_TAPCELL_ROW_151_2586 VSS VDD sky130_fd_sc_hd__tapvpwrvgnd_1
XTAP_TAPCELL_ROW_151_2587 VSS VDD sky130_fd_sc_hd__tapvpwrvgnd_1
XTAP_TAPCELL_ROW_151_2588 VSS VDD sky130_fd_sc_hd__tapvpwrvgnd_1
XTAP_TAPCELL_ROW_151_2589 VSS VDD sky130_fd_sc_hd__tapvpwrvgnd_1
XTAP_TAPCELL_ROW_151_2590 VSS VDD sky130_fd_sc_hd__tapvpwrvgnd_1
XTAP_TAPCELL_ROW_151_2591 VSS VDD sky130_fd_sc_hd__tapvpwrvgnd_1
XTAP_TAPCELL_ROW_151_2592 VSS VDD sky130_fd_sc_hd__tapvpwrvgnd_1
XTAP_TAPCELL_ROW_151_2593 VSS VDD sky130_fd_sc_hd__tapvpwrvgnd_1
XTAP_TAPCELL_ROW_151_2594 VSS VDD sky130_fd_sc_hd__tapvpwrvgnd_1
XTAP_TAPCELL_ROW_151_2595 VSS VDD sky130_fd_sc_hd__tapvpwrvgnd_1
XTAP_TAPCELL_ROW_151_2596 VSS VDD sky130_fd_sc_hd__tapvpwrvgnd_1
XTAP_TAPCELL_ROW_151_2597 VSS VDD sky130_fd_sc_hd__tapvpwrvgnd_1
XTAP_TAPCELL_ROW_151_2598 VSS VDD sky130_fd_sc_hd__tapvpwrvgnd_1
XTAP_TAPCELL_ROW_151_2599 VSS VDD sky130_fd_sc_hd__tapvpwrvgnd_1
XTAP_TAPCELL_ROW_151_2600 VSS VDD sky130_fd_sc_hd__tapvpwrvgnd_1
XTAP_TAPCELL_ROW_152_2601 VSS VDD sky130_fd_sc_hd__tapvpwrvgnd_1
XTAP_TAPCELL_ROW_152_2602 VSS VDD sky130_fd_sc_hd__tapvpwrvgnd_1
XTAP_TAPCELL_ROW_152_2603 VSS VDD sky130_fd_sc_hd__tapvpwrvgnd_1
XTAP_TAPCELL_ROW_152_2604 VSS VDD sky130_fd_sc_hd__tapvpwrvgnd_1
XTAP_TAPCELL_ROW_152_2605 VSS VDD sky130_fd_sc_hd__tapvpwrvgnd_1
XTAP_TAPCELL_ROW_152_2606 VSS VDD sky130_fd_sc_hd__tapvpwrvgnd_1
XTAP_TAPCELL_ROW_152_2607 VSS VDD sky130_fd_sc_hd__tapvpwrvgnd_1
XTAP_TAPCELL_ROW_152_2608 VSS VDD sky130_fd_sc_hd__tapvpwrvgnd_1
XTAP_TAPCELL_ROW_152_2609 VSS VDD sky130_fd_sc_hd__tapvpwrvgnd_1
XTAP_TAPCELL_ROW_152_2610 VSS VDD sky130_fd_sc_hd__tapvpwrvgnd_1
XTAP_TAPCELL_ROW_152_2611 VSS VDD sky130_fd_sc_hd__tapvpwrvgnd_1
XTAP_TAPCELL_ROW_152_2612 VSS VDD sky130_fd_sc_hd__tapvpwrvgnd_1
XTAP_TAPCELL_ROW_152_2613 VSS VDD sky130_fd_sc_hd__tapvpwrvgnd_1
XTAP_TAPCELL_ROW_152_2614 VSS VDD sky130_fd_sc_hd__tapvpwrvgnd_1
XTAP_TAPCELL_ROW_152_2615 VSS VDD sky130_fd_sc_hd__tapvpwrvgnd_1
XTAP_TAPCELL_ROW_152_2616 VSS VDD sky130_fd_sc_hd__tapvpwrvgnd_1
XTAP_TAPCELL_ROW_152_2617 VSS VDD sky130_fd_sc_hd__tapvpwrvgnd_1
XTAP_TAPCELL_ROW_153_2618 VSS VDD sky130_fd_sc_hd__tapvpwrvgnd_1
XTAP_TAPCELL_ROW_153_2619 VSS VDD sky130_fd_sc_hd__tapvpwrvgnd_1
XTAP_TAPCELL_ROW_153_2620 VSS VDD sky130_fd_sc_hd__tapvpwrvgnd_1
XTAP_TAPCELL_ROW_153_2621 VSS VDD sky130_fd_sc_hd__tapvpwrvgnd_1
XTAP_TAPCELL_ROW_153_2622 VSS VDD sky130_fd_sc_hd__tapvpwrvgnd_1
XTAP_TAPCELL_ROW_153_2623 VSS VDD sky130_fd_sc_hd__tapvpwrvgnd_1
XTAP_TAPCELL_ROW_153_2624 VSS VDD sky130_fd_sc_hd__tapvpwrvgnd_1
XTAP_TAPCELL_ROW_153_2625 VSS VDD sky130_fd_sc_hd__tapvpwrvgnd_1
XTAP_TAPCELL_ROW_153_2626 VSS VDD sky130_fd_sc_hd__tapvpwrvgnd_1
XTAP_TAPCELL_ROW_153_2627 VSS VDD sky130_fd_sc_hd__tapvpwrvgnd_1
XTAP_TAPCELL_ROW_153_2628 VSS VDD sky130_fd_sc_hd__tapvpwrvgnd_1
XTAP_TAPCELL_ROW_153_2629 VSS VDD sky130_fd_sc_hd__tapvpwrvgnd_1
XTAP_TAPCELL_ROW_153_2630 VSS VDD sky130_fd_sc_hd__tapvpwrvgnd_1
XTAP_TAPCELL_ROW_153_2631 VSS VDD sky130_fd_sc_hd__tapvpwrvgnd_1
XTAP_TAPCELL_ROW_153_2632 VSS VDD sky130_fd_sc_hd__tapvpwrvgnd_1
XTAP_TAPCELL_ROW_153_2633 VSS VDD sky130_fd_sc_hd__tapvpwrvgnd_1
XTAP_TAPCELL_ROW_153_2634 VSS VDD sky130_fd_sc_hd__tapvpwrvgnd_1
XTAP_TAPCELL_ROW_154_2635 VSS VDD sky130_fd_sc_hd__tapvpwrvgnd_1
XTAP_TAPCELL_ROW_154_2636 VSS VDD sky130_fd_sc_hd__tapvpwrvgnd_1
XTAP_TAPCELL_ROW_154_2637 VSS VDD sky130_fd_sc_hd__tapvpwrvgnd_1
XTAP_TAPCELL_ROW_154_2638 VSS VDD sky130_fd_sc_hd__tapvpwrvgnd_1
XTAP_TAPCELL_ROW_154_2639 VSS VDD sky130_fd_sc_hd__tapvpwrvgnd_1
XTAP_TAPCELL_ROW_154_2640 VSS VDD sky130_fd_sc_hd__tapvpwrvgnd_1
XTAP_TAPCELL_ROW_154_2641 VSS VDD sky130_fd_sc_hd__tapvpwrvgnd_1
XTAP_TAPCELL_ROW_154_2642 VSS VDD sky130_fd_sc_hd__tapvpwrvgnd_1
XTAP_TAPCELL_ROW_154_2643 VSS VDD sky130_fd_sc_hd__tapvpwrvgnd_1
XTAP_TAPCELL_ROW_154_2644 VSS VDD sky130_fd_sc_hd__tapvpwrvgnd_1
XTAP_TAPCELL_ROW_154_2645 VSS VDD sky130_fd_sc_hd__tapvpwrvgnd_1
XTAP_TAPCELL_ROW_154_2646 VSS VDD sky130_fd_sc_hd__tapvpwrvgnd_1
XTAP_TAPCELL_ROW_154_2647 VSS VDD sky130_fd_sc_hd__tapvpwrvgnd_1
XTAP_TAPCELL_ROW_154_2648 VSS VDD sky130_fd_sc_hd__tapvpwrvgnd_1
XTAP_TAPCELL_ROW_154_2649 VSS VDD sky130_fd_sc_hd__tapvpwrvgnd_1
XTAP_TAPCELL_ROW_154_2650 VSS VDD sky130_fd_sc_hd__tapvpwrvgnd_1
XTAP_TAPCELL_ROW_154_2651 VSS VDD sky130_fd_sc_hd__tapvpwrvgnd_1
XTAP_TAPCELL_ROW_155_2652 VSS VDD sky130_fd_sc_hd__tapvpwrvgnd_1
XTAP_TAPCELL_ROW_155_2653 VSS VDD sky130_fd_sc_hd__tapvpwrvgnd_1
XTAP_TAPCELL_ROW_155_2654 VSS VDD sky130_fd_sc_hd__tapvpwrvgnd_1
XTAP_TAPCELL_ROW_155_2655 VSS VDD sky130_fd_sc_hd__tapvpwrvgnd_1
XTAP_TAPCELL_ROW_155_2656 VSS VDD sky130_fd_sc_hd__tapvpwrvgnd_1
XTAP_TAPCELL_ROW_155_2657 VSS VDD sky130_fd_sc_hd__tapvpwrvgnd_1
XTAP_TAPCELL_ROW_155_2658 VSS VDD sky130_fd_sc_hd__tapvpwrvgnd_1
XTAP_TAPCELL_ROW_155_2659 VSS VDD sky130_fd_sc_hd__tapvpwrvgnd_1
XTAP_TAPCELL_ROW_155_2660 VSS VDD sky130_fd_sc_hd__tapvpwrvgnd_1
XTAP_TAPCELL_ROW_155_2661 VSS VDD sky130_fd_sc_hd__tapvpwrvgnd_1
XTAP_TAPCELL_ROW_155_2662 VSS VDD sky130_fd_sc_hd__tapvpwrvgnd_1
XTAP_TAPCELL_ROW_155_2663 VSS VDD sky130_fd_sc_hd__tapvpwrvgnd_1
XTAP_TAPCELL_ROW_155_2664 VSS VDD sky130_fd_sc_hd__tapvpwrvgnd_1
XTAP_TAPCELL_ROW_155_2665 VSS VDD sky130_fd_sc_hd__tapvpwrvgnd_1
XTAP_TAPCELL_ROW_155_2666 VSS VDD sky130_fd_sc_hd__tapvpwrvgnd_1
XTAP_TAPCELL_ROW_155_2667 VSS VDD sky130_fd_sc_hd__tapvpwrvgnd_1
XTAP_TAPCELL_ROW_155_2668 VSS VDD sky130_fd_sc_hd__tapvpwrvgnd_1
XTAP_TAPCELL_ROW_156_2669 VSS VDD sky130_fd_sc_hd__tapvpwrvgnd_1
XTAP_TAPCELL_ROW_156_2670 VSS VDD sky130_fd_sc_hd__tapvpwrvgnd_1
XTAP_TAPCELL_ROW_156_2671 VSS VDD sky130_fd_sc_hd__tapvpwrvgnd_1
XTAP_TAPCELL_ROW_156_2672 VSS VDD sky130_fd_sc_hd__tapvpwrvgnd_1
XTAP_TAPCELL_ROW_156_2673 VSS VDD sky130_fd_sc_hd__tapvpwrvgnd_1
XTAP_TAPCELL_ROW_156_2674 VSS VDD sky130_fd_sc_hd__tapvpwrvgnd_1
XTAP_TAPCELL_ROW_156_2675 VSS VDD sky130_fd_sc_hd__tapvpwrvgnd_1
XTAP_TAPCELL_ROW_156_2676 VSS VDD sky130_fd_sc_hd__tapvpwrvgnd_1
XTAP_TAPCELL_ROW_156_2677 VSS VDD sky130_fd_sc_hd__tapvpwrvgnd_1
XTAP_TAPCELL_ROW_156_2678 VSS VDD sky130_fd_sc_hd__tapvpwrvgnd_1
XTAP_TAPCELL_ROW_156_2679 VSS VDD sky130_fd_sc_hd__tapvpwrvgnd_1
XTAP_TAPCELL_ROW_156_2680 VSS VDD sky130_fd_sc_hd__tapvpwrvgnd_1
XTAP_TAPCELL_ROW_156_2681 VSS VDD sky130_fd_sc_hd__tapvpwrvgnd_1
XTAP_TAPCELL_ROW_156_2682 VSS VDD sky130_fd_sc_hd__tapvpwrvgnd_1
XTAP_TAPCELL_ROW_156_2683 VSS VDD sky130_fd_sc_hd__tapvpwrvgnd_1
XTAP_TAPCELL_ROW_156_2684 VSS VDD sky130_fd_sc_hd__tapvpwrvgnd_1
XTAP_TAPCELL_ROW_156_2685 VSS VDD sky130_fd_sc_hd__tapvpwrvgnd_1
XTAP_TAPCELL_ROW_157_2686 VSS VDD sky130_fd_sc_hd__tapvpwrvgnd_1
XTAP_TAPCELL_ROW_157_2687 VSS VDD sky130_fd_sc_hd__tapvpwrvgnd_1
XTAP_TAPCELL_ROW_157_2688 VSS VDD sky130_fd_sc_hd__tapvpwrvgnd_1
XTAP_TAPCELL_ROW_157_2689 VSS VDD sky130_fd_sc_hd__tapvpwrvgnd_1
XTAP_TAPCELL_ROW_157_2690 VSS VDD sky130_fd_sc_hd__tapvpwrvgnd_1
XTAP_TAPCELL_ROW_157_2691 VSS VDD sky130_fd_sc_hd__tapvpwrvgnd_1
XTAP_TAPCELL_ROW_157_2692 VSS VDD sky130_fd_sc_hd__tapvpwrvgnd_1
XTAP_TAPCELL_ROW_157_2693 VSS VDD sky130_fd_sc_hd__tapvpwrvgnd_1
XTAP_TAPCELL_ROW_157_2694 VSS VDD sky130_fd_sc_hd__tapvpwrvgnd_1
XTAP_TAPCELL_ROW_157_2695 VSS VDD sky130_fd_sc_hd__tapvpwrvgnd_1
XTAP_TAPCELL_ROW_157_2696 VSS VDD sky130_fd_sc_hd__tapvpwrvgnd_1
XTAP_TAPCELL_ROW_157_2697 VSS VDD sky130_fd_sc_hd__tapvpwrvgnd_1
XTAP_TAPCELL_ROW_157_2698 VSS VDD sky130_fd_sc_hd__tapvpwrvgnd_1
XTAP_TAPCELL_ROW_157_2699 VSS VDD sky130_fd_sc_hd__tapvpwrvgnd_1
XTAP_TAPCELL_ROW_157_2700 VSS VDD sky130_fd_sc_hd__tapvpwrvgnd_1
XTAP_TAPCELL_ROW_157_2701 VSS VDD sky130_fd_sc_hd__tapvpwrvgnd_1
XTAP_TAPCELL_ROW_157_2702 VSS VDD sky130_fd_sc_hd__tapvpwrvgnd_1
XTAP_TAPCELL_ROW_158_2703 VSS VDD sky130_fd_sc_hd__tapvpwrvgnd_1
XTAP_TAPCELL_ROW_158_2704 VSS VDD sky130_fd_sc_hd__tapvpwrvgnd_1
XTAP_TAPCELL_ROW_158_2705 VSS VDD sky130_fd_sc_hd__tapvpwrvgnd_1
XTAP_TAPCELL_ROW_158_2706 VSS VDD sky130_fd_sc_hd__tapvpwrvgnd_1
XTAP_TAPCELL_ROW_158_2707 VSS VDD sky130_fd_sc_hd__tapvpwrvgnd_1
XTAP_TAPCELL_ROW_158_2708 VSS VDD sky130_fd_sc_hd__tapvpwrvgnd_1
XTAP_TAPCELL_ROW_158_2709 VSS VDD sky130_fd_sc_hd__tapvpwrvgnd_1
XTAP_TAPCELL_ROW_158_2710 VSS VDD sky130_fd_sc_hd__tapvpwrvgnd_1
XTAP_TAPCELL_ROW_158_2711 VSS VDD sky130_fd_sc_hd__tapvpwrvgnd_1
XTAP_TAPCELL_ROW_158_2712 VSS VDD sky130_fd_sc_hd__tapvpwrvgnd_1
XTAP_TAPCELL_ROW_158_2713 VSS VDD sky130_fd_sc_hd__tapvpwrvgnd_1
XTAP_TAPCELL_ROW_158_2714 VSS VDD sky130_fd_sc_hd__tapvpwrvgnd_1
XTAP_TAPCELL_ROW_158_2715 VSS VDD sky130_fd_sc_hd__tapvpwrvgnd_1
XTAP_TAPCELL_ROW_158_2716 VSS VDD sky130_fd_sc_hd__tapvpwrvgnd_1
XTAP_TAPCELL_ROW_158_2717 VSS VDD sky130_fd_sc_hd__tapvpwrvgnd_1
XTAP_TAPCELL_ROW_158_2718 VSS VDD sky130_fd_sc_hd__tapvpwrvgnd_1
XTAP_TAPCELL_ROW_158_2719 VSS VDD sky130_fd_sc_hd__tapvpwrvgnd_1
XTAP_TAPCELL_ROW_159_2720 VSS VDD sky130_fd_sc_hd__tapvpwrvgnd_1
XTAP_TAPCELL_ROW_159_2721 VSS VDD sky130_fd_sc_hd__tapvpwrvgnd_1
XTAP_TAPCELL_ROW_159_2722 VSS VDD sky130_fd_sc_hd__tapvpwrvgnd_1
XTAP_TAPCELL_ROW_159_2723 VSS VDD sky130_fd_sc_hd__tapvpwrvgnd_1
XTAP_TAPCELL_ROW_159_2724 VSS VDD sky130_fd_sc_hd__tapvpwrvgnd_1
XTAP_TAPCELL_ROW_159_2725 VSS VDD sky130_fd_sc_hd__tapvpwrvgnd_1
XTAP_TAPCELL_ROW_159_2726 VSS VDD sky130_fd_sc_hd__tapvpwrvgnd_1
XTAP_TAPCELL_ROW_159_2727 VSS VDD sky130_fd_sc_hd__tapvpwrvgnd_1
XTAP_TAPCELL_ROW_159_2728 VSS VDD sky130_fd_sc_hd__tapvpwrvgnd_1
XTAP_TAPCELL_ROW_159_2729 VSS VDD sky130_fd_sc_hd__tapvpwrvgnd_1
XTAP_TAPCELL_ROW_159_2730 VSS VDD sky130_fd_sc_hd__tapvpwrvgnd_1
XTAP_TAPCELL_ROW_159_2731 VSS VDD sky130_fd_sc_hd__tapvpwrvgnd_1
XTAP_TAPCELL_ROW_159_2732 VSS VDD sky130_fd_sc_hd__tapvpwrvgnd_1
XTAP_TAPCELL_ROW_159_2733 VSS VDD sky130_fd_sc_hd__tapvpwrvgnd_1
XTAP_TAPCELL_ROW_159_2734 VSS VDD sky130_fd_sc_hd__tapvpwrvgnd_1
XTAP_TAPCELL_ROW_159_2735 VSS VDD sky130_fd_sc_hd__tapvpwrvgnd_1
XTAP_TAPCELL_ROW_159_2736 VSS VDD sky130_fd_sc_hd__tapvpwrvgnd_1
XTAP_TAPCELL_ROW_160_2737 VSS VDD sky130_fd_sc_hd__tapvpwrvgnd_1
XTAP_TAPCELL_ROW_160_2738 VSS VDD sky130_fd_sc_hd__tapvpwrvgnd_1
XTAP_TAPCELL_ROW_160_2739 VSS VDD sky130_fd_sc_hd__tapvpwrvgnd_1
XTAP_TAPCELL_ROW_160_2740 VSS VDD sky130_fd_sc_hd__tapvpwrvgnd_1
XTAP_TAPCELL_ROW_160_2741 VSS VDD sky130_fd_sc_hd__tapvpwrvgnd_1
XTAP_TAPCELL_ROW_160_2742 VSS VDD sky130_fd_sc_hd__tapvpwrvgnd_1
XTAP_TAPCELL_ROW_160_2743 VSS VDD sky130_fd_sc_hd__tapvpwrvgnd_1
XTAP_TAPCELL_ROW_160_2744 VSS VDD sky130_fd_sc_hd__tapvpwrvgnd_1
XTAP_TAPCELL_ROW_160_2745 VSS VDD sky130_fd_sc_hd__tapvpwrvgnd_1
XTAP_TAPCELL_ROW_160_2746 VSS VDD sky130_fd_sc_hd__tapvpwrvgnd_1
XTAP_TAPCELL_ROW_160_2747 VSS VDD sky130_fd_sc_hd__tapvpwrvgnd_1
XTAP_TAPCELL_ROW_160_2748 VSS VDD sky130_fd_sc_hd__tapvpwrvgnd_1
XTAP_TAPCELL_ROW_160_2749 VSS VDD sky130_fd_sc_hd__tapvpwrvgnd_1
XTAP_TAPCELL_ROW_160_2750 VSS VDD sky130_fd_sc_hd__tapvpwrvgnd_1
XTAP_TAPCELL_ROW_160_2751 VSS VDD sky130_fd_sc_hd__tapvpwrvgnd_1
XTAP_TAPCELL_ROW_160_2752 VSS VDD sky130_fd_sc_hd__tapvpwrvgnd_1
XTAP_TAPCELL_ROW_160_2753 VSS VDD sky130_fd_sc_hd__tapvpwrvgnd_1
XTAP_TAPCELL_ROW_161_2754 VSS VDD sky130_fd_sc_hd__tapvpwrvgnd_1
XTAP_TAPCELL_ROW_161_2755 VSS VDD sky130_fd_sc_hd__tapvpwrvgnd_1
XTAP_TAPCELL_ROW_161_2756 VSS VDD sky130_fd_sc_hd__tapvpwrvgnd_1
XTAP_TAPCELL_ROW_161_2757 VSS VDD sky130_fd_sc_hd__tapvpwrvgnd_1
XTAP_TAPCELL_ROW_161_2758 VSS VDD sky130_fd_sc_hd__tapvpwrvgnd_1
XTAP_TAPCELL_ROW_161_2759 VSS VDD sky130_fd_sc_hd__tapvpwrvgnd_1
XTAP_TAPCELL_ROW_161_2760 VSS VDD sky130_fd_sc_hd__tapvpwrvgnd_1
XTAP_TAPCELL_ROW_161_2761 VSS VDD sky130_fd_sc_hd__tapvpwrvgnd_1
XTAP_TAPCELL_ROW_161_2762 VSS VDD sky130_fd_sc_hd__tapvpwrvgnd_1
XTAP_TAPCELL_ROW_161_2763 VSS VDD sky130_fd_sc_hd__tapvpwrvgnd_1
XTAP_TAPCELL_ROW_161_2764 VSS VDD sky130_fd_sc_hd__tapvpwrvgnd_1
XTAP_TAPCELL_ROW_161_2765 VSS VDD sky130_fd_sc_hd__tapvpwrvgnd_1
XTAP_TAPCELL_ROW_161_2766 VSS VDD sky130_fd_sc_hd__tapvpwrvgnd_1
XTAP_TAPCELL_ROW_161_2767 VSS VDD sky130_fd_sc_hd__tapvpwrvgnd_1
XTAP_TAPCELL_ROW_161_2768 VSS VDD sky130_fd_sc_hd__tapvpwrvgnd_1
XTAP_TAPCELL_ROW_161_2769 VSS VDD sky130_fd_sc_hd__tapvpwrvgnd_1
XTAP_TAPCELL_ROW_161_2770 VSS VDD sky130_fd_sc_hd__tapvpwrvgnd_1
XTAP_TAPCELL_ROW_162_2771 VSS VDD sky130_fd_sc_hd__tapvpwrvgnd_1
XTAP_TAPCELL_ROW_162_2772 VSS VDD sky130_fd_sc_hd__tapvpwrvgnd_1
XTAP_TAPCELL_ROW_162_2773 VSS VDD sky130_fd_sc_hd__tapvpwrvgnd_1
XTAP_TAPCELL_ROW_162_2774 VSS VDD sky130_fd_sc_hd__tapvpwrvgnd_1
XTAP_TAPCELL_ROW_162_2775 VSS VDD sky130_fd_sc_hd__tapvpwrvgnd_1
XTAP_TAPCELL_ROW_162_2776 VSS VDD sky130_fd_sc_hd__tapvpwrvgnd_1
XTAP_TAPCELL_ROW_162_2777 VSS VDD sky130_fd_sc_hd__tapvpwrvgnd_1
XTAP_TAPCELL_ROW_162_2778 VSS VDD sky130_fd_sc_hd__tapvpwrvgnd_1
XTAP_TAPCELL_ROW_162_2779 VSS VDD sky130_fd_sc_hd__tapvpwrvgnd_1
XTAP_TAPCELL_ROW_162_2780 VSS VDD sky130_fd_sc_hd__tapvpwrvgnd_1
XTAP_TAPCELL_ROW_162_2781 VSS VDD sky130_fd_sc_hd__tapvpwrvgnd_1
XTAP_TAPCELL_ROW_162_2782 VSS VDD sky130_fd_sc_hd__tapvpwrvgnd_1
XTAP_TAPCELL_ROW_162_2783 VSS VDD sky130_fd_sc_hd__tapvpwrvgnd_1
XTAP_TAPCELL_ROW_162_2784 VSS VDD sky130_fd_sc_hd__tapvpwrvgnd_1
XTAP_TAPCELL_ROW_162_2785 VSS VDD sky130_fd_sc_hd__tapvpwrvgnd_1
XTAP_TAPCELL_ROW_162_2786 VSS VDD sky130_fd_sc_hd__tapvpwrvgnd_1
XTAP_TAPCELL_ROW_162_2787 VSS VDD sky130_fd_sc_hd__tapvpwrvgnd_1
XTAP_TAPCELL_ROW_163_2788 VSS VDD sky130_fd_sc_hd__tapvpwrvgnd_1
XTAP_TAPCELL_ROW_163_2789 VSS VDD sky130_fd_sc_hd__tapvpwrvgnd_1
XTAP_TAPCELL_ROW_163_2790 VSS VDD sky130_fd_sc_hd__tapvpwrvgnd_1
XTAP_TAPCELL_ROW_163_2791 VSS VDD sky130_fd_sc_hd__tapvpwrvgnd_1
XTAP_TAPCELL_ROW_163_2792 VSS VDD sky130_fd_sc_hd__tapvpwrvgnd_1
XTAP_TAPCELL_ROW_163_2793 VSS VDD sky130_fd_sc_hd__tapvpwrvgnd_1
XTAP_TAPCELL_ROW_163_2794 VSS VDD sky130_fd_sc_hd__tapvpwrvgnd_1
XTAP_TAPCELL_ROW_163_2795 VSS VDD sky130_fd_sc_hd__tapvpwrvgnd_1
XTAP_TAPCELL_ROW_163_2796 VSS VDD sky130_fd_sc_hd__tapvpwrvgnd_1
XTAP_TAPCELL_ROW_163_2797 VSS VDD sky130_fd_sc_hd__tapvpwrvgnd_1
XTAP_TAPCELL_ROW_163_2798 VSS VDD sky130_fd_sc_hd__tapvpwrvgnd_1
XTAP_TAPCELL_ROW_163_2799 VSS VDD sky130_fd_sc_hd__tapvpwrvgnd_1
XTAP_TAPCELL_ROW_163_2800 VSS VDD sky130_fd_sc_hd__tapvpwrvgnd_1
XTAP_TAPCELL_ROW_163_2801 VSS VDD sky130_fd_sc_hd__tapvpwrvgnd_1
XTAP_TAPCELL_ROW_163_2802 VSS VDD sky130_fd_sc_hd__tapvpwrvgnd_1
XTAP_TAPCELL_ROW_163_2803 VSS VDD sky130_fd_sc_hd__tapvpwrvgnd_1
XTAP_TAPCELL_ROW_163_2804 VSS VDD sky130_fd_sc_hd__tapvpwrvgnd_1
XTAP_TAPCELL_ROW_164_2805 VSS VDD sky130_fd_sc_hd__tapvpwrvgnd_1
XTAP_TAPCELL_ROW_164_2806 VSS VDD sky130_fd_sc_hd__tapvpwrvgnd_1
XTAP_TAPCELL_ROW_164_2807 VSS VDD sky130_fd_sc_hd__tapvpwrvgnd_1
XTAP_TAPCELL_ROW_164_2808 VSS VDD sky130_fd_sc_hd__tapvpwrvgnd_1
XTAP_TAPCELL_ROW_164_2809 VSS VDD sky130_fd_sc_hd__tapvpwrvgnd_1
XTAP_TAPCELL_ROW_164_2810 VSS VDD sky130_fd_sc_hd__tapvpwrvgnd_1
XTAP_TAPCELL_ROW_164_2811 VSS VDD sky130_fd_sc_hd__tapvpwrvgnd_1
XTAP_TAPCELL_ROW_164_2812 VSS VDD sky130_fd_sc_hd__tapvpwrvgnd_1
XTAP_TAPCELL_ROW_164_2813 VSS VDD sky130_fd_sc_hd__tapvpwrvgnd_1
XTAP_TAPCELL_ROW_164_2814 VSS VDD sky130_fd_sc_hd__tapvpwrvgnd_1
XTAP_TAPCELL_ROW_164_2815 VSS VDD sky130_fd_sc_hd__tapvpwrvgnd_1
XTAP_TAPCELL_ROW_164_2816 VSS VDD sky130_fd_sc_hd__tapvpwrvgnd_1
XTAP_TAPCELL_ROW_164_2817 VSS VDD sky130_fd_sc_hd__tapvpwrvgnd_1
XTAP_TAPCELL_ROW_164_2818 VSS VDD sky130_fd_sc_hd__tapvpwrvgnd_1
XTAP_TAPCELL_ROW_164_2819 VSS VDD sky130_fd_sc_hd__tapvpwrvgnd_1
XTAP_TAPCELL_ROW_164_2820 VSS VDD sky130_fd_sc_hd__tapvpwrvgnd_1
XTAP_TAPCELL_ROW_164_2821 VSS VDD sky130_fd_sc_hd__tapvpwrvgnd_1
XTAP_TAPCELL_ROW_165_2822 VSS VDD sky130_fd_sc_hd__tapvpwrvgnd_1
XTAP_TAPCELL_ROW_165_2823 VSS VDD sky130_fd_sc_hd__tapvpwrvgnd_1
XTAP_TAPCELL_ROW_165_2824 VSS VDD sky130_fd_sc_hd__tapvpwrvgnd_1
XTAP_TAPCELL_ROW_165_2825 VSS VDD sky130_fd_sc_hd__tapvpwrvgnd_1
XTAP_TAPCELL_ROW_165_2826 VSS VDD sky130_fd_sc_hd__tapvpwrvgnd_1
XTAP_TAPCELL_ROW_165_2827 VSS VDD sky130_fd_sc_hd__tapvpwrvgnd_1
XTAP_TAPCELL_ROW_165_2828 VSS VDD sky130_fd_sc_hd__tapvpwrvgnd_1
XTAP_TAPCELL_ROW_165_2829 VSS VDD sky130_fd_sc_hd__tapvpwrvgnd_1
XTAP_TAPCELL_ROW_165_2830 VSS VDD sky130_fd_sc_hd__tapvpwrvgnd_1
XTAP_TAPCELL_ROW_165_2831 VSS VDD sky130_fd_sc_hd__tapvpwrvgnd_1
XTAP_TAPCELL_ROW_165_2832 VSS VDD sky130_fd_sc_hd__tapvpwrvgnd_1
XTAP_TAPCELL_ROW_165_2833 VSS VDD sky130_fd_sc_hd__tapvpwrvgnd_1
XTAP_TAPCELL_ROW_165_2834 VSS VDD sky130_fd_sc_hd__tapvpwrvgnd_1
XTAP_TAPCELL_ROW_165_2835 VSS VDD sky130_fd_sc_hd__tapvpwrvgnd_1
XTAP_TAPCELL_ROW_165_2836 VSS VDD sky130_fd_sc_hd__tapvpwrvgnd_1
XTAP_TAPCELL_ROW_165_2837 VSS VDD sky130_fd_sc_hd__tapvpwrvgnd_1
XTAP_TAPCELL_ROW_165_2838 VSS VDD sky130_fd_sc_hd__tapvpwrvgnd_1
XTAP_TAPCELL_ROW_166_2839 VSS VDD sky130_fd_sc_hd__tapvpwrvgnd_1
XTAP_TAPCELL_ROW_166_2840 VSS VDD sky130_fd_sc_hd__tapvpwrvgnd_1
XTAP_TAPCELL_ROW_166_2841 VSS VDD sky130_fd_sc_hd__tapvpwrvgnd_1
XTAP_TAPCELL_ROW_166_2842 VSS VDD sky130_fd_sc_hd__tapvpwrvgnd_1
XTAP_TAPCELL_ROW_166_2843 VSS VDD sky130_fd_sc_hd__tapvpwrvgnd_1
XTAP_TAPCELL_ROW_166_2844 VSS VDD sky130_fd_sc_hd__tapvpwrvgnd_1
XTAP_TAPCELL_ROW_166_2845 VSS VDD sky130_fd_sc_hd__tapvpwrvgnd_1
XTAP_TAPCELL_ROW_166_2846 VSS VDD sky130_fd_sc_hd__tapvpwrvgnd_1
XTAP_TAPCELL_ROW_166_2847 VSS VDD sky130_fd_sc_hd__tapvpwrvgnd_1
XTAP_TAPCELL_ROW_166_2848 VSS VDD sky130_fd_sc_hd__tapvpwrvgnd_1
XTAP_TAPCELL_ROW_166_2849 VSS VDD sky130_fd_sc_hd__tapvpwrvgnd_1
XTAP_TAPCELL_ROW_166_2850 VSS VDD sky130_fd_sc_hd__tapvpwrvgnd_1
XTAP_TAPCELL_ROW_166_2851 VSS VDD sky130_fd_sc_hd__tapvpwrvgnd_1
XTAP_TAPCELL_ROW_166_2852 VSS VDD sky130_fd_sc_hd__tapvpwrvgnd_1
XTAP_TAPCELL_ROW_166_2853 VSS VDD sky130_fd_sc_hd__tapvpwrvgnd_1
XTAP_TAPCELL_ROW_166_2854 VSS VDD sky130_fd_sc_hd__tapvpwrvgnd_1
XTAP_TAPCELL_ROW_166_2855 VSS VDD sky130_fd_sc_hd__tapvpwrvgnd_1
XTAP_TAPCELL_ROW_167_2856 VSS VDD sky130_fd_sc_hd__tapvpwrvgnd_1
XTAP_TAPCELL_ROW_167_2857 VSS VDD sky130_fd_sc_hd__tapvpwrvgnd_1
XTAP_TAPCELL_ROW_167_2858 VSS VDD sky130_fd_sc_hd__tapvpwrvgnd_1
XTAP_TAPCELL_ROW_167_2859 VSS VDD sky130_fd_sc_hd__tapvpwrvgnd_1
XTAP_TAPCELL_ROW_167_2860 VSS VDD sky130_fd_sc_hd__tapvpwrvgnd_1
XTAP_TAPCELL_ROW_167_2861 VSS VDD sky130_fd_sc_hd__tapvpwrvgnd_1
XTAP_TAPCELL_ROW_167_2862 VSS VDD sky130_fd_sc_hd__tapvpwrvgnd_1
XTAP_TAPCELL_ROW_167_2863 VSS VDD sky130_fd_sc_hd__tapvpwrvgnd_1
XTAP_TAPCELL_ROW_167_2864 VSS VDD sky130_fd_sc_hd__tapvpwrvgnd_1
XTAP_TAPCELL_ROW_167_2865 VSS VDD sky130_fd_sc_hd__tapvpwrvgnd_1
XTAP_TAPCELL_ROW_167_2866 VSS VDD sky130_fd_sc_hd__tapvpwrvgnd_1
XTAP_TAPCELL_ROW_167_2867 VSS VDD sky130_fd_sc_hd__tapvpwrvgnd_1
XTAP_TAPCELL_ROW_167_2868 VSS VDD sky130_fd_sc_hd__tapvpwrvgnd_1
XTAP_TAPCELL_ROW_167_2869 VSS VDD sky130_fd_sc_hd__tapvpwrvgnd_1
XTAP_TAPCELL_ROW_167_2870 VSS VDD sky130_fd_sc_hd__tapvpwrvgnd_1
XTAP_TAPCELL_ROW_167_2871 VSS VDD sky130_fd_sc_hd__tapvpwrvgnd_1
XTAP_TAPCELL_ROW_167_2872 VSS VDD sky130_fd_sc_hd__tapvpwrvgnd_1
XTAP_TAPCELL_ROW_168_2873 VSS VDD sky130_fd_sc_hd__tapvpwrvgnd_1
XTAP_TAPCELL_ROW_168_2874 VSS VDD sky130_fd_sc_hd__tapvpwrvgnd_1
XTAP_TAPCELL_ROW_168_2875 VSS VDD sky130_fd_sc_hd__tapvpwrvgnd_1
XTAP_TAPCELL_ROW_168_2876 VSS VDD sky130_fd_sc_hd__tapvpwrvgnd_1
XTAP_TAPCELL_ROW_168_2877 VSS VDD sky130_fd_sc_hd__tapvpwrvgnd_1
XTAP_TAPCELL_ROW_168_2878 VSS VDD sky130_fd_sc_hd__tapvpwrvgnd_1
XTAP_TAPCELL_ROW_168_2879 VSS VDD sky130_fd_sc_hd__tapvpwrvgnd_1
XTAP_TAPCELL_ROW_168_2880 VSS VDD sky130_fd_sc_hd__tapvpwrvgnd_1
XTAP_TAPCELL_ROW_168_2881 VSS VDD sky130_fd_sc_hd__tapvpwrvgnd_1
XTAP_TAPCELL_ROW_168_2882 VSS VDD sky130_fd_sc_hd__tapvpwrvgnd_1
XTAP_TAPCELL_ROW_168_2883 VSS VDD sky130_fd_sc_hd__tapvpwrvgnd_1
XTAP_TAPCELL_ROW_168_2884 VSS VDD sky130_fd_sc_hd__tapvpwrvgnd_1
XTAP_TAPCELL_ROW_168_2885 VSS VDD sky130_fd_sc_hd__tapvpwrvgnd_1
XTAP_TAPCELL_ROW_168_2886 VSS VDD sky130_fd_sc_hd__tapvpwrvgnd_1
XTAP_TAPCELL_ROW_168_2887 VSS VDD sky130_fd_sc_hd__tapvpwrvgnd_1
XTAP_TAPCELL_ROW_168_2888 VSS VDD sky130_fd_sc_hd__tapvpwrvgnd_1
XTAP_TAPCELL_ROW_168_2889 VSS VDD sky130_fd_sc_hd__tapvpwrvgnd_1
XTAP_TAPCELL_ROW_169_2890 VSS VDD sky130_fd_sc_hd__tapvpwrvgnd_1
XTAP_TAPCELL_ROW_169_2891 VSS VDD sky130_fd_sc_hd__tapvpwrvgnd_1
XTAP_TAPCELL_ROW_169_2892 VSS VDD sky130_fd_sc_hd__tapvpwrvgnd_1
XTAP_TAPCELL_ROW_169_2893 VSS VDD sky130_fd_sc_hd__tapvpwrvgnd_1
XTAP_TAPCELL_ROW_169_2894 VSS VDD sky130_fd_sc_hd__tapvpwrvgnd_1
XTAP_TAPCELL_ROW_169_2895 VSS VDD sky130_fd_sc_hd__tapvpwrvgnd_1
XTAP_TAPCELL_ROW_169_2896 VSS VDD sky130_fd_sc_hd__tapvpwrvgnd_1
XTAP_TAPCELL_ROW_169_2897 VSS VDD sky130_fd_sc_hd__tapvpwrvgnd_1
XTAP_TAPCELL_ROW_169_2898 VSS VDD sky130_fd_sc_hd__tapvpwrvgnd_1
XTAP_TAPCELL_ROW_169_2899 VSS VDD sky130_fd_sc_hd__tapvpwrvgnd_1
XTAP_TAPCELL_ROW_169_2900 VSS VDD sky130_fd_sc_hd__tapvpwrvgnd_1
XTAP_TAPCELL_ROW_169_2901 VSS VDD sky130_fd_sc_hd__tapvpwrvgnd_1
XTAP_TAPCELL_ROW_169_2902 VSS VDD sky130_fd_sc_hd__tapvpwrvgnd_1
XTAP_TAPCELL_ROW_169_2903 VSS VDD sky130_fd_sc_hd__tapvpwrvgnd_1
XTAP_TAPCELL_ROW_169_2904 VSS VDD sky130_fd_sc_hd__tapvpwrvgnd_1
XTAP_TAPCELL_ROW_169_2905 VSS VDD sky130_fd_sc_hd__tapvpwrvgnd_1
XTAP_TAPCELL_ROW_169_2906 VSS VDD sky130_fd_sc_hd__tapvpwrvgnd_1
XTAP_TAPCELL_ROW_170_2907 VSS VDD sky130_fd_sc_hd__tapvpwrvgnd_1
XTAP_TAPCELL_ROW_170_2908 VSS VDD sky130_fd_sc_hd__tapvpwrvgnd_1
XTAP_TAPCELL_ROW_170_2909 VSS VDD sky130_fd_sc_hd__tapvpwrvgnd_1
XTAP_TAPCELL_ROW_170_2910 VSS VDD sky130_fd_sc_hd__tapvpwrvgnd_1
XTAP_TAPCELL_ROW_170_2911 VSS VDD sky130_fd_sc_hd__tapvpwrvgnd_1
XTAP_TAPCELL_ROW_170_2912 VSS VDD sky130_fd_sc_hd__tapvpwrvgnd_1
XTAP_TAPCELL_ROW_170_2913 VSS VDD sky130_fd_sc_hd__tapvpwrvgnd_1
XTAP_TAPCELL_ROW_170_2914 VSS VDD sky130_fd_sc_hd__tapvpwrvgnd_1
XTAP_TAPCELL_ROW_170_2915 VSS VDD sky130_fd_sc_hd__tapvpwrvgnd_1
XTAP_TAPCELL_ROW_170_2916 VSS VDD sky130_fd_sc_hd__tapvpwrvgnd_1
XTAP_TAPCELL_ROW_170_2917 VSS VDD sky130_fd_sc_hd__tapvpwrvgnd_1
XTAP_TAPCELL_ROW_170_2918 VSS VDD sky130_fd_sc_hd__tapvpwrvgnd_1
XTAP_TAPCELL_ROW_170_2919 VSS VDD sky130_fd_sc_hd__tapvpwrvgnd_1
XTAP_TAPCELL_ROW_170_2920 VSS VDD sky130_fd_sc_hd__tapvpwrvgnd_1
XTAP_TAPCELL_ROW_170_2921 VSS VDD sky130_fd_sc_hd__tapvpwrvgnd_1
XTAP_TAPCELL_ROW_170_2922 VSS VDD sky130_fd_sc_hd__tapvpwrvgnd_1
XTAP_TAPCELL_ROW_170_2923 VSS VDD sky130_fd_sc_hd__tapvpwrvgnd_1
XTAP_TAPCELL_ROW_171_2924 VSS VDD sky130_fd_sc_hd__tapvpwrvgnd_1
XTAP_TAPCELL_ROW_171_2925 VSS VDD sky130_fd_sc_hd__tapvpwrvgnd_1
XTAP_TAPCELL_ROW_171_2926 VSS VDD sky130_fd_sc_hd__tapvpwrvgnd_1
XTAP_TAPCELL_ROW_171_2927 VSS VDD sky130_fd_sc_hd__tapvpwrvgnd_1
XTAP_TAPCELL_ROW_171_2928 VSS VDD sky130_fd_sc_hd__tapvpwrvgnd_1
XTAP_TAPCELL_ROW_171_2929 VSS VDD sky130_fd_sc_hd__tapvpwrvgnd_1
XTAP_TAPCELL_ROW_171_2930 VSS VDD sky130_fd_sc_hd__tapvpwrvgnd_1
XTAP_TAPCELL_ROW_171_2931 VSS VDD sky130_fd_sc_hd__tapvpwrvgnd_1
XTAP_TAPCELL_ROW_171_2932 VSS VDD sky130_fd_sc_hd__tapvpwrvgnd_1
XTAP_TAPCELL_ROW_171_2933 VSS VDD sky130_fd_sc_hd__tapvpwrvgnd_1
XTAP_TAPCELL_ROW_171_2934 VSS VDD sky130_fd_sc_hd__tapvpwrvgnd_1
XTAP_TAPCELL_ROW_171_2935 VSS VDD sky130_fd_sc_hd__tapvpwrvgnd_1
XTAP_TAPCELL_ROW_171_2936 VSS VDD sky130_fd_sc_hd__tapvpwrvgnd_1
XTAP_TAPCELL_ROW_171_2937 VSS VDD sky130_fd_sc_hd__tapvpwrvgnd_1
XTAP_TAPCELL_ROW_171_2938 VSS VDD sky130_fd_sc_hd__tapvpwrvgnd_1
XTAP_TAPCELL_ROW_171_2939 VSS VDD sky130_fd_sc_hd__tapvpwrvgnd_1
XTAP_TAPCELL_ROW_171_2940 VSS VDD sky130_fd_sc_hd__tapvpwrvgnd_1
XTAP_TAPCELL_ROW_172_2941 VSS VDD sky130_fd_sc_hd__tapvpwrvgnd_1
XTAP_TAPCELL_ROW_172_2942 VSS VDD sky130_fd_sc_hd__tapvpwrvgnd_1
XTAP_TAPCELL_ROW_172_2943 VSS VDD sky130_fd_sc_hd__tapvpwrvgnd_1
XTAP_TAPCELL_ROW_172_2944 VSS VDD sky130_fd_sc_hd__tapvpwrvgnd_1
XTAP_TAPCELL_ROW_172_2945 VSS VDD sky130_fd_sc_hd__tapvpwrvgnd_1
XTAP_TAPCELL_ROW_172_2946 VSS VDD sky130_fd_sc_hd__tapvpwrvgnd_1
XTAP_TAPCELL_ROW_172_2947 VSS VDD sky130_fd_sc_hd__tapvpwrvgnd_1
XTAP_TAPCELL_ROW_172_2948 VSS VDD sky130_fd_sc_hd__tapvpwrvgnd_1
XTAP_TAPCELL_ROW_172_2949 VSS VDD sky130_fd_sc_hd__tapvpwrvgnd_1
XTAP_TAPCELL_ROW_172_2950 VSS VDD sky130_fd_sc_hd__tapvpwrvgnd_1
XTAP_TAPCELL_ROW_172_2951 VSS VDD sky130_fd_sc_hd__tapvpwrvgnd_1
XTAP_TAPCELL_ROW_172_2952 VSS VDD sky130_fd_sc_hd__tapvpwrvgnd_1
XTAP_TAPCELL_ROW_172_2953 VSS VDD sky130_fd_sc_hd__tapvpwrvgnd_1
XTAP_TAPCELL_ROW_172_2954 VSS VDD sky130_fd_sc_hd__tapvpwrvgnd_1
XTAP_TAPCELL_ROW_172_2955 VSS VDD sky130_fd_sc_hd__tapvpwrvgnd_1
XTAP_TAPCELL_ROW_172_2956 VSS VDD sky130_fd_sc_hd__tapvpwrvgnd_1
XTAP_TAPCELL_ROW_172_2957 VSS VDD sky130_fd_sc_hd__tapvpwrvgnd_1
XTAP_TAPCELL_ROW_172_2958 VSS VDD sky130_fd_sc_hd__tapvpwrvgnd_1
XTAP_TAPCELL_ROW_172_2959 VSS VDD sky130_fd_sc_hd__tapvpwrvgnd_1
XTAP_TAPCELL_ROW_172_2960 VSS VDD sky130_fd_sc_hd__tapvpwrvgnd_1
XTAP_TAPCELL_ROW_172_2961 VSS VDD sky130_fd_sc_hd__tapvpwrvgnd_1
XTAP_TAPCELL_ROW_172_2962 VSS VDD sky130_fd_sc_hd__tapvpwrvgnd_1
XTAP_TAPCELL_ROW_172_2963 VSS VDD sky130_fd_sc_hd__tapvpwrvgnd_1
XTAP_TAPCELL_ROW_172_2964 VSS VDD sky130_fd_sc_hd__tapvpwrvgnd_1
XTAP_TAPCELL_ROW_172_2965 VSS VDD sky130_fd_sc_hd__tapvpwrvgnd_1
XTAP_TAPCELL_ROW_172_2966 VSS VDD sky130_fd_sc_hd__tapvpwrvgnd_1
XTAP_TAPCELL_ROW_172_2967 VSS VDD sky130_fd_sc_hd__tapvpwrvgnd_1
XTAP_TAPCELL_ROW_172_2968 VSS VDD sky130_fd_sc_hd__tapvpwrvgnd_1
XTAP_TAPCELL_ROW_172_2969 VSS VDD sky130_fd_sc_hd__tapvpwrvgnd_1
XTAP_TAPCELL_ROW_172_2970 VSS VDD sky130_fd_sc_hd__tapvpwrvgnd_1
XTAP_TAPCELL_ROW_172_2971 VSS VDD sky130_fd_sc_hd__tapvpwrvgnd_1
XTAP_TAPCELL_ROW_172_2972 VSS VDD sky130_fd_sc_hd__tapvpwrvgnd_1
XTAP_TAPCELL_ROW_172_2973 VSS VDD sky130_fd_sc_hd__tapvpwrvgnd_1
XTAP_TAPCELL_ROW_172_2974 VSS VDD sky130_fd_sc_hd__tapvpwrvgnd_1
Xclkload67 clknet_leaf_138_clk_net VSS VSS VDD VDD _unconnected_85
+ sky130_fd_sc_hd__clkbuf_16
Xclkload68 clknet_leaf_139_clk_net VSS VSS VDD VDD _unconnected_86
+ sky130_fd_sc_hd__clkbuf_8
Xclkload69 clknet_leaf_119_clk_net VSS VSS VDD VDD _unconnected_87
+ sky130_fd_sc_hd__clkbuf_1
Xclkload70 clknet_leaf_120_clk_net VSS VSS VDD VDD _unconnected_88
+ sky130_fd_sc_hd__clkbuf_1
Xclkload71 clknet_leaf_121_clk_net VSS VSS VDD VDD _unconnected_89
+ sky130_fd_sc_hd__clkbuf_8
Xclkload72 clknet_leaf_122_clk_net VSS VSS VDD VDD _unconnected_90
+ sky130_fd_sc_hd__clkbuf_1
Xclkload73 clknet_leaf_123_clk_net VSS VSS VDD VDD _unconnected_91
+ sky130_fd_sc_hd__clkbuf_16
Xclkload74 clknet_leaf_124_clk_net VSS VSS VDD VDD _unconnected_92
+ sky130_fd_sc_hd__clkbuf_1
Xclkload75 clknet_leaf_125_clk_net VSS VSS VDD VDD _unconnected_93
+ sky130_fd_sc_hd__clkbuf_1
Xclkload76 clknet_leaf_126_clk_net VSS VSS VDD VDD _unconnected_94
+ sky130_fd_sc_hd__clkbuf_1
Xclkload77 clknet_leaf_128_clk_net VSS VSS VDD VDD _unconnected_95
+ sky130_fd_sc_hd__clkbuf_1
Xclkload78 clknet_leaf_130_clk_net VSS VSS VDD VDD _unconnected_96
+ sky130_fd_sc_hd__clkbuf_1
Xclkload79 clknet_leaf_104_clk_net VSS VSS VDD VDD _unconnected_97
+ sky130_fd_sc_hd__bufinv_16
Xclkload80 clknet_leaf_105_clk_net VSS VSS VDD VDD _unconnected_98
+ sky130_fd_sc_hd__clkinv_2
Xclkload81 clknet_leaf_106_clk_net VSS VSS VDD VDD _unconnected_99
+ sky130_fd_sc_hd__bufinv_16
Xclkload82 clknet_leaf_140_clk_net VSS VSS VDD VDD _unconnected_100
+ sky130_fd_sc_hd__clkbuf_1
Xclkload83 clknet_leaf_141_clk_net VSS VSS VDD VDD _unconnected_101
+ sky130_fd_sc_hd__clkinv_2
Xclkload84 clknet_leaf_142_clk_net VSS VSS VDD VDD _unconnected_102
+ sky130_fd_sc_hd__clkbuf_16
Xclkload85 clknet_leaf_143_clk_net VSS VSS VDD VDD _unconnected_103
+ sky130_fd_sc_hd__clkbuf_8
Xclkload86 clknet_leaf_144_clk_net VSS VSS VDD VDD _unconnected_104
+ sky130_fd_sc_hd__clkbuf_1
Xclkload87 clknet_leaf_145_clk_net VSS VSS VDD VDD _unconnected_105
+ sky130_fd_sc_hd__clkbuf_8
Xclkload88 clknet_leaf_107_clk_net VSS VSS VDD VDD _unconnected_106
+ sky130_fd_sc_hd__clkbuf_8
Xclkload89 clknet_leaf_108_clk_net VSS VSS VDD VDD _unconnected_107
+ sky130_fd_sc_hd__clkinv_2
Xclkload90 clknet_leaf_109_clk_net VSS VSS VDD VDD _unconnected_108
+ sky130_fd_sc_hd__clkinvlp_4
Xclkload91 clknet_leaf_110_clk_net VSS VSS VDD VDD _unconnected_109
+ sky130_fd_sc_hd__clkbuf_8
Xclkload92 clknet_leaf_111_clk_net VSS VSS VDD VDD _unconnected_110
+ sky130_fd_sc_hd__clkinvlp_4
Xclkload93 clknet_leaf_112_clk_net VSS VSS VDD VDD _unconnected_111
+ sky130_fd_sc_hd__clkbuf_8
Xclkload94 clknet_leaf_113_clk_net VSS VSS VDD VDD _unconnected_112
+ sky130_fd_sc_hd__clkbuf_8
Xclkload95 clknet_leaf_114_clk_net VSS VSS VDD VDD _unconnected_113
+ sky130_fd_sc_hd__clkinv_1
Xclkload96 clknet_leaf_115_clk_net VSS VSS VDD VDD _unconnected_114
+ sky130_fd_sc_hd__clkbuf_1
Xclkload97 clknet_leaf_116_clk_net VSS VSS VDD VDD _unconnected_115
+ sky130_fd_sc_hd__clkinvlp_4
Xclkload98 clknet_leaf_118_clk_net VSS VSS VDD VDD _unconnected_116
+ sky130_fd_sc_hd__clkinv_2
Xclkload99 clknet_leaf_28_clk_net VSS VSS VDD VDD _unconnected_117
+ sky130_fd_sc_hd__clkbuf_8
Xclkload100 clknet_leaf_29_clk_net VSS VSS VDD VDD _unconnected_118
+ sky130_fd_sc_hd__clkinv_2
Xclkload101 clknet_leaf_30_clk_net VSS VSS VDD VDD _unconnected_119
+ sky130_fd_sc_hd__clkbuf_8
Xclkload102 clknet_leaf_31_clk_net VSS VSS VDD VDD _unconnected_120
+ sky130_fd_sc_hd__clkbuf_16
Xclkload103 clknet_leaf_33_clk_net VSS VSS VDD VDD _unconnected_121
+ sky130_fd_sc_hd__clkbuf_8
Xclkload104 clknet_leaf_34_clk_net VSS VSS VDD VDD _unconnected_122
+ sky130_fd_sc_hd__clkbuf_16
Xclkload105 clknet_leaf_35_clk_net VSS VSS VDD VDD _unconnected_123
+ sky130_fd_sc_hd__inv_4
Xclkload106 clknet_leaf_36_clk_net VSS VSS VDD VDD _unconnected_124
+ sky130_fd_sc_hd__clkinv_2
Xclkload107 clknet_leaf_37_clk_net VSS VSS VDD VDD _unconnected_125
+ sky130_fd_sc_hd__clkinv_2
Xclkload108 clknet_leaf_38_clk_net VSS VSS VDD VDD _unconnected_126
+ sky130_fd_sc_hd__clkbuf_8
Xclkload109 clknet_leaf_23_clk_net VSS VSS VDD VDD _unconnected_127
+ sky130_fd_sc_hd__clkbuf_8
Xclkload110 clknet_leaf_24_clk_net VSS VSS VDD VDD _unconnected_128
+ sky130_fd_sc_hd__clkinvlp_4
Xclkload111 clknet_leaf_26_clk_net VSS VSS VDD VDD _unconnected_129
+ sky130_fd_sc_hd__bufinv_16
Xclkload112 clknet_leaf_27_clk_net VSS VSS VDD VDD _unconnected_130
+ sky130_fd_sc_hd__clkinv_1
Xclkload113 clknet_leaf_60_clk_net VSS VSS VDD VDD _unconnected_131
+ sky130_fd_sc_hd__clkinv_2
Xclkload114 clknet_leaf_61_clk_net VSS VSS VDD VDD _unconnected_132
+ sky130_fd_sc_hd__clkinv_2
Xclkload115 clknet_leaf_62_clk_net VSS VSS VDD VDD _unconnected_133
+ sky130_fd_sc_hd__clkinv_2
Xclkload116 clknet_leaf_63_clk_net VSS VSS VDD VDD _unconnected_134
+ sky130_fd_sc_hd__bufinv_16
Xclkload117 clknet_leaf_64_clk_net VSS VSS VDD VDD _unconnected_135
+ sky130_fd_sc_hd__clkinv_2
Xclkload118 clknet_leaf_39_clk_net VSS VSS VDD VDD _unconnected_136
+ sky130_fd_sc_hd__clkinv_1
Xclkload119 clknet_leaf_40_clk_net VSS VSS VDD VDD _unconnected_137
+ sky130_fd_sc_hd__clkbuf_1
Xclkload120 clknet_leaf_41_clk_net VSS VSS VDD VDD _unconnected_138
+ sky130_fd_sc_hd__clkinv_2
Xclkload121 clknet_leaf_42_clk_net VSS VSS VDD VDD _unconnected_139
+ sky130_fd_sc_hd__clkbuf_1
Xclkload122 clknet_leaf_43_clk_net VSS VSS VDD VDD _unconnected_140
+ sky130_fd_sc_hd__clkbuf_1
Xclkload123 clknet_leaf_44_clk_net VSS VSS VDD VDD _unconnected_141
+ sky130_fd_sc_hd__clkinv_2
Xclkload124 clknet_leaf_46_clk_net VSS VSS VDD VDD _unconnected_142
+ sky130_fd_sc_hd__clkbuf_1
Xclkload125 clknet_leaf_47_clk_net VSS VSS VDD VDD _unconnected_143
+ sky130_fd_sc_hd__clkbuf_1
Xclkload126 clknet_leaf_49_clk_net VSS VSS VDD VDD _unconnected_144
+ sky130_fd_sc_hd__clkbuf_1
Xclkload127 clknet_leaf_50_clk_net VSS VSS VDD VDD _unconnected_145
+ sky130_fd_sc_hd__clkbuf_1
Xclkload128 clknet_leaf_51_clk_net VSS VSS VDD VDD _unconnected_146
+ sky130_fd_sc_hd__clkbuf_8
Xclkload129 clknet_leaf_53_clk_net VSS VSS VDD VDD _unconnected_147
+ sky130_fd_sc_hd__clkbuf_8
Xclkload130 clknet_leaf_54_clk_net VSS VSS VDD VDD _unconnected_148
+ sky130_fd_sc_hd__clkbuf_1
Xclkload131 clknet_leaf_55_clk_net VSS VSS VDD VDD _unconnected_149
+ sky130_fd_sc_hd__clkbuf_16
Xclkload132 clknet_leaf_56_clk_net VSS VSS VDD VDD _unconnected_150
+ sky130_fd_sc_hd__clkbuf_16
Xclkload133 clknet_leaf_57_clk_net VSS VSS VDD VDD _unconnected_151
+ sky130_fd_sc_hd__clkbuf_1
Xclkload134 clknet_leaf_58_clk_net VSS VSS VDD VDD _unconnected_152
+ sky130_fd_sc_hd__clkbuf_1
Xclkload135 clknet_leaf_59_clk_net VSS VSS VDD VDD _unconnected_153
+ sky130_fd_sc_hd__clkbuf_1
Xclkload136 clknet_leaf_65_clk_net VSS VSS VDD VDD _unconnected_154
+ sky130_fd_sc_hd__clkbuf_1
Xclkload137 clknet_leaf_66_clk_net VSS VSS VDD VDD _unconnected_155
+ sky130_fd_sc_hd__clkbuf_1
Xclkload138 clknet_leaf_67_clk_net VSS VSS VDD VDD _unconnected_156
+ sky130_fd_sc_hd__bufinv_16
Xclkload139 clknet_leaf_96_clk_net VSS VSS VDD VDD _unconnected_157
+ sky130_fd_sc_hd__clkbuf_1
Xclkload140 clknet_leaf_97_clk_net VSS VSS VDD VDD _unconnected_158
+ sky130_fd_sc_hd__clkbuf_1
Xclkload141 clknet_leaf_98_clk_net VSS VSS VDD VDD _unconnected_159
+ sky130_fd_sc_hd__clkbuf_1
Xclkload142 clknet_leaf_99_clk_net VSS VSS VDD VDD _unconnected_160
+ sky130_fd_sc_hd__clkbuf_1
Xclkload143 clknet_leaf_101_clk_net VSS VSS VDD VDD _unconnected_161
+ sky130_fd_sc_hd__clkbuf_1
Xclkload144 clknet_leaf_102_clk_net VSS VSS VDD VDD _unconnected_162
+ sky130_fd_sc_hd__clkbuf_1
Xclkload145 clknet_leaf_84_clk_net VSS VSS VDD VDD _unconnected_163
+ sky130_fd_sc_hd__clkbuf_1
Xclkload146 clknet_leaf_87_clk_net VSS VSS VDD VDD _unconnected_164
+ sky130_fd_sc_hd__clkbuf_1
Xclkload147 clknet_leaf_88_clk_net VSS VSS VDD VDD _unconnected_165
+ sky130_fd_sc_hd__clkinv_2
Xclkload148 clknet_leaf_89_clk_net VSS VSS VDD VDD _unconnected_166
+ sky130_fd_sc_hd__clkinv_4
Xclkload149 clknet_leaf_90_clk_net VSS VSS VDD VDD _unconnected_167
+ sky130_fd_sc_hd__clkbuf_16
Xclkload150 clknet_leaf_91_clk_net VSS VSS VDD VDD _unconnected_168
+ sky130_fd_sc_hd__clkinv_2
Xclkload151 clknet_leaf_92_clk_net VSS VSS VDD VDD _unconnected_169
+ sky130_fd_sc_hd__clkbuf_8
Xclkload152 clknet_leaf_93_clk_net VSS VSS VDD VDD _unconnected_170
+ sky130_fd_sc_hd__clkbuf_8
Xclkload153 clknet_leaf_94_clk_net VSS VSS VDD VDD _unconnected_171
+ sky130_fd_sc_hd__clkbuf_1
Xclkload154 clknet_leaf_68_clk_net VSS VSS VDD VDD _unconnected_172
+ sky130_fd_sc_hd__clkinvlp_4
Xclkload155 clknet_leaf_69_clk_net VSS VSS VDD VDD _unconnected_173
+ sky130_fd_sc_hd__inv_6
Xclkload156 clknet_leaf_70_clk_net VSS VSS VDD VDD _unconnected_174
+ sky130_fd_sc_hd__clkinv_4
Xclkload157 clknet_leaf_71_clk_net VSS VSS VDD VDD _unconnected_175
+ sky130_fd_sc_hd__clkinv_2
Xclkload158 clknet_leaf_72_clk_net VSS VSS VDD VDD _unconnected_176
+ sky130_fd_sc_hd__clkinv_2
Xclkload159 clknet_leaf_74_clk_net VSS VSS VDD VDD _unconnected_177
+ sky130_fd_sc_hd__bufinv_16
Xclkload160 clknet_leaf_76_clk_net VSS VSS VDD VDD _unconnected_178
+ sky130_fd_sc_hd__clkinv_4
Xclkload161 clknet_leaf_73_clk_net VSS VSS VDD VDD _unconnected_179
+ sky130_fd_sc_hd__clkinv_2
Xclkload162 clknet_leaf_77_clk_net VSS VSS VDD VDD _unconnected_180
+ sky130_fd_sc_hd__clkbuf_8
Xclkload163 clknet_leaf_78_clk_net VSS VSS VDD VDD _unconnected_181
+ sky130_fd_sc_hd__clkbuf_1
Xclkload164 clknet_leaf_79_clk_net VSS VSS VDD VDD _unconnected_182
+ sky130_fd_sc_hd__clkbuf_8
Xclkload165 clknet_leaf_80_clk_net VSS VSS VDD VDD _unconnected_183
+ sky130_fd_sc_hd__clkbuf_1
Xclkload166 clknet_leaf_81_clk_net VSS VSS VDD VDD _unconnected_184
+ sky130_fd_sc_hd__bufinv_16
Xclkload167 clknet_leaf_82_clk_net VSS VSS VDD VDD _unconnected_185
+ sky130_fd_sc_hd__clkinv_2
Xclkload168 clknet_leaf_83_clk_net VSS VSS VDD VDD _unconnected_186
+ sky130_fd_sc_hd__clkbuf_8
Xclkload169 clknet_leaf_86_clk_net VSS VSS VDD VDD _unconnected_187
+ sky130_fd_sc_hd__clkbuf_8
Xclkbuf_leaf_0_clk_load clknet_3_0__leaf_clk_load VSS VSS
+ VDD VDD clknet_leaf_0_clk_load sky130_fd_sc_hd__clkbuf_16
Xclkbuf_leaf_1_clk_load clknet_3_0__leaf_clk_load VSS VSS
+ VDD VDD clknet_leaf_1_clk_load sky130_fd_sc_hd__clkbuf_16
Xclkbuf_leaf_2_clk_load clknet_3_0__leaf_clk_load VSS VSS
+ VDD VDD clknet_leaf_2_clk_load sky130_fd_sc_hd__clkbuf_16
Xclkbuf_leaf_3_clk_load clknet_3_0__leaf_clk_load VSS VSS
+ VDD VDD clknet_leaf_3_clk_load sky130_fd_sc_hd__clkbuf_16
Xclkbuf_leaf_4_clk_load clknet_3_0__leaf_clk_load VSS VSS
+ VDD VDD clknet_leaf_4_clk_load sky130_fd_sc_hd__clkbuf_16
Xclkbuf_leaf_5_clk_load clknet_3_0__leaf_clk_load VSS VSS
+ VDD VDD clknet_leaf_5_clk_load sky130_fd_sc_hd__clkbuf_16
Xclkbuf_leaf_6_clk_load clknet_3_0__leaf_clk_load VSS VSS
+ VDD VDD clknet_leaf_6_clk_load sky130_fd_sc_hd__clkbuf_16
Xclkbuf_leaf_7_clk_load clknet_3_0__leaf_clk_load VSS VSS
+ VDD VDD clknet_leaf_7_clk_load sky130_fd_sc_hd__clkbuf_16
Xclkbuf_leaf_8_clk_load clknet_3_0__leaf_clk_load VSS VSS
+ VDD VDD clknet_leaf_8_clk_load sky130_fd_sc_hd__clkbuf_16
Xclkbuf_leaf_9_clk_load clknet_3_0__leaf_clk_load VSS VSS
+ VDD VDD clknet_leaf_9_clk_load sky130_fd_sc_hd__clkbuf_16
Xclkbuf_leaf_10_clk_load clknet_3_1__leaf_clk_load VSS VSS
+ VDD VDD clknet_leaf_10_clk_load sky130_fd_sc_hd__clkbuf_16
Xclkbuf_leaf_11_clk_load clknet_3_1__leaf_clk_load VSS VSS
+ VDD VDD clknet_leaf_11_clk_load sky130_fd_sc_hd__clkbuf_16
Xclkbuf_leaf_12_clk_load clknet_3_1__leaf_clk_load VSS VSS
+ VDD VDD clknet_leaf_12_clk_load sky130_fd_sc_hd__clkbuf_16
Xclkbuf_leaf_13_clk_load clknet_3_1__leaf_clk_load VSS VSS
+ VDD VDD clknet_leaf_13_clk_load sky130_fd_sc_hd__clkbuf_16
Xclkbuf_leaf_14_clk_load clknet_3_1__leaf_clk_load VSS VSS
+ VDD VDD clknet_leaf_14_clk_load sky130_fd_sc_hd__clkbuf_16
Xclkbuf_leaf_15_clk_load clknet_3_1__leaf_clk_load VSS VSS
+ VDD VDD clknet_leaf_15_clk_load sky130_fd_sc_hd__clkbuf_16
Xclkbuf_leaf_16_clk_load clknet_3_1__leaf_clk_load VSS VSS
+ VDD VDD clknet_leaf_16_clk_load sky130_fd_sc_hd__clkbuf_16
Xclkbuf_leaf_17_clk_load clknet_3_3__leaf_clk_load VSS VSS
+ VDD VDD clknet_leaf_17_clk_load sky130_fd_sc_hd__clkbuf_16
Xclkbuf_leaf_18_clk_load clknet_3_3__leaf_clk_load VSS VSS
+ VDD VDD clknet_leaf_18_clk_load sky130_fd_sc_hd__clkbuf_16
Xclkbuf_leaf_19_clk_load clknet_3_3__leaf_clk_load VSS VSS
+ VDD VDD clknet_leaf_19_clk_load sky130_fd_sc_hd__clkbuf_16
Xclkbuf_leaf_20_clk_load clknet_3_2__leaf_clk_load VSS VSS
+ VDD VDD clknet_leaf_20_clk_load sky130_fd_sc_hd__clkbuf_16
Xclkbuf_leaf_21_clk_load clknet_3_2__leaf_clk_load VSS VSS
+ VDD VDD clknet_leaf_21_clk_load sky130_fd_sc_hd__clkbuf_16
Xclkbuf_leaf_22_clk_load clknet_3_2__leaf_clk_load VSS VSS
+ VDD VDD clknet_leaf_22_clk_load sky130_fd_sc_hd__clkbuf_16
Xclkbuf_leaf_23_clk_load clknet_3_0__leaf_clk_load VSS VSS
+ VDD VDD clknet_leaf_23_clk_load sky130_fd_sc_hd__clkbuf_16
Xclkbuf_leaf_24_clk_load clknet_3_2__leaf_clk_load VSS VSS
+ VDD VDD clknet_leaf_24_clk_load sky130_fd_sc_hd__clkbuf_16
Xclkbuf_leaf_25_clk_load clknet_3_2__leaf_clk_load VSS VSS
+ VDD VDD clknet_leaf_25_clk_load sky130_fd_sc_hd__clkbuf_16
Xclkbuf_leaf_26_clk_load clknet_3_2__leaf_clk_load VSS VSS
+ VDD VDD clknet_leaf_26_clk_load sky130_fd_sc_hd__clkbuf_16
Xclkbuf_leaf_27_clk_load clknet_3_2__leaf_clk_load VSS VSS
+ VDD VDD clknet_leaf_27_clk_load sky130_fd_sc_hd__clkbuf_16
Xclkbuf_leaf_28_clk_load clknet_3_2__leaf_clk_load VSS VSS
+ VDD VDD clknet_leaf_28_clk_load sky130_fd_sc_hd__clkbuf_16
Xclkbuf_leaf_29_clk_load clknet_3_2__leaf_clk_load VSS VSS
+ VDD VDD clknet_leaf_29_clk_load sky130_fd_sc_hd__clkbuf_16
Xclkbuf_leaf_30_clk_load clknet_3_2__leaf_clk_load VSS VSS
+ VDD VDD clknet_leaf_30_clk_load sky130_fd_sc_hd__clkbuf_16
Xclkbuf_leaf_31_clk_load clknet_3_2__leaf_clk_load VSS VSS
+ VDD VDD clknet_leaf_31_clk_load sky130_fd_sc_hd__clkbuf_16
Xclkbuf_leaf_32_clk_load clknet_3_2__leaf_clk_load VSS VSS
+ VDD VDD clknet_leaf_32_clk_load sky130_fd_sc_hd__clkbuf_16
Xclkbuf_leaf_33_clk_load clknet_3_2__leaf_clk_load VSS VSS
+ VDD VDD clknet_leaf_33_clk_load sky130_fd_sc_hd__clkbuf_16
Xclkbuf_leaf_34_clk_load clknet_3_2__leaf_clk_load VSS VSS
+ VDD VDD clknet_leaf_34_clk_load sky130_fd_sc_hd__clkbuf_16
Xclkbuf_leaf_35_clk_load clknet_3_2__leaf_clk_load VSS VSS
+ VDD VDD clknet_leaf_35_clk_load sky130_fd_sc_hd__clkbuf_16
Xclkbuf_leaf_36_clk_load clknet_3_2__leaf_clk_load VSS VSS
+ VDD VDD clknet_leaf_36_clk_load sky130_fd_sc_hd__clkbuf_16
Xclkbuf_leaf_37_clk_load clknet_3_3__leaf_clk_load VSS VSS
+ VDD VDD clknet_leaf_37_clk_load sky130_fd_sc_hd__clkbuf_16
Xclkbuf_leaf_38_clk_load clknet_3_3__leaf_clk_load VSS VSS
+ VDD VDD clknet_leaf_38_clk_load sky130_fd_sc_hd__clkbuf_16
Xclkbuf_leaf_39_clk_load clknet_3_3__leaf_clk_load VSS VSS
+ VDD VDD clknet_leaf_39_clk_load sky130_fd_sc_hd__clkbuf_16
Xclkbuf_leaf_40_clk_load clknet_3_3__leaf_clk_load VSS VSS
+ VDD VDD clknet_leaf_40_clk_load sky130_fd_sc_hd__clkbuf_16
Xclkbuf_leaf_41_clk_load clknet_3_3__leaf_clk_load VSS VSS
+ VDD VDD clknet_leaf_41_clk_load sky130_fd_sc_hd__clkbuf_16
Xclkbuf_leaf_42_clk_load clknet_3_3__leaf_clk_load VSS VSS
+ VDD VDD clknet_leaf_42_clk_load sky130_fd_sc_hd__clkbuf_16
Xclkbuf_leaf_43_clk_load clknet_3_3__leaf_clk_load VSS VSS
+ VDD VDD clknet_leaf_43_clk_load sky130_fd_sc_hd__clkbuf_16
Xclkbuf_leaf_44_clk_load clknet_3_3__leaf_clk_load VSS VSS
+ VDD VDD clknet_leaf_44_clk_load sky130_fd_sc_hd__clkbuf_16
Xclkbuf_leaf_45_clk_load clknet_3_3__leaf_clk_load VSS VSS
+ VDD VDD clknet_leaf_45_clk_load sky130_fd_sc_hd__clkbuf_16
Xclkbuf_leaf_46_clk_load clknet_3_3__leaf_clk_load VSS VSS
+ VDD VDD clknet_leaf_46_clk_load sky130_fd_sc_hd__clkbuf_16
Xclkbuf_leaf_47_clk_load clknet_3_3__leaf_clk_load VSS VSS
+ VDD VDD clknet_leaf_47_clk_load sky130_fd_sc_hd__clkbuf_16
Xclkbuf_leaf_48_clk_load clknet_3_3__leaf_clk_load VSS VSS
+ VDD VDD clknet_leaf_48_clk_load sky130_fd_sc_hd__clkbuf_16
Xclkbuf_leaf_49_clk_load clknet_3_6__leaf_clk_load VSS VSS
+ VDD VDD clknet_leaf_49_clk_load sky130_fd_sc_hd__clkbuf_16
Xclkbuf_leaf_50_clk_load clknet_3_6__leaf_clk_load VSS VSS
+ VDD VDD clknet_leaf_50_clk_load sky130_fd_sc_hd__clkbuf_16
Xclkbuf_leaf_51_clk_load clknet_3_7__leaf_clk_load VSS VSS
+ VDD VDD clknet_leaf_51_clk_load sky130_fd_sc_hd__clkbuf_16
Xclkbuf_leaf_52_clk_load clknet_3_7__leaf_clk_load VSS VSS
+ VDD VDD clknet_leaf_52_clk_load sky130_fd_sc_hd__clkbuf_16
Xclkbuf_leaf_53_clk_load clknet_3_7__leaf_clk_load VSS VSS
+ VDD VDD clknet_leaf_53_clk_load sky130_fd_sc_hd__clkbuf_16
Xclkbuf_leaf_54_clk_load clknet_3_7__leaf_clk_load VSS VSS
+ VDD VDD clknet_leaf_54_clk_load sky130_fd_sc_hd__clkbuf_16
Xclkbuf_leaf_55_clk_load clknet_3_6__leaf_clk_load VSS VSS
+ VDD VDD clknet_leaf_55_clk_load sky130_fd_sc_hd__clkbuf_16
Xclkbuf_leaf_56_clk_load clknet_3_6__leaf_clk_load VSS VSS
+ VDD VDD clknet_leaf_56_clk_load sky130_fd_sc_hd__clkbuf_16
Xclkbuf_leaf_57_clk_load clknet_3_6__leaf_clk_load VSS VSS
+ VDD VDD clknet_leaf_57_clk_load sky130_fd_sc_hd__clkbuf_16
Xclkbuf_leaf_58_clk_load clknet_3_6__leaf_clk_load VSS VSS
+ VDD VDD clknet_leaf_58_clk_load sky130_fd_sc_hd__clkbuf_16
Xclkbuf_leaf_59_clk_load clknet_3_6__leaf_clk_load VSS VSS
+ VDD VDD clknet_leaf_59_clk_load sky130_fd_sc_hd__clkbuf_16
Xclkbuf_leaf_60_clk_load clknet_3_7__leaf_clk_load VSS VSS
+ VDD VDD clknet_leaf_60_clk_load sky130_fd_sc_hd__clkbuf_16
Xclkbuf_leaf_61_clk_load clknet_3_5__leaf_clk_load VSS VSS
+ VDD VDD clknet_leaf_61_clk_load sky130_fd_sc_hd__clkbuf_16
Xclkbuf_leaf_62_clk_load clknet_3_7__leaf_clk_load VSS VSS
+ VDD VDD clknet_leaf_62_clk_load sky130_fd_sc_hd__clkbuf_16
Xclkbuf_leaf_63_clk_load clknet_3_7__leaf_clk_load VSS VSS
+ VDD VDD clknet_leaf_63_clk_load sky130_fd_sc_hd__clkbuf_16
Xclkbuf_leaf_64_clk_load clknet_3_7__leaf_clk_load VSS VSS
+ VDD VDD clknet_leaf_64_clk_load sky130_fd_sc_hd__clkbuf_16
Xclkbuf_leaf_65_clk_load clknet_3_7__leaf_clk_load VSS VSS
+ VDD VDD clknet_leaf_65_clk_load sky130_fd_sc_hd__clkbuf_16
Xclkbuf_leaf_66_clk_load clknet_3_7__leaf_clk_load VSS VSS
+ VDD VDD clknet_leaf_66_clk_load sky130_fd_sc_hd__clkbuf_16
Xclkbuf_leaf_67_clk_load clknet_3_5__leaf_clk_load VSS VSS
+ VDD VDD clknet_leaf_67_clk_load sky130_fd_sc_hd__clkbuf_16
Xclkbuf_leaf_68_clk_load clknet_3_5__leaf_clk_load VSS VSS
+ VDD VDD clknet_leaf_68_clk_load sky130_fd_sc_hd__clkbuf_16
Xclkbuf_leaf_69_clk_load clknet_3_5__leaf_clk_load VSS VSS
+ VDD VDD clknet_leaf_69_clk_load sky130_fd_sc_hd__clkbuf_16
Xclkbuf_leaf_70_clk_load clknet_3_5__leaf_clk_load VSS VSS
+ VDD VDD clknet_leaf_70_clk_load sky130_fd_sc_hd__clkbuf_16
Xclkbuf_leaf_71_clk_load clknet_3_5__leaf_clk_load VSS VSS
+ VDD VDD clknet_leaf_71_clk_load sky130_fd_sc_hd__clkbuf_16
Xclkbuf_leaf_72_clk_load clknet_3_5__leaf_clk_load VSS VSS
+ VDD VDD clknet_leaf_72_clk_load sky130_fd_sc_hd__clkbuf_16
Xclkbuf_leaf_73_clk_load clknet_3_5__leaf_clk_load VSS VSS
+ VDD VDD clknet_leaf_73_clk_load sky130_fd_sc_hd__clkbuf_16
Xclkbuf_leaf_74_clk_load clknet_3_5__leaf_clk_load VSS VSS
+ VDD VDD clknet_leaf_74_clk_load sky130_fd_sc_hd__clkbuf_16
Xclkbuf_leaf_75_clk_load clknet_3_5__leaf_clk_load VSS VSS
+ VDD VDD clknet_leaf_75_clk_load sky130_fd_sc_hd__clkbuf_16
Xclkbuf_leaf_76_clk_load clknet_3_5__leaf_clk_load VSS VSS
+ VDD VDD clknet_leaf_76_clk_load sky130_fd_sc_hd__clkbuf_16
Xclkbuf_leaf_77_clk_load clknet_3_5__leaf_clk_load VSS VSS
+ VDD VDD clknet_leaf_77_clk_load sky130_fd_sc_hd__clkbuf_16
Xclkbuf_leaf_78_clk_load clknet_3_5__leaf_clk_load VSS VSS
+ VDD VDD clknet_leaf_78_clk_load sky130_fd_sc_hd__clkbuf_16
Xclkbuf_leaf_79_clk_load clknet_3_4__leaf_clk_load VSS VSS
+ VDD VDD clknet_leaf_79_clk_load sky130_fd_sc_hd__clkbuf_16
Xclkbuf_leaf_80_clk_load clknet_3_5__leaf_clk_load VSS VSS
+ VDD VDD clknet_leaf_80_clk_load sky130_fd_sc_hd__clkbuf_16
Xclkbuf_leaf_81_clk_load clknet_3_4__leaf_clk_load VSS VSS
+ VDD VDD clknet_leaf_81_clk_load sky130_fd_sc_hd__clkbuf_16
Xclkbuf_leaf_82_clk_load clknet_3_4__leaf_clk_load VSS VSS
+ VDD VDD clknet_leaf_82_clk_load sky130_fd_sc_hd__clkbuf_16
Xclkbuf_leaf_83_clk_load clknet_3_4__leaf_clk_load VSS VSS
+ VDD VDD clknet_leaf_83_clk_load sky130_fd_sc_hd__clkbuf_16
Xclkbuf_leaf_84_clk_load clknet_3_4__leaf_clk_load VSS VSS
+ VDD VDD clknet_leaf_84_clk_load sky130_fd_sc_hd__clkbuf_16
Xclkbuf_leaf_85_clk_load clknet_3_4__leaf_clk_load VSS VSS
+ VDD VDD clknet_leaf_85_clk_load sky130_fd_sc_hd__clkbuf_16
Xclkbuf_leaf_86_clk_load clknet_3_4__leaf_clk_load VSS VSS
+ VDD VDD clknet_leaf_86_clk_load sky130_fd_sc_hd__clkbuf_16
Xclkbuf_leaf_87_clk_load clknet_3_4__leaf_clk_load VSS VSS
+ VDD VDD clknet_leaf_87_clk_load sky130_fd_sc_hd__clkbuf_16
Xclkbuf_leaf_88_clk_load clknet_3_4__leaf_clk_load VSS VSS
+ VDD VDD clknet_leaf_88_clk_load sky130_fd_sc_hd__clkbuf_16
Xclkbuf_leaf_89_clk_load clknet_3_4__leaf_clk_load VSS VSS
+ VDD VDD clknet_leaf_89_clk_load sky130_fd_sc_hd__clkbuf_16
Xclkbuf_leaf_90_clk_load clknet_3_6__leaf_clk_load VSS VSS
+ VDD VDD clknet_leaf_90_clk_load sky130_fd_sc_hd__clkbuf_16
Xclkbuf_leaf_91_clk_load clknet_3_6__leaf_clk_load VSS VSS
+ VDD VDD clknet_leaf_91_clk_load sky130_fd_sc_hd__clkbuf_16
Xclkbuf_leaf_92_clk_load clknet_3_6__leaf_clk_load VSS VSS
+ VDD VDD clknet_leaf_92_clk_load sky130_fd_sc_hd__clkbuf_16
Xclkbuf_leaf_93_clk_load clknet_3_4__leaf_clk_load VSS VSS
+ VDD VDD clknet_leaf_93_clk_load sky130_fd_sc_hd__clkbuf_16
Xclkbuf_leaf_94_clk_load clknet_3_4__leaf_clk_load VSS VSS
+ VDD VDD clknet_leaf_94_clk_load sky130_fd_sc_hd__clkbuf_16
Xclkbuf_leaf_95_clk_load clknet_3_1__leaf_clk_load VSS VSS
+ VDD VDD clknet_leaf_95_clk_load sky130_fd_sc_hd__clkbuf_16
Xclkbuf_leaf_96_clk_load clknet_3_4__leaf_clk_load VSS VSS
+ VDD VDD clknet_leaf_96_clk_load sky130_fd_sc_hd__clkbuf_16
Xclkbuf_leaf_97_clk_load clknet_3_4__leaf_clk_load VSS VSS
+ VDD VDD clknet_leaf_97_clk_load sky130_fd_sc_hd__clkbuf_16
Xclkbuf_leaf_98_clk_load clknet_3_4__leaf_clk_load VSS VSS
+ VDD VDD clknet_leaf_98_clk_load sky130_fd_sc_hd__clkbuf_16
Xclkbuf_leaf_99_clk_load clknet_3_4__leaf_clk_load VSS VSS
+ VDD VDD clknet_leaf_99_clk_load sky130_fd_sc_hd__clkbuf_16
Xclkbuf_leaf_100_clk_load clknet_3_4__leaf_clk_load VSS VSS
+ VDD VDD clknet_leaf_100_clk_load sky130_fd_sc_hd__clkbuf_16
Xclkbuf_leaf_101_clk_load clknet_3_1__leaf_clk_load VSS VSS
+ VDD VDD clknet_leaf_101_clk_load sky130_fd_sc_hd__clkbuf_16
Xclkbuf_leaf_102_clk_load clknet_3_1__leaf_clk_load VSS VSS
+ VDD VDD clknet_leaf_102_clk_load sky130_fd_sc_hd__clkbuf_16
Xclkbuf_leaf_103_clk_load clknet_3_1__leaf_clk_load VSS VSS
+ VDD VDD clknet_leaf_103_clk_load sky130_fd_sc_hd__clkbuf_16
Xclkbuf_leaf_104_clk_load clknet_3_1__leaf_clk_load VSS VSS
+ VDD VDD clknet_leaf_104_clk_load sky130_fd_sc_hd__clkbuf_16
Xclkbuf_leaf_105_clk_load clknet_3_0__leaf_clk_load VSS VSS
+ VDD VDD clknet_leaf_105_clk_load sky130_fd_sc_hd__clkbuf_16
Xclkbuf_leaf_106_clk_load clknet_3_0__leaf_clk_load VSS VSS
+ VDD VDD clknet_leaf_106_clk_load sky130_fd_sc_hd__clkbuf_16
Xclkbuf_leaf_107_clk_load clknet_3_0__leaf_clk_load VSS VSS
+ VDD VDD clknet_leaf_107_clk_load sky130_fd_sc_hd__clkbuf_16
Xclkbuf_leaf_108_clk_load clknet_3_0__leaf_clk_load VSS VSS
+ VDD VDD clknet_leaf_108_clk_load sky130_fd_sc_hd__clkbuf_16
Xclkbuf_leaf_109_clk_load clknet_3_0__leaf_clk_load VSS VSS
+ VDD VDD clknet_leaf_109_clk_load sky130_fd_sc_hd__clkbuf_16
Xclkbuf_0_clk_load clk_load VSS VSS VDD VDD clknet_0_clk_load
+ sky130_fd_sc_hd__clkbuf_16
Xclkbuf_3_0__f_clk_load clknet_0_clk_load VSS VSS VDD VDD
+ clknet_3_0__leaf_clk_load sky130_fd_sc_hd__clkbuf_16
Xclkbuf_3_1__f_clk_load clknet_0_clk_load VSS VSS VDD VDD
+ clknet_3_1__leaf_clk_load sky130_fd_sc_hd__clkbuf_16
Xclkbuf_3_2__f_clk_load clknet_0_clk_load VSS VSS VDD VDD
+ clknet_3_2__leaf_clk_load sky130_fd_sc_hd__clkbuf_16
Xclkbuf_3_3__f_clk_load clknet_0_clk_load VSS VSS VDD VDD
+ clknet_3_3__leaf_clk_load sky130_fd_sc_hd__clkbuf_16
Xclkbuf_3_4__f_clk_load clknet_0_clk_load VSS VSS VDD VDD
+ clknet_3_4__leaf_clk_load sky130_fd_sc_hd__clkbuf_16
Xclkbuf_3_5__f_clk_load clknet_0_clk_load VSS VSS VDD VDD
+ clknet_3_5__leaf_clk_load sky130_fd_sc_hd__clkbuf_16
Xclkbuf_3_6__f_clk_load clknet_0_clk_load VSS VSS VDD VDD
+ clknet_3_6__leaf_clk_load sky130_fd_sc_hd__clkbuf_16
Xclkbuf_3_7__f_clk_load clknet_0_clk_load VSS VSS VDD VDD
+ clknet_3_7__leaf_clk_load sky130_fd_sc_hd__clkbuf_16
Xclkload170 clknet_3_0__leaf_clk_load VSS VSS VDD VDD _unconnected_188
+ sky130_fd_sc_hd__clkbuf_16
Xclkload171 clknet_3_1__leaf_clk_load VSS VSS VDD VDD _unconnected_189
+ sky130_fd_sc_hd__clkinv_16
Xclkload172 clknet_3_2__leaf_clk_load VSS VSS VDD VDD _unconnected_190
+ sky130_fd_sc_hd__clkbuf_16
Xclkload173 clknet_3_3__leaf_clk_load VSS VSS VDD VDD _unconnected_191
+ sky130_fd_sc_hd__inv_6
Xclkload174 clknet_3_5__leaf_clk_load VSS VSS VDD VDD _unconnected_192
+ sky130_fd_sc_hd__clkinv_8
Xclkload175 clknet_3_6__leaf_clk_load VSS VSS VDD VDD _unconnected_193
+ sky130_fd_sc_hd__clkinv_16
Xclkload176 clknet_3_7__leaf_clk_load VSS VSS VDD VDD _unconnected_194
+ sky130_fd_sc_hd__clkinv_16
Xclkload177 clknet_leaf_0_clk_load VSS VSS VDD VDD _unconnected_195
+ sky130_fd_sc_hd__clkinv_1
Xclkload178 clknet_leaf_1_clk_load VSS VSS VDD VDD _unconnected_196
+ sky130_fd_sc_hd__clkinv_2
Xclkload179 clknet_leaf_2_clk_load VSS VSS VDD VDD _unconnected_197
+ sky130_fd_sc_hd__clkinv_1
Xclkload180 clknet_leaf_3_clk_load VSS VSS VDD VDD _unconnected_198
+ sky130_fd_sc_hd__clkinvlp_4
Xclkload181 clknet_leaf_4_clk_load VSS VSS VDD VDD _unconnected_199
+ sky130_fd_sc_hd__clkinv_1
Xclkload182 clknet_leaf_5_clk_load VSS VSS VDD VDD _unconnected_200
+ sky130_fd_sc_hd__bufinv_16
Xclkload183 clknet_leaf_6_clk_load VSS VSS VDD VDD _unconnected_201
+ sky130_fd_sc_hd__bufinv_16
Xclkload184 clknet_leaf_8_clk_load VSS VSS VDD VDD _unconnected_202
+ sky130_fd_sc_hd__bufinv_16
Xclkload185 clknet_leaf_9_clk_load VSS VSS VDD VDD _unconnected_203
+ sky130_fd_sc_hd__bufinv_16
Xclkload186 clknet_leaf_23_clk_load VSS VSS VDD VDD _unconnected_204
+ sky130_fd_sc_hd__bufinv_16
Xclkload187 clknet_leaf_105_clk_load VSS VSS VDD VDD _unconnected_205
+ sky130_fd_sc_hd__bufinv_16
Xclkload188 clknet_leaf_106_clk_load VSS VSS VDD VDD _unconnected_206
+ sky130_fd_sc_hd__bufinv_16
Xclkload189 clknet_leaf_107_clk_load VSS VSS VDD VDD _unconnected_207
+ sky130_fd_sc_hd__clkinv_1
Xclkload190 clknet_leaf_108_clk_load VSS VSS VDD VDD _unconnected_208
+ sky130_fd_sc_hd__bufinv_16
Xclkload191 clknet_leaf_109_clk_load VSS VSS VDD VDD _unconnected_209
+ sky130_fd_sc_hd__clkinv_1
Xclkload192 clknet_leaf_10_clk_load VSS VSS VDD VDD _unconnected_210
+ sky130_fd_sc_hd__clkinv_1
Xclkload193 clknet_leaf_11_clk_load VSS VSS VDD VDD _unconnected_211
+ sky130_fd_sc_hd__clkinvlp_4
Xclkload194 clknet_leaf_12_clk_load VSS VSS VDD VDD _unconnected_212
+ sky130_fd_sc_hd__bufinv_16
Xclkload195 clknet_leaf_13_clk_load VSS VSS VDD VDD _unconnected_213
+ sky130_fd_sc_hd__clkinv_1
Xclkload196 clknet_leaf_14_clk_load VSS VSS VDD VDD _unconnected_214
+ sky130_fd_sc_hd__clkinv_2
Xclkload197 clknet_leaf_15_clk_load VSS VSS VDD VDD _unconnected_215
+ sky130_fd_sc_hd__clkinv_1
Xclkload198 clknet_leaf_16_clk_load VSS VSS VDD VDD _unconnected_216
+ sky130_fd_sc_hd__clkinv_1
Xclkload199 clknet_leaf_95_clk_load VSS VSS VDD VDD _unconnected_217
+ sky130_fd_sc_hd__bufinv_16
Xclkload200 clknet_leaf_101_clk_load VSS VSS VDD VDD _unconnected_218
+ sky130_fd_sc_hd__clkbuf_1
Xclkload201 clknet_leaf_102_clk_load VSS VSS VDD VDD _unconnected_219
+ sky130_fd_sc_hd__clkbuf_1
Xclkload202 clknet_leaf_103_clk_load VSS VSS VDD VDD _unconnected_220
+ sky130_fd_sc_hd__clkinv_1
Xclkload203 clknet_leaf_20_clk_load VSS VSS VDD VDD _unconnected_221
+ sky130_fd_sc_hd__clkinv_1
Xclkload204 clknet_leaf_21_clk_load VSS VSS VDD VDD _unconnected_222
+ sky130_fd_sc_hd__clkinvlp_4
Xclkload205 clknet_leaf_24_clk_load VSS VSS VDD VDD _unconnected_223
+ sky130_fd_sc_hd__clkbuf_1
Xclkload206 clknet_leaf_25_clk_load VSS VSS VDD VDD _unconnected_224
+ sky130_fd_sc_hd__clkinv_2
Xclkload207 clknet_leaf_26_clk_load VSS VSS VDD VDD _unconnected_225
+ sky130_fd_sc_hd__clkbuf_1
Xclkload208 clknet_leaf_27_clk_load VSS VSS VDD VDD _unconnected_226
+ sky130_fd_sc_hd__clkinv_1
Xclkload209 clknet_leaf_28_clk_load VSS VSS VDD VDD _unconnected_227
+ sky130_fd_sc_hd__clkinv_1
Xclkload210 clknet_leaf_29_clk_load VSS VSS VDD VDD _unconnected_228
+ sky130_fd_sc_hd__clkbuf_1
Xclkload211 clknet_leaf_30_clk_load VSS VSS VDD VDD _unconnected_229
+ sky130_fd_sc_hd__clkinv_1
Xclkload212 clknet_leaf_31_clk_load VSS VSS VDD VDD _unconnected_230
+ sky130_fd_sc_hd__clkinv_1
Xclkload213 clknet_leaf_32_clk_load VSS VSS VDD VDD _unconnected_231
+ sky130_fd_sc_hd__clkinv_1
Xclkload214 clknet_leaf_34_clk_load VSS VSS VDD VDD _unconnected_232
+ sky130_fd_sc_hd__clkinv_1
Xclkload215 clknet_leaf_35_clk_load VSS VSS VDD VDD _unconnected_233
+ sky130_fd_sc_hd__clkinv_1
Xclkload216 clknet_leaf_36_clk_load VSS VSS VDD VDD _unconnected_234
+ sky130_fd_sc_hd__clkinv_2
Xclkload217 clknet_leaf_17_clk_load VSS VSS VDD VDD _unconnected_235
+ sky130_fd_sc_hd__clkbuf_1
Xclkload218 clknet_leaf_18_clk_load VSS VSS VDD VDD _unconnected_236
+ sky130_fd_sc_hd__clkinv_1
Xclkload219 clknet_leaf_37_clk_load VSS VSS VDD VDD _unconnected_237
+ sky130_fd_sc_hd__clkinv_2
Xclkload220 clknet_leaf_38_clk_load VSS VSS VDD VDD _unconnected_238
+ sky130_fd_sc_hd__clkinvlp_4
Xclkload221 clknet_leaf_39_clk_load VSS VSS VDD VDD _unconnected_239
+ sky130_fd_sc_hd__clkinv_1
Xclkload222 clknet_leaf_40_clk_load VSS VSS VDD VDD _unconnected_240
+ sky130_fd_sc_hd__inv_6
Xclkload223 clknet_leaf_41_clk_load VSS VSS VDD VDD _unconnected_241
+ sky130_fd_sc_hd__clkinv_1
Xclkload224 clknet_leaf_42_clk_load VSS VSS VDD VDD _unconnected_242
+ sky130_fd_sc_hd__clkinv_4
Xclkload225 clknet_leaf_43_clk_load VSS VSS VDD VDD _unconnected_243
+ sky130_fd_sc_hd__clkinvlp_4
Xclkload226 clknet_leaf_44_clk_load VSS VSS VDD VDD _unconnected_244
+ sky130_fd_sc_hd__bufinv_16
Xclkload227 clknet_leaf_45_clk_load VSS VSS VDD VDD _unconnected_245
+ sky130_fd_sc_hd__clkinv_4
Xclkload228 clknet_leaf_46_clk_load VSS VSS VDD VDD _unconnected_246
+ sky130_fd_sc_hd__clkbuf_1
Xclkload229 clknet_leaf_47_clk_load VSS VSS VDD VDD _unconnected_247
+ sky130_fd_sc_hd__clkinv_2
Xclkload230 clknet_leaf_48_clk_load VSS VSS VDD VDD _unconnected_248
+ sky130_fd_sc_hd__clkinv_2
Xclkload231 clknet_leaf_79_clk_load VSS VSS VDD VDD _unconnected_249
+ sky130_fd_sc_hd__clkinv_1
Xclkload232 clknet_leaf_81_clk_load VSS VSS VDD VDD _unconnected_250
+ sky130_fd_sc_hd__clkinv_1
Xclkload233 clknet_leaf_82_clk_load VSS VSS VDD VDD _unconnected_251
+ sky130_fd_sc_hd__clkbuf_1
Xclkload234 clknet_leaf_84_clk_load VSS VSS VDD VDD _unconnected_252
+ sky130_fd_sc_hd__bufinv_16
Xclkload235 clknet_leaf_85_clk_load VSS VSS VDD VDD _unconnected_253
+ sky130_fd_sc_hd__clkinv_1
Xclkload236 clknet_leaf_86_clk_load VSS VSS VDD VDD _unconnected_254
+ sky130_fd_sc_hd__clkbuf_1
Xclkload237 clknet_leaf_87_clk_load VSS VSS VDD VDD _unconnected_255
+ sky130_fd_sc_hd__bufinv_16
Xclkload238 clknet_leaf_88_clk_load VSS VSS VDD VDD _unconnected_256
+ sky130_fd_sc_hd__clkinv_1
Xclkload239 clknet_leaf_89_clk_load VSS VSS VDD VDD _unconnected_257
+ sky130_fd_sc_hd__clkinv_2
Xclkload240 clknet_leaf_93_clk_load VSS VSS VDD VDD _unconnected_258
+ sky130_fd_sc_hd__clkinv_2
Xclkload241 clknet_leaf_94_clk_load VSS VSS VDD VDD _unconnected_259
+ sky130_fd_sc_hd__clkinv_2
Xclkload242 clknet_leaf_97_clk_load VSS VSS VDD VDD _unconnected_260
+ sky130_fd_sc_hd__clkinv_2
Xclkload243 clknet_leaf_98_clk_load VSS VSS VDD VDD _unconnected_261
+ sky130_fd_sc_hd__clkinv_1
Xclkload244 clknet_leaf_99_clk_load VSS VSS VDD VDD _unconnected_262
+ sky130_fd_sc_hd__clkbuf_1
Xclkload245 clknet_leaf_100_clk_load VSS VSS VDD VDD _unconnected_263
+ sky130_fd_sc_hd__clkbuf_1
Xclkload246 clknet_leaf_61_clk_load VSS VSS VDD VDD _unconnected_264
+ sky130_fd_sc_hd__clkinvlp_4
Xclkload247 clknet_leaf_67_clk_load VSS VSS VDD VDD _unconnected_265
+ sky130_fd_sc_hd__clkinv_1
Xclkload248 clknet_leaf_68_clk_load VSS VSS VDD VDD _unconnected_266
+ sky130_fd_sc_hd__clkinvlp_4
Xclkload249 clknet_leaf_69_clk_load VSS VSS VDD VDD _unconnected_267
+ sky130_fd_sc_hd__clkinv_2
Xclkload250 clknet_leaf_70_clk_load VSS VSS VDD VDD _unconnected_268
+ sky130_fd_sc_hd__clkinv_1
Xclkload251 clknet_leaf_71_clk_load VSS VSS VDD VDD _unconnected_269
+ sky130_fd_sc_hd__clkinv_4
Xclkload252 clknet_leaf_72_clk_load VSS VSS VDD VDD _unconnected_270
+ sky130_fd_sc_hd__clkinv_2
Xclkload253 clknet_leaf_73_clk_load VSS VSS VDD VDD _unconnected_271
+ sky130_fd_sc_hd__clkinv_2
Xclkload254 clknet_leaf_74_clk_load VSS VSS VDD VDD _unconnected_272
+ sky130_fd_sc_hd__clkinv_1
Xclkload255 clknet_leaf_76_clk_load VSS VSS VDD VDD _unconnected_273
+ sky130_fd_sc_hd__clkinv_1
Xclkload256 clknet_leaf_77_clk_load VSS VSS VDD VDD _unconnected_274
+ sky130_fd_sc_hd__clkinvlp_4
Xclkload257 clknet_leaf_78_clk_load VSS VSS VDD VDD _unconnected_275
+ sky130_fd_sc_hd__clkbuf_1
Xclkload258 clknet_leaf_80_clk_load VSS VSS VDD VDD _unconnected_276
+ sky130_fd_sc_hd__clkbuf_1
Xclkload259 clknet_leaf_49_clk_load VSS VSS VDD VDD _unconnected_277
+ sky130_fd_sc_hd__clkinv_1
Xclkload260 clknet_leaf_50_clk_load VSS VSS VDD VDD _unconnected_278
+ sky130_fd_sc_hd__clkinv_4
Xclkload261 clknet_leaf_55_clk_load VSS VSS VDD VDD _unconnected_279
+ sky130_fd_sc_hd__clkinv_2
Xclkload262 clknet_leaf_56_clk_load VSS VSS VDD VDD _unconnected_280
+ sky130_fd_sc_hd__clkinv_2
Xclkload263 clknet_leaf_58_clk_load VSS VSS VDD VDD _unconnected_281
+ sky130_fd_sc_hd__clkinvlp_4
Xclkload264 clknet_leaf_59_clk_load VSS VSS VDD VDD _unconnected_282
+ sky130_fd_sc_hd__clkinv_1
Xclkload265 clknet_leaf_90_clk_load VSS VSS VDD VDD _unconnected_283
+ sky130_fd_sc_hd__clkinv_1
Xclkload266 clknet_leaf_91_clk_load VSS VSS VDD VDD _unconnected_284
+ sky130_fd_sc_hd__clkbuf_1
Xclkload267 clknet_leaf_92_clk_load VSS VSS VDD VDD _unconnected_285
+ sky130_fd_sc_hd__clkinvlp_4
Xclkload268 clknet_leaf_51_clk_load VSS VSS VDD VDD _unconnected_286
+ sky130_fd_sc_hd__clkinv_2
Xclkload269 clknet_leaf_52_clk_load VSS VSS VDD VDD _unconnected_287
+ sky130_fd_sc_hd__clkbuf_1
Xclkload270 clknet_leaf_53_clk_load VSS VSS VDD VDD _unconnected_288
+ sky130_fd_sc_hd__clkinv_2
Xclkload271 clknet_leaf_54_clk_load VSS VSS VDD VDD _unconnected_289
+ sky130_fd_sc_hd__clkinv_2
Xclkload272 clknet_leaf_60_clk_load VSS VSS VDD VDD _unconnected_290
+ sky130_fd_sc_hd__clkinvlp_4
Xclkload273 clknet_leaf_62_clk_load VSS VSS VDD VDD _unconnected_291
+ sky130_fd_sc_hd__clkinv_2
Xclkload274 clknet_leaf_63_clk_load VSS VSS VDD VDD _unconnected_292
+ sky130_fd_sc_hd__clkinv_1
Xclkload275 clknet_leaf_64_clk_load VSS VSS VDD VDD _unconnected_293
+ sky130_fd_sc_hd__clkinv_1
Xclkload276 clknet_leaf_66_clk_load VSS VSS VDD VDD _unconnected_294
+ sky130_fd_sc_hd__clkbuf_1
Xdelaybuf_0_core_clk clk_root VSS VSS VDD VDD delaynet_0_core_clk
+ sky130_fd_sc_hd__clkbuf_4
Xdelaybuf_1_core_clk delaynet_0_core_clk VSS VSS VDD VDD delaynet_1_core_clk
+ sky130_fd_sc_hd__clkdlybuf4s50_1
Xdelaybuf_2_core_clk delaynet_1_core_clk VSS VSS VDD VDD delaynet_2_core_clk
+ sky130_fd_sc_hd__clkdlybuf4s15_2
Xhold444 start VSS VSS VDD VDD net443 sky130_fd_sc_hd__dlygate4sd3_1
Xhold445 net24 VSS VSS VDD VDD net444 sky130_fd_sc_hd__dlygate4sd3_1
Xhold446 _01958_ VSS VSS VDD VDD net445 sky130_fd_sc_hd__dlygate4sd3_1
Xhold447 net461 VSS VSS VDD VDD net446 sky130_fd_sc_hd__dlygate4sd3_1
Xhold448 net23 VSS VSS VDD VDD net447 sky130_fd_sc_hd__buf_2
Xhold449 icg_net.en VSS VSS VDD VDD net448 sky130_fd_sc_hd__dlygate4sd3_1
Xhold450 load_data[0] VSS VSS VDD VDD net449 sky130_fd_sc_hd__dlygate4sd3_1
Xhold451 net18 VSS VSS VDD VDD net450 sky130_fd_sc_hd__dlygate4sd3_1
Xhold452 net454 VSS VSS VDD VDD net451 sky130_fd_sc_hd__dlygate4sd3_1
Xhold453 net21 VSS VSS VDD VDD net452 sky130_fd_sc_hd__dlygate4sd3_1
Xhold454 net417 VSS VSS VDD VDD net453 sky130_fd_sc_hd__dlygate4sd3_1
Xhold455 load_data[3] VSS VSS VDD VDD net454 sky130_fd_sc_hd__dlygate4sd3_1
Xhold456 load_data[1] VSS VSS VDD VDD net455 sky130_fd_sc_hd__dlygate4sd3_1
Xhold457 net19 VSS VSS VDD VDD net456 sky130_fd_sc_hd__dlygate4sd3_1
Xhold458 load_data[2] VSS VSS VDD VDD net457 sky130_fd_sc_hd__dlygate4sd3_1
Xhold459 net20 VSS VSS VDD VDD net458 sky130_fd_sc_hd__dlygate4sd3_1
Xhold460 net33 VSS VSS VDD VDD net459 sky130_fd_sc_hd__dlygate4sd3_1
Xhold461 load_valid VSS VSS VDD VDD net460 sky130_fd_sc_hd__dlygate4sd3_1
Xhold462 reset VSS VSS VDD VDD net461 sky130_fd_sc_hd__dlygate4sd3_1
Xhold463 net46 VSS VSS VDD VDD net462 sky130_fd_sc_hd__dlygate4sd3_1
Xhold464 network.in_period\[238\]\[3\] VSS VSS VDD VDD net463
+ sky130_fd_sc_hd__dlygate4sd3_1
Xhold465 network.in_period\[235\]\[3\] VSS VSS VDD VDD net464
+ sky130_fd_sc_hd__dlygate4sd3_1
Xhold466 network.in_period\[239\]\[1\] VSS VSS VDD VDD net465
+ sky130_fd_sc_hd__dlygate4sd3_1
Xhold467 network.in_period\[238\]\[1\] VSS VSS VDD VDD net466
+ sky130_fd_sc_hd__dlygate4sd3_1
Xhold468 network.in_period\[235\]\[1\] VSS VSS VDD VDD net467
+ sky130_fd_sc_hd__dlygate4sd3_1
Xhold469 network.in_period\[235\]\[0\] VSS VSS VDD VDD net468
+ sky130_fd_sc_hd__dlygate4sd3_1
Xhold470 network.in_period\[239\]\[0\] VSS VSS VDD VDD net469
+ sky130_fd_sc_hd__dlygate4sd3_1
Xhold471 network.in_period\[238\]\[0\] VSS VSS VDD VDD net470
+ sky130_fd_sc_hd__dlygate4sd3_1
Xhold472 network.in_period\[230\]\[3\] VSS VSS VDD VDD net471
+ sky130_fd_sc_hd__dlygate4sd3_1
Xhold473 network.in_period\[230\]\[1\] VSS VSS VDD VDD net472
+ sky130_fd_sc_hd__dlygate4sd3_1
Xhold474 network.in_period\[203\]\[1\] VSS VSS VDD VDD net473
+ sky130_fd_sc_hd__dlygate4sd3_1
Xhold475 network.in_period\[234\]\[3\] VSS VSS VDD VDD net474
+ sky130_fd_sc_hd__dlygate4sd3_1
Xhold476 network.in_period\[203\]\[0\] VSS VSS VDD VDD net475
+ sky130_fd_sc_hd__dlygate4sd3_1
Xhold477 network.in_period\[203\]\[3\] VSS VSS VDD VDD net476
+ sky130_fd_sc_hd__dlygate4sd3_1
Xhold478 network.in_period\[234\]\[1\] VSS VSS VDD VDD net477
+ sky130_fd_sc_hd__dlygate4sd3_1
Xhold479 network.in_period\[230\]\[0\] VSS VSS VDD VDD net478
+ sky130_fd_sc_hd__dlygate4sd3_1
Xhold480 network.in_period\[234\]\[0\] VSS VSS VDD VDD net479
+ sky130_fd_sc_hd__dlygate4sd3_1
Xhold481 network.arbit.counter\[3\] VSS VSS VDD VDD net480
+ sky130_fd_sc_hd__dlygate4sd3_1
Xhold482 network.in_period\[239\]\[3\] VSS VSS VDD VDD net481
+ sky130_fd_sc_hd__dlygate4sd3_1
Xhold483 network.neuron_out4.IF0.membrane_potential\[7\] VSS
+ VSS VDD VDD net482 sky130_fd_sc_hd__dlygate4sd3_1
Xhold484 network.neuron_out3.IF0.membrane_potential\[7\] VSS
+ VSS VDD VDD net483 sky130_fd_sc_hd__dlygate4sd3_1
Xhold485 network.neuron_out2.IF0.membrane_potential\[7\] VSS
+ VSS VDD VDD net484 sky130_fd_sc_hd__dlygate4sd3_1
Xhold486 network.neuron_out0.IF0.membrane_potential\[7\] VSS
+ VSS VDD VDD net485 sky130_fd_sc_hd__dlygate4sd3_1
Xhold487 network.ctrl_addr\[7\] VSS VSS VDD VDD net486 sky130_fd_sc_hd__dlygate4sd3_1
Xhold488 network.ctrl_addr\[6\] VSS VSS VDD VDD net487 sky130_fd_sc_hd__dlygate4sd3_1
Xhold489 network.in_period\[210\]\[3\] VSS VSS VDD VDD net488
+ sky130_fd_sc_hd__dlygate4sd3_1
Xhold490 network.in_period\[209\]\[3\] VSS VSS VDD VDD net489
+ sky130_fd_sc_hd__dlygate4sd3_1
Xhold491 network.in_period\[206\]\[3\] VSS VSS VDD VDD net490
+ sky130_fd_sc_hd__dlygate4sd3_1
Xhold492 network.ctrl_addr\[3\] VSS VSS VDD VDD net491 sky130_fd_sc_hd__dlygate4sd3_1
Xhold493 network.in_period\[209\]\[2\] VSS VSS VDD VDD net492
+ sky130_fd_sc_hd__dlygate4sd3_1
Xhold494 network.in_period\[237\]\[3\] VSS VSS VDD VDD net493
+ sky130_fd_sc_hd__dlygate4sd3_1
Xhold495 network.in_period\[202\]\[3\] VSS VSS VDD VDD net494
+ sky130_fd_sc_hd__dlygate4sd3_1
Xhold496 network.in_period\[226\]\[3\] VSS VSS VDD VDD net495
+ sky130_fd_sc_hd__dlygate4sd3_1
Xhold497 network.in_period\[196\]\[3\] VSS VSS VDD VDD net496
+ sky130_fd_sc_hd__dlygate4sd3_1
Xhold498 network.ctrl_addr\[1\] VSS VSS VDD VDD net497 sky130_fd_sc_hd__dlygate4sd3_1
Xhold499 network.in_period\[205\]\[3\] VSS VSS VDD VDD net498
+ sky130_fd_sc_hd__dlygate4sd3_1
Xhold500 network.ctrl_addr\[2\] VSS VSS VDD VDD net499 sky130_fd_sc_hd__dlygate4sd3_1
Xhold501 network.in_period\[224\]\[3\] VSS VSS VDD VDD net500
+ sky130_fd_sc_hd__dlygate4sd3_1
Xhold502 network.in_period\[199\]\[2\] VSS VSS VDD VDD net501
+ sky130_fd_sc_hd__dlygate4sd3_1
Xhold503 network.in_period\[201\]\[3\] VSS VSS VDD VDD net502
+ sky130_fd_sc_hd__dlygate4sd3_1
Xhold504 network.in_period\[193\]\[3\] VSS VSS VDD VDD net503
+ sky130_fd_sc_hd__dlygate4sd3_1
Xhold505 network.in_period\[228\]\[3\] VSS VSS VDD VDD net504
+ sky130_fd_sc_hd__dlygate4sd3_1
Xhold506 network.in_period\[236\]\[3\] VSS VSS VDD VDD net505
+ sky130_fd_sc_hd__dlygate4sd3_1
Xhold507 network.in_period\[195\]\[2\] VSS VSS VDD VDD net506
+ sky130_fd_sc_hd__dlygate4sd3_1
Xhold508 network.in_period\[192\]\[3\] VSS VSS VDD VDD net507
+ sky130_fd_sc_hd__dlygate4sd3_1
Xhold509 network.in_period\[198\]\[3\] VSS VSS VDD VDD net508
+ sky130_fd_sc_hd__dlygate4sd3_1
Xhold510 network.in_period\[206\]\[1\] VSS VSS VDD VDD net509
+ sky130_fd_sc_hd__dlygate4sd3_1
Xhold511 network.in_period\[206\]\[0\] VSS VSS VDD VDD net510
+ sky130_fd_sc_hd__dlygate4sd3_1
Xhold512 network.in_period\[209\]\[1\] VSS VSS VDD VDD net511
+ sky130_fd_sc_hd__dlygate4sd3_1
Xhold513 network.in_period\[210\]\[1\] VSS VSS VDD VDD net512
+ sky130_fd_sc_hd__dlygate4sd3_1
Xhold514 network.in_period\[211\]\[1\] VSS VSS VDD VDD net513
+ sky130_fd_sc_hd__dlygate4sd3_1
Xhold515 network.in_period\[202\]\[1\] VSS VSS VDD VDD net514
+ sky130_fd_sc_hd__dlygate4sd3_1
Xhold516 network.in_period\[205\]\[1\] VSS VSS VDD VDD net515
+ sky130_fd_sc_hd__dlygate4sd3_1
Xhold517 network.in_period\[209\]\[0\] VSS VSS VDD VDD net516
+ sky130_fd_sc_hd__dlygate4sd3_1
Xhold518 network.in_period\[211\]\[0\] VSS VSS VDD VDD net517
+ sky130_fd_sc_hd__dlygate4sd3_1
Xhold519 network.in_period\[212\]\[1\] VSS VSS VDD VDD net518
+ sky130_fd_sc_hd__dlygate4sd3_1
Xhold520 network.in_period\[205\]\[0\] VSS VSS VDD VDD net519
+ sky130_fd_sc_hd__dlygate4sd3_1
Xhold521 network.in_period\[226\]\[1\] VSS VSS VDD VDD net520
+ sky130_fd_sc_hd__dlygate4sd3_1
Xhold522 network.in_period\[210\]\[0\] VSS VSS VDD VDD net521
+ sky130_fd_sc_hd__dlygate4sd3_1
Xhold523 network.in_period\[202\]\[0\] VSS VSS VDD VDD net522
+ sky130_fd_sc_hd__dlygate4sd3_1
Xhold524 network.in_period\[224\]\[0\] VSS VSS VDD VDD net523
+ sky130_fd_sc_hd__dlygate4sd3_1
Xhold525 network.in_period\[212\]\[0\] VSS VSS VDD VDD net524
+ sky130_fd_sc_hd__dlygate4sd3_1
Xhold526 network.in_period\[236\]\[0\] VSS VSS VDD VDD net525
+ sky130_fd_sc_hd__dlygate4sd3_1
Xhold527 network.in_period\[201\]\[0\] VSS VSS VDD VDD net526
+ sky130_fd_sc_hd__dlygate4sd3_1
Xhold528 network.in_period\[224\]\[1\] VSS VSS VDD VDD net527
+ sky130_fd_sc_hd__dlygate4sd3_1
Xhold529 network.in_period\[236\]\[1\] VSS VSS VDD VDD net528
+ sky130_fd_sc_hd__dlygate4sd3_1
Xhold530 network.in_period\[248\]\[1\] VSS VSS VDD VDD net529
+ sky130_fd_sc_hd__dlygate4sd3_1
Xhold531 network.in_period\[201\]\[1\] VSS VSS VDD VDD net530
+ sky130_fd_sc_hd__dlygate4sd3_1
Xhold532 network.in_period\[228\]\[0\] VSS VSS VDD VDD net531
+ sky130_fd_sc_hd__dlygate4sd3_1
Xhold533 network.in_period\[237\]\[1\] VSS VSS VDD VDD net532
+ sky130_fd_sc_hd__dlygate4sd3_1
Xhold534 network.in_period\[226\]\[0\] VSS VSS VDD VDD net533
+ sky130_fd_sc_hd__dlygate4sd3_1
Xhold535 network.in_period\[228\]\[1\] VSS VSS VDD VDD net534
+ sky130_fd_sc_hd__dlygate4sd3_1
Xhold536 network.in_period\[199\]\[1\] VSS VSS VDD VDD net535
+ sky130_fd_sc_hd__dlygate4sd3_1
Xhold537 network.in_period\[248\]\[0\] VSS VSS VDD VDD net536
+ sky130_fd_sc_hd__dlygate4sd3_1
Xhold538 network.in_period\[196\]\[0\] VSS VSS VDD VDD net537
+ sky130_fd_sc_hd__dlygate4sd3_1
Xhold539 network.in_period\[193\]\[0\] VSS VSS VDD VDD net538
+ sky130_fd_sc_hd__dlygate4sd3_1
Xhold540 network.in_period\[225\]\[1\] VSS VSS VDD VDD net539
+ sky130_fd_sc_hd__dlygate4sd3_1
Xhold541 network.in_period\[207\]\[0\] VSS VSS VDD VDD net540
+ sky130_fd_sc_hd__dlygate4sd3_1
Xhold542 network.in_period\[250\]\[0\] VSS VSS VDD VDD net541
+ sky130_fd_sc_hd__dlygate4sd3_1
Xhold543 network.in_period\[194\]\[0\] VSS VSS VDD VDD net542
+ sky130_fd_sc_hd__dlygate4sd3_1
Xhold544 network.in_period\[194\]\[1\] VSS VSS VDD VDD net543
+ sky130_fd_sc_hd__dlygate4sd3_1
Xhold545 network.in_period\[196\]\[1\] VSS VSS VDD VDD net544
+ sky130_fd_sc_hd__dlygate4sd3_1
Xhold546 network.in_period\[243\]\[1\] VSS VSS VDD VDD net545
+ sky130_fd_sc_hd__dlygate4sd3_1
Xhold547 network.in_period\[207\]\[3\] VSS VSS VDD VDD net546
+ sky130_fd_sc_hd__dlygate4sd3_1
Xhold548 network.in_period\[237\]\[0\] VSS VSS VDD VDD net547
+ sky130_fd_sc_hd__dlygate4sd3_1
Xhold549 network.in_period\[198\]\[0\] VSS VSS VDD VDD net548
+ sky130_fd_sc_hd__dlygate4sd3_1
Xhold550 network.in_period\[243\]\[0\] VSS VSS VDD VDD net549
+ sky130_fd_sc_hd__dlygate4sd3_1
Xhold551 network.in_period\[199\]\[0\] VSS VSS VDD VDD net550
+ sky130_fd_sc_hd__dlygate4sd3_1
Xhold552 network.in_period\[207\]\[1\] VSS VSS VDD VDD net551
+ sky130_fd_sc_hd__dlygate4sd3_1
Xhold553 network.in_period\[250\]\[1\] VSS VSS VDD VDD net552
+ sky130_fd_sc_hd__dlygate4sd3_1
Xhold554 network.in_period\[225\]\[0\] VSS VSS VDD VDD net553
+ sky130_fd_sc_hd__dlygate4sd3_1
Xhold555 network.in_period\[198\]\[1\] VSS VSS VDD VDD net554
+ sky130_fd_sc_hd__dlygate4sd3_1
Xhold556 network.in_period\[193\]\[1\] VSS VSS VDD VDD net555
+ sky130_fd_sc_hd__dlygate4sd3_1
Xhold557 network.in_period\[192\]\[1\] VSS VSS VDD VDD net556
+ sky130_fd_sc_hd__dlygate4sd3_1
Xhold558 network.in_period\[197\]\[0\] VSS VSS VDD VDD net557
+ sky130_fd_sc_hd__dlygate4sd3_1
Xhold559 network.in_period\[150\]\[1\] VSS VSS VDD VDD net558
+ sky130_fd_sc_hd__dlygate4sd3_1
Xhold560 network.in_period\[204\]\[0\] VSS VSS VDD VDD net559
+ sky130_fd_sc_hd__dlygate4sd3_1
Xhold561 network.in_period\[231\]\[0\] VSS VSS VDD VDD net560
+ sky130_fd_sc_hd__dlygate4sd3_1
Xhold562 network.in_period\[231\]\[1\] VSS VSS VDD VDD net561
+ sky130_fd_sc_hd__dlygate4sd3_1
Xhold563 network.in_period\[192\]\[0\] VSS VSS VDD VDD net562
+ sky130_fd_sc_hd__dlygate4sd3_1
Xhold564 network.in_period\[197\]\[1\] VSS VSS VDD VDD net563
+ sky130_fd_sc_hd__dlygate4sd3_1
Xhold565 network.in_period\[150\]\[0\] VSS VSS VDD VDD net564
+ sky130_fd_sc_hd__dlygate4sd3_1
Xhold566 network.in_period\[151\]\[3\] VSS VSS VDD VDD net565
+ sky130_fd_sc_hd__dlygate4sd3_1
Xhold567 network.in_period\[231\]\[3\] VSS VSS VDD VDD net566
+ sky130_fd_sc_hd__dlygate4sd3_1
Xhold568 network.in_period\[229\]\[0\] VSS VSS VDD VDD net567
+ sky130_fd_sc_hd__dlygate4sd3_1
Xhold569 network.in_period\[204\]\[3\] VSS VSS VDD VDD net568
+ sky130_fd_sc_hd__dlygate4sd3_1
Xhold570 network.in_period\[217\]\[3\] VSS VSS VDD VDD net569
+ sky130_fd_sc_hd__dlygate4sd3_1
Xhold571 network.in_period\[147\]\[1\] VSS VSS VDD VDD net570
+ sky130_fd_sc_hd__dlygate4sd3_1
Xhold572 network.in_period\[204\]\[1\] VSS VSS VDD VDD net571
+ sky130_fd_sc_hd__dlygate4sd3_1
Xhold573 network.in_period\[38\]\[0\] VSS VSS VDD VDD net572
+ sky130_fd_sc_hd__dlygate4sd3_1
Xhold574 network.in_period\[218\]\[1\] VSS VSS VDD VDD net573
+ sky130_fd_sc_hd__dlygate4sd3_1
Xhold575 network.in_period\[208\]\[0\] VSS VSS VDD VDD net574
+ sky130_fd_sc_hd__dlygate4sd3_1
Xhold576 network.cnt_main.counter\[0\] VSS VSS VDD VDD net575
+ sky130_fd_sc_hd__dlygate4sd3_1
Xhold577 network.in_period\[229\]\[1\] VSS VSS VDD VDD net576
+ sky130_fd_sc_hd__dlygate4sd3_1
Xhold578 network.in_period\[38\]\[1\] VSS VSS VDD VDD net577
+ sky130_fd_sc_hd__dlygate4sd3_1
Xhold579 network.in_period\[218\]\[0\] VSS VSS VDD VDD net578
+ sky130_fd_sc_hd__dlygate4sd3_1
Xhold580 network.in_period\[171\]\[1\] VSS VSS VDD VDD net579
+ sky130_fd_sc_hd__dlygate4sd3_1
Xhold581 network.in_period\[217\]\[1\] VSS VSS VDD VDD net580
+ sky130_fd_sc_hd__dlygate4sd3_1
Xhold582 network.in_period\[208\]\[1\] VSS VSS VDD VDD net581
+ sky130_fd_sc_hd__dlygate4sd3_1
Xhold583 network.in_period\[150\]\[3\] VSS VSS VDD VDD net582
+ sky130_fd_sc_hd__dlygate4sd3_1
Xhold584 network.in_period\[197\]\[3\] VSS VSS VDD VDD net583
+ sky130_fd_sc_hd__dlygate4sd3_1
Xhold585 network.in_period\[213\]\[0\] VSS VSS VDD VDD net584
+ sky130_fd_sc_hd__dlygate4sd3_1
Xhold586 network.in_period\[227\]\[0\] VSS VSS VDD VDD net585
+ sky130_fd_sc_hd__dlygate4sd3_1
Xhold587 network.in_period\[147\]\[0\] VSS VSS VDD VDD net586
+ sky130_fd_sc_hd__dlygate4sd3_1
Xhold588 network.in_period\[246\]\[1\] VSS VSS VDD VDD net587
+ sky130_fd_sc_hd__dlygate4sd3_1
Xhold589 network.in_period\[246\]\[0\] VSS VSS VDD VDD net588
+ sky130_fd_sc_hd__dlygate4sd3_1
Xhold590 network.in_period\[151\]\[1\] VSS VSS VDD VDD net589
+ sky130_fd_sc_hd__dlygate4sd3_1
Xhold591 network.in_period\[213\]\[1\] VSS VSS VDD VDD net590
+ sky130_fd_sc_hd__dlygate4sd3_1
Xhold592 network.cnt_main.counter\[5\] VSS VSS VDD VDD net591
+ sky130_fd_sc_hd__dlygate4sd3_1
Xhold593 network.in_period\[195\]\[1\] VSS VSS VDD VDD net592
+ sky130_fd_sc_hd__dlygate4sd3_1
Xhold594 network.in_period\[154\]\[0\] VSS VSS VDD VDD net593
+ sky130_fd_sc_hd__dlygate4sd3_1
Xhold595 network.ctrl_addr\[0\] VSS VSS VDD VDD net594 sky130_fd_sc_hd__dlygate4sd3_1
Xhold596 network.cnt_main.counter\[9\] VSS VSS VDD VDD net595
+ sky130_fd_sc_hd__dlygate4sd3_1
Xhold597 network.in_period\[146\]\[0\] VSS VSS VDD VDD net596
+ sky130_fd_sc_hd__dlygate4sd3_1
Xhold598 network.ctrl_addr\[5\] VSS VSS VDD VDD net597 sky130_fd_sc_hd__dlygate4sd3_1
Xhold599 network.in_period\[232\]\[0\] VSS VSS VDD VDD net598
+ sky130_fd_sc_hd__dlygate4sd3_1
Xhold600 network.in_period\[217\]\[0\] VSS VSS VDD VDD net599
+ sky130_fd_sc_hd__dlygate4sd3_1
Xhold601 network.in_period\[246\]\[3\] VSS VSS VDD VDD net600
+ sky130_fd_sc_hd__dlygate4sd3_1
Xhold602 network.in_period\[251\]\[3\] VSS VSS VDD VDD net601
+ sky130_fd_sc_hd__dlygate4sd3_1
Xhold603 network.in_period\[147\]\[3\] VSS VSS VDD VDD net602
+ sky130_fd_sc_hd__dlygate4sd3_1
Xhold604 network.in_period\[227\]\[1\] VSS VSS VDD VDD net603
+ sky130_fd_sc_hd__dlygate4sd3_1
Xhold605 network.in_period\[118\]\[1\] VSS VSS VDD VDD net604
+ sky130_fd_sc_hd__dlygate4sd3_1
Xhold606 network.in_period\[151\]\[0\] VSS VSS VDD VDD net605
+ sky130_fd_sc_hd__dlygate4sd3_1
Xhold607 network.in_period\[83\]\[1\] VSS VSS VDD VDD net606
+ sky130_fd_sc_hd__dlygate4sd3_1
Xhold608 network.in_period\[200\]\[1\] VSS VSS VDD VDD net607
+ sky130_fd_sc_hd__dlygate4sd3_1
Xhold609 network.in_period\[83\]\[0\] VSS VSS VDD VDD net608
+ sky130_fd_sc_hd__dlygate4sd3_1
Xhold610 network.in_period\[170\]\[0\] VSS VSS VDD VDD net609
+ sky130_fd_sc_hd__dlygate4sd3_1
Xhold611 network.in_period\[195\]\[0\] VSS VSS VDD VDD net610
+ sky130_fd_sc_hd__dlygate4sd3_1
Xhold612 network.in_period\[245\]\[1\] VSS VSS VDD VDD net611
+ sky130_fd_sc_hd__dlygate4sd3_1
Xhold613 network.in_period\[131\]\[1\] VSS VSS VDD VDD net612
+ sky130_fd_sc_hd__dlygate4sd3_1
Xhold614 network.in_period\[170\]\[1\] VSS VSS VDD VDD net613
+ sky130_fd_sc_hd__dlygate4sd3_1
Xhold615 network.in_period\[186\]\[0\] VSS VSS VDD VDD net614
+ sky130_fd_sc_hd__dlygate4sd3_1
Xhold616 network.in_period\[142\]\[1\] VSS VSS VDD VDD net615
+ sky130_fd_sc_hd__dlygate4sd3_1
Xhold617 network.in_period\[245\]\[0\] VSS VSS VDD VDD net616
+ sky130_fd_sc_hd__dlygate4sd3_1
Xhold618 network.in_period\[114\]\[0\] VSS VSS VDD VDD net617
+ sky130_fd_sc_hd__dlygate4sd3_1
Xhold619 network.in_period\[189\]\[1\] VSS VSS VDD VDD net618
+ sky130_fd_sc_hd__dlygate4sd3_1
Xhold620 network.in_period\[252\]\[0\] VSS VSS VDD VDD net619
+ sky130_fd_sc_hd__dlygate4sd3_1
Xhold621 network.in_period\[233\]\[1\] VSS VSS VDD VDD net620
+ sky130_fd_sc_hd__dlygate4sd3_1
Xhold622 network.in_period\[215\]\[0\] VSS VSS VDD VDD net621
+ sky130_fd_sc_hd__dlygate4sd3_1
Xhold623 network.in_period\[178\]\[0\] VSS VSS VDD VDD net622
+ sky130_fd_sc_hd__dlygate4sd3_1
Xhold624 network.in_period\[115\]\[0\] VSS VSS VDD VDD net623
+ sky130_fd_sc_hd__dlygate4sd3_1
Xhold625 network.in_period\[200\]\[0\] VSS VSS VDD VDD net624
+ sky130_fd_sc_hd__dlygate4sd3_1
Xhold626 network.in_period\[216\]\[0\] VSS VSS VDD VDD net625
+ sky130_fd_sc_hd__dlygate4sd3_1
Xhold627 network.in_period\[145\]\[1\] VSS VSS VDD VDD net626
+ sky130_fd_sc_hd__dlygate4sd3_1
Xhold628 network.in_period\[176\]\[0\] VSS VSS VDD VDD net627
+ sky130_fd_sc_hd__dlygate4sd3_1
Xhold629 network.in_period\[115\]\[1\] VSS VSS VDD VDD net628
+ sky130_fd_sc_hd__dlygate4sd3_1
Xhold630 network.in_period\[142\]\[0\] VSS VSS VDD VDD net629
+ sky130_fd_sc_hd__dlygate4sd3_1
Xhold631 network.in_period\[232\]\[1\] VSS VSS VDD VDD net630
+ sky130_fd_sc_hd__dlygate4sd3_1
Xhold632 network.in_period\[38\]\[3\] VSS VSS VDD VDD net631
+ sky130_fd_sc_hd__dlygate4sd3_1
Xhold633 network.in_period\[129\]\[0\] VSS VSS VDD VDD net632
+ sky130_fd_sc_hd__dlygate4sd3_1
Xhold634 network.in_period\[252\]\[1\] VSS VSS VDD VDD net633
+ sky130_fd_sc_hd__dlygate4sd3_1
Xhold635 network.in_period\[129\]\[1\] VSS VSS VDD VDD net634
+ sky130_fd_sc_hd__dlygate4sd3_1
Xhold636 network.in_period\[223\]\[1\] VSS VSS VDD VDD net635
+ sky130_fd_sc_hd__dlygate4sd3_1
Xhold637 network.in_period\[177\]\[0\] VSS VSS VDD VDD net636
+ sky130_fd_sc_hd__dlygate4sd3_1
Xhold638 network.in_period\[46\]\[0\] VSS VSS VDD VDD net637
+ sky130_fd_sc_hd__dlygate4sd3_1
Xhold639 network.in_period\[185\]\[0\] VSS VSS VDD VDD net638
+ sky130_fd_sc_hd__dlygate4sd3_1
Xhold640 network.in_period\[80\]\[1\] VSS VSS VDD VDD net639
+ sky130_fd_sc_hd__dlygate4sd3_1
Xhold641 network.in_period\[214\]\[0\] VSS VSS VDD VDD net640
+ sky130_fd_sc_hd__dlygate4sd3_1
Xhold642 network.in_period\[251\]\[0\] VSS VSS VDD VDD net641
+ sky130_fd_sc_hd__dlygate4sd3_1
Xhold643 network.in_period\[221\]\[0\] VSS VSS VDD VDD net642
+ sky130_fd_sc_hd__dlygate4sd3_1
Xhold644 network.in_period\[139\]\[1\] VSS VSS VDD VDD net643
+ sky130_fd_sc_hd__dlygate4sd3_1
Xhold645 network.in_period\[215\]\[1\] VSS VSS VDD VDD net644
+ sky130_fd_sc_hd__dlygate4sd3_1
Xhold646 network.in_period\[183\]\[1\] VSS VSS VDD VDD net645
+ sky130_fd_sc_hd__dlygate4sd3_1
Xhold647 network.in_period\[178\]\[1\] VSS VSS VDD VDD net646
+ sky130_fd_sc_hd__dlygate4sd3_1
Xhold648 network.in_period\[80\]\[0\] VSS VSS VDD VDD net647
+ sky130_fd_sc_hd__dlygate4sd3_1
Xhold649 network.in_period\[86\]\[1\] VSS VSS VDD VDD net648
+ sky130_fd_sc_hd__dlygate4sd3_1
Xhold650 network.in_period\[177\]\[1\] VSS VSS VDD VDD net649
+ sky130_fd_sc_hd__dlygate4sd3_1
Xhold651 network.in_period\[72\]\[1\] VSS VSS VDD VDD net650
+ sky130_fd_sc_hd__dlygate4sd3_1
Xhold652 network.in_period\[72\]\[0\] VSS VSS VDD VDD net651
+ sky130_fd_sc_hd__dlygate4sd3_1
Xhold653 network.in_period\[182\]\[1\] VSS VSS VDD VDD net652
+ sky130_fd_sc_hd__dlygate4sd3_1
Xhold654 network.in_period\[214\]\[1\] VSS VSS VDD VDD net653
+ sky130_fd_sc_hd__dlygate4sd3_1
Xhold655 network.in_period\[176\]\[1\] VSS VSS VDD VDD net654
+ sky130_fd_sc_hd__dlygate4sd3_1
Xhold656 network.in_period\[216\]\[1\] VSS VSS VDD VDD net655
+ sky130_fd_sc_hd__dlygate4sd3_1
Xhold657 network.in_period\[79\]\[1\] VSS VSS VDD VDD net656
+ sky130_fd_sc_hd__dlygate4sd3_1
Xhold658 network.in_period\[220\]\[0\] VSS VSS VDD VDD net657
+ sky130_fd_sc_hd__dlygate4sd3_1
Xhold659 network.in_period\[131\]\[0\] VSS VSS VDD VDD net658
+ sky130_fd_sc_hd__dlygate4sd3_1
Xhold660 network.in_period\[145\]\[0\] VSS VSS VDD VDD net659
+ sky130_fd_sc_hd__dlygate4sd3_1
Xhold661 network.in_period\[148\]\[0\] VSS VSS VDD VDD net660
+ sky130_fd_sc_hd__dlygate4sd3_1
Xhold662 network.in_period\[137\]\[1\] VSS VSS VDD VDD net661
+ sky130_fd_sc_hd__dlygate4sd3_1
Xhold663 network.in_period\[142\]\[3\] VSS VSS VDD VDD net662
+ sky130_fd_sc_hd__dlygate4sd3_1
Xhold664 network.in_period\[185\]\[1\] VSS VSS VDD VDD net663
+ sky130_fd_sc_hd__dlygate4sd3_1
Xhold665 network.in_period\[233\]\[0\] VSS VSS VDD VDD net664
+ sky130_fd_sc_hd__dlygate4sd3_1
Xhold666 network.in_spk15_13 VSS VSS VDD VDD net665 sky130_fd_sc_hd__dlygate4sd3_1
Xhold667 network.in_period\[138\]\[0\] VSS VSS VDD VDD net666
+ sky130_fd_sc_hd__dlygate4sd3_1
Xhold668 network.in_period\[128\]\[1\] VSS VSS VDD VDD net667
+ sky130_fd_sc_hd__dlygate4sd3_1
Xhold669 network.in_period\[179\]\[0\] VSS VSS VDD VDD net668
+ sky130_fd_sc_hd__dlygate4sd3_1
Xhold670 network.in_period\[114\]\[1\] VSS VSS VDD VDD net669
+ sky130_fd_sc_hd__dlygate4sd3_1
Xhold671 network.in_period\[222\]\[3\] VSS VSS VDD VDD net670
+ sky130_fd_sc_hd__dlygate4sd3_1
Xhold672 network.in_period\[187\]\[1\] VSS VSS VDD VDD net671
+ sky130_fd_sc_hd__dlygate4sd3_1
Xhold673 network.in_period\[222\]\[1\] VSS VSS VDD VDD net672
+ sky130_fd_sc_hd__dlygate4sd3_1
Xhold674 network.in_period\[179\]\[1\] VSS VSS VDD VDD net673
+ sky130_fd_sc_hd__dlygate4sd3_1
Xhold675 network.in_period\[139\]\[0\] VSS VSS VDD VDD net674
+ sky130_fd_sc_hd__dlygate4sd3_1
Xhold676 network.in_period\[221\]\[1\] VSS VSS VDD VDD net675
+ sky130_fd_sc_hd__dlygate4sd3_1
Xhold677 network.in_period\[77\]\[0\] VSS VSS VDD VDD net676
+ sky130_fd_sc_hd__dlygate4sd3_1
Xhold678 network.in_period\[152\]\[1\] VSS VSS VDD VDD net677
+ sky130_fd_sc_hd__dlygate4sd3_1
Xhold679 network.in_period\[223\]\[0\] VSS VSS VDD VDD net678
+ sky130_fd_sc_hd__dlygate4sd3_1
Xhold680 network.in_period\[253\]\[1\] VSS VSS VDD VDD net679
+ sky130_fd_sc_hd__dlygate4sd3_1
Xhold681 network.in_period\[153\]\[1\] VSS VSS VDD VDD net680
+ sky130_fd_sc_hd__dlygate4sd3_1
Xhold682 network.in_period\[84\]\[1\] VSS VSS VDD VDD net681
+ sky130_fd_sc_hd__dlygate4sd3_1
Xhold683 network.in_period\[188\]\[1\] VSS VSS VDD VDD net682
+ sky130_fd_sc_hd__dlygate4sd3_1
Xhold684 network.in_period\[137\]\[3\] VSS VSS VDD VDD net683
+ sky130_fd_sc_hd__dlygate4sd3_1
Xhold685 network.in_period\[180\]\[1\] VSS VSS VDD VDD net684
+ sky130_fd_sc_hd__dlygate4sd3_1
Xhold686 network.in_period\[85\]\[0\] VSS VSS VDD VDD net685
+ sky130_fd_sc_hd__dlygate4sd3_1
Xhold687 network.in_period\[159\]\[0\] VSS VSS VDD VDD net686
+ sky130_fd_sc_hd__dlygate4sd3_1
Xhold688 network.in_period\[181\]\[0\] VSS VSS VDD VDD net687
+ sky130_fd_sc_hd__dlygate4sd3_1
Xhold689 network.in_period\[137\]\[0\] VSS VSS VDD VDD net688
+ sky130_fd_sc_hd__dlygate4sd3_1
Xhold690 network.in_period\[213\]\[3\] VSS VSS VDD VDD net689
+ sky130_fd_sc_hd__dlygate4sd3_1
Xhold691 network.in_period\[46\]\[1\] VSS VSS VDD VDD net690
+ sky130_fd_sc_hd__dlygate4sd3_1
Xhold692 network.in_period\[78\]\[0\] VSS VSS VDD VDD net691
+ sky130_fd_sc_hd__dlygate4sd3_1
Xhold693 network.in_spk07_12 VSS VSS VDD VDD net692 sky130_fd_sc_hd__dlygate4sd3_1
Xhold694 network.in_spk11_15 VSS VSS VDD VDD net693 sky130_fd_sc_hd__dlygate4sd3_1
Xhold695 network.in_period\[136\]\[0\] VSS VSS VDD VDD net694
+ sky130_fd_sc_hd__dlygate4sd3_1
Xhold696 network.in_period\[29\]\[1\] VSS VSS VDD VDD net695
+ sky130_fd_sc_hd__dlygate4sd3_1
Xhold697 network.in_spk07_08 VSS VSS VDD VDD net696 sky130_fd_sc_hd__dlygate4sd3_1
Xhold698 network.in_period\[95\]\[0\] VSS VSS VDD VDD net697
+ sky130_fd_sc_hd__dlygate4sd3_1
Xhold699 network.in_period\[219\]\[0\] VSS VSS VDD VDD net698
+ sky130_fd_sc_hd__dlygate4sd3_1
Xhold700 network.in_period\[138\]\[1\] VSS VSS VDD VDD net699
+ sky130_fd_sc_hd__dlygate4sd3_1
Xhold701 network.in_period\[183\]\[0\] VSS VSS VDD VDD net700
+ sky130_fd_sc_hd__dlygate4sd3_1
Xhold702 network.in_period\[132\]\[0\] VSS VSS VDD VDD net701
+ sky130_fd_sc_hd__dlygate4sd3_1
Xhold703 network.in_period\[157\]\[0\] VSS VSS VDD VDD net702
+ sky130_fd_sc_hd__dlygate4sd3_1
Xhold704 network.in_period\[232\]\[3\] VSS VSS VDD VDD net703
+ sky130_fd_sc_hd__dlygate4sd3_1
Xhold705 network.in_period\[50\]\[0\] VSS VSS VDD VDD net704
+ sky130_fd_sc_hd__dlygate4sd3_1
Xhold706 network.in_period\[253\]\[0\] VSS VSS VDD VDD net705
+ sky130_fd_sc_hd__dlygate4sd3_1
Xhold707 network.in_period\[136\]\[1\] VSS VSS VDD VDD net706
+ sky130_fd_sc_hd__dlygate4sd3_1
Xhold708 network.in_period\[182\]\[0\] VSS VSS VDD VDD net707
+ sky130_fd_sc_hd__dlygate4sd3_1
Xhold709 network.in_spk07_13 VSS VSS VDD VDD net708 sky130_fd_sc_hd__dlygate4sd3_1
Xhold710 network.in_period\[155\]\[1\] VSS VSS VDD VDD net709
+ sky130_fd_sc_hd__dlygate4sd3_1
Xhold711 network.in_period\[126\]\[1\] VSS VSS VDD VDD net710
+ sky130_fd_sc_hd__dlygate4sd3_1
Xhold712 network.in_period\[21\]\[0\] VSS VSS VDD VDD net711
+ sky130_fd_sc_hd__dlygate4sd3_1
Xhold713 network.in_period\[55\]\[1\] VSS VSS VDD VDD net712
+ sky130_fd_sc_hd__dlygate4sd3_1
Xhold714 network.in_period\[181\]\[1\] VSS VSS VDD VDD net713
+ sky130_fd_sc_hd__dlygate4sd3_1
Xhold715 network.in_period\[50\]\[3\] VSS VSS VDD VDD net714
+ sky130_fd_sc_hd__dlygate4sd3_1
Xhold716 network.in_period\[123\]\[1\] VSS VSS VDD VDD net715
+ sky130_fd_sc_hd__dlygate4sd3_1
Xhold717 network.in_period\[148\]\[1\] VSS VSS VDD VDD net716
+ sky130_fd_sc_hd__dlygate4sd3_1
Xhold718 network.in_period\[127\]\[0\] VSS VSS VDD VDD net717
+ sky130_fd_sc_hd__dlygate4sd3_1
Xhold719 network.in_period\[84\]\[0\] VSS VSS VDD VDD net718
+ sky130_fd_sc_hd__dlygate4sd3_1
Xhold720 network.in_period\[189\]\[0\] VSS VSS VDD VDD net719
+ sky130_fd_sc_hd__dlygate4sd3_1
Xhold721 network.in_spk15_06 VSS VSS VDD VDD net720 sky130_fd_sc_hd__dlygate4sd3_1
Xhold722 network.in_period\[75\]\[0\] VSS VSS VDD VDD net721
+ sky130_fd_sc_hd__dlygate4sd3_1
Xhold723 network.in_period\[186\]\[1\] VSS VSS VDD VDD net722
+ sky130_fd_sc_hd__dlygate4sd3_1
Xhold724 network.in_period\[85\]\[1\] VSS VSS VDD VDD net723
+ sky130_fd_sc_hd__dlygate4sd3_1
Xhold725 network.in_period\[220\]\[1\] VSS VSS VDD VDD net724
+ sky130_fd_sc_hd__dlygate4sd3_1
Xhold726 network.in_period\[78\]\[1\] VSS VSS VDD VDD net725
+ sky130_fd_sc_hd__dlygate4sd3_1
Xhold727 network.in_period\[114\]\[3\] VSS VSS VDD VDD net726
+ sky130_fd_sc_hd__dlygate4sd3_1
Xhold728 network.in_period\[126\]\[0\] VSS VSS VDD VDD net727
+ sky130_fd_sc_hd__dlygate4sd3_1
Xhold729 network.in_period\[76\]\[1\] VSS VSS VDD VDD net728
+ sky130_fd_sc_hd__dlygate4sd3_1
Xhold730 network.in_period\[152\]\[0\] VSS VSS VDD VDD net729
+ sky130_fd_sc_hd__dlygate4sd3_1
Xhold731 network.in_period\[28\]\[0\] VSS VSS VDD VDD net730
+ sky130_fd_sc_hd__dlygate4sd3_1
Xhold732 network.in_spk15_09 VSS VSS VDD VDD net731 sky130_fd_sc_hd__dlygate4sd3_1
Xhold733 network.in_spk15_10 VSS VSS VDD VDD net732 sky130_fd_sc_hd__dlygate4sd3_1
Xhold734 network.in_period\[127\]\[1\] VSS VSS VDD VDD net733
+ sky130_fd_sc_hd__dlygate4sd3_1
Xhold735 network.in_period\[154\]\[1\] VSS VSS VDD VDD net734
+ sky130_fd_sc_hd__dlygate4sd3_1
Xhold736 network.in_period\[6\]\[0\] VSS VSS VDD VDD net735
+ sky130_fd_sc_hd__dlygate4sd3_1
Xhold737 network.in_period\[112\]\[1\] VSS VSS VDD VDD net736
+ sky130_fd_sc_hd__dlygate4sd3_1
Xhold738 network.in_period\[90\]\[0\] VSS VSS VDD VDD net737
+ sky130_fd_sc_hd__dlygate4sd3_1
Xhold739 network.in_period\[31\]\[1\] VSS VSS VDD VDD net738
+ sky130_fd_sc_hd__dlygate4sd3_1
Xhold740 network.in_period\[187\]\[0\] VSS VSS VDD VDD net739
+ sky130_fd_sc_hd__dlygate4sd3_1
Xhold741 network.in_period\[44\]\[0\] VSS VSS VDD VDD net740
+ sky130_fd_sc_hd__dlygate4sd3_1
Xhold742 network.in_period\[132\]\[1\] VSS VSS VDD VDD net741
+ sky130_fd_sc_hd__dlygate4sd3_1
Xhold743 network.in_period\[253\]\[3\] VSS VSS VDD VDD net742
+ sky130_fd_sc_hd__dlygate4sd3_1
Xhold744 network.in_period\[219\]\[1\] VSS VSS VDD VDD net743
+ sky130_fd_sc_hd__dlygate4sd3_1
Xhold745 network.in_period\[88\]\[0\] VSS VSS VDD VDD net744
+ sky130_fd_sc_hd__dlygate4sd3_1
Xhold746 network.in_period\[46\]\[3\] VSS VSS VDD VDD net745
+ sky130_fd_sc_hd__dlygate4sd3_1
Xhold747 network.in_period\[130\]\[0\] VSS VSS VDD VDD net746
+ sky130_fd_sc_hd__dlygate4sd3_1
Xhold748 network.in_period\[165\]\[1\] VSS VSS VDD VDD net747
+ sky130_fd_sc_hd__dlygate4sd3_1
Xhold749 network.in_period\[77\]\[3\] VSS VSS VDD VDD net748
+ sky130_fd_sc_hd__dlygate4sd3_1
Xhold750 network.in_period\[161\]\[0\] VSS VSS VDD VDD net749
+ sky130_fd_sc_hd__dlygate4sd3_1
Xhold751 network.in_period\[79\]\[0\] VSS VSS VDD VDD net750
+ sky130_fd_sc_hd__dlygate4sd3_1
Xhold752 network.in_period\[146\]\[1\] VSS VSS VDD VDD net751
+ sky130_fd_sc_hd__dlygate4sd3_1
Xhold753 network.in_period\[157\]\[1\] VSS VSS VDD VDD net752
+ sky130_fd_sc_hd__dlygate4sd3_1
Xhold754 network.in_period\[162\]\[0\] VSS VSS VDD VDD net753
+ sky130_fd_sc_hd__dlygate4sd3_1
Xhold755 network.in_period\[155\]\[0\] VSS VSS VDD VDD net754
+ sky130_fd_sc_hd__dlygate4sd3_1
Xhold756 network.in_period\[94\]\[0\] VSS VSS VDD VDD net755
+ sky130_fd_sc_hd__dlygate4sd3_1
Xhold757 network.in_period\[41\]\[0\] VSS VSS VDD VDD net756
+ sky130_fd_sc_hd__dlygate4sd3_1
Xhold758 network.in_spk06_08 VSS VSS VDD VDD net757 sky130_fd_sc_hd__dlygate4sd3_1
Xhold759 network.in_period\[86\]\[0\] VSS VSS VDD VDD net758
+ sky130_fd_sc_hd__dlygate4sd3_1
Xhold760 network.in_period\[144\]\[1\] VSS VSS VDD VDD net759
+ sky130_fd_sc_hd__dlygate4sd3_1
Xhold761 network.in_spk14_15 VSS VSS VDD VDD net760 sky130_fd_sc_hd__dlygate4sd3_1
Xhold762 network.in_period\[212\]\[3\] VSS VSS VDD VDD net761
+ sky130_fd_sc_hd__dlygate4sd3_1
Xhold763 network.in_spk11_14 VSS VSS VDD VDD net762 sky130_fd_sc_hd__dlygate4sd3_1
Xhold764 network.in_spk02_11 VSS VSS VDD VDD net763 sky130_fd_sc_hd__dlygate4sd3_1
Xhold765 network.in_period\[167\]\[0\] VSS VSS VDD VDD net764
+ sky130_fd_sc_hd__dlygate4sd3_1
Xhold766 network.in_period\[91\]\[0\] VSS VSS VDD VDD net765
+ sky130_fd_sc_hd__dlygate4sd3_1
Xhold767 network.in_period\[52\]\[1\] VSS VSS VDD VDD net766
+ sky130_fd_sc_hd__dlygate4sd3_1
Xhold768 network.in_period\[157\]\[3\] VSS VSS VDD VDD net767
+ sky130_fd_sc_hd__dlygate4sd3_1
Xhold769 network.in_period\[26\]\[1\] VSS VSS VDD VDD net768
+ sky130_fd_sc_hd__dlygate4sd3_1
Xhold770 network.in_period\[44\]\[1\] VSS VSS VDD VDD net769
+ sky130_fd_sc_hd__dlygate4sd3_1
Xhold771 network.in_period\[90\]\[1\] VSS VSS VDD VDD net770
+ sky130_fd_sc_hd__dlygate4sd3_1
Xhold772 network.in_period\[122\]\[3\] VSS VSS VDD VDD net771
+ sky130_fd_sc_hd__dlygate4sd3_1
Xhold773 network.in_period\[21\]\[3\] VSS VSS VDD VDD net772
+ sky130_fd_sc_hd__dlygate4sd3_1
Xhold774 network.in_period\[4\]\[1\] VSS VSS VDD VDD net773
+ sky130_fd_sc_hd__dlygate4sd3_1
Xhold775 network.in_period\[26\]\[0\] VSS VSS VDD VDD net774
+ sky130_fd_sc_hd__dlygate4sd3_1
Xhold776 network.in_spk15_05 VSS VSS VDD VDD net775 sky130_fd_sc_hd__dlygate4sd3_1
Xhold777 network.in_period\[190\]\[1\] VSS VSS VDD VDD net776
+ sky130_fd_sc_hd__dlygate4sd3_1
Xhold778 network.in_period\[90\]\[3\] VSS VSS VDD VDD net777
+ sky130_fd_sc_hd__dlygate4sd3_1
Xhold779 network.in_period\[156\]\[1\] VSS VSS VDD VDD net778
+ sky130_fd_sc_hd__dlygate4sd3_1
Xhold780 network.in_period\[7\]\[1\] VSS VSS VDD VDD net779
+ sky130_fd_sc_hd__dlygate4sd3_1
Xhold781 network.in_period\[130\]\[1\] VSS VSS VDD VDD net780
+ sky130_fd_sc_hd__dlygate4sd3_1
Xhold782 network.in_period\[124\]\[1\] VSS VSS VDD VDD net781
+ sky130_fd_sc_hd__dlygate4sd3_1
Xhold783 network.in_period\[112\]\[0\] VSS VSS VDD VDD net782
+ sky130_fd_sc_hd__dlygate4sd3_1
Xhold784 network.in_period\[77\]\[1\] VSS VSS VDD VDD net783
+ sky130_fd_sc_hd__dlygate4sd3_1
Xhold785 network.in_period\[94\]\[1\] VSS VSS VDD VDD net784
+ sky130_fd_sc_hd__dlygate4sd3_1
Xhold786 network.in_period\[162\]\[1\] VSS VSS VDD VDD net785
+ sky130_fd_sc_hd__dlygate4sd3_1
Xhold787 network.in_period\[29\]\[0\] VSS VSS VDD VDD net786
+ sky130_fd_sc_hd__dlygate4sd3_1
Xhold788 network.in_period\[14\]\[0\] VSS VSS VDD VDD net787
+ sky130_fd_sc_hd__dlygate4sd3_1
Xwire789 net416 VSS VSS VDD VDD net788 sky130_fd_sc_hd__buf_12
Xhold790 network.in_period\[119\]\[0\] VSS VSS VDD VDD net789
+ sky130_fd_sc_hd__dlygate4sd3_1
Xhold791 network.in_period\[110\]\[1\] VSS VSS VDD VDD net790
+ sky130_fd_sc_hd__dlygate4sd3_1
Xhold792 network.in_period\[75\]\[1\] VSS VSS VDD VDD net791
+ sky130_fd_sc_hd__dlygate4sd3_1
Xhold793 network.in_period\[116\]\[1\] VSS VSS VDD VDD net792
+ sky130_fd_sc_hd__dlygate4sd3_1
Xhold794 network.in_period\[117\]\[3\] VSS VSS VDD VDD net793
+ sky130_fd_sc_hd__dlygate4sd3_1
Xhold795 network.in_period\[188\]\[0\] VSS VSS VDD VDD net794
+ sky130_fd_sc_hd__dlygate4sd3_1
Xhold796 network.ctrl_spk VSS VSS VDD VDD net795 sky130_fd_sc_hd__dlygate4sd3_1
Xhold797 network.in_period\[111\]\[1\] VSS VSS VDD VDD net796
+ sky130_fd_sc_hd__dlygate4sd3_1
Xhold798 network.in_period\[74\]\[0\] VSS VSS VDD VDD net797
+ sky130_fd_sc_hd__dlygate4sd3_1
Xhold799 network.in_period\[113\]\[0\] VSS VSS VDD VDD net798
+ sky130_fd_sc_hd__dlygate4sd3_1
Xhold800 network.in_period\[110\]\[0\] VSS VSS VDD VDD net799
+ sky130_fd_sc_hd__dlygate4sd3_1
Xhold801 network.in_period\[71\]\[0\] VSS VSS VDD VDD net800
+ sky130_fd_sc_hd__dlygate4sd3_1
Xhold802 network.in_period\[117\]\[1\] VSS VSS VDD VDD net801
+ sky130_fd_sc_hd__dlygate4sd3_1
Xhold803 network.in_period\[191\]\[1\] VSS VSS VDD VDD net802
+ sky130_fd_sc_hd__dlygate4sd3_1
Xhold804 network.in_period\[21\]\[1\] VSS VSS VDD VDD net803
+ sky130_fd_sc_hd__dlygate4sd3_1
Xhold805 network.in_period\[117\]\[0\] VSS VSS VDD VDD net804
+ sky130_fd_sc_hd__dlygate4sd3_1
Xhold806 network.in_period\[254\]\[1\] VSS VSS VDD VDD net805
+ sky130_fd_sc_hd__dlygate4sd3_1
Xhold807 network.in_period\[70\]\[0\] VSS VSS VDD VDD net806
+ sky130_fd_sc_hd__dlygate4sd3_1
Xhold808 network.in_period\[28\]\[1\] VSS VSS VDD VDD net807
+ sky130_fd_sc_hd__dlygate4sd3_1
Xhold809 network.in_period\[107\]\[0\] VSS VSS VDD VDD net808
+ sky130_fd_sc_hd__dlygate4sd3_1
Xhold810 network.in_period\[70\]\[1\] VSS VSS VDD VDD net809
+ sky130_fd_sc_hd__dlygate4sd3_1
Xhold811 network.in_period\[104\]\[1\] VSS VSS VDD VDD net810
+ sky130_fd_sc_hd__dlygate4sd3_1
Xhold812 network.in_period\[73\]\[1\] VSS VSS VDD VDD net811
+ sky130_fd_sc_hd__dlygate4sd3_1
Xhold813 network.in_period\[255\]\[0\] VSS VSS VDD VDD net812
+ sky130_fd_sc_hd__dlygate4sd3_1
Xhold814 network.in_period\[71\]\[1\] VSS VSS VDD VDD net813
+ sky130_fd_sc_hd__dlygate4sd3_1
XANTENNA_1 clk VSS VSS VDD VDD sky130_fd_sc_hd__diode_2
XANTENNA_2 _04028_ VSS VSS VDD VDD sky130_fd_sc_hd__diode_2
XANTENNA_3 _04081_ VSS VSS VDD VDD sky130_fd_sc_hd__diode_2
XANTENNA_4 start VSS VSS VDD VDD sky130_fd_sc_hd__diode_2
XANTENNA_5 _08161_ VSS VSS VDD VDD sky130_fd_sc_hd__diode_2
.ENDS ecg_snn_core
