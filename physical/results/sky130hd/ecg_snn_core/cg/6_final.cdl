* CDL Netlist generated by OpenROAD

*.BUSDELIMITER [

.SUBCKT ecg_snn_core busy clk done inference_cycles[0] inference_cycles[10]
+ inference_cycles[11] inference_cycles[12] inference_cycles[13]
+ inference_cycles[14] inference_cycles[15] inference_cycles[1]
+ inference_cycles[2] inference_cycles[3] inference_cycles[4]
+ inference_cycles[5] inference_cycles[6] inference_cycles[7]
+ inference_cycles[8] inference_cycles[9] input_complete load_data[0]
+ load_data[1] load_data[2] load_data[3] load_ready load_valid
+ no_spike reset result_class[0] result_class[1] start VDD VSS
X_09732_ network.neuron_hid0.IF0.ref_counter\[0\] VSS VSS
+ VDD VDD _01044_ sky130_fd_sc_hd__inv_1
X_09733_ network.neuron_hid1.IF0.ref_counter\[0\] VSS VSS
+ VDD VDD _01128_ sky130_fd_sc_hd__inv_1
X_09734_ network.neuron_hid2.IF0.ref_counter\[0\] VSS VSS
+ VDD VDD _00154_ sky130_fd_sc_hd__inv_1
X_09735_ network.neuron_hid3.IF0.ref_counter\[0\] VSS VSS
+ VDD VDD _00672_ sky130_fd_sc_hd__inv_1
X_09736_ network.neuron_hid4.IF0.ref_counter\[0\] VSS VSS
+ VDD VDD _01220_ sky130_fd_sc_hd__inv_1
X_09737_ network.neuron_hid5.IF0.ref_counter\[0\] VSS VSS
+ VDD VDD _00050_ sky130_fd_sc_hd__inv_1
X_09738_ network.neuron_hid6.IF0.ref_counter\[0\] VSS VSS
+ VDD VDD _00089_ sky130_fd_sc_hd__inv_1
X_09739_ network.neuron_hid7.IF0.ref_counter\[0\] VSS VSS
+ VDD VDD _00684_ sky130_fd_sc_hd__inv_1
X_09740_ network.arbit.counter\[0\] VSS VSS VDD VDD _01024_
+ sky130_fd_sc_hd__inv_1
X_09741_ network.neuron_in066.counter\[1\] VSS VSS VDD VDD
+ _00190_ sky130_fd_sc_hd__inv_1
Xclkload36 clknet_leaf_175_clk_net VSS VSS VDD VDD _unconnected_0
+ sky130_fd_sc_hd__clkbuf_1
X_09743_ state\[0\] VSS VSS VDD VDD _06658_ sky130_fd_sc_hd__inv_1
X_09744_ state\[1\] _06658_ VSS VSS VDD VDD _06659_ sky130_fd_sc_hd__nand2_1
X_09745_ net455 _06659_ VSS VSS VDD VDD _06660_ sky130_fd_sc_hd__nor2_4
Xclkload35 clknet_leaf_174_clk_net VSS VSS VDD VDD _unconnected_1
+ sky130_fd_sc_hd__clkbuf_1
Xclkload34 clknet_leaf_173_clk_net VSS VSS VDD VDD _unconnected_2
+ sky130_fd_sc_hd__clkbuf_1
X_09748_ network.neuron_in159.counter\[2\] VSS VSS VDD VDD
+ _06663_ sky130_fd_sc_hd__inv_1
X_09749_ _06663_ _00694_ VSS VSS VDD VDD _06664_ sky130_fd_sc_hd__nand2_1
X_09750_ network.neuron_in159.counter\[3\] _06664_ VSS VSS
+ VDD VDD _06665_ sky130_fd_sc_hd__or2_2
X_09751_ net358 _06665_ VSS VSS VDD VDD _06666_ sky130_fd_sc_hd__nand2_1
X_09752_ network.in_period\[159\]\[1\] _06666_ VSS VSS VDD
+ VDD _06667_ sky130_fd_sc_hd__nand2_1
X_09753_ _00695_ _06666_ _06667_ VSS VSS VDD VDD _02700_ sky130_fd_sc_hd__o21ai_0
Xclkload33 clknet_leaf_172_clk_net VSS VSS VDD VDD _unconnected_3
+ sky130_fd_sc_hd__clkbuf_1
Xclkload32 clknet_leaf_170_clk_net VSS VSS VDD VDD _unconnected_4
+ sky130_fd_sc_hd__clkbuf_1
Xclkload31 clknet_leaf_169_clk_net VSS VSS VDD VDD _unconnected_5
+ sky130_fd_sc_hd__clkbuf_1
X_09757_ network.neuron_in160.counter\[2\] _01102_ VSS VSS
+ VDD VDD _06671_ sky130_fd_sc_hd__xnor2_1
X_09758_ state\[1\] VSS VSS VDD VDD _06672_ sky130_fd_sc_hd__inv_1
X_09759_ _06672_ state\[0\] net455 VSS VSS VDD VDD _06673_
+ sky130_fd_sc_hd__or3_1
Xclkload30 clknet_leaf_168_clk_net VSS VSS VDD VDD _unconnected_6
+ sky130_fd_sc_hd__clkbuf_1
Xclkload29 clknet_leaf_167_clk_net VSS VSS VDD VDD _unconnected_7
+ sky130_fd_sc_hd__clkbuf_1
Xclkload28 clknet_leaf_150_clk_net VSS VSS VDD VDD _unconnected_8
+ sky130_fd_sc_hd__clkbuf_1
X_09763_ network.neuron_in160.counter\[2\] network.neuron_in160.counter\[3\]
+ VSS VSS VDD VDD _06677_ sky130_fd_sc_hd__nor2_1
X_09764_ net415 _06677_ VSS VSS VDD VDD _06678_ sky130_fd_sc_hd__nor2_1
X_09765_ network.in_period\[160\]\[2\] _06678_ VSS VSS VDD
+ VDD _06679_ sky130_fd_sc_hd__nor2_1
X_09766_ net361 _06671_ _06679_ VSS VSS VDD VDD _02705_ sky130_fd_sc_hd__a21oi_1
X_09767_ network.neuron_in066.counter\[0\] VSS VSS VDD VDD
+ _00189_ sky130_fd_sc_hd__inv_1
X_09768_ network.neuron_in077.counter\[1\] VSS VSS VDD VDD
+ _00109_ sky130_fd_sc_hd__inv_1
X_09769_ network.neuron_in160.counter\[3\] _01102_ VSS VSS
+ VDD VDD _06680_ sky130_fd_sc_hd__nand2b_1
X_09770_ network.neuron_in160.counter\[2\] _06680_ VSS VSS
+ VDD VDD _06681_ sky130_fd_sc_hd__or2_2
X_09771_ net361 _06681_ VSS VSS VDD VDD _06682_ sky130_fd_sc_hd__nand2_1
X_09772_ network.in_period\[160\]\[1\] _06682_ VSS VSS VDD
+ VDD _06683_ sky130_fd_sc_hd__nand2_1
X_09773_ _01103_ _06682_ _06683_ VSS VSS VDD VDD _02704_ sky130_fd_sc_hd__o21ai_0
X_09774_ network.neuron_in161.counter\[3\] _00799_ VSS VSS
+ VDD VDD _06684_ sky130_fd_sc_hd__nand2b_1
X_09775_ network.neuron_in161.counter\[2\] VSS VSS VDD VDD
+ _06685_ sky130_fd_sc_hd__inv_1
X_09776_ _06684_ _06685_ VSS VSS VDD VDD _06686_ sky130_fd_sc_hd__nand2b_1
X_09777_ net346 _06686_ VSS VSS VDD VDD _06687_ sky130_fd_sc_hd__nand2_1
X_09778_ network.in_period\[161\]\[1\] _06687_ VSS VSS VDD
+ VDD _06688_ sky130_fd_sc_hd__nand2_1
X_09779_ _00800_ _06687_ _06688_ VSS VSS VDD VDD _02708_ sky130_fd_sc_hd__o21ai_0
X_09780_ network.neuron_in067.counter\[1\] VSS VSS VDD VDD
+ _00186_ sky130_fd_sc_hd__inv_1
X_09781_ network.neuron_in105.counter\[1\] VSS VSS VDD VDD
+ _00556_ sky130_fd_sc_hd__inv_1
X_09782_ network.neuron_in045.counter\[0\] VSS VSS VDD VDD
+ _00331_ sky130_fd_sc_hd__inv_1
X_09783_ network.neuron_in161.counter\[0\] VSS VSS VDD VDD
+ _00797_ sky130_fd_sc_hd__inv_1
X_09784_ network.in_period\[161\]\[0\] _06687_ VSS VSS VDD
+ VDD _06689_ sky130_fd_sc_hd__nand2_1
X_09785_ network.neuron_in161.counter\[0\] _06687_ _06689_
+ VSS VSS VDD VDD _02707_ sky130_fd_sc_hd__o21ai_0
X_09786_ network.neuron_in162.counter\[3\] _00803_ VSS VSS
+ VDD VDD _06690_ sky130_fd_sc_hd__nand2b_1
X_09787_ network.neuron_in162.counter\[2\] _06690_ VSS VSS
+ VDD VDD _06691_ sky130_fd_sc_hd__or2_2
X_09788_ net361 _06691_ VSS VSS VDD VDD _06692_ sky130_fd_sc_hd__nand2_1
X_09789_ network.in_period\[162\]\[1\] _06692_ VSS VSS VDD
+ VDD _06693_ sky130_fd_sc_hd__nand2_1
X_09790_ _00804_ _06692_ _06693_ VSS VSS VDD VDD _02712_ sky130_fd_sc_hd__o21ai_0
X_09791_ network.neuron_in189.counter\[2\] _00837_ VSS VSS
+ VDD VDD _06694_ sky130_fd_sc_hd__xnor2_1
X_09792_ network.neuron_in189.counter\[2\] network.neuron_in189.counter\[3\]
+ VSS VSS VDD VDD _06695_ sky130_fd_sc_hd__nor2_1
X_09793_ net415 _06695_ VSS VSS VDD VDD _06696_ sky130_fd_sc_hd__nor2_1
X_09794_ network.in_period\[189\]\[2\] _06696_ VSS VSS VDD
+ VDD _06697_ sky130_fd_sc_hd__nor2_1
X_09795_ net363 _06694_ _06697_ VSS VSS VDD VDD _02821_ sky130_fd_sc_hd__a21oi_1
X_09796_ network.neuron_in184.counter\[2\] _01098_ VSS VSS
+ VDD VDD _06698_ sky130_fd_sc_hd__xnor2_1
X_09797_ network.neuron_in184.counter\[2\] network.neuron_in184.counter\[3\]
+ VSS VSS VDD VDD _06699_ sky130_fd_sc_hd__nor2_1
X_09798_ net415 _06699_ VSS VSS VDD VDD _06700_ sky130_fd_sc_hd__nor2_1
X_09799_ network.in_period\[184\]\[2\] _06700_ VSS VSS VDD
+ VDD _06701_ sky130_fd_sc_hd__nor2_1
X_09800_ net362 _06698_ _06701_ VSS VSS VDD VDD _02801_ sky130_fd_sc_hd__a21oi_1
X_09801_ network.neuron_in188.counter\[0\] VSS VSS VDD VDD
+ _01178_ sky130_fd_sc_hd__inv_1
Xclkload27 clknet_leaf_148_clk_net VSS VSS VDD VDD _unconnected_9
+ sky130_fd_sc_hd__clkinv_2
Xclkload26 clknet_leaf_187_clk_net VSS VSS VDD VDD _unconnected_10
+ sky130_fd_sc_hd__clkinv_2
Xclkload25 clknet_leaf_186_clk_net VSS VSS VDD VDD _unconnected_11
+ sky130_fd_sc_hd__clkbuf_8
X_09805_ network.neuron_in188.counter\[3\] _01180_ VSS VSS
+ VDD VDD _06705_ sky130_fd_sc_hd__nand2b_1
X_09806_ network.neuron_in188.counter\[2\] _06705_ VSS VSS
+ VDD VDD _06706_ sky130_fd_sc_hd__or2_2
X_09807_ net363 _06706_ VSS VSS VDD VDD _06707_ sky130_fd_sc_hd__nand2_1
X_09808_ network.in_period\[188\]\[0\] _06707_ VSS VSS VDD
+ VDD _06708_ sky130_fd_sc_hd__nand2_1
X_09809_ network.neuron_in188.counter\[0\] _06707_ _06708_
+ VSS VSS VDD VDD _02815_ sky130_fd_sc_hd__o21ai_0
X_09810_ network.neuron_in112.counter\[0\] VSS VSS VDD VDD
+ _00769_ sky130_fd_sc_hd__inv_1
X_09811_ network.neuron_in181.counter\[3\] _01192_ VSS VSS
+ VDD VDD _06709_ sky130_fd_sc_hd__nand2b_1
X_09812_ network.neuron_in181.counter\[2\] _06709_ VSS VSS
+ VDD VDD _06710_ sky130_fd_sc_hd__or2_2
X_09813_ net361 _06710_ VSS VSS VDD VDD _06711_ sky130_fd_sc_hd__nand2_1
X_09814_ network.in_period\[181\]\[1\] _06711_ VSS VSS VDD
+ VDD _06712_ sky130_fd_sc_hd__nand2_1
X_09815_ _01193_ _06711_ _06712_ VSS VSS VDD VDD _02788_ sky130_fd_sc_hd__o21ai_0
X_09816_ network.neuron_in183.counter\[0\] VSS VSS VDD VDD
+ _00247_ sky130_fd_sc_hd__inv_1
X_09817_ network.neuron_in183.counter\[3\] _00249_ VSS VSS
+ VDD VDD _06713_ sky130_fd_sc_hd__nand2b_1
X_09818_ network.neuron_in183.counter\[2\] _06713_ VSS VSS
+ VDD VDD _06714_ sky130_fd_sc_hd__or2_2
X_09819_ net361 _06714_ VSS VSS VDD VDD _06715_ sky130_fd_sc_hd__nand2_1
X_09820_ network.in_period\[183\]\[0\] _06715_ VSS VSS VDD
+ VDD _06716_ sky130_fd_sc_hd__nand2_1
X_09821_ network.neuron_in183.counter\[0\] _06715_ _06716_
+ VSS VSS VDD VDD _02795_ sky130_fd_sc_hd__o21ai_0
X_09822_ network.neuron_in046.counter\[1\] VSS VSS VDD VDD
+ _00316_ sky130_fd_sc_hd__inv_1
X_09823_ network.neuron_in076.counter\[1\] VSS VSS VDD VDD
+ _00123_ sky130_fd_sc_hd__inv_1
X_09824_ network.neuron_in186.counter\[3\] _01106_ VSS VSS
+ VDD VDD _06717_ sky130_fd_sc_hd__nand2b_1
X_09825_ network.neuron_in186.counter\[2\] _06717_ VSS VSS
+ VDD VDD _06718_ sky130_fd_sc_hd__or2_2
X_09826_ net362 _06718_ VSS VSS VDD VDD _06719_ sky130_fd_sc_hd__nand2_1
X_09827_ network.in_period\[186\]\[1\] _06719_ VSS VSS VDD
+ VDD _06720_ sky130_fd_sc_hd__nand2_1
X_09828_ _01107_ _06719_ _06720_ VSS VSS VDD VDD _02808_ sky130_fd_sc_hd__o21ai_0
X_09829_ network.in_period\[188\]\[1\] _06707_ VSS VSS VDD
+ VDD _06721_ sky130_fd_sc_hd__nand2_1
X_09830_ _01181_ _06707_ _06721_ VSS VSS VDD VDD _02816_ sky130_fd_sc_hd__o21ai_0
X_09831_ network.neuron_in180.counter\[2\] _00988_ VSS VSS
+ VDD VDD _06722_ sky130_fd_sc_hd__xnor2_1
X_09832_ network.neuron_in180.counter\[2\] network.neuron_in180.counter\[3\]
+ VSS VSS VDD VDD _06723_ sky130_fd_sc_hd__nor2_1
X_09833_ net414 _06723_ VSS VSS VDD VDD _06724_ sky130_fd_sc_hd__nor2_1
X_09834_ network.in_period\[180\]\[2\] _06724_ VSS VSS VDD
+ VDD _06725_ sky130_fd_sc_hd__nor2_1
X_09835_ net361 _06722_ _06725_ VSS VSS VDD VDD _02785_ sky130_fd_sc_hd__a21oi_1
X_09836_ network.neuron_in140.counter\[0\] VSS VSS VDD VDD
+ _01088_ sky130_fd_sc_hd__inv_1
X_09837_ network.neuron_in136.counter\[3\] _00762_ VSS VSS
+ VDD VDD _06726_ sky130_fd_sc_hd__nand2b_1
X_09838_ network.neuron_in136.counter\[2\] _06726_ VSS VSS
+ VDD VDD _06727_ sky130_fd_sc_hd__or2_2
X_09839_ net359 _06727_ VSS VSS VDD VDD _06728_ sky130_fd_sc_hd__nand2_1
X_09840_ network.in_period\[136\]\[1\] _06728_ VSS VSS VDD
+ VDD _06729_ sky130_fd_sc_hd__nand2_1
X_09841_ _00763_ _06728_ _06729_ VSS VSS VDD VDD _02608_ sky130_fd_sc_hd__o21ai_0
Xclkload24 clknet_leaf_185_clk_net VSS VSS VDD VDD _unconnected_12
+ sky130_fd_sc_hd__clkinv_2
Xclkload23 clknet_leaf_184_clk_net VSS VSS VDD VDD _unconnected_13
+ sky130_fd_sc_hd__clkbuf_8
X_09844_ network.neuron_in181.counter\[2\] net361 VSS VSS
+ VDD VDD _06732_ sky130_fd_sc_hd__nand2_1
X_09845_ network.in_period\[181\]\[2\] network.neuron_in181.counter\[3\]
+ _06732_ VSS VSS VDD VDD _06733_ sky130_fd_sc_hd__o21ai_0
Xclkload22 clknet_leaf_183_clk_net VSS VSS VDD VDD _unconnected_14
+ sky130_fd_sc_hd__clkbuf_8
X_09847_ _01192_ network.neuron_in181.counter\[2\] net415
+ VSS VSS VDD VDD _06735_ sky130_fd_sc_hd__or3_1
X_09848_ network.in_period\[181\]\[2\] net361 _06735_ VSS
+ VSS VDD VDD _06736_ sky130_fd_sc_hd__o21ai_0
X_09849_ _01192_ _06733_ _06736_ VSS VSS VDD VDD _02789_ sky130_fd_sc_hd__a21oi_1
X_09850_ network.neuron_in182.counter\[3\] _00960_ VSS VSS
+ VDD VDD _06737_ sky130_fd_sc_hd__nand2b_1
X_09851_ network.neuron_in182.counter\[2\] _06737_ VSS VSS
+ VDD VDD _06738_ sky130_fd_sc_hd__or2_2
X_09852_ net362 _06738_ VSS VSS VDD VDD _06739_ sky130_fd_sc_hd__nand2_1
X_09853_ network.in_period\[182\]\[1\] _06739_ VSS VSS VDD
+ VDD _06740_ sky130_fd_sc_hd__nand2_1
X_09854_ _00961_ _06739_ _06740_ VSS VSS VDD VDD _02792_ sky130_fd_sc_hd__o21ai_0
X_09855_ network.in_period\[183\]\[1\] _06715_ VSS VSS VDD
+ VDD _06741_ sky130_fd_sc_hd__nand2_1
X_09856_ _00250_ _06715_ _06741_ VSS VSS VDD VDD _02796_ sky130_fd_sc_hd__o21ai_0
X_09857_ network.arbit.counter\[1\] VSS VSS VDD VDD _01025_
+ sky130_fd_sc_hd__inv_1
X_09858_ network.neuron_in075.counter\[1\] VSS VSS VDD VDD
+ _00131_ sky130_fd_sc_hd__inv_1
X_09859_ network.neuron_in185.counter\[2\] _00277_ VSS VSS
+ VDD VDD _06742_ sky130_fd_sc_hd__xnor2_1
X_09860_ network.neuron_in185.counter\[2\] network.neuron_in185.counter\[3\]
+ VSS VSS VDD VDD _06743_ sky130_fd_sc_hd__nor2_1
X_09861_ net415 _06743_ VSS VSS VDD VDD _06744_ sky130_fd_sc_hd__nor2_1
X_09862_ network.in_period\[185\]\[2\] _06744_ VSS VSS VDD
+ VDD _06745_ sky130_fd_sc_hd__nor2_1
X_09863_ net362 _06742_ _06745_ VSS VSS VDD VDD _02805_ sky130_fd_sc_hd__a21oi_1
X_09864_ network.neuron_in186.counter\[2\] _01106_ VSS VSS
+ VDD VDD _06746_ sky130_fd_sc_hd__xnor2_1
X_09865_ network.neuron_in186.counter\[2\] network.neuron_in186.counter\[3\]
+ VSS VSS VDD VDD _06747_ sky130_fd_sc_hd__nor2_1
X_09866_ net415 _06747_ VSS VSS VDD VDD _06748_ sky130_fd_sc_hd__nor2_1
X_09867_ network.in_period\[186\]\[2\] _06748_ VSS VSS VDD
+ VDD _06749_ sky130_fd_sc_hd__nor2_1
X_09868_ net362 _06746_ _06749_ VSS VSS VDD VDD _02809_ sky130_fd_sc_hd__a21oi_1
X_09869_ network.neuron_in187.counter\[3\] _00980_ VSS VSS
+ VDD VDD _06750_ sky130_fd_sc_hd__nand2b_1
X_09870_ network.neuron_in187.counter\[2\] VSS VSS VDD VDD
+ _06751_ sky130_fd_sc_hd__inv_1
X_09871_ _06750_ _06751_ VSS VSS VDD VDD _06752_ sky130_fd_sc_hd__nand2b_1
X_09872_ net363 _06752_ VSS VSS VDD VDD _06753_ sky130_fd_sc_hd__nand2_1
X_09873_ network.in_period\[187\]\[1\] _06753_ VSS VSS VDD
+ VDD _06754_ sky130_fd_sc_hd__nand2_1
X_09874_ _00981_ _06753_ _06754_ VSS VSS VDD VDD _02812_ sky130_fd_sc_hd__o21ai_0
X_09875_ network.neuron_in067.counter\[0\] VSS VSS VDD VDD
+ _00185_ sky130_fd_sc_hd__inv_1
X_09876_ network.neuron_in236.counter\[0\] VSS VSS VDD VDD
+ _00559_ sky130_fd_sc_hd__inv_1
X_09877_ network.neuron_in073.counter\[1\] VSS VSS VDD VDD
+ _00138_ sky130_fd_sc_hd__inv_1
X_09878_ network.neuron_in216.counter\[1\] VSS VSS VDD VDD
+ _00510_ sky130_fd_sc_hd__inv_1
X_09879_ network.neuron_in140.counter\[2\] _01090_ VSS VSS
+ VDD VDD _06755_ sky130_fd_sc_hd__nand2b_1
X_09880_ network.neuron_in140.counter\[3\] _06755_ VSS VSS
+ VDD VDD _06756_ sky130_fd_sc_hd__or2_2
X_09881_ net352 _06756_ VSS VSS VDD VDD _06757_ sky130_fd_sc_hd__nand2_1
X_09882_ network.in_period\[140\]\[1\] _06757_ VSS VSS VDD
+ VDD _06758_ sky130_fd_sc_hd__nand2_1
X_09883_ _01091_ _06757_ _06758_ VSS VSS VDD VDD _02624_ sky130_fd_sc_hd__o21ai_0
X_09884_ network.neuron_in074.counter\[1\] VSS VSS VDD VDD
+ _00127_ sky130_fd_sc_hd__inv_1
X_09885_ network.neuron_in143.counter\[1\] VSS VSS VDD VDD
+ _00757_ sky130_fd_sc_hd__inv_1
X_09886_ network.neuron_in162.counter\[2\] _00803_ VSS VSS
+ VDD VDD _06759_ sky130_fd_sc_hd__xnor2_1
Xclkload21 clknet_leaf_181_clk_net VSS VSS VDD VDD _unconnected_15
+ sky130_fd_sc_hd__clkinv_1
X_09888_ network.neuron_in162.counter\[2\] network.neuron_in162.counter\[3\]
+ VSS VSS VDD VDD _06761_ sky130_fd_sc_hd__nor2_1
X_09889_ net415 _06761_ VSS VSS VDD VDD _06762_ sky130_fd_sc_hd__nor2_1
X_09890_ network.in_period\[162\]\[2\] _06762_ VSS VSS VDD
+ VDD _06763_ sky130_fd_sc_hd__nor2_1
X_09891_ net361 _06759_ _06763_ VSS VSS VDD VDD _02713_ sky130_fd_sc_hd__a21oi_1
Xclkload20 clknet_leaf_180_clk_net VSS VSS VDD VDD _unconnected_16
+ sky130_fd_sc_hd__clkbuf_1
X_09893_ network.neuron_in188.counter\[2\] _01180_ VSS VSS
+ VDD VDD _06765_ sky130_fd_sc_hd__xnor2_1
X_09894_ network.neuron_in188.counter\[2\] network.neuron_in188.counter\[3\]
+ VSS VSS VDD VDD _06766_ sky130_fd_sc_hd__nor2_1
X_09895_ net415 _06766_ VSS VSS VDD VDD _06767_ sky130_fd_sc_hd__nor2_1
X_09896_ network.in_period\[188\]\[2\] _06767_ VSS VSS VDD
+ VDD _06768_ sky130_fd_sc_hd__nor2_1
X_09897_ net363 _06765_ _06768_ VSS VSS VDD VDD _02817_ sky130_fd_sc_hd__a21oi_1
X_09898_ network.neuron_in179.counter\[3\] _00219_ VSS VSS
+ VDD VDD _06769_ sky130_fd_sc_hd__nand2b_1
X_09899_ network.neuron_in179.counter\[2\] VSS VSS VDD VDD
+ _06770_ sky130_fd_sc_hd__inv_1
X_09900_ _06769_ _06770_ VSS VSS VDD VDD _06771_ sky130_fd_sc_hd__nand2b_1
X_09901_ net363 _06771_ VSS VSS VDD VDD _06772_ sky130_fd_sc_hd__nand2_1
X_09902_ network.in_period\[179\]\[1\] _06772_ VSS VSS VDD
+ VDD _06773_ sky130_fd_sc_hd__nand2_1
X_09903_ _00220_ _06772_ _06773_ VSS VSS VDD VDD _02780_ sky130_fd_sc_hd__o21ai_0
X_09904_ network.neuron_in065.counter\[1\] VSS VSS VDD VDD
+ _00196_ sky130_fd_sc_hd__inv_1
X_09905_ network.neuron_in250.counter\[1\] VSS VSS VDD VDD
+ _01085_ sky130_fd_sc_hd__inv_1
X_09906_ network.neuron_in179.counter\[0\] VSS VSS VDD VDD
+ _00217_ sky130_fd_sc_hd__inv_1
X_09907_ network.in_period\[179\]\[0\] _06772_ VSS VSS VDD
+ VDD _06774_ sky130_fd_sc_hd__nand2_1
X_09908_ network.neuron_in179.counter\[0\] _06772_ _06774_
+ VSS VSS VDD VDD _02779_ sky130_fd_sc_hd__o21ai_0
X_09909_ network.neuron_in180.counter\[3\] _00988_ VSS VSS
+ VDD VDD _06775_ sky130_fd_sc_hd__nand2b_1
X_09910_ network.neuron_in180.counter\[2\] _06775_ VSS VSS
+ VDD VDD _06776_ sky130_fd_sc_hd__or2_2
X_09911_ net361 _06776_ VSS VSS VDD VDD _06777_ sky130_fd_sc_hd__nand2_1
X_09912_ network.in_period\[180\]\[1\] _06777_ VSS VSS VDD
+ VDD _06778_ sky130_fd_sc_hd__nand2_1
X_09913_ _00989_ _06777_ _06778_ VSS VSS VDD VDD _02784_ sky130_fd_sc_hd__o21ai_0
X_09914_ network.neuron_in152.counter\[0\] VSS VSS VDD VDD
+ _00563_ sky130_fd_sc_hd__inv_1
X_09915_ network.neuron_in071.counter\[1\] VSS VSS VDD VDD
+ _00148_ sky130_fd_sc_hd__inv_1
X_09916_ network.neuron_in159.counter\[0\] VSS VSS VDD VDD
+ _00692_ sky130_fd_sc_hd__inv_1
X_09917_ network.in_period\[159\]\[0\] _06666_ VSS VSS VDD
+ VDD _06779_ sky130_fd_sc_hd__nand2_1
X_09918_ network.neuron_in159.counter\[0\] _06666_ _06779_
+ VSS VSS VDD VDD _02699_ sky130_fd_sc_hd__o21ai_0
X_09919_ network.neuron_in046.counter\[0\] VSS VSS VDD VDD
+ _00315_ sky130_fd_sc_hd__inv_1
X_09920_ network.neuron_in078.counter\[1\] VSS VSS VDD VDD
+ _00103_ sky130_fd_sc_hd__inv_1
X_09921_ network.neuron_in231.counter\[0\] VSS VSS VDD VDD
+ _00730_ sky130_fd_sc_hd__inv_1
X_09922_ network.neuron_in144.counter\[0\] VSS VSS VDD VDD
+ _00706_ sky130_fd_sc_hd__inv_1
X_09923_ network.neuron_in196.counter\[1\] VSS VSS VDD VDD
+ _00727_ sky130_fd_sc_hd__inv_1
X_09924_ network.neuron_in094.counter\[1\] VSS VSS VDD VDD
+ _01233_ sky130_fd_sc_hd__inv_1
X_09925_ network.neuron_in140.counter\[1\] VSS VSS VDD VDD
+ _01089_ sky130_fd_sc_hd__inv_1
X_09926_ network.neuron_in180.counter\[0\] VSS VSS VDD VDD
+ _00986_ sky130_fd_sc_hd__inv_1
X_09927_ network.in_period\[180\]\[0\] _06777_ VSS VSS VDD
+ VDD _06780_ sky130_fd_sc_hd__nand2_1
X_09928_ network.neuron_in180.counter\[0\] _06777_ _06780_
+ VSS VSS VDD VDD _02783_ sky130_fd_sc_hd__o21ai_0
X_09929_ network.neuron_in093.counter\[0\] VSS VSS VDD VDD
+ _01228_ sky130_fd_sc_hd__inv_1
X_09930_ network.neuron_in070.counter\[1\] VSS VSS VDD VDD
+ _00163_ sky130_fd_sc_hd__inv_1
X_09931_ network.neuron_in006.counter\[1\] VSS VSS VDD VDD
+ _00739_ sky130_fd_sc_hd__inv_1
X_09932_ network.neuron_in205.counter\[1\] VSS VSS VDD VDD
+ _00312_ sky130_fd_sc_hd__inv_1
X_09933_ network.neuron_in250.counter\[0\] VSS VSS VDD VDD
+ _01084_ sky130_fd_sc_hd__inv_1
X_09934_ network.neuron_in152.counter\[1\] VSS VSS VDD VDD
+ _00564_ sky130_fd_sc_hd__inv_1
X_09935_ network.neuron_in069.counter\[1\] VSS VSS VDD VDD
+ _00169_ sky130_fd_sc_hd__inv_1
X_09936_ network.neuron_in181.counter\[0\] VSS VSS VDD VDD
+ _01190_ sky130_fd_sc_hd__inv_1
X_09937_ network.in_period\[181\]\[0\] _06711_ VSS VSS VDD
+ VDD _06781_ sky130_fd_sc_hd__nand2_1
X_09938_ network.neuron_in181.counter\[0\] _06711_ _06781_
+ VSS VSS VDD VDD _02787_ sky130_fd_sc_hd__o21ai_0
X_09939_ network.neuron_in182.counter\[2\] _00960_ VSS VSS
+ VDD VDD _06782_ sky130_fd_sc_hd__xnor2_1
X_09940_ network.neuron_in182.counter\[2\] network.neuron_in182.counter\[3\]
+ VSS VSS VDD VDD _06783_ sky130_fd_sc_hd__nor2_1
X_09941_ net415 _06783_ VSS VSS VDD VDD _06784_ sky130_fd_sc_hd__nor2_1
X_09942_ network.in_period\[182\]\[2\] _06784_ VSS VSS VDD
+ VDD _06785_ sky130_fd_sc_hd__nor2_1
X_09943_ net362 _06782_ _06785_ VSS VSS VDD VDD _02793_ sky130_fd_sc_hd__a21oi_1
X_09944_ network.neuron_in182.counter\[0\] VSS VSS VDD VDD
+ _00958_ sky130_fd_sc_hd__inv_1
X_09945_ network.in_period\[182\]\[0\] _06739_ VSS VSS VDD
+ VDD _06786_ sky130_fd_sc_hd__nand2_1
X_09946_ network.neuron_in182.counter\[0\] _06739_ _06786_
+ VSS VSS VDD VDD _02791_ sky130_fd_sc_hd__o21ai_0
X_09947_ network.neuron_in183.counter\[2\] _00249_ VSS VSS
+ VDD VDD _06787_ sky130_fd_sc_hd__xnor2_1
X_09948_ network.neuron_in183.counter\[2\] network.neuron_in183.counter\[3\]
+ VSS VSS VDD VDD _06788_ sky130_fd_sc_hd__nor2_1
X_09949_ net415 _06788_ VSS VSS VDD VDD _06789_ sky130_fd_sc_hd__nor2_1
X_09950_ network.in_period\[183\]\[2\] _06789_ VSS VSS VDD
+ VDD _06790_ sky130_fd_sc_hd__nor2_1
X_09951_ net361 _06787_ _06790_ VSS VSS VDD VDD _02797_ sky130_fd_sc_hd__a21oi_1
Xclkload19 clknet_leaf_178_clk_net VSS VSS VDD VDD _unconnected_17
+ sky130_fd_sc_hd__clkinv_2
X_09953_ network.neuron_in184.counter\[3\] _01098_ VSS VSS
+ VDD VDD _06792_ sky130_fd_sc_hd__nand2b_1
X_09954_ network.neuron_in184.counter\[2\] _06792_ VSS VSS
+ VDD VDD _06793_ sky130_fd_sc_hd__or2_2
X_09955_ net362 _06793_ VSS VSS VDD VDD _06794_ sky130_fd_sc_hd__nand2_1
X_09956_ network.in_period\[184\]\[1\] _06794_ VSS VSS VDD
+ VDD _06795_ sky130_fd_sc_hd__nand2_1
X_09957_ _01099_ _06794_ _06795_ VSS VSS VDD VDD _02800_ sky130_fd_sc_hd__o21ai_0
X_09958_ network.neuron_in068.counter\[1\] VSS VSS VDD VDD
+ _00173_ sky130_fd_sc_hd__inv_1
X_09959_ network.neuron_in184.counter\[0\] VSS VSS VDD VDD
+ _01096_ sky130_fd_sc_hd__inv_1
X_09960_ network.in_period\[184\]\[0\] _06794_ VSS VSS VDD
+ VDD _06796_ sky130_fd_sc_hd__nand2_1
X_09961_ network.neuron_in184.counter\[0\] _06794_ _06796_
+ VSS VSS VDD VDD _02799_ sky130_fd_sc_hd__o21ai_0
X_09962_ network.neuron_in185.counter\[3\] _00277_ VSS VSS
+ VDD VDD _06797_ sky130_fd_sc_hd__nand2b_1
X_09963_ network.neuron_in185.counter\[2\] _06797_ VSS VSS
+ VDD VDD _06798_ sky130_fd_sc_hd__or2_2
X_09964_ net362 _06798_ VSS VSS VDD VDD _06799_ sky130_fd_sc_hd__nand2_1
X_09965_ network.in_period\[185\]\[1\] _06799_ VSS VSS VDD
+ VDD _06800_ sky130_fd_sc_hd__nand2_1
X_09966_ _00278_ _06799_ _06800_ VSS VSS VDD VDD _02804_ sky130_fd_sc_hd__o21ai_0
X_09967_ network.neuron_in209.counter\[1\] VSS VSS VDD VDD
+ _01171_ sky130_fd_sc_hd__inv_1
X_09968_ network.neuron_in243.counter\[0\] VSS VSS VDD VDD
+ _00567_ sky130_fd_sc_hd__inv_1
X_09969_ network.neuron_in185.counter\[0\] VSS VSS VDD VDD
+ _00275_ sky130_fd_sc_hd__inv_1
X_09970_ network.in_period\[185\]\[0\] _06799_ VSS VSS VDD
+ VDD _06801_ sky130_fd_sc_hd__nand2_1
X_09971_ network.neuron_in185.counter\[0\] _06799_ _06801_
+ VSS VSS VDD VDD _02803_ sky130_fd_sc_hd__o21ai_0
X_09972_ network.neuron_in186.counter\[0\] VSS VSS VDD VDD
+ _01104_ sky130_fd_sc_hd__inv_1
X_09973_ network.in_period\[186\]\[0\] _06719_ VSS VSS VDD
+ VDD _06802_ sky130_fd_sc_hd__nand2_1
X_09974_ network.neuron_in186.counter\[0\] _06719_ _06802_
+ VSS VSS VDD VDD _02807_ sky130_fd_sc_hd__o21ai_0
X_09975_ network.neuron_in156.counter\[1\] VSS VSS VDD VDD
+ _01081_ sky130_fd_sc_hd__inv_1
Xclkload18 clknet_leaf_177_clk_net VSS VSS VDD VDD _unconnected_18
+ sky130_fd_sc_hd__clkbuf_8
Xclkload17 clknet_leaf_3_clk_net VSS VSS VDD VDD _unconnected_19
+ sky130_fd_sc_hd__clkbuf_8
X_09978_ network.neuron_in187.counter\[3\] network.in_period\[187\]\[2\]
+ _00980_ net415 VSS VSS VDD VDD _06805_ sky130_fd_sc_hd__o22ai_1
Xclkload16 clknet_leaf_2_clk_net VSS VSS VDD VDD _unconnected_20
+ sky130_fd_sc_hd__clkbuf_1
Xclkload15 clknet_leaf_1_clk_net VSS VSS VDD VDD _unconnected_21
+ sky130_fd_sc_hd__clkinv_2
X_09981_ network.neuron_in187.counter\[2\] _00980_ net363
+ VSS VSS VDD VDD _06808_ sky130_fd_sc_hd__nand3_1
X_09982_ network.in_period\[187\]\[2\] net363 _06808_ VSS
+ VSS VDD VDD _06809_ sky130_fd_sc_hd__o21ai_0
X_09983_ _06751_ _06805_ _06809_ VSS VSS VDD VDD _02813_ sky130_fd_sc_hd__a21oi_1
X_09984_ network.neuron_in187.counter\[0\] VSS VSS VDD VDD
+ _00978_ sky130_fd_sc_hd__inv_1
X_09985_ network.in_period\[187\]\[0\] _06753_ VSS VSS VDD
+ VDD _06810_ sky130_fd_sc_hd__nand2_1
X_09986_ network.neuron_in187.counter\[0\] _06753_ _06810_
+ VSS VSS VDD VDD _02811_ sky130_fd_sc_hd__o21ai_0
X_09987_ network.neuron_in199.counter\[2\] _01156_ VSS VSS
+ VDD VDD _06811_ sky130_fd_sc_hd__xnor2_1
X_09988_ network.neuron_in199.counter\[2\] network.neuron_in199.counter\[3\]
+ VSS VSS VDD VDD _06812_ sky130_fd_sc_hd__nor2_1
X_09989_ net426 _06812_ VSS VSS VDD VDD _06813_ sky130_fd_sc_hd__nor2_1
X_09990_ network.in_period\[199\]\[2\] _06813_ VSS VSS VDD
+ VDD _06814_ sky130_fd_sc_hd__nor2_1
X_09991_ net344 _06811_ _06814_ VSS VSS VDD VDD _02861_ sky130_fd_sc_hd__a21oi_1
X_09992_ network.neuron_in194.counter\[2\] _00289_ VSS VSS
+ VDD VDD _06815_ sky130_fd_sc_hd__xnor2_1
X_09993_ network.neuron_in194.counter\[2\] network.neuron_in194.counter\[3\]
+ VSS VSS VDD VDD _06816_ sky130_fd_sc_hd__nor2_1
X_09994_ net417 _06816_ VSS VSS VDD VDD _06817_ sky130_fd_sc_hd__nor2_1
X_09995_ network.in_period\[194\]\[2\] _06817_ VSS VSS VDD
+ VDD _06818_ sky130_fd_sc_hd__nor2_1
X_09996_ net366 _06815_ _06818_ VSS VSS VDD VDD _02841_ sky130_fd_sc_hd__a21oi_1
X_09997_ network.neuron_in137.counter\[3\] _00724_ VSS VSS
+ VDD VDD _06819_ sky130_fd_sc_hd__nand2b_1
X_09998_ network.neuron_in137.counter\[2\] VSS VSS VDD VDD
+ _06820_ sky130_fd_sc_hd__inv_1
X_09999_ _06819_ _06820_ VSS VSS VDD VDD _06821_ sky130_fd_sc_hd__nand2b_1
X_10000_ net352 _06821_ VSS VSS VDD VDD _06822_ sky130_fd_sc_hd__nand2_1
X_10001_ network.in_period\[137\]\[1\] _06822_ VSS VSS VDD
+ VDD _06823_ sky130_fd_sc_hd__nand2_1
X_10002_ _00725_ _06822_ _06823_ VSS VSS VDD VDD _02612_ sky130_fd_sc_hd__o21ai_0
X_10003_ network.neuron_in198.counter\[0\] VSS VSS VDD VDD
+ _00379_ sky130_fd_sc_hd__inv_1
X_10004_ network.neuron_in198.counter\[3\] _00381_ VSS VSS
+ VDD VDD _06824_ sky130_fd_sc_hd__nand2b_1
X_10005_ network.neuron_in198.counter\[2\] _06824_ VSS VSS
+ VDD VDD _06825_ sky130_fd_sc_hd__or2_2
X_10006_ net366 _06825_ VSS VSS VDD VDD _06826_ sky130_fd_sc_hd__nand2_1
X_10007_ network.in_period\[198\]\[0\] _06826_ VSS VSS VDD
+ VDD _06827_ sky130_fd_sc_hd__nand2_1
X_10008_ network.neuron_in198.counter\[0\] _06826_ _06827_
+ VSS VSS VDD VDD _02855_ sky130_fd_sc_hd__o21ai_0
X_10009_ network.neuron_in079.counter\[0\] VSS VSS VDD VDD
+ _00094_ sky130_fd_sc_hd__inv_1
X_10010_ network.neuron_in191.counter\[3\] _00976_ VSS VSS
+ VDD VDD _06828_ sky130_fd_sc_hd__nand2b_1
X_10011_ network.neuron_in191.counter\[2\] VSS VSS VDD VDD
+ _06829_ sky130_fd_sc_hd__inv_1
X_10012_ _06828_ _06829_ VSS VSS VDD VDD _06830_ sky130_fd_sc_hd__nand2b_1
X_10013_ net363 _06830_ VSS VSS VDD VDD _06831_ sky130_fd_sc_hd__nand2_1
X_10014_ network.in_period\[191\]\[1\] _06831_ VSS VSS VDD
+ VDD _06832_ sky130_fd_sc_hd__nand2_1
X_10015_ _00977_ _06831_ _06832_ VSS VSS VDD VDD _02828_ sky130_fd_sc_hd__o21ai_0
X_10016_ network.neuron_in155.counter\[3\] _01118_ VSS VSS
+ VDD VDD _06833_ sky130_fd_sc_hd__nand2b_1
X_10017_ network.neuron_in155.counter\[2\] VSS VSS VDD VDD
+ _06834_ sky130_fd_sc_hd__inv_1
X_10018_ _06833_ _06834_ VSS VSS VDD VDD _06835_ sky130_fd_sc_hd__nand2b_1
X_10019_ net358 _06835_ VSS VSS VDD VDD _06836_ sky130_fd_sc_hd__nand2_1
X_10020_ network.in_period\[155\]\[1\] _06836_ VSS VSS VDD
+ VDD _06837_ sky130_fd_sc_hd__nand2_1
X_10021_ _01119_ _06836_ _06837_ VSS VSS VDD VDD _02684_ sky130_fd_sc_hd__o21ai_0
X_10022_ network.neuron_in193.counter\[0\] VSS VSS VDD VDD
+ _00970_ sky130_fd_sc_hd__inv_1
X_10023_ network.neuron_in193.counter\[3\] _00972_ VSS VSS
+ VDD VDD _06838_ sky130_fd_sc_hd__nand2b_1
X_10024_ network.neuron_in193.counter\[2\] VSS VSS VDD VDD
+ _06839_ sky130_fd_sc_hd__inv_1
X_10025_ _06838_ _06839_ VSS VSS VDD VDD _06840_ sky130_fd_sc_hd__nand2b_1
X_10026_ net360 _06840_ VSS VSS VDD VDD _06841_ sky130_fd_sc_hd__nand2_1
X_10027_ network.in_period\[193\]\[0\] _06841_ VSS VSS VDD
+ VDD _06842_ sky130_fd_sc_hd__nand2_1
X_10028_ network.neuron_in193.counter\[0\] _06841_ _06842_
+ VSS VSS VDD VDD _02835_ sky130_fd_sc_hd__o21ai_0
X_10029_ network.neuron_in068.counter\[0\] VSS VSS VDD VDD
+ _00172_ sky130_fd_sc_hd__inv_1
X_10030_ network.neuron_in196.counter\[2\] network.neuron_in196.counter\[3\]
+ VSS VSS VDD VDD _06843_ sky130_fd_sc_hd__nor2_1
X_10031_ _00728_ _06843_ VSS VSS VDD VDD _06844_ sky130_fd_sc_hd__nand2_1
X_10032_ net365 _06844_ VSS VSS VDD VDD _06845_ sky130_fd_sc_hd__nand2_1
X_10033_ network.in_period\[196\]\[1\] _06845_ VSS VSS VDD
+ VDD _06846_ sky130_fd_sc_hd__nand2_1
X_10034_ _00729_ _06845_ _06846_ VSS VSS VDD VDD _02848_ sky130_fd_sc_hd__o21ai_0
X_10035_ network.in_period\[198\]\[1\] _06826_ VSS VSS VDD
+ VDD _06847_ sky130_fd_sc_hd__nand2_1
X_10036_ _00382_ _06826_ _06847_ VSS VSS VDD VDD _02856_ sky130_fd_sc_hd__o21ai_0
X_10037_ network.neuron_in190.counter\[2\] VSS VSS VDD VDD
+ _06848_ sky130_fd_sc_hd__inv_1
X_10038_ network.neuron_in190.counter\[3\] network.in_period\[190\]\[2\]
+ _00285_ net415 VSS VSS VDD VDD _06849_ sky130_fd_sc_hd__o22ai_1
Xclkload14 clknet_leaf_0_clk_net VSS VSS VDD VDD _unconnected_22
+ sky130_fd_sc_hd__clkinv_2
Xclkload13 clknet_4_15__leaf_clk_net VSS VSS VDD VDD _unconnected_23
+ sky130_fd_sc_hd__inv_6
X_10041_ network.neuron_in190.counter\[2\] _00285_ net363
+ VSS VSS VDD VDD _06852_ sky130_fd_sc_hd__nand3_1
X_10042_ network.in_period\[190\]\[2\] net363 _06852_ VSS
+ VSS VDD VDD _06853_ sky130_fd_sc_hd__o21ai_0
X_10043_ _06848_ _06849_ _06853_ VSS VSS VDD VDD _02825_ sky130_fd_sc_hd__a21oi_1
X_10044_ network.neuron_in191.counter\[3\] network.in_period\[191\]\[2\]
+ _00976_ net415 VSS VSS VDD VDD _06854_ sky130_fd_sc_hd__o22ai_1
X_10045_ network.neuron_in191.counter\[2\] _00976_ net363
+ VSS VSS VDD VDD _06855_ sky130_fd_sc_hd__nand3_1
X_10046_ network.in_period\[191\]\[2\] net363 _06855_ VSS
+ VSS VDD VDD _06856_ sky130_fd_sc_hd__o21ai_0
X_10047_ _06829_ _06854_ _06856_ VSS VSS VDD VDD _02829_ sky130_fd_sc_hd__a21oi_1
X_10048_ network.neuron_in192.counter\[3\] _01126_ VSS VSS
+ VDD VDD _06857_ sky130_fd_sc_hd__nand2b_1
X_10049_ network.neuron_in192.counter\[2\] VSS VSS VDD VDD
+ _06858_ sky130_fd_sc_hd__inv_1
X_10050_ _06857_ _06858_ VSS VSS VDD VDD _06859_ sky130_fd_sc_hd__nand2b_1
X_10051_ net360 _06859_ VSS VSS VDD VDD _06860_ sky130_fd_sc_hd__nand2_1
X_10052_ network.in_period\[192\]\[1\] _06860_ VSS VSS VDD
+ VDD _06861_ sky130_fd_sc_hd__nand2_1
X_10053_ _01127_ _06860_ _06861_ VSS VSS VDD VDD _02832_ sky130_fd_sc_hd__o21ai_0
X_10054_ network.in_period\[193\]\[1\] _06841_ VSS VSS VDD
+ VDD _06862_ sky130_fd_sc_hd__nand2_1
X_10055_ _00973_ _06841_ _06862_ VSS VSS VDD VDD _02836_ sky130_fd_sc_hd__o21ai_0
X_10056_ network.neuron_in195.counter\[2\] _00377_ VSS VSS
+ VDD VDD _06863_ sky130_fd_sc_hd__xnor2_1
X_10057_ network.neuron_in195.counter\[2\] network.neuron_in195.counter\[3\]
+ VSS VSS VDD VDD _06864_ sky130_fd_sc_hd__nor2_1
X_10058_ net426 _06864_ VSS VSS VDD VDD _06865_ sky130_fd_sc_hd__nor2_1
X_10059_ network.in_period\[195\]\[2\] _06865_ VSS VSS VDD
+ VDD _06866_ sky130_fd_sc_hd__nor2_1
X_10060_ net366 _06863_ _06866_ VSS VSS VDD VDD _02845_ sky130_fd_sc_hd__a21oi_1
X_10061_ network.neuron_in160.counter\[0\] VSS VSS VDD VDD
+ _01100_ sky130_fd_sc_hd__inv_1
X_10062_ network.in_period\[160\]\[0\] _06682_ VSS VSS VDD
+ VDD _06867_ sky130_fd_sc_hd__nand2_1
X_10063_ network.neuron_in160.counter\[0\] _06682_ _06867_
+ VSS VSS VDD VDD _02703_ sky130_fd_sc_hd__o21ai_0
X_10064_ network.neuron_in243.counter\[1\] VSS VSS VDD VDD
+ _00568_ sky130_fd_sc_hd__inv_1
X_10065_ network.neuron_in156.counter\[0\] VSS VSS VDD VDD
+ _01080_ sky130_fd_sc_hd__inv_1
Xclkload12 clknet_4_14__leaf_clk_net VSS VSS VDD VDD _unconnected_24
+ sky130_fd_sc_hd__inv_6
X_10067_ net417 _06843_ VSS VSS VDD VDD _06869_ sky130_fd_sc_hd__nor2_1
X_10068_ network.neuron_in196.counter\[2\] _00728_ VSS VSS
+ VDD VDD _06870_ sky130_fd_sc_hd__xnor2_1
Xclkload11 clknet_4_13__leaf_clk_net VSS VSS VDD VDD _unconnected_25
+ sky130_fd_sc_hd__clkbuf_16
Xclkload10 clknet_4_9__leaf_clk_net VSS VSS VDD VDD _unconnected_26
+ sky130_fd_sc_hd__inv_6
X_10071_ network.in_period\[196\]\[2\] _06869_ _06870_ net365
+ VSS VSS VDD VDD _02849_ sky130_fd_sc_hd__a2bb2oi_1
X_10072_ network.neuron_in197.counter\[2\] _00833_ VSS VSS
+ VDD VDD _06873_ sky130_fd_sc_hd__xnor2_1
X_10073_ network.neuron_in197.counter\[2\] network.neuron_in197.counter\[3\]
+ VSS VSS VDD VDD _06874_ sky130_fd_sc_hd__nor2_1
X_10074_ net426 _06874_ VSS VSS VDD VDD _06875_ sky130_fd_sc_hd__nor2_1
X_10075_ network.in_period\[197\]\[2\] _06875_ VSS VSS VDD
+ VDD _06876_ sky130_fd_sc_hd__nor2_1
X_10076_ net366 _06873_ _06876_ VSS VSS VDD VDD _02853_ sky130_fd_sc_hd__a21oi_1
X_10077_ network.neuron_in121.counter\[1\] VSS VSS VDD VDD
+ _00640_ sky130_fd_sc_hd__inv_1
X_10078_ network.neuron_in205.counter\[0\] VSS VSS VDD VDD
+ _00311_ sky130_fd_sc_hd__inv_1
X_10079_ network.neuron_in174.counter\[1\] VSS VSS VDD VDD
+ _00328_ sky130_fd_sc_hd__inv_1
X_10080_ network.neuron_in064.counter\[1\] VSS VSS VDD VDD
+ _00202_ sky130_fd_sc_hd__inv_1
X_10081_ network.neuron_in061.counter\[1\] VSS VSS VDD VDD
+ _00636_ sky130_fd_sc_hd__inv_1
X_10082_ network.neuron_in060.counter\[1\] VSS VSS VDD VDD
+ _00210_ sky130_fd_sc_hd__inv_1
X_10083_ network.neuron_in151.counter\[1\] VSS VSS VDD VDD
+ _00572_ sky130_fd_sc_hd__inv_1
X_10084_ network.neuron_in206.counter\[1\] VSS VSS VDD VDD
+ _00308_ sky130_fd_sc_hd__inv_1
X_10085_ network.neuron_in179.counter\[1\] VSS VSS VDD VDD
+ _00218_ sky130_fd_sc_hd__inv_1
X_10086_ network.neuron_in030.counter\[1\] VSS VSS VDD VDD
+ _00482_ sky130_fd_sc_hd__inv_1
X_10087_ network.neuron_in198.counter\[2\] _00381_ VSS VSS
+ VDD VDD _06877_ sky130_fd_sc_hd__xnor2_1
X_10088_ network.neuron_in198.counter\[2\] network.neuron_in198.counter\[3\]
+ VSS VSS VDD VDD _06878_ sky130_fd_sc_hd__nor2_1
X_10089_ net426 _06878_ VSS VSS VDD VDD _06879_ sky130_fd_sc_hd__nor2_1
X_10090_ network.in_period\[198\]\[2\] _06879_ VSS VSS VDD
+ VDD _06880_ sky130_fd_sc_hd__nor2_1
X_10091_ net366 _06877_ _06880_ VSS VSS VDD VDD _02857_ sky130_fd_sc_hd__a21oi_1
X_10092_ network.neuron_in189.counter\[3\] _00837_ VSS VSS
+ VDD VDD _06881_ sky130_fd_sc_hd__nand2b_1
X_10093_ network.neuron_in189.counter\[2\] _06881_ VSS VSS
+ VDD VDD _06882_ sky130_fd_sc_hd__or2_2
X_10094_ net363 _06882_ VSS VSS VDD VDD _06883_ sky130_fd_sc_hd__nand2_1
X_10095_ network.in_period\[189\]\[1\] _06883_ VSS VSS VDD
+ VDD _06884_ sky130_fd_sc_hd__nand2_1
X_10096_ _00838_ _06883_ _06884_ VSS VSS VDD VDD _02820_ sky130_fd_sc_hd__o21ai_0
X_10097_ network.neuron_in189.counter\[0\] VSS VSS VDD VDD
+ _00835_ sky130_fd_sc_hd__inv_1
X_10098_ network.in_period\[189\]\[0\] _06883_ VSS VSS VDD
+ VDD _06885_ sky130_fd_sc_hd__nand2_1
X_10099_ network.neuron_in189.counter\[0\] _06883_ _06885_
+ VSS VSS VDD VDD _02819_ sky130_fd_sc_hd__o21ai_0
X_10100_ network.neuron_in081.counter\[1\] VSS VSS VDD VDD
+ _00081_ sky130_fd_sc_hd__inv_1
X_10101_ network.neuron_in236.counter\[1\] VSS VSS VDD VDD
+ _00560_ sky130_fd_sc_hd__inv_1
X_10102_ network.neuron_in059.counter\[1\] VSS VSS VDD VDD
+ _00236_ sky130_fd_sc_hd__inv_1
Xclkload9 clknet_4_8__leaf_clk_net VSS VSS VDD VDD _unconnected_27
+ sky130_fd_sc_hd__clkbuf_16
X_10104_ network.neuron_in190.counter\[3\] _00285_ VSS VSS
+ VDD VDD _06887_ sky130_fd_sc_hd__nand2b_1
X_10105_ _06887_ _06848_ VSS VSS VDD VDD _06888_ sky130_fd_sc_hd__nand2b_1
X_10106_ net363 _06888_ VSS VSS VDD VDD _06889_ sky130_fd_sc_hd__nand2_1
X_10107_ network.in_period\[190\]\[1\] _06889_ VSS VSS VDD
+ VDD _06890_ sky130_fd_sc_hd__nand2_1
X_10108_ _00286_ _06889_ _06890_ VSS VSS VDD VDD _02824_ sky130_fd_sc_hd__o21ai_0
X_10109_ network.neuron_in190.counter\[0\] VSS VSS VDD VDD
+ _00283_ sky130_fd_sc_hd__inv_1
X_10110_ network.in_period\[190\]\[0\] _06889_ VSS VSS VDD
+ VDD _06891_ sky130_fd_sc_hd__nand2_1
X_10111_ network.neuron_in190.counter\[0\] _06889_ _06891_
+ VSS VSS VDD VDD _02823_ sky130_fd_sc_hd__o21ai_0
X_10112_ network.neuron_in246.counter\[0\] VSS VSS VDD VDD
+ _00451_ sky130_fd_sc_hd__inv_1
X_10113_ network.neuron_in136.counter\[0\] VSS VSS VDD VDD
+ _00760_ sky130_fd_sc_hd__inv_1
X_10114_ network.in_period\[136\]\[0\] _06728_ VSS VSS VDD
+ VDD _06892_ sky130_fd_sc_hd__nand2_1
X_10115_ network.neuron_in136.counter\[0\] _06728_ _06892_
+ VSS VSS VDD VDD _02607_ sky130_fd_sc_hd__o21ai_0
X_10116_ network.neuron_in191.counter\[0\] VSS VSS VDD VDD
+ _00974_ sky130_fd_sc_hd__inv_1
X_10117_ network.in_period\[191\]\[0\] _06831_ VSS VSS VDD
+ VDD _06893_ sky130_fd_sc_hd__nand2_1
X_10118_ network.neuron_in191.counter\[0\] _06831_ _06893_
+ VSS VSS VDD VDD _02827_ sky130_fd_sc_hd__o21ai_0
X_10119_ network.neuron_in192.counter\[3\] network.in_period\[192\]\[2\]
+ _01126_ net426 VSS VSS VDD VDD _06894_ sky130_fd_sc_hd__o22ai_1
Xclkload8 clknet_4_6__leaf_clk_net VSS VSS VDD VDD _unconnected_28
+ sky130_fd_sc_hd__inv_16
X_10121_ network.neuron_in192.counter\[2\] _01126_ net360
+ VSS VSS VDD VDD _06896_ sky130_fd_sc_hd__nand3_1
X_10122_ network.in_period\[192\]\[2\] net360 _06896_ VSS
+ VSS VDD VDD _06897_ sky130_fd_sc_hd__o21ai_0
X_10123_ _06858_ _06894_ _06897_ VSS VSS VDD VDD _02833_ sky130_fd_sc_hd__a21oi_1
X_10124_ network.neuron_in145.counter\[2\] network.neuron_in145.counter\[3\]
+ VSS VSS VDD VDD _06898_ sky130_fd_sc_hd__nor2_1
X_10125_ _00698_ _06898_ VSS VSS VDD VDD _06899_ sky130_fd_sc_hd__nand2_1
X_10126_ net346 _06899_ VSS VSS VDD VDD _06900_ sky130_fd_sc_hd__nand2_1
X_10127_ network.in_period\[145\]\[1\] _06900_ VSS VSS VDD
+ VDD _06901_ sky130_fd_sc_hd__nand2_1
X_10128_ _00699_ _06900_ _06901_ VSS VSS VDD VDD _02644_ sky130_fd_sc_hd__o21ai_0
X_10129_ network.neuron_in150.counter\[0\] VSS VSS VDD VDD
+ _00575_ sky130_fd_sc_hd__inv_1
X_10130_ network.neuron_in192.counter\[0\] VSS VSS VDD VDD
+ _01124_ sky130_fd_sc_hd__inv_1
X_10131_ network.in_period\[192\]\[0\] _06860_ VSS VSS VDD
+ VDD _06902_ sky130_fd_sc_hd__nand2_1
X_10132_ network.neuron_in192.counter\[0\] _06860_ _06902_
+ VSS VSS VDD VDD _02831_ sky130_fd_sc_hd__o21ai_0
Xclkload7 clknet_4_5__leaf_clk_net VSS VSS VDD VDD _unconnected_29
+ sky130_fd_sc_hd__inv_6
X_10134_ network.neuron_in193.counter\[3\] network.in_period\[193\]\[2\]
+ _00972_ net426 VSS VSS VDD VDD _06904_ sky130_fd_sc_hd__o22ai_1
X_10135_ network.neuron_in193.counter\[2\] _00972_ net360
+ VSS VSS VDD VDD _06905_ sky130_fd_sc_hd__nand3_1
X_10136_ network.in_period\[193\]\[2\] net360 _06905_ VSS
+ VSS VDD VDD _06906_ sky130_fd_sc_hd__o21ai_0
X_10137_ _06839_ _06904_ _06906_ VSS VSS VDD VDD _02837_ sky130_fd_sc_hd__a21oi_1
X_10138_ network.neuron_in255.counter\[1\] VSS VSS VDD VDD
+ _01069_ sky130_fd_sc_hd__inv_1
X_10139_ network.neuron_in210.counter\[1\] VSS VSS VDD VDD
+ _00320_ sky130_fd_sc_hd__inv_1
X_10140_ network.neuron_in102.counter\[1\] VSS VSS VDD VDD
+ _00214_ sky130_fd_sc_hd__inv_1
X_10141_ network.neuron_in153.counter\[0\] VSS VSS VDD VDD
+ _00551_ sky130_fd_sc_hd__inv_1
X_10142_ network.neuron_in182.counter\[1\] VSS VSS VDD VDD
+ _00959_ sky130_fd_sc_hd__inv_1
X_10143_ network.neuron_in058.counter\[1\] VSS VSS VDD VDD
+ _00244_ sky130_fd_sc_hd__inv_1
X_10144_ network.neuron_in255.counter\[0\] VSS VSS VDD VDD
+ _01068_ sky130_fd_sc_hd__inv_1
X_10145_ network.neuron_in188.counter\[1\] VSS VSS VDD VDD
+ _01179_ sky130_fd_sc_hd__inv_1
X_10146_ network.neuron_in057.counter\[1\] VSS VSS VDD VDD
+ _00256_ sky130_fd_sc_hd__inv_1
X_10147_ network.neuron_in109.counter\[0\] VSS VSS VDD VDD
+ _00221_ sky130_fd_sc_hd__inv_1
X_10148_ network.neuron_in129.counter\[0\] VSS VSS VDD VDD
+ _00587_ sky130_fd_sc_hd__inv_1
X_10149_ network.neuron_in129.counter\[2\] _00589_ VSS VSS
+ VDD VDD _06907_ sky130_fd_sc_hd__nand2b_1
X_10150_ network.neuron_in129.counter\[3\] _06907_ VSS VSS
+ VDD VDD _06908_ sky130_fd_sc_hd__or2_2
X_10151_ net351 _06908_ VSS VSS VDD VDD _06909_ sky130_fd_sc_hd__nand2_1
X_10152_ network.in_period\[129\]\[0\] _06909_ VSS VSS VDD
+ VDD _06910_ sky130_fd_sc_hd__nand2_1
X_10153_ network.neuron_in129.counter\[0\] _06909_ _06910_
+ VSS VSS VDD VDD _02579_ sky130_fd_sc_hd__o21ai_0
X_10154_ network.neuron_in194.counter\[3\] _00289_ VSS VSS
+ VDD VDD _06911_ sky130_fd_sc_hd__nand2b_1
X_10155_ network.neuron_in194.counter\[2\] _06911_ VSS VSS
+ VDD VDD _06912_ sky130_fd_sc_hd__or2_2
X_10156_ net366 _06912_ VSS VSS VDD VDD _06913_ sky130_fd_sc_hd__nand2_1
X_10157_ network.in_period\[194\]\[1\] _06913_ VSS VSS VDD
+ VDD _06914_ sky130_fd_sc_hd__nand2_1
X_10158_ _00290_ _06913_ _06914_ VSS VSS VDD VDD _02840_ sky130_fd_sc_hd__o21ai_0
X_10159_ network.neuron_in194.counter\[0\] VSS VSS VDD VDD
+ _00287_ sky130_fd_sc_hd__inv_1
X_10160_ network.in_period\[194\]\[0\] _06913_ VSS VSS VDD
+ VDD _06915_ sky130_fd_sc_hd__nand2_1
X_10161_ network.neuron_in194.counter\[0\] _06913_ _06915_
+ VSS VSS VDD VDD _02839_ sky130_fd_sc_hd__o21ai_0
X_10162_ network.neuron_in195.counter\[3\] _00377_ VSS VSS
+ VDD VDD _06916_ sky130_fd_sc_hd__nand2b_1
X_10163_ network.neuron_in195.counter\[2\] _06916_ VSS VSS
+ VDD VDD _06917_ sky130_fd_sc_hd__or2_2
X_10164_ net366 _06917_ VSS VSS VDD VDD _06918_ sky130_fd_sc_hd__nand2_1
X_10165_ network.in_period\[195\]\[1\] _06918_ VSS VSS VDD
+ VDD _06919_ sky130_fd_sc_hd__nand2_1
X_10166_ _00378_ _06918_ _06919_ VSS VSS VDD VDD _02844_ sky130_fd_sc_hd__o21ai_0
X_10167_ network.neuron_in127.counter\[1\] VSS VSS VDD VDD
+ _01113_ sky130_fd_sc_hd__inv_1
X_10168_ network.neuron_in069.counter\[0\] VSS VSS VDD VDD
+ _00168_ sky130_fd_sc_hd__inv_1
X_10169_ network.neuron_in195.counter\[0\] VSS VSS VDD VDD
+ _00375_ sky130_fd_sc_hd__inv_1
X_10170_ network.in_period\[195\]\[0\] _06918_ VSS VSS VDD
+ VDD _06920_ sky130_fd_sc_hd__nand2_1
X_10171_ network.neuron_in195.counter\[0\] _06918_ _06920_
+ VSS VSS VDD VDD _02843_ sky130_fd_sc_hd__o21ai_0
X_10172_ network.neuron_in196.counter\[0\] VSS VSS VDD VDD
+ _00726_ sky130_fd_sc_hd__inv_1
X_10173_ network.in_period\[196\]\[0\] _06845_ VSS VSS VDD
+ VDD _06921_ sky130_fd_sc_hd__nand2_1
X_10174_ network.neuron_in196.counter\[0\] _06845_ _06921_
+ VSS VSS VDD VDD _02847_ sky130_fd_sc_hd__o21ai_0
X_10175_ network.neuron_in150.counter\[1\] VSS VSS VDD VDD
+ _00576_ sky130_fd_sc_hd__inv_1
X_10176_ network.neuron_in197.counter\[3\] _00833_ VSS VSS
+ VDD VDD _06922_ sky130_fd_sc_hd__nand2b_1
X_10177_ network.neuron_in197.counter\[2\] _06922_ VSS VSS
+ VDD VDD _06923_ sky130_fd_sc_hd__or2_2
X_10178_ net366 _06923_ VSS VSS VDD VDD _06924_ sky130_fd_sc_hd__nand2_1
X_10179_ network.in_period\[197\]\[1\] _06924_ VSS VSS VDD
+ VDD _06925_ sky130_fd_sc_hd__nand2_1
X_10180_ _00834_ _06924_ _06925_ VSS VSS VDD VDD _02852_ sky130_fd_sc_hd__o21ai_0
X_10181_ network.neuron_in172.counter\[1\] VSS VSS VDD VDD
+ _01059_ sky130_fd_sc_hd__inv_1
X_10182_ network.neuron_in056.counter\[1\] VSS VSS VDD VDD
+ _00252_ sky130_fd_sc_hd__inv_1
X_10183_ network.neuron_in197.counter\[0\] VSS VSS VDD VDD
+ _00831_ sky130_fd_sc_hd__inv_1
X_10184_ network.in_period\[197\]\[0\] _06924_ VSS VSS VDD
+ VDD _06926_ sky130_fd_sc_hd__nand2_1
X_10185_ network.neuron_in197.counter\[0\] _06924_ _06926_
+ VSS VSS VDD VDD _02851_ sky130_fd_sc_hd__o21ai_0
X_10186_ network.neuron_in042.counter\[1\] VSS VSS VDD VDD
+ _00350_ sky130_fd_sc_hd__inv_1
X_10187_ network.in_period\[129\]\[1\] _06909_ VSS VSS VDD
+ VDD _06927_ sky130_fd_sc_hd__nand2_1
X_10188_ _00590_ _06909_ _06927_ VSS VSS VDD VDD _02580_ sky130_fd_sc_hd__o21ai_0
X_10189_ network.neuron_in237.counter\[1\] VSS VSS VDD VDD
+ _00432_ sky130_fd_sc_hd__inv_1
X_10190_ network.neuron_in141.counter\[1\] VSS VSS VDD VDD
+ _00260_ sky130_fd_sc_hd__inv_1
X_10191_ network.neuron_in209.counter\[2\] net343 VSS VSS
+ VDD VDD _06928_ sky130_fd_sc_hd__nand2_1
X_10192_ network.in_period\[209\]\[2\] network.neuron_in209.counter\[3\]
+ _06928_ VSS VSS VDD VDD _06929_ sky130_fd_sc_hd__o21ai_0
X_10193_ _01172_ network.neuron_in209.counter\[2\] net425
+ VSS VSS VDD VDD _06930_ sky130_fd_sc_hd__or3_1
X_10194_ network.in_period\[209\]\[2\] net343 _06930_ VSS
+ VSS VDD VDD _06931_ sky130_fd_sc_hd__o21ai_0
X_10195_ _01172_ _06929_ _06931_ VSS VSS VDD VDD _02901_ sky130_fd_sc_hd__a21oi_1
X_10196_ network.neuron_in204.counter\[2\] _00825_ VSS VSS
+ VDD VDD _06932_ sky130_fd_sc_hd__xnor2_1
X_10197_ network.neuron_in204.counter\[2\] network.neuron_in204.counter\[3\]
+ VSS VSS VDD VDD _06933_ sky130_fd_sc_hd__nor2_1
X_10198_ net425 _06933_ VSS VSS VDD VDD _06934_ sky130_fd_sc_hd__nor2_1
X_10199_ network.in_period\[204\]\[2\] _06934_ VSS VSS VDD
+ VDD _06935_ sky130_fd_sc_hd__nor2_1
X_10200_ net339 _06932_ _06935_ VSS VSS VDD VDD _02881_ sky130_fd_sc_hd__a21oi_1
X_10201_ network.neuron_in206.counter\[0\] VSS VSS VDD VDD
+ _00307_ sky130_fd_sc_hd__inv_1
X_10202_ network.neuron_in023.counter\[1\] VSS VSS VDD VDD
+ _00440_ sky130_fd_sc_hd__inv_1
X_10203_ network.neuron_in208.counter\[0\] VSS VSS VDD VDD
+ _00998_ sky130_fd_sc_hd__inv_1
X_10204_ network.neuron_in208.counter\[2\] VSS VSS VDD VDD
+ _06936_ sky130_fd_sc_hd__inv_1
X_10205_ _06936_ _01000_ VSS VSS VDD VDD _06937_ sky130_fd_sc_hd__nand2_1
X_10206_ network.neuron_in208.counter\[3\] _06937_ VSS VSS
+ VDD VDD _06938_ sky130_fd_sc_hd__or2_2
X_10207_ net343 _06938_ VSS VSS VDD VDD _06939_ sky130_fd_sc_hd__nand2_1
X_10208_ network.in_period\[208\]\[0\] _06939_ VSS VSS VDD
+ VDD _06940_ sky130_fd_sc_hd__nand2_1
X_10209_ network.neuron_in208.counter\[0\] _06939_ _06940_
+ VSS VSS VDD VDD _02895_ sky130_fd_sc_hd__o21ai_0
X_10210_ network.neuron_in201.counter\[3\] _01122_ VSS VSS
+ VDD VDD _06941_ sky130_fd_sc_hd__nand2b_1
X_10211_ network.neuron_in201.counter\[2\] VSS VSS VDD VDD
+ _06942_ sky130_fd_sc_hd__inv_1
X_10212_ _06941_ _06942_ VSS VSS VDD VDD _06943_ sky130_fd_sc_hd__nand2b_1
X_10213_ net360 _06943_ VSS VSS VDD VDD _06944_ sky130_fd_sc_hd__nand2_1
X_10214_ network.in_period\[201\]\[1\] _06944_ VSS VSS VDD
+ VDD _06945_ sky130_fd_sc_hd__nand2_1
X_10215_ _01123_ _06944_ _06945_ VSS VSS VDD VDD _02868_ sky130_fd_sc_hd__o21ai_0
X_10216_ network.neuron_in101.counter\[0\] VSS VSS VDD VDD
+ _01174_ sky130_fd_sc_hd__inv_1
X_10217_ network.neuron_in239.counter\[0\] VSS VSS VDD VDD
+ _00579_ sky130_fd_sc_hd__inv_1
X_10218_ network.neuron_in190.counter\[1\] VSS VSS VDD VDD
+ _00284_ sky130_fd_sc_hd__inv_1
X_10219_ network.neuron_in203.counter\[0\] VSS VSS VDD VDD
+ _00231_ sky130_fd_sc_hd__inv_1
X_10220_ network.neuron_in203.counter\[3\] _00233_ VSS VSS
+ VDD VDD _06946_ sky130_fd_sc_hd__nand2b_1
X_10221_ network.neuron_in203.counter\[2\] VSS VSS VDD VDD
+ _06947_ sky130_fd_sc_hd__inv_1
X_10222_ _06946_ _06947_ VSS VSS VDD VDD _06948_ sky130_fd_sc_hd__nand2b_1
X_10223_ net339 _06948_ VSS VSS VDD VDD _06949_ sky130_fd_sc_hd__nand2_1
X_10224_ network.in_period\[203\]\[0\] _06949_ VSS VSS VDD
+ VDD _06950_ sky130_fd_sc_hd__nand2_1
X_10225_ network.neuron_in203.counter\[0\] _06949_ _06950_
+ VSS VSS VDD VDD _02875_ sky130_fd_sc_hd__o21ai_0
Xclkload6 clknet_4_4__leaf_clk_net VSS VSS VDD VDD _unconnected_30
+ sky130_fd_sc_hd__clkinv_8
X_10227_ network.neuron_in206.counter\[2\] network.neuron_in206.counter\[3\]
+ VSS VSS VDD VDD _06952_ sky130_fd_sc_hd__nor2_1
X_10228_ _00309_ _06952_ VSS VSS VDD VDD _06953_ sky130_fd_sc_hd__nand2_1
X_10229_ net339 _06953_ VSS VSS VDD VDD _06954_ sky130_fd_sc_hd__nand2_1
X_10230_ network.in_period\[206\]\[1\] _06954_ VSS VSS VDD
+ VDD _06955_ sky130_fd_sc_hd__nand2_1
X_10231_ _00310_ _06954_ _06955_ VSS VSS VDD VDD _02888_ sky130_fd_sc_hd__o21ai_0
X_10232_ network.in_period\[208\]\[1\] _06939_ VSS VSS VDD
+ VDD _06956_ sky130_fd_sc_hd__nand2_1
X_10233_ _01001_ _06939_ _06956_ VSS VSS VDD VDD _02896_ sky130_fd_sc_hd__o21ai_0
X_10234_ network.neuron_in200.counter\[2\] VSS VSS VDD VDD
+ _06957_ sky130_fd_sc_hd__inv_1
X_10235_ network.neuron_in200.counter\[3\] network.in_period\[200\]\[2\]
+ _00297_ net421 VSS VSS VDD VDD _06958_ sky130_fd_sc_hd__o22ai_1
X_10236_ network.neuron_in200.counter\[2\] _00297_ net344
+ VSS VSS VDD VDD _06959_ sky130_fd_sc_hd__nand3_1
X_10237_ network.in_period\[200\]\[2\] net344 _06959_ VSS
+ VSS VDD VDD _06960_ sky130_fd_sc_hd__o21ai_0
X_10238_ _06957_ _06958_ _06960_ VSS VSS VDD VDD _02865_ sky130_fd_sc_hd__a21oi_1
X_10239_ network.neuron_in055.counter\[1\] VSS VSS VDD VDD
+ _00264_ sky130_fd_sc_hd__inv_1
X_10240_ network.neuron_in146.counter\[0\] VSS VSS VDD VDD
+ _00345_ sky130_fd_sc_hd__inv_1
X_10241_ network.neuron_in146.counter\[3\] _00347_ VSS VSS
+ VDD VDD _06961_ sky130_fd_sc_hd__nand2b_1
X_10242_ network.neuron_in146.counter\[2\] VSS VSS VDD VDD
+ _06962_ sky130_fd_sc_hd__inv_1
X_10243_ _06961_ _06962_ VSS VSS VDD VDD _06963_ sky130_fd_sc_hd__nand2b_1
X_10244_ net346 _06963_ VSS VSS VDD VDD _06964_ sky130_fd_sc_hd__nand2_1
X_10245_ network.in_period\[146\]\[0\] _06964_ VSS VSS VDD
+ VDD _06965_ sky130_fd_sc_hd__nand2_1
X_10246_ network.neuron_in146.counter\[0\] _06964_ _06965_
+ VSS VSS VDD VDD _02647_ sky130_fd_sc_hd__o21ai_0
X_10247_ network.neuron_in201.counter\[3\] network.in_period\[201\]\[2\]
+ _01122_ net421 VSS VSS VDD VDD _06966_ sky130_fd_sc_hd__o22ai_1
X_10248_ network.neuron_in201.counter\[2\] _01122_ net360
+ VSS VSS VDD VDD _06967_ sky130_fd_sc_hd__nand3_1
X_10249_ network.in_period\[201\]\[2\] net360 _06967_ VSS
+ VSS VDD VDD _06968_ sky130_fd_sc_hd__o21ai_0
X_10250_ _06942_ _06966_ _06968_ VSS VSS VDD VDD _02869_ sky130_fd_sc_hd__a21oi_1
Xclkload5 clknet_4_3__leaf_clk_net VSS VSS VDD VDD _unconnected_31
+ sky130_fd_sc_hd__clkbuf_16
X_10252_ network.neuron_in202.counter\[3\] _00964_ VSS VSS
+ VDD VDD _06970_ sky130_fd_sc_hd__nand2b_1
X_10253_ network.neuron_in202.counter\[2\] VSS VSS VDD VDD
+ _06971_ sky130_fd_sc_hd__inv_1
X_10254_ _06970_ _06971_ VSS VSS VDD VDD _06972_ sky130_fd_sc_hd__nand2b_1
X_10255_ net339 _06972_ VSS VSS VDD VDD _06973_ sky130_fd_sc_hd__nand2_1
X_10256_ network.in_period\[202\]\[1\] _06973_ VSS VSS VDD
+ VDD _06974_ sky130_fd_sc_hd__nand2_1
X_10257_ _00965_ _06973_ _06974_ VSS VSS VDD VDD _02872_ sky130_fd_sc_hd__o21ai_0
X_10258_ network.in_period\[203\]\[1\] _06949_ VSS VSS VDD
+ VDD _06975_ sky130_fd_sc_hd__nand2_1
X_10259_ _00234_ _06949_ _06975_ VSS VSS VDD VDD _02876_ sky130_fd_sc_hd__o21ai_0
X_10260_ network.neuron_in172.counter\[0\] VSS VSS VDD VDD
+ _01058_ sky130_fd_sc_hd__inv_1
X_10261_ network.neuron_in054.counter\[1\] VSS VSS VDD VDD
+ _00268_ sky130_fd_sc_hd__inv_1
X_10262_ network.neuron_in053.counter\[1\] VSS VSS VDD VDD
+ _00272_ sky130_fd_sc_hd__inv_1
X_10263_ network.neuron_in205.counter\[2\] net339 VSS VSS
+ VDD VDD _06976_ sky130_fd_sc_hd__nand2_1
X_10264_ network.neuron_in205.counter\[3\] network.in_period\[205\]\[2\]
+ _06976_ VSS VSS VDD VDD _06977_ sky130_fd_sc_hd__o21ai_0
Xclkload4 clknet_4_2__leaf_clk_net VSS VSS VDD VDD _unconnected_32
+ sky130_fd_sc_hd__clkbuf_16
X_10266_ _00313_ network.neuron_in205.counter\[2\] net425
+ VSS VSS VDD VDD _06979_ sky130_fd_sc_hd__or3_1
X_10267_ network.in_period\[205\]\[2\] net339 _06979_ VSS
+ VSS VDD VDD _06980_ sky130_fd_sc_hd__o21ai_0
X_10268_ _00313_ _06977_ _06980_ VSS VSS VDD VDD _02885_ sky130_fd_sc_hd__a21oi_1
X_10269_ network.neuron_in206.counter\[2\] net339 VSS VSS
+ VDD VDD _06981_ sky130_fd_sc_hd__nand2_1
X_10270_ network.neuron_in206.counter\[3\] network.in_period\[206\]\[2\]
+ _06981_ VSS VSS VDD VDD _06982_ sky130_fd_sc_hd__o21ai_0
X_10271_ _00309_ network.neuron_in206.counter\[2\] net425
+ VSS VSS VDD VDD _06983_ sky130_fd_sc_hd__or3_1
X_10272_ network.in_period\[206\]\[2\] net339 _06983_ VSS
+ VSS VDD VDD _06984_ sky130_fd_sc_hd__o21ai_0
X_10273_ _00309_ _06982_ _06984_ VSS VSS VDD VDD _02889_ sky130_fd_sc_hd__a21oi_1
X_10274_ network.neuron_in207.counter\[2\] VSS VSS VDD VDD
+ _06985_ sky130_fd_sc_hd__inv_1
X_10275_ network.neuron_in207.counter\[3\] network.in_period\[207\]\[2\]
+ _00956_ net425 VSS VSS VDD VDD _06986_ sky130_fd_sc_hd__o22ai_1
X_10276_ network.neuron_in207.counter\[2\] _00956_ net339
+ VSS VSS VDD VDD _06987_ sky130_fd_sc_hd__nand3_1
X_10277_ network.in_period\[207\]\[2\] net339 _06987_ VSS
+ VSS VDD VDD _06988_ sky130_fd_sc_hd__o21ai_0
X_10278_ _06985_ _06986_ _06988_ VSS VSS VDD VDD _02893_ sky130_fd_sc_hd__a21oi_1
X_10279_ network.neuron_in070.counter\[0\] VSS VSS VDD VDD
+ _00162_ sky130_fd_sc_hd__inv_1
X_10280_ network.neuron_in087.counter\[0\] VSS VSS VDD VDD
+ _00034_ sky130_fd_sc_hd__inv_1
X_10281_ network.neuron_in193.counter\[1\] VSS VSS VDD VDD
+ _00971_ sky130_fd_sc_hd__inv_1
X_10282_ network.neuron_in208.counter\[3\] network.in_period\[208\]\[2\]
+ _01000_ net425 VSS VSS VDD VDD _06989_ sky130_fd_sc_hd__o22ai_1
Xclkload3 clknet_4_1__leaf_clk_net VSS VSS VDD VDD _unconnected_33
+ sky130_fd_sc_hd__clkbuf_16
X_10284_ network.neuron_in208.counter\[2\] _01000_ net344
+ VSS VSS VDD VDD _06991_ sky130_fd_sc_hd__nand3_1
X_10285_ network.in_period\[208\]\[2\] net344 _06991_ VSS
+ VSS VDD VDD _06992_ sky130_fd_sc_hd__o21ai_0
X_10286_ _06936_ _06989_ _06992_ VSS VSS VDD VDD _02897_ sky130_fd_sc_hd__a21oi_1
X_10287_ network.neuron_in199.counter\[3\] _01156_ VSS VSS
+ VDD VDD _06993_ sky130_fd_sc_hd__nand2b_1
X_10288_ network.neuron_in199.counter\[2\] _06993_ VSS VSS
+ VDD VDD _06994_ sky130_fd_sc_hd__or2_2
X_10289_ net344 _06994_ VSS VSS VDD VDD _06995_ sky130_fd_sc_hd__nand2_1
X_10290_ network.in_period\[199\]\[1\] _06995_ VSS VSS VDD
+ VDD _06996_ sky130_fd_sc_hd__nand2_1
X_10291_ _01157_ _06995_ _06996_ VSS VSS VDD VDD _02860_ sky130_fd_sc_hd__o21ai_0
X_10292_ network.neuron_in199.counter\[0\] VSS VSS VDD VDD
+ _01154_ sky130_fd_sc_hd__inv_1
X_10293_ network.in_period\[199\]\[0\] _06995_ VSS VSS VDD
+ VDD _06997_ sky130_fd_sc_hd__nand2_1
X_10294_ network.neuron_in199.counter\[0\] _06995_ _06997_
+ VSS VSS VDD VDD _02859_ sky130_fd_sc_hd__o21ai_0
X_10295_ network.neuron_in110.counter\[1\] VSS VSS VDD VDD
+ _00159_ sky130_fd_sc_hd__inv_1
X_10296_ network.neuron_in000.counter\[1\] VSS VSS VDD VDD
+ _00681_ sky130_fd_sc_hd__inv_1
X_10297_ network.neuron_in219.counter\[1\] VSS VSS VDD VDD
+ _01055_ sky130_fd_sc_hd__inv_1
X_10298_ network.neuron_in072.counter\[0\] VSS VSS VDD VDD
+ _00227_ sky130_fd_sc_hd__inv_1
X_10299_ network.neuron_in239.counter\[1\] VSS VSS VDD VDD
+ _00580_ sky130_fd_sc_hd__inv_1
X_10300_ network.neuron_in047.counter\[1\] VSS VSS VDD VDD
+ _00304_ sky130_fd_sc_hd__inv_1
X_10301_ network.neuron_in197.counter\[1\] VSS VSS VDD VDD
+ _00832_ sky130_fd_sc_hd__inv_1
X_10302_ network.neuron_in195.counter\[1\] VSS VSS VDD VDD
+ _00376_ sky130_fd_sc_hd__inv_1
X_10303_ network.neuron_in194.counter\[1\] VSS VSS VDD VDD
+ _00288_ sky130_fd_sc_hd__inv_1
X_10304_ network.neuron_in052.counter\[1\] VSS VSS VDD VDD
+ _00280_ sky130_fd_sc_hd__inv_1
X_10305_ network.neuron_in159.counter\[1\] VSS VSS VDD VDD
+ _00693_ sky130_fd_sc_hd__inv_1
X_10306_ network.neuron_in144.counter\[2\] network.neuron_in144.counter\[3\]
+ VSS VSS VDD VDD _06998_ sky130_fd_sc_hd__nor2_1
X_10307_ _00708_ _06998_ VSS VSS VDD VDD _06999_ sky130_fd_sc_hd__nand2_1
X_10308_ net358 _06999_ VSS VSS VDD VDD _07000_ sky130_fd_sc_hd__nand2_1
X_10309_ network.in_period\[144\]\[1\] _07000_ VSS VSS VDD
+ VDD _07001_ sky130_fd_sc_hd__nand2_1
X_10310_ _00709_ _07000_ _07001_ VSS VSS VDD VDD _02640_ sky130_fd_sc_hd__o21ai_0
X_10311_ network.neuron_in201.counter\[1\] VSS VSS VDD VDD
+ _01121_ sky130_fd_sc_hd__inv_1
X_10312_ network.neuron_in216.counter\[0\] VSS VSS VDD VDD
+ _00509_ sky130_fd_sc_hd__inv_1
X_10313_ network.neuron_in092.counter\[1\] VSS VSS VDD VDD
+ _01225_ sky130_fd_sc_hd__inv_1
X_10314_ network.neuron_in219.counter\[0\] VSS VSS VDD VDD
+ _01054_ sky130_fd_sc_hd__inv_1
X_10315_ network.neuron_in149.counter\[1\] VSS VSS VDD VDD
+ _00584_ sky130_fd_sc_hd__inv_1
X_10316_ network.neuron_in049.counter\[1\] VSS VSS VDD VDD
+ _00292_ sky130_fd_sc_hd__inv_1
X_10317_ network.neuron_in048.counter\[1\] VSS VSS VDD VDD
+ _00300_ sky130_fd_sc_hd__inv_1
X_10318_ network.neuron_in047.counter\[0\] VSS VSS VDD VDD
+ _00303_ sky130_fd_sc_hd__inv_1
X_10319_ network.neuron_in050.counter\[1\] VSS VSS VDD VDD
+ _00384_ sky130_fd_sc_hd__inv_1
X_10320_ network.neuron_in028.counter\[0\] VSS VSS VDD VDD
+ _00423_ sky130_fd_sc_hd__inv_1
X_10321_ network.neuron_in143.counter\[0\] VSS VSS VDD VDD
+ _00756_ sky130_fd_sc_hd__inv_1
X_10322_ network.neuron_in143.counter\[3\] _00758_ VSS VSS
+ VDD VDD _07002_ sky130_fd_sc_hd__nand2b_1
X_10323_ network.neuron_in143.counter\[2\] _07002_ VSS VSS
+ VDD VDD _07003_ sky130_fd_sc_hd__or2_2
X_10324_ net360 _07003_ VSS VSS VDD VDD _07004_ sky130_fd_sc_hd__nand2_1
X_10325_ network.in_period\[143\]\[0\] _07004_ VSS VSS VDD
+ VDD _07005_ sky130_fd_sc_hd__nand2_1
X_10326_ network.neuron_in143.counter\[0\] _07004_ _07005_
+ VSS VSS VDD VDD _02635_ sky130_fd_sc_hd__o21ai_0
X_10327_ network.neuron_in122.counter\[1\] VSS VSS VDD VDD
+ _01051_ sky130_fd_sc_hd__inv_1
X_10328_ network.neuron_in109.counter\[1\] VSS VSS VDD VDD
+ _00222_ sky130_fd_sc_hd__inv_1
X_10329_ net417 _06998_ VSS VSS VDD VDD _07006_ sky130_fd_sc_hd__nor2_1
X_10330_ network.neuron_in144.counter\[2\] _00708_ VSS VSS
+ VDD VDD _07007_ sky130_fd_sc_hd__xnor2_1
Xclkbuf_4_15__f_clk_net clknet_2_3_0_clk_net VSS VSS VDD VDD
+ clknet_4_15__leaf_clk_net sky130_fd_sc_hd__clkbuf_16
Xclkbuf_4_14__f_clk_net clknet_2_3_0_clk_net VSS VSS VDD VDD
+ clknet_4_14__leaf_clk_net sky130_fd_sc_hd__clkbuf_16
X_10333_ network.in_period\[144\]\[2\] _07006_ _07007_ net358
+ VSS VSS VDD VDD _02641_ sky130_fd_sc_hd__a2bb2oi_1
X_10334_ network.neuron_in122.counter\[0\] VSS VSS VDD VDD
+ _01050_ sky130_fd_sc_hd__inv_1
X_10335_ network.neuron_in028.counter\[1\] VSS VSS VDD VDD
+ _00424_ sky130_fd_sc_hd__inv_1
X_10336_ network.neuron_in148.counter\[0\] VSS VSS VDD VDD
+ _00591_ sky130_fd_sc_hd__inv_1
X_10337_ network.neuron_in148.counter\[2\] _00593_ VSS VSS
+ VDD VDD _07010_ sky130_fd_sc_hd__nand2b_1
X_10338_ network.neuron_in148.counter\[3\] _07010_ VSS VSS
+ VDD VDD _07011_ sky130_fd_sc_hd__or2_2
X_10339_ net346 _07011_ VSS VSS VDD VDD _07012_ sky130_fd_sc_hd__nand2_1
X_10340_ network.in_period\[148\]\[0\] _07012_ VSS VSS VDD
+ VDD _07013_ sky130_fd_sc_hd__nand2_1
X_10341_ network.neuron_in148.counter\[0\] _07012_ _07013_
+ VSS VSS VDD VDD _02655_ sky130_fd_sc_hd__o21ai_0
X_10342_ network.neuron_in044.counter\[1\] VSS VSS VDD VDD
+ _00324_ sky130_fd_sc_hd__inv_1
X_10343_ network.neuron_in039.counter\[1\] VSS VSS VDD VDD
+ _00368_ sky130_fd_sc_hd__inv_1
X_10344_ network.neuron_in045.counter\[1\] VSS VSS VDD VDD
+ _00332_ sky130_fd_sc_hd__inv_1
X_10345_ network.neuron_in201.counter\[0\] VSS VSS VDD VDD
+ _01120_ sky130_fd_sc_hd__inv_1
X_10346_ network.neuron_in124.counter\[1\] VSS VSS VDD VDD
+ _00404_ sky130_fd_sc_hd__inv_1
X_10347_ network.neuron_in129.counter\[1\] VSS VSS VDD VDD
+ _00588_ sky130_fd_sc_hd__inv_1
X_10348_ network.in_period\[143\]\[1\] _07004_ VSS VSS VDD
+ VDD _07014_ sky130_fd_sc_hd__nand2_1
X_10349_ _00759_ _07004_ _07014_ VSS VSS VDD VDD _02636_ sky130_fd_sc_hd__o21ai_0
X_10350_ network.neuron_in087.counter\[1\] VSS VSS VDD VDD
+ _00035_ sky130_fd_sc_hd__inv_1
X_10351_ network.neuron_hid0.IF0.ref_counter\[1\] VSS VSS
+ VDD VDD _01045_ sky130_fd_sc_hd__inv_1
X_10352_ network.neuron_in151.counter\[0\] VSS VSS VDD VDD
+ _00571_ sky130_fd_sc_hd__inv_1
X_10353_ network.neuron_in063.counter\[1\] VSS VSS VDD VDD
+ _00206_ sky130_fd_sc_hd__inv_1
X_10354_ network.neuron_in200.counter\[3\] _00297_ VSS VSS
+ VDD VDD _07015_ sky130_fd_sc_hd__nand2b_1
X_10355_ _07015_ _06957_ VSS VSS VDD VDD _07016_ sky130_fd_sc_hd__nand2b_1
X_10356_ net344 _07016_ VSS VSS VDD VDD _07017_ sky130_fd_sc_hd__nand2_1
X_10357_ network.in_period\[200\]\[1\] _07017_ VSS VSS VDD
+ VDD _07018_ sky130_fd_sc_hd__nand2_1
X_10358_ _00298_ _07017_ _07018_ VSS VSS VDD VDD _02864_ sky130_fd_sc_hd__o21ai_0
X_10359_ network.neuron_in200.counter\[0\] VSS VSS VDD VDD
+ _00295_ sky130_fd_sc_hd__inv_1
X_10360_ network.in_period\[200\]\[0\] _07017_ VSS VSS VDD
+ VDD _07019_ sky130_fd_sc_hd__nand2_1
X_10361_ network.neuron_in200.counter\[0\] _07017_ _07019_
+ VSS VSS VDD VDD _02863_ sky130_fd_sc_hd__o21ai_0
X_10362_ network.in_period\[201\]\[0\] _06944_ VSS VSS VDD
+ VDD _07020_ sky130_fd_sc_hd__nand2_1
X_10363_ network.neuron_in201.counter\[0\] _06944_ _07020_
+ VSS VSS VDD VDD _02867_ sky130_fd_sc_hd__o21ai_0
X_10364_ network.neuron_in202.counter\[3\] network.in_period\[202\]\[2\]
+ _00964_ net426 VSS VSS VDD VDD _07021_ sky130_fd_sc_hd__o22ai_1
X_10365_ network.neuron_in202.counter\[2\] _00964_ net339
+ VSS VSS VDD VDD _07022_ sky130_fd_sc_hd__nand3_1
X_10366_ network.in_period\[202\]\[2\] net339 _07022_ VSS
+ VSS VDD VDD _07023_ sky130_fd_sc_hd__o21ai_0
X_10367_ _06971_ _07021_ _07023_ VSS VSS VDD VDD _02873_ sky130_fd_sc_hd__a21oi_1
X_10368_ network.neuron_in202.counter\[0\] VSS VSS VDD VDD
+ _00962_ sky130_fd_sc_hd__inv_1
X_10369_ network.in_period\[202\]\[0\] _06973_ VSS VSS VDD
+ VDD _07024_ sky130_fd_sc_hd__nand2_1
X_10370_ network.neuron_in202.counter\[0\] _06973_ _07024_
+ VSS VSS VDD VDD _02871_ sky130_fd_sc_hd__o21ai_0
X_10371_ network.neuron_in203.counter\[3\] network.in_period\[203\]\[2\]
+ _00233_ net425 VSS VSS VDD VDD _07025_ sky130_fd_sc_hd__o22ai_1
X_10372_ network.neuron_in203.counter\[2\] _00233_ net339
+ VSS VSS VDD VDD _07026_ sky130_fd_sc_hd__nand3_1
X_10373_ network.in_period\[203\]\[2\] net339 _07026_ VSS
+ VSS VDD VDD _07027_ sky130_fd_sc_hd__o21ai_0
X_10374_ _06947_ _07025_ _07027_ VSS VSS VDD VDD _02877_ sky130_fd_sc_hd__a21oi_1
X_10375_ network.neuron_in155.counter\[1\] VSS VSS VDD VDD
+ _01117_ sky130_fd_sc_hd__inv_1
X_10376_ network.neuron_in020.counter\[0\] VSS VSS VDD VDD
+ _00457_ sky130_fd_sc_hd__inv_1
X_10377_ network.neuron_in212.counter\[1\] VSS VSS VDD VDD
+ _00342_ sky130_fd_sc_hd__inv_1
X_10378_ network.neuron_in204.counter\[3\] _00825_ VSS VSS
+ VDD VDD _07028_ sky130_fd_sc_hd__nand2b_1
X_10379_ network.neuron_in204.counter\[2\] _07028_ VSS VSS
+ VDD VDD _07029_ sky130_fd_sc_hd__or2_2
X_10380_ net339 _07029_ VSS VSS VDD VDD _07030_ sky130_fd_sc_hd__nand2_1
X_10381_ network.in_period\[204\]\[1\] _07030_ VSS VSS VDD
+ VDD _07031_ sky130_fd_sc_hd__nand2_1
X_10382_ _00826_ _07030_ _07031_ VSS VSS VDD VDD _02880_ sky130_fd_sc_hd__o21ai_0
X_10383_ network.neuron_in204.counter\[0\] VSS VSS VDD VDD
+ _00823_ sky130_fd_sc_hd__inv_1
X_10384_ network.in_period\[204\]\[0\] _07030_ VSS VSS VDD
+ VDD _07032_ sky130_fd_sc_hd__nand2_1
X_10385_ network.neuron_in204.counter\[0\] _07030_ _07032_
+ VSS VSS VDD VDD _02879_ sky130_fd_sc_hd__o21ai_0
X_10386_ network.neuron_in108.counter\[1\] VSS VSS VDD VDD
+ _01021_ sky130_fd_sc_hd__inv_1
X_10387_ network.neuron_in221.counter\[1\] VSS VSS VDD VDD
+ _01041_ sky130_fd_sc_hd__inv_1
X_10388_ network.neuron_in205.counter\[2\] network.neuron_in205.counter\[3\]
+ VSS VSS VDD VDD _07033_ sky130_fd_sc_hd__nor2_1
X_10389_ _00313_ _07033_ VSS VSS VDD VDD _07034_ sky130_fd_sc_hd__nand2_1
X_10390_ net339 _07034_ VSS VSS VDD VDD _07035_ sky130_fd_sc_hd__nand2_1
X_10391_ network.in_period\[205\]\[1\] _07035_ VSS VSS VDD
+ VDD _07036_ sky130_fd_sc_hd__nand2_1
X_10392_ _00314_ _07035_ _07036_ VSS VSS VDD VDD _02884_ sky130_fd_sc_hd__o21ai_0
X_10393_ network.neuron_in215.counter\[1\] VSS VSS VDD VDD
+ _01183_ sky130_fd_sc_hd__inv_1
X_10394_ network.neuron_in043.counter\[1\] VSS VSS VDD VDD
+ _00336_ sky130_fd_sc_hd__inv_1
X_10395_ network.in_period\[205\]\[0\] _07035_ VSS VSS VDD
+ VDD _07037_ sky130_fd_sc_hd__nand2_1
X_10396_ network.neuron_in205.counter\[0\] _07035_ _07037_
+ VSS VSS VDD VDD _02883_ sky130_fd_sc_hd__o21ai_0
X_10397_ network.neuron_in228.counter\[1\] VSS VSS VDD VDD
+ _01093_ sky130_fd_sc_hd__inv_1
X_10398_ network.neuron_in135.counter\[0\] VSS VSS VDD VDD
+ _00066_ sky130_fd_sc_hd__inv_1
X_10399_ network.neuron_in041.counter\[1\] VSS VSS VDD VDD
+ _00354_ sky130_fd_sc_hd__inv_1
X_10400_ network.neuron_in253.counter\[0\] VSS VSS VDD VDD
+ _00395_ sky130_fd_sc_hd__inv_1
X_10401_ network.neuron_in153.counter\[3\] _00553_ VSS VSS
+ VDD VDD _07038_ sky130_fd_sc_hd__nand2b_1
X_10402_ network.neuron_in153.counter\[2\] VSS VSS VDD VDD
+ _07039_ sky130_fd_sc_hd__inv_1
X_10403_ _07038_ _07039_ VSS VSS VDD VDD _07040_ sky130_fd_sc_hd__nand2b_1
X_10404_ net358 _07040_ VSS VSS VDD VDD _07041_ sky130_fd_sc_hd__nand2_1
X_10405_ network.in_period\[153\]\[0\] _07041_ VSS VSS VDD
+ VDD _07042_ sky130_fd_sc_hd__nand2_1
X_10406_ network.neuron_in153.counter\[0\] _07041_ _07042_
+ VSS VSS VDD VDD _02675_ sky130_fd_sc_hd__o21ai_0
X_10407_ _00758_ network.neuron_in143.counter\[2\] VSS VSS
+ VDD VDD _07043_ sky130_fd_sc_hd__nand2b_1
X_10408_ network.neuron_in143.counter\[2\] _00758_ VSS VSS
+ VDD VDD _07044_ sky130_fd_sc_hd__nand2b_1
X_10409_ net360 _07002_ network.in_period\[143\]\[2\] VSS
+ VSS VDD VDD _07045_ sky130_fd_sc_hd__a21oi_1
X_10410_ net360 _07043_ _07044_ _07045_ VSS VSS VDD VDD _02637_
+ sky130_fd_sc_hd__a31oi_1
X_10411_ network.neuron_in142.counter\[0\] VSS VSS VDD VDD
+ _00607_ sky130_fd_sc_hd__inv_1
X_10412_ network.neuron_in142.counter\[2\] network.neuron_in142.counter\[3\]
+ VSS VSS VDD VDD _07046_ sky130_fd_sc_hd__nor2_1
X_10413_ _00609_ _07046_ VSS VSS VDD VDD _07047_ sky130_fd_sc_hd__nand2_1
X_10414_ net360 _07047_ VSS VSS VDD VDD _07048_ sky130_fd_sc_hd__nand2_1
X_10415_ network.in_period\[142\]\[0\] _07048_ VSS VSS VDD
+ VDD _07049_ sky130_fd_sc_hd__nand2_1
X_10416_ network.neuron_in142.counter\[0\] _07048_ _07049_
+ VSS VSS VDD VDD _02631_ sky130_fd_sc_hd__o21ai_0
X_10417_ network.neuron_in218.counter\[1\] VSS VSS VDD VDD
+ _00939_ sky130_fd_sc_hd__inv_1
X_10418_ network.neuron_in221.counter\[0\] VSS VSS VDD VDD
+ _01040_ sky130_fd_sc_hd__inv_1
X_10419_ network.neuron_in040.counter\[1\] VSS VSS VDD VDD
+ _00362_ sky130_fd_sc_hd__inv_1
X_10420_ network.neuron_in154.counter\[2\] network.neuron_in154.counter\[3\]
+ VSS VSS VDD VDD _07050_ sky130_fd_sc_hd__nor2_1
X_10421_ _01160_ _07050_ VSS VSS VDD VDD _07051_ sky130_fd_sc_hd__nand2_1
X_10422_ net358 _07051_ VSS VSS VDD VDD _07052_ sky130_fd_sc_hd__nand2_1
X_10423_ network.in_period\[154\]\[1\] _07052_ VSS VSS VDD
+ VDD _07053_ sky130_fd_sc_hd__nand2_1
X_10424_ _01161_ _07052_ _07053_ VSS VSS VDD VDD _02680_ sky130_fd_sc_hd__o21ai_0
X_10425_ network.in_period\[206\]\[0\] _06954_ VSS VSS VDD
+ VDD _07054_ sky130_fd_sc_hd__nand2_1
X_10426_ network.neuron_in206.counter\[0\] _06954_ _07054_
+ VSS VSS VDD VDD _02887_ sky130_fd_sc_hd__o21ai_0
X_10427_ network.neuron_in110.counter\[0\] VSS VSS VDD VDD
+ _00158_ sky130_fd_sc_hd__inv_1
X_10428_ network.neuron_in148.counter\[1\] VSS VSS VDD VDD
+ _00592_ sky130_fd_sc_hd__inv_1
X_10429_ network.neuron_in207.counter\[3\] _00956_ VSS VSS
+ VDD VDD _07055_ sky130_fd_sc_hd__nand2b_1
X_10430_ _07055_ _06985_ VSS VSS VDD VDD _07056_ sky130_fd_sc_hd__nand2b_1
X_10431_ net339 _07056_ VSS VSS VDD VDD _07057_ sky130_fd_sc_hd__nand2_1
X_10432_ network.in_period\[207\]\[1\] _07057_ VSS VSS VDD
+ VDD _07058_ sky130_fd_sc_hd__nand2_1
X_10433_ _00957_ _07057_ _07058_ VSS VSS VDD VDD _02892_ sky130_fd_sc_hd__o21ai_0
X_10434_ network.neuron_in207.counter\[0\] VSS VSS VDD VDD
+ _00954_ sky130_fd_sc_hd__inv_1
X_10435_ network.in_period\[207\]\[0\] _07057_ VSS VSS VDD
+ VDD _07059_ sky130_fd_sc_hd__nand2_1
X_10436_ network.neuron_in207.counter\[0\] _07057_ _07059_
+ VSS VSS VDD VDD _02891_ sky130_fd_sc_hd__o21ai_0
X_10437_ network.neuron_in090.counter\[0\] VSS VSS VDD VDD
+ _00643_ sky130_fd_sc_hd__inv_1
X_10438_ network.neuron_in048.counter\[0\] VSS VSS VDD VDD
+ _00299_ sky130_fd_sc_hd__inv_1
X_10439_ network.neuron_in219.counter\[2\] net340 VSS VSS
+ VDD VDD _07060_ sky130_fd_sc_hd__nand2_1
X_10440_ network.neuron_in219.counter\[3\] network.in_period\[219\]\[2\]
+ _07060_ VSS VSS VDD VDD _07061_ sky130_fd_sc_hd__o21ai_0
X_10441_ _01056_ network.neuron_in219.counter\[2\] net425
+ VSS VSS VDD VDD _07062_ sky130_fd_sc_hd__or3_1
X_10442_ network.in_period\[219\]\[2\] net340 _07062_ VSS
+ VSS VDD VDD _07063_ sky130_fd_sc_hd__o21ai_0
X_10443_ _01056_ _07061_ _07063_ VSS VSS VDD VDD _02941_ sky130_fd_sc_hd__a21oi_1
X_10444_ network.neuron_in214.counter\[2\] VSS VSS VDD VDD
+ _07064_ sky130_fd_sc_hd__inv_1
X_10445_ network.neuron_in214.counter\[3\] network.in_period\[214\]\[2\]
+ _00944_ net425 VSS VSS VDD VDD _07065_ sky130_fd_sc_hd__o22ai_1
X_10446_ network.neuron_in214.counter\[2\] _00944_ net344
+ VSS VSS VDD VDD _07066_ sky130_fd_sc_hd__nand3_1
X_10447_ network.in_period\[214\]\[2\] net343 _07066_ VSS
+ VSS VDD VDD _07067_ sky130_fd_sc_hd__o21ai_0
X_10448_ _07064_ _07065_ _07067_ VSS VSS VDD VDD _02921_ sky130_fd_sc_hd__a21oi_1
X_10449_ network.neuron_in218.counter\[0\] VSS VSS VDD VDD
+ _00938_ sky130_fd_sc_hd__inv_1
X_10450_ network.neuron_in218.counter\[2\] network.neuron_in218.counter\[3\]
+ VSS VSS VDD VDD _07068_ sky130_fd_sc_hd__nor2_1
X_10451_ _00940_ _07068_ VSS VSS VDD VDD _07069_ sky130_fd_sc_hd__nand2_1
X_10452_ net344 _07069_ VSS VSS VDD VDD _07070_ sky130_fd_sc_hd__nand2_1
X_10453_ network.in_period\[218\]\[0\] _07070_ VSS VSS VDD
+ VDD _07071_ sky130_fd_sc_hd__nand2_1
X_10454_ network.neuron_in218.counter\[0\] _07070_ _07071_
+ VSS VSS VDD VDD _02935_ sky130_fd_sc_hd__o21ai_0
X_10455_ network.neuron_in125.counter\[0\] VSS VSS VDD VDD
+ _00595_ sky130_fd_sc_hd__inv_1
X_10456_ network.in_period\[142\]\[1\] _07048_ VSS VSS VDD
+ VDD _07072_ sky130_fd_sc_hd__nand2_1
X_10457_ _00610_ _07048_ _07072_ VSS VSS VDD VDD _02632_ sky130_fd_sc_hd__o21ai_0
Xclkbuf_4_13__f_clk_net clknet_2_3_0_clk_net VSS VSS VDD VDD
+ clknet_4_13__leaf_clk_net sky130_fd_sc_hd__clkbuf_16
X_10459_ network.neuron_in211.counter\[3\] _01038_ VSS VSS
+ VDD VDD _07074_ sky130_fd_sc_hd__nand2b_1
X_10460_ network.neuron_in211.counter\[2\] VSS VSS VDD VDD
+ _07075_ sky130_fd_sc_hd__inv_1
X_10461_ _07074_ _07075_ VSS VSS VDD VDD _07076_ sky130_fd_sc_hd__nand2b_1
X_10462_ net343 _07076_ VSS VSS VDD VDD _07077_ sky130_fd_sc_hd__nand2_1
X_10463_ network.in_period\[211\]\[1\] _07077_ VSS VSS VDD
+ VDD _07078_ sky130_fd_sc_hd__nand2_1
X_10464_ _01039_ _07077_ _07078_ VSS VSS VDD VDD _02908_ sky130_fd_sc_hd__o21ai_0
X_10465_ network.neuron_in211.counter\[1\] VSS VSS VDD VDD
+ _01037_ sky130_fd_sc_hd__inv_1
X_10466_ network.neuron_in038.counter\[1\] VSS VSS VDD VDD
+ _00372_ sky130_fd_sc_hd__inv_1
X_10467_ network.neuron_in213.counter\[0\] VSS VSS VDD VDD
+ _01006_ sky130_fd_sc_hd__inv_1
X_10468_ network.neuron_in213.counter\[3\] _01008_ VSS VSS
+ VDD VDD _07079_ sky130_fd_sc_hd__nand2b_1
X_10469_ network.neuron_in213.counter\[2\] VSS VSS VDD VDD
+ _07080_ sky130_fd_sc_hd__inv_1
X_10470_ _07079_ _07080_ VSS VSS VDD VDD _07081_ sky130_fd_sc_hd__nand2b_1
X_10471_ net339 _07081_ VSS VSS VDD VDD _07082_ sky130_fd_sc_hd__nand2_1
X_10472_ network.in_period\[213\]\[0\] _07082_ VSS VSS VDD
+ VDD _07083_ sky130_fd_sc_hd__nand2_1
X_10473_ network.neuron_in213.counter\[0\] _07082_ _07083_
+ VSS VSS VDD VDD _02915_ sky130_fd_sc_hd__o21ai_0
X_10474_ network.neuron_in216.counter\[2\] VSS VSS VDD VDD
+ _07084_ sky130_fd_sc_hd__inv_1
X_10475_ network.neuron_in216.counter\[3\] network.in_period\[216\]\[2\]
+ _00511_ net424 VSS VSS VDD VDD _07085_ sky130_fd_sc_hd__o22ai_1
X_10476_ network.neuron_in216.counter\[2\] _00511_ net352
+ VSS VSS VDD VDD _07086_ sky130_fd_sc_hd__nand3_1
X_10477_ network.in_period\[216\]\[2\] net352 _07086_ VSS
+ VSS VDD VDD _07087_ sky130_fd_sc_hd__o21ai_0
X_10478_ _07084_ _07085_ _07087_ VSS VSS VDD VDD _02929_ sky130_fd_sc_hd__a21oi_1
X_10479_ network.in_period\[218\]\[1\] _07070_ VSS VSS VDD
+ VDD _07088_ sky130_fd_sc_hd__nand2_1
X_10480_ _00941_ _07070_ _07088_ VSS VSS VDD VDD _02936_ sky130_fd_sc_hd__o21ai_0
X_10481_ network.neuron_in222.counter\[1\] VSS VSS VDD VDD
+ _00820_ sky130_fd_sc_hd__inv_1
X_10482_ network.neuron_in133.counter\[0\] VSS VSS VDD VDD
+ _00098_ sky130_fd_sc_hd__inv_1
X_10483_ network.neuron_in133.counter\[2\] network.neuron_in133.counter\[3\]
+ VSS VSS VDD VDD _07089_ sky130_fd_sc_hd__nor2_1
X_10484_ _00100_ _07089_ VSS VSS VDD VDD _07090_ sky130_fd_sc_hd__nand2_1
X_10485_ net352 _07090_ VSS VSS VDD VDD _07091_ sky130_fd_sc_hd__nand2_1
X_10486_ network.in_period\[133\]\[0\] _07091_ VSS VSS VDD
+ VDD _07092_ sky130_fd_sc_hd__nand2_1
X_10487_ network.neuron_in133.counter\[0\] _07091_ _07092_
+ VSS VSS VDD VDD _02595_ sky130_fd_sc_hd__o21ai_0
X_10488_ network.neuron_in133.counter\[1\] VSS VSS VDD VDD
+ _00099_ sky130_fd_sc_hd__inv_1
X_10489_ network.neuron_in210.counter\[2\] VSS VSS VDD VDD
+ _07093_ sky130_fd_sc_hd__inv_1
X_10490_ network.neuron_in210.counter\[3\] network.in_period\[210\]\[2\]
+ _00321_ net425 VSS VSS VDD VDD _07094_ sky130_fd_sc_hd__o22ai_1
Xclkbuf_4_12__f_clk_net clknet_2_3_0_clk_net VSS VSS VDD VDD
+ clknet_4_12__leaf_clk_net sky130_fd_sc_hd__clkbuf_16
X_10492_ network.neuron_in210.counter\[2\] _00321_ net344
+ VSS VSS VDD VDD _07096_ sky130_fd_sc_hd__nand3_1
X_10493_ network.in_period\[210\]\[2\] net344 _07096_ VSS
+ VSS VDD VDD _07097_ sky130_fd_sc_hd__o21ai_0
X_10494_ _07093_ _07094_ _07097_ VSS VSS VDD VDD _02905_ sky130_fd_sc_hd__a21oi_1
Xclkbuf_4_11__f_clk_net clknet_2_2_0_clk_net VSS VSS VDD VDD
+ clknet_4_11__leaf_clk_net sky130_fd_sc_hd__clkbuf_16
X_10496_ network.neuron_in211.counter\[3\] network.in_period\[211\]\[2\]
+ _01038_ net425 VSS VSS VDD VDD _07099_ sky130_fd_sc_hd__o22ai_1
X_10497_ network.neuron_in211.counter\[2\] _01038_ net343
+ VSS VSS VDD VDD _07100_ sky130_fd_sc_hd__nand3_1
X_10498_ network.in_period\[211\]\[2\] net343 _07100_ VSS
+ VSS VDD VDD _07101_ sky130_fd_sc_hd__o21ai_0
X_10499_ _07075_ _07099_ _07101_ VSS VSS VDD VDD _02909_ sky130_fd_sc_hd__a21oi_1
X_10500_ network.neuron_hid2.IF0.ref_counter\[1\] VSS VSS
+ VDD VDD _00155_ sky130_fd_sc_hd__inv_1
X_10501_ network.neuron_in212.counter\[3\] _00343_ VSS VSS
+ VDD VDD _07102_ sky130_fd_sc_hd__nand2b_1
X_10502_ network.neuron_in212.counter\[2\] _07102_ VSS VSS
+ VDD VDD _07103_ sky130_fd_sc_hd__or2_2
X_10503_ net344 _07103_ VSS VSS VDD VDD _07104_ sky130_fd_sc_hd__nand2_1
X_10504_ network.in_period\[212\]\[1\] _07104_ VSS VSS VDD
+ VDD _07105_ sky130_fd_sc_hd__nand2_1
X_10505_ _00344_ _07104_ _07105_ VSS VSS VDD VDD _02912_ sky130_fd_sc_hd__o21ai_0
X_10506_ network.in_period\[213\]\[1\] _07082_ VSS VSS VDD
+ VDD _07106_ sky130_fd_sc_hd__nand2_1
X_10507_ _01009_ _07082_ _07106_ VSS VSS VDD VDD _02916_ sky130_fd_sc_hd__o21ai_0
X_10508_ network.neuron_in215.counter\[2\] VSS VSS VDD VDD
+ _07107_ sky130_fd_sc_hd__inv_1
X_10509_ network.neuron_in215.counter\[3\] network.in_period\[215\]\[2\]
+ _01184_ net424 VSS VSS VDD VDD _07108_ sky130_fd_sc_hd__o22ai_1
X_10510_ network.neuron_in215.counter\[2\] _01184_ net343
+ VSS VSS VDD VDD _07109_ sky130_fd_sc_hd__nand3_1
X_10511_ network.in_period\[215\]\[2\] net343 _07109_ VSS
+ VSS VDD VDD _07110_ sky130_fd_sc_hd__o21ai_0
X_10512_ _07107_ _07108_ _07110_ VSS VSS VDD VDD _02925_ sky130_fd_sc_hd__a21oi_1
Xclkbuf_4_10__f_clk_net clknet_2_2_0_clk_net VSS VSS VDD VDD
+ clknet_4_10__leaf_clk_net sky130_fd_sc_hd__clkbuf_16
X_10514_ network.neuron_in129.counter\[2\] net351 VSS VSS
+ VDD VDD _07112_ sky130_fd_sc_hd__nand2_1
X_10515_ network.in_period\[129\]\[2\] network.neuron_in129.counter\[3\]
+ _07112_ VSS VSS VDD VDD _07113_ sky130_fd_sc_hd__o21ai_0
X_10516_ _00589_ network.neuron_in129.counter\[2\] net421
+ VSS VSS VDD VDD _07114_ sky130_fd_sc_hd__or3_1
X_10517_ network.in_period\[129\]\[2\] net351 _07114_ VSS
+ VSS VDD VDD _07115_ sky130_fd_sc_hd__o21ai_0
X_10518_ _00589_ _07113_ _07115_ VSS VSS VDD VDD _02581_ sky130_fd_sc_hd__a21oi_1
X_10519_ network.neuron_in149.counter\[0\] VSS VSS VDD VDD
+ _00583_ sky130_fd_sc_hd__inv_1
X_10520_ network.neuron_in198.counter\[1\] VSS VSS VDD VDD
+ _00380_ sky130_fd_sc_hd__inv_1
X_10521_ network.neuron_in215.counter\[0\] VSS VSS VDD VDD
+ _01182_ sky130_fd_sc_hd__inv_1
X_10522_ network.neuron_in215.counter\[3\] _01184_ VSS VSS
+ VDD VDD _07116_ sky130_fd_sc_hd__nand2b_1
X_10523_ _07116_ _07107_ VSS VSS VDD VDD _07117_ sky130_fd_sc_hd__nand2b_1
X_10524_ net343 _07117_ VSS VSS VDD VDD _07118_ sky130_fd_sc_hd__nand2_1
X_10525_ network.in_period\[215\]\[0\] _07118_ VSS VSS VDD
+ VDD _07119_ sky130_fd_sc_hd__nand2_1
X_10526_ network.neuron_in215.counter\[0\] _07118_ _07119_
+ VSS VSS VDD VDD _02923_ sky130_fd_sc_hd__o21ai_0
X_10527_ network.neuron_in217.counter\[2\] VSS VSS VDD VDD
+ _07120_ sky130_fd_sc_hd__inv_1
X_10528_ network.neuron_in217.counter\[3\] network.in_period\[217\]\[2\]
+ _01016_ net424 VSS VSS VDD VDD _07121_ sky130_fd_sc_hd__o22ai_1
Xclkbuf_4_9__f_clk_net clknet_2_2_0_clk_net VSS VSS VDD VDD
+ clknet_4_9__leaf_clk_net sky130_fd_sc_hd__clkbuf_16
X_10530_ network.neuron_in217.counter\[2\] _01016_ net343
+ VSS VSS VDD VDD _07123_ sky130_fd_sc_hd__nand3_1
X_10531_ network.in_period\[217\]\[2\] net343 _07123_ VSS
+ VSS VDD VDD _07124_ sky130_fd_sc_hd__o21ai_0
X_10532_ _07120_ _07121_ _07124_ VSS VSS VDD VDD _02933_ sky130_fd_sc_hd__a21oi_1
X_10533_ network.neuron_in218.counter\[2\] VSS VSS VDD VDD
+ _07125_ sky130_fd_sc_hd__inv_1
X_10534_ network.neuron_in218.counter\[3\] network.in_period\[218\]\[2\]
+ _00940_ net425 VSS VSS VDD VDD _07126_ sky130_fd_sc_hd__o22ai_1
X_10535_ network.neuron_in218.counter\[2\] _00940_ net344
+ VSS VSS VDD VDD _07127_ sky130_fd_sc_hd__nand3_1
X_10536_ network.in_period\[218\]\[2\] net344 _07127_ VSS
+ VSS VDD VDD _07128_ sky130_fd_sc_hd__o21ai_0
X_10537_ _07125_ _07126_ _07128_ VSS VSS VDD VDD _02937_ sky130_fd_sc_hd__a21oi_1
X_10538_ network.neuron_in209.counter\[2\] _01172_ VSS VSS
+ VDD VDD _07129_ sky130_fd_sc_hd__nand2b_1
X_10539_ network.neuron_in209.counter\[3\] _07129_ VSS VSS
+ VDD VDD _07130_ sky130_fd_sc_hd__or2_2
X_10540_ net343 _07130_ VSS VSS VDD VDD _07131_ sky130_fd_sc_hd__nand2_1
X_10541_ network.in_period\[209\]\[1\] _07131_ VSS VSS VDD
+ VDD _07132_ sky130_fd_sc_hd__nand2_1
X_10542_ _01173_ _07131_ _07132_ VSS VSS VDD VDD _02900_ sky130_fd_sc_hd__o21ai_0
X_10543_ network.neuron_in209.counter\[0\] VSS VSS VDD VDD
+ _01170_ sky130_fd_sc_hd__inv_1
X_10544_ network.in_period\[209\]\[0\] _07131_ VSS VSS VDD
+ VDD _07133_ sky130_fd_sc_hd__nand2_1
X_10545_ network.neuron_in209.counter\[0\] _07131_ _07133_
+ VSS VSS VDD VDD _02899_ sky130_fd_sc_hd__o21ai_0
X_10546_ network.neuron_in210.counter\[2\] network.neuron_in210.counter\[3\]
+ VSS VSS VDD VDD _07134_ sky130_fd_sc_hd__nor2_1
X_10547_ _00321_ _07134_ VSS VSS VDD VDD _07135_ sky130_fd_sc_hd__nand2_1
X_10548_ net344 _07135_ VSS VSS VDD VDD _07136_ sky130_fd_sc_hd__nand2_1
X_10549_ network.in_period\[210\]\[1\] _07136_ VSS VSS VDD
+ VDD _07137_ sky130_fd_sc_hd__nand2_1
X_10550_ _00322_ _07136_ _07137_ VSS VSS VDD VDD _02904_ sky130_fd_sc_hd__o21ai_0
X_10551_ network.neuron_in211.counter\[0\] VSS VSS VDD VDD
+ _01036_ sky130_fd_sc_hd__inv_1
X_10552_ network.neuron_in210.counter\[0\] VSS VSS VDD VDD
+ _00319_ sky130_fd_sc_hd__inv_1
X_10553_ network.in_period\[210\]\[0\] _07136_ VSS VSS VDD
+ VDD _07138_ sky130_fd_sc_hd__nand2_1
X_10554_ network.neuron_in210.counter\[0\] _07136_ _07138_
+ VSS VSS VDD VDD _02903_ sky130_fd_sc_hd__o21ai_0
X_10555_ network.in_period\[211\]\[0\] _07077_ VSS VSS VDD
+ VDD _07139_ sky130_fd_sc_hd__nand2_1
X_10556_ network.neuron_in211.counter\[0\] _07077_ _07139_
+ VSS VSS VDD VDD _02907_ sky130_fd_sc_hd__o21ai_0
X_10557_ network.neuron_in212.counter\[2\] net344 VSS VSS
+ VDD VDD _07140_ sky130_fd_sc_hd__nand2_1
X_10558_ network.neuron_in212.counter\[3\] network.in_period\[212\]\[2\]
+ _07140_ VSS VSS VDD VDD _07141_ sky130_fd_sc_hd__o21ai_0
X_10559_ _00343_ network.neuron_in212.counter\[2\] net425
+ VSS VSS VDD VDD _07142_ sky130_fd_sc_hd__or3_1
X_10560_ network.in_period\[212\]\[2\] net344 _07142_ VSS
+ VSS VDD VDD _07143_ sky130_fd_sc_hd__o21ai_0
X_10561_ _00343_ _07141_ _07143_ VSS VSS VDD VDD _02913_ sky130_fd_sc_hd__a21oi_1
X_10562_ network.neuron_in037.counter\[1\] VSS VSS VDD VDD
+ _00392_ sky130_fd_sc_hd__inv_1
X_10563_ network.neuron_in071.counter\[0\] VSS VSS VDD VDD
+ _00147_ sky130_fd_sc_hd__inv_1
X_10564_ network.neuron_in212.counter\[0\] VSS VSS VDD VDD
+ _00341_ sky130_fd_sc_hd__inv_1
X_10565_ network.in_period\[212\]\[0\] _07104_ VSS VSS VDD
+ VDD _07144_ sky130_fd_sc_hd__nand2_1
X_10566_ network.neuron_in212.counter\[0\] _07104_ _07144_
+ VSS VSS VDD VDD _02911_ sky130_fd_sc_hd__o21ai_0
X_10567_ network.neuron_in213.counter\[3\] network.in_period\[213\]\[2\]
+ _01008_ net425 VSS VSS VDD VDD _07145_ sky130_fd_sc_hd__o22ai_1
X_10568_ network.neuron_in213.counter\[2\] _01008_ net339
+ VSS VSS VDD VDD _07146_ sky130_fd_sc_hd__nand3_1
X_10569_ network.in_period\[213\]\[2\] net339 _07146_ VSS
+ VSS VDD VDD _07147_ sky130_fd_sc_hd__o21ai_0
X_10570_ _07080_ _07145_ _07147_ VSS VSS VDD VDD _02917_ sky130_fd_sc_hd__a21oi_1
X_10571_ network.neuron_in078.counter\[0\] VSS VSS VDD VDD
+ _00102_ sky130_fd_sc_hd__inv_1
X_10572_ network.neuron_in094.counter\[0\] VSS VSS VDD VDD
+ _01232_ sky130_fd_sc_hd__inv_1
X_10573_ network.neuron_in214.counter\[2\] network.neuron_in214.counter\[3\]
+ VSS VSS VDD VDD _07148_ sky130_fd_sc_hd__nor2_1
X_10574_ _00944_ _07148_ VSS VSS VDD VDD _07149_ sky130_fd_sc_hd__nand2_1
X_10575_ net344 _07149_ VSS VSS VDD VDD _07150_ sky130_fd_sc_hd__nand2_1
X_10576_ network.in_period\[214\]\[1\] _07150_ VSS VSS VDD
+ VDD _07151_ sky130_fd_sc_hd__nand2_1
X_10577_ _00945_ _07150_ _07151_ VSS VSS VDD VDD _02920_ sky130_fd_sc_hd__o21ai_0
X_10578_ network.neuron_in128.counter\[1\] VSS VSS VDD VDD
+ _01033_ sky130_fd_sc_hd__inv_1
X_10579_ net421 _07046_ VSS VSS VDD VDD _07152_ sky130_fd_sc_hd__nor2_1
X_10580_ network.neuron_in142.counter\[2\] _00609_ VSS VSS
+ VDD VDD _07153_ sky130_fd_sc_hd__xnor2_1
X_10581_ network.in_period\[142\]\[2\] _07152_ _07153_ net360
+ VSS VSS VDD VDD _02633_ sky130_fd_sc_hd__a2bb2oi_1
X_10582_ network.neuron_in141.counter\[0\] VSS VSS VDD VDD
+ _00259_ sky130_fd_sc_hd__inv_1
X_10583_ network.neuron_in141.counter\[2\] network.neuron_in141.counter\[3\]
+ VSS VSS VDD VDD _07154_ sky130_fd_sc_hd__nor2_1
X_10584_ _00261_ _07154_ VSS VSS VDD VDD _07155_ sky130_fd_sc_hd__nand2_1
X_10585_ net352 _07155_ VSS VSS VDD VDD _07156_ sky130_fd_sc_hd__nand2_1
X_10586_ network.in_period\[141\]\[0\] _07156_ VSS VSS VDD
+ VDD _07157_ sky130_fd_sc_hd__nand2_1
X_10587_ network.neuron_in141.counter\[0\] _07156_ _07157_
+ VSS VSS VDD VDD _02627_ sky130_fd_sc_hd__o21ai_0
X_10588_ network.neuron_in214.counter\[0\] VSS VSS VDD VDD
+ _00942_ sky130_fd_sc_hd__inv_1
X_10589_ network.in_period\[214\]\[0\] _07150_ VSS VSS VDD
+ VDD _07158_ sky130_fd_sc_hd__nand2_1
X_10590_ network.neuron_in214.counter\[0\] _07150_ _07158_
+ VSS VSS VDD VDD _02919_ sky130_fd_sc_hd__o21ai_0
X_10591_ network.neuron_in080.counter\[1\] VSS VSS VDD VDD
+ _00085_ sky130_fd_sc_hd__inv_1
X_10592_ network.neuron_in055.counter\[0\] VSS VSS VDD VDD
+ _00263_ sky130_fd_sc_hd__inv_1
X_10593_ network.neuron_in138.counter\[1\] VSS VSS VDD VDD
+ _00656_ sky130_fd_sc_hd__inv_1
X_10594_ network.in_period\[215\]\[1\] _07118_ VSS VSS VDD
+ VDD _07159_ sky130_fd_sc_hd__nand2_1
X_10595_ _01185_ _07118_ _07159_ VSS VSS VDD VDD _02924_ sky130_fd_sc_hd__o21ai_0
X_10596_ network.neuron_in091.counter\[1\] VSS VSS VDD VDD
+ _00144_ sky130_fd_sc_hd__inv_1
X_10597_ _07084_ _00511_ VSS VSS VDD VDD _07160_ sky130_fd_sc_hd__nand2_1
X_10598_ network.neuron_in216.counter\[3\] _07160_ VSS VSS
+ VDD VDD _07161_ sky130_fd_sc_hd__or2_2
X_10599_ net352 _07161_ VSS VSS VDD VDD _07162_ sky130_fd_sc_hd__nand2_1
X_10600_ network.in_period\[216\]\[1\] _07162_ VSS VSS VDD
+ VDD _07163_ sky130_fd_sc_hd__nand2_1
X_10601_ _00512_ _07162_ _07163_ VSS VSS VDD VDD _02928_ sky130_fd_sc_hd__o21ai_0
X_10602_ network.in_period\[216\]\[0\] _07162_ VSS VSS VDD
+ VDD _07164_ sky130_fd_sc_hd__nand2_1
X_10603_ network.neuron_in216.counter\[0\] _07162_ _07164_
+ VSS VSS VDD VDD _02927_ sky130_fd_sc_hd__o21ai_0
X_10604_ network.neuron_in217.counter\[3\] _01016_ VSS VSS
+ VDD VDD _07165_ sky130_fd_sc_hd__nand2b_1
X_10605_ _07165_ _07120_ VSS VSS VDD VDD _07166_ sky130_fd_sc_hd__nand2b_1
X_10606_ net343 _07166_ VSS VSS VDD VDD _07167_ sky130_fd_sc_hd__nand2_1
X_10607_ network.in_period\[217\]\[1\] _07167_ VSS VSS VDD
+ VDD _07168_ sky130_fd_sc_hd__nand2_1
X_10608_ _01017_ _07167_ _07168_ VSS VSS VDD VDD _02932_ sky130_fd_sc_hd__o21ai_0
X_10609_ network.neuron_in217.counter\[0\] VSS VSS VDD VDD
+ _01014_ sky130_fd_sc_hd__inv_1
X_10610_ network.in_period\[217\]\[0\] _07167_ VSS VSS VDD
+ VDD _07169_ sky130_fd_sc_hd__nand2_1
X_10611_ network.neuron_in217.counter\[0\] _07167_ _07169_
+ VSS VSS VDD VDD _02931_ sky130_fd_sc_hd__o21ai_0
X_10612_ network.neuron_in229.counter\[2\] VSS VSS VDD VDD
+ _07170_ sky130_fd_sc_hd__inv_1
X_10613_ network.neuron_in229.counter\[3\] network.in_period\[229\]\[2\]
+ _00932_ net412 VSS VSS VDD VDD _07171_ sky130_fd_sc_hd__o22ai_1
X_10614_ network.neuron_in229.counter\[2\] _00932_ net358
+ VSS VSS VDD VDD _07172_ sky130_fd_sc_hd__nand3_1
X_10615_ network.in_period\[229\]\[2\] net358 _07172_ VSS
+ VSS VDD VDD _07173_ sky130_fd_sc_hd__o21ai_0
X_10616_ _07170_ _07171_ _07173_ VSS VSS VDD VDD _02981_ sky130_fd_sc_hd__a21oi_1
X_10617_ network.neuron_in200.counter\[1\] VSS VSS VDD VDD
+ _00296_ sky130_fd_sc_hd__inv_1
X_10618_ network.neuron_in224.counter\[2\] VSS VSS VDD VDD
+ _07174_ sky130_fd_sc_hd__inv_1
X_10619_ network.neuron_in224.counter\[3\] network.in_period\[224\]\[2\]
+ _00813_ net416 VSS VSS VDD VDD _07175_ sky130_fd_sc_hd__o22ai_1
X_10620_ network.neuron_in224.counter\[2\] _00813_ net347
+ VSS VSS VDD VDD _07176_ sky130_fd_sc_hd__nand3_1
X_10621_ network.in_period\[224\]\[2\] net347 _07176_ VSS
+ VSS VDD VDD _07177_ sky130_fd_sc_hd__o21ai_0
X_10622_ _07174_ _07175_ _07177_ VSS VSS VDD VDD _02961_ sky130_fd_sc_hd__a21oi_1
X_10623_ network.neuron_in228.counter\[0\] VSS VSS VDD VDD
+ _01092_ sky130_fd_sc_hd__inv_1
X_10624_ network.neuron_in228.counter\[3\] _01094_ VSS VSS
+ VDD VDD _07178_ sky130_fd_sc_hd__nand2b_1
X_10625_ network.neuron_in228.counter\[2\] _07178_ VSS VSS
+ VDD VDD _07179_ sky130_fd_sc_hd__or2_2
X_10626_ net347 _07179_ VSS VSS VDD VDD _07180_ sky130_fd_sc_hd__nand2_1
X_10627_ network.in_period\[228\]\[0\] _07180_ VSS VSS VDD
+ VDD _07181_ sky130_fd_sc_hd__nand2_1
X_10628_ network.neuron_in228.counter\[0\] _07180_ _07181_
+ VSS VSS VDD VDD _02975_ sky130_fd_sc_hd__o21ai_0
X_10629_ network.neuron_in036.counter\[1\] VSS VSS VDD VDD
+ _00400_ sky130_fd_sc_hd__inv_1
X_10630_ network.neuron_in125.counter\[1\] VSS VSS VDD VDD
+ _00596_ sky130_fd_sc_hd__inv_1
X_10631_ network.neuron_in221.counter\[2\] network.neuron_in221.counter\[3\]
+ VSS VSS VDD VDD _07182_ sky130_fd_sc_hd__nor2_1
X_10632_ _01042_ _07182_ VSS VSS VDD VDD _07183_ sky130_fd_sc_hd__nand2_1
X_10633_ net344 _07183_ VSS VSS VDD VDD _07184_ sky130_fd_sc_hd__nand2_1
X_10634_ network.in_period\[221\]\[1\] _07184_ VSS VSS VDD
+ VDD _07185_ sky130_fd_sc_hd__nand2_1
X_10635_ _01043_ _07184_ _07185_ VSS VSS VDD VDD _02948_ sky130_fd_sc_hd__o21ai_0
X_10636_ network.neuron_in223.counter\[0\] VSS VSS VDD VDD
+ _00864_ sky130_fd_sc_hd__inv_1
X_10637_ network.neuron_in223.counter\[3\] _00866_ VSS VSS
+ VDD VDD _07186_ sky130_fd_sc_hd__nand2b_1
X_10638_ network.neuron_in223.counter\[2\] VSS VSS VDD VDD
+ _07187_ sky130_fd_sc_hd__inv_1
X_10639_ _07186_ _07187_ VSS VSS VDD VDD _07188_ sky130_fd_sc_hd__nand2b_1
X_10640_ net339 _07188_ VSS VSS VDD VDD _07189_ sky130_fd_sc_hd__nand2_1
X_10641_ network.in_period\[223\]\[0\] _07189_ VSS VSS VDD
+ VDD _07190_ sky130_fd_sc_hd__nand2_1
X_10642_ network.neuron_in223.counter\[0\] _07189_ _07190_
+ VSS VSS VDD VDD _02955_ sky130_fd_sc_hd__o21ai_0
X_10643_ network.neuron_in226.counter\[2\] VSS VSS VDD VDD
+ _07191_ sky130_fd_sc_hd__inv_1
X_10644_ network.neuron_in226.counter\[3\] network.in_period\[226\]\[2\]
+ _00817_ net416 VSS VSS VDD VDD _07192_ sky130_fd_sc_hd__o22ai_1
X_10645_ network.neuron_in226.counter\[2\] _00817_ net347
+ VSS VSS VDD VDD _07193_ sky130_fd_sc_hd__nand3_1
X_10646_ network.in_period\[226\]\[2\] net347 _07193_ VSS
+ VSS VDD VDD _07194_ sky130_fd_sc_hd__o21ai_0
X_10647_ _07191_ _07192_ _07194_ VSS VSS VDD VDD _02969_ sky130_fd_sc_hd__a21oi_1
X_10648_ network.in_period\[228\]\[1\] _07180_ VSS VSS VDD
+ VDD _07195_ sky130_fd_sc_hd__nand2_1
X_10649_ _01095_ _07180_ _07195_ VSS VSS VDD VDD _02976_ sky130_fd_sc_hd__o21ai_0
X_10650_ network.neuron_in220.counter\[2\] VSS VSS VDD VDD
+ _07196_ sky130_fd_sc_hd__inv_1
X_10651_ network.neuron_in220.counter\[3\] network.in_period\[220\]\[2\]
+ _00924_ net425 VSS VSS VDD VDD _07197_ sky130_fd_sc_hd__o22ai_1
X_10652_ network.neuron_in220.counter\[2\] _00924_ net344
+ VSS VSS VDD VDD _07198_ sky130_fd_sc_hd__nand3_1
X_10653_ network.in_period\[220\]\[2\] net344 _07198_ VSS
+ VSS VDD VDD _07199_ sky130_fd_sc_hd__o21ai_0
X_10654_ _07196_ _07197_ _07199_ VSS VSS VDD VDD _02945_ sky130_fd_sc_hd__a21oi_1
X_10655_ network.neuron_in221.counter\[2\] net344 VSS VSS
+ VDD VDD _07200_ sky130_fd_sc_hd__nand2_1
X_10656_ network.neuron_in221.counter\[3\] network.in_period\[221\]\[2\]
+ _07200_ VSS VSS VDD VDD _07201_ sky130_fd_sc_hd__o21ai_0
X_10657_ _01042_ network.neuron_in221.counter\[2\] net425
+ VSS VSS VDD VDD _07202_ sky130_fd_sc_hd__or3_1
X_10658_ network.in_period\[221\]\[2\] net344 _07202_ VSS
+ VSS VDD VDD _07203_ sky130_fd_sc_hd__o21ai_0
X_10659_ _01042_ _07201_ _07203_ VSS VSS VDD VDD _02949_ sky130_fd_sc_hd__a21oi_1
X_10660_ network.neuron_in222.counter\[3\] _00821_ VSS VSS
+ VDD VDD _07204_ sky130_fd_sc_hd__nand2b_1
X_10661_ network.neuron_in222.counter\[2\] VSS VSS VDD VDD
+ _07205_ sky130_fd_sc_hd__inv_1
X_10662_ _07204_ _07205_ VSS VSS VDD VDD _07206_ sky130_fd_sc_hd__nand2b_1
X_10663_ net344 _07206_ VSS VSS VDD VDD _07207_ sky130_fd_sc_hd__nand2_1
X_10664_ network.in_period\[222\]\[1\] _07207_ VSS VSS VDD
+ VDD _07208_ sky130_fd_sc_hd__nand2_1
X_10665_ _00822_ _07207_ _07208_ VSS VSS VDD VDD _02952_ sky130_fd_sc_hd__o21ai_0
X_10666_ network.in_period\[223\]\[1\] _07189_ VSS VSS VDD
+ VDD _07209_ sky130_fd_sc_hd__nand2_1
X_10667_ _00867_ _07189_ _07209_ VSS VSS VDD VDD _02956_ sky130_fd_sc_hd__o21ai_0
X_10668_ network.neuron_in147.counter\[1\] VSS VSS VDD VDD
+ _01195_ sky130_fd_sc_hd__inv_1
X_10669_ network.neuron_in225.counter\[2\] VSS VSS VDD VDD
+ _07210_ sky130_fd_sc_hd__inv_1
X_10670_ network.neuron_in225.counter\[3\] network.in_period\[225\]\[2\]
+ _00359_ net417 VSS VSS VDD VDD _07211_ sky130_fd_sc_hd__o22ai_1
Xclkbuf_4_8__f_clk_net clknet_2_2_0_clk_net VSS VSS VDD VDD
+ clknet_4_8__leaf_clk_net sky130_fd_sc_hd__clkbuf_16
X_10672_ network.neuron_in225.counter\[2\] _00359_ net348
+ VSS VSS VDD VDD _07213_ sky130_fd_sc_hd__nand3_1
X_10673_ network.in_period\[225\]\[2\] net348 _07213_ VSS
+ VSS VDD VDD _07214_ sky130_fd_sc_hd__o21ai_0
X_10674_ _07210_ _07211_ _07214_ VSS VSS VDD VDD _02965_ sky130_fd_sc_hd__a21oi_1
X_10675_ network.neuron_in225.counter\[0\] VSS VSS VDD VDD
+ _00357_ sky130_fd_sc_hd__inv_1
Xclkbuf_4_7__f_clk_net clknet_2_1_0_clk_net VSS VSS VDD VDD
+ clknet_4_7__leaf_clk_net sky130_fd_sc_hd__clkbuf_16
X_10677_ network.neuron_in225.counter\[3\] _00359_ VSS VSS
+ VDD VDD _07216_ sky130_fd_sc_hd__nand2b_1
X_10678_ _07216_ _07210_ VSS VSS VDD VDD _07217_ sky130_fd_sc_hd__nand2b_1
X_10679_ net348 _07217_ VSS VSS VDD VDD _07218_ sky130_fd_sc_hd__nand2_1
X_10680_ network.in_period\[225\]\[0\] _07218_ VSS VSS VDD
+ VDD _07219_ sky130_fd_sc_hd__nand2_1
X_10681_ network.neuron_in225.counter\[0\] _07218_ _07219_
+ VSS VSS VDD VDD _02963_ sky130_fd_sc_hd__o21ai_0
X_10682_ network.neuron_in227.counter\[2\] VSS VSS VDD VDD
+ _07220_ sky130_fd_sc_hd__inv_1
Xclkbuf_4_6__f_clk_net clknet_2_1_0_clk_net VSS VSS VDD VDD
+ clknet_4_6__leaf_clk_net sky130_fd_sc_hd__clkbuf_16
X_10684_ network.neuron_in227.counter\[3\] network.in_period\[227\]\[2\]
+ _00625_ net416 VSS VSS VDD VDD _07222_ sky130_fd_sc_hd__o22ai_1
Xclkbuf_4_5__f_clk_net clknet_2_1_0_clk_net VSS VSS VDD VDD
+ clknet_4_5__leaf_clk_net sky130_fd_sc_hd__clkbuf_16
X_10686_ network.neuron_in227.counter\[2\] _00625_ net348
+ VSS VSS VDD VDD _07224_ sky130_fd_sc_hd__nand3_1
X_10687_ network.in_period\[227\]\[2\] net348 _07224_ VSS
+ VSS VDD VDD _07225_ sky130_fd_sc_hd__o21ai_0
X_10688_ _07220_ _07222_ _07225_ VSS VSS VDD VDD _02973_ sky130_fd_sc_hd__a21oi_1
X_10689_ network.neuron_in083.counter\[0\] VSS VSS VDD VDD
+ _00058_ sky130_fd_sc_hd__inv_1
X_10690_ network.neuron_in128.counter\[0\] VSS VSS VDD VDD
+ _01032_ sky130_fd_sc_hd__inv_1
X_10691_ network.neuron_in228.counter\[2\] net347 VSS VSS
+ VDD VDD _07226_ sky130_fd_sc_hd__nand2_1
X_10692_ network.neuron_in228.counter\[3\] network.in_period\[228\]\[2\]
+ _07226_ VSS VSS VDD VDD _07227_ sky130_fd_sc_hd__o21ai_0
X_10693_ _01094_ network.neuron_in228.counter\[2\] net417
+ VSS VSS VDD VDD _07228_ sky130_fd_sc_hd__or3_1
X_10694_ network.in_period\[228\]\[2\] net347 _07228_ VSS
+ VSS VDD VDD _07229_ sky130_fd_sc_hd__o21ai_0
X_10695_ _01094_ _07227_ _07229_ VSS VSS VDD VDD _02977_ sky130_fd_sc_hd__a21oi_1
X_10696_ network.neuron_in219.counter\[2\] network.neuron_in219.counter\[3\]
+ VSS VSS VDD VDD _07230_ sky130_fd_sc_hd__nor2_1
X_10697_ _01056_ _07230_ VSS VSS VDD VDD _07231_ sky130_fd_sc_hd__nand2_1
X_10698_ net340 _07231_ VSS VSS VDD VDD _07232_ sky130_fd_sc_hd__nand2_1
X_10699_ network.in_period\[219\]\[1\] _07232_ VSS VSS VDD
+ VDD _07233_ sky130_fd_sc_hd__nand2_1
X_10700_ _01057_ _07232_ _07233_ VSS VSS VDD VDD _02940_ sky130_fd_sc_hd__o21ai_0
X_10701_ network.neuron_hid1.IF0.ref_counter\[1\] VSS VSS
+ VDD VDD _01129_ sky130_fd_sc_hd__inv_1
X_10702_ network.neuron_in007.counter\[0\] VSS VSS VDD VDD
+ _00599_ sky130_fd_sc_hd__inv_1
X_10703_ network.in_period\[219\]\[0\] _07232_ VSS VSS VDD
+ VDD _07234_ sky130_fd_sc_hd__nand2_1
X_10704_ network.neuron_in219.counter\[0\] _07232_ _07234_
+ VSS VSS VDD VDD _02939_ sky130_fd_sc_hd__o21ai_0
X_10705_ network.neuron_in220.counter\[3\] _00924_ VSS VSS
+ VDD VDD _07235_ sky130_fd_sc_hd__nand2b_1
X_10706_ _07235_ _07196_ VSS VSS VDD VDD _07236_ sky130_fd_sc_hd__nand2b_1
X_10707_ net344 _07236_ VSS VSS VDD VDD _07237_ sky130_fd_sc_hd__nand2_1
X_10708_ network.in_period\[220\]\[1\] _07237_ VSS VSS VDD
+ VDD _07238_ sky130_fd_sc_hd__nand2_1
X_10709_ _00925_ _07237_ _07238_ VSS VSS VDD VDD _02944_ sky130_fd_sc_hd__o21ai_0
X_10710_ network.neuron_in220.counter\[0\] VSS VSS VDD VDD
+ _00922_ sky130_fd_sc_hd__inv_1
X_10711_ network.in_period\[220\]\[0\] _07237_ VSS VSS VDD
+ VDD _07239_ sky130_fd_sc_hd__nand2_1
X_10712_ network.neuron_in220.counter\[0\] _07237_ _07239_
+ VSS VSS VDD VDD _02943_ sky130_fd_sc_hd__o21ai_0
X_10713_ network.neuron_in086.counter\[0\] VSS VSS VDD VDD
+ _00038_ sky130_fd_sc_hd__inv_1
X_10714_ network.neuron_in157.counter\[3\] _00736_ VSS VSS
+ VDD VDD _07240_ sky130_fd_sc_hd__nand2b_1
X_10715_ network.neuron_in157.counter\[2\] VSS VSS VDD VDD
+ _07241_ sky130_fd_sc_hd__inv_1
X_10716_ _07240_ _07241_ VSS VSS VDD VDD _07242_ sky130_fd_sc_hd__nand2b_1
X_10717_ net354 _07242_ VSS VSS VDD VDD _07243_ sky130_fd_sc_hd__nand2_1
X_10718_ network.in_period\[157\]\[1\] _07243_ VSS VSS VDD
+ VDD _07244_ sky130_fd_sc_hd__nand2_1
X_10719_ _00737_ _07243_ _07244_ VSS VSS VDD VDD _02692_ sky130_fd_sc_hd__o21ai_0
X_10720_ network.neuron_in035.counter\[1\] VSS VSS VDD VDD
+ _00416_ sky130_fd_sc_hd__inv_1
X_10721_ network.in_period\[221\]\[0\] _07184_ VSS VSS VDD
+ VDD _07245_ sky130_fd_sc_hd__nand2_1
X_10722_ network.neuron_in221.counter\[0\] _07184_ _07245_
+ VSS VSS VDD VDD _02947_ sky130_fd_sc_hd__o21ai_0
X_10723_ network.neuron_in222.counter\[3\] network.in_period\[222\]\[2\]
+ _00821_ net425 VSS VSS VDD VDD _07246_ sky130_fd_sc_hd__o22ai_1
X_10724_ network.neuron_in222.counter\[2\] _00821_ net344
+ VSS VSS VDD VDD _07247_ sky130_fd_sc_hd__nand3_1
X_10725_ network.in_period\[222\]\[2\] net344 _07247_ VSS
+ VSS VDD VDD _07248_ sky130_fd_sc_hd__o21ai_0
X_10726_ _07205_ _07246_ _07248_ VSS VSS VDD VDD _02953_ sky130_fd_sc_hd__a21oi_1
X_10727_ network.neuron_in082.counter\[1\] VSS VSS VDD VDD
+ _00055_ sky130_fd_sc_hd__inv_1
X_10728_ network.neuron_in222.counter\[0\] VSS VSS VDD VDD
+ _00819_ sky130_fd_sc_hd__inv_1
X_10729_ network.in_period\[222\]\[0\] _07207_ VSS VSS VDD
+ VDD _07249_ sky130_fd_sc_hd__nand2_1
X_10730_ network.neuron_in222.counter\[0\] _07207_ _07249_
+ VSS VSS VDD VDD _02951_ sky130_fd_sc_hd__o21ai_0
X_10731_ network.neuron_in223.counter\[3\] network.in_period\[223\]\[2\]
+ _00866_ net425 VSS VSS VDD VDD _07250_ sky130_fd_sc_hd__o22ai_1
X_10732_ network.neuron_in223.counter\[2\] _00866_ net339
+ VSS VSS VDD VDD _07251_ sky130_fd_sc_hd__nand3_1
X_10733_ network.in_period\[223\]\[2\] net339 _07251_ VSS
+ VSS VDD VDD _07252_ sky130_fd_sc_hd__o21ai_0
X_10734_ _07187_ _07250_ _07252_ VSS VSS VDD VDD _02957_ sky130_fd_sc_hd__a21oi_1
X_10735_ network.neuron_in224.counter\[3\] _00813_ VSS VSS
+ VDD VDD _07253_ sky130_fd_sc_hd__nand2b_1
X_10736_ _07253_ _07174_ VSS VSS VDD VDD _07254_ sky130_fd_sc_hd__nand2b_1
X_10737_ net347 _07254_ VSS VSS VDD VDD _07255_ sky130_fd_sc_hd__nand2_1
X_10738_ network.in_period\[224\]\[1\] _07255_ VSS VSS VDD
+ VDD _07256_ sky130_fd_sc_hd__nand2_1
X_10739_ _00814_ _07255_ _07256_ VSS VSS VDD VDD _02960_ sky130_fd_sc_hd__o21ai_0
X_10740_ network.neuron_in134.counter\[2\] _00893_ VSS VSS
+ VDD VDD _07257_ sky130_fd_sc_hd__xnor2_1
X_10741_ network.neuron_in134.counter\[2\] network.neuron_in134.counter\[3\]
+ VSS VSS VDD VDD _07258_ sky130_fd_sc_hd__nor2_1
X_10742_ net420 _07258_ VSS VSS VDD VDD _07259_ sky130_fd_sc_hd__nor2_1
X_10743_ network.in_period\[134\]\[2\] _07259_ VSS VSS VDD
+ VDD _07260_ sky130_fd_sc_hd__nor2_1
X_10744_ net352 _07257_ _07260_ VSS VSS VDD VDD _02601_ sky130_fd_sc_hd__a21oi_1
X_10745_ network.neuron_in224.counter\[0\] VSS VSS VDD VDD
+ _00811_ sky130_fd_sc_hd__inv_1
X_10746_ network.in_period\[224\]\[0\] _07255_ VSS VSS VDD
+ VDD _07261_ sky130_fd_sc_hd__nand2_1
X_10747_ network.neuron_in224.counter\[0\] _07255_ _07261_
+ VSS VSS VDD VDD _02959_ sky130_fd_sc_hd__o21ai_0
X_10748_ network.neuron_in029.counter\[1\] VSS VSS VDD VDD
+ _00408_ sky130_fd_sc_hd__inv_1
X_10749_ network.neuron_in171.counter\[1\] VSS VSS VDD VDD
+ _01029_ sky130_fd_sc_hd__inv_1
X_10750_ network.neuron_in134.counter\[3\] _00893_ VSS VSS
+ VDD VDD _07262_ sky130_fd_sc_hd__nand2b_1
X_10751_ network.neuron_in134.counter\[2\] _07262_ VSS VSS
+ VDD VDD _07263_ sky130_fd_sc_hd__or2_2
X_10752_ net352 _07263_ VSS VSS VDD VDD _07264_ sky130_fd_sc_hd__nand2_1
X_10753_ network.in_period\[134\]\[1\] _07264_ VSS VSS VDD
+ VDD _07265_ sky130_fd_sc_hd__nand2_1
X_10754_ _00894_ _07264_ _07265_ VSS VSS VDD VDD _02600_ sky130_fd_sc_hd__o21ai_0
X_10755_ network.in_period\[225\]\[1\] _07218_ VSS VSS VDD
+ VDD _07266_ sky130_fd_sc_hd__nand2_1
X_10756_ _00360_ _07218_ _07266_ VSS VSS VDD VDD _02964_ sky130_fd_sc_hd__o21ai_0
X_10757_ network.neuron_in226.counter\[3\] _00817_ VSS VSS
+ VDD VDD _07267_ sky130_fd_sc_hd__nand2b_1
X_10758_ _07267_ _07191_ VSS VSS VDD VDD _07268_ sky130_fd_sc_hd__nand2b_1
X_10759_ net347 _07268_ VSS VSS VDD VDD _07269_ sky130_fd_sc_hd__nand2_1
X_10760_ network.in_period\[226\]\[1\] _07269_ VSS VSS VDD
+ VDD _07270_ sky130_fd_sc_hd__nand2_1
X_10761_ _00818_ _07269_ _07270_ VSS VSS VDD VDD _02968_ sky130_fd_sc_hd__o21ai_0
X_10762_ network.neuron_in226.counter\[0\] VSS VSS VDD VDD
+ _00815_ sky130_fd_sc_hd__inv_1
X_10763_ network.in_period\[226\]\[0\] _07269_ VSS VSS VDD
+ VDD _07271_ sky130_fd_sc_hd__nand2_1
X_10764_ network.neuron_in226.counter\[0\] _07269_ _07271_
+ VSS VSS VDD VDD _02967_ sky130_fd_sc_hd__o21ai_0
X_10765_ network.in_period\[140\]\[0\] _06757_ VSS VSS VDD
+ VDD _07272_ sky130_fd_sc_hd__nand2_1
X_10766_ network.neuron_in140.counter\[0\] _06757_ _07272_
+ VSS VSS VDD VDD _02623_ sky130_fd_sc_hd__o21ai_0
X_10767_ network.neuron_in007.counter\[1\] VSS VSS VDD VDD
+ _00600_ sky130_fd_sc_hd__inv_1
X_10768_ network.neuron_in092.counter\[0\] VSS VSS VDD VDD
+ _01224_ sky130_fd_sc_hd__inv_1
X_10769_ network.neuron_in171.counter\[0\] VSS VSS VDD VDD
+ _01028_ sky130_fd_sc_hd__inv_1
X_10770_ network.neuron_in027.counter\[1\] VSS VSS VDD VDD
+ _00530_ sky130_fd_sc_hd__inv_1
X_10771_ network.neuron_in107.counter\[0\] VSS VSS VDD VDD
+ _00603_ sky130_fd_sc_hd__inv_1
X_10772_ network.neuron_in242.counter\[1\] VSS VSS VDD VDD
+ _01187_ sky130_fd_sc_hd__inv_1
X_10773_ network.neuron_in025.counter\[1\] VSS VSS VDD VDD
+ _00436_ sky130_fd_sc_hd__inv_1
X_10774_ network.neuron_in079.counter\[1\] VSS VSS VDD VDD
+ _00095_ sky130_fd_sc_hd__inv_1
X_10775_ network.neuron_in107.counter\[1\] VSS VSS VDD VDD
+ _00604_ sky130_fd_sc_hd__inv_1
X_10776_ network.neuron_in024.counter\[1\] VSS VSS VDD VDD
+ _00444_ sky130_fd_sc_hd__inv_1
X_10777_ network.neuron_in178.counter\[1\] VSS VSS VDD VDD
+ _01151_ sky130_fd_sc_hd__inv_1
X_10778_ network.neuron_in155.counter\[3\] network.in_period\[155\]\[2\]
+ _01118_ net412 VSS VSS VDD VDD _07273_ sky130_fd_sc_hd__o22ai_1
X_10779_ network.neuron_in155.counter\[2\] _01118_ net358
+ VSS VSS VDD VDD _07274_ sky130_fd_sc_hd__nand3_1
X_10780_ network.in_period\[155\]\[2\] net358 _07274_ VSS
+ VSS VDD VDD _07275_ sky130_fd_sc_hd__o21ai_0
X_10781_ _06834_ _07273_ _07275_ VSS VSS VDD VDD _02685_ sky130_fd_sc_hd__a21oi_1
X_10782_ network.neuron_in247.counter\[1\] VSS VSS VDD VDD
+ _00612_ sky130_fd_sc_hd__inv_1
X_10783_ network.neuron_in049.counter\[0\] VSS VSS VDD VDD
+ _00291_ sky130_fd_sc_hd__inv_1
X_10784_ network.neuron_in248.counter\[1\] VSS VSS VDD VDD
+ _00462_ sky130_fd_sc_hd__inv_1
X_10785_ network.neuron_in021.counter\[1\] VSS VSS VDD VDD
+ _00466_ sky130_fd_sc_hd__inv_1
X_10786_ net417 _06898_ VSS VSS VDD VDD _07276_ sky130_fd_sc_hd__nor2_1
X_10787_ network.neuron_in145.counter\[2\] _00698_ VSS VSS
+ VDD VDD _07277_ sky130_fd_sc_hd__xnor2_1
X_10788_ network.in_period\[145\]\[2\] _07276_ _07277_ net346
+ VSS VSS VDD VDD _02645_ sky130_fd_sc_hd__a2bb2oi_1
X_10789_ network.neuron_in142.counter\[1\] VSS VSS VDD VDD
+ _00608_ sky130_fd_sc_hd__inv_1
X_10790_ network.neuron_in249.counter\[1\] VSS VSS VDD VDD
+ _01145_ sky130_fd_sc_hd__inv_1
X_10791_ network.neuron_in022.counter\[1\] VSS VSS VDD VDD
+ _00448_ sky130_fd_sc_hd__inv_1
X_10792_ network.neuron_hid3.IF0.ref_counter\[1\] VSS VSS
+ VDD VDD _00673_ sky130_fd_sc_hd__inv_1
X_10793_ network.neuron_in247.counter\[0\] VSS VSS VDD VDD
+ _00611_ sky130_fd_sc_hd__inv_1
X_10794_ network.neuron_in020.counter\[1\] VSS VSS VDD VDD
+ _00458_ sky130_fd_sc_hd__inv_1
X_10795_ network.neuron_in052.counter\[0\] VSS VSS VDD VDD
+ _00279_ sky130_fd_sc_hd__inv_1
X_10796_ network.neuron_in019.counter\[1\] VSS VSS VDD VDD
+ _00478_ sky130_fd_sc_hd__inv_1
X_10797_ network.neuron_in003.counter\[1\] VSS VSS VDD VDD
+ _00677_ sky130_fd_sc_hd__inv_1
X_10798_ network.neuron_in108.counter\[0\] VSS VSS VDD VDD
+ _01020_ sky130_fd_sc_hd__inv_1
X_10799_ network.neuron_in015.counter\[1\] VSS VSS VDD VDD
+ _00506_ sky130_fd_sc_hd__inv_1
X_10800_ network.neuron_in018.counter\[1\] VSS VSS VDD VDD
+ _00494_ sky130_fd_sc_hd__inv_1
X_10801_ network.neuron_in017.counter\[1\] VSS VSS VDD VDD
+ _00490_ sky130_fd_sc_hd__inv_1
X_10802_ network.neuron_in217.counter\[1\] VSS VSS VDD VDD
+ _01015_ sky130_fd_sc_hd__inv_1
X_10803_ network.neuron_in095.counter\[0\] VSS VSS VDD VDD
+ _01241_ sky130_fd_sc_hd__inv_1
X_10804_ network.neuron_in016.counter\[1\] VSS VSS VDD VDD
+ _00498_ sky130_fd_sc_hd__inv_1
X_10805_ network.neuron_in176.counter\[0\] VSS VSS VDD VDD
+ _00615_ sky130_fd_sc_hd__inv_1
X_10806_ network.neuron_in123.counter\[0\] VSS VSS VDD VDD
+ _00239_ sky130_fd_sc_hd__inv_1
X_10807_ network.neuron_in013.counter\[1\] VSS VSS VDD VDD
+ _00514_ sky130_fd_sc_hd__inv_1
X_10808_ network.neuron_in083.counter\[1\] VSS VSS VDD VDD
+ _00059_ sky130_fd_sc_hd__inv_1
X_10809_ network.neuron_in014.counter\[1\] VSS VSS VDD VDD
+ _00502_ sky130_fd_sc_hd__inv_1
X_10810_ network.neuron_in128.counter\[2\] _01034_ VSS VSS
+ VDD VDD _07278_ sky130_fd_sc_hd__nand2b_1
X_10811_ network.neuron_in128.counter\[3\] _07278_ VSS VSS
+ VDD VDD _07279_ sky130_fd_sc_hd__or2_2
X_10812_ net358 _07279_ VSS VSS VDD VDD _07280_ sky130_fd_sc_hd__nand2_1
X_10813_ network.in_period\[128\]\[0\] _07280_ VSS VSS VDD
+ VDD _07281_ sky130_fd_sc_hd__nand2_1
X_10814_ network.neuron_in128.counter\[0\] _07280_ _07281_
+ VSS VSS VDD VDD _02575_ sky130_fd_sc_hd__o21ai_0
X_10815_ network.neuron_in001.counter\[0\] VSS VSS VDD VDD
+ _00619_ sky130_fd_sc_hd__inv_1
X_10816_ network.neuron_in176.counter\[1\] VSS VSS VDD VDD
+ _00616_ sky130_fd_sc_hd__inv_1
X_10817_ network.neuron_in170.counter\[1\] VSS VSS VDD VDD
+ _01011_ sky130_fd_sc_hd__inv_1
X_10818_ network.in_period\[128\]\[1\] _07280_ VSS VSS VDD
+ VDD _07282_ sky130_fd_sc_hd__nand2_1
X_10819_ _01035_ _07280_ _07282_ VSS VSS VDD VDD _02576_ sky130_fd_sc_hd__o21ai_0
X_10820_ network.neuron_in012.counter\[1\] VSS VSS VDD VDD
+ _00518_ sky130_fd_sc_hd__inv_1
X_10821_ network.neuron_in227.counter\[3\] _00625_ VSS VSS
+ VDD VDD _07283_ sky130_fd_sc_hd__nand2b_1
X_10822_ _07283_ _07220_ VSS VSS VDD VDD _07284_ sky130_fd_sc_hd__nand2b_1
X_10823_ net348 _07284_ VSS VSS VDD VDD _07285_ sky130_fd_sc_hd__nand2_1
X_10824_ network.in_period\[227\]\[1\] _07285_ VSS VSS VDD
+ VDD _07286_ sky130_fd_sc_hd__nand2_1
X_10825_ _00626_ _07285_ _07286_ VSS VSS VDD VDD _02972_ sky130_fd_sc_hd__o21ai_0
X_10826_ network.neuron_in101.counter\[1\] VSS VSS VDD VDD
+ _01175_ sky130_fd_sc_hd__inv_1
X_10827_ network.neuron_in227.counter\[0\] VSS VSS VDD VDD
+ _00623_ sky130_fd_sc_hd__inv_1
X_10828_ network.in_period\[227\]\[0\] _07285_ VSS VSS VDD
+ VDD _07287_ sky130_fd_sc_hd__nand2_1
X_10829_ network.neuron_in227.counter\[0\] _07285_ _07287_
+ VSS VSS VDD VDD _02971_ sky130_fd_sc_hd__o21ai_0
X_10830_ network.neuron_in117.counter\[0\] VSS VSS VDD VDD
+ _00062_ sky130_fd_sc_hd__inv_1
X_10831_ network.neuron_in034.counter\[1\] VSS VSS VDD VDD
+ _00412_ sky130_fd_sc_hd__inv_1
X_10832_ network.neuron_in203.counter\[1\] VSS VSS VDD VDD
+ _00232_ sky130_fd_sc_hd__inv_1
X_10833_ network.neuron_in011.counter\[1\] VSS VSS VDD VDD
+ _00522_ sky130_fd_sc_hd__inv_1
X_10834_ network.neuron_in234.counter\[2\] VSS VSS VDD VDD
+ _07288_ sky130_fd_sc_hd__inv_1
X_10835_ network.neuron_in234.counter\[3\] network.in_period\[234\]\[2\]
+ _00928_ net416 VSS VSS VDD VDD _07289_ sky130_fd_sc_hd__o22ai_1
X_10836_ network.neuron_in234.counter\[2\] _00928_ net348
+ VSS VSS VDD VDD _07290_ sky130_fd_sc_hd__nand3_1
X_10837_ network.in_period\[234\]\[2\] net348 _07290_ VSS
+ VSS VDD VDD _07291_ sky130_fd_sc_hd__o21ai_0
X_10838_ _07288_ _07289_ _07291_ VSS VSS VDD VDD _03001_ sky130_fd_sc_hd__a21oi_1
X_10839_ network.neuron_in231.counter\[2\] VSS VSS VDD VDD
+ _07292_ sky130_fd_sc_hd__inv_1
X_10840_ _07292_ _00732_ VSS VSS VDD VDD _07293_ sky130_fd_sc_hd__nand2_1
X_10841_ network.neuron_in231.counter\[3\] _07293_ VSS VSS
+ VDD VDD _07294_ sky130_fd_sc_hd__or2_2
X_10842_ net358 _07294_ VSS VSS VDD VDD _07295_ sky130_fd_sc_hd__nand2_1
X_10843_ network.in_period\[231\]\[1\] _07295_ VSS VSS VDD
+ VDD _07296_ sky130_fd_sc_hd__nand2_1
X_10844_ _00733_ _07295_ _07296_ VSS VSS VDD VDD _02988_ sky130_fd_sc_hd__o21ai_0
X_10845_ network.neuron_in233.counter\[0\] VSS VSS VDD VDD
+ _00994_ sky130_fd_sc_hd__inv_1
X_10846_ network.neuron_in233.counter\[3\] _00996_ VSS VSS
+ VDD VDD _07297_ sky130_fd_sc_hd__nand2b_1
X_10847_ network.neuron_in233.counter\[2\] VSS VSS VDD VDD
+ _07298_ sky130_fd_sc_hd__inv_1
X_10848_ _07297_ _07298_ VSS VSS VDD VDD _07299_ sky130_fd_sc_hd__nand2b_1
X_10849_ net347 _07299_ VSS VSS VDD VDD _07300_ sky130_fd_sc_hd__nand2_1
X_10850_ network.in_period\[233\]\[0\] _07300_ VSS VSS VDD
+ VDD _07301_ sky130_fd_sc_hd__nand2_1
X_10851_ network.neuron_in233.counter\[0\] _07300_ _07301_
+ VSS VSS VDD VDD _02995_ sky130_fd_sc_hd__o21ai_0
X_10852_ network.neuron_hid0.ROM0.read_en net366 VSS VSS VDD
+ VDD _07302_ sky130_fd_sc_hd__and2_1
X_10853_ network.neuron_hid0.ROM0.address\[7\] VSS VSS VDD
+ VDD _07303_ sky130_fd_sc_hd__inv_1
Xclkbuf_4_4__f_clk_net clknet_2_1_0_clk_net VSS VSS VDD VDD
+ clknet_4_4__leaf_clk_net sky130_fd_sc_hd__clkbuf_16
Xclkbuf_4_3__f_clk_net clknet_2_0_0_clk_net VSS VSS VDD VDD
+ clknet_4_3__leaf_clk_net sky130_fd_sc_hd__clkbuf_16
X_10856_ _07303_ net427 net431 VSS VSS VDD VDD _07306_ sky130_fd_sc_hd__nor3_2
X_10857_ _07302_ _07306_ VSS VSS VDD VDD _07307_ sky130_fd_sc_hd__nand2_1
Xclkbuf_4_2__f_clk_net clknet_2_0_0_clk_net VSS VSS VDD VDD
+ clknet_4_2__leaf_clk_net sky130_fd_sc_hd__clkbuf_16
Xclkbuf_4_1__f_clk_net clknet_2_0_0_clk_net VSS VSS VDD VDD
+ clknet_4_1__leaf_clk_net sky130_fd_sc_hd__clkbuf_16
Xclkbuf_4_0__f_clk_net clknet_2_0_0_clk_net VSS VSS VDD VDD
+ clknet_4_0__leaf_clk_net sky130_fd_sc_hd__clkbuf_16
Xclkbuf_2_3_0_clk_net clknet_0_clk_net VSS VSS VDD VDD clknet_2_3_0_clk_net
+ sky130_fd_sc_hd__clkbuf_16
Xclkbuf_2_2_0_clk_net clknet_0_clk_net VSS VSS VDD VDD clknet_2_2_0_clk_net
+ sky130_fd_sc_hd__clkbuf_16
Xclkbuf_2_1_0_clk_net clknet_0_clk_net VSS VSS VDD VDD clknet_2_1_0_clk_net
+ sky130_fd_sc_hd__clkbuf_16
Xclkbuf_2_0_0_clk_net clknet_0_clk_net VSS VSS VDD VDD clknet_2_0_0_clk_net
+ sky130_fd_sc_hd__clkbuf_16
Xclkbuf_0_clk_net clk_net VSS VSS VDD VDD clknet_0_clk_net
+ sky130_fd_sc_hd__clkbuf_16
Xclkbuf_leaf_187_clk_net clknet_4_0__leaf_clk_net VSS VSS
+ VDD VDD clknet_leaf_187_clk_net sky130_fd_sc_hd__clkbuf_16
Xclkbuf_leaf_186_clk_net clknet_4_0__leaf_clk_net VSS VSS
+ VDD VDD clknet_leaf_186_clk_net sky130_fd_sc_hd__clkbuf_16
Xclkbuf_leaf_185_clk_net clknet_4_0__leaf_clk_net VSS VSS
+ VDD VDD clknet_leaf_185_clk_net sky130_fd_sc_hd__clkbuf_16
Xclkbuf_leaf_184_clk_net clknet_4_0__leaf_clk_net VSS VSS
+ VDD VDD clknet_leaf_184_clk_net sky130_fd_sc_hd__clkbuf_16
Xclkbuf_leaf_183_clk_net clknet_4_0__leaf_clk_net VSS VSS
+ VDD VDD clknet_leaf_183_clk_net sky130_fd_sc_hd__clkbuf_16
Xclkbuf_leaf_182_clk_net clknet_4_0__leaf_clk_net VSS VSS
+ VDD VDD clknet_leaf_182_clk_net sky130_fd_sc_hd__clkbuf_16
Xclkbuf_leaf_181_clk_net clknet_4_0__leaf_clk_net VSS VSS
+ VDD VDD clknet_leaf_181_clk_net sky130_fd_sc_hd__clkbuf_16
Xclkbuf_leaf_180_clk_net clknet_4_0__leaf_clk_net VSS VSS
+ VDD VDD clknet_leaf_180_clk_net sky130_fd_sc_hd__clkbuf_16
Xclkbuf_leaf_179_clk_net clknet_4_1__leaf_clk_net VSS VSS
+ VDD VDD clknet_leaf_179_clk_net sky130_fd_sc_hd__clkbuf_16
Xclkbuf_leaf_178_clk_net clknet_4_0__leaf_clk_net VSS VSS
+ VDD VDD clknet_leaf_178_clk_net sky130_fd_sc_hd__clkbuf_16
X_10876_ net451 net441 VSS VSS VDD VDD _07326_ sky130_fd_sc_hd__nor2b_2
Xclkbuf_leaf_177_clk_net clknet_4_0__leaf_clk_net VSS VSS
+ VDD VDD clknet_leaf_177_clk_net sky130_fd_sc_hd__clkbuf_16
Xclkbuf_leaf_176_clk_net clknet_4_1__leaf_clk_net VSS VSS
+ VDD VDD clknet_leaf_176_clk_net sky130_fd_sc_hd__clkbuf_16
X_10879_ net440 net451 VSS VSS VDD VDD _07329_ sky130_fd_sc_hd__nand2b_1
Xclkbuf_leaf_175_clk_net clknet_4_1__leaf_clk_net VSS VSS
+ VDD VDD clknet_leaf_175_clk_net sky130_fd_sc_hd__clkbuf_16
X_10881_ net433 net410 _07329_ VSS VSS VDD VDD _07331_ sky130_fd_sc_hd__o21ai_0
Xclkbuf_leaf_174_clk_net clknet_4_1__leaf_clk_net VSS VSS
+ VDD VDD clknet_leaf_174_clk_net sky130_fd_sc_hd__clkbuf_16
Xclkbuf_leaf_173_clk_net clknet_4_1__leaf_clk_net VSS VSS
+ VDD VDD clknet_leaf_173_clk_net sky130_fd_sc_hd__clkbuf_16
Xclkbuf_leaf_172_clk_net clknet_4_1__leaf_clk_net VSS VSS
+ VDD VDD clknet_leaf_172_clk_net sky130_fd_sc_hd__clkbuf_16
X_10885_ net445 net440 VSS VSS VDD VDD _07335_ sky130_fd_sc_hd__nand2b_1
Xclkbuf_leaf_171_clk_net clknet_4_1__leaf_clk_net VSS VSS
+ VDD VDD clknet_leaf_171_clk_net sky130_fd_sc_hd__clkbuf_16
X_10887_ net434 _07335_ VSS VSS VDD VDD _07337_ sky130_fd_sc_hd__nor2_1
X_10888_ net442 _07331_ _07337_ VSS VSS VDD VDD _07338_ sky130_fd_sc_hd__a21oi_1
X_10889_ net434 net443 VSS VSS VDD VDD _07339_ sky130_fd_sc_hd__or2_2
Xclkbuf_leaf_170_clk_net clknet_4_1__leaf_clk_net VSS VSS
+ VDD VDD clknet_leaf_170_clk_net sky130_fd_sc_hd__clkbuf_16
X_10891_ net441 net448 VSS VSS VDD VDD _07341_ sky130_fd_sc_hd__nor2b_2
X_10892_ net410 net408 VSS VSS VDD VDD _07342_ sky130_fd_sc_hd__nor2_1
X_10893_ net448 _07338_ _07339_ _07342_ VSS VSS VDD VDD _07343_
+ sky130_fd_sc_hd__o22a_1
X_10894_ _07303_ _07302_ VSS VSS VDD VDD _07344_ sky130_fd_sc_hd__nand2_1
Xclkbuf_leaf_169_clk_net clknet_4_1__leaf_clk_net VSS VSS
+ VDD VDD clknet_leaf_169_clk_net sky130_fd_sc_hd__clkbuf_16
Xclkbuf_leaf_168_clk_net clknet_4_1__leaf_clk_net VSS VSS
+ VDD VDD clknet_leaf_168_clk_net sky130_fd_sc_hd__clkbuf_16
Xclkbuf_leaf_167_clk_net clknet_4_1__leaf_clk_net VSS VSS
+ VDD VDD clknet_leaf_167_clk_net sky130_fd_sc_hd__clkbuf_16
Xclkbuf_leaf_166_clk_net clknet_4_3__leaf_clk_net VSS VSS
+ VDD VDD clknet_leaf_166_clk_net sky130_fd_sc_hd__clkbuf_16
Xclkbuf_leaf_165_clk_net clknet_4_3__leaf_clk_net VSS VSS
+ VDD VDD clknet_leaf_165_clk_net sky130_fd_sc_hd__clkbuf_16
Xclkbuf_leaf_164_clk_net clknet_4_3__leaf_clk_net VSS VSS
+ VDD VDD clknet_leaf_164_clk_net sky130_fd_sc_hd__clkbuf_16
Xclkbuf_leaf_163_clk_net clknet_4_3__leaf_clk_net VSS VSS
+ VDD VDD clknet_leaf_163_clk_net sky130_fd_sc_hd__clkbuf_16
X_10902_ net430 net440 VSS VSS VDD VDD _07352_ sky130_fd_sc_hd__and2_1
X_10903_ net434 net451 VSS VSS VDD VDD _07353_ sky130_fd_sc_hd__nor2b_1
Xclkbuf_leaf_162_clk_net clknet_4_3__leaf_clk_net VSS VSS
+ VDD VDD clknet_leaf_162_clk_net sky130_fd_sc_hd__clkbuf_16
X_10905_ net446 _07352_ net407 VSS VSS VDD VDD _07355_ sky130_fd_sc_hd__o21ai_0
Xclkbuf_leaf_161_clk_net clknet_4_3__leaf_clk_net VSS VSS
+ VDD VDD clknet_leaf_161_clk_net sky130_fd_sc_hd__clkbuf_16
Xclkbuf_leaf_160_clk_net clknet_4_3__leaf_clk_net VSS VSS
+ VDD VDD clknet_leaf_160_clk_net sky130_fd_sc_hd__clkbuf_16
Xclkbuf_leaf_159_clk_net clknet_4_6__leaf_clk_net VSS VSS
+ VDD VDD clknet_leaf_159_clk_net sky130_fd_sc_hd__clkbuf_16
Xclkbuf_leaf_158_clk_net clknet_4_6__leaf_clk_net VSS VSS
+ VDD VDD clknet_leaf_158_clk_net sky130_fd_sc_hd__clkbuf_16
Xclkbuf_leaf_157_clk_net clknet_4_3__leaf_clk_net VSS VSS
+ VDD VDD clknet_leaf_157_clk_net sky130_fd_sc_hd__clkbuf_16
Xclkbuf_leaf_156_clk_net clknet_4_6__leaf_clk_net VSS VSS
+ VDD VDD clknet_leaf_156_clk_net sky130_fd_sc_hd__clkbuf_16
Xclkbuf_leaf_155_clk_net clknet_4_6__leaf_clk_net VSS VSS
+ VDD VDD clknet_leaf_155_clk_net sky130_fd_sc_hd__clkbuf_16
X_10913_ net451 VSS VSS VDD VDD _07363_ sky130_fd_sc_hd__clkinv_1
Xclkbuf_leaf_154_clk_net clknet_4_6__leaf_clk_net VSS VSS
+ VDD VDD clknet_leaf_154_clk_net sky130_fd_sc_hd__clkbuf_16
Xclkbuf_leaf_153_clk_net clknet_4_4__leaf_clk_net VSS VSS
+ VDD VDD clknet_leaf_153_clk_net sky130_fd_sc_hd__clkbuf_16
Xclkbuf_leaf_152_clk_net clknet_4_4__leaf_clk_net VSS VSS
+ VDD VDD clknet_leaf_152_clk_net sky130_fd_sc_hd__clkbuf_16
Xclkbuf_leaf_151_clk_net clknet_4_4__leaf_clk_net VSS VSS
+ VDD VDD clknet_leaf_151_clk_net sky130_fd_sc_hd__clkbuf_16
X_10918_ net433 net440 net446 VSS VSS VDD VDD _07368_ sky130_fd_sc_hd__a21oi_1
X_10919_ net446 net410 VSS VSS VDD VDD _07369_ sky130_fd_sc_hd__nor2_1
Xclkbuf_leaf_150_clk_net clknet_4_1__leaf_clk_net VSS VSS
+ VDD VDD clknet_leaf_150_clk_net sky130_fd_sc_hd__clkbuf_16
Xclkbuf_leaf_149_clk_net clknet_4_4__leaf_clk_net VSS VSS
+ VDD VDD clknet_leaf_149_clk_net sky130_fd_sc_hd__clkbuf_16
X_10922_ net406 _07368_ _07369_ net433 VSS VSS VDD VDD _07372_
+ sky130_fd_sc_hd__o22a_1
Xclkbuf_leaf_148_clk_net clknet_4_1__leaf_clk_net VSS VSS
+ VDD VDD clknet_leaf_148_clk_net sky130_fd_sc_hd__clkbuf_16
Xclkbuf_leaf_147_clk_net clknet_4_4__leaf_clk_net VSS VSS
+ VDD VDD clknet_leaf_147_clk_net sky130_fd_sc_hd__clkbuf_16
X_10925_ net429 net406 VSS VSS VDD VDD _07375_ sky130_fd_sc_hd__nand2_1
Xclkbuf_leaf_146_clk_net clknet_4_4__leaf_clk_net VSS VSS
+ VDD VDD clknet_leaf_146_clk_net sky130_fd_sc_hd__clkbuf_16
X_10927_ net440 net448 VSS VSS VDD VDD _07377_ sky130_fd_sc_hd__nand2_1
Xclkbuf_leaf_145_clk_net clknet_4_4__leaf_clk_net VSS VSS
+ VDD VDD clknet_leaf_145_clk_net sky130_fd_sc_hd__clkbuf_16
X_10929_ net441 net448 VSS VSS VDD VDD _07379_ sky130_fd_sc_hd__nor2_2
Xclkbuf_leaf_144_clk_net clknet_4_4__leaf_clk_net VSS VSS
+ VDD VDD clknet_leaf_144_clk_net sky130_fd_sc_hd__clkbuf_16
Xclkbuf_leaf_143_clk_net clknet_4_4__leaf_clk_net VSS VSS
+ VDD VDD clknet_leaf_143_clk_net sky130_fd_sc_hd__clkbuf_16
X_10932_ net433 net405 net404 VSS VSS VDD VDD _07382_ sky130_fd_sc_hd__a21oi_1
Xclkbuf_leaf_142_clk_net clknet_4_4__leaf_clk_net VSS VSS
+ VDD VDD clknet_leaf_142_clk_net sky130_fd_sc_hd__clkbuf_16
Xclkbuf_leaf_141_clk_net clknet_4_4__leaf_clk_net VSS VSS
+ VDD VDD clknet_leaf_141_clk_net sky130_fd_sc_hd__clkbuf_16
X_10935_ net441 net448 VSS VSS VDD VDD _07385_ sky130_fd_sc_hd__and2_1
Xclkbuf_leaf_140_clk_net clknet_4_5__leaf_clk_net VSS VSS
+ VDD VDD clknet_leaf_140_clk_net sky130_fd_sc_hd__clkbuf_16
X_10937_ net450 net403 VSS VSS VDD VDD _07387_ sky130_fd_sc_hd__nand2_1
X_10938_ net429 _07372_ _07375_ _07382_ _07387_ VSS VSS VDD
+ VDD _07388_ sky130_fd_sc_hd__o221ai_1
X_10939_ net443 VSS VSS VDD VDD _07389_ sky130_fd_sc_hd__inv_2
Xclkbuf_leaf_139_clk_net clknet_4_4__leaf_clk_net VSS VSS
+ VDD VDD clknet_leaf_139_clk_net sky130_fd_sc_hd__clkbuf_16
X_10941_ net434 net441 VSS VSS VDD VDD _07391_ sky130_fd_sc_hd__nor2_1
Xclkbuf_leaf_138_clk_net clknet_4_5__leaf_clk_net VSS VSS
+ VDD VDD clknet_leaf_138_clk_net sky130_fd_sc_hd__clkbuf_16
X_10943_ net449 net437 VSS VSS VDD VDD _07393_ sky130_fd_sc_hd__nor2b_1
X_10944_ _07391_ _07393_ VSS VSS VDD VDD _07394_ sky130_fd_sc_hd__nor2_1
X_10945_ net429 _07394_ VSS VSS VDD VDD _07395_ sky130_fd_sc_hd__nor2_1
X_10946_ net448 net441 VSS VSS VDD VDD _07396_ sky130_fd_sc_hd__nor2b_2
Xclkbuf_leaf_137_clk_net clknet_4_5__leaf_clk_net VSS VSS
+ VDD VDD clknet_leaf_137_clk_net sky130_fd_sc_hd__clkbuf_16
X_10948_ net440 net448 VSS VSS VDD VDD _07398_ sky130_fd_sc_hd__nand2b_2
X_10949_ net437 net400 VSS VSS VDD VDD _07399_ sky130_fd_sc_hd__nor2_1
X_10950_ net402 _07395_ _07396_ _07399_ VSS VSS VDD VDD _07400_
+ sky130_fd_sc_hd__or4_1
X_10951_ net442 _07388_ _07400_ VSS VSS VDD VDD _07401_ sky130_fd_sc_hd__o21ai_0
X_10952_ net428 VSS VSS VDD VDD _07402_ sky130_fd_sc_hd__inv_1
Xclkbuf_leaf_136_clk_net clknet_4_5__leaf_clk_net VSS VSS
+ VDD VDD clknet_leaf_136_clk_net sky130_fd_sc_hd__clkbuf_16
Xclkbuf_leaf_135_clk_net clknet_4_5__leaf_clk_net VSS VSS
+ VDD VDD clknet_leaf_135_clk_net sky130_fd_sc_hd__clkbuf_16
Xclkbuf_leaf_134_clk_net clknet_4_5__leaf_clk_net VSS VSS
+ VDD VDD clknet_leaf_134_clk_net sky130_fd_sc_hd__clkbuf_16
X_10956_ net440 VSS VSS VDD VDD _07406_ sky130_fd_sc_hd__inv_1
Xclkbuf_leaf_133_clk_net clknet_4_5__leaf_clk_net VSS VSS
+ VDD VDD clknet_leaf_133_clk_net sky130_fd_sc_hd__clkbuf_16
Xclkbuf_leaf_132_clk_net clknet_4_5__leaf_clk_net VSS VSS
+ VDD VDD clknet_leaf_132_clk_net sky130_fd_sc_hd__clkbuf_16
X_10959_ net451 net448 VSS VSS VDD VDD _07409_ sky130_fd_sc_hd__or2_2
Xclkbuf_leaf_131_clk_net clknet_4_5__leaf_clk_net VSS VSS
+ VDD VDD clknet_leaf_131_clk_net sky130_fd_sc_hd__clkbuf_16
Xclkbuf_leaf_130_clk_net clknet_4_5__leaf_clk_net VSS VSS
+ VDD VDD clknet_leaf_130_clk_net sky130_fd_sc_hd__clkbuf_16
Xclkbuf_leaf_129_clk_net clknet_4_5__leaf_clk_net VSS VSS
+ VDD VDD clknet_leaf_129_clk_net sky130_fd_sc_hd__clkbuf_16
Xclkbuf_leaf_128_clk_net clknet_4_5__leaf_clk_net VSS VSS
+ VDD VDD clknet_leaf_128_clk_net sky130_fd_sc_hd__clkbuf_16
X_10964_ net451 net448 VSS VSS VDD VDD _07414_ sky130_fd_sc_hd__and2_1
Xclkbuf_leaf_127_clk_net clknet_4_5__leaf_clk_net VSS VSS
+ VDD VDD clknet_leaf_127_clk_net sky130_fd_sc_hd__clkbuf_16
X_10966_ net443 net397 VSS VSS VDD VDD _07416_ sky130_fd_sc_hd__nand2_1
X_10967_ net433 _07409_ _07416_ VSS VSS VDD VDD _07417_ sky130_fd_sc_hd__o21ai_0
X_10968_ net429 net398 _07417_ VSS VSS VDD VDD _07418_ sky130_fd_sc_hd__nand3_1
Xclkbuf_leaf_126_clk_net clknet_4_7__leaf_clk_net VSS VSS
+ VDD VDD clknet_leaf_126_clk_net sky130_fd_sc_hd__clkbuf_16
X_10970_ net429 net446 VSS VSS VDD VDD _07420_ sky130_fd_sc_hd__nor2_1
Xclkbuf_leaf_125_clk_net clknet_4_7__leaf_clk_net VSS VSS
+ VDD VDD clknet_leaf_125_clk_net sky130_fd_sc_hd__clkbuf_16
X_10972_ net451 net443 VSS VSS VDD VDD _07422_ sky130_fd_sc_hd__nor2b_1
X_10973_ net439 _07420_ net396 VSS VSS VDD VDD _07423_ sky130_fd_sc_hd__o21ai_0
Xclkbuf_leaf_124_clk_net clknet_4_7__leaf_clk_net VSS VSS
+ VDD VDD clknet_leaf_124_clk_net sky130_fd_sc_hd__clkbuf_16
X_10975_ net451 net448 VSS VSS VDD VDD _07425_ sky130_fd_sc_hd__nor2b_2
X_10976_ net448 net451 VSS VSS VDD VDD _07426_ sky130_fd_sc_hd__nor2b_1
Xclkbuf_leaf_123_clk_net clknet_4_7__leaf_clk_net VSS VSS
+ VDD VDD clknet_leaf_123_clk_net sky130_fd_sc_hd__clkbuf_16
X_10978_ net395 _07426_ VSS VSS VDD VDD _07428_ sky130_fd_sc_hd__nor2_1
X_10979_ net449 _07396_ VSS VSS VDD VDD _07429_ sky130_fd_sc_hd__nand2_1
X_10980_ net429 _07428_ _07429_ VSS VSS VDD VDD _07430_ sky130_fd_sc_hd__o21ai_0
X_10981_ net443 net451 VSS VSS VDD VDD _07431_ sky130_fd_sc_hd__nand2b_1
Xclkbuf_leaf_122_clk_net clknet_4_7__leaf_clk_net VSS VSS
+ VDD VDD clknet_leaf_122_clk_net sky130_fd_sc_hd__clkbuf_16
X_10983_ net439 _07431_ VSS VSS VDD VDD _07433_ sky130_fd_sc_hd__nand2_1
Xclkbuf_leaf_121_clk_net clknet_4_7__leaf_clk_net VSS VSS
+ VDD VDD clknet_leaf_121_clk_net sky130_fd_sc_hd__clkbuf_16
X_10985_ net402 _07430_ _07433_ net429 VSS VSS VDD VDD _07435_
+ sky130_fd_sc_hd__o2bb2ai_1
Xclkbuf_leaf_120_clk_net clknet_4_7__leaf_clk_net VSS VSS
+ VDD VDD clknet_leaf_120_clk_net sky130_fd_sc_hd__clkbuf_16
X_10987_ net449 net400 VSS VSS VDD VDD _07437_ sky130_fd_sc_hd__nor2_1
X_10988_ net442 net440 VSS VSS VDD VDD _07438_ sky130_fd_sc_hd__and2_0
X_10989_ net338 _07438_ net430 VSS VSS VDD VDD _07439_ sky130_fd_sc_hd__o21ai_0
X_10990_ net406 net401 VSS VSS VDD VDD _07440_ sky130_fd_sc_hd__nand2_1
X_10991_ net443 _07377_ VSS VSS VDD VDD _07441_ sky130_fd_sc_hd__nor2_1
X_10992_ net440 net443 VSS VSS VDD VDD _07442_ sky130_fd_sc_hd__nor2b_1
X_10993_ net430 net406 VSS VSS VDD VDD _07443_ sky130_fd_sc_hd__nor2_1
X_10994_ _07441_ net393 _07443_ VSS VSS VDD VDD _07444_ sky130_fd_sc_hd__o21ai_0
X_10995_ net433 _07439_ _07440_ _07444_ VSS VSS VDD VDD _07445_
+ sky130_fd_sc_hd__nand4_1
X_10996_ net433 _07435_ _07445_ VSS VSS VDD VDD _07446_ sky130_fd_sc_hd__o21ai_0
X_10997_ net399 _07418_ _07423_ _07446_ VSS VSS VDD VDD _07447_
+ sky130_fd_sc_hd__and4_1
X_10998_ net427 _07355_ _07401_ _07447_ VSS VSS VDD VDD _07448_
+ sky130_fd_sc_hd__a31oi_1
X_10999_ _07307_ _07343_ _07344_ _07448_ VSS VSS VDD VDD _01505_
+ sky130_fd_sc_hd__o22ai_1
X_11000_ network.neuron_hid4.IF0.ref_counter\[1\] VSS VSS
+ VDD VDD _01221_ sky130_fd_sc_hd__inv_1
X_11001_ network.neuron_in230.counter\[2\] VSS VSS VDD VDD
+ _07449_ sky130_fd_sc_hd__inv_1
X_11002_ network.neuron_in230.counter\[3\] network.in_period\[230\]\[2\]
+ _00702_ net413 VSS VSS VDD VDD _07450_ sky130_fd_sc_hd__o22ai_1
X_11003_ network.neuron_in230.counter\[2\] _00702_ net347
+ VSS VSS VDD VDD _07451_ sky130_fd_sc_hd__nand3_1
X_11004_ network.in_period\[230\]\[2\] net347 _07451_ VSS
+ VSS VDD VDD _07452_ sky130_fd_sc_hd__o21ai_0
X_11005_ _07449_ _07450_ _07452_ VSS VSS VDD VDD _02985_ sky130_fd_sc_hd__a21oi_1
X_11006_ network.neuron_in170.counter\[0\] VSS VSS VDD VDD
+ _01010_ sky130_fd_sc_hd__inv_1
X_11007_ network.neuron_in059.counter\[0\] VSS VSS VDD VDD
+ _00235_ sky130_fd_sc_hd__inv_1
X_11008_ network.neuron_in131.counter\[1\] VSS VSS VDD VDD
+ _00901_ sky130_fd_sc_hd__inv_1
X_11009_ network.neuron_in026.counter\[1\] VSS VSS VDD VDD
+ _00534_ sky130_fd_sc_hd__inv_1
X_11010_ network.neuron_in231.counter\[3\] network.in_period\[231\]\[2\]
+ _00732_ net412 VSS VSS VDD VDD _07453_ sky130_fd_sc_hd__o22ai_1
X_11011_ network.neuron_in231.counter\[2\] _00732_ net358
+ VSS VSS VDD VDD _07454_ sky130_fd_sc_hd__nand3_1
X_11012_ network.in_period\[231\]\[2\] net358 _07454_ VSS
+ VSS VDD VDD _07455_ sky130_fd_sc_hd__o21ai_0
X_11013_ _07292_ _07453_ _07455_ VSS VSS VDD VDD _02989_ sky130_fd_sc_hd__a21oi_1
Xclkbuf_leaf_119_clk_net clknet_4_7__leaf_clk_net VSS VSS
+ VDD VDD clknet_leaf_119_clk_net sky130_fd_sc_hd__clkbuf_16
X_11015_ network.neuron_in232.counter\[3\] _00527_ VSS VSS
+ VDD VDD _07457_ sky130_fd_sc_hd__nand2b_1
X_11016_ network.neuron_in232.counter\[2\] VSS VSS VDD VDD
+ _07458_ sky130_fd_sc_hd__inv_1
X_11017_ _07457_ _07458_ VSS VSS VDD VDD _07459_ sky130_fd_sc_hd__nand2b_1
X_11018_ net347 _07459_ VSS VSS VDD VDD _07460_ sky130_fd_sc_hd__nand2_1
X_11019_ network.in_period\[232\]\[1\] _07460_ VSS VSS VDD
+ VDD _07461_ sky130_fd_sc_hd__nand2_1
X_11020_ _00528_ _07460_ _07461_ VSS VSS VDD VDD _02992_ sky130_fd_sc_hd__o21ai_0
X_11021_ network.neuron_in010.counter\[1\] VSS VSS VDD VDD
+ _00538_ sky130_fd_sc_hd__inv_1
X_11022_ network.in_period\[233\]\[1\] _07300_ VSS VSS VDD
+ VDD _07462_ sky130_fd_sc_hd__nand2_1
X_11023_ _00997_ _07300_ _07462_ VSS VSS VDD VDD _02996_ sky130_fd_sc_hd__o21ai_0
X_11024_ network.neuron_in234.counter\[0\] VSS VSS VDD VDD
+ _00926_ sky130_fd_sc_hd__inv_1
X_11025_ network.neuron_in234.counter\[3\] _00928_ VSS VSS
+ VDD VDD _07463_ sky130_fd_sc_hd__nand2b_1
X_11026_ _07463_ _07288_ VSS VSS VDD VDD _07464_ sky130_fd_sc_hd__nand2b_1
X_11027_ net348 _07464_ VSS VSS VDD VDD _07465_ sky130_fd_sc_hd__nand2_1
X_11028_ network.in_period\[234\]\[0\] _07465_ VSS VSS VDD
+ VDD _07466_ sky130_fd_sc_hd__nand2_1
X_11029_ network.neuron_in234.counter\[0\] _07465_ _07466_
+ VSS VSS VDD VDD _02999_ sky130_fd_sc_hd__o21ai_0
X_11030_ network.neuron_in235.counter\[0\] VSS VSS VDD VDD
+ _00419_ sky130_fd_sc_hd__inv_1
X_11031_ network.neuron_in235.counter\[3\] _00421_ VSS VSS
+ VDD VDD _07467_ sky130_fd_sc_hd__nand2b_1
X_11032_ network.neuron_in235.counter\[2\] VSS VSS VDD VDD
+ _07468_ sky130_fd_sc_hd__inv_1
X_11033_ _07467_ _07468_ VSS VSS VDD VDD _07469_ sky130_fd_sc_hd__nand2b_1
X_11034_ net359 _07469_ VSS VSS VDD VDD _07470_ sky130_fd_sc_hd__nand2_1
X_11035_ network.in_period\[235\]\[0\] _07470_ VSS VSS VDD
+ VDD _07471_ sky130_fd_sc_hd__nand2_1
X_11036_ network.neuron_in235.counter\[0\] _07470_ _07471_
+ VSS VSS VDD VDD _03003_ sky130_fd_sc_hd__o21ai_0
Xclkbuf_leaf_118_clk_net clknet_4_7__leaf_clk_net VSS VSS
+ VDD VDD clknet_leaf_118_clk_net sky130_fd_sc_hd__clkbuf_16
X_11038_ network.neuron_hid0.ROM0.read_en _06660_ VSS VSS
+ VDD VDD _07473_ sky130_fd_sc_hd__nand2_1
X_11039_ network.neuron_hid0.ROM0.address\[7\] net327 VSS
+ VSS VDD VDD _07474_ sky130_fd_sc_hd__nor2_2
Xclkbuf_leaf_117_clk_net clknet_4_7__leaf_clk_net VSS VSS
+ VDD VDD clknet_leaf_117_clk_net sky130_fd_sc_hd__clkbuf_16
Xclkbuf_leaf_116_clk_net clknet_4_7__leaf_clk_net VSS VSS
+ VDD VDD clknet_leaf_116_clk_net sky130_fd_sc_hd__clkbuf_16
X_11042_ net450 net404 VSS VSS VDD VDD _07477_ sky130_fd_sc_hd__nand2_1
X_11043_ net445 net447 VSS VSS VDD VDD _07478_ sky130_fd_sc_hd__nor2b_2
Xclkbuf_leaf_115_clk_net clknet_4_7__leaf_clk_net VSS VSS
+ VDD VDD clknet_leaf_115_clk_net sky130_fd_sc_hd__clkbuf_16
Xclkbuf_leaf_114_clk_net clknet_4_7__leaf_clk_net VSS VSS
+ VDD VDD clknet_leaf_114_clk_net sky130_fd_sc_hd__clkbuf_16
Xclkbuf_leaf_113_clk_net clknet_4_7__leaf_clk_net VSS VSS
+ VDD VDD clknet_leaf_113_clk_net sky130_fd_sc_hd__clkbuf_16
Xclkbuf_leaf_112_clk_net clknet_4_6__leaf_clk_net VSS VSS
+ VDD VDD clknet_leaf_112_clk_net sky130_fd_sc_hd__clkbuf_16
X_11048_ net444 net440 VSS VSS VDD VDD _07483_ sky130_fd_sc_hd__nand2_1
X_11049_ net435 _07483_ VSS VSS VDD VDD _07484_ sky130_fd_sc_hd__nor2_1
X_11050_ net392 _07484_ net406 VSS VSS VDD VDD _07485_ sky130_fd_sc_hd__o21ai_0
X_11051_ net441 net451 VSS VSS VDD VDD _07486_ sky130_fd_sc_hd__nor2b_2
Xclkbuf_leaf_111_clk_net clknet_4_6__leaf_clk_net VSS VSS
+ VDD VDD clknet_leaf_111_clk_net sky130_fd_sc_hd__clkbuf_16
Xclkbuf_leaf_110_clk_net clknet_4_6__leaf_clk_net VSS VSS
+ VDD VDD clknet_leaf_110_clk_net sky130_fd_sc_hd__clkbuf_16
X_11054_ net446 net449 VSS VSS VDD VDD _07489_ sky130_fd_sc_hd__nand2b_1
Xclkbuf_leaf_109_clk_net clknet_4_6__leaf_clk_net VSS VSS
+ VDD VDD clknet_leaf_109_clk_net sky130_fd_sc_hd__clkbuf_16
X_11056_ net439 _07489_ net437 VSS VSS VDD VDD _07491_ sky130_fd_sc_hd__a21oi_1
X_11057_ net391 _07491_ net402 VSS VSS VDD VDD _07492_ sky130_fd_sc_hd__o21ai_0
Xclkbuf_leaf_108_clk_net clknet_4_6__leaf_clk_net VSS VSS
+ VDD VDD clknet_leaf_108_clk_net sky130_fd_sc_hd__clkbuf_16
X_11059_ net427 net431 VSS VSS VDD VDD _07494_ sky130_fd_sc_hd__nand2_1
X_11060_ _07477_ _07485_ _07492_ _07494_ VSS VSS VDD VDD _07495_
+ sky130_fd_sc_hd__a31o_2
X_11061_ net451 net441 VSS VSS VDD VDD _07496_ sky130_fd_sc_hd__nand2_1
Xclkbuf_leaf_107_clk_net clknet_4_6__leaf_clk_net VSS VSS
+ VDD VDD clknet_leaf_107_clk_net sky130_fd_sc_hd__clkbuf_16
X_11063_ net451 net441 VSS VSS VDD VDD _07498_ sky130_fd_sc_hd__nor2_1
X_11064_ net402 net390 net389 VSS VSS VDD VDD _07499_ sky130_fd_sc_hd__a21oi_1
X_11065_ net446 net438 VSS VSS VDD VDD _07500_ sky130_fd_sc_hd__nand2b_1
X_11066_ net437 net449 VSS VSS VDD VDD _07501_ sky130_fd_sc_hd__or2_2
X_11067_ net390 _07500_ _07501_ VSS VSS VDD VDD _07502_ sky130_fd_sc_hd__o21ai_0
X_11068_ net444 _07502_ VSS VSS VDD VDD _07503_ sky130_fd_sc_hd__nand2_1
Xclkbuf_leaf_106_clk_net clknet_4_12__leaf_clk_net VSS VSS
+ VDD VDD clknet_leaf_106_clk_net sky130_fd_sc_hd__clkbuf_16
X_11070_ net451 net440 VSS VSS VDD VDD _07505_ sky130_fd_sc_hd__nand2b_1
Xclkbuf_leaf_105_clk_net clknet_4_12__leaf_clk_net VSS VSS
+ VDD VDD clknet_leaf_105_clk_net sky130_fd_sc_hd__clkbuf_16
X_11072_ net402 net388 _07431_ VSS VSS VDD VDD _07507_ sky130_fd_sc_hd__o21ai_0
Xclkbuf_leaf_104_clk_net clknet_4_12__leaf_clk_net VSS VSS
+ VDD VDD clknet_leaf_104_clk_net sky130_fd_sc_hd__clkbuf_16
X_11074_ net446 _07507_ net431 VSS VSS VDD VDD _07509_ sky130_fd_sc_hd__a21oi_1
X_11075_ net446 _07499_ _07503_ _07509_ VSS VSS VDD VDD _07510_
+ sky130_fd_sc_hd__o211ai_1
Xclkbuf_leaf_103_clk_net clknet_4_13__leaf_clk_net VSS VSS
+ VDD VDD clknet_leaf_103_clk_net sky130_fd_sc_hd__clkbuf_16
X_11077_ net402 net406 VSS VSS VDD VDD _07512_ sky130_fd_sc_hd__nor2_1
X_11078_ net445 net435 VSS VSS VDD VDD _07513_ sky130_fd_sc_hd__nand2b_1
Xclkbuf_leaf_102_clk_net clknet_4_13__leaf_clk_net VSS VSS
+ VDD VDD clknet_leaf_102_clk_net sky130_fd_sc_hd__clkbuf_16
X_11080_ net447 _07513_ VSS VSS VDD VDD _07515_ sky130_fd_sc_hd__nand2_1
Xclkbuf_leaf_101_clk_net clknet_4_13__leaf_clk_net VSS VSS
+ VDD VDD clknet_leaf_101_clk_net sky130_fd_sc_hd__clkbuf_16
X_11082_ net447 _07393_ _07512_ _07515_ net440 VSS VSS VDD
+ VDD _07517_ sky130_fd_sc_hd__o311ai_0
X_11083_ net443 net440 VSS VSS VDD VDD _07518_ sky130_fd_sc_hd__or2_2
Xclkbuf_leaf_100_clk_net clknet_4_13__leaf_clk_net VSS VSS
+ VDD VDD clknet_leaf_100_clk_net sky130_fd_sc_hd__clkbuf_16
X_11085_ net436 _07518_ VSS VSS VDD VDD _07520_ sky130_fd_sc_hd__nor2_1
X_11086_ net434 net443 net450 VSS VSS VDD VDD _07521_ sky130_fd_sc_hd__and3_1
X_11087_ _07520_ _07521_ VSS VSS VDD VDD _07522_ sky130_fd_sc_hd__nor2_1
X_11088_ net444 net450 VSS VSS VDD VDD _07523_ sky130_fd_sc_hd__nor2b_2
X_11089_ net451 net440 VSS VSS VDD VDD _07524_ sky130_fd_sc_hd__or2_2
Xclkbuf_leaf_99_clk_net clknet_4_13__leaf_clk_net VSS VSS
+ VDD VDD clknet_leaf_99_clk_net sky130_fd_sc_hd__clkbuf_16
X_11091_ net436 _07524_ VSS VSS VDD VDD _07526_ sky130_fd_sc_hd__nor2_1
X_11092_ net387 _07526_ net447 VSS VSS VDD VDD _07527_ sky130_fd_sc_hd__o21ai_0
X_11093_ net432 _07517_ _07522_ _07527_ VSS VSS VDD VDD _07528_
+ sky130_fd_sc_hd__nand4_1
X_11094_ net399 _07510_ _07528_ VSS VSS VDD VDD _07529_ sky130_fd_sc_hd__nand3_1
Xclkbuf_leaf_98_clk_net clknet_4_7__leaf_clk_net VSS VSS VDD
+ VDD clknet_leaf_98_clk_net sky130_fd_sc_hd__clkbuf_16
Xclkbuf_leaf_97_clk_net clknet_4_13__leaf_clk_net VSS VSS
+ VDD VDD clknet_leaf_97_clk_net sky130_fd_sc_hd__clkbuf_16
Xclkbuf_leaf_96_clk_net clknet_4_13__leaf_clk_net VSS VSS
+ VDD VDD clknet_leaf_96_clk_net sky130_fd_sc_hd__clkbuf_16
X_11098_ net450 net447 VSS VSS VDD VDD _07533_ sky130_fd_sc_hd__nand2b_1
X_11099_ _07533_ _07477_ net442 VSS VSS VDD VDD _07534_ sky130_fd_sc_hd__a21oi_1
X_11100_ net443 net410 _07534_ VSS VSS VDD VDD _07535_ sky130_fd_sc_hd__a21oi_1
X_11101_ net451 net408 VSS VSS VDD VDD _07536_ sky130_fd_sc_hd__nand2_1
X_11102_ _07440_ _07536_ VSS VSS VDD VDD _07537_ sky130_fd_sc_hd__nand2_1
Xclkbuf_leaf_95_clk_net clknet_4_13__leaf_clk_net VSS VSS
+ VDD VDD clknet_leaf_95_clk_net sky130_fd_sc_hd__clkbuf_16
X_11104_ net434 net406 VSS VSS VDD VDD _07539_ sky130_fd_sc_hd__nand2_1
X_11105_ net449 net446 VSS VSS VDD VDD _07540_ sky130_fd_sc_hd__nand2_1
Xclkbuf_leaf_94_clk_net clknet_4_13__leaf_clk_net VSS VSS
+ VDD VDD clknet_leaf_94_clk_net sky130_fd_sc_hd__clkbuf_16
X_11107_ net448 _07539_ _07540_ VSS VSS VDD VDD _07542_ sky130_fd_sc_hd__o21ai_0
X_11108_ net430 net427 VSS VSS VDD VDD _07543_ sky130_fd_sc_hd__nand2b_1
X_11109_ net434 _07537_ _07542_ net443 _07543_ VSS VSS VDD
+ VDD _07544_ sky130_fd_sc_hd__a221oi_1
X_11110_ net434 _07535_ _07544_ VSS VSS VDD VDD _07545_ sky130_fd_sc_hd__o21ai_0
X_11111_ _07495_ _07529_ _07545_ VSS VSS VDD VDD _07546_ sky130_fd_sc_hd__nand3_1
Xclkbuf_leaf_93_clk_net clknet_4_13__leaf_clk_net VSS VSS
+ VDD VDD clknet_leaf_93_clk_net sky130_fd_sc_hd__clkbuf_16
Xclkbuf_leaf_92_clk_net clknet_4_13__leaf_clk_net VSS VSS
+ VDD VDD clknet_leaf_92_clk_net sky130_fd_sc_hd__clkbuf_16
Xclkbuf_leaf_91_clk_net clknet_4_15__leaf_clk_net VSS VSS
+ VDD VDD clknet_leaf_91_clk_net sky130_fd_sc_hd__clkbuf_16
Xclkbuf_leaf_90_clk_net clknet_4_15__leaf_clk_net VSS VSS
+ VDD VDD clknet_leaf_90_clk_net sky130_fd_sc_hd__clkbuf_16
X_11116_ net439 _07426_ VSS VSS VDD VDD _07551_ sky130_fd_sc_hd__nor2_1
Xclkbuf_leaf_89_clk_net clknet_4_15__leaf_clk_net VSS VSS
+ VDD VDD clknet_leaf_89_clk_net sky130_fd_sc_hd__clkbuf_16
X_11118_ net443 net441 VSS VSS VDD VDD _07553_ sky130_fd_sc_hd__nor2_1
X_11119_ net449 _07553_ VSS VSS VDD VDD _07554_ sky130_fd_sc_hd__nor2_1
X_11120_ net402 _07551_ _07554_ net446 VSS VSS VDD VDD _07555_
+ sky130_fd_sc_hd__a2bb2oi_1
X_11121_ net449 net446 net442 VSS VSS VDD VDD _07556_ sky130_fd_sc_hd__nor3b_1
X_11122_ net440 net434 VSS VSS VDD VDD _07557_ sky130_fd_sc_hd__nor2b_1
X_11123_ net392 _07556_ net386 VSS VSS VDD VDD _07558_ sky130_fd_sc_hd__o21ai_0
X_11124_ net437 _07555_ _07558_ VSS VSS VDD VDD _07559_ sky130_fd_sc_hd__o21ai_0
X_11125_ net428 net432 VSS VSS VDD VDD _07560_ sky130_fd_sc_hd__nor2_1
X_11126_ network.neuron_hid0.ROM0.address\[7\] net385 VSS
+ VSS VDD VDD _07561_ sky130_fd_sc_hd__nand2_1
X_11127_ net327 _07561_ VSS VSS VDD VDD _07562_ sky130_fd_sc_hd__nor2_2
Xclkbuf_leaf_88_clk_net clknet_4_15__leaf_clk_net VSS VSS
+ VDD VDD clknet_leaf_88_clk_net sky130_fd_sc_hd__clkbuf_16
X_11129_ _07474_ _07546_ _07559_ _07562_ VSS VSS VDD VDD _01506_
+ sky130_fd_sc_hd__a22o_1
X_11130_ network.neuron_in085.counter\[0\] VSS VSS VDD VDD
+ _00042_ sky130_fd_sc_hd__inv_1
X_11131_ network.neuron_in236.counter\[2\] _00561_ VSS VSS
+ VDD VDD _07564_ sky130_fd_sc_hd__nand2b_1
X_11132_ network.neuron_in236.counter\[3\] _07564_ VSS VSS
+ VDD VDD _07565_ sky130_fd_sc_hd__or2_2
X_11133_ net359 _07565_ VSS VSS VDD VDD _07566_ sky130_fd_sc_hd__nand2_1
X_11134_ network.in_period\[236\]\[0\] _07566_ VSS VSS VDD
+ VDD _07567_ sky130_fd_sc_hd__nand2_1
X_11135_ network.neuron_in236.counter\[0\] _07566_ _07567_
+ VSS VSS VDD VDD _03007_ sky130_fd_sc_hd__o21ai_0
X_11136_ network.neuron_in229.counter\[3\] _00932_ VSS VSS
+ VDD VDD _07568_ sky130_fd_sc_hd__nand2b_1
X_11137_ _07568_ _07170_ VSS VSS VDD VDD _07569_ sky130_fd_sc_hd__nand2b_1
X_11138_ net358 _07569_ VSS VSS VDD VDD _07570_ sky130_fd_sc_hd__nand2_1
X_11139_ network.in_period\[229\]\[1\] _07570_ VSS VSS VDD
+ VDD _07571_ sky130_fd_sc_hd__nand2_1
X_11140_ _00933_ _07570_ _07571_ VSS VSS VDD VDD _02980_ sky130_fd_sc_hd__o21ai_0
X_11141_ network.neuron_in229.counter\[0\] VSS VSS VDD VDD
+ _00930_ sky130_fd_sc_hd__inv_1
X_11142_ network.in_period\[229\]\[0\] _07570_ VSS VSS VDD
+ VDD _07572_ sky130_fd_sc_hd__nand2_1
X_11143_ network.neuron_in229.counter\[0\] _07570_ _07572_
+ VSS VSS VDD VDD _02979_ sky130_fd_sc_hd__o21ai_0
X_11144_ network.neuron_in213.counter\[1\] VSS VSS VDD VDD
+ _01007_ sky130_fd_sc_hd__inv_1
X_11145_ network.neuron_in009.counter\[1\] VSS VSS VDD VDD
+ _00544_ sky130_fd_sc_hd__inv_1
X_11146_ network.neuron_in001.counter\[1\] VSS VSS VDD VDD
+ _00620_ sky130_fd_sc_hd__inv_1
X_11147_ network.neuron_in008.counter\[1\] VSS VSS VDD VDD
+ _00548_ sky130_fd_sc_hd__inv_1
X_11148_ network.neuron_in160.counter\[1\] VSS VSS VDD VDD
+ _01101_ sky130_fd_sc_hd__inv_1
X_11149_ network.neuron_in230.counter\[3\] _00702_ VSS VSS
+ VDD VDD _07573_ sky130_fd_sc_hd__nand2b_1
X_11150_ _07573_ _07449_ VSS VSS VDD VDD _07574_ sky130_fd_sc_hd__nand2b_1
X_11151_ net347 _07574_ VSS VSS VDD VDD _07575_ sky130_fd_sc_hd__nand2_1
X_11152_ network.in_period\[230\]\[1\] _07575_ VSS VSS VDD
+ VDD _07576_ sky130_fd_sc_hd__nand2_1
X_11153_ _00703_ _07575_ _07576_ VSS VSS VDD VDD _02984_ sky130_fd_sc_hd__o21ai_0
X_11154_ network.neuron_in230.counter\[0\] VSS VSS VDD VDD
+ _00700_ sky130_fd_sc_hd__inv_1
X_11155_ network.in_period\[230\]\[0\] _07575_ VSS VSS VDD
+ VDD _07577_ sky130_fd_sc_hd__nand2_1
X_11156_ network.neuron_in230.counter\[0\] _07575_ _07577_
+ VSS VSS VDD VDD _02983_ sky130_fd_sc_hd__o21ai_0
X_11157_ network.in_period\[231\]\[0\] _07295_ VSS VSS VDD
+ VDD _07578_ sky130_fd_sc_hd__nand2_1
X_11158_ network.neuron_in231.counter\[0\] _07295_ _07578_
+ VSS VSS VDD VDD _02987_ sky130_fd_sc_hd__o21ai_0
X_11159_ network.neuron_in232.counter\[3\] network.in_period\[232\]\[2\]
+ _00527_ net417 VSS VSS VDD VDD _07579_ sky130_fd_sc_hd__o22ai_1
X_11160_ network.neuron_in232.counter\[2\] _00527_ net347
+ VSS VSS VDD VDD _07580_ sky130_fd_sc_hd__nand3_1
X_11161_ network.in_period\[232\]\[2\] net347 _07580_ VSS
+ VSS VDD VDD _07581_ sky130_fd_sc_hd__o21ai_0
X_11162_ _07458_ _07579_ _07581_ VSS VSS VDD VDD _02993_ sky130_fd_sc_hd__a21oi_1
X_11163_ network.neuron_in232.counter\[0\] VSS VSS VDD VDD
+ _00525_ sky130_fd_sc_hd__inv_1
X_11164_ network.in_period\[232\]\[0\] _07460_ VSS VSS VDD
+ VDD _07582_ sky130_fd_sc_hd__nand2_1
X_11165_ network.neuron_in232.counter\[0\] _07460_ _07582_
+ VSS VSS VDD VDD _02991_ sky130_fd_sc_hd__o21ai_0
X_11166_ network.neuron_in233.counter\[3\] network.in_period\[233\]\[2\]
+ _00996_ net417 VSS VSS VDD VDD _07583_ sky130_fd_sc_hd__o22ai_1
X_11167_ network.neuron_in233.counter\[2\] _00996_ net346
+ VSS VSS VDD VDD _07584_ sky130_fd_sc_hd__nand3_1
X_11168_ network.in_period\[233\]\[2\] net347 _07584_ VSS
+ VSS VDD VDD _07585_ sky130_fd_sc_hd__o21ai_0
X_11169_ _07298_ _07583_ _07585_ VSS VSS VDD VDD _02997_ sky130_fd_sc_hd__a21oi_1
X_11170_ network.in_period\[234\]\[1\] _07465_ VSS VSS VDD
+ VDD _07586_ sky130_fd_sc_hd__nand2_1
X_11171_ _00929_ _07465_ _07586_ VSS VSS VDD VDD _03000_ sky130_fd_sc_hd__o21ai_0
X_11172_ network.neuron_in157.counter\[0\] VSS VSS VDD VDD
+ _00734_ sky130_fd_sc_hd__inv_1
X_11173_ network.neuron_in113.counter\[1\] VSS VSS VDD VDD
+ _01003_ sky130_fd_sc_hd__inv_1
X_11174_ network.neuron_in235.counter\[3\] network.in_period\[235\]\[2\]
+ _00421_ net413 VSS VSS VDD VDD _07587_ sky130_fd_sc_hd__o22ai_1
Xclkbuf_leaf_87_clk_net clknet_4_15__leaf_clk_net VSS VSS
+ VDD VDD clknet_leaf_87_clk_net sky130_fd_sc_hd__clkbuf_16
Xclkbuf_leaf_86_clk_net clknet_4_15__leaf_clk_net VSS VSS
+ VDD VDD clknet_leaf_86_clk_net sky130_fd_sc_hd__clkbuf_16
X_11177_ network.neuron_in235.counter\[2\] _00421_ net359
+ VSS VSS VDD VDD _07590_ sky130_fd_sc_hd__nand3_1
X_11178_ network.in_period\[235\]\[2\] net359 _07590_ VSS
+ VSS VDD VDD _07591_ sky130_fd_sc_hd__o21ai_0
X_11179_ _07468_ _07587_ _07591_ VSS VSS VDD VDD _03005_ sky130_fd_sc_hd__a21oi_1
X_11180_ network.in_period\[235\]\[1\] _07470_ VSS VSS VDD
+ VDD _07592_ sky130_fd_sc_hd__nand2_1
X_11181_ _00422_ _07470_ _07592_ VSS VSS VDD VDD _03004_ sky130_fd_sc_hd__o21ai_0
X_11182_ net440 net448 VSS VSS VDD VDD _07593_ sky130_fd_sc_hd__or2_2
Xclkbuf_leaf_85_clk_net clknet_4_15__leaf_clk_net VSS VSS
+ VDD VDD clknet_leaf_85_clk_net sky130_fd_sc_hd__clkbuf_16
Xclkbuf_leaf_84_clk_net clknet_4_15__leaf_clk_net VSS VSS
+ VDD VDD clknet_leaf_84_clk_net sky130_fd_sc_hd__clkbuf_16
X_11185_ net442 _07593_ _07540_ VSS VSS VDD VDD _07596_ sky130_fd_sc_hd__nand3_1
X_11186_ _07518_ _07596_ net433 VSS VSS VDD VDD _07597_ sky130_fd_sc_hd__a21oi_1
X_11187_ _07428_ _07553_ _07597_ VSS VSS VDD VDD _07598_ sky130_fd_sc_hd__a21oi_1
Xclkbuf_leaf_83_clk_net clknet_4_15__leaf_clk_net VSS VSS
+ VDD VDD clknet_leaf_83_clk_net sky130_fd_sc_hd__clkbuf_16
X_11189_ net438 net450 VSS VSS VDD VDD _07600_ sky130_fd_sc_hd__nor2_1
X_11190_ _07600_ net386 net448 VSS VSS VDD VDD _07601_ sky130_fd_sc_hd__o21ai_0
X_11191_ net448 _07539_ _07601_ VSS VSS VDD VDD _07602_ sky130_fd_sc_hd__o21ai_0
X_11192_ net438 net448 VSS VSS VDD VDD _07603_ sky130_fd_sc_hd__nor2b_1
X_11193_ net451 _07391_ VSS VSS VDD VDD _07604_ sky130_fd_sc_hd__nor2_1
X_11194_ net448 _07604_ _07496_ VSS VSS VDD VDD _07605_ sky130_fd_sc_hd__o21ai_0
X_11195_ net389 net383 _07605_ net442 net430 VSS VSS VDD VDD
+ _07606_ sky130_fd_sc_hd__a221o_1
X_11196_ net402 _07602_ _07606_ VSS VSS VDD VDD _07607_ sky130_fd_sc_hd__a21oi_1
X_11197_ net430 net434 VSS VSS VDD VDD _07608_ sky130_fd_sc_hd__nand2_1
Xclkbuf_leaf_82_clk_net clknet_4_14__leaf_clk_net VSS VSS
+ VDD VDD clknet_leaf_82_clk_net sky130_fd_sc_hd__clkbuf_16
X_11199_ net451 _07518_ net448 VSS VSS VDD VDD _07610_ sky130_fd_sc_hd__a21oi_1
X_11200_ net442 net410 _07610_ VSS VSS VDD VDD _07611_ sky130_fd_sc_hd__a21oi_1
X_11201_ net435 net432 VSS VSS VDD VDD _07612_ sky130_fd_sc_hd__nand2b_1
Xclkbuf_leaf_81_clk_net clknet_4_14__leaf_clk_net VSS VSS
+ VDD VDD clknet_leaf_81_clk_net sky130_fd_sc_hd__clkbuf_16
X_11203_ net443 net451 VSS VSS VDD VDD _07614_ sky130_fd_sc_hd__nand2_1
X_11204_ net448 _07614_ VSS VSS VDD VDD _07615_ sky130_fd_sc_hd__nand2_1
X_11205_ net445 net450 VSS VSS VDD VDD _07616_ sky130_fd_sc_hd__nor2_1
Xclkbuf_leaf_80_clk_net clknet_4_14__leaf_clk_net VSS VSS
+ VDD VDD clknet_leaf_80_clk_net sky130_fd_sc_hd__clkbuf_16
X_11207_ net441 _07615_ net382 net408 VSS VSS VDD VDD _07618_
+ sky130_fd_sc_hd__a211oi_1
Xclkbuf_leaf_79_clk_net clknet_4_14__leaf_clk_net VSS VSS
+ VDD VDD clknet_leaf_79_clk_net sky130_fd_sc_hd__clkbuf_16
X_11209_ _07608_ _07611_ _07612_ _07618_ net427 VSS VSS VDD
+ VDD _07620_ sky130_fd_sc_hd__o221ai_1
X_11210_ net432 net438 VSS VSS VDD VDD _07621_ sky130_fd_sc_hd__nand2b_1
Xclkbuf_leaf_78_clk_net clknet_4_14__leaf_clk_net VSS VSS
+ VDD VDD clknet_leaf_78_clk_net sky130_fd_sc_hd__clkbuf_16
X_11212_ net439 net397 VSS VSS VDD VDD _07623_ sky130_fd_sc_hd__nor2_1
X_11213_ net443 net448 VSS VSS VDD VDD _07624_ sky130_fd_sc_hd__or2_2
Xclkbuf_leaf_77_clk_net clknet_4_14__leaf_clk_net VSS VSS
+ VDD VDD clknet_leaf_77_clk_net sky130_fd_sc_hd__clkbuf_16
X_11215_ net442 net439 net446 VSS VSS VDD VDD _07626_ sky130_fd_sc_hd__nand3_1
X_11216_ _07624_ _07626_ VSS VSS VDD VDD _07627_ sky130_fd_sc_hd__nand2_1
Xclkbuf_leaf_76_clk_net clknet_4_15__leaf_clk_net VSS VSS
+ VDD VDD clknet_leaf_76_clk_net sky130_fd_sc_hd__clkbuf_16
X_11218_ net442 _07623_ _07627_ net449 VSS VSS VDD VDD _07629_
+ sky130_fd_sc_hd__a22oi_1
Xclkbuf_leaf_75_clk_net clknet_4_12__leaf_clk_net VSS VSS
+ VDD VDD clknet_leaf_75_clk_net sky130_fd_sc_hd__clkbuf_16
Xclkbuf_leaf_74_clk_net clknet_4_12__leaf_clk_net VSS VSS
+ VDD VDD clknet_leaf_74_clk_net sky130_fd_sc_hd__clkbuf_16
Xclkbuf_leaf_73_clk_net clknet_4_12__leaf_clk_net VSS VSS
+ VDD VDD clknet_leaf_73_clk_net sky130_fd_sc_hd__clkbuf_16
Xclkbuf_leaf_72_clk_net clknet_4_12__leaf_clk_net VSS VSS
+ VDD VDD clknet_leaf_72_clk_net sky130_fd_sc_hd__clkbuf_16
X_11223_ net438 net449 VSS VSS VDD VDD _07634_ sky130_fd_sc_hd__nand2_1
X_11224_ net451 net443 VSS VSS VDD VDD _07635_ sky130_fd_sc_hd__nand2b_1
X_11225_ net402 net391 VSS VSS VDD VDD _07636_ sky130_fd_sc_hd__nand2_1
X_11226_ net433 _07635_ _07636_ VSS VSS VDD VDD _07637_ sky130_fd_sc_hd__o21a_1
Xclkbuf_leaf_71_clk_net clknet_4_12__leaf_clk_net VSS VSS
+ VDD VDD clknet_leaf_71_clk_net sky130_fd_sc_hd__clkbuf_16
X_11228_ net451 net440 VSS VSS VDD VDD _07639_ sky130_fd_sc_hd__xnor2_1
X_11229_ net443 net383 net380 VSS VSS VDD VDD _07640_ sky130_fd_sc_hd__o21ai_0
X_11230_ net400 _07634_ _07637_ net448 _07640_ VSS VSS VDD
+ VDD _07641_ sky130_fd_sc_hd__o221ai_1
X_11231_ net444 _07524_ VSS VSS VDD VDD _07642_ sky130_fd_sc_hd__nand2_1
X_11232_ net432 net437 VSS VSS VDD VDD _07643_ sky130_fd_sc_hd__nor2_1
X_11233_ net446 net443 VSS VSS VDD VDD _07644_ sky130_fd_sc_hd__nor2b_1
X_11234_ _07486_ _07644_ VSS VSS VDD VDD _07645_ sky130_fd_sc_hd__nand2_1
X_11235_ net402 net410 VSS VSS VDD VDD _07646_ sky130_fd_sc_hd__nand2_1
X_11236_ _07643_ _07645_ _07646_ VSS VSS VDD VDD _07647_ sky130_fd_sc_hd__nand3_1
X_11237_ net447 _07642_ _07647_ VSS VSS VDD VDD _07648_ sky130_fd_sc_hd__a21oi_1
X_11238_ net430 _07641_ _07648_ net427 VSS VSS VDD VDD _07649_
+ sky130_fd_sc_hd__a211oi_1
X_11239_ net381 _07629_ _07649_ VSS VSS VDD VDD _07650_ sky130_fd_sc_hd__o21ai_0
X_11240_ _07607_ _07620_ _07650_ VSS VSS VDD VDD _07651_ sky130_fd_sc_hd__o21ai_0
X_11241_ _07307_ _07598_ _07651_ _07344_ VSS VSS VDD VDD _01507_
+ sky130_fd_sc_hd__o22ai_1
Xclkbuf_leaf_70_clk_net clknet_4_12__leaf_clk_net VSS VSS
+ VDD VDD clknet_leaf_70_clk_net sky130_fd_sc_hd__clkbuf_16
X_11243_ net439 net397 net436 VSS VSS VDD VDD _07653_ sky130_fd_sc_hd__o21ai_0
X_11244_ _07526_ _07653_ net444 VSS VSS VDD VDD _07654_ sky130_fd_sc_hd__nand3b_1
Xclkbuf_leaf_69_clk_net clknet_4_12__leaf_clk_net VSS VSS
+ VDD VDD clknet_leaf_69_clk_net sky130_fd_sc_hd__clkbuf_16
Xclkbuf_leaf_68_clk_net clknet_4_12__leaf_clk_net VSS VSS
+ VDD VDD clknet_leaf_68_clk_net sky130_fd_sc_hd__clkbuf_16
X_11247_ net402 net406 VSS VSS VDD VDD _07657_ sky130_fd_sc_hd__nand2_1
X_11248_ net436 _07657_ VSS VSS VDD VDD _07658_ sky130_fd_sc_hd__nand2_1
X_11249_ _07396_ _07658_ VSS VSS VDD VDD _07659_ sky130_fd_sc_hd__nand2_1
Xclkbuf_leaf_67_clk_net clknet_4_9__leaf_clk_net VSS VSS VDD
+ VDD clknet_leaf_67_clk_net sky130_fd_sc_hd__clkbuf_16
X_11251_ _07654_ _07659_ net431 VSS VSS VDD VDD _07661_ sky130_fd_sc_hd__a21oi_1
X_11252_ net435 net447 VSS VSS VDD VDD _07662_ sky130_fd_sc_hd__and2_1
X_11253_ net435 net397 VSS VSS VDD VDD _07663_ sky130_fd_sc_hd__nor2_1
X_11254_ net444 net394 VSS VSS VDD VDD _07664_ sky130_fd_sc_hd__nand2_1
X_11255_ net444 _07663_ _07664_ VSS VSS VDD VDD _07665_ sky130_fd_sc_hd__o21ai_0
X_11256_ net444 _07524_ VSS VSS VDD VDD _07666_ sky130_fd_sc_hd__nor2_1
X_11257_ net390 _07662_ _07665_ net439 _07666_ VSS VSS VDD
+ VDD _07667_ sky130_fd_sc_hd__a221o_1
X_11258_ net431 _07667_ VSS VSS VDD VDD _07668_ sky130_fd_sc_hd__nand2_1
X_11259_ _07387_ _07513_ _07668_ VSS VSS VDD VDD _07669_ sky130_fd_sc_hd__o21ai_0
X_11260_ network.neuron_hid0.ROM0.address\[7\] net427 VSS
+ VSS VDD VDD _07670_ sky130_fd_sc_hd__nor2_1
X_11261_ _07661_ _07669_ _07670_ VSS VSS VDD VDD _07671_ sky130_fd_sc_hd__o21ai_0
Xclkbuf_leaf_66_clk_net clknet_4_12__leaf_clk_net VSS VSS
+ VDD VDD clknet_leaf_66_clk_net sky130_fd_sc_hd__clkbuf_16
X_11263_ net450 net408 net401 VSS VSS VDD VDD _07673_ sky130_fd_sc_hd__a21oi_1
X_11264_ net437 net398 VSS VSS VDD VDD _07674_ sky130_fd_sc_hd__nor2_1
X_11265_ net437 net404 _07674_ VSS VSS VDD VDD _07675_ sky130_fd_sc_hd__a21oi_1
X_11266_ net437 _07673_ _07675_ net449 net442 VSS VSS VDD
+ VDD _07676_ sky130_fd_sc_hd__o221ai_1
Xclkbuf_leaf_65_clk_net clknet_4_11__leaf_clk_net VSS VSS
+ VDD VDD clknet_leaf_65_clk_net sky130_fd_sc_hd__clkbuf_16
X_11268_ net437 net446 VSS VSS VDD VDD _07678_ sky130_fd_sc_hd__nor2_1
X_11269_ net437 _07409_ _07678_ VSS VSS VDD VDD _07679_ sky130_fd_sc_hd__a21oi_1
Xclkbuf_leaf_64_clk_net clknet_4_11__leaf_clk_net VSS VSS
+ VDD VDD clknet_leaf_64_clk_net sky130_fd_sc_hd__clkbuf_16
Xclkbuf_leaf_63_clk_net clknet_4_11__leaf_clk_net VSS VSS
+ VDD VDD clknet_leaf_63_clk_net sky130_fd_sc_hd__clkbuf_16
X_11272_ net407 net403 net442 VSS VSS VDD VDD _07682_ sky130_fd_sc_hd__a21oi_1
X_11273_ net439 _07679_ _07682_ VSS VSS VDD VDD _07683_ sky130_fd_sc_hd__o21ai_0
X_11274_ net448 net441 VSS VSS VDD VDD _07684_ sky130_fd_sc_hd__nand2b_1
Xclkbuf_leaf_62_clk_net clknet_4_10__leaf_clk_net VSS VSS
+ VDD VDD clknet_leaf_62_clk_net sky130_fd_sc_hd__clkbuf_16
Xclkbuf_leaf_61_clk_net clknet_4_11__leaf_clk_net VSS VSS
+ VDD VDD clknet_leaf_61_clk_net sky130_fd_sc_hd__clkbuf_16
X_11277_ net442 net405 VSS VSS VDD VDD _07687_ sky130_fd_sc_hd__nand2_1
X_11278_ net402 net390 VSS VSS VDD VDD _07688_ sky130_fd_sc_hd__nor2_1
X_11279_ _07666_ _07688_ net435 VSS VSS VDD VDD _07689_ sky130_fd_sc_hd__o21ai_0
X_11280_ net442 net379 _07501_ _07687_ _07689_ VSS VSS VDD
+ VDD _07690_ sky130_fd_sc_hd__o221ai_1
X_11281_ net438 net442 VSS VSS VDD VDD _07691_ sky130_fd_sc_hd__nand2_1
Xclkbuf_leaf_60_clk_net clknet_4_11__leaf_clk_net VSS VSS
+ VDD VDD clknet_leaf_60_clk_net sky130_fd_sc_hd__clkbuf_16
X_11283_ net446 net388 net433 VSS VSS VDD VDD _07693_ sky130_fd_sc_hd__a21oi_1
Xclkbuf_leaf_59_clk_net clknet_4_14__leaf_clk_net VSS VSS
+ VDD VDD clknet_leaf_59_clk_net sky130_fd_sc_hd__clkbuf_16
X_11285_ net391 _07693_ net402 VSS VSS VDD VDD _07695_ sky130_fd_sc_hd__o21ai_0
X_11286_ _07524_ net378 _07489_ net429 _07695_ VSS VSS VDD
+ VDD _07696_ sky130_fd_sc_hd__o2111ai_1
X_11287_ net429 _07690_ _07696_ VSS VSS VDD VDD _07697_ sky130_fd_sc_hd__o21ai_0
X_11288_ net430 net437 VSS VSS VDD VDD _07698_ sky130_fd_sc_hd__or2_2
Xclkbuf_leaf_58_clk_net clknet_4_14__leaf_clk_net VSS VSS
+ VDD VDD clknet_leaf_58_clk_net sky130_fd_sc_hd__clkbuf_16
X_11290_ net429 _07393_ VSS VSS VDD VDD _07700_ sky130_fd_sc_hd__nand2_1
X_11291_ net409 _07698_ _07700_ VSS VSS VDD VDD _07701_ sky130_fd_sc_hd__o21ai_0
X_11292_ network.neuron_hid0.ROM0.address\[7\] _07402_ VSS
+ VSS VDD VDD _07702_ sky130_fd_sc_hd__nor2_2
X_11293_ _07428_ net378 _07702_ VSS VSS VDD VDD _07703_ sky130_fd_sc_hd__o21ai_0
X_11294_ net446 _07701_ _07703_ VSS VSS VDD VDD _07704_ sky130_fd_sc_hd__a21oi_1
X_11295_ _07306_ _07676_ _07683_ _07697_ _07704_ VSS VSS VDD
+ VDD _07705_ sky130_fd_sc_hd__a32oi_1
Xclkbuf_leaf_57_clk_net clknet_4_14__leaf_clk_net VSS VSS
+ VDD VDD clknet_leaf_57_clk_net sky130_fd_sc_hd__clkbuf_16
X_11297_ _07671_ _07705_ net327 VSS VSS VDD VDD _01508_ sky130_fd_sc_hd__a21oi_1
X_11298_ network.neuron_in236.counter\[2\] net359 VSS VSS
+ VDD VDD _07707_ sky130_fd_sc_hd__nand2_1
X_11299_ network.neuron_in236.counter\[3\] network.in_period\[236\]\[2\]
+ _07707_ VSS VSS VDD VDD _07708_ sky130_fd_sc_hd__o21ai_0
X_11300_ _00561_ network.neuron_in236.counter\[2\] net421
+ VSS VSS VDD VDD _07709_ sky130_fd_sc_hd__or3_1
X_11301_ network.in_period\[236\]\[2\] net359 _07709_ VSS
+ VSS VDD VDD _07710_ sky130_fd_sc_hd__o21ai_0
X_11302_ _00561_ _07708_ _07710_ VSS VSS VDD VDD _03009_ sky130_fd_sc_hd__a21oi_1
X_11303_ network.in_period\[236\]\[1\] _07566_ VSS VSS VDD
+ VDD _07711_ sky130_fd_sc_hd__nand2_1
X_11304_ _00562_ _07566_ _07711_ VSS VSS VDD VDD _03008_ sky130_fd_sc_hd__o21ai_0
X_11305_ network.neuron_in005.counter\[1\] VSS VSS VDD VDD
+ _00661_ sky130_fd_sc_hd__inv_1
X_11306_ network.neuron_in241.counter\[2\] network.neuron_in241.counter\[3\]
+ VSS VSS VDD VDD _07712_ sky130_fd_sc_hd__nor2_1
X_11307_ net417 _07712_ VSS VSS VDD VDD _07713_ sky130_fd_sc_hd__nor2_1
X_11308_ network.neuron_in241.counter\[2\] _00910_ VSS VSS
+ VDD VDD _07714_ sky130_fd_sc_hd__xnor2_1
X_11309_ network.in_period\[241\]\[2\] _07713_ _07714_ net364
+ VSS VSS VDD VDD _03029_ sky130_fd_sc_hd__a2bb2oi_1
X_11310_ network.neuron_in240.counter\[1\] VSS VSS VDD VDD
+ _00428_ sky130_fd_sc_hd__inv_1
Xclkbuf_leaf_56_clk_net clknet_4_14__leaf_clk_net VSS VSS
+ VDD VDD clknet_leaf_56_clk_net sky130_fd_sc_hd__clkbuf_16
X_11312_ network.neuron_in237.counter\[2\] network.neuron_in237.counter\[3\]
+ VSS VSS VDD VDD _07716_ sky130_fd_sc_hd__nor2_1
X_11313_ _00433_ _07716_ VSS VSS VDD VDD _07717_ sky130_fd_sc_hd__nand2_1
X_11314_ net358 _07717_ VSS VSS VDD VDD _07718_ sky130_fd_sc_hd__nand2_1
X_11315_ network.in_period\[237\]\[1\] _07718_ VSS VSS VDD
+ VDD _07719_ sky130_fd_sc_hd__nand2_1
X_11316_ _00434_ _07718_ _07719_ VSS VSS VDD VDD _03012_ sky130_fd_sc_hd__o21ai_0
X_11317_ network.neuron_in113.counter\[0\] VSS VSS VDD VDD
+ _01002_ sky130_fd_sc_hd__inv_1
X_11318_ network.neuron_in238.counter\[3\] _00807_ VSS VSS
+ VDD VDD _07720_ sky130_fd_sc_hd__nand2b_1
X_11319_ network.neuron_in238.counter\[2\] VSS VSS VDD VDD
+ _07721_ sky130_fd_sc_hd__inv_1
X_11320_ _07720_ _07721_ VSS VSS VDD VDD _07722_ sky130_fd_sc_hd__nand2b_1
X_11321_ net359 _07722_ VSS VSS VDD VDD _07723_ sky130_fd_sc_hd__nand2_1
X_11322_ network.in_period\[238\]\[1\] _07723_ VSS VSS VDD
+ VDD _07724_ sky130_fd_sc_hd__nand2_1
X_11323_ _00808_ _07723_ _07724_ VSS VSS VDD VDD _03016_ sky130_fd_sc_hd__o21ai_0
X_11324_ network.neuron_in239.counter\[2\] _00581_ VSS VSS
+ VDD VDD _07725_ sky130_fd_sc_hd__nand2b_1
X_11325_ network.neuron_in239.counter\[3\] _07725_ VSS VSS
+ VDD VDD _07726_ sky130_fd_sc_hd__or2_2
X_11326_ net359 _07726_ VSS VSS VDD VDD _07727_ sky130_fd_sc_hd__nand2_1
X_11327_ network.in_period\[239\]\[1\] _07727_ VSS VSS VDD
+ VDD _07728_ sky130_fd_sc_hd__nand2_1
X_11328_ _00582_ _07727_ _07728_ VSS VSS VDD VDD _03020_ sky130_fd_sc_hd__o21ai_0
X_11329_ network.neuron_in240.counter\[3\] _00429_ VSS VSS
+ VDD VDD _07729_ sky130_fd_sc_hd__nand2b_1
X_11330_ network.neuron_in240.counter\[2\] VSS VSS VDD VDD
+ _07730_ sky130_fd_sc_hd__inv_1
X_11331_ _07729_ _07730_ VSS VSS VDD VDD _07731_ sky130_fd_sc_hd__nand2b_1
X_11332_ net364 _07731_ VSS VSS VDD VDD _07732_ sky130_fd_sc_hd__nand2_1
X_11333_ network.in_period\[240\]\[1\] _07732_ VSS VSS VDD
+ VDD _07733_ sky130_fd_sc_hd__nand2_1
X_11334_ _00430_ _07732_ _07733_ VSS VSS VDD VDD _03024_ sky130_fd_sc_hd__o21ai_0
X_11335_ network.neuron_in237.counter\[2\] VSS VSS VDD VDD
+ _07734_ sky130_fd_sc_hd__inv_1
Xclkbuf_leaf_55_clk_net clknet_4_11__leaf_clk_net VSS VSS
+ VDD VDD clknet_leaf_55_clk_net sky130_fd_sc_hd__clkbuf_16
X_11337_ network.neuron_in237.counter\[3\] network.in_period\[237\]\[2\]
+ _00433_ net420 VSS VSS VDD VDD _07736_ sky130_fd_sc_hd__o22ai_1
X_11338_ network.neuron_in237.counter\[2\] _00433_ net358
+ VSS VSS VDD VDD _07737_ sky130_fd_sc_hd__nand3_1
X_11339_ network.in_period\[237\]\[2\] net358 _07737_ VSS
+ VSS VDD VDD _07738_ sky130_fd_sc_hd__o21ai_0
X_11340_ _07734_ _07736_ _07738_ VSS VSS VDD VDD _03013_ sky130_fd_sc_hd__a21oi_1
X_11341_ network.neuron_in237.counter\[0\] VSS VSS VDD VDD
+ _00431_ sky130_fd_sc_hd__inv_1
X_11342_ network.in_period\[237\]\[0\] _07718_ VSS VSS VDD
+ VDD _07739_ sky130_fd_sc_hd__nand2_1
X_11343_ network.neuron_in237.counter\[0\] _07718_ _07739_
+ VSS VSS VDD VDD _03011_ sky130_fd_sc_hd__o21ai_0
X_11344_ network.neuron_in238.counter\[3\] network.in_period\[238\]\[2\]
+ _00807_ net421 VSS VSS VDD VDD _07740_ sky130_fd_sc_hd__o22ai_1
X_11345_ network.neuron_in238.counter\[2\] _00807_ net359
+ VSS VSS VDD VDD _07741_ sky130_fd_sc_hd__nand3_1
X_11346_ network.in_period\[238\]\[2\] net359 _07741_ VSS
+ VSS VDD VDD _07742_ sky130_fd_sc_hd__o21ai_0
X_11347_ _07721_ _07740_ _07742_ VSS VSS VDD VDD _03017_ sky130_fd_sc_hd__a21oi_1
X_11348_ network.neuron_in238.counter\[0\] VSS VSS VDD VDD
+ _00805_ sky130_fd_sc_hd__inv_1
X_11349_ network.in_period\[238\]\[0\] _07723_ VSS VSS VDD
+ VDD _07743_ sky130_fd_sc_hd__nand2_1
X_11350_ network.neuron_in238.counter\[0\] _07723_ _07743_
+ VSS VSS VDD VDD _03015_ sky130_fd_sc_hd__o21ai_0
X_11351_ network.neuron_in060.counter\[0\] VSS VSS VDD VDD
+ _00209_ sky130_fd_sc_hd__inv_1
X_11352_ network.neuron_in134.counter\[0\] VSS VSS VDD VDD
+ _00891_ sky130_fd_sc_hd__inv_1
X_11353_ network.in_period\[134\]\[0\] _07264_ VSS VSS VDD
+ VDD _07744_ sky130_fd_sc_hd__nand2_1
X_11354_ network.neuron_in134.counter\[0\] _07264_ _07744_
+ VSS VSS VDD VDD _02599_ sky130_fd_sc_hd__o21ai_0
X_11355_ network.neuron_in135.counter\[2\] net352 VSS VSS
+ VDD VDD _07745_ sky130_fd_sc_hd__nand2_1
X_11356_ network.neuron_in135.counter\[3\] network.in_period\[135\]\[2\]
+ _07745_ VSS VSS VDD VDD _07746_ sky130_fd_sc_hd__o21ai_0
X_11357_ _00068_ network.neuron_in135.counter\[2\] net421
+ VSS VSS VDD VDD _07747_ sky130_fd_sc_hd__or3_1
X_11358_ network.in_period\[135\]\[2\] net352 _07747_ VSS
+ VSS VDD VDD _07748_ sky130_fd_sc_hd__o21ai_0
X_11359_ _00068_ _07746_ _07748_ VSS VSS VDD VDD _02605_ sky130_fd_sc_hd__a21oi_1
X_11360_ network.neuron_in239.counter\[2\] net359 VSS VSS
+ VDD VDD _07749_ sky130_fd_sc_hd__nand2_1
X_11361_ network.neuron_in239.counter\[3\] network.in_period\[239\]\[2\]
+ _07749_ VSS VSS VDD VDD _07750_ sky130_fd_sc_hd__o21ai_0
X_11362_ _00581_ network.neuron_in239.counter\[2\] net413
+ VSS VSS VDD VDD _07751_ sky130_fd_sc_hd__or3_1
X_11363_ network.in_period\[239\]\[2\] net359 _07751_ VSS
+ VSS VDD VDD _07752_ sky130_fd_sc_hd__o21ai_0
X_11364_ _00581_ _07750_ _07752_ VSS VSS VDD VDD _03021_ sky130_fd_sc_hd__a21oi_1
X_11365_ network.in_period\[239\]\[0\] _07727_ VSS VSS VDD
+ VDD _07753_ sky130_fd_sc_hd__nand2_1
X_11366_ network.neuron_in239.counter\[0\] _07727_ _07753_
+ VSS VSS VDD VDD _03019_ sky130_fd_sc_hd__o21ai_0
X_11367_ network.neuron_in240.counter\[3\] network.in_period\[240\]\[2\]
+ _00429_ net417 VSS VSS VDD VDD _07754_ sky130_fd_sc_hd__o22ai_1
X_11368_ network.neuron_in240.counter\[2\] _00429_ net364
+ VSS VSS VDD VDD _07755_ sky130_fd_sc_hd__nand3_1
X_11369_ network.in_period\[240\]\[2\] net364 _07755_ VSS
+ VSS VDD VDD _07756_ sky130_fd_sc_hd__o21ai_0
X_11370_ _07730_ _07754_ _07756_ VSS VSS VDD VDD _03025_ sky130_fd_sc_hd__a21oi_1
X_11371_ network.neuron_in240.counter\[0\] VSS VSS VDD VDD
+ _00427_ sky130_fd_sc_hd__inv_1
X_11372_ network.in_period\[240\]\[0\] _07732_ VSS VSS VDD
+ VDD _07757_ sky130_fd_sc_hd__nand2_1
X_11373_ network.neuron_in240.counter\[0\] _07732_ _07757_
+ VSS VSS VDD VDD _03023_ sky130_fd_sc_hd__o21ai_0
X_11374_ network.neuron_in208.counter\[1\] VSS VSS VDD VDD
+ _00999_ sky130_fd_sc_hd__inv_1
X_11375_ network.neuron_in242.counter\[2\] VSS VSS VDD VDD
+ _07758_ sky130_fd_sc_hd__inv_1
X_11376_ network.in_period\[242\]\[2\] network.neuron_in242.counter\[3\]
+ _01188_ net417 VSS VSS VDD VDD _07759_ sky130_fd_sc_hd__o22ai_1
X_11377_ network.neuron_in242.counter\[2\] _01188_ net365
+ VSS VSS VDD VDD _07760_ sky130_fd_sc_hd__nand3_1
X_11378_ network.in_period\[242\]\[2\] net365 _07760_ VSS
+ VSS VDD VDD _07761_ sky130_fd_sc_hd__o21ai_0
X_11379_ _07758_ _07759_ _07761_ VSS VSS VDD VDD _03033_ sky130_fd_sc_hd__a21oi_1
X_11380_ network.neuron_in252.counter\[0\] VSS VSS VDD VDD
+ _00485_ sky130_fd_sc_hd__inv_1
X_11381_ network.neuron_in072.counter\[1\] VSS VSS VDD VDD
+ _00228_ sky130_fd_sc_hd__inv_1
X_11382_ network.neuron_in051.counter\[1\] VSS VSS VDD VDD
+ _00388_ sky130_fd_sc_hd__inv_1
X_11383_ network.neuron_in243.counter\[2\] net364 VSS VSS
+ VDD VDD _07762_ sky130_fd_sc_hd__nand2_1
X_11384_ network.in_period\[243\]\[2\] network.neuron_in243.counter\[3\]
+ _07762_ VSS VSS VDD VDD _07763_ sky130_fd_sc_hd__o21ai_0
Xclkbuf_leaf_54_clk_net clknet_4_11__leaf_clk_net VSS VSS
+ VDD VDD clknet_leaf_54_clk_net sky130_fd_sc_hd__clkbuf_16
X_11386_ _00569_ network.neuron_in243.counter\[2\] net415
+ VSS VSS VDD VDD _07765_ sky130_fd_sc_hd__or3_1
X_11387_ network.in_period\[243\]\[2\] net364 _07765_ VSS
+ VSS VDD VDD _07766_ sky130_fd_sc_hd__o21ai_0
X_11388_ _00569_ _07763_ _07766_ VSS VSS VDD VDD _03037_ sky130_fd_sc_hd__a21oi_1
X_11389_ network.neuron_in098.counter\[1\] VSS VSS VDD VDD
+ _00780_ sky130_fd_sc_hd__inv_1
X_11390_ network.neuron_in056.counter\[0\] VSS VSS VDD VDD
+ _00251_ sky130_fd_sc_hd__inv_1
X_11391_ network.neuron_in243.counter\[2\] _00569_ VSS VSS
+ VDD VDD _07767_ sky130_fd_sc_hd__nand2b_1
X_11392_ network.neuron_in243.counter\[3\] _07767_ VSS VSS
+ VDD VDD _07768_ sky130_fd_sc_hd__or2_2
X_11393_ net364 _07768_ VSS VSS VDD VDD _07769_ sky130_fd_sc_hd__nand2_1
X_11394_ network.in_period\[243\]\[0\] _07769_ VSS VSS VDD
+ VDD _07770_ sky130_fd_sc_hd__nand2_1
X_11395_ network.neuron_in243.counter\[0\] _07769_ _07770_
+ VSS VSS VDD VDD _03035_ sky130_fd_sc_hd__o21ai_0
X_11396_ network.neuron_in244.counter\[2\] net348 VSS VSS
+ VDD VDD _07771_ sky130_fd_sc_hd__nand2_1
X_11397_ network.in_period\[244\]\[2\] network.neuron_in244.counter\[3\]
+ _07771_ VSS VSS VDD VDD _07772_ sky130_fd_sc_hd__o21ai_0
X_11398_ _00670_ network.neuron_in244.counter\[2\] net416
+ VSS VSS VDD VDD _07773_ sky130_fd_sc_hd__or3_1
X_11399_ network.in_period\[244\]\[2\] net348 _07773_ VSS
+ VSS VDD VDD _07774_ sky130_fd_sc_hd__o21ai_0
X_11400_ _00670_ _07772_ _07774_ VSS VSS VDD VDD _03041_ sky130_fd_sc_hd__a21oi_1
X_11401_ network.neuron_in097.counter\[1\] VSS VSS VDD VDD
+ _00077_ sky130_fd_sc_hd__inv_1
X_11402_ network.neuron_in112.counter\[1\] VSS VSS VDD VDD
+ _00770_ sky130_fd_sc_hd__inv_1
X_11403_ network.neuron_in245.counter\[2\] VSS VSS VDD VDD
+ _07775_ sky130_fd_sc_hd__inv_1
X_11404_ network.in_period\[245\]\[2\] network.neuron_in245.counter\[3\]
+ _00906_ net416 VSS VSS VDD VDD _07776_ sky130_fd_sc_hd__o22ai_1
Xclkbuf_leaf_53_clk_net clknet_4_11__leaf_clk_net VSS VSS
+ VDD VDD clknet_leaf_53_clk_net sky130_fd_sc_hd__clkbuf_16
X_11406_ network.neuron_in245.counter\[2\] _00906_ net348
+ VSS VSS VDD VDD _07778_ sky130_fd_sc_hd__nand3_1
X_11407_ network.in_period\[245\]\[2\] net348 _07778_ VSS
+ VSS VDD VDD _07779_ sky130_fd_sc_hd__o21ai_0
X_11408_ _07775_ _07776_ _07779_ VSS VSS VDD VDD _03045_ sky130_fd_sc_hd__a21oi_1
Xclkbuf_leaf_52_clk_net clknet_4_11__leaf_clk_net VSS VSS
+ VDD VDD clknet_leaf_52_clk_net sky130_fd_sc_hd__clkbuf_16
X_11410_ _00910_ _07712_ VSS VSS VDD VDD _07781_ sky130_fd_sc_hd__nand2_1
X_11411_ net364 _07781_ VSS VSS VDD VDD _07782_ sky130_fd_sc_hd__nand2_1
X_11412_ network.in_period\[241\]\[1\] _07782_ VSS VSS VDD
+ VDD _07783_ sky130_fd_sc_hd__nand2_1
X_11413_ _00911_ _07782_ _07783_ VSS VSS VDD VDD _03028_ sky130_fd_sc_hd__o21ai_0
X_11414_ network.neuron_in241.counter\[0\] VSS VSS VDD VDD
+ _00908_ sky130_fd_sc_hd__inv_1
X_11415_ network.in_period\[241\]\[0\] _07782_ VSS VSS VDD
+ VDD _07784_ sky130_fd_sc_hd__nand2_1
X_11416_ network.neuron_in241.counter\[0\] _07782_ _07784_
+ VSS VSS VDD VDD _03027_ sky130_fd_sc_hd__o21ai_0
X_11417_ network.neuron_in233.counter\[1\] VSS VSS VDD VDD
+ _00995_ sky130_fd_sc_hd__inv_1
X_11418_ network.neuron_in242.counter\[3\] _01188_ VSS VSS
+ VDD VDD _07785_ sky130_fd_sc_hd__nand2b_1
X_11419_ _07785_ _07758_ VSS VSS VDD VDD _07786_ sky130_fd_sc_hd__nand2b_1
X_11420_ net365 _07786_ VSS VSS VDD VDD _07787_ sky130_fd_sc_hd__nand2_1
X_11421_ network.in_period\[242\]\[1\] _07787_ VSS VSS VDD
+ VDD _07788_ sky130_fd_sc_hd__nand2_1
X_11422_ _01189_ _07787_ _07788_ VSS VSS VDD VDD _03032_ sky130_fd_sc_hd__o21ai_0
X_11423_ network.neuron_in177.counter\[0\] VSS VSS VDD VDD
+ _00950_ sky130_fd_sc_hd__inv_1
X_11424_ network.neuron_in177.counter\[3\] _00952_ VSS VSS
+ VDD VDD _07789_ sky130_fd_sc_hd__nand2b_1
X_11425_ network.neuron_in177.counter\[2\] VSS VSS VDD VDD
+ _07790_ sky130_fd_sc_hd__inv_1
X_11426_ _07789_ _07790_ VSS VSS VDD VDD _07791_ sky130_fd_sc_hd__nand2b_1
X_11427_ net361 _07791_ VSS VSS VDD VDD _07792_ sky130_fd_sc_hd__nand2_1
X_11428_ network.in_period\[177\]\[0\] _07792_ VSS VSS VDD
+ VDD _07793_ sky130_fd_sc_hd__nand2_1
X_11429_ network.neuron_in177.counter\[0\] _07792_ _07793_
+ VSS VSS VDD VDD _02771_ sky130_fd_sc_hd__o21ai_0
X_11430_ network.neuron_in172.counter\[3\] _01060_ VSS VSS
+ VDD VDD _07794_ sky130_fd_sc_hd__nand2b_1
X_11431_ network.neuron_in172.counter\[2\] VSS VSS VDD VDD
+ _07795_ sky130_fd_sc_hd__inv_1
X_11432_ _07794_ _07795_ VSS VSS VDD VDD _07796_ sky130_fd_sc_hd__nand2b_1
X_11433_ net364 _07796_ VSS VSS VDD VDD _07797_ sky130_fd_sc_hd__nand2_1
X_11434_ network.in_period\[172\]\[1\] _07797_ VSS VSS VDD
+ VDD _07798_ sky130_fd_sc_hd__nand2_1
X_11435_ _01061_ _07797_ _07798_ VSS VSS VDD VDD _02752_ sky130_fd_sc_hd__o21ai_0
X_11436_ network.in_period\[177\]\[1\] _07792_ VSS VSS VDD
+ VDD _07799_ sky130_fd_sc_hd__nand2_1
X_11437_ _00953_ _07792_ _07799_ VSS VSS VDD VDD _02772_ sky130_fd_sc_hd__o21ai_0
X_11438_ network.neuron_in169.counter\[0\] VSS VSS VDD VDD
+ _00982_ sky130_fd_sc_hd__inv_1
X_11439_ network.neuron_in169.counter\[3\] _00984_ VSS VSS
+ VDD VDD _07800_ sky130_fd_sc_hd__nand2b_1
X_11440_ network.neuron_in169.counter\[2\] VSS VSS VDD VDD
+ _07801_ sky130_fd_sc_hd__inv_1
X_11441_ _07800_ _07801_ VSS VSS VDD VDD _07802_ sky130_fd_sc_hd__nand2b_1
X_11442_ net346 _07802_ VSS VSS VDD VDD _07803_ sky130_fd_sc_hd__nand2_1
X_11443_ network.in_period\[169\]\[0\] _07803_ VSS VSS VDD
+ VDD _07804_ sky130_fd_sc_hd__nand2_1
X_11444_ network.neuron_in169.counter\[0\] _07803_ _07804_
+ VSS VSS VDD VDD _02739_ sky130_fd_sc_hd__o21ai_0
Xclkbuf_leaf_51_clk_net clknet_4_11__leaf_clk_net VSS VSS
+ VDD VDD clknet_leaf_51_clk_net sky130_fd_sc_hd__clkbuf_16
Xclkbuf_leaf_50_clk_net clknet_4_11__leaf_clk_net VSS VSS
+ VDD VDD clknet_leaf_50_clk_net sky130_fd_sc_hd__clkbuf_16
X_11447_ network.neuron_in172.counter\[3\] network.in_period\[172\]\[2\]
+ net415 _01060_ VSS VSS VDD VDD _07807_ sky130_fd_sc_hd__o22ai_1
X_11448_ network.neuron_in172.counter\[2\] _01060_ net364
+ VSS VSS VDD VDD _07808_ sky130_fd_sc_hd__nand3_1
X_11449_ network.in_period\[172\]\[2\] net364 _07808_ VSS
+ VSS VDD VDD _07809_ sky130_fd_sc_hd__o21ai_0
X_11450_ _07795_ _07807_ _07809_ VSS VSS VDD VDD _02753_ sky130_fd_sc_hd__a21oi_1
X_11451_ network.neuron_in174.counter\[0\] VSS VSS VDD VDD
+ _00327_ sky130_fd_sc_hd__inv_1
X_11452_ network.neuron_in174.counter\[3\] _00329_ VSS VSS
+ VDD VDD _07810_ sky130_fd_sc_hd__nand2b_1
X_11453_ network.neuron_in174.counter\[2\] VSS VSS VDD VDD
+ _07811_ sky130_fd_sc_hd__inv_1
X_11454_ _07810_ _07811_ VSS VSS VDD VDD _07812_ sky130_fd_sc_hd__nand2b_1
X_11455_ net363 _07812_ VSS VSS VDD VDD _07813_ sky130_fd_sc_hd__nand2_1
X_11456_ network.in_period\[174\]\[0\] _07813_ VSS VSS VDD
+ VDD _07814_ sky130_fd_sc_hd__nand2_1
X_11457_ network.neuron_in174.counter\[0\] _07813_ _07814_
+ VSS VSS VDD VDD _02759_ sky130_fd_sc_hd__o21ai_0
X_11458_ network.neuron_in177.counter\[3\] network.in_period\[177\]\[2\]
+ _00952_ net415 VSS VSS VDD VDD _07815_ sky130_fd_sc_hd__o22ai_1
X_11459_ network.neuron_in177.counter\[2\] _00952_ net361
+ VSS VSS VDD VDD _07816_ sky130_fd_sc_hd__nand3_1
X_11460_ network.in_period\[177\]\[2\] net361 _07816_ VSS
+ VSS VDD VDD _07817_ sky130_fd_sc_hd__o21ai_0
X_11461_ _07790_ _07815_ _07817_ VSS VSS VDD VDD _02773_ sky130_fd_sc_hd__a21oi_1
X_11462_ network.neuron_in168.counter\[3\] _00948_ VSS VSS
+ VDD VDD _07818_ sky130_fd_sc_hd__nand2b_1
X_11463_ network.neuron_in168.counter\[2\] VSS VSS VDD VDD
+ _07819_ sky130_fd_sc_hd__inv_1
X_11464_ _07818_ _07819_ VSS VSS VDD VDD _07820_ sky130_fd_sc_hd__nand2b_1
X_11465_ net346 _07820_ VSS VSS VDD VDD _07821_ sky130_fd_sc_hd__nand2_1
X_11466_ network.in_period\[168\]\[1\] _07821_ VSS VSS VDD
+ VDD _07822_ sky130_fd_sc_hd__nand2_1
X_11467_ _00949_ _07821_ _07822_ VSS VSS VDD VDD _02736_ sky130_fd_sc_hd__o21ai_0
X_11468_ network.in_period\[169\]\[1\] _07803_ VSS VSS VDD
+ VDD _07823_ sky130_fd_sc_hd__nand2_1
X_11469_ _00985_ _07803_ _07823_ VSS VSS VDD VDD _02740_ sky130_fd_sc_hd__o21ai_0
X_11470_ network.neuron_in170.counter\[2\] network.neuron_in170.counter\[3\]
+ VSS VSS VDD VDD _07824_ sky130_fd_sc_hd__nor2_1
X_11471_ _01012_ _07824_ VSS VSS VDD VDD _07825_ sky130_fd_sc_hd__nand2_1
X_11472_ net361 _07825_ VSS VSS VDD VDD _07826_ sky130_fd_sc_hd__nand2_1
X_11473_ network.in_period\[170\]\[0\] _07826_ VSS VSS VDD
+ VDD _07827_ sky130_fd_sc_hd__nand2_1
X_11474_ network.neuron_in170.counter\[0\] _07826_ _07827_
+ VSS VSS VDD VDD _02743_ sky130_fd_sc_hd__o21ai_0
X_11475_ network.neuron_in171.counter\[3\] _01030_ VSS VSS
+ VDD VDD _07828_ sky130_fd_sc_hd__nand2b_1
X_11476_ network.neuron_in171.counter\[2\] VSS VSS VDD VDD
+ _07829_ sky130_fd_sc_hd__inv_1
X_11477_ _07828_ _07829_ VSS VSS VDD VDD _07830_ sky130_fd_sc_hd__nand2b_1
X_11478_ net361 _07830_ VSS VSS VDD VDD _07831_ sky130_fd_sc_hd__nand2_1
X_11479_ network.in_period\[171\]\[0\] _07831_ VSS VSS VDD
+ VDD _07832_ sky130_fd_sc_hd__nand2_1
X_11480_ network.neuron_in171.counter\[0\] _07831_ _07832_
+ VSS VSS VDD VDD _02747_ sky130_fd_sc_hd__o21ai_0
X_11481_ network.neuron_in173.counter\[2\] network.neuron_in173.counter\[3\]
+ VSS VSS VDD VDD _07833_ sky130_fd_sc_hd__nor2_1
X_11482_ _00841_ _07833_ VSS VSS VDD VDD _07834_ sky130_fd_sc_hd__nand2_1
X_11483_ net363 _07834_ VSS VSS VDD VDD _07835_ sky130_fd_sc_hd__nand2_1
X_11484_ network.in_period\[173\]\[1\] _07835_ VSS VSS VDD
+ VDD _07836_ sky130_fd_sc_hd__nand2_1
X_11485_ _00842_ _07835_ _07836_ VSS VSS VDD VDD _02756_ sky130_fd_sc_hd__o21ai_0
X_11486_ network.in_period\[174\]\[1\] _07813_ VSS VSS VDD
+ VDD _07837_ sky130_fd_sc_hd__nand2_1
X_11487_ _00330_ _07813_ _07837_ VSS VSS VDD VDD _02760_ sky130_fd_sc_hd__o21ai_0
X_11488_ network.neuron_in175.counter\[0\] VSS VSS VDD VDD
+ _00990_ sky130_fd_sc_hd__inv_1
X_11489_ network.neuron_in175.counter\[3\] _00992_ VSS VSS
+ VDD VDD _07838_ sky130_fd_sc_hd__nand2b_1
X_11490_ network.neuron_in175.counter\[2\] VSS VSS VDD VDD
+ _07839_ sky130_fd_sc_hd__inv_1
X_11491_ _07838_ _07839_ VSS VSS VDD VDD _07840_ sky130_fd_sc_hd__nand2b_1
X_11492_ net361 _07840_ VSS VSS VDD VDD _07841_ sky130_fd_sc_hd__nand2_1
X_11493_ network.in_period\[175\]\[0\] _07841_ VSS VSS VDD
+ VDD _07842_ sky130_fd_sc_hd__nand2_1
X_11494_ network.neuron_in175.counter\[0\] _07841_ _07842_
+ VSS VSS VDD VDD _02763_ sky130_fd_sc_hd__o21ai_0
X_11495_ network.neuron_in176.counter\[3\] _00617_ VSS VSS
+ VDD VDD _07843_ sky130_fd_sc_hd__nand2b_1
X_11496_ network.neuron_in176.counter\[2\] VSS VSS VDD VDD
+ _07844_ sky130_fd_sc_hd__inv_1
X_11497_ _07843_ _07844_ VSS VSS VDD VDD _07845_ sky130_fd_sc_hd__nand2b_1
X_11498_ net362 _07845_ VSS VSS VDD VDD _07846_ sky130_fd_sc_hd__nand2_1
X_11499_ network.in_period\[176\]\[0\] _07846_ VSS VSS VDD
+ VDD _07847_ sky130_fd_sc_hd__nand2_1
X_11500_ network.neuron_in176.counter\[0\] _07846_ _07847_
+ VSS VSS VDD VDD _02767_ sky130_fd_sc_hd__o21ai_0
X_11501_ network.neuron_in167.counter\[0\] VSS VSS VDD VDD
+ _00918_ sky130_fd_sc_hd__inv_1
Xclkbuf_leaf_49_clk_net clknet_4_10__leaf_clk_net VSS VSS
+ VDD VDD clknet_leaf_49_clk_net sky130_fd_sc_hd__clkbuf_16
Xclkbuf_leaf_48_clk_net clknet_4_10__leaf_clk_net VSS VSS
+ VDD VDD clknet_leaf_48_clk_net sky130_fd_sc_hd__clkbuf_16
X_11504_ network.neuron_in167.counter\[3\] _00920_ VSS VSS
+ VDD VDD _07850_ sky130_fd_sc_hd__nand2b_1
X_11505_ network.neuron_in167.counter\[2\] _07850_ VSS VSS
+ VDD VDD _07851_ sky130_fd_sc_hd__or2_2
X_11506_ net346 _07851_ VSS VSS VDD VDD _07852_ sky130_fd_sc_hd__nand2_1
X_11507_ network.in_period\[167\]\[0\] _07852_ VSS VSS VDD
+ VDD _07853_ sky130_fd_sc_hd__nand2_1
X_11508_ network.neuron_in167.counter\[0\] _07852_ _07853_
+ VSS VSS VDD VDD _02731_ sky130_fd_sc_hd__o21ai_0
X_11509_ network.neuron_in168.counter\[3\] network.in_period\[168\]\[2\]
+ _00948_ net414 VSS VSS VDD VDD _07854_ sky130_fd_sc_hd__o22ai_1
X_11510_ network.neuron_in168.counter\[2\] _00948_ net346
+ VSS VSS VDD VDD _07855_ sky130_fd_sc_hd__nand3_1
X_11511_ network.in_period\[168\]\[2\] net346 _07855_ VSS
+ VSS VDD VDD _07856_ sky130_fd_sc_hd__o21ai_0
X_11512_ _07819_ _07854_ _07856_ VSS VSS VDD VDD _02737_ sky130_fd_sc_hd__a21oi_1
X_11513_ network.neuron_in168.counter\[0\] VSS VSS VDD VDD
+ _00946_ sky130_fd_sc_hd__inv_1
X_11514_ network.in_period\[168\]\[0\] _07821_ VSS VSS VDD
+ VDD _07857_ sky130_fd_sc_hd__nand2_1
X_11515_ network.neuron_in168.counter\[0\] _07821_ _07857_
+ VSS VSS VDD VDD _02735_ sky130_fd_sc_hd__o21ai_0
X_11516_ network.neuron_in169.counter\[3\] network.in_period\[169\]\[2\]
+ _00984_ net414 VSS VSS VDD VDD _07858_ sky130_fd_sc_hd__o22ai_1
X_11517_ network.neuron_in169.counter\[2\] _00984_ net346
+ VSS VSS VDD VDD _07859_ sky130_fd_sc_hd__nand3_1
X_11518_ network.in_period\[169\]\[2\] net346 _07859_ VSS
+ VSS VDD VDD _07860_ sky130_fd_sc_hd__o21ai_0
X_11519_ _07801_ _07858_ _07860_ VSS VSS VDD VDD _02741_ sky130_fd_sc_hd__a21oi_1
X_11520_ network.neuron_in170.counter\[2\] net361 VSS VSS
+ VDD VDD _07861_ sky130_fd_sc_hd__nand2_1
X_11521_ network.in_period\[170\]\[2\] network.neuron_in170.counter\[3\]
+ _07861_ VSS VSS VDD VDD _07862_ sky130_fd_sc_hd__o21ai_0
X_11522_ _01012_ network.neuron_in170.counter\[2\] net415
+ VSS VSS VDD VDD _07863_ sky130_fd_sc_hd__or3_1
X_11523_ network.in_period\[170\]\[2\] net361 _07863_ VSS
+ VSS VDD VDD _07864_ sky130_fd_sc_hd__o21ai_0
X_11524_ _01012_ _07862_ _07864_ VSS VSS VDD VDD _02745_ sky130_fd_sc_hd__a21oi_1
X_11525_ network.in_period\[170\]\[1\] _07826_ VSS VSS VDD
+ VDD _07865_ sky130_fd_sc_hd__nand2_1
X_11526_ _01013_ _07826_ _07865_ VSS VSS VDD VDD _02744_ sky130_fd_sc_hd__o21ai_0
X_11527_ network.neuron_in171.counter\[3\] network.in_period\[171\]\[2\]
+ net415 _01030_ VSS VSS VDD VDD _07866_ sky130_fd_sc_hd__o22ai_1
Xclkbuf_leaf_47_clk_net clknet_4_10__leaf_clk_net VSS VSS
+ VDD VDD clknet_leaf_47_clk_net sky130_fd_sc_hd__clkbuf_16
X_11529_ network.neuron_in171.counter\[2\] _01030_ net361
+ VSS VSS VDD VDD _07868_ sky130_fd_sc_hd__nand3_1
X_11530_ network.in_period\[171\]\[2\] net361 _07868_ VSS
+ VSS VDD VDD _07869_ sky130_fd_sc_hd__o21ai_0
X_11531_ _07829_ _07866_ _07869_ VSS VSS VDD VDD _02749_ sky130_fd_sc_hd__a21oi_1
X_11532_ network.in_period\[171\]\[1\] _07831_ VSS VSS VDD
+ VDD _07870_ sky130_fd_sc_hd__nand2_1
X_11533_ _01031_ _07831_ _07870_ VSS VSS VDD VDD _02748_ sky130_fd_sc_hd__o21ai_0
X_11534_ network.in_period\[172\]\[0\] _07797_ VSS VSS VDD
+ VDD _07871_ sky130_fd_sc_hd__nand2_1
X_11535_ network.neuron_in172.counter\[0\] _07797_ _07871_
+ VSS VSS VDD VDD _02751_ sky130_fd_sc_hd__o21ai_0
X_11536_ network.neuron_in173.counter\[2\] VSS VSS VDD VDD
+ _07872_ sky130_fd_sc_hd__inv_1
X_11537_ network.in_period\[173\]\[2\] network.neuron_in173.counter\[3\]
+ _00841_ net415 VSS VSS VDD VDD _07873_ sky130_fd_sc_hd__o22ai_1
X_11538_ network.neuron_in173.counter\[2\] _00841_ net363
+ VSS VSS VDD VDD _07874_ sky130_fd_sc_hd__nand3_1
X_11539_ network.in_period\[173\]\[2\] net363 _07874_ VSS
+ VSS VDD VDD _07875_ sky130_fd_sc_hd__o21ai_0
X_11540_ _07872_ _07873_ _07875_ VSS VSS VDD VDD _02757_ sky130_fd_sc_hd__a21oi_1
X_11541_ network.neuron_in173.counter\[0\] VSS VSS VDD VDD
+ _00839_ sky130_fd_sc_hd__inv_1
X_11542_ network.in_period\[173\]\[0\] _07835_ VSS VSS VDD
+ VDD _07876_ sky130_fd_sc_hd__nand2_1
X_11543_ network.neuron_in173.counter\[0\] _07835_ _07876_
+ VSS VSS VDD VDD _02755_ sky130_fd_sc_hd__o21ai_0
X_11544_ network.neuron_in174.counter\[3\] network.in_period\[174\]\[2\]
+ _00329_ net415 VSS VSS VDD VDD _07877_ sky130_fd_sc_hd__o22ai_1
X_11545_ network.neuron_in174.counter\[2\] _00329_ net364
+ VSS VSS VDD VDD _07878_ sky130_fd_sc_hd__nand3_1
X_11546_ network.in_period\[174\]\[2\] net363 _07878_ VSS
+ VSS VDD VDD _07879_ sky130_fd_sc_hd__o21ai_0
X_11547_ _07811_ _07877_ _07879_ VSS VSS VDD VDD _02761_ sky130_fd_sc_hd__a21oi_1
Xclkbuf_leaf_46_clk_net clknet_4_10__leaf_clk_net VSS VSS
+ VDD VDD clknet_leaf_46_clk_net sky130_fd_sc_hd__clkbuf_16
X_11549_ network.neuron_in175.counter\[3\] network.in_period\[175\]\[2\]
+ _00992_ net416 VSS VSS VDD VDD _07881_ sky130_fd_sc_hd__o22ai_1
X_11550_ network.neuron_in175.counter\[2\] _00992_ net364
+ VSS VSS VDD VDD _07882_ sky130_fd_sc_hd__nand3_1
X_11551_ network.in_period\[175\]\[2\] net364 _07882_ VSS
+ VSS VDD VDD _07883_ sky130_fd_sc_hd__o21ai_0
X_11552_ _07839_ _07881_ _07883_ VSS VSS VDD VDD _02765_ sky130_fd_sc_hd__a21oi_1
X_11553_ network.in_period\[175\]\[1\] _07841_ VSS VSS VDD
+ VDD _07884_ sky130_fd_sc_hd__nand2_1
X_11554_ _00993_ _07841_ _07884_ VSS VSS VDD VDD _02764_ sky130_fd_sc_hd__o21ai_0
X_11555_ network.neuron_in176.counter\[3\] network.in_period\[176\]\[2\]
+ net415 _00617_ VSS VSS VDD VDD _07885_ sky130_fd_sc_hd__o22ai_1
Xclkbuf_leaf_45_clk_net clknet_4_10__leaf_clk_net VSS VSS
+ VDD VDD clknet_leaf_45_clk_net sky130_fd_sc_hd__clkbuf_16
X_11557_ network.neuron_in176.counter\[2\] _00617_ net362
+ VSS VSS VDD VDD _07887_ sky130_fd_sc_hd__nand3_1
X_11558_ network.in_period\[176\]\[2\] net362 _07887_ VSS
+ VSS VDD VDD _07888_ sky130_fd_sc_hd__o21ai_0
X_11559_ _07844_ _07885_ _07888_ VSS VSS VDD VDD _02769_ sky130_fd_sc_hd__a21oi_1
X_11560_ network.in_period\[176\]\[1\] _07846_ VSS VSS VDD
+ VDD _07889_ sky130_fd_sc_hd__nand2_1
X_11561_ _00618_ _07846_ _07889_ VSS VSS VDD VDD _02768_ sky130_fd_sc_hd__o21ai_0
X_11562_ network.neuron_in028.counter\[2\] VSS VSS VDD VDD
+ _07890_ sky130_fd_sc_hd__inv_1
X_11563_ _07890_ _00425_ VSS VSS VDD VDD _07891_ sky130_fd_sc_hd__nand2_1
X_11564_ network.neuron_in028.counter\[3\] _07891_ VSS VSS
+ VDD VDD _07892_ sky130_fd_sc_hd__or2_2
X_11565_ net341 _07892_ VSS VSS VDD VDD _07893_ sky130_fd_sc_hd__nand2_1
X_11566_ network.in_period\[28\]\[0\] _07893_ VSS VSS VDD
+ VDD _07894_ sky130_fd_sc_hd__nand2_1
X_11567_ network.neuron_in028.counter\[0\] _07893_ _07894_
+ VSS VSS VDD VDD _02175_ sky130_fd_sc_hd__o21ai_0
X_11568_ network.in_period\[28\]\[1\] _07893_ VSS VSS VDD
+ VDD _07895_ sky130_fd_sc_hd__nand2_1
X_11569_ _00426_ _07893_ _07895_ VSS VSS VDD VDD _02176_ sky130_fd_sc_hd__o21ai_0
X_11570_ network.neuron_in029.counter\[2\] VSS VSS VDD VDD
+ _07896_ sky130_fd_sc_hd__inv_1
X_11571_ network.in_period\[29\]\[2\] network.neuron_in029.counter\[3\]
+ net422 _00409_ VSS VSS VDD VDD _07897_ sky130_fd_sc_hd__o22ai_1
X_11572_ network.neuron_in029.counter\[2\] _00409_ net349
+ VSS VSS VDD VDD _07898_ sky130_fd_sc_hd__nand3_1
X_11573_ network.in_period\[29\]\[2\] net349 _07898_ VSS VSS
+ VDD VDD _07899_ sky130_fd_sc_hd__o21ai_0
X_11574_ _07896_ _07897_ _07899_ VSS VSS VDD VDD _02181_ sky130_fd_sc_hd__a21oi_1
X_11575_ network.in_period\[28\]\[2\] network.neuron_in028.counter\[3\]
+ _00425_ net424 VSS VSS VDD VDD _07900_ sky130_fd_sc_hd__o22ai_1
X_11576_ network.neuron_in028.counter\[2\] _00425_ net341
+ VSS VSS VDD VDD _07901_ sky130_fd_sc_hd__nand3_1
X_11577_ network.in_period\[28\]\[2\] net341 _07901_ VSS VSS
+ VDD VDD _07902_ sky130_fd_sc_hd__o21ai_0
X_11578_ _07890_ _07900_ _07902_ VSS VSS VDD VDD _02177_ sky130_fd_sc_hd__a21oi_1
X_11579_ network.neuron_in029.counter\[3\] _00409_ VSS VSS
+ VDD VDD _07903_ sky130_fd_sc_hd__nand2b_1
X_11580_ _07903_ _07896_ VSS VSS VDD VDD _07904_ sky130_fd_sc_hd__nand2b_1
X_11581_ net349 _07904_ VSS VSS VDD VDD _07905_ sky130_fd_sc_hd__nand2_1
X_11582_ network.in_period\[29\]\[1\] _07905_ VSS VSS VDD
+ VDD _07906_ sky130_fd_sc_hd__nand2_1
X_11583_ _00410_ _07905_ _07906_ VSS VSS VDD VDD _02180_ sky130_fd_sc_hd__o21ai_0
X_11584_ network.neuron_in029.counter\[0\] VSS VSS VDD VDD
+ _00407_ sky130_fd_sc_hd__inv_1
X_11585_ network.in_period\[29\]\[0\] _07905_ VSS VSS VDD
+ VDD _07907_ sky130_fd_sc_hd__nand2_1
X_11586_ network.neuron_in029.counter\[0\] _07905_ _07907_
+ VSS VSS VDD VDD _02179_ sky130_fd_sc_hd__o21ai_0
X_11587_ network.neuron_in146.counter\[1\] VSS VSS VDD VDD
+ _00346_ sky130_fd_sc_hd__inv_1
X_11588_ network.neuron_in073.counter\[0\] VSS VSS VDD VDD
+ _00137_ sky130_fd_sc_hd__inv_1
X_11589_ network.neuron_in242.counter\[0\] VSS VSS VDD VDD
+ _01186_ sky130_fd_sc_hd__inv_1
X_11590_ network.in_period\[242\]\[0\] _07787_ VSS VSS VDD
+ VDD _07908_ sky130_fd_sc_hd__nand2_1
X_11591_ network.neuron_in242.counter\[0\] _07787_ _07908_
+ VSS VSS VDD VDD _03031_ sky130_fd_sc_hd__o21ai_0
X_11592_ network.in_period\[243\]\[1\] _07769_ VSS VSS VDD
+ VDD _07909_ sky130_fd_sc_hd__nand2_1
X_11593_ _00570_ _07769_ _07909_ VSS VSS VDD VDD _03036_ sky130_fd_sc_hd__o21ai_0
X_11594_ network.neuron_in127.counter\[0\] VSS VSS VDD VDD
+ _01112_ sky130_fd_sc_hd__inv_1
X_11595_ network.in_period\[144\]\[0\] _07000_ VSS VSS VDD
+ VDD _07910_ sky130_fd_sc_hd__nand2_1
X_11596_ network.neuron_in144.counter\[0\] _07000_ _07910_
+ VSS VSS VDD VDD _02639_ sky130_fd_sc_hd__o21ai_0
X_11597_ network.neuron_in132.counter\[1\] VSS VSS VDD VDD
+ _01167_ sky130_fd_sc_hd__inv_1
X_11598_ network.neuron_in089.counter\[1\] VSS VSS VDD VDD
+ _01217_ sky130_fd_sc_hd__inv_1
X_11599_ network.neuron_in102.counter\[0\] VSS VSS VDD VDD
+ _00213_ sky130_fd_sc_hd__inv_1
X_11600_ network.neuron_in033.counter\[1\] VSS VSS VDD VDD
+ _00628_ sky130_fd_sc_hd__inv_1
Xclkbuf_leaf_44_clk_net clknet_4_10__leaf_clk_net VSS VSS
+ VDD VDD clknet_leaf_44_clk_net sky130_fd_sc_hd__clkbuf_16
X_11602_ network.neuron_in141.counter\[2\] net352 VSS VSS
+ VDD VDD _07912_ sky130_fd_sc_hd__nand2_1
X_11603_ network.in_period\[141\]\[2\] network.neuron_in141.counter\[3\]
+ _07912_ VSS VSS VDD VDD _07913_ sky130_fd_sc_hd__o21ai_0
X_11604_ _00261_ network.neuron_in141.counter\[2\] net421
+ VSS VSS VDD VDD _07914_ sky130_fd_sc_hd__or3_1
X_11605_ network.in_period\[141\]\[2\] net352 _07914_ VSS
+ VSS VDD VDD _07915_ sky130_fd_sc_hd__o21ai_0
X_11606_ _00261_ _07913_ _07915_ VSS VSS VDD VDD _02629_ sky130_fd_sc_hd__a21oi_1
X_11607_ network.in_period\[141\]\[1\] _07156_ VSS VSS VDD
+ VDD _07916_ sky130_fd_sc_hd__nand2_1
X_11608_ _00262_ _07156_ _07916_ VSS VSS VDD VDD _02628_ sky130_fd_sc_hd__o21ai_0
X_11609_ network.neuron_in231.counter\[1\] VSS VSS VDD VDD
+ _00731_ sky130_fd_sc_hd__inv_1
X_11610_ network.neuron_in175.counter\[1\] VSS VSS VDD VDD
+ _00991_ sky130_fd_sc_hd__inv_1
X_11611_ network.neuron_in084.counter\[1\] VSS VSS VDD VDD
+ _00047_ sky130_fd_sc_hd__inv_1
X_11612_ network.neuron_in234.counter\[1\] VSS VSS VDD VDD
+ _00927_ sky130_fd_sc_hd__inv_1
X_11613_ network.neuron_in123.counter\[1\] VSS VSS VDD VDD
+ _00240_ sky130_fd_sc_hd__inv_1
X_11614_ network.neuron_in246.counter\[1\] VSS VSS VDD VDD
+ _00452_ sky130_fd_sc_hd__inv_1
X_11615_ network.neuron_in177.counter\[1\] VSS VSS VDD VDD
+ _00951_ sky130_fd_sc_hd__inv_1
X_11616_ network.neuron_in032.counter\[1\] VSS VSS VDD VDD
+ _01135_ sky130_fd_sc_hd__inv_1
X_11617_ network.neuron_in062.counter\[1\] VSS VSS VDD VDD
+ _00632_ sky130_fd_sc_hd__inv_1
X_11618_ network.neuron_in090.counter\[1\] VSS VSS VDD VDD
+ _00644_ sky130_fd_sc_hd__inv_1
X_11619_ network.neuron_in009.counter\[0\] VSS VSS VDD VDD
+ _00543_ sky130_fd_sc_hd__inv_1
X_11620_ network.neuron_in115.counter\[1\] VSS VSS VDD VDD
+ _01209_ sky130_fd_sc_hd__inv_1
X_11621_ network.neuron_in043.counter\[0\] VSS VSS VDD VDD
+ _00335_ sky130_fd_sc_hd__inv_1
X_11622_ network.neuron_in132.counter\[0\] VSS VSS VDD VDD
+ _01166_ sky130_fd_sc_hd__inv_1
X_11623_ network.neuron_in180.counter\[1\] VSS VSS VDD VDD
+ _00987_ sky130_fd_sc_hd__inv_1
X_11624_ network.neuron_in013.counter\[0\] VSS VSS VDD VDD
+ _00513_ sky130_fd_sc_hd__inv_1
X_11625_ network.neuron_in135.counter\[1\] VSS VSS VDD VDD
+ _00067_ sky130_fd_sc_hd__inv_1
X_11626_ network.neuron_in119.counter\[1\] VSS VSS VDD VDD
+ _00652_ sky130_fd_sc_hd__inv_1
X_11627_ network.neuron_in153.counter\[1\] VSS VSS VDD VDD
+ _00552_ sky130_fd_sc_hd__inv_1
X_11628_ network.neuron_in030.counter\[0\] VSS VSS VDD VDD
+ _00481_ sky130_fd_sc_hd__inv_1
X_11629_ network.neuron_in252.counter\[1\] VSS VSS VDD VDD
+ _00486_ sky130_fd_sc_hd__inv_1
X_11630_ network.neuron_in244.counter\[3\] _00670_ VSS VSS
+ VDD VDD _07917_ sky130_fd_sc_hd__nand2b_1
X_11631_ network.neuron_in244.counter\[2\] _07917_ VSS VSS
+ VDD VDD _07918_ sky130_fd_sc_hd__or2_2
X_11632_ net348 _07918_ VSS VSS VDD VDD _07919_ sky130_fd_sc_hd__nand2_1
X_11633_ network.in_period\[244\]\[1\] _07919_ VSS VSS VDD
+ VDD _07920_ sky130_fd_sc_hd__nand2_1
X_11634_ _00671_ _07919_ _07920_ VSS VSS VDD VDD _03040_ sky130_fd_sc_hd__o21ai_0
X_11635_ network.neuron_in244.counter\[0\] VSS VSS VDD VDD
+ _00668_ sky130_fd_sc_hd__inv_1
X_11636_ network.in_period\[244\]\[0\] _07919_ VSS VSS VDD
+ VDD _07921_ sky130_fd_sc_hd__nand2_1
X_11637_ network.neuron_in244.counter\[0\] _07919_ _07921_
+ VSS VSS VDD VDD _03039_ sky130_fd_sc_hd__o21ai_0
X_11638_ net434 net401 _07399_ VSS VSS VDD VDD _07922_ sky130_fd_sc_hd__a21oi_1
X_11639_ net443 _07540_ _07409_ VSS VSS VDD VDD _07923_ sky130_fd_sc_hd__o21ai_0
X_11640_ net441 net445 VSS VSS VDD VDD _07924_ sky130_fd_sc_hd__nand2b_1
X_11641_ net388 _07924_ net434 VSS VSS VDD VDD _07925_ sky130_fd_sc_hd__a21oi_1
X_11642_ net442 net446 net440 VSS VSS VDD VDD _07926_ sky130_fd_sc_hd__nor3b_1
X_11643_ net434 _07923_ _07925_ net377 VSS VSS VDD VDD _07927_
+ sky130_fd_sc_hd__a211oi_1
Xclkbuf_leaf_43_clk_net clknet_4_8__leaf_clk_net VSS VSS VDD
+ VDD clknet_leaf_43_clk_net sky130_fd_sc_hd__clkbuf_16
X_11645_ net434 net448 VSS VSS VDD VDD _07929_ sky130_fd_sc_hd__nand2_1
X_11646_ _07442_ _07929_ net451 _07441_ VSS VSS VDD VDD _07930_
+ sky130_fd_sc_hd__a211oi_1
X_11647_ _07603_ VSS VSS VDD VDD _07931_ sky130_fd_sc_hd__inv_1
X_11648_ net440 net336 _07614_ VSS VSS VDD VDD _07932_ sky130_fd_sc_hd__a21oi_1
X_11649_ _07930_ _07932_ net430 VSS VSS VDD VDD _07933_ sky130_fd_sc_hd__o21ai_0
X_11650_ net443 _07922_ _07927_ net430 _07933_ VSS VSS VDD
+ VDD _07934_ sky130_fd_sc_hd__o221ai_1
X_11651_ _07678_ _07437_ VSS VSS VDD VDD _07935_ sky130_fd_sc_hd__nor2_1
X_11652_ net400 net379 VSS VSS VDD VDD _07936_ sky130_fd_sc_hd__nand2_1
X_11653_ net406 _07593_ VSS VSS VDD VDD _07937_ sky130_fd_sc_hd__nor2_1
X_11654_ net384 _07936_ _07937_ VSS VSS VDD VDD _07938_ sky130_fd_sc_hd__a21oi_1
X_11655_ net445 _07935_ _07938_ VSS VSS VDD VDD _07939_ sky130_fd_sc_hd__o21ai_0
Xclkbuf_leaf_42_clk_net clknet_4_10__leaf_clk_net VSS VSS
+ VDD VDD clknet_leaf_42_clk_net sky130_fd_sc_hd__clkbuf_16
X_11657_ net430 net441 VSS VSS VDD VDD _07941_ sky130_fd_sc_hd__nand2b_1
X_11658_ _07524_ _07941_ VSS VSS VDD VDD _07942_ sky130_fd_sc_hd__nand2_1
X_11659_ net402 _07942_ VSS VSS VDD VDD _07943_ sky130_fd_sc_hd__nand2_1
X_11660_ net444 net391 VSS VSS VDD VDD _07944_ sky130_fd_sc_hd__nand2_1
X_11661_ net409 net388 VSS VSS VDD VDD _07945_ sky130_fd_sc_hd__nand2_1
X_11662_ net430 net450 VSS VSS VDD VDD _07946_ sky130_fd_sc_hd__nor2_1
X_11663_ net432 _07945_ _07946_ net445 net447 VSS VSS VDD
+ VDD _07947_ sky130_fd_sc_hd__a221oi_1
X_11664_ net447 _07943_ _07944_ _07947_ VSS VSS VDD VDD _07948_
+ sky130_fd_sc_hd__a31oi_1
Xclkbuf_leaf_41_clk_net clknet_4_10__leaf_clk_net VSS VSS
+ VDD VDD clknet_leaf_41_clk_net sky130_fd_sc_hd__clkbuf_16
X_11666_ net445 net379 _07946_ _07523_ net408 VSS VSS VDD
+ VDD _07950_ sky130_fd_sc_hd__a32oi_1
X_11667_ net430 _07624_ _07614_ VSS VSS VDD VDD _07951_ sky130_fd_sc_hd__o21a_1
X_11668_ net443 net407 net430 VSS VSS VDD VDD _07952_ sky130_fd_sc_hd__o21ai_0
X_11669_ net434 _07951_ _07952_ VSS VSS VDD VDD _07953_ sky130_fd_sc_hd__o21ai_0
X_11670_ net441 _07953_ VSS VSS VDD VDD _07954_ sky130_fd_sc_hd__nand2_1
X_11671_ net434 _07950_ _07954_ _07702_ VSS VSS VDD VDD _07955_
+ sky130_fd_sc_hd__o211ai_1
X_11672_ net438 _07948_ _07955_ VSS VSS VDD VDD _07956_ sky130_fd_sc_hd__a21oi_1
X_11673_ _07670_ _07934_ _07939_ _07306_ _07956_ VSS VSS VDD
+ VDD _07957_ sky130_fd_sc_hd__a221oi_1
X_11674_ net327 _07957_ VSS VSS VDD VDD _01509_ sky130_fd_sc_hd__nor2_1
X_11675_ net443 _07498_ VSS VSS VDD VDD _07958_ sky130_fd_sc_hd__nand2_1
X_11676_ net406 _07406_ VSS VSS VDD VDD _07959_ sky130_fd_sc_hd__nor2_1
X_11677_ net402 net335 VSS VSS VDD VDD _07960_ sky130_fd_sc_hd__nand2_1
X_11678_ net445 net395 VSS VSS VDD VDD _07961_ sky130_fd_sc_hd__nand2_1
X_11679_ _07960_ _07961_ VSS VSS VDD VDD _07962_ sky130_fd_sc_hd__nand2_1
X_11680_ net448 net443 VSS VSS VDD VDD _07963_ sky130_fd_sc_hd__nand2b_1
Xclkbuf_leaf_40_clk_net clknet_4_8__leaf_clk_net VSS VSS VDD
+ VDD clknet_leaf_40_clk_net sky130_fd_sc_hd__clkbuf_16
X_11682_ net443 net448 VSS VSS VDD VDD _07965_ sky130_fd_sc_hd__nand2b_1
Xclkbuf_leaf_39_clk_net clknet_4_8__leaf_clk_net VSS VSS VDD
+ VDD clknet_leaf_39_clk_net sky130_fd_sc_hd__clkbuf_16
X_11684_ net335 net376 net380 _07965_ net437 VSS VSS VDD VDD
+ _07967_ sky130_fd_sc_hd__o221ai_1
X_11685_ net438 _07962_ _07967_ VSS VSS VDD VDD _07968_ sky130_fd_sc_hd__o21ai_0
X_11686_ _07958_ _07968_ net432 VSS VSS VDD VDD _07969_ sky130_fd_sc_hd__a21oi_1
Xclkbuf_leaf_38_clk_net clknet_4_8__leaf_clk_net VSS VSS VDD
+ VDD clknet_leaf_38_clk_net sky130_fd_sc_hd__clkbuf_16
X_11688_ _07965_ net376 VSS VSS VDD VDD _07971_ sky130_fd_sc_hd__nand2_1
X_11689_ net450 net447 net439 VSS VSS VDD VDD _07972_ sky130_fd_sc_hd__nor3b_1
X_11690_ net450 _07971_ net375 VSS VSS VDD VDD _07973_ sky130_fd_sc_hd__a21oi_1
X_11691_ _07612_ _07973_ VSS VSS VDD VDD _07974_ sky130_fd_sc_hd__nor2_1
X_11692_ net409 _07635_ VSS VSS VDD VDD _07975_ sky130_fd_sc_hd__nand2_1
X_11693_ net447 _07524_ VSS VSS VDD VDD _07976_ sky130_fd_sc_hd__nor2_1
X_11694_ net447 _07975_ net334 _07608_ VSS VSS VDD VDD _07977_
+ sky130_fd_sc_hd__a211oi_1
X_11695_ _07533_ _07489_ VSS VSS VDD VDD _07978_ sky130_fd_sc_hd__nand2_1
X_11696_ net439 _07978_ net402 VSS VSS VDD VDD _07979_ sky130_fd_sc_hd__a21oi_1
X_11697_ net402 _07593_ _07540_ _07979_ VSS VSS VDD VDD _07980_
+ sky130_fd_sc_hd__a31oi_1
X_11698_ net443 net448 VSS VSS VDD VDD _07981_ sky130_fd_sc_hd__nand2_1
X_11699_ net335 _07981_ _07437_ VSS VSS VDD VDD _07982_ sky130_fd_sc_hd__a21oi_1
X_11700_ _07643_ _07982_ net427 VSS VSS VDD VDD _07983_ sky130_fd_sc_hd__a21oi_1
X_11701_ net443 net448 VSS VSS VDD VDD _07984_ sky130_fd_sc_hd__and2_1
Xclkbuf_leaf_37_clk_net clknet_4_8__leaf_clk_net VSS VSS VDD
+ VDD clknet_leaf_37_clk_net sky130_fd_sc_hd__clkbuf_16
X_11703_ net444 net447 VSS VSS VDD VDD _07986_ sky130_fd_sc_hd__nor2_1
X_11704_ _07593_ _07657_ _07986_ net380 VSS VSS VDD VDD _07987_
+ sky130_fd_sc_hd__o22ai_1
X_11705_ net432 net438 VSS VSS VDD VDD _07988_ sky130_fd_sc_hd__nor2b_1
X_11706_ _07984_ _07987_ net374 VSS VSS VDD VDD _07989_ sky130_fd_sc_hd__o21ai_0
X_11707_ net444 _07409_ _07596_ net437 net432 VSS VSS VDD
+ VDD _07990_ sky130_fd_sc_hd__o2111ai_1
X_11708_ _07612_ _07980_ _07983_ _07989_ _07990_ VSS VSS VDD
+ VDD _07991_ sky130_fd_sc_hd__o2111ai_1
X_11709_ net399 _07969_ _07974_ _07977_ _07991_ VSS VSS VDD
+ VDD _07992_ sky130_fd_sc_hd__o41ai_1
Xclkbuf_leaf_36_clk_net clknet_4_8__leaf_clk_net VSS VSS VDD
+ VDD clknet_leaf_36_clk_net sky130_fd_sc_hd__clkbuf_16
X_11711_ net402 _07489_ VSS VSS VDD VDD _07994_ sky130_fd_sc_hd__nor2_1
X_11712_ _07635_ _07431_ VSS VSS VDD VDD _07995_ sky130_fd_sc_hd__nand2_1
Xclkbuf_leaf_35_clk_net clknet_4_8__leaf_clk_net VSS VSS VDD
+ VDD clknet_leaf_35_clk_net sky130_fd_sc_hd__clkbuf_16
X_11714_ _07994_ _07658_ _07995_ net436 VSS VSS VDD VDD _07997_
+ sky130_fd_sc_hd__o22ai_1
Xclkbuf_leaf_34_clk_net clknet_4_9__leaf_clk_net VSS VSS VDD
+ VDD clknet_leaf_34_clk_net sky130_fd_sc_hd__clkbuf_16
Xclkbuf_leaf_33_clk_net clknet_4_8__leaf_clk_net VSS VSS VDD
+ VDD clknet_leaf_33_clk_net sky130_fd_sc_hd__clkbuf_16
X_11717_ net449 net446 VSS VSS VDD VDD _08000_ sky130_fd_sc_hd__nor2_1
X_11718_ net450 net403 net373 net402 VSS VSS VDD VDD _08001_
+ sky130_fd_sc_hd__a22oi_1
Xclkbuf_leaf_32_clk_net clknet_4_8__leaf_clk_net VSS VSS VDD
+ VDD clknet_leaf_32_clk_net sky130_fd_sc_hd__clkbuf_16
X_11720_ net439 _07997_ _08001_ net436 VSS VSS VDD VDD _08003_
+ sky130_fd_sc_hd__o22ai_1
X_11721_ _07562_ _08003_ VSS VSS VDD VDD _08004_ sky130_fd_sc_hd__nand2_1
X_11722_ _07344_ _07992_ _08004_ VSS VSS VDD VDD _01510_ sky130_fd_sc_hd__o21ai_0
X_11723_ net398 net373 VSS VSS VDD VDD _08005_ sky130_fd_sc_hd__nand2_1
X_11724_ net435 _08005_ net402 VSS VSS VDD VDD _08006_ sky130_fd_sc_hd__a21oi_1
X_11725_ _07540_ _08005_ net435 VSS VSS VDD VDD _08007_ sky130_fd_sc_hd__a21oi_1
X_11726_ net408 _07523_ _08006_ _08007_ VSS VSS VDD VDD _08008_
+ sky130_fd_sc_hd__a211oi_1
Xclkbuf_leaf_31_clk_net clknet_4_10__leaf_clk_net VSS VSS
+ VDD VDD clknet_leaf_31_clk_net sky130_fd_sc_hd__clkbuf_16
X_11728_ net438 net445 VSS VSS VDD VDD _08010_ sky130_fd_sc_hd__nand2b_1
Xclkbuf_leaf_30_clk_net clknet_4_10__leaf_clk_net VSS VSS
+ VDD VDD clknet_leaf_30_clk_net sky130_fd_sc_hd__clkbuf_16
X_11730_ net449 net430 VSS VSS VDD VDD _08012_ sky130_fd_sc_hd__nor2b_1
X_11731_ net429 net451 VSS VSS VDD VDD _08013_ sky130_fd_sc_hd__nand2b_1
X_11732_ net444 _07500_ _08013_ VSS VSS VDD VDD _08014_ sky130_fd_sc_hd__a21oi_1
X_11733_ net437 _07986_ _08010_ _08012_ _08014_ VSS VSS VDD
+ VDD _08015_ sky130_fd_sc_hd__a221o_1
X_11734_ net430 net402 VSS VSS VDD VDD _08016_ sky130_fd_sc_hd__nand2_1
X_11735_ _07981_ _08016_ _07539_ VSS VSS VDD VDD _08017_ sky130_fd_sc_hd__a21oi_1
X_11736_ net446 net430 VSS VSS VDD VDD _08018_ sky130_fd_sc_hd__nand2b_1
X_11737_ net430 net402 _07385_ VSS VSS VDD VDD _08019_ sky130_fd_sc_hd__o21ai_0
X_11738_ _07438_ _08018_ _08019_ VSS VSS VDD VDD _08020_ sky130_fd_sc_hd__o21ai_0
X_11739_ net441 net448 net443 VSS VSS VDD VDD _08021_ sky130_fd_sc_hd__nand3b_1
X_11740_ _07624_ _08021_ net449 VSS VSS VDD VDD _08022_ sky130_fd_sc_hd__a21oi_1
X_11741_ net445 net401 VSS VSS VDD VDD _08023_ sky130_fd_sc_hd__nand2_1
X_11742_ _07965_ _08023_ _08013_ VSS VSS VDD VDD _08024_ sky130_fd_sc_hd__a21oi_1
X_11743_ net437 _08020_ _08022_ _08024_ VSS VSS VDD VDD _08025_
+ sky130_fd_sc_hd__nor4_1
X_11744_ net440 _08015_ _08017_ _08025_ net427 VSS VSS VDD
+ VDD _08026_ sky130_fd_sc_hd__a2111oi_0
X_11745_ _07483_ _07657_ net434 VSS VSS VDD VDD _08027_ sky130_fd_sc_hd__a21oi_1
X_11746_ net446 _07512_ _08027_ VSS VSS VDD VDD _08028_ sky130_fd_sc_hd__nor3_1
X_11747_ net446 _07431_ _07958_ _08028_ VSS VSS VDD VDD _08029_
+ sky130_fd_sc_hd__a31oi_1
X_11748_ net434 _07335_ net376 _08029_ _07543_ VSS VSS VDD
+ VDD _08030_ sky130_fd_sc_hd__a311oi_1
X_11749_ net435 net445 VSS VSS VDD VDD _08031_ sky130_fd_sc_hd__nor2_1
X_11750_ net435 _07971_ VSS VSS VDD VDD _08032_ sky130_fd_sc_hd__nand2_1
X_11751_ net433 net442 net446 VSS VSS VDD VDD _08033_ sky130_fd_sc_hd__or3_1
X_11752_ net449 _08032_ _08033_ VSS VSS VDD VDD _08034_ sky130_fd_sc_hd__nand3_1
X_11753_ _08031_ net403 _08034_ net398 _07556_ VSS VSS VDD
+ VDD _08035_ sky130_fd_sc_hd__a221oi_1
X_11754_ _07494_ _08035_ VSS VSS VDD VDD _08036_ sky130_fd_sc_hd__nor2_1
X_11755_ net311 _08030_ _08036_ VSS VSS VDD VDD _08037_ sky130_fd_sc_hd__nor3_1
X_11756_ _07307_ _08008_ _08037_ _07344_ VSS VSS VDD VDD _01511_
+ sky130_fd_sc_hd__o22ai_1
X_11757_ _07335_ _07924_ VSS VSS VDD VDD _08038_ sky130_fd_sc_hd__nand2_1
X_11758_ net379 _08010_ VSS VSS VDD VDD _08039_ sky130_fd_sc_hd__nor2_1
X_11759_ net446 _07483_ _08038_ net438 _08039_ VSS VSS VDD
+ VDD _08040_ sky130_fd_sc_hd__a221oi_1
X_11760_ net400 net407 net379 VSS VSS VDD VDD _08041_ sky130_fd_sc_hd__nand3_1
X_11761_ net400 net378 _08040_ net449 _08041_ VSS VSS VDD
+ VDD _08042_ sky130_fd_sc_hd__o221ai_1
X_11762_ net430 _08042_ VSS VSS VDD VDD _08043_ sky130_fd_sc_hd__nand2_1
X_11763_ net437 net405 _07593_ VSS VSS VDD VDD _08044_ sky130_fd_sc_hd__o21ai_0
X_11764_ _07524_ _07624_ net437 VSS VSS VDD VDD _08045_ sky130_fd_sc_hd__a21oi_1
X_11765_ net449 _08044_ _08045_ VSS VSS VDD VDD _08046_ sky130_fd_sc_hd__a21oi_1
X_11766_ _07303_ net430 _08046_ VSS VSS VDD VDD _08047_ sky130_fd_sc_hd__or3_1
X_11767_ network.neuron_hid0.ROM0.address\[7\] _08043_ _08047_
+ VSS VSS VDD VDD _08048_ sky130_fd_sc_hd__o21ai_0
X_11768_ net399 _08048_ VSS VSS VDD VDD _08049_ sky130_fd_sc_hd__nand2_1
X_11769_ _07385_ _07443_ _07945_ net430 VSS VSS VDD VDD _08050_
+ sky130_fd_sc_hd__a22o_1
X_11770_ net430 net400 net379 VSS VSS VDD VDD _08051_ sky130_fd_sc_hd__o21a_1
X_11771_ net449 _08051_ VSS VSS VDD VDD _08052_ sky130_fd_sc_hd__nor2_1
X_11772_ net404 net407 _08050_ net434 _08052_ VSS VSS VDD
+ VDD _08053_ sky130_fd_sc_hd__a221oi_1
X_11773_ _07379_ net383 _07946_ VSS VSS VDD VDD _08054_ sky130_fd_sc_hd__o21ai_0
X_11774_ net379 _07608_ _08054_ VSS VSS VDD VDD _08055_ sky130_fd_sc_hd__o21ai_0
X_11775_ net450 _07379_ net430 VSS VSS VDD VDD _08056_ sky130_fd_sc_hd__o21ai_0
X_11776_ net390 _08056_ net434 VSS VSS VDD VDD _08057_ sky130_fd_sc_hd__a21oi_1
X_11777_ _08055_ _08057_ net402 VSS VSS VDD VDD _08058_ sky130_fd_sc_hd__o21ai_0
X_11778_ net390 _07612_ _08053_ net402 _08058_ VSS VSS VDD
+ VDD _08059_ sky130_fd_sc_hd__o221ai_1
X_11779_ net427 _08059_ VSS VSS VDD VDD _08060_ sky130_fd_sc_hd__nand2_1
X_11780_ net335 _07976_ VSS VSS VDD VDD _08061_ sky130_fd_sc_hd__nor2_1
X_11781_ net434 net410 _07937_ VSS VSS VDD VDD _08062_ sky130_fd_sc_hd__nor3_1
X_11782_ net434 _08061_ _08062_ net442 VSS VSS VDD VDD _08063_
+ sky130_fd_sc_hd__a211o_1
X_11783_ net433 net440 VSS VSS VDD VDD _08064_ sky130_fd_sc_hd__nand2b_1
X_11784_ net400 net407 net395 _08064_ VSS VSS VDD VDD _08065_
+ sky130_fd_sc_hd__o22ai_1
X_11785_ net442 _08065_ VSS VSS VDD VDD _08066_ sky130_fd_sc_hd__nand2_1
X_11786_ _08063_ _08066_ VSS VSS VDD VDD _08067_ sky130_fd_sc_hd__nand2_1
X_11787_ net385 _08067_ VSS VSS VDD VDD _08068_ sky130_fd_sc_hd__nand2_1
X_11788_ _08060_ _08068_ network.neuron_hid0.ROM0.address\[7\]
+ VSS VSS VDD VDD _08069_ sky130_fd_sc_hd__a21o_1
X_11789_ _08049_ _08069_ net327 VSS VSS VDD VDD _01512_ sky130_fd_sc_hd__a21oi_1
X_11790_ net438 net445 VSS VSS VDD VDD _08070_ sky130_fd_sc_hd__nor2b_2
Xclkbuf_leaf_29_clk_net clknet_4_9__leaf_clk_net VSS VSS VDD
+ VDD clknet_leaf_29_clk_net sky130_fd_sc_hd__clkbuf_16
X_11792_ net448 _07486_ VSS VSS VDD VDD _08072_ sky130_fd_sc_hd__nor2_1
X_11793_ net434 net397 _07523_ _07929_ VSS VSS VDD VDD _08073_
+ sky130_fd_sc_hd__o22ai_1
X_11794_ net372 _08072_ _08073_ net441 VSS VSS VDD VDD _08074_
+ sky130_fd_sc_hd__o2bb2ai_1
X_11795_ _07335_ _08021_ VSS VSS VDD VDD _08075_ sky130_fd_sc_hd__nand2_1
X_11796_ _07518_ _07626_ net436 VSS VSS VDD VDD _08076_ sky130_fd_sc_hd__a21oi_1
X_11797_ net436 _08075_ _08076_ VSS VSS VDD VDD _08077_ sky130_fd_sc_hd__a21oi_1
X_11798_ net444 net400 VSS VSS VDD VDD _08078_ sky130_fd_sc_hd__nor2_1
X_11799_ _07994_ _08078_ VSS VSS VDD VDD _08079_ sky130_fd_sc_hd__nor2_1
X_11800_ net450 _08077_ _08079_ net436 VSS VSS VDD VDD _08080_
+ sky130_fd_sc_hd__o22ai_1
X_11801_ net436 net400 net444 VSS VSS VDD VDD _08081_ sky130_fd_sc_hd__a21oi_1
X_11802_ net436 net410 net394 _08081_ VSS VSS VDD VDD _08082_
+ sky130_fd_sc_hd__o31ai_1
X_11803_ _07540_ net376 VSS VSS VDD VDD _08083_ sky130_fd_sc_hd__nand2_1
X_11804_ net436 _08083_ VSS VSS VDD VDD _08084_ sky130_fd_sc_hd__nand2_1
X_11805_ _08082_ _08084_ net431 VSS VSS VDD VDD _08085_ sky130_fd_sc_hd__a21oi_1
X_11806_ net440 _07984_ VSS VSS VDD VDD _08086_ sky130_fd_sc_hd__xnor2_1
X_11807_ net435 net450 VSS VSS VDD VDD _08087_ sky130_fd_sc_hd__and2_1
X_11808_ _07420_ _07945_ _08086_ _08087_ net399 VSS VSS VDD
+ VDD _08088_ sky130_fd_sc_hd__a221o_1
X_11809_ net431 _08080_ _08085_ _08088_ VSS VSS VDD VDD _08089_
+ sky130_fd_sc_hd__a211o_1
X_11810_ net390 _07518_ net436 VSS VSS VDD VDD _08090_ sky130_fd_sc_hd__a21oi_1
X_11811_ _07393_ _08090_ net447 VSS VSS VDD VDD _08091_ sky130_fd_sc_hd__o21ai_0
X_11812_ net436 net394 _07526_ VSS VSS VDD VDD _08092_ sky130_fd_sc_hd__a21o_1
X_11813_ net444 _08092_ VSS VSS VDD VDD _08093_ sky130_fd_sc_hd__nand2_1
X_11814_ net399 net429 VSS VSS VDD VDD _08094_ sky130_fd_sc_hd__nand2_1
X_11815_ net379 _07657_ VSS VSS VDD VDD _08095_ sky130_fd_sc_hd__nor2_1
X_11816_ _08094_ _08095_ VSS VSS VDD VDD _08096_ sky130_fd_sc_hd__nor2_1
X_11817_ net444 _07593_ VSS VSS VDD VDD _08097_ sky130_fd_sc_hd__nor2_1
X_11818_ net410 _08097_ net436 VSS VSS VDD VDD _08098_ sky130_fd_sc_hd__o21ai_0
X_11819_ _08091_ _08093_ _08096_ _08098_ VSS VSS VDD VDD _08099_
+ sky130_fd_sc_hd__nand4_1
X_11820_ net442 net397 _07409_ VSS VSS VDD VDD _08100_ sky130_fd_sc_hd__o21ai_0
X_11821_ net439 _08100_ VSS VSS VDD VDD _08101_ sky130_fd_sc_hd__nor2_1
X_11822_ net433 _07477_ _07626_ VSS VSS VDD VDD _08102_ sky130_fd_sc_hd__nand3_1
X_11823_ net433 _07396_ _08101_ _08102_ VSS VSS VDD VDD _08103_
+ sky130_fd_sc_hd__o31a_1
X_11824_ net433 net440 VSS VSS VDD VDD _08104_ sky130_fd_sc_hd__nand2_1
X_11825_ _08104_ _08033_ net449 VSS VSS VDD VDD _08105_ sky130_fd_sc_hd__a21oi_1
X_11826_ _08103_ _08105_ net385 VSS VSS VDD VDD _08106_ sky130_fd_sc_hd__o21ai_0
X_11827_ _08089_ _08099_ _08106_ network.neuron_hid0.ROM0.address\[7\]
+ VSS VSS VDD VDD _08107_ sky130_fd_sc_hd__a31oi_1
X_11828_ network.neuron_hid0.ROM0.address\[7\] net385 _08074_
+ _08107_ VSS VSS VDD VDD _08108_ sky130_fd_sc_hd__a31oi_1
X_11829_ net327 _08108_ VSS VSS VDD VDD _01513_ sky130_fd_sc_hd__nor2_1
X_11830_ net445 _07945_ _07666_ VSS VSS VDD VDD _08109_ sky130_fd_sc_hd__a21oi_1
X_11831_ net390 _07981_ VSS VSS VDD VDD _08110_ sky130_fd_sc_hd__nand2_1
X_11832_ _07593_ _07634_ net445 VSS VSS VDD VDD _08111_ sky130_fd_sc_hd__a21oi_1
X_11833_ net435 _08110_ _08111_ VSS VSS VDD VDD _08112_ sky130_fd_sc_hd__a21oi_1
X_11834_ net435 _08109_ _08112_ _07387_ VSS VSS VDD VDD _08113_
+ sky130_fd_sc_hd__o211ai_1
X_11835_ net444 net400 net376 VSS VSS VDD VDD _08114_ sky130_fd_sc_hd__o21ai_0
X_11836_ _07536_ _07646_ net435 VSS VSS VDD VDD _08115_ sky130_fd_sc_hd__a21oi_1
X_11837_ net406 _08114_ _08115_ VSS VSS VDD VDD _08116_ sky130_fd_sc_hd__a21oi_1
X_11838_ net431 _08116_ VSS VSS VDD VDD _08117_ sky130_fd_sc_hd__nor2_1
X_11839_ net404 _07523_ _08113_ net431 _08117_ VSS VSS VDD
+ VDD _08118_ sky130_fd_sc_hd__a221oi_1
X_11840_ _07409_ _08064_ net402 VSS VSS VDD VDD _08119_ sky130_fd_sc_hd__a21oi_1
X_11841_ _07440_ _07636_ net433 VSS VSS VDD VDD _08120_ sky130_fd_sc_hd__a21oi_1
X_11842_ _08119_ _08120_ VSS VSS VDD VDD _08121_ sky130_fd_sc_hd__nor2_1
X_11843_ net435 _07409_ net372 _07540_ net392 VSS VSS VDD
+ VDD _08122_ sky130_fd_sc_hd__a221oi_1
X_11844_ net375 _07523_ net435 VSS VSS VDD VDD _08123_ sky130_fd_sc_hd__o21ai_0
X_11845_ net444 _07540_ _08122_ net439 _08123_ VSS VSS VDD
+ VDD _08124_ sky130_fd_sc_hd__o221ai_1
X_11846_ net431 _08124_ VSS VSS VDD VDD _08125_ sky130_fd_sc_hd__nand2_1
X_11847_ net444 _08013_ net437 VSS VSS VDD VDD _08126_ sky130_fd_sc_hd__a21boi_0
X_11848_ _07484_ _08126_ net447 VSS VSS VDD VDD _08127_ sky130_fd_sc_hd__o21ai_0
X_11849_ net431 _08121_ _08125_ _08127_ net428 VSS VSS VDD
+ VDD _08128_ sky130_fd_sc_hd__o2111ai_1
X_11850_ net428 _08118_ _08128_ VSS VSS VDD VDD _08129_ sky130_fd_sc_hd__o21ai_0
X_11851_ net439 _07657_ net447 VSS VSS VDD VDD _08130_ sky130_fd_sc_hd__a21oi_1
X_11852_ net450 _07385_ _08130_ VSS VSS VDD VDD _08131_ sky130_fd_sc_hd__a21oi_1
X_11853_ _07937_ net383 net445 VSS VSS VDD VDD _08132_ sky130_fd_sc_hd__o21ai_0
X_11854_ net435 _08131_ _08132_ VSS VSS VDD VDD _08133_ sky130_fd_sc_hd__o21ai_0
X_11855_ _07562_ _08133_ VSS VSS VDD VDD _08134_ sky130_fd_sc_hd__nand2_1
X_11856_ _07344_ _08129_ _08134_ VSS VSS VDD VDD _01514_ sky130_fd_sc_hd__o21ai_0
X_11857_ net386 net382 VSS VSS VDD VDD _08135_ sky130_fd_sc_hd__nor2_1
X_11858_ net430 _08135_ _07958_ VSS VSS VDD VDD _08136_ sky130_fd_sc_hd__o21ai_0
X_11859_ _07486_ _07621_ _07440_ VSS VSS VDD VDD _08137_ sky130_fd_sc_hd__o21ai_0
X_11860_ _07379_ _07443_ _07441_ VSS VSS VDD VDD _08138_ sky130_fd_sc_hd__a21oi_1
X_11861_ net434 _08138_ VSS VSS VDD VDD _08139_ sky130_fd_sc_hd__nor2_1
X_11862_ net448 _08136_ _08137_ net442 _08139_ VSS VSS VDD
+ VDD _08140_ sky130_fd_sc_hd__a221oi_1
X_11863_ _07335_ _08021_ net436 VSS VSS VDD VDD _08141_ sky130_fd_sc_hd__a21oi_1
X_11864_ net449 net379 VSS VSS VDD VDD _08142_ sky130_fd_sc_hd__nand2_1
X_11865_ _07521_ net382 VSS VSS VDD VDD _08143_ sky130_fd_sc_hd__nor2_1
X_11866_ _07513_ _08142_ _08143_ net447 VSS VSS VDD VDD _08144_
+ sky130_fd_sc_hd__o22ai_1
X_11867_ _08141_ _08144_ net429 VSS VSS VDD VDD _08145_ sky130_fd_sc_hd__o21ai_0
X_11868_ _07429_ net381 _08140_ _08145_ VSS VSS VDD VDD _08146_
+ sky130_fd_sc_hd__o211ai_1
X_11869_ net444 net404 VSS VSS VDD VDD _08147_ sky130_fd_sc_hd__nor2_1
X_11870_ net402 net397 _07644_ VSS VSS VDD VDD _08148_ sky130_fd_sc_hd__a21oi_1
X_11871_ _07501_ _08147_ _08148_ net440 VSS VSS VDD VDD _08149_
+ sky130_fd_sc_hd__o22ai_1
X_11872_ net431 net450 net447 net390 VSS VSS VDD VDD _08150_
+ sky130_fd_sc_hd__o31ai_1
X_11873_ _07513_ _08010_ VSS VSS VDD VDD _08151_ sky130_fd_sc_hd__nand2_1
X_11874_ net435 net439 _07431_ _08151_ net394 VSS VSS VDD
+ VDD _08152_ sky130_fd_sc_hd__a32oi_1
X_11875_ net431 _07958_ _08152_ VSS VSS VDD VDD _08153_ sky130_fd_sc_hd__nand3_1
X_11876_ net431 net397 net334 _08153_ VSS VSS VDD VDD _08154_
+ sky130_fd_sc_hd__o31ai_1
X_11877_ _07941_ _08005_ net435 VSS VSS VDD VDD _08155_ sky130_fd_sc_hd__a21oi_1
X_11878_ _07536_ _07698_ net444 VSS VSS VDD VDD _08156_ sky130_fd_sc_hd__a21oi_1
X_11879_ net450 net405 VSS VSS VDD VDD _08157_ sky130_fd_sc_hd__nor2_1
X_11880_ _08155_ _08156_ _08157_ VSS VSS VDD VDD _08158_ sky130_fd_sc_hd__nor3_1
X_11881_ _07303_ net428 VSS VSS VDD VDD _08159_ sky130_fd_sc_hd__nand2_1
X_11882_ _08031_ _08150_ _08154_ _08158_ _08159_ VSS VSS VDD
+ VDD _08160_ sky130_fd_sc_hd__a221oi_1
X_11883_ _07670_ _08146_ _08149_ _07306_ _08160_ VSS VSS VDD
+ VDD _08161_ sky130_fd_sc_hd__a221oi_1
X_11884_ net327 _08161_ VSS VSS VDD VDD _01515_ sky130_fd_sc_hd__nor2_1
X_11885_ net435 _07533_ _07489_ VSS VSS VDD VDD _08162_ sky130_fd_sc_hd__o21ai_0
Xclkbuf_leaf_28_clk_net clknet_4_9__leaf_clk_net VSS VSS VDD
+ VDD clknet_leaf_28_clk_net sky130_fd_sc_hd__clkbuf_16
X_11887_ net402 net395 VSS VSS VDD VDD _08164_ sky130_fd_sc_hd__nand2_1
X_11888_ net376 _08164_ VSS VSS VDD VDD _08165_ sky130_fd_sc_hd__nand2_1
X_11889_ net445 _08162_ _08165_ net435 VSS VSS VDD VDD _08166_
+ sky130_fd_sc_hd__a22oi_1
X_11890_ net405 _07614_ VSS VSS VDD VDD _08167_ sky130_fd_sc_hd__nor2_1
X_11891_ net400 net382 _08167_ VSS VSS VDD VDD _08168_ sky130_fd_sc_hd__a21oi_1
X_11892_ net439 _08166_ _08168_ net435 VSS VSS VDD VDD _08169_
+ sky130_fd_sc_hd__o22ai_1
X_11893_ _07562_ _08169_ VSS VSS VDD VDD _08170_ sky130_fd_sc_hd__nand2_1
X_11894_ net435 net398 VSS VSS VDD VDD _08171_ sky130_fd_sc_hd__nand2_1
X_11895_ net435 net405 VSS VSS VDD VDD _08172_ sky130_fd_sc_hd__nand2_1
X_11896_ net435 _07936_ _08172_ VSS VSS VDD VDD _08173_ sky130_fd_sc_hd__o21ai_0
X_11897_ net392 _08171_ _08173_ net445 VSS VSS VDD VDD _08174_
+ sky130_fd_sc_hd__o22ai_1
X_11898_ _07385_ net389 VSS VSS VDD VDD _08175_ sky130_fd_sc_hd__nor2_1
X_11899_ net434 _08175_ _07500_ VSS VSS VDD VDD _08176_ sky130_fd_sc_hd__o21ai_0
X_11900_ net450 _08174_ _08176_ net445 VSS VSS VDD VDD _08177_
+ sky130_fd_sc_hd__a22o_1
X_11901_ net383 _08038_ _07646_ VSS VSS VDD VDD _08178_ sky130_fd_sc_hd__a21boi_0
X_11902_ net432 net388 net392 VSS VSS VDD VDD _08179_ sky130_fd_sc_hd__a21oi_1
X_11903_ net435 _07944_ _08179_ _07385_ net384 VSS VSS VDD
+ VDD _08180_ sky130_fd_sc_hd__a32oi_1
X_11904_ net432 _08178_ _08180_ VSS VSS VDD VDD _08181_ sky130_fd_sc_hd__o21ai_0
X_11905_ net432 _08177_ _08181_ VSS VSS VDD VDD _08182_ sky130_fd_sc_hd__a21oi_1
X_11906_ net432 _07657_ net405 VSS VSS VDD VDD _08183_ sky130_fd_sc_hd__a21oi_1
X_11907_ net430 net443 VSS VSS VDD VDD _08184_ sky130_fd_sc_hd__nor2_1
X_11908_ net404 _08184_ VSS VSS VDD VDD _08185_ sky130_fd_sc_hd__nand2_1
X_11909_ net335 _07698_ _08018_ net388 VSS VSS VDD VDD _08186_
+ sky130_fd_sc_hd__o22ai_1
X_11910_ net400 _07941_ _07634_ VSS VSS VDD VDD _08187_ sky130_fd_sc_hd__a21oi_1
X_11911_ _08186_ _08187_ net444 VSS VSS VDD VDD _08188_ sky130_fd_sc_hd__o21ai_0
X_11912_ _08183_ _08185_ _08188_ net427 VSS VSS VDD VDD _08189_
+ sky130_fd_sc_hd__nand4b_1
X_11913_ net401 _07437_ net431 VSS VSS VDD VDD _08190_ sky130_fd_sc_hd__o21ai_0
X_11914_ _07960_ _08190_ net435 VSS VSS VDD VDD _08191_ sky130_fd_sc_hd__a21oi_1
X_11915_ net427 _08182_ _08189_ _08191_ _07474_ VSS VSS VDD
+ VDD _08192_ sky130_fd_sc_hd__o221ai_1
X_11916_ _08170_ _08192_ VSS VSS VDD VDD _01516_ sky130_fd_sc_hd__nand2_1
X_11917_ network.neuron_in145.counter\[1\] VSS VSS VDD VDD
+ _00697_ sky130_fd_sc_hd__inv_1
X_11918_ network.neuron_in245.counter\[3\] _00906_ VSS VSS
+ VDD VDD _08193_ sky130_fd_sc_hd__nand2b_1
X_11919_ _08193_ _07775_ VSS VSS VDD VDD _08194_ sky130_fd_sc_hd__nand2b_1
X_11920_ net348 _08194_ VSS VSS VDD VDD _08195_ sky130_fd_sc_hd__nand2_1
X_11921_ network.in_period\[245\]\[1\] _08195_ VSS VSS VDD
+ VDD _08196_ sky130_fd_sc_hd__nand2_1
X_11922_ _00907_ _08195_ _08196_ VSS VSS VDD VDD _03044_ sky130_fd_sc_hd__o21ai_0
X_11923_ network.neuron_in245.counter\[0\] VSS VSS VDD VDD
+ _00904_ sky130_fd_sc_hd__inv_1
X_11924_ network.in_period\[245\]\[0\] _08195_ VSS VSS VDD
+ VDD _08197_ sky130_fd_sc_hd__nand2_1
X_11925_ network.neuron_in245.counter\[0\] _08195_ _08197_
+ VSS VSS VDD VDD _03043_ sky130_fd_sc_hd__o21ai_0
X_11926_ network.neuron_in169.counter\[1\] VSS VSS VDD VDD
+ _00983_ sky130_fd_sc_hd__inv_1
X_11927_ network.neuron_in227.counter\[1\] VSS VSS VDD VDD
+ _00624_ sky130_fd_sc_hd__inv_1
X_11928_ network.neuron_in135.counter\[2\] _00068_ VSS VSS
+ VDD VDD _08198_ sky130_fd_sc_hd__nand2b_1
X_11929_ network.neuron_in135.counter\[3\] _08198_ VSS VSS
+ VDD VDD _08199_ sky130_fd_sc_hd__or2_2
X_11930_ net352 _08199_ VSS VSS VDD VDD _08200_ sky130_fd_sc_hd__nand2_1
X_11931_ network.in_period\[135\]\[1\] _08200_ VSS VSS VDD
+ VDD _08201_ sky130_fd_sc_hd__nand2_1
X_11932_ _00069_ _08200_ _08201_ VSS VSS VDD VDD _02604_ sky130_fd_sc_hd__o21ai_0
X_11933_ network.in_period\[135\]\[0\] _08200_ VSS VSS VDD
+ VDD _08202_ sky130_fd_sc_hd__nand2_1
X_11934_ network.neuron_in135.counter\[0\] _08200_ _08202_
+ VSS VSS VDD VDD _02603_ sky130_fd_sc_hd__o21ai_0
X_11935_ network.neuron_in250.counter\[2\] net348 VSS VSS
+ VDD VDD _08203_ sky130_fd_sc_hd__nand2_1
X_11936_ network.neuron_in250.counter\[3\] network.in_period\[250\]\[2\]
+ _08203_ VSS VSS VDD VDD _08204_ sky130_fd_sc_hd__o21ai_0
X_11937_ _01086_ network.neuron_in250.counter\[2\] net416
+ VSS VSS VDD VDD _08205_ sky130_fd_sc_hd__or3_1
X_11938_ network.in_period\[250\]\[2\] net348 _08205_ VSS
+ VSS VDD VDD _08206_ sky130_fd_sc_hd__o21ai_0
X_11939_ _01086_ _08204_ _08206_ VSS VSS VDD VDD _03065_ sky130_fd_sc_hd__a21oi_1
X_11940_ network.neuron_in246.counter\[2\] network.neuron_in246.counter\[3\]
+ VSS VSS VDD VDD _08207_ sky130_fd_sc_hd__nor2_1
X_11941_ _00453_ _08207_ VSS VSS VDD VDD _08208_ sky130_fd_sc_hd__nand2_1
X_11942_ net364 _08208_ VSS VSS VDD VDD _08209_ sky130_fd_sc_hd__nand2_1
X_11943_ network.in_period\[246\]\[0\] _08209_ VSS VSS VDD
+ VDD _08210_ sky130_fd_sc_hd__nand2_1
X_11944_ network.neuron_in246.counter\[0\] _08209_ _08210_
+ VSS VSS VDD VDD _03047_ sky130_fd_sc_hd__o21ai_0
X_11945_ network.neuron_in247.counter\[3\] _00613_ VSS VSS
+ VDD VDD _08211_ sky130_fd_sc_hd__nand2b_1
X_11946_ network.neuron_in247.counter\[2\] VSS VSS VDD VDD
+ _08212_ sky130_fd_sc_hd__inv_1
X_11947_ _08211_ _08212_ VSS VSS VDD VDD _08213_ sky130_fd_sc_hd__nand2b_1
X_11948_ net365 _08213_ VSS VSS VDD VDD _08214_ sky130_fd_sc_hd__nand2_1
X_11949_ network.in_period\[247\]\[0\] _08214_ VSS VSS VDD
+ VDD _08215_ sky130_fd_sc_hd__nand2_1
X_11950_ network.neuron_in247.counter\[0\] _08214_ _08215_
+ VSS VSS VDD VDD _03051_ sky130_fd_sc_hd__o21ai_0
X_11951_ network.neuron_in057.counter\[0\] VSS VSS VDD VDD
+ _00255_ sky130_fd_sc_hd__inv_1
X_11952_ network.neuron_in248.counter\[0\] VSS VSS VDD VDD
+ _00461_ sky130_fd_sc_hd__inv_1
X_11953_ network.neuron_in248.counter\[3\] _00463_ VSS VSS
+ VDD VDD _08216_ sky130_fd_sc_hd__nand2b_1
X_11954_ network.neuron_in248.counter\[2\] VSS VSS VDD VDD
+ _08217_ sky130_fd_sc_hd__inv_1
X_11955_ _08216_ _08217_ VSS VSS VDD VDD _08218_ sky130_fd_sc_hd__nand2b_1
X_11956_ net364 _08218_ VSS VSS VDD VDD _08219_ sky130_fd_sc_hd__nand2_1
X_11957_ network.in_period\[248\]\[0\] _08219_ VSS VSS VDD
+ VDD _08220_ sky130_fd_sc_hd__nand2_1
X_11958_ network.neuron_in248.counter\[0\] _08219_ _08220_
+ VSS VSS VDD VDD _03055_ sky130_fd_sc_hd__o21ai_0
X_11959_ network.neuron_in249.counter\[0\] VSS VSS VDD VDD
+ _01144_ sky130_fd_sc_hd__inv_1
X_11960_ network.neuron_in249.counter\[3\] _01146_ VSS VSS
+ VDD VDD _08221_ sky130_fd_sc_hd__nand2b_1
X_11961_ network.neuron_in249.counter\[2\] VSS VSS VDD VDD
+ _08222_ sky130_fd_sc_hd__inv_1
X_11962_ _08221_ _08222_ VSS VSS VDD VDD _08223_ sky130_fd_sc_hd__nand2b_1
X_11963_ net364 _08223_ VSS VSS VDD VDD _08224_ sky130_fd_sc_hd__nand2_1
X_11964_ network.in_period\[249\]\[0\] _08224_ VSS VSS VDD
+ VDD _08225_ sky130_fd_sc_hd__nand2_1
X_11965_ network.neuron_in249.counter\[0\] _08224_ _08225_
+ VSS VSS VDD VDD _03059_ sky130_fd_sc_hd__o21ai_0
X_11966_ network.neuron_in251.counter\[2\] VSS VSS VDD VDD
+ _08226_ sky130_fd_sc_hd__inv_1
X_11967_ network.neuron_in251.counter\[3\] network.in_period\[251\]\[2\]
+ _00475_ net416 VSS VSS VDD VDD _08227_ sky130_fd_sc_hd__o22ai_1
X_11968_ network.neuron_in251.counter\[2\] _00475_ net365
+ VSS VSS VDD VDD _08228_ sky130_fd_sc_hd__nand3_1
X_11969_ network.in_period\[251\]\[2\] net365 _08228_ VSS
+ VSS VDD VDD _08229_ sky130_fd_sc_hd__o21ai_0
X_11970_ _08226_ _08227_ _08229_ VSS VSS VDD VDD _03069_ sky130_fd_sc_hd__a21oi_1
X_11971_ network.neuron_in033.counter\[0\] VSS VSS VDD VDD
+ _00627_ sky130_fd_sc_hd__inv_1
X_11972_ network.neuron_in004.counter\[1\] VSS VSS VDD VDD
+ _00665_ sky130_fd_sc_hd__inv_1
X_11973_ network.neuron_in235.counter\[1\] VSS VSS VDD VDD
+ _00420_ sky130_fd_sc_hd__inv_1
X_11974_ network.neuron_in062.counter\[0\] VSS VSS VDD VDD
+ _00631_ sky130_fd_sc_hd__inv_1
X_11975_ network.neuron_in085.counter\[1\] VSS VSS VDD VDD
+ _00043_ sky130_fd_sc_hd__inv_1
X_11976_ network.neuron_in187.counter\[1\] VSS VSS VDD VDD
+ _00979_ sky130_fd_sc_hd__inv_1
X_11977_ network.neuron_in151.counter\[2\] VSS VSS VDD VDD
+ _08230_ sky130_fd_sc_hd__inv_1
X_11978_ network.in_period\[151\]\[2\] network.neuron_in151.counter\[3\]
+ net417 _00573_ VSS VSS VDD VDD _08231_ sky130_fd_sc_hd__o22ai_1
X_11979_ network.neuron_in151.counter\[2\] _00573_ net358
+ VSS VSS VDD VDD _08232_ sky130_fd_sc_hd__nand3_1
X_11980_ network.in_period\[151\]\[2\] net358 _08232_ VSS
+ VSS VDD VDD _08233_ sky130_fd_sc_hd__o21ai_0
X_11981_ _08230_ _08231_ _08233_ VSS VSS VDD VDD _02669_ sky130_fd_sc_hd__a21oi_1
X_11982_ network.neuron_in144.counter\[1\] VSS VSS VDD VDD
+ _00707_ sky130_fd_sc_hd__inv_1
X_11983_ net415 _08207_ VSS VSS VDD VDD _08234_ sky130_fd_sc_hd__nor2_1
X_11984_ network.neuron_in246.counter\[2\] _00453_ VSS VSS
+ VDD VDD _08235_ sky130_fd_sc_hd__xnor2_1
X_11985_ network.in_period\[246\]\[2\] _08234_ _08235_ net364
+ VSS VSS VDD VDD _03049_ sky130_fd_sc_hd__a2bb2oi_1
X_11986_ network.neuron_in136.counter\[2\] net359 VSS VSS
+ VDD VDD _08236_ sky130_fd_sc_hd__nand2_1
X_11987_ network.in_period\[136\]\[2\] network.neuron_in136.counter\[3\]
+ _08236_ VSS VSS VDD VDD _08237_ sky130_fd_sc_hd__o21ai_0
X_11988_ _00762_ network.neuron_in136.counter\[2\] net413
+ VSS VSS VDD VDD _08238_ sky130_fd_sc_hd__or3_1
X_11989_ network.in_period\[136\]\[2\] net359 _08238_ VSS
+ VSS VDD VDD _08239_ sky130_fd_sc_hd__o21ai_0
X_11990_ _00762_ _08237_ _08239_ VSS VSS VDD VDD _02609_ sky130_fd_sc_hd__a21oi_1
X_11991_ net433 net442 net449 VSS VSS VDD VDD _08240_ sky130_fd_sc_hd__nor3b_1
X_11992_ _07339_ _07409_ net431 VSS VSS VDD VDD _08241_ sky130_fd_sc_hd__a21oi_1
X_11993_ net371 _08241_ net398 VSS VSS VDD VDD _08242_ sky130_fd_sc_hd__o21ai_0
X_11994_ net405 net387 _08016_ _07489_ VSS VSS VDD VDD _08243_
+ sky130_fd_sc_hd__o22ai_1
X_11995_ net400 _07635_ net430 VSS VSS VDD VDD _08244_ sky130_fd_sc_hd__a21oi_1
X_11996_ net440 net376 net451 VSS VSS VDD VDD _08245_ sky130_fd_sc_hd__a21oi_1
X_11997_ net451 _07352_ _07624_ _08244_ _08245_ VSS VSS VDD
+ VDD _08246_ sky130_fd_sc_hd__a311oi_1
X_11998_ net433 _08246_ VSS VSS VDD VDD _08247_ sky130_fd_sc_hd__nand2_1
X_11999_ net433 _08243_ _08247_ VSS VSS VDD VDD _08248_ sky130_fd_sc_hd__o21ai_0
X_12000_ net392 _07644_ VSS VSS VDD VDD _08249_ sky130_fd_sc_hd__nor2_1
X_12001_ net438 _08249_ VSS VSS VDD VDD _08250_ sky130_fd_sc_hd__nor2_1
X_12002_ _07523_ _08250_ VSS VSS VDD VDD _08251_ sky130_fd_sc_hd__nor2_1
X_12003_ net392 _07608_ _08251_ net432 VSS VSS VDD VDD _08252_
+ sky130_fd_sc_hd__o22ai_1
X_12004_ net435 net432 VSS VSS VDD VDD _08253_ sky130_fd_sc_hd__nor2b_1
X_12005_ net408 _08253_ _07644_ net374 VSS VSS VDD VDD _08254_
+ sky130_fd_sc_hd__a22oi_1
X_12006_ net437 _07981_ VSS VSS VDD VDD _08255_ sky130_fd_sc_hd__nor2_1
X_12007_ net430 _07500_ VSS VSS VDD VDD _08256_ sky130_fd_sc_hd__nand2_1
X_12008_ _07339_ _07924_ net446 VSS VSS VDD VDD _08257_ sky130_fd_sc_hd__a21boi_0
X_12009_ _08255_ _08256_ _08257_ net430 net449 VSS VSS VDD
+ VDD _08258_ sky130_fd_sc_hd__o221ai_1
X_12010_ net449 _08254_ _08258_ VSS VSS VDD VDD _08259_ sky130_fd_sc_hd__o21ai_0
X_12011_ net440 _08252_ _08259_ net427 VSS VSS VDD VDD _08260_
+ sky130_fd_sc_hd__a211oi_1
X_12012_ net428 _08242_ _08248_ _08260_ VSS VSS VDD VDD _08261_
+ sky130_fd_sc_hd__a31oi_1
X_12013_ net447 _07391_ net450 VSS VSS VDD VDD _08262_ sky130_fd_sc_hd__o21ai_0
X_12014_ net439 _07978_ net444 VSS VSS VDD VDD _08263_ sky130_fd_sc_hd__a21oi_1
X_12015_ net444 net400 _08262_ _08263_ VSS VSS VDD VDD _08264_
+ sky130_fd_sc_hd__a31oi_1
X_12016_ _07562_ _07653_ VSS VSS VDD VDD _08265_ sky130_fd_sc_hd__nand2_1
X_12017_ _07344_ _08261_ _08264_ _08265_ VSS VSS VDD VDD _01517_
+ sky130_fd_sc_hd__o22ai_1
X_12018_ net444 _07489_ net395 VSS VSS VDD VDD _08266_ sky130_fd_sc_hd__a21oi_1
X_12019_ net435 _08266_ VSS VSS VDD VDD _08267_ sky130_fd_sc_hd__nor2_1
X_12020_ _08087_ _07971_ _08267_ VSS VSS VDD VDD _08268_ sky130_fd_sc_hd__a21oi_1
X_12021_ net444 net395 _07523_ _07396_ VSS VSS VDD VDD _08269_
+ sky130_fd_sc_hd__a22oi_1
X_12022_ net439 _08268_ _08269_ net435 VSS VSS VDD VDD _08270_
+ sky130_fd_sc_hd__o22ai_1
X_12023_ net440 _08184_ VSS VSS VDD VDD _08271_ sky130_fd_sc_hd__nor2_1
X_12024_ net429 net393 VSS VSS VDD VDD _08272_ sky130_fd_sc_hd__nand2_1
X_12025_ net436 _08271_ _08272_ VSS VSS VDD VDD _08273_ sky130_fd_sc_hd__o21ai_0
X_12026_ net443 net441 VSS VSS VDD VDD _08274_ sky130_fd_sc_hd__nor2b_1
X_12027_ net442 net404 net370 VSS VSS VDD VDD _08275_ sky130_fd_sc_hd__a21oi_1
X_12028_ net370 _07420_ net437 VSS VSS VDD VDD _08276_ sky130_fd_sc_hd__o21ai_0
X_12029_ net429 _08275_ _08276_ VSS VSS VDD VDD _08277_ sky130_fd_sc_hd__o21ai_0
X_12030_ net446 _08273_ _08277_ VSS VSS VDD VDD _08278_ sky130_fd_sc_hd__a21oi_1
X_12031_ net436 _07644_ VSS VSS VDD VDD _08279_ sky130_fd_sc_hd__nand2_1
X_12032_ net436 _07335_ _08279_ VSS VSS VDD VDD _08280_ sky130_fd_sc_hd__o21ai_0
X_12033_ net434 _07438_ VSS VSS VDD VDD _08281_ sky130_fd_sc_hd__nand2_1
X_12034_ net434 net446 _08271_ _08281_ VSS VSS VDD VDD _08282_
+ sky130_fd_sc_hd__o31ai_1
X_12035_ net429 _08280_ _08282_ net449 VSS VSS VDD VDD _08283_
+ sky130_fd_sc_hd__a211oi_1
X_12036_ net449 _08278_ _08283_ VSS VSS VDD VDD _08284_ sky130_fd_sc_hd__a21oi_1
X_12037_ net431 net436 net377 _08284_ VSS VSS VDD VDD _08285_
+ sky130_fd_sc_hd__a31oi_1
X_12038_ net408 _07438_ net436 VSS VSS VDD VDD _08286_ sky130_fd_sc_hd__o21ai_0
X_12039_ _07339_ net379 _08286_ VSS VSS VDD VDD _08287_ sky130_fd_sc_hd__o21ai_0
X_12040_ net436 _07984_ _07624_ VSS VSS VDD VDD _08288_ sky130_fd_sc_hd__o21ai_0
X_12041_ net403 net372 _08288_ net398 net406 VSS VSS VDD VDD
+ _08289_ sky130_fd_sc_hd__a221o_1
X_12042_ net450 _08287_ _08289_ VSS VSS VDD VDD _08290_ sky130_fd_sc_hd__o21ai_0
X_12043_ net450 _07396_ net400 VSS VSS VDD VDD _08291_ sky130_fd_sc_hd__o21ai_0
X_12044_ net402 _08291_ _07437_ VSS VSS VDD VDD _08292_ sky130_fd_sc_hd__a21oi_1
X_12045_ net399 net431 VSS VSS VDD VDD _08293_ sky130_fd_sc_hd__nor2_1
X_12046_ net405 _07691_ _08293_ VSS VSS VDD VDD _08294_ sky130_fd_sc_hd__o21ai_0
X_12047_ net450 net336 _08038_ _08294_ VSS VSS VDD VDD _08295_
+ sky130_fd_sc_hd__a31oi_1
X_12048_ net436 _08292_ _08295_ VSS VSS VDD VDD _08296_ sky130_fd_sc_hd__o21ai_0
X_12049_ net428 _08285_ _08290_ _07494_ _08296_ VSS VSS VDD
+ VDD _08297_ sky130_fd_sc_hd__o221ai_1
X_12050_ _07562_ _08270_ _08297_ _07474_ VSS VSS VDD VDD _01518_
+ sky130_fd_sc_hd__a22o_1
X_12051_ _07946_ VSS VSS VDD VDD _08298_ sky130_fd_sc_hd__inv_1
X_12052_ net447 _07431_ _08298_ net405 VSS VSS VDD VDD _08299_
+ sky130_fd_sc_hd__o22ai_1
X_12053_ net435 _08249_ VSS VSS VDD VDD _08300_ sky130_fd_sc_hd__nand2_1
X_12054_ net435 net447 net450 VSS VSS VDD VDD _08301_ sky130_fd_sc_hd__o21ai_0
X_12055_ net447 _07614_ net435 VSS VSS VDD VDD _08302_ sky130_fd_sc_hd__a21oi_1
X_12056_ net435 net392 VSS VSS VDD VDD _08303_ sky130_fd_sc_hd__nand2_1
X_12057_ _08303_ net376 net450 VSS VSS VDD VDD _08304_ sky130_fd_sc_hd__a21oi_1
X_12058_ net439 _08302_ _08304_ VSS VSS VDD VDD _08305_ sky130_fd_sc_hd__nor3_1
X_12059_ net439 _08300_ _08301_ _08305_ VSS VSS VDD VDD _08306_
+ sky130_fd_sc_hd__a31oi_1
X_12060_ net444 net373 _08023_ VSS VSS VDD VDD _08307_ sky130_fd_sc_hd__o21ai_0
X_12061_ net435 _08307_ VSS VSS VDD VDD _08308_ sky130_fd_sc_hd__nand2b_1
X_12062_ _07536_ _08308_ net431 VSS VSS VDD VDD _08309_ sky130_fd_sc_hd__a21oi_1
X_12063_ net435 _08299_ _08306_ net431 _08309_ VSS VSS VDD
+ VDD _08310_ sky130_fd_sc_hd__a221o_1
X_12064_ net439 _07489_ net444 VSS VSS VDD VDD _08311_ sky130_fd_sc_hd__a21oi_1
X_12065_ net444 net400 _07429_ _08311_ net436 VSS VSS VDD
+ VDD _08312_ sky130_fd_sc_hd__a311oi_1
X_12066_ net408 net382 _08312_ VSS VSS VDD VDD _08313_ sky130_fd_sc_hd__a21oi_1
X_12067_ net431 net446 VSS VSS VDD VDD _08314_ sky130_fd_sc_hd__nor2b_1
X_12068_ net393 _08314_ net377 VSS VSS VDD VDD _08315_ sky130_fd_sc_hd__a21oi_1
X_12069_ _07483_ net381 _08033_ VSS VSS VDD VDD _08316_ sky130_fd_sc_hd__o21ai_0
X_12070_ net437 net404 net372 VSS VSS VDD VDD _08317_ sky130_fd_sc_hd__a21oi_1
X_12071_ net437 net370 VSS VSS VDD VDD _08318_ sky130_fd_sc_hd__nand2_1
X_12072_ net431 _08317_ _08318_ net449 VSS VSS VDD VDD _08319_
+ sky130_fd_sc_hd__o211ai_1
X_12073_ net449 _08316_ _08319_ VSS VSS VDD VDD _08320_ sky130_fd_sc_hd__o21ai_0
X_12074_ net406 net400 net437 VSS VSS VDD VDD _08321_ sky130_fd_sc_hd__a21oi_1
X_12075_ _07396_ _08321_ VSS VSS VDD VDD _08322_ sky130_fd_sc_hd__nor2_1
X_12076_ net437 _07614_ VSS VSS VDD VDD _08323_ sky130_fd_sc_hd__nand2_1
X_12077_ net402 _08322_ _08323_ _07646_ net429 VSS VSS VDD
+ VDD _08324_ sky130_fd_sc_hd__o2111ai_1
X_12078_ net436 _08315_ _08320_ _07702_ _08324_ VSS VSS VDD
+ VDD _08325_ sky130_fd_sc_hd__o2111ai_1
X_12079_ _07561_ _08313_ _08325_ VSS VSS VDD VDD _08326_ sky130_fd_sc_hd__o21ai_0
X_12080_ _07670_ _08310_ _08326_ VSS VSS VDD VDD _08327_ sky130_fd_sc_hd__a21oi_1
X_12081_ net327 _08327_ VSS VSS VDD VDD _01519_ sky130_fd_sc_hd__nor2_1
X_12082_ net396 net387 VSS VSS VDD VDD _08328_ sky130_fd_sc_hd__nor2_1
X_12083_ net435 _08328_ net371 VSS VSS VDD VDD _08329_ sky130_fd_sc_hd__a21oi_1
X_12084_ _07540_ _08010_ _08329_ net447 VSS VSS VDD VDD _08330_
+ sky130_fd_sc_hd__o22ai_1
X_12085_ net435 net388 _08249_ VSS VSS VDD VDD _08331_ sky130_fd_sc_hd__nor3_1
X_12086_ net398 _08330_ _08331_ VSS VSS VDD VDD _08332_ sky130_fd_sc_hd__a21oi_1
X_12087_ net436 net376 VSS VSS VDD VDD _08333_ sky130_fd_sc_hd__nor2_1
X_12088_ _07494_ _08333_ VSS VSS VDD VDD _08334_ sky130_fd_sc_hd__nor2_1
X_12089_ net435 _07965_ _08300_ VSS VSS VDD VDD _08335_ sky130_fd_sc_hd__o21ai_0
X_12090_ net439 _08335_ _07593_ net436 VSS VSS VDD VDD _08336_
+ sky130_fd_sc_hd__o2bb2ai_1
X_12091_ _07438_ _08078_ VSS VSS VDD VDD _08337_ sky130_fd_sc_hd__nor2_1
X_12092_ net444 _07557_ VSS VSS VDD VDD _08338_ sky130_fd_sc_hd__nor2_1
X_12093_ net436 _08337_ _08338_ net447 net450 VSS VSS VDD
+ VDD _08339_ sky130_fd_sc_hd__o221ai_1
X_12094_ net450 _08336_ _08339_ VSS VSS VDD VDD _08340_ sky130_fd_sc_hd__o21ai_0
X_12095_ net436 net390 VSS VSS VDD VDD _08341_ sky130_fd_sc_hd__nor2_1
X_12096_ net395 _08341_ VSS VSS VDD VDD _08342_ sky130_fd_sc_hd__nor2_1
X_12097_ net409 net376 VSS VSS VDD VDD _08343_ sky130_fd_sc_hd__nor2_1
X_12098_ net395 _08343_ VSS VSS VDD VDD _08344_ sky130_fd_sc_hd__nor2_1
X_12099_ net444 _08342_ _08344_ net436 net405 VSS VSS VDD
+ VDD _08345_ sky130_fd_sc_hd__o221ai_1
X_12100_ _07593_ _07941_ _08010_ VSS VSS VDD VDD _08346_ sky130_fd_sc_hd__a21oi_1
X_12101_ net377 _08346_ VSS VSS VDD VDD _08347_ sky130_fd_sc_hd__nor2_1
X_12102_ net437 _07965_ VSS VSS VDD VDD _08348_ sky130_fd_sc_hd__nor2_1
X_12103_ _07518_ _07626_ net433 VSS VSS VDD VDD _08349_ sky130_fd_sc_hd__a21boi_0
X_12104_ _08348_ _08349_ net429 VSS VSS VDD VDD _08350_ sky130_fd_sc_hd__o21ai_0
X_12105_ _08347_ _08350_ VSS VSS VDD VDD _08351_ sky130_fd_sc_hd__nand2_1
X_12106_ net439 _07691_ net449 VSS VSS VDD VDD _08352_ sky130_fd_sc_hd__a21oi_1
X_12107_ net437 _07553_ VSS VSS VDD VDD _08353_ sky130_fd_sc_hd__nand2_1
X_12108_ net446 _08031_ net393 VSS VSS VDD VDD _08354_ sky130_fd_sc_hd__nor3_1
X_12109_ net446 _07501_ _08353_ _08354_ VSS VSS VDD VDD _08355_
+ sky130_fd_sc_hd__a31oi_1
X_12110_ _08352_ _08355_ VSS VSS VDD VDD _08356_ sky130_fd_sc_hd__nor2_1
X_12111_ net429 net403 net334 VSS VSS VDD VDD _08357_ sky130_fd_sc_hd__a21oi_1
X_12112_ net408 net396 net427 VSS VSS VDD VDD _08358_ sky130_fd_sc_hd__a21oi_1
X_12113_ net429 _08356_ _08357_ _07339_ _08358_ VSS VSS VDD
+ VDD _08359_ sky130_fd_sc_hd__o221ai_1
X_12114_ net449 _08351_ _08359_ VSS VSS VDD VDD _08360_ sky130_fd_sc_hd__a21oi_1
X_12115_ _08334_ _08340_ _08345_ _08293_ _08360_ VSS VSS VDD
+ VDD _08361_ sky130_fd_sc_hd__a221oi_1
X_12116_ _07307_ _08332_ _08361_ _07344_ VSS VSS VDD VDD _01520_
+ sky130_fd_sc_hd__o22ai_1
X_12117_ network.neuron_in150.counter\[2\] network.neuron_in150.counter\[3\]
+ VSS VSS VDD VDD _08362_ sky130_fd_sc_hd__nor2_1
X_12118_ _00577_ _08362_ VSS VSS VDD VDD _08363_ sky130_fd_sc_hd__nand2_1
X_12119_ net358 _08363_ VSS VSS VDD VDD _08364_ sky130_fd_sc_hd__nand2_1
X_12120_ network.in_period\[150\]\[1\] _08364_ VSS VSS VDD
+ VDD _08365_ sky130_fd_sc_hd__nand2_1
X_12121_ _00578_ _08364_ _08365_ VSS VSS VDD VDD _02664_ sky130_fd_sc_hd__o21ai_0
X_12122_ network.in_period\[246\]\[1\] _08209_ VSS VSS VDD
+ VDD _08366_ sky130_fd_sc_hd__nand2_1
X_12123_ _00454_ _08209_ _08366_ VSS VSS VDD VDD _03048_ sky130_fd_sc_hd__o21ai_0
X_12124_ network.in_period\[150\]\[0\] _08364_ VSS VSS VDD
+ VDD _08367_ sky130_fd_sc_hd__nand2_1
X_12125_ network.neuron_in150.counter\[0\] _08364_ _08367_
+ VSS VSS VDD VDD _02663_ sky130_fd_sc_hd__o21ai_0
X_12126_ network.in_period\[247\]\[2\] network.neuron_in247.counter\[3\]
+ net416 _00613_ VSS VSS VDD VDD _08368_ sky130_fd_sc_hd__o22ai_1
X_12127_ network.neuron_in247.counter\[2\] _00613_ net365
+ VSS VSS VDD VDD _08369_ sky130_fd_sc_hd__nand3_1
X_12128_ network.in_period\[247\]\[2\] net365 _08369_ VSS
+ VSS VDD VDD _08370_ sky130_fd_sc_hd__o21ai_0
X_12129_ _08212_ _08368_ _08370_ VSS VSS VDD VDD _03053_ sky130_fd_sc_hd__a21oi_1
X_12130_ network.in_period\[247\]\[1\] _08214_ VSS VSS VDD
+ VDD _08371_ sky130_fd_sc_hd__nand2_1
X_12131_ _00614_ _08214_ _08371_ VSS VSS VDD VDD _03052_ sky130_fd_sc_hd__o21ai_0
X_12132_ network.neuron_in248.counter\[3\] network.in_period\[248\]\[2\]
+ _00463_ net415 VSS VSS VDD VDD _08372_ sky130_fd_sc_hd__o22ai_1
Xclkbuf_leaf_27_clk_net clknet_4_9__leaf_clk_net VSS VSS VDD
+ VDD clknet_leaf_27_clk_net sky130_fd_sc_hd__clkbuf_16
Xclkbuf_leaf_26_clk_net clknet_4_9__leaf_clk_net VSS VSS VDD
+ VDD clknet_leaf_26_clk_net sky130_fd_sc_hd__clkbuf_16
X_12135_ network.neuron_in248.counter\[2\] _00463_ net364
+ VSS VSS VDD VDD _08375_ sky130_fd_sc_hd__nand3_1
X_12136_ network.in_period\[248\]\[2\] net364 _08375_ VSS
+ VSS VDD VDD _08376_ sky130_fd_sc_hd__o21ai_0
X_12137_ _08217_ _08372_ _08376_ VSS VSS VDD VDD _03057_ sky130_fd_sc_hd__a21oi_1
X_12138_ network.neuron_in082.counter\[0\] VSS VSS VDD VDD
+ _00054_ sky130_fd_sc_hd__inv_1
X_12139_ network.in_period\[248\]\[1\] _08219_ VSS VSS VDD
+ VDD _08377_ sky130_fd_sc_hd__nand2_1
X_12140_ _00464_ _08219_ _08377_ VSS VSS VDD VDD _03056_ sky130_fd_sc_hd__o21ai_0
X_12141_ network.neuron_in249.counter\[3\] network.in_period\[249\]\[2\]
+ _01146_ net417 VSS VSS VDD VDD _08378_ sky130_fd_sc_hd__o22ai_1
Xclkbuf_leaf_25_clk_net clknet_4_9__leaf_clk_net VSS VSS VDD
+ VDD clknet_leaf_25_clk_net sky130_fd_sc_hd__clkbuf_16
X_12143_ network.neuron_in249.counter\[2\] _01146_ net364
+ VSS VSS VDD VDD _08380_ sky130_fd_sc_hd__nand3_1
X_12144_ network.in_period\[249\]\[2\] net364 _08380_ VSS
+ VSS VDD VDD _08381_ sky130_fd_sc_hd__o21ai_0
X_12145_ _08222_ _08378_ _08381_ VSS VSS VDD VDD _03061_ sky130_fd_sc_hd__a21oi_1
X_12146_ network.in_period\[249\]\[1\] _08224_ VSS VSS VDD
+ VDD _08382_ sky130_fd_sc_hd__nand2_1
X_12147_ _01147_ _08224_ _08382_ VSS VSS VDD VDD _03060_ sky130_fd_sc_hd__o21ai_0
Xclkbuf_leaf_24_clk_net clknet_4_9__leaf_clk_net VSS VSS VDD
+ VDD clknet_leaf_24_clk_net sky130_fd_sc_hd__clkbuf_16
X_12149_ network.neuron_in250.counter\[2\] _01086_ VSS VSS
+ VDD VDD _08384_ sky130_fd_sc_hd__nand2b_1
X_12150_ network.neuron_in250.counter\[3\] _08384_ VSS VSS
+ VDD VDD _08385_ sky130_fd_sc_hd__or2_2
X_12151_ net348 _08385_ VSS VSS VDD VDD _08386_ sky130_fd_sc_hd__nand2_1
X_12152_ network.in_period\[250\]\[1\] _08386_ VSS VSS VDD
+ VDD _08387_ sky130_fd_sc_hd__nand2_1
X_12153_ _01087_ _08386_ _08387_ VSS VSS VDD VDD _03064_ sky130_fd_sc_hd__o21ai_0
X_12154_ network.in_period\[250\]\[0\] _08386_ VSS VSS VDD
+ VDD _08388_ sky130_fd_sc_hd__nand2_1
X_12155_ network.neuron_in250.counter\[0\] _08386_ _08388_
+ VSS VSS VDD VDD _03063_ sky130_fd_sc_hd__o21ai_0
X_12156_ network.neuron_in251.counter\[3\] _00475_ VSS VSS
+ VDD VDD _08389_ sky130_fd_sc_hd__nand2b_1
X_12157_ _08389_ _08226_ VSS VSS VDD VDD _08390_ sky130_fd_sc_hd__nand2b_1
X_12158_ net365 _08390_ VSS VSS VDD VDD _08391_ sky130_fd_sc_hd__nand2_1
X_12159_ network.in_period\[251\]\[1\] _08391_ VSS VSS VDD
+ VDD _08392_ sky130_fd_sc_hd__nand2_1
X_12160_ _00476_ _08391_ _08392_ VSS VSS VDD VDD _03068_ sky130_fd_sc_hd__o21ai_0
X_12161_ network.neuron_in251.counter\[0\] VSS VSS VDD VDD
+ _00473_ sky130_fd_sc_hd__inv_1
X_12162_ network.in_period\[251\]\[0\] _08391_ VSS VSS VDD
+ VDD _08393_ sky130_fd_sc_hd__nand2_1
X_12163_ network.neuron_in251.counter\[0\] _08391_ _08393_
+ VSS VSS VDD VDD _03067_ sky130_fd_sc_hd__o21ai_0
X_12164_ network.neuron_in252.counter\[3\] _00487_ VSS VSS
+ VDD VDD _08394_ sky130_fd_sc_hd__nand2b_1
X_12165_ network.neuron_in252.counter\[2\] VSS VSS VDD VDD
+ _08395_ sky130_fd_sc_hd__inv_1
X_12166_ _08394_ _08395_ VSS VSS VDD VDD _08396_ sky130_fd_sc_hd__nand2b_1
X_12167_ net360 _08396_ VSS VSS VDD VDD _08397_ sky130_fd_sc_hd__nand2_1
X_12168_ network.in_period\[252\]\[0\] _08397_ VSS VSS VDD
+ VDD _08398_ sky130_fd_sc_hd__nand2_1
X_12169_ network.neuron_in252.counter\[0\] _08397_ _08398_
+ VSS VSS VDD VDD _03071_ sky130_fd_sc_hd__o21ai_0
X_12170_ network.neuron_in253.counter\[2\] network.neuron_in253.counter\[3\]
+ VSS VSS VDD VDD _08399_ sky130_fd_sc_hd__nor2_1
X_12171_ _00397_ _08399_ VSS VSS VDD VDD _08400_ sky130_fd_sc_hd__nand2_1
X_12172_ net348 _08400_ VSS VSS VDD VDD _08401_ sky130_fd_sc_hd__nand2_1
X_12173_ network.in_period\[253\]\[1\] _08401_ VSS VSS VDD
+ VDD _08402_ sky130_fd_sc_hd__nand2_1
X_12174_ _00398_ _08401_ _08402_ VSS VSS VDD VDD _03076_ sky130_fd_sc_hd__o21ai_0
X_12175_ network.neuron_in254.counter\[0\] VSS VSS VDD VDD
+ _00469_ sky130_fd_sc_hd__inv_1
X_12176_ network.neuron_in254.counter\[2\] VSS VSS VDD VDD
+ _08403_ sky130_fd_sc_hd__inv_1
X_12177_ _08403_ _00471_ VSS VSS VDD VDD _08404_ sky130_fd_sc_hd__nand2_1
X_12178_ network.neuron_in254.counter\[3\] _08404_ VSS VSS
+ VDD VDD _08405_ sky130_fd_sc_hd__or2_2
X_12179_ net365 _08405_ VSS VSS VDD VDD _08406_ sky130_fd_sc_hd__nand2_1
X_12180_ network.in_period\[254\]\[0\] _08406_ VSS VSS VDD
+ VDD _08407_ sky130_fd_sc_hd__nand2_1
X_12181_ network.neuron_in254.counter\[0\] _08406_ _08407_
+ VSS VSS VDD VDD _03079_ sky130_fd_sc_hd__o21ai_0
X_12182_ network.neuron_in255.counter\[2\] _01070_ VSS VSS
+ VDD VDD _08408_ sky130_fd_sc_hd__nand2b_1
X_12183_ network.neuron_in255.counter\[3\] _08408_ VSS VSS
+ VDD VDD _08409_ sky130_fd_sc_hd__or2_2
X_12184_ net365 _08409_ VSS VSS VDD VDD _08410_ sky130_fd_sc_hd__nand2_1
X_12185_ network.in_period\[255\]\[0\] _08410_ VSS VSS VDD
+ VDD _08411_ sky130_fd_sc_hd__nand2_1
X_12186_ network.neuron_in255.counter\[0\] _08410_ _08411_
+ VSS VSS VDD VDD _03083_ sky130_fd_sc_hd__o21ai_0
X_12187_ network.neuron_in252.counter\[3\] network.in_period\[252\]\[2\]
+ net426 _00487_ VSS VSS VDD VDD _08412_ sky130_fd_sc_hd__o22ai_1
X_12188_ network.neuron_in252.counter\[2\] _00487_ net360
+ VSS VSS VDD VDD _08413_ sky130_fd_sc_hd__nand3_1
X_12189_ network.in_period\[252\]\[2\] net360 _08413_ VSS
+ VSS VDD VDD _08414_ sky130_fd_sc_hd__o21ai_0
X_12190_ _08395_ _08412_ _08414_ VSS VSS VDD VDD _03073_ sky130_fd_sc_hd__a21oi_1
X_12191_ network.in_period\[252\]\[1\] _08397_ VSS VSS VDD
+ VDD _08415_ sky130_fd_sc_hd__nand2_1
X_12192_ _00488_ _08397_ _08415_ VSS VSS VDD VDD _03072_ sky130_fd_sc_hd__o21ai_0
X_12193_ network.neuron_in253.counter\[2\] VSS VSS VDD VDD
+ _08416_ sky130_fd_sc_hd__inv_1
X_12194_ network.neuron_in253.counter\[3\] network.in_period\[253\]\[2\]
+ _00397_ net426 VSS VSS VDD VDD _08417_ sky130_fd_sc_hd__o22ai_1
X_12195_ network.neuron_in253.counter\[2\] _00397_ net348
+ VSS VSS VDD VDD _08418_ sky130_fd_sc_hd__nand3_1
X_12196_ network.in_period\[253\]\[2\] net348 _08418_ VSS
+ VSS VDD VDD _08419_ sky130_fd_sc_hd__o21ai_0
X_12197_ _08416_ _08417_ _08419_ VSS VSS VDD VDD _03077_ sky130_fd_sc_hd__a21oi_1
X_12198_ network.in_period\[253\]\[0\] _08401_ VSS VSS VDD
+ VDD _08420_ sky130_fd_sc_hd__nand2_1
X_12199_ network.neuron_in253.counter\[0\] _08401_ _08420_
+ VSS VSS VDD VDD _03075_ sky130_fd_sc_hd__o21ai_0
X_12200_ network.neuron_in254.counter\[3\] network.in_period\[254\]\[2\]
+ _00471_ net417 VSS VSS VDD VDD _08421_ sky130_fd_sc_hd__o22ai_1
X_12201_ network.neuron_in254.counter\[2\] _00471_ net365
+ VSS VSS VDD VDD _08422_ sky130_fd_sc_hd__nand3_1
X_12202_ network.in_period\[254\]\[2\] net365 _08422_ VSS
+ VSS VDD VDD _08423_ sky130_fd_sc_hd__o21ai_0
X_12203_ _08403_ _08421_ _08423_ VSS VSS VDD VDD _03081_ sky130_fd_sc_hd__a21oi_1
X_12204_ network.in_period\[254\]\[1\] _08406_ VSS VSS VDD
+ VDD _08424_ sky130_fd_sc_hd__nand2_1
X_12205_ _00472_ _08406_ _08424_ VSS VSS VDD VDD _03080_ sky130_fd_sc_hd__o21ai_0
X_12206_ network.neuron_in255.counter\[2\] net364 VSS VSS
+ VDD VDD _08425_ sky130_fd_sc_hd__nand2_1
X_12207_ network.neuron_in255.counter\[3\] network.in_period\[255\]\[2\]
+ _08425_ VSS VSS VDD VDD _08426_ sky130_fd_sc_hd__o21ai_0
X_12208_ _01070_ network.neuron_in255.counter\[2\] net417
+ VSS VSS VDD VDD _08427_ sky130_fd_sc_hd__or3_1
X_12209_ network.in_period\[255\]\[2\] net364 _08427_ VSS
+ VSS VDD VDD _08428_ sky130_fd_sc_hd__o21ai_0
X_12210_ _01070_ _08426_ _08428_ VSS VSS VDD VDD _03085_ sky130_fd_sc_hd__a21oi_1
X_12211_ network.in_period\[255\]\[1\] _08410_ VSS VSS VDD
+ VDD _08429_ sky130_fd_sc_hd__nand2_1
X_12212_ _01071_ _08410_ _08429_ VSS VSS VDD VDD _03084_ sky130_fd_sc_hd__o21ai_0
X_12213_ network.neuron_in154.counter\[0\] VSS VSS VDD VDD
+ _01158_ sky130_fd_sc_hd__inv_1
X_12214_ network.neuron_in149.counter\[2\] net346 VSS VSS
+ VDD VDD _08430_ sky130_fd_sc_hd__nand2_1
X_12215_ network.in_period\[149\]\[2\] network.neuron_in149.counter\[3\]
+ _08430_ VSS VSS VDD VDD _08431_ sky130_fd_sc_hd__o21ai_0
X_12216_ _00585_ network.neuron_in149.counter\[2\] net417
+ VSS VSS VDD VDD _08432_ sky130_fd_sc_hd__or3_1
X_12217_ network.in_period\[149\]\[2\] net346 _08432_ VSS
+ VSS VDD VDD _08433_ sky130_fd_sc_hd__o21ai_0
X_12218_ _00585_ _08431_ _08433_ VSS VSS VDD VDD _02661_ sky130_fd_sc_hd__a21oi_1
X_12219_ network.in_period\[157\]\[0\] _07243_ VSS VSS VDD
+ VDD _08434_ sky130_fd_sc_hd__nand2_1
X_12220_ network.neuron_in157.counter\[0\] _07243_ _08434_
+ VSS VSS VDD VDD _02691_ sky130_fd_sc_hd__o21ai_0
X_12221_ network.in_period\[137\]\[2\] network.neuron_in137.counter\[3\]
+ _00724_ net421 VSS VSS VDD VDD _08435_ sky130_fd_sc_hd__o22ai_1
X_12222_ network.neuron_in137.counter\[2\] _00724_ net352
+ VSS VSS VDD VDD _08436_ sky130_fd_sc_hd__nand3_1
X_12223_ network.in_period\[137\]\[2\] net352 _08436_ VSS
+ VSS VDD VDD _08437_ sky130_fd_sc_hd__o21ai_0
X_12224_ _06820_ _08435_ _08437_ VSS VSS VDD VDD _02613_ sky130_fd_sc_hd__a21oi_1
X_12225_ network.neuron_in253.counter\[1\] VSS VSS VDD VDD
+ _00396_ sky130_fd_sc_hd__inv_1
X_12226_ network.neuron_in191.counter\[1\] VSS VSS VDD VDD
+ _00975_ sky130_fd_sc_hd__inv_1
X_12227_ network.neuron_in041.counter\[0\] VSS VSS VDD VDD
+ _00353_ sky130_fd_sc_hd__inv_1
X_12228_ network.neuron_in158.counter\[1\] VSS VSS VDD VDD
+ _00711_ sky130_fd_sc_hd__inv_1
X_12229_ network.neuron_in106.counter\[1\] VSS VSS VDD VDD
+ _00715_ sky130_fd_sc_hd__inv_1
X_12230_ network.neuron_in089.counter\[0\] VSS VSS VDD VDD
+ _01216_ sky130_fd_sc_hd__inv_1
X_12231_ network.neuron_in091.counter\[0\] VSS VSS VDD VDD
+ _00143_ sky130_fd_sc_hd__inv_1
Xclkbuf_leaf_23_clk_net clknet_4_9__leaf_clk_net VSS VSS VDD
+ VDD clknet_leaf_23_clk_net sky130_fd_sc_hd__clkbuf_16
X_12233_ network.neuron_out0.ROM0.address\[1\] network.neuron_out0.ROM0.read_en
+ net339 VSS VSS VDD VDD _08439_ sky130_fd_sc_hd__nand3_1
X_12234_ _08439_ VSS VSS VDD VDD _01521_ sky130_fd_sc_hd__inv_1
Xclkbuf_leaf_22_clk_net clknet_4_3__leaf_clk_net VSS VSS VDD
+ VDD clknet_leaf_22_clk_net sky130_fd_sc_hd__clkbuf_16
Xclkbuf_leaf_21_clk_net clknet_4_3__leaf_clk_net VSS VSS VDD
+ VDD clknet_leaf_21_clk_net sky130_fd_sc_hd__clkbuf_16
Xclkbuf_leaf_20_clk_net clknet_4_3__leaf_clk_net VSS VSS VDD
+ VDD clknet_leaf_20_clk_net sky130_fd_sc_hd__clkbuf_16
X_12238_ network.neuron_out0.ROM0.address\[2\] network.neuron_out0.ROM0.address\[0\]
+ VSS VSS VDD VDD _08443_ sky130_fd_sc_hd__nand2_1
X_12239_ network.neuron_out0.ROM0.read_en net339 _08443_ VSS
+ VSS VDD VDD _08444_ sky130_fd_sc_hd__nand3_1
X_12240_ network.neuron_out0.ROM0.address\[1\] _08444_ VSS
+ VSS VDD VDD _01522_ sky130_fd_sc_hd__nor2_1
X_12241_ network.neuron_out0.ROM0.address\[0\] VSS VSS VDD
+ VDD _08445_ sky130_fd_sc_hd__inv_1
X_12242_ network.neuron_out0.ROM0.address\[2\] _08445_ VSS
+ VSS VDD VDD _08446_ sky130_fd_sc_hd__nor2_1
X_12243_ network.neuron_out0.ROM0.address\[0\] network.neuron_out0.ROM0.address\[2\]
+ VSS VSS VDD VDD _08447_ sky130_fd_sc_hd__nor2b_1
X_12244_ network.neuron_out0.ROM0.address\[1\] _08446_ _08447_
+ VSS VSS VDD VDD _08448_ sky130_fd_sc_hd__nor3_1
X_12245_ network.neuron_out0.ROM0.read_en net339 VSS VSS VDD
+ VDD _08449_ sky130_fd_sc_hd__nand2_1
Xclkbuf_leaf_19_clk_net clknet_4_3__leaf_clk_net VSS VSS VDD
+ VDD clknet_leaf_19_clk_net sky130_fd_sc_hd__clkbuf_16
X_12247_ network.neuron_out0.ROM0.address\[1\] _08446_ _08448_
+ _08449_ VSS VSS VDD VDD _01523_ sky130_fd_sc_hd__a211oi_1
Xclkbuf_leaf_18_clk_net clknet_4_3__leaf_clk_net VSS VSS VDD
+ VDD clknet_leaf_18_clk_net sky130_fd_sc_hd__clkbuf_16
X_12249_ network.neuron_out0.ROM0.address\[1\] _08445_ VSS
+ VSS VDD VDD _08452_ sky130_fd_sc_hd__nor2_1
X_12250_ _08452_ network.neuron_out0.ROM0.address\[2\] VSS
+ VSS VDD VDD _08453_ sky130_fd_sc_hd__nor2b_1
X_12251_ _08449_ _08453_ VSS VSS VDD VDD _01524_ sky130_fd_sc_hd__nor2_1
X_12252_ network.neuron_out0.ROM0.address\[2\] network.neuron_out0.ROM0.address\[1\]
+ VSS VSS VDD VDD _08454_ sky130_fd_sc_hd__nand2b_1
X_12253_ network.neuron_out0.ROM0.address\[2\] network.neuron_out0.ROM0.address\[0\]
+ VSS VSS VDD VDD _08455_ sky130_fd_sc_hd__nor2_1
X_12254_ network.neuron_out0.ROM0.address\[1\] _08455_ VSS
+ VSS VDD VDD _08456_ sky130_fd_sc_hd__or2_2
X_12255_ _08454_ _08456_ _08449_ VSS VSS VDD VDD _01525_ sky130_fd_sc_hd__a21oi_1
Xclkbuf_leaf_17_clk_net clknet_4_2__leaf_clk_net VSS VSS VDD
+ VDD clknet_leaf_17_clk_net sky130_fd_sc_hd__clkbuf_16
X_12257_ network.neuron_out0.ROM0.address\[2\] _08445_ VSS
+ VSS VDD VDD _08458_ sky130_fd_sc_hd__nand2_1
X_12258_ network.neuron_out0.ROM0.address\[1\] _08458_ _08454_
+ VSS VSS VDD VDD _08459_ sky130_fd_sc_hd__o21ai_0
X_12259_ network.neuron_out0.ROM0.read_en net339 _08459_ VSS
+ VSS VDD VDD _01526_ sky130_fd_sc_hd__and3_1
X_12260_ network.neuron_out0.ROM0.address\[1\] _08458_ _08446_
+ VSS VSS VDD VDD _08460_ sky130_fd_sc_hd__a21oi_1
X_12261_ _08449_ _08460_ VSS VSS VDD VDD _01527_ sky130_fd_sc_hd__nor2_1
X_12262_ network.neuron_out0.ROM0.address\[2\] network.neuron_out0.ROM0.address\[0\]
+ VSS VSS VDD VDD _08461_ sky130_fd_sc_hd__nand2b_1
X_12263_ network.neuron_out0.ROM0.address\[1\] _08447_ VSS
+ VSS VDD VDD _08462_ sky130_fd_sc_hd__nand2_1
X_12264_ network.neuron_out0.ROM0.address\[1\] _08461_ _08462_
+ VSS VSS VDD VDD _08463_ sky130_fd_sc_hd__o21ai_0
X_12265_ _08449_ _08463_ VSS VSS VDD VDD _01528_ sky130_fd_sc_hd__nor2_1
X_12266_ network.neuron_out0.ROM0.address\[1\] _08443_ _08455_
+ VSS VSS VDD VDD _08464_ sky130_fd_sc_hd__a21oi_1
X_12267_ _08449_ _08464_ VSS VSS VDD VDD _01529_ sky130_fd_sc_hd__nor2_1
X_12268_ network.neuron_out0.ROM0.address\[1\] _08461_ _08449_
+ VSS VSS VDD VDD _01530_ sky130_fd_sc_hd__a21oi_1
X_12269_ network.neuron_out0.ROM0.address\[1\] network.neuron_out0.ROM0.address\[2\]
+ VSS VSS VDD VDD _08465_ sky130_fd_sc_hd__nor2_1
X_12270_ network.neuron_out0.ROM0.address\[1\] _08447_ _08465_
+ VSS VSS VDD VDD _08466_ sky130_fd_sc_hd__a21oi_1
X_12271_ _08449_ _08466_ VSS VSS VDD VDD _01531_ sky130_fd_sc_hd__nor2_1
X_12272_ network.neuron_out0.ROM0.read_en net339 _08463_ VSS
+ VSS VDD VDD _01532_ sky130_fd_sc_hd__and3_1
X_12273_ network.neuron_out0.ROM0.address\[1\] _08455_ _08452_
+ _08449_ VSS VSS VDD VDD _01533_ sky130_fd_sc_hd__a211oi_1
X_12274_ network.neuron_out0.ROM0.address\[0\] _08439_ VSS
+ VSS VDD VDD _01534_ sky130_fd_sc_hd__nor2_1
X_12275_ _08446_ _08447_ VSS VSS VDD VDD _08467_ sky130_fd_sc_hd__nor2_1
X_12276_ network.neuron_out0.ROM0.address\[1\] network.neuron_out0.ROM0.address\[2\]
+ network.neuron_out0.ROM0.address\[0\] VSS VSS VDD VDD _08468_
+ sky130_fd_sc_hd__nand3_1
X_12277_ network.neuron_out0.ROM0.address\[1\] _08467_ _08468_
+ VSS VSS VDD VDD _08469_ sky130_fd_sc_hd__o21a_1
X_12278_ _08449_ _08469_ VSS VSS VDD VDD _01535_ sky130_fd_sc_hd__nor2_1
X_12279_ _08443_ _08454_ _08449_ VSS VSS VDD VDD _01536_ sky130_fd_sc_hd__a21oi_1
X_12280_ _08444_ _08465_ VSS VSS VDD VDD _01537_ sky130_fd_sc_hd__nor2_1
X_12281_ network.neuron_out0.ROM0.address\[1\] network.neuron_out0.ROM0.address\[0\]
+ VSS VSS VDD VDD _08470_ sky130_fd_sc_hd__nor2_1
X_12282_ _08444_ _08470_ VSS VSS VDD VDD _01538_ sky130_fd_sc_hd__nor2_1
X_12283_ network.neuron_out0.ROM0.address\[2\] network.neuron_out0.ROM0.address\[0\]
+ network.neuron_out0.ROM0.address\[1\] VSS VSS VDD VDD _08471_
+ sky130_fd_sc_hd__a21oi_1
X_12284_ network.neuron_out0.ROM0.address\[1\] _08467_ _08471_
+ _08449_ VSS VSS VDD VDD _01539_ sky130_fd_sc_hd__a211oi_1
X_12285_ network.neuron_in185.counter\[1\] VSS VSS VDD VDD
+ _00276_ sky130_fd_sc_hd__inv_1
X_12286_ _07593_ net382 _08167_ VSS VSS VDD VDD _08472_ sky130_fd_sc_hd__a21oi_1
X_12287_ _07489_ _07657_ VSS VSS VDD VDD _08473_ sky130_fd_sc_hd__nand2_1
X_12288_ net433 _08473_ net371 VSS VSS VDD VDD _08474_ sky130_fd_sc_hd__a21oi_1
X_12289_ net433 _08472_ _08474_ net439 VSS VSS VDD VDD _08475_
+ sky130_fd_sc_hd__o22ai_1
X_12290_ net441 _07929_ net451 VSS VSS VDD VDD _08476_ sky130_fd_sc_hd__a21oi_1
X_12291_ net451 _07518_ VSS VSS VDD VDD _08477_ sky130_fd_sc_hd__nand2_1
X_12292_ net441 _07624_ net434 VSS VSS VDD VDD _08478_ sky130_fd_sc_hd__a21oi_1
X_12293_ _08477_ _08478_ VSS VSS VDD VDD _08479_ sky130_fd_sc_hd__nor2_1
X_12294_ net430 _08476_ _08479_ VSS VSS VDD VDD _08480_ sky130_fd_sc_hd__nor3_1
X_12295_ net429 net449 VSS VSS VDD VDD _08481_ sky130_fd_sc_hd__and2_1
X_12296_ net433 net446 net439 VSS VSS VDD VDD _08482_ sky130_fd_sc_hd__o21ai_0
X_12297_ _08481_ _08482_ _07399_ VSS VSS VDD VDD _08483_ sky130_fd_sc_hd__a21oi_1
X_12298_ net431 net404 VSS VSS VDD VDD _08484_ sky130_fd_sc_hd__nand2_1
X_12299_ net429 _07540_ _08484_ VSS VSS VDD VDD _08485_ sky130_fd_sc_hd__o21ai_0
X_12300_ net437 _08485_ VSS VSS VDD VDD _08486_ sky130_fd_sc_hd__nand2_1
X_12301_ _08483_ _08486_ net402 VSS VSS VDD VDD _08487_ sky130_fd_sc_hd__a21oi_1
X_12302_ net442 _07489_ VSS VSS VDD VDD _08488_ sky130_fd_sc_hd__nor2_1
X_12303_ _08157_ _08488_ net437 VSS VSS VDD VDD _08489_ sky130_fd_sc_hd__o21ai_0
X_12304_ _07339_ _07409_ _08489_ VSS VSS VDD VDD _08490_ sky130_fd_sc_hd__o21ai_0
X_12305_ net429 _08490_ VSS VSS VDD VDD _08491_ sky130_fd_sc_hd__nand2_1
X_12306_ net409 net336 _07646_ _08491_ VSS VSS VDD VDD _08492_
+ sky130_fd_sc_hd__o211ai_1
X_12307_ net430 _07593_ _07965_ VSS VSS VDD VDD _08493_ sky130_fd_sc_hd__o21ai_0
X_12308_ _07339_ net405 net430 VSS VSS VDD VDD _08494_ sky130_fd_sc_hd__a21oi_1
X_12309_ net433 _08493_ _08494_ _07441_ VSS VSS VDD VDD _08495_
+ sky130_fd_sc_hd__a211oi_1
X_12310_ net451 _08495_ VSS VSS VDD VDD _08496_ sky130_fd_sc_hd__nor2_1
X_12311_ net391 _08184_ net433 VSS VSS VDD VDD _08497_ sky130_fd_sc_hd__o21bai_1
X_12312_ _07636_ _08497_ net448 VSS VSS VDD VDD _08498_ sky130_fd_sc_hd__a21oi_1
X_12313_ net440 _07409_ net433 VSS VSS VDD VDD _08499_ sky130_fd_sc_hd__a21oi_1
X_12314_ net433 net335 net334 _08499_ VSS VSS VDD VDD _08500_
+ sky130_fd_sc_hd__a211o_1
X_12315_ _07634_ _08051_ VSS VSS VDD VDD _08501_ sky130_fd_sc_hd__nor2_1
X_12316_ net430 _08500_ _08501_ VSS VSS VDD VDD _08502_ sky130_fd_sc_hd__a21oi_1
X_12317_ net402 _08502_ VSS VSS VDD VDD _08503_ sky130_fd_sc_hd__nor2_1
X_12318_ net399 _08496_ _08498_ _08503_ VSS VSS VDD VDD _08504_
+ sky130_fd_sc_hd__or4_1
X_12319_ net427 _08480_ _08487_ _08492_ _08504_ VSS VSS VDD
+ VDD _08505_ sky130_fd_sc_hd__o41ai_1
X_12320_ _07562_ _08475_ _08505_ _07474_ VSS VSS VDD VDD _01540_
+ sky130_fd_sc_hd__a22o_1
X_12321_ network.neuron_out0.ROM0.address\[1\] _08447_ _08448_
+ VSS VSS VDD VDD _08506_ sky130_fd_sc_hd__a21oi_1
X_12322_ _08449_ _08506_ VSS VSS VDD VDD _01541_ sky130_fd_sc_hd__nor2_1
X_12323_ _08449_ _08456_ VSS VSS VDD VDD _01542_ sky130_fd_sc_hd__nor2_1
X_12324_ _08449_ _08465_ _08468_ VSS VSS VDD VDD _01543_ sky130_fd_sc_hd__nor3b_1
X_12325_ _08445_ _08449_ VSS VSS VDD VDD _01544_ sky130_fd_sc_hd__nor2_1
X_12326_ network.neuron_out0.ROM0.address\[1\] network.neuron_out0.ROM0.address\[2\]
+ VSS VSS VDD VDD _08507_ sky130_fd_sc_hd__nand2b_1
X_12327_ _08445_ _08507_ _08449_ VSS VSS VDD VDD _01545_ sky130_fd_sc_hd__a21oi_1
X_12328_ net387 _07556_ net437 VSS VSS VDD VDD _08508_ sky130_fd_sc_hd__o21ai_0
X_12329_ net437 _07433_ _07536_ _08508_ VSS VSS VDD VDD _08509_
+ sky130_fd_sc_hd__o211ai_1
X_12330_ _07391_ net376 net392 VSS VSS VDD VDD _08510_ sky130_fd_sc_hd__a21oi_1
X_12331_ _07393_ net371 net439 VSS VSS VDD VDD _08511_ sky130_fd_sc_hd__o21ai_0
X_12332_ net404 _07984_ _08087_ VSS VSS VDD VDD _08512_ sky130_fd_sc_hd__o21ai_0
X_12333_ net449 _08510_ _08511_ net429 _08512_ VSS VSS VDD
+ VDD _08513_ sky130_fd_sc_hd__o2111ai_1
X_12334_ net429 _08509_ _08513_ VSS VSS VDD VDD _08514_ sky130_fd_sc_hd__o21ai_0
X_12335_ _07339_ _07489_ _08514_ VSS VSS VDD VDD _08515_ sky130_fd_sc_hd__o21ai_0
X_12336_ net434 net389 VSS VSS VDD VDD _08516_ sky130_fd_sc_hd__nand2_1
X_12337_ net434 _07518_ net378 net335 VSS VSS VDD VDD _08517_
+ sky130_fd_sc_hd__o22ai_1
X_12338_ net434 _07981_ net372 net379 VSS VSS VDD VDD _08518_
+ sky130_fd_sc_hd__o22ai_1
X_12339_ net446 _08517_ _08518_ net449 VSS VSS VDD VDD _08519_
+ sky130_fd_sc_hd__a22oi_1
X_12340_ _08516_ _08519_ _07543_ VSS VSS VDD VDD _08520_ sky130_fd_sc_hd__a21oi_1
X_12341_ net399 _08515_ _08520_ VSS VSS VDD VDD _08521_ sky130_fd_sc_hd__a21oi_1
X_12342_ net445 _07533_ VSS VSS VDD VDD _08522_ sky130_fd_sc_hd__nor2_1
X_12343_ net437 _07561_ net337 _08522_ VSS VSS VDD VDD _08523_
+ sky130_fd_sc_hd__nor4_1
X_12344_ _07635_ _07636_ net448 VSS VSS VDD VDD _08524_ sky130_fd_sc_hd__a21o_1
X_12345_ net434 _08072_ _08516_ VSS VSS VDD VDD _08525_ sky130_fd_sc_hd__o21ai_0
X_12346_ _07614_ _07936_ VSS VSS VDD VDD _08526_ sky130_fd_sc_hd__nor2_1
X_12347_ _07486_ _08010_ _07440_ net430 _07702_ VSS VSS VDD
+ VDD _08527_ sky130_fd_sc_hd__o2111ai_1
X_12348_ net402 _08525_ _08526_ _08527_ VSS VSS VDD VDD _08528_
+ sky130_fd_sc_hd__a211oi_1
X_12349_ _08523_ _08524_ _08528_ VSS VSS VDD VDD _08529_ sky130_fd_sc_hd__a21oi_1
X_12350_ network.neuron_hid0.ROM0.address\[7\] _08521_ _08529_
+ VSS VSS VDD VDD _08530_ sky130_fd_sc_hd__o21ai_0
X_12351_ _07302_ _08530_ _07558_ _07307_ VSS VSS VDD VDD _01546_
+ sky130_fd_sc_hd__o2bb2ai_1
X_12352_ net402 net403 VSS VSS VDD VDD _08531_ sky130_fd_sc_hd__nand2_1
X_12353_ _07646_ _08021_ VSS VSS VDD VDD _08532_ sky130_fd_sc_hd__nand2_1
X_12354_ net384 _08531_ _07687_ _08532_ net433 VSS VSS VDD
+ VDD _08533_ sky130_fd_sc_hd__a32oi_1
X_12355_ net433 net393 VSS VSS VDD VDD _08534_ sky130_fd_sc_hd__nand2_1
X_12356_ net433 _07965_ _08534_ VSS VSS VDD VDD _08535_ sky130_fd_sc_hd__o21ai_0
X_12357_ net449 _08535_ VSS VSS VDD VDD _08536_ sky130_fd_sc_hd__nand2_1
X_12358_ net439 net373 net402 VSS VSS VDD VDD _08537_ sky130_fd_sc_hd__o21ai_0
X_12359_ net442 _07428_ _08488_ net389 net433 VSS VSS VDD
+ VDD _08538_ sky130_fd_sc_hd__a2111oi_0
X_12360_ net433 _07536_ _08537_ _08538_ VSS VSS VDD VDD _08539_
+ sky130_fd_sc_hd__a31oi_1
X_12361_ _08094_ _08539_ _07429_ VSS VSS VDD VDD _08540_ sky130_fd_sc_hd__nor3b_1
X_12362_ net433 _07396_ VSS VSS VDD VDD _08541_ sky130_fd_sc_hd__nand2_1
X_12363_ net433 _08016_ _08541_ VSS VSS VDD VDD _08542_ sky130_fd_sc_hd__o21ai_0
X_12364_ net429 net446 _07657_ _08343_ VSS VSS VDD VDD _08543_
+ sky130_fd_sc_hd__a31oi_1
X_12365_ net431 net445 VSS VSS VDD VDD _08544_ sky130_fd_sc_hd__nand2_1
X_12366_ _07551_ _08544_ _07429_ VSS VSS VDD VDD _08545_ sky130_fd_sc_hd__o21ai_0
X_12367_ net433 _08545_ VSS VSS VDD VDD _08546_ sky130_fd_sc_hd__nor2_1
X_12368_ net433 _08543_ _08546_ VSS VSS VDD VDD _08547_ sky130_fd_sc_hd__a21oi_1
X_12369_ net436 _07614_ VSS VSS VDD VDD _08548_ sky130_fd_sc_hd__nor2_1
X_12370_ net447 net384 _07515_ _08548_ VSS VSS VDD VDD _08549_
+ sky130_fd_sc_hd__o22ai_1
X_12371_ net436 _08142_ _08341_ VSS VSS VDD VDD _08550_ sky130_fd_sc_hd__a21oi_1
X_12372_ net440 _08549_ _08550_ net444 VSS VSS VDD VDD _08551_
+ sky130_fd_sc_hd__o22a_1
X_12373_ net430 _08551_ VSS VSS VDD VDD _08552_ sky130_fd_sc_hd__nor2_1
X_12374_ net406 _08542_ _08547_ _08552_ net399 VSS VSS VDD
+ VDD _08553_ sky130_fd_sc_hd__a2111oi_0
X_12375_ net385 _08533_ _08536_ _08540_ _08553_ VSS VSS VDD
+ VDD _08554_ sky130_fd_sc_hd__a311oi_1
X_12376_ net376 net380 net433 VSS VSS VDD VDD _08555_ sky130_fd_sc_hd__a21oi_1
X_12377_ net408 net407 VSS VSS VDD VDD _08556_ sky130_fd_sc_hd__nor2_1
X_12378_ net442 _08556_ VSS VSS VDD VDD _08557_ sky130_fd_sc_hd__nor2_1
X_12379_ _08555_ _08557_ _07562_ VSS VSS VDD VDD _08558_ sky130_fd_sc_hd__o21ai_0
X_12380_ _07344_ _08554_ _08558_ VSS VSS VDD VDD _01547_ sky130_fd_sc_hd__o21ai_0
X_12381_ net400 net376 VSS VSS VDD VDD _08559_ sky130_fd_sc_hd__nand2_1
X_12382_ net429 _08559_ VSS VSS VDD VDD _08560_ sky130_fd_sc_hd__nand2_1
X_12383_ _07984_ net377 VSS VSS VDD VDD _08561_ sky130_fd_sc_hd__nor2_1
X_12384_ net429 net404 VSS VSS VDD VDD _08562_ sky130_fd_sc_hd__nor2_1
X_12385_ net434 _08562_ VSS VSS VDD VDD _08563_ sky130_fd_sc_hd__nor2_1
X_12386_ net434 _08185_ _08560_ _08561_ _08563_ VSS VSS VDD
+ VDD _08564_ sky130_fd_sc_hd__a32oi_1
X_12387_ _07352_ _07513_ _08010_ net374 _07553_ VSS VSS VDD
+ VDD _08565_ sky130_fd_sc_hd__a32oi_1
X_12388_ net429 _08010_ _08565_ net451 VSS VSS VDD VDD _08566_
+ sky130_fd_sc_hd__o22ai_1
X_12389_ net442 _07551_ _08473_ net439 VSS VSS VDD VDD _08567_
+ sky130_fd_sc_hd__a22oi_1
X_12390_ net442 _07391_ _08013_ net399 VSS VSS VDD VDD _08568_
+ sky130_fd_sc_hd__a31oi_1
X_12391_ net381 _08567_ _08568_ VSS VSS VDD VDD _08569_ sky130_fd_sc_hd__o21ai_0
X_12392_ net451 _08564_ _08566_ net448 _08569_ VSS VSS VDD
+ VDD _08570_ sky130_fd_sc_hd__a221oi_1
X_12393_ net397 _07608_ VSS VSS VDD VDD _08571_ sky130_fd_sc_hd__nor2_1
X_12394_ _07593_ _07657_ _08571_ VSS VSS VDD VDD _08572_ sky130_fd_sc_hd__o21ai_0
X_12395_ net443 net440 _07409_ _08572_ VSS VSS VDD VDD _08573_
+ sky130_fd_sc_hd__a31oi_1
X_12396_ net405 _07512_ _08097_ VSS VSS VDD VDD _08574_ sky130_fd_sc_hd__a21oi_1
X_12397_ _07533_ _08574_ _07612_ VSS VSS VDD VDD _08575_ sky130_fd_sc_hd__a21oi_1
X_12398_ net433 net388 _07614_ VSS VSS VDD VDD _08576_ sky130_fd_sc_hd__nand3_1
X_12399_ net433 _07975_ _08576_ VSS VSS VDD VDD _08577_ sky130_fd_sc_hd__o21ai_0
X_12400_ net451 net378 _08064_ _07995_ _07636_ VSS VSS VDD
+ VDD _08578_ sky130_fd_sc_hd__o221ai_1
X_12401_ net448 _08578_ VSS VSS VDD VDD _08579_ sky130_fd_sc_hd__nor2_1
X_12402_ net448 _08577_ _08579_ net430 VSS VSS VDD VDD _08580_
+ sky130_fd_sc_hd__a211oi_1
X_12403_ net427 _08573_ _08575_ _08580_ _07474_ VSS VSS VDD
+ VDD _08581_ sky130_fd_sc_hd__o41ai_1
X_12404_ net451 _07518_ _07981_ net395 VSS VSS VDD VDD _08582_
+ sky130_fd_sc_hd__a31oi_1
X_12405_ net433 _08582_ _07558_ VSS VSS VDD VDD _08583_ sky130_fd_sc_hd__o21ai_0
X_12406_ _07562_ _08583_ VSS VSS VDD VDD _08584_ sky130_fd_sc_hd__nand2_1
X_12407_ _08570_ _08581_ _08584_ VSS VSS VDD VDD _01548_ sky130_fd_sc_hd__o21ai_0
X_12408_ network.cnt_main.counter\[1\] VSS VSS VDD VDD _00689_
+ sky130_fd_sc_hd__inv_1
X_12409_ network.neuron_in000.counter\[2\] VSS VSS VDD VDD
+ _08585_ sky130_fd_sc_hd__inv_1
X_12410_ network.neuron_in000.counter\[3\] network.in_period\[0\]\[2\]
+ _00682_ net424 VSS VSS VDD VDD _08586_ sky130_fd_sc_hd__o22ai_1
X_12411_ network.neuron_in000.counter\[2\] _00682_ net340
+ VSS VSS VDD VDD _08587_ sky130_fd_sc_hd__nand3_1
X_12412_ network.in_period\[0\]\[2\] net340 _08587_ VSS VSS
+ VDD VDD _08588_ sky130_fd_sc_hd__o21ai_0
X_12413_ _08585_ _08586_ _08588_ VSS VSS VDD VDD _02065_ sky130_fd_sc_hd__a21oi_1
X_12414_ network.neuron_in137.counter\[1\] VSS VSS VDD VDD
+ _00723_ sky130_fd_sc_hd__inv_1
X_12415_ network.neuron_in061.counter\[0\] VSS VSS VDD VDD
+ _00635_ sky130_fd_sc_hd__inv_1
X_12416_ network.neuron_in014.counter\[0\] VSS VSS VDD VDD
+ _00501_ sky130_fd_sc_hd__inv_1
X_12417_ network.neuron_in003.counter\[2\] network.neuron_in003.counter\[3\]
+ VSS VSS VDD VDD _08589_ sky130_fd_sc_hd__nor2_1
X_12418_ _00678_ _08589_ VSS VSS VDD VDD _08590_ sky130_fd_sc_hd__nand2_1
X_12419_ net343 _08590_ VSS VSS VDD VDD _08591_ sky130_fd_sc_hd__nand2_1
X_12420_ network.in_period\[3\]\[1\] _08591_ VSS VSS VDD VDD
+ _08592_ sky130_fd_sc_hd__nand2_1
X_12421_ _00679_ _08591_ _08592_ VSS VSS VDD VDD _02076_ sky130_fd_sc_hd__o21ai_0
X_12422_ network.neuron_in128.counter\[2\] net358 VSS VSS
+ VDD VDD _08593_ sky130_fd_sc_hd__nand2_1
X_12423_ network.neuron_in128.counter\[3\] network.in_period\[128\]\[2\]
+ _08593_ VSS VSS VDD VDD _08594_ sky130_fd_sc_hd__o21ai_0
X_12424_ _01034_ network.neuron_in128.counter\[2\] net420
+ VSS VSS VDD VDD _08595_ sky130_fd_sc_hd__or3_1
X_12425_ network.in_period\[128\]\[2\] net358 _08595_ VSS
+ VSS VDD VDD _08596_ sky130_fd_sc_hd__o21ai_0
X_12426_ _01034_ _08594_ _08596_ VSS VSS VDD VDD _02577_ sky130_fd_sc_hd__a21oi_1
X_12427_ network.neuron_in230.counter\[1\] VSS VSS VDD VDD
+ _00701_ sky130_fd_sc_hd__inv_1
X_12428_ network.neuron_in001.counter\[2\] net341 VSS VSS
+ VDD VDD _08597_ sky130_fd_sc_hd__nand2_1
X_12429_ network.neuron_in001.counter\[3\] network.in_period\[1\]\[2\]
+ _08597_ VSS VSS VDD VDD _08598_ sky130_fd_sc_hd__o21ai_0
X_12430_ _00621_ network.neuron_in001.counter\[2\] net424
+ VSS VSS VDD VDD _08599_ sky130_fd_sc_hd__or3_1
X_12431_ network.in_period\[1\]\[2\] net341 _08599_ VSS VSS
+ VDD VDD _08600_ sky130_fd_sc_hd__o21ai_0
X_12432_ _00621_ _08598_ _08600_ VSS VSS VDD VDD _02069_ sky130_fd_sc_hd__a21oi_1
X_12433_ network.neuron_in086.counter\[1\] VSS VSS VDD VDD
+ _00039_ sky130_fd_sc_hd__inv_1
X_12434_ network.in_period\[133\]\[1\] _07091_ VSS VSS VDD
+ VDD _08601_ sky130_fd_sc_hd__nand2_1
X_12435_ _00101_ _07091_ _08601_ VSS VSS VDD VDD _02596_ sky130_fd_sc_hd__o21ai_0
X_12436_ network.neuron_in225.counter\[1\] VSS VSS VDD VDD
+ _00358_ sky130_fd_sc_hd__inv_1
X_12437_ network.neuron_in002.counter\[2\] VSS VSS VDD VDD
+ _08602_ sky130_fd_sc_hd__inv_1
X_12438_ _08602_ _00785_ VSS VSS VDD VDD _08603_ sky130_fd_sc_hd__nand2_1
X_12439_ network.neuron_in002.counter\[3\] _08603_ VSS VSS
+ VDD VDD _08604_ sky130_fd_sc_hd__or2_2
X_12440_ net343 _08604_ VSS VSS VDD VDD _08605_ sky130_fd_sc_hd__nand2_1
X_12441_ network.in_period\[2\]\[1\] _08605_ VSS VSS VDD VDD
+ _08606_ sky130_fd_sc_hd__nand2_1
X_12442_ _00786_ _08605_ _08606_ VSS VSS VDD VDD _02072_ sky130_fd_sc_hd__o21ai_0
X_12443_ network.neuron_in106.counter\[0\] VSS VSS VDD VDD
+ _00714_ sky130_fd_sc_hd__inv_1
X_12444_ _08585_ _00682_ VSS VSS VDD VDD _08607_ sky130_fd_sc_hd__nand2_1
X_12445_ network.neuron_in000.counter\[3\] _08607_ VSS VSS
+ VDD VDD _08608_ sky130_fd_sc_hd__or2_2
X_12446_ net340 _08608_ VSS VSS VDD VDD _08609_ sky130_fd_sc_hd__nand2_1
X_12447_ network.in_period\[0\]\[1\] _08609_ VSS VSS VDD VDD
+ _08610_ sky130_fd_sc_hd__nand2_1
X_12448_ _00683_ _08609_ _08610_ VSS VSS VDD VDD _02064_ sky130_fd_sc_hd__o21ai_0
X_12449_ network.neuron_in000.counter\[0\] VSS VSS VDD VDD
+ _00680_ sky130_fd_sc_hd__inv_1
X_12450_ network.in_period\[0\]\[0\] _08609_ VSS VSS VDD VDD
+ _08611_ sky130_fd_sc_hd__nand2_1
X_12451_ network.neuron_in000.counter\[0\] _08609_ _08611_
+ VSS VSS VDD VDD _02063_ sky130_fd_sc_hd__o21ai_0
X_12452_ network.neuron_in001.counter\[2\] _00621_ VSS VSS
+ VDD VDD _08612_ sky130_fd_sc_hd__nand2b_1
X_12453_ network.neuron_in001.counter\[3\] _08612_ VSS VSS
+ VDD VDD _08613_ sky130_fd_sc_hd__or2_2
X_12454_ net341 _08613_ VSS VSS VDD VDD _08614_ sky130_fd_sc_hd__nand2_1
X_12455_ network.in_period\[1\]\[1\] _08614_ VSS VSS VDD VDD
+ _08615_ sky130_fd_sc_hd__nand2_1
X_12456_ _00622_ _08614_ _08615_ VSS VSS VDD VDD _02068_ sky130_fd_sc_hd__o21ai_0
X_12457_ network.in_period\[1\]\[0\] _08614_ VSS VSS VDD VDD
+ _08616_ sky130_fd_sc_hd__nand2_1
X_12458_ network.neuron_in001.counter\[0\] _08614_ _08616_
+ VSS VSS VDD VDD _02067_ sky130_fd_sc_hd__o21ai_0
X_12459_ network.neuron_in002.counter\[3\] network.in_period\[2\]\[2\]
+ _00785_ net423 VSS VSS VDD VDD _08617_ sky130_fd_sc_hd__o22ai_1
Xclkbuf_leaf_16_clk_net clknet_4_2__leaf_clk_net VSS VSS VDD
+ VDD clknet_leaf_16_clk_net sky130_fd_sc_hd__clkbuf_16
Xclkbuf_leaf_15_clk_net clknet_4_2__leaf_clk_net VSS VSS VDD
+ VDD clknet_leaf_15_clk_net sky130_fd_sc_hd__clkbuf_16
X_12462_ network.neuron_in002.counter\[2\] _00785_ net343
+ VSS VSS VDD VDD _08620_ sky130_fd_sc_hd__nand3_1
X_12463_ network.in_period\[2\]\[2\] net343 _08620_ VSS VSS
+ VDD VDD _08621_ sky130_fd_sc_hd__o21ai_0
X_12464_ _08602_ _08617_ _08621_ VSS VSS VDD VDD _02073_ sky130_fd_sc_hd__a21oi_1
X_12465_ network.neuron_in002.counter\[0\] VSS VSS VDD VDD
+ _00783_ sky130_fd_sc_hd__inv_1
X_12466_ network.in_period\[2\]\[0\] _08605_ VSS VSS VDD VDD
+ _08622_ sky130_fd_sc_hd__nand2_1
X_12467_ network.neuron_in002.counter\[0\] _08605_ _08622_
+ VSS VSS VDD VDD _02071_ sky130_fd_sc_hd__o21ai_0
X_12468_ network.neuron_in003.counter\[2\] VSS VSS VDD VDD
+ _08623_ sky130_fd_sc_hd__inv_1
Xclkbuf_leaf_14_clk_net clknet_4_2__leaf_clk_net VSS VSS VDD
+ VDD clknet_leaf_14_clk_net sky130_fd_sc_hd__clkbuf_16
X_12470_ network.in_period\[3\]\[2\] network.neuron_in003.counter\[3\]
+ _00678_ net422 VSS VSS VDD VDD _08625_ sky130_fd_sc_hd__o22ai_1
X_12471_ network.neuron_in003.counter\[2\] _00678_ net343
+ VSS VSS VDD VDD _08626_ sky130_fd_sc_hd__nand3_1
X_12472_ network.in_period\[3\]\[2\] net343 _08626_ VSS VSS
+ VDD VDD _08627_ sky130_fd_sc_hd__o21ai_0
X_12473_ _08623_ _08625_ _08627_ VSS VSS VDD VDD _02077_ sky130_fd_sc_hd__a21oi_1
X_12474_ network.neuron_in004.counter\[2\] VSS VSS VDD VDD
+ _08628_ sky130_fd_sc_hd__inv_1
X_12475_ _08628_ _00666_ VSS VSS VDD VDD _08629_ sky130_fd_sc_hd__nand2_1
X_12476_ network.neuron_in004.counter\[3\] _08629_ VSS VSS
+ VDD VDD _08630_ sky130_fd_sc_hd__or2_2
X_12477_ net341 _08630_ VSS VSS VDD VDD _08631_ sky130_fd_sc_hd__nand2_1
X_12478_ network.in_period\[4\]\[1\] _08631_ VSS VSS VDD VDD
+ _08632_ sky130_fd_sc_hd__nand2_1
X_12479_ _00667_ _08631_ _08632_ VSS VSS VDD VDD _02080_ sky130_fd_sc_hd__o21ai_0
X_12480_ network.neuron_in005.counter\[2\] VSS VSS VDD VDD
+ _08633_ sky130_fd_sc_hd__inv_1
X_12481_ network.neuron_in005.counter\[3\] network.in_period\[5\]\[2\]
+ _00662_ net422 VSS VSS VDD VDD _08634_ sky130_fd_sc_hd__o22ai_1
X_12482_ network.neuron_in005.counter\[2\] _00662_ net341
+ VSS VSS VDD VDD _08635_ sky130_fd_sc_hd__nand3_1
X_12483_ network.in_period\[5\]\[2\] net341 _08635_ VSS VSS
+ VDD VDD _08636_ sky130_fd_sc_hd__o21ai_0
X_12484_ _08633_ _08634_ _08636_ VSS VSS VDD VDD _02085_ sky130_fd_sc_hd__a21oi_1
X_12485_ network.neuron_in006.counter\[0\] VSS VSS VDD VDD
+ _00738_ sky130_fd_sc_hd__inv_1
X_12486_ network.neuron_in006.counter\[2\] network.neuron_in006.counter\[3\]
+ VSS VSS VDD VDD _08637_ sky130_fd_sc_hd__nor2_1
X_12487_ _00740_ _08637_ VSS VSS VDD VDD _08638_ sky130_fd_sc_hd__nand2_1
X_12488_ net341 _08638_ VSS VSS VDD VDD _08639_ sky130_fd_sc_hd__nand2_1
X_12489_ network.in_period\[6\]\[0\] _08639_ VSS VSS VDD VDD
+ _08640_ sky130_fd_sc_hd__nand2_1
X_12490_ network.neuron_in006.counter\[0\] _08639_ _08640_
+ VSS VSS VDD VDD _02087_ sky130_fd_sc_hd__o21ai_0
X_12491_ network.neuron_in003.counter\[0\] VSS VSS VDD VDD
+ _00676_ sky130_fd_sc_hd__inv_1
X_12492_ network.in_period\[3\]\[0\] _08591_ VSS VSS VDD VDD
+ _08641_ sky130_fd_sc_hd__nand2_1
X_12493_ network.neuron_in003.counter\[0\] _08591_ _08641_
+ VSS VSS VDD VDD _02075_ sky130_fd_sc_hd__o21ai_0
X_12494_ network.neuron_in004.counter\[3\] network.in_period\[4\]\[2\]
+ _00666_ net422 VSS VSS VDD VDD _08642_ sky130_fd_sc_hd__o22ai_1
Xclkbuf_leaf_13_clk_net clknet_4_2__leaf_clk_net VSS VSS VDD
+ VDD clknet_leaf_13_clk_net sky130_fd_sc_hd__clkbuf_16
X_12496_ network.neuron_in004.counter\[2\] _00666_ net341
+ VSS VSS VDD VDD _08644_ sky130_fd_sc_hd__nand3_1
X_12497_ network.in_period\[4\]\[2\] net341 _08644_ VSS VSS
+ VDD VDD _08645_ sky130_fd_sc_hd__o21ai_0
X_12498_ _08628_ _08642_ _08645_ VSS VSS VDD VDD _02081_ sky130_fd_sc_hd__a21oi_1
X_12499_ network.neuron_in004.counter\[0\] VSS VSS VDD VDD
+ _00664_ sky130_fd_sc_hd__inv_1
X_12500_ network.in_period\[4\]\[0\] _08631_ VSS VSS VDD VDD
+ _08646_ sky130_fd_sc_hd__nand2_1
X_12501_ network.neuron_in004.counter\[0\] _08631_ _08646_
+ VSS VSS VDD VDD _02079_ sky130_fd_sc_hd__o21ai_0
X_12502_ network.neuron_in005.counter\[3\] _00662_ VSS VSS
+ VDD VDD _08647_ sky130_fd_sc_hd__nand2b_1
X_12503_ _08647_ _08633_ VSS VSS VDD VDD _08648_ sky130_fd_sc_hd__nand2b_1
X_12504_ net341 _08648_ VSS VSS VDD VDD _08649_ sky130_fd_sc_hd__nand2_1
X_12505_ network.in_period\[5\]\[1\] _08649_ VSS VSS VDD VDD
+ _08650_ sky130_fd_sc_hd__nand2_1
X_12506_ _00663_ _08649_ _08650_ VSS VSS VDD VDD _02084_ sky130_fd_sc_hd__o21ai_0
X_12507_ network.neuron_in005.counter\[0\] VSS VSS VDD VDD
+ _00660_ sky130_fd_sc_hd__inv_1
X_12508_ network.in_period\[5\]\[0\] _08649_ VSS VSS VDD VDD
+ _08651_ sky130_fd_sc_hd__nand2_1
X_12509_ network.neuron_in005.counter\[0\] _08649_ _08651_
+ VSS VSS VDD VDD _02083_ sky130_fd_sc_hd__o21ai_0
X_12510_ network.neuron_in006.counter\[2\] net342 VSS VSS
+ VDD VDD _08652_ sky130_fd_sc_hd__nand2_1
X_12511_ network.neuron_in006.counter\[3\] network.in_period\[6\]\[2\]
+ _08652_ VSS VSS VDD VDD _08653_ sky130_fd_sc_hd__o21ai_0
Xclkbuf_leaf_12_clk_net clknet_4_2__leaf_clk_net VSS VSS VDD
+ VDD clknet_leaf_12_clk_net sky130_fd_sc_hd__clkbuf_16
Xclkbuf_leaf_11_clk_net clknet_4_8__leaf_clk_net VSS VSS VDD
+ VDD clknet_leaf_11_clk_net sky130_fd_sc_hd__clkbuf_16
X_12514_ _00740_ network.neuron_in006.counter\[2\] net423
+ VSS VSS VDD VDD _08656_ sky130_fd_sc_hd__or3_1
X_12515_ network.in_period\[6\]\[2\] net342 _08656_ VSS VSS
+ VDD VDD _08657_ sky130_fd_sc_hd__o21ai_0
X_12516_ _00740_ _08653_ _08657_ VSS VSS VDD VDD _02089_ sky130_fd_sc_hd__a21oi_1
X_12517_ network.in_period\[6\]\[1\] _08639_ VSS VSS VDD VDD
+ _08658_ sky130_fd_sc_hd__nand2_1
X_12518_ _00741_ _08639_ _08658_ VSS VSS VDD VDD _02088_ sky130_fd_sc_hd__o21ai_0
X_12519_ network.neuron_in157.counter\[1\] VSS VSS VDD VDD
+ _00735_ sky130_fd_sc_hd__inv_1
X_12520_ network.neuron_in099.counter\[1\] VSS VSS VDD VDD
+ _00747_ sky130_fd_sc_hd__inv_1
X_12521_ network.neuron_in002.counter\[1\] VSS VSS VDD VDD
+ _00784_ sky130_fd_sc_hd__inv_1
X_12522_ network.neuron_in007.counter\[2\] VSS VSS VDD VDD
+ _08659_ sky130_fd_sc_hd__inv_1
X_12523_ network.neuron_in007.counter\[3\] network.in_period\[7\]\[2\]
+ net424 _00601_ VSS VSS VDD VDD _08660_ sky130_fd_sc_hd__o22ai_1
X_12524_ network.neuron_in007.counter\[2\] _00601_ net340
+ VSS VSS VDD VDD _08661_ sky130_fd_sc_hd__nand3_1
X_12525_ network.in_period\[7\]\[2\] net340 _08661_ VSS VSS
+ VDD VDD _08662_ sky130_fd_sc_hd__o21ai_0
X_12526_ _08659_ _08660_ _08662_ VSS VSS VDD VDD _02093_ sky130_fd_sc_hd__a21oi_1
Xclkbuf_leaf_10_clk_net clknet_4_2__leaf_clk_net VSS VSS VDD
+ VDD clknet_leaf_10_clk_net sky130_fd_sc_hd__clkbuf_16
X_12528_ _08659_ _00601_ VSS VSS VDD VDD _08664_ sky130_fd_sc_hd__nand2_1
X_12529_ network.neuron_in007.counter\[3\] _08664_ VSS VSS
+ VDD VDD _08665_ sky130_fd_sc_hd__or2_2
X_12530_ net340 _08665_ VSS VSS VDD VDD _08666_ sky130_fd_sc_hd__nand2_1
X_12531_ network.in_period\[7\]\[1\] _08666_ VSS VSS VDD VDD
+ _08667_ sky130_fd_sc_hd__nand2_1
X_12532_ _00602_ _08666_ _08667_ VSS VSS VDD VDD _02092_ sky130_fd_sc_hd__o21ai_0
X_12533_ network.in_period\[7\]\[0\] _08666_ VSS VSS VDD VDD
+ _08668_ sky130_fd_sc_hd__nand2_1
X_12534_ network.neuron_in007.counter\[0\] _08666_ _08668_
+ VSS VSS VDD VDD _02091_ sky130_fd_sc_hd__o21ai_0
X_12535_ network.neuron_in008.counter\[0\] VSS VSS VDD VDD
+ _00547_ sky130_fd_sc_hd__inv_1
X_12536_ network.neuron_in008.counter\[2\] VSS VSS VDD VDD
+ _08669_ sky130_fd_sc_hd__inv_1
X_12537_ _08669_ _00549_ VSS VSS VDD VDD _08670_ sky130_fd_sc_hd__nand2_1
X_12538_ network.neuron_in008.counter\[3\] _08670_ VSS VSS
+ VDD VDD _08671_ sky130_fd_sc_hd__or2_2
X_12539_ net340 _08671_ VSS VSS VDD VDD _08672_ sky130_fd_sc_hd__nand2_1
X_12540_ network.in_period\[8\]\[0\] _08672_ VSS VSS VDD VDD
+ _08673_ sky130_fd_sc_hd__nand2_1
X_12541_ network.neuron_in008.counter\[0\] _08672_ _08673_
+ VSS VSS VDD VDD _02095_ sky130_fd_sc_hd__o21ai_0
X_12542_ loaded\[0\] VSS VSS VDD VDD _00843_ sky130_fd_sc_hd__inv_1
X_12543_ network.in_period\[8\]\[2\] network.neuron_in008.counter\[3\]
+ _00549_ net424 VSS VSS VDD VDD _08674_ sky130_fd_sc_hd__o22ai_1
X_12544_ network.neuron_in008.counter\[2\] _00549_ net340
+ VSS VSS VDD VDD _08675_ sky130_fd_sc_hd__nand3_1
X_12545_ network.in_period\[8\]\[2\] net340 _08675_ VSS VSS
+ VDD VDD _08676_ sky130_fd_sc_hd__o21ai_0
X_12546_ _08669_ _08674_ _08676_ VSS VSS VDD VDD _02097_ sky130_fd_sc_hd__a21oi_1
X_12547_ network.neuron_out0.IF0.membrane_potential\[2\] network.neuron_out0.IF0.membrane_potential\[3\]
+ network.neuron_out0.IF0.membrane_potential\[1\] network.neuron_out0.IF0.membrane_potential\[0\]
+ VSS VSS VDD VDD _08677_ sky130_fd_sc_hd__nor4_1
X_12548_ network.neuron_out0.IF0.membrane_potential\[6\] network.neuron_out0.IF0.membrane_potential\[5\]
+ network.neuron_out0.IF0.membrane_potential\[4\] VSS VSS VDD
+ VDD _08678_ sky130_fd_sc_hd__nand3_1
X_12549_ network.neuron_out0.IF0.membrane_potential\[8\] network.neuron_out0.IF0.membrane_potential\[7\]
+ network.neuron_out0.IF0.membrane_potential\[9\] network.neuron_out0.IF0.membrane_potential\[10\]
+ VSS VSS VDD VDD _08679_ sky130_fd_sc_hd__nor4_1
X_12550_ _08677_ _08678_ _08679_ VSS VSS VDD VDD _08680_ sky130_fd_sc_hd__o21ai_0
X_12551_ network.neuron_out3.IF0.membrane_potential\[0\] network.neuron_out3.IF0.membrane_potential\[3\]
+ network.neuron_out3.IF0.membrane_potential\[2\] network.neuron_out3.IF0.membrane_potential\[1\]
+ VSS VSS VDD VDD _08681_ sky130_fd_sc_hd__nor4_1
X_12552_ network.neuron_out3.IF0.membrane_potential\[6\] network.neuron_out3.IF0.membrane_potential\[5\]
+ network.neuron_out3.IF0.membrane_potential\[4\] VSS VSS VDD
+ VDD _08682_ sky130_fd_sc_hd__nand3_1
X_12553_ network.neuron_out3.IF0.membrane_potential\[7\] network.neuron_out3.IF0.membrane_potential\[8\]
+ network.neuron_out3.IF0.membrane_potential\[9\] network.neuron_out3.IF0.membrane_potential\[10\]
+ VSS VSS VDD VDD _08683_ sky130_fd_sc_hd__nor4_1
X_12554_ _08681_ _08682_ _08683_ VSS VSS VDD VDD _08684_ sky130_fd_sc_hd__o21ai_0
X_12555_ network.neuron_out2.IF0.membrane_potential\[0\] network.neuron_out2.IF0.membrane_potential\[2\]
+ network.neuron_out2.IF0.membrane_potential\[3\] network.neuron_out2.IF0.membrane_potential\[1\]
+ VSS VSS VDD VDD _08685_ sky130_fd_sc_hd__nor4_1
X_12556_ network.neuron_out2.IF0.membrane_potential\[5\] network.neuron_out2.IF0.membrane_potential\[6\]
+ network.neuron_out2.IF0.membrane_potential\[4\] VSS VSS VDD
+ VDD _08686_ sky130_fd_sc_hd__nand3_1
X_12557_ network.neuron_out2.IF0.membrane_potential\[8\] network.neuron_out2.IF0.membrane_potential\[9\]
+ network.neuron_out2.IF0.membrane_potential\[7\] network.neuron_out2.IF0.membrane_potential\[10\]
+ VSS VSS VDD VDD _08687_ sky130_fd_sc_hd__nor4_1
X_12558_ _08685_ _08686_ _08687_ VSS VSS VDD VDD _08688_ sky130_fd_sc_hd__o21ai_0
X_12559_ _08684_ _08688_ VSS VSS VDD VDD _08689_ sky130_fd_sc_hd__nor2_1
X_12560_ network.neuron_out4.IF0.membrane_potential\[2\] network.neuron_out4.IF0.membrane_potential\[0\]
+ network.neuron_out4.IF0.membrane_potential\[1\] network.neuron_out4.IF0.membrane_potential\[3\]
+ VSS VSS VDD VDD _08690_ sky130_fd_sc_hd__nor4_1
X_12561_ network.neuron_out4.IF0.membrane_potential\[6\] network.neuron_out4.IF0.membrane_potential\[5\]
+ network.neuron_out4.IF0.membrane_potential\[4\] VSS VSS VDD
+ VDD _08691_ sky130_fd_sc_hd__nand3_1
X_12562_ network.neuron_out4.IF0.membrane_potential\[7\] network.neuron_out4.IF0.membrane_potential\[9\]
+ network.neuron_out4.IF0.membrane_potential\[10\] network.neuron_out4.IF0.membrane_potential\[8\]
+ VSS VSS VDD VDD _08692_ sky130_fd_sc_hd__nor4_1
X_12563_ _08690_ _08691_ _08692_ VSS VSS VDD VDD _08693_ sky130_fd_sc_hd__o21ai_0
X_12564_ network.neuron_out5.IF0.membrane_potential\[1\] network.neuron_out5.IF0.membrane_potential\[2\]
+ network.neuron_out5.IF0.membrane_potential\[3\] network.neuron_out5.IF0.membrane_potential\[0\]
+ VSS VSS VDD VDD _08694_ sky130_fd_sc_hd__nor4_1
X_12565_ network.neuron_out5.IF0.membrane_potential\[6\] network.neuron_out5.IF0.membrane_potential\[5\]
+ network.neuron_out5.IF0.membrane_potential\[4\] VSS VSS VDD
+ VDD _08695_ sky130_fd_sc_hd__nand3_1
X_12566_ network.neuron_out5.IF0.membrane_potential\[8\] network.neuron_out5.IF0.membrane_potential\[7\]
+ network.neuron_out5.IF0.membrane_potential\[9\] network.neuron_out5.IF0.membrane_potential\[10\]
+ VSS VSS VDD VDD _08696_ sky130_fd_sc_hd__nor4_1
X_12567_ _08694_ _08695_ _08696_ VSS VSS VDD VDD _08697_ sky130_fd_sc_hd__o21ai_0
X_12568_ net333 _08697_ VSS VSS VDD VDD _08698_ sky130_fd_sc_hd__nand2b_1
X_12569_ network.neuron_out1.IF0.membrane_potential\[1\] network.neuron_out1.IF0.membrane_potential\[2\]
+ network.neuron_out1.IF0.membrane_potential\[3\] network.neuron_out1.IF0.membrane_potential\[0\]
+ VSS VSS VDD VDD _08699_ sky130_fd_sc_hd__nor4_1
X_12570_ network.neuron_out1.IF0.membrane_potential\[6\] network.neuron_out1.IF0.membrane_potential\[5\]
+ network.neuron_out1.IF0.membrane_potential\[4\] VSS VSS VDD
+ VDD _08700_ sky130_fd_sc_hd__nand3_1
X_12571_ network.neuron_out1.IF0.membrane_potential\[7\] network.neuron_out1.IF0.membrane_potential\[9\]
+ network.neuron_out1.IF0.membrane_potential\[8\] network.neuron_out1.IF0.membrane_potential\[10\]
+ VSS VSS VDD VDD _08701_ sky130_fd_sc_hd__nor4_1
X_12572_ _08699_ _08700_ _08701_ VSS VSS VDD VDD _08702_ sky130_fd_sc_hd__o21ai_0
X_12573_ _08689_ _08698_ net332 VSS VSS VDD VDD _08703_ sky130_fd_sc_hd__a21oi_1
X_12574_ _08680_ net332 VSS VSS VDD VDD _08704_ sky130_fd_sc_hd__nor2_1
X_12575_ network.arbit.counter\[3\] network.arbit.counter\[2\]
+ _01026_ VSS VSS VDD VDD _08705_ sky130_fd_sc_hd__nor3b_1
X_12576_ net333 _08697_ _08705_ VSS VSS VDD VDD _08706_ sky130_fd_sc_hd__nor3_1
X_12577_ _08689_ _08704_ _08706_ _06659_ VSS VSS VDD VDD _08707_
+ sky130_fd_sc_hd__a31oi_1
X_12578_ _08680_ _08703_ _08707_ VSS VSS VDD VDD _08708_ sky130_fd_sc_hd__o21ai_0
X_12579_ net46 _08707_ VSS VSS VDD VDD _08709_ sky130_fd_sc_hd__or2_2
Xclkbuf_leaf_9_clk_net clknet_4_2__leaf_clk_net VSS VSS VDD
+ VDD clknet_leaf_9_clk_net sky130_fd_sc_hd__clkbuf_16
X_12581_ _08708_ _08709_ net455 VSS VSS VDD VDD _01549_ sky130_fd_sc_hd__a21o_1
X_12582_ net35 _00183_ VSS VSS VDD VDD _08711_ sky130_fd_sc_hd__nand2_1
X_12583_ _06659_ _08711_ VSS VSS VDD VDD _08712_ sky130_fd_sc_hd__nor2_1
X_12584_ net36 net37 net38 VSS VSS VDD VDD _08713_ sky130_fd_sc_hd__and3_1
X_12585_ net39 net40 _08713_ VSS VSS VDD VDD _08714_ sky130_fd_sc_hd__and3_1
Xclkbuf_leaf_8_clk_net clknet_4_2__leaf_clk_net VSS VSS VDD
+ VDD clknet_leaf_8_clk_net sky130_fd_sc_hd__clkbuf_16
X_12587_ net41 net42 net28 _08714_ VSS VSS VDD VDD _08716_
+ sky130_fd_sc_hd__and4_1
X_12588_ net29 _08716_ VSS VSS VDD VDD _08717_ sky130_fd_sc_hd__and2_1
X_12589_ net30 net31 _08717_ VSS VSS VDD VDD _08718_ sky130_fd_sc_hd__and3_1
X_12590_ _08712_ _08718_ VSS VSS VDD VDD _08719_ sky130_fd_sc_hd__nand2_1
Xclkbuf_leaf_7_clk_net clknet_4_2__leaf_clk_net VSS VSS VDD
+ VDD clknet_leaf_7_clk_net sky130_fd_sc_hd__clkbuf_16
X_12592_ loaded\[2\] loaded\[3\] VSS VSS VDD VDD _08721_ sky130_fd_sc_hd__nor2_1
X_12593_ _00845_ _08721_ VSS VSS VDD VDD _08722_ sky130_fd_sc_hd__nand2_2
Xclkbuf_leaf_6_clk_net clknet_4_2__leaf_clk_net VSS VSS VDD
+ VDD clknet_leaf_6_clk_net sky130_fd_sc_hd__clkbuf_16
Xclkbuf_leaf_5_clk_net clknet_4_2__leaf_clk_net VSS VSS VDD
+ VDD clknet_leaf_5_clk_net sky130_fd_sc_hd__clkbuf_16
X_12596_ net454 net453 VSS VSS VDD VDD _08725_ sky130_fd_sc_hd__nor2_1
X_12597_ loaded\[4\] _08725_ loaded\[8\] VSS VSS VDD VDD _08726_
+ sky130_fd_sc_hd__nand3b_1
X_12598_ loaded\[5\] _08722_ _08726_ VSS VSS VDD VDD net43
+ sky130_fd_sc_hd__nor3_1
X_12599_ _06672_ _06658_ net24 net43 VSS VSS VDD VDD _08727_
+ sky130_fd_sc_hd__nand4_1
X_12600_ net32 _08719_ _08727_ VSS VSS VDD VDD _08728_ sky130_fd_sc_hd__nand3_1
X_12601_ net32 _08719_ VSS VSS VDD VDD _08729_ sky130_fd_sc_hd__or2_2
Xclkbuf_leaf_4_clk_net clknet_4_2__leaf_clk_net VSS VSS VDD
+ VDD clknet_leaf_4_clk_net sky130_fd_sc_hd__clkbuf_16
X_12603_ _08728_ _08729_ net455 VSS VSS VDD VDD _01550_ sky130_fd_sc_hd__a21oi_1
X_12604_ net30 _08717_ VSS VSS VDD VDD _08731_ sky130_fd_sc_hd__nand2_1
X_12605_ net27 net34 net35 VSS VSS VDD VDD _08732_ sky130_fd_sc_hd__nand3_1
X_12606_ _06672_ state\[0\] VSS VSS VDD VDD _08733_ sky130_fd_sc_hd__nor2_1
Xclkbuf_leaf_3_clk_net clknet_4_0__leaf_clk_net VSS VSS VDD
+ VDD clknet_leaf_3_clk_net sky130_fd_sc_hd__clkbuf_16
X_12608_ _08731_ _08732_ _08733_ VSS VSS VDD VDD _08735_ sky130_fd_sc_hd__o21ai_0
X_12609_ net24 net43 VSS VSS VDD VDD _08736_ sky130_fd_sc_hd__nand2_1
X_12610_ _06672_ _08736_ state\[0\] VSS VSS VDD VDD _08737_
+ sky130_fd_sc_hd__a21oi_1
Xclkbuf_leaf_2_clk_net clknet_4_0__leaf_clk_net VSS VSS VDD
+ VDD clknet_leaf_2_clk_net sky130_fd_sc_hd__clkbuf_16
X_12612_ _06659_ _08732_ VSS VSS VDD VDD _08739_ sky130_fd_sc_hd__nor2_1
X_12613_ net30 _08717_ _08739_ net31 VSS VSS VDD VDD _08740_
+ sky130_fd_sc_hd__a31oi_1
X_12614_ net31 _08735_ _08737_ _08740_ net455 VSS VSS VDD
+ VDD _01551_ sky130_fd_sc_hd__a311oi_1
X_12615_ net29 _08716_ VSS VSS VDD VDD _08741_ sky130_fd_sc_hd__nand2_1
X_12616_ _08711_ _08741_ _08733_ VSS VSS VDD VDD _08742_ sky130_fd_sc_hd__o21ai_0
X_12617_ _08712_ _08717_ net30 VSS VSS VDD VDD _08743_ sky130_fd_sc_hd__a21oi_1
X_12618_ net30 _08737_ _08742_ _08743_ net455 VSS VSS VDD
+ VDD _01552_ sky130_fd_sc_hd__a311oi_1
X_12619_ _08716_ _08739_ VSS VSS VDD VDD _08744_ sky130_fd_sc_hd__nand2_1
X_12620_ net29 _08727_ _08744_ VSS VSS VDD VDD _08745_ sky130_fd_sc_hd__nand3_1
X_12621_ net29 _08744_ VSS VSS VDD VDD _08746_ sky130_fd_sc_hd__or2_2
X_12622_ _08745_ _08746_ net455 VSS VSS VDD VDD _01553_ sky130_fd_sc_hd__a21oi_1
X_12623_ net41 net42 _08714_ VSS VSS VDD VDD _08747_ sky130_fd_sc_hd__nand3_1
X_12624_ _08711_ _08747_ _08733_ VSS VSS VDD VDD _08748_ sky130_fd_sc_hd__o21ai_0
X_12625_ net41 net42 _08712_ _08714_ net28 VSS VSS VDD VDD
+ _08749_ sky130_fd_sc_hd__a41oi_1
X_12626_ net28 _08737_ _08748_ _08749_ net455 VSS VSS VDD
+ VDD _01554_ sky130_fd_sc_hd__a311oi_1
X_12627_ net41 _08714_ VSS VSS VDD VDD _08750_ sky130_fd_sc_hd__nand2_1
X_12628_ _08750_ _08732_ _08733_ VSS VSS VDD VDD _08751_ sky130_fd_sc_hd__o21ai_0
X_12629_ net41 _08714_ _08739_ net42 VSS VSS VDD VDD _08752_
+ sky130_fd_sc_hd__a31oi_1
X_12630_ net42 _08737_ _08751_ _08752_ net455 VSS VSS VDD
+ VDD _01555_ sky130_fd_sc_hd__a311oi_1
X_12631_ net35 _00183_ _08714_ VSS VSS VDD VDD _08753_ sky130_fd_sc_hd__nand3_1
X_12632_ _08733_ _08753_ VSS VSS VDD VDD _08754_ sky130_fd_sc_hd__nand2_1
X_12633_ _08712_ _08714_ net41 VSS VSS VDD VDD _08755_ sky130_fd_sc_hd__a21oi_1
X_12634_ net41 _08737_ _08754_ _08755_ net455 VSS VSS VDD
+ VDD _01556_ sky130_fd_sc_hd__a311oi_1
X_12635_ net39 _08713_ VSS VSS VDD VDD _08756_ sky130_fd_sc_hd__nand2_1
X_12636_ _08756_ _08732_ _08733_ VSS VSS VDD VDD _08757_ sky130_fd_sc_hd__o21ai_0
X_12637_ _06659_ _08756_ _08732_ VSS VSS VDD VDD _08758_ sky130_fd_sc_hd__nor3_1
X_12638_ net40 _08758_ VSS VSS VDD VDD _08759_ sky130_fd_sc_hd__nor2_1
X_12639_ net40 _08737_ _08757_ _08759_ net455 VSS VSS VDD
+ VDD _01557_ sky130_fd_sc_hd__a311oi_1
X_12640_ net35 _00183_ _08713_ VSS VSS VDD VDD _08760_ sky130_fd_sc_hd__nand3_1
X_12641_ _08733_ _08760_ VSS VSS VDD VDD _08761_ sky130_fd_sc_hd__nand2_1
X_12642_ _08712_ _08713_ net39 VSS VSS VDD VDD _08762_ sky130_fd_sc_hd__a21oi_1
X_12643_ net39 _08737_ _08761_ _08762_ net455 VSS VSS VDD
+ VDD _01558_ sky130_fd_sc_hd__a311oi_1
X_12644_ net36 net37 VSS VSS VDD VDD _08763_ sky130_fd_sc_hd__nand2_1
X_12645_ _08763_ _08732_ _08733_ VSS VSS VDD VDD _08764_ sky130_fd_sc_hd__o21ai_0
X_12646_ net36 net37 _08739_ net38 VSS VSS VDD VDD _08765_
+ sky130_fd_sc_hd__a31oi_1
X_12647_ net38 _08737_ _08764_ _08765_ net455 VSS VSS VDD
+ VDD _01559_ sky130_fd_sc_hd__a311oi_1
X_12648_ _06672_ _08736_ state\[0\] VSS VSS VDD VDD _08766_
+ sky130_fd_sc_hd__a21o_1
X_12649_ net35 net36 _00183_ _06659_ VSS VSS VDD VDD _08767_
+ sky130_fd_sc_hd__a31oi_1
X_12650_ _08766_ _08767_ net37 VSS VSS VDD VDD _08768_ sky130_fd_sc_hd__o21ai_0
X_12651_ net37 _08712_ net36 VSS VSS VDD VDD _08769_ sky130_fd_sc_hd__nand3b_1
X_12652_ _08768_ _08769_ net455 VSS VSS VDD VDD _01560_ sky130_fd_sc_hd__a21oi_1
X_12653_ _08733_ _08732_ VSS VSS VDD VDD _08770_ sky130_fd_sc_hd__nand2_1
X_12654_ net36 _08739_ VSS VSS VDD VDD _08771_ sky130_fd_sc_hd__nor2_1
X_12655_ net36 _08737_ _08770_ _08771_ net455 VSS VSS VDD
+ VDD _01561_ sky130_fd_sc_hd__a311oi_1
X_12656_ _00183_ _06659_ _08737_ VSS VSS VDD VDD _08772_ sky130_fd_sc_hd__o21ai_0
X_12657_ _00183_ _08733_ VSS VSS VDD VDD _08773_ sky130_fd_sc_hd__nand2_1
X_12658_ net35 _08773_ VSS VSS VDD VDD _08774_ sky130_fd_sc_hd__nor2_1
X_12659_ net35 _08772_ _08774_ VSS VSS VDD VDD _08775_ sky130_fd_sc_hd__a21oi_1
X_12660_ net455 _08775_ VSS VSS VDD VDD _01562_ sky130_fd_sc_hd__nor2_1
X_12661_ _00184_ _08733_ _08766_ net34 VSS VSS VDD VDD _08776_
+ sky130_fd_sc_hd__a22oi_1
X_12662_ net455 _08776_ VSS VSS VDD VDD _01563_ sky130_fd_sc_hd__nor2_1
X_12663_ net27 _08733_ VSS VSS VDD VDD _08777_ sky130_fd_sc_hd__nor2_1
X_12664_ net27 _08737_ _08777_ net455 VSS VSS VDD VDD _01564_
+ sky130_fd_sc_hd__a211oi_1
X_12665_ _06658_ _08689_ _08704_ _08706_ _06672_ VSS VSS VDD
+ VDD _08778_ sky130_fd_sc_hd__a41oi_1
X_12666_ net455 _08778_ VSS VSS VDD VDD _08779_ sky130_fd_sc_hd__or2_2
Xclkbuf_leaf_1_clk_net clknet_4_0__leaf_clk_net VSS VSS VDD
+ VDD clknet_leaf_1_clk_net sky130_fd_sc_hd__clkbuf_16
X_12668_ loaded\[4\] loaded\[5\] net454 VSS VSS VDD VDD _08781_
+ sky130_fd_sc_hd__nand3_1
X_12669_ state\[1\] state\[0\] net455 VSS VSS VDD VDD icg_net.en
+ sky130_fd_sc_hd__or3_1
X_12670_ loaded\[8\] icg_net.en VSS VSS VDD VDD net44 sky130_fd_sc_hd__nor2_1
X_12671_ net22 net44 VSS VSS VDD VDD _08782_ sky130_fd_sc_hd__nand2_1
X_12672_ _08782_ VSS VSS VDD VDD icg_load.en sky130_fd_sc_hd__inv_1
X_12673_ _08778_ icg_load.en VSS VSS VDD VDD _08783_ sky130_fd_sc_hd__nor2_1
X_12674_ loaded\[2\] loaded\[3\] VSS VSS VDD VDD _08784_ sky130_fd_sc_hd__and2_0
Xclkbuf_leaf_0_clk_net clknet_4_0__leaf_clk_net VSS VSS VDD
+ VDD clknet_leaf_0_clk_net sky130_fd_sc_hd__clkbuf_16
X_12676_ loaded\[0\] loaded\[1\] _08784_ VSS VSS VDD VDD _08786_
+ sky130_fd_sc_hd__nand3_1
X_12677_ _08781_ _08783_ _08786_ VSS VSS VDD VDD _08787_ sky130_fd_sc_hd__nor3_1
X_12678_ net453 _08787_ VSS VSS VDD VDD _08788_ sky130_fd_sc_hd__xnor2_1
X_12679_ _08779_ _08788_ VSS VSS VDD VDD _01565_ sky130_fd_sc_hd__nor2_1
X_12680_ loaded\[4\] loaded\[5\] VSS VSS VDD VDD _08789_ sky130_fd_sc_hd__nand2_1
X_12681_ _00849_ _08784_ VSS VSS VDD VDD _08790_ sky130_fd_sc_hd__nand2_4
X_12682_ _08789_ _08783_ _08790_ VSS VSS VDD VDD _08791_ sky130_fd_sc_hd__nor3_1
X_12683_ net454 _08791_ VSS VSS VDD VDD _08792_ sky130_fd_sc_hd__xnor2_1
X_12684_ _08779_ _08792_ VSS VSS VDD VDD _01566_ sky130_fd_sc_hd__nor2_1
X_12685_ _08783_ _08786_ loaded\[4\] VSS VSS VDD VDD _08793_
+ sky130_fd_sc_hd__nor3b_1
X_12686_ loaded\[5\] _08793_ VSS VSS VDD VDD _08794_ sky130_fd_sc_hd__xnor2_1
X_12687_ _08779_ _08794_ VSS VSS VDD VDD _01567_ sky130_fd_sc_hd__nor2_1
X_12688_ _08783_ _08790_ loaded\[4\] VSS VSS VDD VDD _08795_
+ sky130_fd_sc_hd__o21ai_0
X_12689_ loaded\[4\] _08783_ _08790_ VSS VSS VDD VDD _08796_
+ sky130_fd_sc_hd__or3_1
X_12690_ _08795_ _08796_ _08779_ VSS VSS VDD VDD _01568_ sky130_fd_sc_hd__a21oi_1
X_12691_ loaded\[0\] loaded\[1\] loaded\[2\] VSS VSS VDD VDD
+ _08797_ sky130_fd_sc_hd__nand3_1
X_12692_ _08783_ _08797_ loaded\[3\] VSS VSS VDD VDD _08798_
+ sky130_fd_sc_hd__o21ai_0
X_12693_ loaded\[3\] _08783_ _08797_ VSS VSS VDD VDD _08799_
+ sky130_fd_sc_hd__or3_1
X_12694_ _08798_ _08799_ _08779_ VSS VSS VDD VDD _01569_ sky130_fd_sc_hd__a21oi_1
X_12695_ _08778_ icg_load.en _00849_ VSS VSS VDD VDD _08800_
+ sky130_fd_sc_hd__o21ai_0
X_12696_ loaded\[2\] _08800_ VSS VSS VDD VDD _08801_ sky130_fd_sc_hd__xor2_1
X_12697_ _08779_ _08801_ VSS VSS VDD VDD _01570_ sky130_fd_sc_hd__nor2_1
X_12698_ state\[1\] _08782_ state\[0\] _00846_ VSS VSS VDD
+ VDD _08802_ sky130_fd_sc_hd__nor4b_1
X_12699_ loaded\[1\] _08783_ _08802_ VSS VSS VDD VDD _08803_
+ sky130_fd_sc_hd__a21oi_1
X_12700_ net455 _08803_ VSS VSS VDD VDD _01571_ sky130_fd_sc_hd__nor2_1
X_12701_ state\[1\] state\[0\] loaded\[0\] _08782_ VSS VSS
+ VDD VDD _08804_ sky130_fd_sc_hd__nor4_1
X_12702_ loaded\[0\] _08783_ _08804_ VSS VSS VDD VDD _08805_
+ sky130_fd_sc_hd__a21oi_1
X_12703_ net455 _08805_ VSS VSS VDD VDD _01572_ sky130_fd_sc_hd__nor2_1
X_12704_ _08736_ icg_net.en VSS VSS VDD VDD _01573_ sky130_fd_sc_hd__nor2_1
X_12705_ network.cnt_main.counter\[2\] network.cnt_main.counter\[3\]
+ network.cnt_main.counter\[4\] VSS VSS VDD VDD _08806_ sky130_fd_sc_hd__nor3_1
X_12706_ network.cnt_main.counter\[5\] _00690_ _08806_ VSS
+ VSS VDD VDD _08807_ sky130_fd_sc_hd__nand3b_1
X_12707_ network.cnt_main.counter\[7\] network.cnt_main.counter\[6\]
+ _08807_ VSS VSS VDD VDD _08808_ sky130_fd_sc_hd__or3_1
Xclkload2 clknet_2_2__leaf_clk_regs VSS VSS VDD VDD _unconnected_34
+ sky130_fd_sc_hd__clkinv_2
X_12709_ network.cnt_main.counter\[9\] network.cnt_main.counter\[8\]
+ network.cnt_main.counter\[10\] VSS VSS VDD VDD _08810_ sky130_fd_sc_hd__or3_1
X_12710_ network.cnt_main.counter\[12\] network.cnt_main.counter\[11\]
+ _08810_ VSS VSS VDD VDD _08811_ sky130_fd_sc_hd__or3_1
X_12711_ network.cnt_main.counter\[13\] _08808_ _08811_ VSS
+ VSS VDD VDD _08812_ sky130_fd_sc_hd__nor3_1
X_12712_ _01026_ _08812_ network.arbit.counter\[2\] VSS VSS
+ VDD VDD _08813_ sky130_fd_sc_hd__a21oi_1
X_12713_ network.arbit.counter\[2\] _01026_ _08812_ VSS VSS
+ VDD VDD _08814_ sky130_fd_sc_hd__and3_1
X_12714_ _08813_ _08814_ net366 VSS VSS VDD VDD _01574_ sky130_fd_sc_hd__o21ai_0
Xclkload1 clknet_2_1__leaf_clk_regs VSS VSS VDD VDD _unconnected_35
+ sky130_fd_sc_hd__bufinv_16
Xclkload0 clknet_2_0__leaf_clk_regs VSS VSS VDD VDD _unconnected_36
+ sky130_fd_sc_hd__clkinvlp_4
Xplace427 _06673_ VSS VSS VDD VDD net426 sky130_fd_sc_hd__buf_4
X_12718_ network.cnt_main.counter\[13\] _08808_ _08811_ VSS
+ VSS VDD VDD _08818_ sky130_fd_sc_hd__or3_1
X_12719_ _01027_ _08818_ VSS VSS VDD VDD _08819_ sky130_fd_sc_hd__nor2_1
X_12720_ network.arbit.counter\[1\] _08818_ _08819_ VSS VSS
+ VDD VDD _08820_ sky130_fd_sc_hd__a21oi_1
X_12721_ net426 _08820_ VSS VSS VDD VDD _01575_ sky130_fd_sc_hd__nor2_1
X_12722_ network.cnt_main.counter\[13\] _08808_ _08811_ VSS
+ VSS VDD VDD _08821_ sky130_fd_sc_hd__or3_1
Xplace426 net426 VSS VSS VDD VDD net425 sky130_fd_sc_hd__buf_4
X_12724_ _01024_ _08821_ VSS VSS VDD VDD _08823_ sky130_fd_sc_hd__xnor2_1
X_12725_ net426 _08823_ VSS VSS VDD VDD _01576_ sky130_fd_sc_hd__nor2_1
X_12726_ _00789_ VSS VSS VDD VDD _08824_ sky130_fd_sc_hd__inv_1
X_12727_ _01139_ VSS VSS VDD VDD _08825_ sky130_fd_sc_hd__inv_1
X_12728_ _00015_ _00226_ _00225_ VSS VSS VDD VDD _08826_ sky130_fd_sc_hd__a21o_1
X_12729_ _00854_ _08826_ _00853_ VSS VSS VDD VDD _08827_ sky130_fd_sc_hd__a21oi_1
X_12730_ _08825_ _08827_ _01138_ VSS VSS VDD VDD _08828_ sky130_fd_sc_hd__o21bai_1
X_12731_ _01077_ _08828_ _01076_ VSS VSS VDD VDD _08829_ sky130_fd_sc_hd__a21oi_1
X_12732_ _08829_ _00796_ VSS VSS VDD VDD _08830_ sky130_fd_sc_hd__nor2b_1
X_12733_ _00795_ _08830_ _00790_ VSS VSS VDD VDD _08831_ sky130_fd_sc_hd__o21ai_0
X_12734_ net426 _08697_ VSS VSS VDD VDD _08832_ sky130_fd_sc_hd__or2_2
Xplace425 net425 VSS VSS VDD VDD net424 sky130_fd_sc_hd__buf_4
X_12736_ _08824_ _08831_ _08832_ VSS VSS VDD VDD _01577_ sky130_fd_sc_hd__a21oi_1
X_12737_ _00016_ _00854_ _00853_ VSS VSS VDD VDD _08834_ sky130_fd_sc_hd__a21oi_1
X_12738_ _08825_ _08834_ _01138_ VSS VSS VDD VDD _08835_ sky130_fd_sc_hd__o21bai_1
X_12739_ _01077_ _08835_ _01076_ VSS VSS VDD VDD _08836_ sky130_fd_sc_hd__a21o_1
X_12740_ _00796_ _08836_ _00795_ VSS VSS VDD VDD _08837_ sky130_fd_sc_hd__a21oi_1
X_12741_ _00790_ _08837_ VSS VSS VDD VDD _08838_ sky130_fd_sc_hd__xor2_1
X_12742_ _08832_ _08838_ VSS VSS VDD VDD _01578_ sky130_fd_sc_hd__nor2_1
X_12743_ _00796_ _08829_ VSS VSS VDD VDD _08839_ sky130_fd_sc_hd__nor2b_1
X_12744_ _08832_ _08830_ _08839_ VSS VSS VDD VDD _01579_ sky130_fd_sc_hd__nor3_1
X_12745_ _01077_ _08835_ VSS VSS VDD VDD _08840_ sky130_fd_sc_hd__xnor2_1
X_12746_ _08832_ _08840_ VSS VSS VDD VDD _01580_ sky130_fd_sc_hd__nor2_1
X_12747_ _08825_ _08827_ VSS VSS VDD VDD _08841_ sky130_fd_sc_hd__xnor2_1
X_12748_ _08832_ _08841_ VSS VSS VDD VDD _01581_ sky130_fd_sc_hd__nor2_1
X_12749_ _00016_ _00854_ VSS VSS VDD VDD _08842_ sky130_fd_sc_hd__xnor2_1
X_12750_ _08832_ _08842_ VSS VSS VDD VDD _01582_ sky130_fd_sc_hd__nor2_1
X_12751_ _00017_ VSS VSS VDD VDD _08843_ sky130_fd_sc_hd__inv_1
X_12752_ _08843_ _08832_ VSS VSS VDD VDD _01583_ sky130_fd_sc_hd__nor2_1
X_12753_ _00888_ VSS VSS VDD VDD _08844_ sky130_fd_sc_hd__inv_1
X_12754_ _08844_ _08832_ VSS VSS VDD VDD _01584_ sky130_fd_sc_hd__nor2_1
X_12755_ net426 net333 VSS VSS VDD VDD _08845_ sky130_fd_sc_hd__or2_2
Xplace424 net424 VSS VSS VDD VDD net423 sky130_fd_sc_hd__buf_4
X_12757_ _00031_ _00200_ _00199_ VSS VSS VDD VDD _08847_ sky130_fd_sc_hd__a21o_1
X_12758_ _01049_ _08847_ _01048_ VSS VSS VDD VDD _08848_ sky130_fd_sc_hd__a21oi_1
X_12759_ _08848_ _00107_ VSS VSS VDD VDD _08849_ sky130_fd_sc_hd__nor2b_1
X_12760_ _00106_ _08849_ _00542_ VSS VSS VDD VDD _08850_ sky130_fd_sc_hd__o21ai_0
X_12761_ _00541_ _08850_ VSS VSS VDD VDD _08851_ sky130_fd_sc_hd__nand2b_1
X_12762_ network.neuron_out4.IF0.membrane_potential\[6\] network.neuron_out4.IF0.membrane_potential\[5\]
+ _08851_ network.neuron_out4.IF0.membrane_potential\[7\] VSS
+ VSS VDD VDD _08852_ sky130_fd_sc_hd__a31oi_1
X_12763_ _08845_ _08852_ VSS VSS VDD VDD _01585_ sky130_fd_sc_hd__nor2_1
X_12764_ _00032_ _01049_ _01048_ VSS VSS VDD VDD _08853_ sky130_fd_sc_hd__a21o_1
X_12765_ _00107_ _08853_ _00106_ VSS VSS VDD VDD _08854_ sky130_fd_sc_hd__a21oi_1
X_12766_ _08854_ _00542_ VSS VSS VDD VDD _08855_ sky130_fd_sc_hd__nor2b_1
X_12767_ _00541_ _08855_ network.neuron_out4.IF0.membrane_potential\[5\]
+ VSS VSS VDD VDD _08856_ sky130_fd_sc_hd__o21ai_0
X_12768_ network.neuron_out4.IF0.membrane_potential\[6\] _08856_
+ VSS VSS VDD VDD _08857_ sky130_fd_sc_hd__xor2_1
X_12769_ _08845_ _08857_ VSS VSS VDD VDD _01586_ sky130_fd_sc_hd__nor2_1
X_12770_ network.neuron_out4.IF0.membrane_potential\[5\] _08851_
+ VSS VSS VDD VDD _08858_ sky130_fd_sc_hd__xnor2_1
X_12771_ _08845_ _08858_ VSS VSS VDD VDD _01587_ sky130_fd_sc_hd__nor2_1
X_12772_ _00542_ _08854_ VSS VSS VDD VDD _08859_ sky130_fd_sc_hd__nor2b_1
X_12773_ _08845_ _08855_ _08859_ VSS VSS VDD VDD _01588_ sky130_fd_sc_hd__nor3_1
X_12774_ _00107_ _08848_ VSS VSS VDD VDD _08860_ sky130_fd_sc_hd__nor2b_1
X_12775_ _08845_ _08849_ _08860_ VSS VSS VDD VDD _01589_ sky130_fd_sc_hd__nor3_1
X_12776_ _00032_ _01049_ VSS VSS VDD VDD _08861_ sky130_fd_sc_hd__xnor2_1
X_12777_ _08845_ _08861_ VSS VSS VDD VDD _01590_ sky130_fd_sc_hd__nor2_1
X_12778_ _00033_ VSS VSS VDD VDD _08862_ sky130_fd_sc_hd__inv_1
X_12779_ _08862_ _08845_ VSS VSS VDD VDD _01591_ sky130_fd_sc_hd__nor2_1
X_12780_ _00176_ VSS VSS VDD VDD _08863_ sky130_fd_sc_hd__inv_1
X_12781_ _08863_ _08845_ VSS VSS VDD VDD _01592_ sky130_fd_sc_hd__nor2_1
X_12782_ net426 _08684_ VSS VSS VDD VDD _08864_ sky130_fd_sc_hd__or2_2
Xplace423 net423 VSS VSS VDD VDD net422 sky130_fd_sc_hd__buf_4
X_12784_ _00007_ _00167_ _00166_ VSS VSS VDD VDD _08866_ sky130_fd_sc_hd__a21o_1
X_12785_ _01143_ _08866_ _01142_ VSS VSS VDD VDD _08867_ sky130_fd_sc_hd__a21oi_1
X_12786_ _08867_ _01141_ VSS VSS VDD VDD _08868_ sky130_fd_sc_hd__nor2b_1
X_12787_ _01140_ _08868_ _01067_ VSS VSS VDD VDD _08869_ sky130_fd_sc_hd__o21ai_0
X_12788_ _01066_ _08869_ VSS VSS VDD VDD _08870_ sky130_fd_sc_hd__nand2b_1
X_12789_ network.neuron_out3.IF0.membrane_potential\[6\] network.neuron_out3.IF0.membrane_potential\[5\]
+ _08870_ network.neuron_out3.IF0.membrane_potential\[7\] VSS
+ VSS VDD VDD _08871_ sky130_fd_sc_hd__a31oi_1
X_12790_ _08864_ _08871_ VSS VSS VDD VDD _01593_ sky130_fd_sc_hd__nor2_1
X_12791_ _01143_ _00008_ _01142_ VSS VSS VDD VDD _08872_ sky130_fd_sc_hd__a21o_1
X_12792_ _01141_ _08872_ _01140_ VSS VSS VDD VDD _08873_ sky130_fd_sc_hd__a21oi_1
X_12793_ _08873_ _01067_ VSS VSS VDD VDD _08874_ sky130_fd_sc_hd__nor2b_1
X_12794_ _01066_ _08874_ network.neuron_out3.IF0.membrane_potential\[5\]
+ VSS VSS VDD VDD _08875_ sky130_fd_sc_hd__o21ai_0
X_12795_ network.neuron_out3.IF0.membrane_potential\[6\] _08875_
+ VSS VSS VDD VDD _08876_ sky130_fd_sc_hd__xor2_1
X_12796_ _08864_ _08876_ VSS VSS VDD VDD _01594_ sky130_fd_sc_hd__nor2_1
X_12797_ network.neuron_out3.IF0.membrane_potential\[5\] _08870_
+ VSS VSS VDD VDD _08877_ sky130_fd_sc_hd__xnor2_1
X_12798_ _08864_ _08877_ VSS VSS VDD VDD _01595_ sky130_fd_sc_hd__nor2_1
X_12799_ _01067_ _08873_ VSS VSS VDD VDD _08878_ sky130_fd_sc_hd__nor2b_1
X_12800_ _08864_ _08874_ _08878_ VSS VSS VDD VDD _01596_ sky130_fd_sc_hd__nor3_1
X_12801_ _01141_ _08867_ VSS VSS VDD VDD _08879_ sky130_fd_sc_hd__nor2b_1
X_12802_ _08864_ _08868_ _08879_ VSS VSS VDD VDD _01597_ sky130_fd_sc_hd__nor3_1
X_12803_ _01143_ _00008_ VSS VSS VDD VDD _08880_ sky130_fd_sc_hd__xnor2_1
X_12804_ _08864_ _08880_ VSS VSS VDD VDD _01598_ sky130_fd_sc_hd__nor2_1
X_12805_ _00009_ VSS VSS VDD VDD _08881_ sky130_fd_sc_hd__inv_1
X_12806_ _08881_ _08864_ VSS VSS VDD VDD _01599_ sky130_fd_sc_hd__nor2_1
X_12807_ _00857_ VSS VSS VDD VDD _08882_ sky130_fd_sc_hd__inv_1
X_12808_ _08882_ _08864_ VSS VSS VDD VDD _01600_ sky130_fd_sc_hd__nor2_1
X_12809_ network.neuron_out2.IF0.membrane_potential\[5\] network.neuron_out2.IF0.membrane_potential\[6\]
+ VSS VSS VDD VDD _08883_ sky130_fd_sc_hd__nand2_1
X_12810_ _00742_ _00004_ _00764_ VSS VSS VDD VDD _08884_ sky130_fd_sc_hd__a21o_1
X_12811_ _00852_ _08884_ _00851_ VSS VSS VDD VDD _08885_ sky130_fd_sc_hd__a21o_1
X_12812_ _00774_ _08885_ _00773_ VSS VSS VDD VDD _08886_ sky130_fd_sc_hd__a21o_1
X_12813_ _00794_ _08886_ _00793_ VSS VSS VDD VDD _08887_ sky130_fd_sc_hd__a21oi_1
X_12814_ _08883_ _08887_ network.neuron_out2.IF0.membrane_potential\[7\]
+ VSS VSS VDD VDD _08888_ sky130_fd_sc_hd__o21ai_0
X_12815_ network.neuron_out2.IF0.membrane_potential\[7\] _08883_
+ _08887_ VSS VSS VDD VDD _08889_ sky130_fd_sc_hd__or3_1
X_12816_ net426 _08688_ VSS VSS VDD VDD _08890_ sky130_fd_sc_hd__or2_2
Xplace422 net425 VSS VSS VDD VDD net421 sky130_fd_sc_hd__buf_4
X_12818_ _08888_ _08889_ _08890_ VSS VSS VDD VDD _01601_ sky130_fd_sc_hd__a21oi_1
X_12819_ _00852_ _00005_ _00851_ VSS VSS VDD VDD _08892_ sky130_fd_sc_hd__a21o_1
X_12820_ _00774_ _08892_ _00773_ VSS VSS VDD VDD _08893_ sky130_fd_sc_hd__a21oi_1
X_12821_ _08893_ _00794_ VSS VSS VDD VDD _08894_ sky130_fd_sc_hd__nor2b_1
X_12822_ _00793_ _08894_ network.neuron_out2.IF0.membrane_potential\[5\]
+ VSS VSS VDD VDD _08895_ sky130_fd_sc_hd__o21ai_0
X_12823_ network.neuron_out2.IF0.membrane_potential\[6\] _08895_
+ VSS VSS VDD VDD _08896_ sky130_fd_sc_hd__xor2_1
X_12824_ _08890_ _08896_ VSS VSS VDD VDD _01602_ sky130_fd_sc_hd__nor2_1
X_12825_ network.neuron_out2.IF0.membrane_potential\[5\] _08887_
+ VSS VSS VDD VDD _08897_ sky130_fd_sc_hd__xor2_1
X_12826_ _08890_ _08897_ VSS VSS VDD VDD _01603_ sky130_fd_sc_hd__nor2_1
X_12827_ _00794_ _08893_ VSS VSS VDD VDD _08898_ sky130_fd_sc_hd__nor2b_1
X_12828_ _08890_ _08894_ _08898_ VSS VSS VDD VDD _01604_ sky130_fd_sc_hd__nor3_1
X_12829_ _00774_ _08885_ VSS VSS VDD VDD _08899_ sky130_fd_sc_hd__xnor2_1
X_12830_ _08890_ _08899_ VSS VSS VDD VDD _01605_ sky130_fd_sc_hd__nor2_1
X_12831_ _00852_ _00005_ VSS VSS VDD VDD _08900_ sky130_fd_sc_hd__xnor2_1
X_12832_ _08890_ _08900_ VSS VSS VDD VDD _01606_ sky130_fd_sc_hd__nor2_1
X_12833_ _00006_ VSS VSS VDD VDD _08901_ sky130_fd_sc_hd__inv_1
X_12834_ _08901_ _08890_ VSS VSS VDD VDD _01607_ sky130_fd_sc_hd__nor2_1
X_12835_ _00151_ VSS VSS VDD VDD _08902_ sky130_fd_sc_hd__inv_1
X_12836_ _08902_ _08890_ VSS VSS VDD VDD _01608_ sky130_fd_sc_hd__nor2_1
X_12837_ net426 net332 VSS VSS VDD VDD _08903_ sky130_fd_sc_hd__or2_2
Xplace421 net421 VSS VSS VDD VDD net420 sky130_fd_sc_hd__buf_4
X_12839_ _00010_ _00719_ _00718_ VSS VSS VDD VDD _08905_ sky130_fd_sc_hd__a21o_1
X_12840_ _01065_ _08905_ _01064_ VSS VSS VDD VDD _08906_ sky130_fd_sc_hd__a21oi_1
X_12841_ _08906_ _00178_ VSS VSS VDD VDD _08907_ sky130_fd_sc_hd__nor2b_1
X_12842_ _00177_ _08907_ _01165_ VSS VSS VDD VDD _08908_ sky130_fd_sc_hd__o21ai_0
X_12843_ _01164_ _08908_ VSS VSS VDD VDD _08909_ sky130_fd_sc_hd__nand2b_1
X_12844_ network.neuron_out1.IF0.membrane_potential\[6\] network.neuron_out1.IF0.membrane_potential\[5\]
+ _08909_ network.neuron_out1.IF0.membrane_potential\[7\] VSS
+ VSS VDD VDD _08910_ sky130_fd_sc_hd__a31oi_1
X_12845_ _08903_ _08910_ VSS VSS VDD VDD _01609_ sky130_fd_sc_hd__nor2_1
X_12846_ _01065_ _00011_ _01064_ VSS VSS VDD VDD _08911_ sky130_fd_sc_hd__a21o_1
X_12847_ _00178_ _08911_ _00177_ VSS VSS VDD VDD _08912_ sky130_fd_sc_hd__a21oi_1
X_12848_ _08912_ _01165_ VSS VSS VDD VDD _08913_ sky130_fd_sc_hd__nor2b_1
X_12849_ _01164_ _08913_ network.neuron_out1.IF0.membrane_potential\[5\]
+ VSS VSS VDD VDD _08914_ sky130_fd_sc_hd__o21ai_0
X_12850_ network.neuron_out1.IF0.membrane_potential\[6\] _08914_
+ VSS VSS VDD VDD _08915_ sky130_fd_sc_hd__xor2_1
X_12851_ _08903_ _08915_ VSS VSS VDD VDD _01610_ sky130_fd_sc_hd__nor2_1
X_12852_ network.neuron_out1.IF0.membrane_potential\[5\] _08909_
+ VSS VSS VDD VDD _08916_ sky130_fd_sc_hd__xnor2_1
X_12853_ _08903_ _08916_ VSS VSS VDD VDD _01611_ sky130_fd_sc_hd__nor2_1
X_12854_ _01165_ _08912_ VSS VSS VDD VDD _08917_ sky130_fd_sc_hd__nor2b_1
X_12855_ _08903_ _08913_ _08917_ VSS VSS VDD VDD _01612_ sky130_fd_sc_hd__nor3_1
X_12856_ _00178_ _08906_ VSS VSS VDD VDD _08918_ sky130_fd_sc_hd__nor2b_1
X_12857_ _08903_ _08907_ _08918_ VSS VSS VDD VDD _01613_ sky130_fd_sc_hd__nor3_1
X_12858_ _01065_ _00011_ VSS VSS VDD VDD _08919_ sky130_fd_sc_hd__xnor2_1
X_12859_ _08903_ _08919_ VSS VSS VDD VDD _01614_ sky130_fd_sc_hd__nor2_1
X_12860_ _00012_ VSS VSS VDD VDD _08920_ sky130_fd_sc_hd__inv_1
X_12861_ _08920_ _08903_ VSS VSS VDD VDD _01615_ sky130_fd_sc_hd__nor2_1
X_12862_ _00659_ VSS VSS VDD VDD _08921_ sky130_fd_sc_hd__inv_1
X_12863_ _08921_ _08903_ VSS VSS VDD VDD _01616_ sky130_fd_sc_hd__nor2_1
X_12864_ net426 _08680_ VSS VSS VDD VDD _08922_ sky130_fd_sc_hd__or2_2
Xplace420 net420 VSS VSS VDD VDD net419 sky130_fd_sc_hd__buf_4
X_12866_ _00366_ VSS VSS VDD VDD _08924_ sky130_fd_sc_hd__inv_1
X_12867_ _00755_ _00028_ _00754_ VSS VSS VDD VDD _08925_ sky130_fd_sc_hd__a21o_1
X_12868_ _01075_ _08925_ _01074_ VSS VSS VDD VDD _08926_ sky130_fd_sc_hd__a21oi_1
X_12869_ _08924_ _08926_ _00365_ VSS VSS VDD VDD _08927_ sky130_fd_sc_hd__o21bai_1
X_12870_ _00721_ _08927_ _00720_ VSS VSS VDD VDD _08928_ sky130_fd_sc_hd__a21oi_1
X_12871_ _08928_ _00142_ VSS VSS VDD VDD _08929_ sky130_fd_sc_hd__nor2b_1
X_12872_ _00141_ _08929_ network.neuron_out0.IF0.membrane_potential\[6\]
+ VSS VSS VDD VDD _08930_ sky130_fd_sc_hd__o21ai_0
X_12873_ network.neuron_out0.IF0.membrane_potential\[7\] _08930_
+ VSS VSS VDD VDD _08931_ sky130_fd_sc_hd__xor2_1
X_12874_ _08922_ _08931_ VSS VSS VDD VDD _01617_ sky130_fd_sc_hd__nor2_1
X_12875_ _01075_ _00029_ _01074_ VSS VSS VDD VDD _08932_ sky130_fd_sc_hd__a21oi_1
X_12876_ _08924_ _08932_ _00365_ VSS VSS VDD VDD _08933_ sky130_fd_sc_hd__o21bai_1
X_12877_ _00721_ _08933_ _00720_ VSS VSS VDD VDD _08934_ sky130_fd_sc_hd__a21o_1
X_12878_ _00142_ _08934_ _00141_ VSS VSS VDD VDD _08935_ sky130_fd_sc_hd__a21oi_1
X_12879_ network.neuron_out0.IF0.membrane_potential\[6\] _08935_
+ VSS VSS VDD VDD _08936_ sky130_fd_sc_hd__xor2_1
X_12880_ _08922_ _08936_ VSS VSS VDD VDD _01618_ sky130_fd_sc_hd__nor2_1
X_12881_ _00142_ _08928_ VSS VSS VDD VDD _08937_ sky130_fd_sc_hd__nor2b_1
X_12882_ _08922_ _08929_ _08937_ VSS VSS VDD VDD _01619_ sky130_fd_sc_hd__nor3_1
X_12883_ _00721_ _08933_ VSS VSS VDD VDD _08938_ sky130_fd_sc_hd__xnor2_1
X_12884_ _08922_ _08938_ VSS VSS VDD VDD _01620_ sky130_fd_sc_hd__nor2_1
X_12885_ _08924_ _08926_ VSS VSS VDD VDD _08939_ sky130_fd_sc_hd__xnor2_1
X_12886_ _08922_ _08939_ VSS VSS VDD VDD _01621_ sky130_fd_sc_hd__nor2_1
X_12887_ _01075_ _00029_ VSS VSS VDD VDD _08940_ sky130_fd_sc_hd__xnor2_1
X_12888_ _08922_ _08940_ VSS VSS VDD VDD _01622_ sky130_fd_sc_hd__nor2_1
X_12889_ _00030_ VSS VSS VDD VDD _08941_ sky130_fd_sc_hd__inv_1
X_12890_ _08941_ _08922_ VSS VSS VDD VDD _01623_ sky130_fd_sc_hd__nor2_1
X_12891_ _00850_ VSS VSS VDD VDD _08942_ sky130_fd_sc_hd__inv_1
X_12892_ _08942_ _08922_ VSS VSS VDD VDD _01624_ sky130_fd_sc_hd__nor2_1
Xplace419 net420 VSS VSS VDD VDD net418 sky130_fd_sc_hd__buf_4
X_12894_ network.hid_spk7 network.hid_spk6 VSS VSS VDD VDD
+ _08944_ sky130_fd_sc_hd__nor2_1
X_12895_ network.hid_spk5 network.hid_spk4 _08944_ VSS VSS
+ VDD VDD _08945_ sky130_fd_sc_hd__nor3_1
X_12896_ network.hid_spk3 network.hid_spk2 _08945_ VSS VSS
+ VDD VDD _08946_ sky130_fd_sc_hd__nor3_1
X_12897_ network.hid_spk1 network.hid_spk0 net426 _08946_
+ VSS VSS VDD VDD _01625_ sky130_fd_sc_hd__nor4_1
Xplace418 net426 VSS VSS VDD VDD net417 sky130_fd_sc_hd__buf_4
X_12899_ network.hid_spk3 network.hid_spk2 network.hid_spk1
+ network.hid_spk0 VSS VSS VDD VDD _08948_ sky130_fd_sc_hd__or4_1
X_12900_ network.hid_spk5 network.hid_spk4 _08948_ VSS VSS
+ VDD VDD _08949_ sky130_fd_sc_hd__or3_1
X_12901_ network.hid_spk6 _08949_ VSS VSS VDD VDD _08950_
+ sky130_fd_sc_hd__nor2_1
X_12902_ network.hid_spk4 VSS VSS VDD VDD _08951_ sky130_fd_sc_hd__inv_1
X_12903_ network.hid_spk5 _08951_ network.hid_spk3 VSS VSS
+ VDD VDD _08952_ sky130_fd_sc_hd__a21oi_1
X_12904_ network.hid_spk2 _08952_ VSS VSS VDD VDD _08953_
+ sky130_fd_sc_hd__nor2_1
X_12905_ network.hid_spk7 _08950_ _08953_ network.hid_spk1
+ VSS VSS VDD VDD _08954_ sky130_fd_sc_hd__a211oi_1
X_12906_ network.hid_spk0 net426 _08954_ VSS VSS VDD VDD _01626_
+ sky130_fd_sc_hd__nor3_1
X_12907_ network.neuron_hid7.IF0.membrane_potential\[3\] network.neuron_hid7.IF0.membrane_potential\[0\]
+ network.neuron_hid7.IF0.membrane_potential\[5\] network.neuron_hid7.IF0.membrane_potential\[4\]
+ VSS VSS VDD VDD _08955_ sky130_fd_sc_hd__or4_1
X_12908_ network.neuron_hid7.IF0.membrane_potential\[1\] network.neuron_hid7.IF0.membrane_potential\[2\]
+ _08955_ network.neuron_hid7.IF0.membrane_potential\[6\] VSS
+ VSS VDD VDD _08956_ sky130_fd_sc_hd__o31a_1
X_12909_ network.neuron_hid7.IF0.membrane_potential\[7\] _08956_
+ network.neuron_hid7.IF0.membrane_potential\[8\] VSS VSS VDD
+ VDD _08957_ sky130_fd_sc_hd__o21a_1
X_12910_ network.neuron_hid7.IF0.membrane_potential\[9\] network.neuron_hid7.IF0.membrane_potential\[10\]
+ _08957_ _00686_ VSS VSS VDD VDD _08958_ sky130_fd_sc_hd__o31ai_1
X_12911_ net365 _08958_ VSS VSS VDD VDD _08959_ sky130_fd_sc_hd__nand2_1
Xplace417 net417 VSS VSS VDD VDD net416 sky130_fd_sc_hd__buf_4
X_12913_ _00686_ _08821_ VSS VSS VDD VDD _08961_ sky130_fd_sc_hd__nor2_1
X_12914_ network.neuron_hid7.IF0.ref_counter\[0\] _08961_
+ VSS VSS VDD VDD _08962_ sky130_fd_sc_hd__xnor2_1
X_12915_ _08959_ _08962_ VSS VSS VDD VDD _01627_ sky130_fd_sc_hd__nor2_1
X_12916_ _00180_ VSS VSS VDD VDD _08963_ sky130_fd_sc_hd__inv_1
X_12917_ _00136_ VSS VSS VDD VDD _08964_ sky130_fd_sc_hd__inv_1
X_12918_ _00013_ _00745_ _00744_ VSS VSS VDD VDD _08965_ sky130_fd_sc_hd__a21o_1
X_12919_ _01133_ _08965_ _01132_ VSS VSS VDD VDD _08966_ sky130_fd_sc_hd__a21oi_1
X_12920_ _08964_ _08966_ _00135_ VSS VSS VDD VDD _08967_ sky130_fd_sc_hd__o21bai_1
X_12921_ _00182_ _08967_ _00181_ VSS VSS VDD VDD _08968_ sky130_fd_sc_hd__a21oi_1
X_12922_ _08963_ _08968_ _00179_ VSS VSS VDD VDD _08969_ sky130_fd_sc_hd__o21bai_1
X_12923_ network.neuron_hid7.IF0.membrane_potential\[8\] _01162_
+ VSS VSS VDD VDD _08970_ sky130_fd_sc_hd__nand2_1
X_12924_ _01163_ _00704_ network.neuron_hid7.IF0.membrane_potential\[8\]
+ VSS VSS VDD VDD _08971_ sky130_fd_sc_hd__nand3_1
X_12925_ _08970_ _08971_ VSS VSS VDD VDD _08972_ sky130_fd_sc_hd__nand2_1
X_12926_ _00705_ _01163_ network.neuron_hid7.IF0.membrane_potential\[8\]
+ _08969_ _08972_ VSS VSS VDD VDD _08973_ sky130_fd_sc_hd__a41oi_1
X_12927_ network.neuron_hid7.IF0.membrane_potential\[9\] _08973_
+ VSS VSS VDD VDD _08974_ sky130_fd_sc_hd__xor2_1
X_12928_ _08959_ _08974_ VSS VSS VDD VDD _01628_ sky130_fd_sc_hd__nor2_1
X_12929_ _00705_ _01163_ VSS VSS VDD VDD _08975_ sky130_fd_sc_hd__nand2_1
X_12930_ _00182_ VSS VSS VDD VDD _08976_ sky130_fd_sc_hd__inv_1
X_12931_ _00014_ _01133_ _01132_ VSS VSS VDD VDD _08977_ sky130_fd_sc_hd__a21o_1
X_12932_ _00136_ _08977_ _00135_ VSS VSS VDD VDD _08978_ sky130_fd_sc_hd__a21oi_1
X_12933_ _08976_ _08978_ _00181_ VSS VSS VDD VDD _08979_ sky130_fd_sc_hd__o21bai_1
X_12934_ _00180_ _08979_ _00179_ VSS VSS VDD VDD _08980_ sky130_fd_sc_hd__a21oi_1
X_12935_ _01163_ _00704_ _01162_ VSS VSS VDD VDD _08981_ sky130_fd_sc_hd__a21oi_1
X_12936_ _08975_ _08980_ _08981_ VSS VSS VDD VDD _08982_ sky130_fd_sc_hd__o21ai_0
X_12937_ network.neuron_hid7.IF0.membrane_potential\[8\] _08982_
+ VSS VSS VDD VDD _08983_ sky130_fd_sc_hd__xnor2_1
X_12938_ _08959_ _08983_ VSS VSS VDD VDD _01629_ sky130_fd_sc_hd__nor2_1
X_12939_ _00705_ _08969_ _00704_ VSS VSS VDD VDD _08984_ sky130_fd_sc_hd__a21oi_1
X_12940_ _01163_ _08984_ VSS VSS VDD VDD _08985_ sky130_fd_sc_hd__xor2_1
X_12941_ _08959_ _08985_ VSS VSS VDD VDD _01630_ sky130_fd_sc_hd__nor2_1
X_12942_ _00705_ _08980_ VSS VSS VDD VDD _08986_ sky130_fd_sc_hd__xor2_1
X_12943_ _08959_ _08986_ VSS VSS VDD VDD _01631_ sky130_fd_sc_hd__nor2_1
X_12944_ _08963_ _08968_ VSS VSS VDD VDD _08987_ sky130_fd_sc_hd__xnor2_1
X_12945_ _08959_ _08987_ VSS VSS VDD VDD _01632_ sky130_fd_sc_hd__nor2_1
X_12946_ _08976_ _08978_ VSS VSS VDD VDD _08988_ sky130_fd_sc_hd__xnor2_1
X_12947_ _08959_ _08988_ VSS VSS VDD VDD _01633_ sky130_fd_sc_hd__nor2_1
X_12948_ _08964_ _08966_ VSS VSS VDD VDD _08989_ sky130_fd_sc_hd__xnor2_1
X_12949_ _08959_ _08989_ VSS VSS VDD VDD _01634_ sky130_fd_sc_hd__nor2_1
X_12950_ _00014_ _01133_ VSS VSS VDD VDD _08990_ sky130_fd_sc_hd__xnor2_1
X_12951_ _08959_ _08990_ VSS VSS VDD VDD _01635_ sky130_fd_sc_hd__nor2_1
X_12952_ network.neuron_hid7.IF0.add_out\[1\] net365 _08958_
+ VSS VSS VDD VDD _01636_ sky130_fd_sc_hd__and3_1
X_12953_ network.neuron_hid7.IF0.add_out\[0\] net365 _08958_
+ VSS VSS VDD VDD _01637_ sky130_fd_sc_hd__and3_1
X_12954_ network.neuron_hid6.IF0.membrane_potential\[1\] network.neuron_hid6.IF0.membrane_potential\[5\]
+ network.neuron_hid6.IF0.membrane_potential\[2\] network.neuron_hid6.IF0.membrane_potential\[4\]
+ VSS VSS VDD VDD _08991_ sky130_fd_sc_hd__or4_1
X_12955_ network.neuron_hid6.IF0.membrane_potential\[0\] network.neuron_hid6.IF0.membrane_potential\[3\]
+ _08991_ network.neuron_hid6.IF0.membrane_potential\[6\] VSS
+ VSS VDD VDD _08992_ sky130_fd_sc_hd__o31a_1
X_12956_ network.neuron_hid6.IF0.membrane_potential\[7\] _08992_
+ network.neuron_hid6.IF0.membrane_potential\[8\] VSS VSS VDD
+ VDD _08993_ sky130_fd_sc_hd__o21a_1
X_12957_ network.neuron_hid6.IF0.membrane_potential\[9\] network.neuron_hid6.IF0.membrane_potential\[10\]
+ _08993_ _00091_ VSS VSS VDD VDD _08994_ sky130_fd_sc_hd__o31ai_1
X_12958_ net365 net319 VSS VSS VDD VDD _08995_ sky130_fd_sc_hd__nand2_1
Xplace416 net417 VSS VSS VDD VDD net415 sky130_fd_sc_hd__buf_4
X_12960_ _00091_ _08821_ VSS VSS VDD VDD _08997_ sky130_fd_sc_hd__nor2_1
X_12961_ network.neuron_hid6.IF0.ref_counter\[0\] _08997_
+ VSS VSS VDD VDD _08998_ sky130_fd_sc_hd__xnor2_1
X_12962_ _08995_ _08998_ VSS VSS VDD VDD _01638_ sky130_fd_sc_hd__nor2_1
X_12963_ _00002_ _00093_ _00134_ VSS VSS VDD VDD _08999_ sky130_fd_sc_hd__a21o_1
X_12964_ _01079_ _08999_ _01078_ VSS VSS VDD VDD _09000_ sky130_fd_sc_hd__a21o_1
X_12965_ _00856_ _09000_ _00855_ VSS VSS VDD VDD _09001_ sky130_fd_sc_hd__a21o_1
X_12966_ _00792_ _09001_ _00791_ VSS VSS VDD VDD _09002_ sky130_fd_sc_hd__a21oi_1
X_12967_ network.neuron_hid6.IF0.membrane_potential\[8\] network.neuron_hid6.IF0.membrane_potential\[7\]
+ network.neuron_hid6.IF0.membrane_potential\[6\] network.neuron_hid6.IF0.membrane_potential\[5\]
+ VSS VSS VDD VDD _09003_ sky130_fd_sc_hd__nand4_1
X_12968_ _09002_ _09003_ network.neuron_hid6.IF0.membrane_potential\[9\]
+ VSS VSS VDD VDD _09004_ sky130_fd_sc_hd__o21ai_0
X_12969_ network.neuron_hid6.IF0.membrane_potential\[9\] _09002_
+ _09003_ VSS VSS VDD VDD _09005_ sky130_fd_sc_hd__or3_1
X_12970_ _09004_ _09005_ _08995_ VSS VSS VDD VDD _01639_ sky130_fd_sc_hd__a21oi_1
X_12971_ _00003_ _01079_ _01078_ VSS VSS VDD VDD _09006_ sky130_fd_sc_hd__a21o_1
X_12972_ _00856_ _09006_ _00855_ VSS VSS VDD VDD _09007_ sky130_fd_sc_hd__a21oi_1
X_12973_ _09007_ VSS VSS VDD VDD _09008_ sky130_fd_sc_hd__inv_1
X_12974_ _00792_ _09008_ _00791_ VSS VSS VDD VDD _09009_ sky130_fd_sc_hd__a21oi_1
X_12975_ network.neuron_hid6.IF0.membrane_potential\[6\] network.neuron_hid6.IF0.membrane_potential\[5\]
+ VSS VSS VDD VDD _09010_ sky130_fd_sc_hd__nand2_1
X_12976_ _09009_ _09010_ network.neuron_hid6.IF0.membrane_potential\[7\]
+ VSS VSS VDD VDD _09011_ sky130_fd_sc_hd__nor3b_1
X_12977_ network.neuron_hid6.IF0.membrane_potential\[8\] _09011_
+ VSS VSS VDD VDD _09012_ sky130_fd_sc_hd__xnor2_1
X_12978_ _08995_ _09012_ VSS VSS VDD VDD _01640_ sky130_fd_sc_hd__nor2_1
X_12979_ _09002_ _09010_ network.neuron_hid6.IF0.membrane_potential\[7\]
+ VSS VSS VDD VDD _09013_ sky130_fd_sc_hd__o21ai_0
X_12980_ network.neuron_hid6.IF0.membrane_potential\[7\] _09002_
+ _09010_ VSS VSS VDD VDD _09014_ sky130_fd_sc_hd__or3_1
X_12981_ _09013_ _09014_ _08995_ VSS VSS VDD VDD _01641_ sky130_fd_sc_hd__a21oi_1
X_12982_ _09009_ network.neuron_hid6.IF0.membrane_potential\[5\]
+ VSS VSS VDD VDD _09015_ sky130_fd_sc_hd__nor2b_1
X_12983_ network.neuron_hid6.IF0.membrane_potential\[6\] _09015_
+ VSS VSS VDD VDD _09016_ sky130_fd_sc_hd__xnor2_1
X_12984_ _08995_ _09016_ VSS VSS VDD VDD _01642_ sky130_fd_sc_hd__nor2_1
X_12985_ network.neuron_hid6.IF0.membrane_potential\[5\] _09002_
+ VSS VSS VDD VDD _09017_ sky130_fd_sc_hd__xor2_1
X_12986_ _08995_ _09017_ VSS VSS VDD VDD _01643_ sky130_fd_sc_hd__nor2_1
X_12987_ _00792_ _09007_ VSS VSS VDD VDD _09018_ sky130_fd_sc_hd__xor2_1
X_12988_ _08995_ _09018_ VSS VSS VDD VDD _01644_ sky130_fd_sc_hd__nor2_1
X_12989_ _00856_ _09000_ VSS VSS VDD VDD _09019_ sky130_fd_sc_hd__xnor2_1
X_12990_ _08995_ _09019_ VSS VSS VDD VDD _01645_ sky130_fd_sc_hd__nor2_1
X_12991_ _00003_ _01079_ VSS VSS VDD VDD _09020_ sky130_fd_sc_hd__xnor2_1
X_12992_ _08995_ _09020_ VSS VSS VDD VDD _01646_ sky130_fd_sc_hd__nor2_1
Xplace367 _06660_ VSS VSS VDD VDD net366 sky130_fd_sc_hd__buf_4
X_12994_ network.neuron_hid6.IF0.add_out\[1\] net365 net319
+ VSS VSS VDD VDD _01647_ sky130_fd_sc_hd__and3_1
X_12995_ network.neuron_hid6.IF0.add_out\[0\] net365 net319
+ VSS VSS VDD VDD _01648_ sky130_fd_sc_hd__and3_1
X_12996_ network.neuron_hid5.IF0.membrane_potential\[5\] network.neuron_hid5.IF0.membrane_potential\[0\]
+ network.neuron_hid5.IF0.membrane_potential\[4\] network.neuron_hid5.IF0.membrane_potential\[2\]
+ VSS VSS VDD VDD _09022_ sky130_fd_sc_hd__or4_1
X_12997_ network.neuron_hid5.IF0.membrane_potential\[1\] network.neuron_hid5.IF0.membrane_potential\[3\]
+ _09022_ network.neuron_hid5.IF0.membrane_potential\[6\] VSS
+ VSS VDD VDD _09023_ sky130_fd_sc_hd__o31a_1
X_12998_ network.neuron_hid5.IF0.membrane_potential\[7\] _09023_
+ network.neuron_hid5.IF0.membrane_potential\[8\] VSS VSS VDD
+ VDD _09024_ sky130_fd_sc_hd__o21a_1
X_12999_ network.neuron_hid5.IF0.membrane_potential\[9\] network.neuron_hid5.IF0.membrane_potential\[10\]
+ _09024_ _00052_ VSS VSS VDD VDD _09025_ sky130_fd_sc_hd__o31ai_1
X_13000_ net365 _09025_ VSS VSS VDD VDD _09026_ sky130_fd_sc_hd__nand2_1
Xplace366 net366 VSS VSS VDD VDD net365 sky130_fd_sc_hd__buf_4
X_13002_ _00052_ _08821_ VSS VSS VDD VDD _09028_ sky130_fd_sc_hd__nor2_1
X_13003_ network.neuron_hid5.IF0.ref_counter\[0\] _09028_
+ VSS VSS VDD VDD _09029_ sky130_fd_sc_hd__xnor2_1
X_13004_ _09026_ _09029_ VSS VSS VDD VDD _01649_ sky130_fd_sc_hd__nor2_1
X_13005_ _00340_ _00018_ _00339_ VSS VSS VDD VDD _09030_ sky130_fd_sc_hd__a21o_1
X_13006_ _00117_ _09030_ _00116_ VSS VSS VDD VDD _09031_ sky130_fd_sc_hd__a21o_1
X_13007_ _00859_ _09031_ _00858_ VSS VSS VDD VDD _09032_ sky130_fd_sc_hd__a21o_1
X_13008_ _00153_ _09032_ _00152_ VSS VSS VDD VDD _09033_ sky130_fd_sc_hd__a21oi_1
X_13009_ network.neuron_hid5.IF0.membrane_potential\[6\] network.neuron_hid5.IF0.membrane_potential\[5\]
+ network.neuron_hid5.IF0.membrane_potential\[8\] network.neuron_hid5.IF0.membrane_potential\[7\]
+ VSS VSS VDD VDD _09034_ sky130_fd_sc_hd__nand4_1
X_13010_ _09033_ _09034_ network.neuron_hid5.IF0.membrane_potential\[9\]
+ VSS VSS VDD VDD _09035_ sky130_fd_sc_hd__o21ai_0
X_13011_ network.neuron_hid5.IF0.membrane_potential\[9\] _09033_
+ _09034_ VSS VSS VDD VDD _09036_ sky130_fd_sc_hd__or3_1
X_13012_ _09035_ _09036_ _09026_ VSS VSS VDD VDD _01650_ sky130_fd_sc_hd__a21oi_1
X_13013_ _00117_ _00019_ _00116_ VSS VSS VDD VDD _09037_ sky130_fd_sc_hd__a21o_1
X_13014_ _00859_ _09037_ _00858_ VSS VSS VDD VDD _09038_ sky130_fd_sc_hd__a21oi_1
X_13015_ _09038_ VSS VSS VDD VDD _09039_ sky130_fd_sc_hd__inv_1
X_13016_ _00153_ _09039_ _00152_ VSS VSS VDD VDD _09040_ sky130_fd_sc_hd__a21oi_1
X_13017_ network.neuron_hid5.IF0.membrane_potential\[6\] network.neuron_hid5.IF0.membrane_potential\[5\]
+ VSS VSS VDD VDD _09041_ sky130_fd_sc_hd__nand2_1
X_13018_ _09040_ _09041_ network.neuron_hid5.IF0.membrane_potential\[7\]
+ VSS VSS VDD VDD _09042_ sky130_fd_sc_hd__nor3b_1
X_13019_ network.neuron_hid5.IF0.membrane_potential\[8\] _09042_
+ VSS VSS VDD VDD _09043_ sky130_fd_sc_hd__xnor2_1
X_13020_ _09026_ _09043_ VSS VSS VDD VDD _01651_ sky130_fd_sc_hd__nor2_1
X_13021_ _09033_ _09041_ network.neuron_hid5.IF0.membrane_potential\[7\]
+ VSS VSS VDD VDD _09044_ sky130_fd_sc_hd__o21ai_0
X_13022_ network.neuron_hid5.IF0.membrane_potential\[7\] _09033_
+ _09041_ VSS VSS VDD VDD _09045_ sky130_fd_sc_hd__or3_1
X_13023_ _09044_ _09045_ _09026_ VSS VSS VDD VDD _01652_ sky130_fd_sc_hd__a21oi_1
X_13024_ _09040_ network.neuron_hid5.IF0.membrane_potential\[5\]
+ VSS VSS VDD VDD _09046_ sky130_fd_sc_hd__nor2b_1
X_13025_ network.neuron_hid5.IF0.membrane_potential\[6\] _09046_
+ VSS VSS VDD VDD _09047_ sky130_fd_sc_hd__xnor2_1
X_13026_ _09026_ _09047_ VSS VSS VDD VDD _01653_ sky130_fd_sc_hd__nor2_1
X_13027_ network.neuron_hid5.IF0.membrane_potential\[5\] _09033_
+ VSS VSS VDD VDD _09048_ sky130_fd_sc_hd__xor2_1
X_13028_ _09026_ _09048_ VSS VSS VDD VDD _01654_ sky130_fd_sc_hd__nor2_1
X_13029_ _00153_ _09038_ VSS VSS VDD VDD _09049_ sky130_fd_sc_hd__xor2_1
X_13030_ _09026_ _09049_ VSS VSS VDD VDD _01655_ sky130_fd_sc_hd__nor2_1
X_13031_ _00859_ _09031_ VSS VSS VDD VDD _09050_ sky130_fd_sc_hd__xnor2_1
X_13032_ _09026_ _09050_ VSS VSS VDD VDD _01656_ sky130_fd_sc_hd__nor2_1
X_13033_ _00117_ _00019_ VSS VSS VDD VDD _09051_ sky130_fd_sc_hd__xnor2_1
X_13034_ _09026_ _09051_ VSS VSS VDD VDD _01657_ sky130_fd_sc_hd__nor2_1
X_13035_ network.neuron_hid5.IF0.add_out\[1\] net365 _09025_
+ VSS VSS VDD VDD _01658_ sky130_fd_sc_hd__and3_1
X_13036_ network.neuron_hid5.IF0.add_out\[0\] net365 _09025_
+ VSS VSS VDD VDD _01659_ sky130_fd_sc_hd__and3_1
X_13037_ network.neuron_hid4.IF0.membrane_potential\[5\] network.neuron_hid4.IF0.membrane_potential\[1\]
+ network.neuron_hid4.IF0.membrane_potential\[4\] network.neuron_hid4.IF0.membrane_potential\[0\]
+ VSS VSS VDD VDD _09052_ sky130_fd_sc_hd__or4_1
X_13038_ network.neuron_hid4.IF0.membrane_potential\[3\] network.neuron_hid4.IF0.membrane_potential\[2\]
+ _09052_ network.neuron_hid4.IF0.membrane_potential\[6\] VSS
+ VSS VDD VDD _09053_ sky130_fd_sc_hd__o31a_1
X_13039_ network.neuron_hid4.IF0.membrane_potential\[7\] _09053_
+ network.neuron_hid4.IF0.membrane_potential\[8\] VSS VSS VDD
+ VDD _09054_ sky130_fd_sc_hd__o21a_1
X_13040_ network.neuron_hid4.IF0.membrane_potential\[9\] network.neuron_hid4.IF0.membrane_potential\[10\]
+ _09054_ _01222_ VSS VSS VDD VDD _09055_ sky130_fd_sc_hd__o31ai_1
X_13041_ net365 _09055_ VSS VSS VDD VDD _09056_ sky130_fd_sc_hd__nand2_1
Xplace365 net365 VSS VSS VDD VDD net364 sky130_fd_sc_hd__buf_4
X_13043_ _01222_ _08821_ VSS VSS VDD VDD _09058_ sky130_fd_sc_hd__nor2_1
X_13044_ network.neuron_hid4.IF0.ref_counter\[0\] _09058_
+ VSS VSS VDD VDD _09059_ sky130_fd_sc_hd__xnor2_1
X_13045_ _09056_ _09059_ VSS VSS VDD VDD _01660_ sky130_fd_sc_hd__nor2_1
X_13046_ _00026_ _00075_ _00074_ VSS VSS VDD VDD _09060_ sky130_fd_sc_hd__a21o_1
X_13047_ _00871_ _09060_ _00870_ VSS VSS VDD VDD _09061_ sky130_fd_sc_hd__a21o_1
X_13048_ _00776_ _09061_ _00775_ VSS VSS VDD VDD _09062_ sky130_fd_sc_hd__a21o_1
X_13049_ _00869_ _09062_ _00868_ VSS VSS VDD VDD _09063_ sky130_fd_sc_hd__a21oi_1
X_13050_ network.neuron_hid4.IF0.membrane_potential\[7\] network.neuron_hid4.IF0.membrane_potential\[6\]
+ network.neuron_hid4.IF0.membrane_potential\[5\] network.neuron_hid4.IF0.membrane_potential\[8\]
+ VSS VSS VDD VDD _09064_ sky130_fd_sc_hd__nand4_1
X_13051_ _09063_ _09064_ network.neuron_hid4.IF0.membrane_potential\[9\]
+ VSS VSS VDD VDD _09065_ sky130_fd_sc_hd__o21ai_0
X_13052_ network.neuron_hid4.IF0.membrane_potential\[9\] _09063_
+ _09064_ VSS VSS VDD VDD _09066_ sky130_fd_sc_hd__or3_1
X_13053_ _09065_ _09066_ _09056_ VSS VSS VDD VDD _01661_ sky130_fd_sc_hd__a21oi_1
X_13054_ _00027_ _00871_ _00870_ VSS VSS VDD VDD _09067_ sky130_fd_sc_hd__a21o_1
X_13055_ _00776_ _09067_ _00775_ VSS VSS VDD VDD _09068_ sky130_fd_sc_hd__a21oi_1
X_13056_ _09068_ VSS VSS VDD VDD _09069_ sky130_fd_sc_hd__inv_1
X_13057_ _00869_ _09069_ _00868_ VSS VSS VDD VDD _09070_ sky130_fd_sc_hd__a21oi_1
X_13058_ network.neuron_hid4.IF0.membrane_potential\[6\] network.neuron_hid4.IF0.membrane_potential\[5\]
+ VSS VSS VDD VDD _09071_ sky130_fd_sc_hd__nand2_1
X_13059_ _09070_ _09071_ network.neuron_hid4.IF0.membrane_potential\[7\]
+ VSS VSS VDD VDD _09072_ sky130_fd_sc_hd__nor3b_1
X_13060_ network.neuron_hid4.IF0.membrane_potential\[8\] _09072_
+ VSS VSS VDD VDD _09073_ sky130_fd_sc_hd__xnor2_1
X_13061_ _09056_ _09073_ VSS VSS VDD VDD _01662_ sky130_fd_sc_hd__nor2_1
X_13062_ _09063_ _09071_ network.neuron_hid4.IF0.membrane_potential\[7\]
+ VSS VSS VDD VDD _09074_ sky130_fd_sc_hd__o21ai_0
X_13063_ network.neuron_hid4.IF0.membrane_potential\[7\] _09063_
+ _09071_ VSS VSS VDD VDD _09075_ sky130_fd_sc_hd__or3_1
X_13064_ _09074_ _09075_ _09056_ VSS VSS VDD VDD _01663_ sky130_fd_sc_hd__a21oi_1
X_13065_ _09070_ network.neuron_hid4.IF0.membrane_potential\[5\]
+ VSS VSS VDD VDD _09076_ sky130_fd_sc_hd__nor2b_1
X_13066_ network.neuron_hid4.IF0.membrane_potential\[6\] _09076_
+ VSS VSS VDD VDD _09077_ sky130_fd_sc_hd__xnor2_1
X_13067_ _09056_ _09077_ VSS VSS VDD VDD _01664_ sky130_fd_sc_hd__nor2_1
X_13068_ network.neuron_hid4.IF0.membrane_potential\[5\] _09063_
+ VSS VSS VDD VDD _09078_ sky130_fd_sc_hd__xor2_1
X_13069_ _09056_ _09078_ VSS VSS VDD VDD _01665_ sky130_fd_sc_hd__nor2_1
X_13070_ _00869_ _09068_ VSS VSS VDD VDD _09079_ sky130_fd_sc_hd__xor2_1
X_13071_ _09056_ _09079_ VSS VSS VDD VDD _01666_ sky130_fd_sc_hd__nor2_1
X_13072_ _00776_ _09061_ VSS VSS VDD VDD _09080_ sky130_fd_sc_hd__xnor2_1
X_13073_ _09056_ _09080_ VSS VSS VDD VDD _01667_ sky130_fd_sc_hd__nor2_1
X_13074_ _00027_ _00871_ VSS VSS VDD VDD _09081_ sky130_fd_sc_hd__xnor2_1
X_13075_ _09056_ _09081_ VSS VSS VDD VDD _01668_ sky130_fd_sc_hd__nor2_1
X_13076_ network.neuron_hid4.IF0.add_out\[1\] net365 _09055_
+ VSS VSS VDD VDD _01669_ sky130_fd_sc_hd__and3_1
X_13077_ network.neuron_hid4.IF0.add_out\[0\] net365 _09055_
+ VSS VSS VDD VDD _01670_ sky130_fd_sc_hd__and3_1
X_13078_ network.neuron_hid3.IF0.membrane_potential\[4\] network.neuron_hid3.IF0.membrane_potential\[1\]
+ network.neuron_hid3.IF0.membrane_potential\[5\] network.neuron_hid3.IF0.membrane_potential\[2\]
+ VSS VSS VDD VDD _09082_ sky130_fd_sc_hd__or4_1
X_13079_ network.neuron_hid3.IF0.membrane_potential\[3\] network.neuron_hid3.IF0.membrane_potential\[0\]
+ _09082_ network.neuron_hid3.IF0.membrane_potential\[6\] VSS
+ VSS VDD VDD _09083_ sky130_fd_sc_hd__o31a_1
X_13080_ network.neuron_hid3.IF0.membrane_potential\[7\] _09083_
+ network.neuron_hid3.IF0.membrane_potential\[8\] VSS VSS VDD
+ VDD _09084_ sky130_fd_sc_hd__o21a_1
X_13081_ network.neuron_hid3.IF0.membrane_potential\[9\] network.neuron_hid3.IF0.membrane_potential\[10\]
+ _09084_ _00674_ VSS VSS VDD VDD _09085_ sky130_fd_sc_hd__o31ai_1
X_13082_ net365 _09085_ VSS VSS VDD VDD _09086_ sky130_fd_sc_hd__nand2_1
Xplace364 net364 VSS VSS VDD VDD net363 sky130_fd_sc_hd__buf_4
X_13084_ _00674_ _08821_ VSS VSS VDD VDD _09088_ sky130_fd_sc_hd__nor2_1
X_13085_ network.neuron_hid3.IF0.ref_counter\[0\] _09088_
+ VSS VSS VDD VDD _09089_ sky130_fd_sc_hd__xnor2_1
X_13086_ _09086_ _09089_ VSS VSS VDD VDD _01671_ sky130_fd_sc_hd__nor2_1
X_13087_ _00877_ VSS VSS VDD VDD _09090_ sky130_fd_sc_hd__inv_1
X_13088_ _01063_ VSS VSS VDD VDD _09091_ sky130_fd_sc_hd__inv_1
X_13089_ _00000_ _00088_ _00743_ VSS VSS VDD VDD _09092_ sky130_fd_sc_hd__a21o_1
X_13090_ _00456_ _09092_ _00455_ VSS VSS VDD VDD _09093_ sky130_fd_sc_hd__a21oi_1
X_13091_ _09091_ _09093_ _01062_ VSS VSS VDD VDD _09094_ sky130_fd_sc_hd__o21bai_1
X_13092_ _01073_ _09094_ _01072_ VSS VSS VDD VDD _09095_ sky130_fd_sc_hd__a21oi_1
X_13093_ _09090_ _09095_ _00876_ VSS VSS VDD VDD _09096_ sky130_fd_sc_hd__o21bai_1
X_13094_ network.neuron_hid3.IF0.membrane_potential\[8\] _01202_
+ VSS VSS VDD VDD _09097_ sky130_fd_sc_hd__nand2_1
X_13095_ network.neuron_hid3.IF0.membrane_potential\[8\] _01203_
+ _00889_ VSS VSS VDD VDD _09098_ sky130_fd_sc_hd__nand3_1
X_13096_ _09097_ _09098_ VSS VSS VDD VDD _09099_ sky130_fd_sc_hd__nand2_1
X_13097_ network.neuron_hid3.IF0.membrane_potential\[8\] _01203_
+ _00890_ _09096_ _09099_ VSS VSS VDD VDD _09100_ sky130_fd_sc_hd__a41oi_1
X_13098_ network.neuron_hid3.IF0.membrane_potential\[9\] _09100_
+ VSS VSS VDD VDD _09101_ sky130_fd_sc_hd__xor2_1
X_13099_ _09086_ _09101_ VSS VSS VDD VDD _01672_ sky130_fd_sc_hd__nor2_1
X_13100_ _01073_ VSS VSS VDD VDD _09102_ sky130_fd_sc_hd__inv_1
X_13101_ _00456_ _00001_ _00455_ VSS VSS VDD VDD _09103_ sky130_fd_sc_hd__a21o_1
X_13102_ _01063_ _09103_ _01062_ VSS VSS VDD VDD _09104_ sky130_fd_sc_hd__a21oi_1
X_13103_ _09102_ _09104_ _01072_ VSS VSS VDD VDD _09105_ sky130_fd_sc_hd__o21bai_1
X_13104_ _00877_ _09105_ _00876_ VSS VSS VDD VDD _09106_ sky130_fd_sc_hd__a21oi_1
X_13105_ _01203_ _00890_ VSS VSS VDD VDD _09107_ sky130_fd_sc_hd__nand2_1
X_13106_ _01203_ _00889_ _01202_ VSS VSS VDD VDD _09108_ sky130_fd_sc_hd__a21oi_1
X_13107_ _09106_ _09107_ _09108_ VSS VSS VDD VDD _09109_ sky130_fd_sc_hd__o21ai_0
X_13108_ network.neuron_hid3.IF0.membrane_potential\[8\] _09109_
+ VSS VSS VDD VDD _09110_ sky130_fd_sc_hd__xnor2_1
X_13109_ _09086_ _09110_ VSS VSS VDD VDD _01673_ sky130_fd_sc_hd__nor2_1
X_13110_ _00890_ _09096_ _00889_ VSS VSS VDD VDD _09111_ sky130_fd_sc_hd__a21oi_1
X_13111_ _01203_ _09111_ VSS VSS VDD VDD _09112_ sky130_fd_sc_hd__xor2_1
X_13112_ _09086_ _09112_ VSS VSS VDD VDD _01674_ sky130_fd_sc_hd__nor2_1
X_13113_ _00890_ _09106_ VSS VSS VDD VDD _09113_ sky130_fd_sc_hd__xor2_1
X_13114_ _09086_ _09113_ VSS VSS VDD VDD _01675_ sky130_fd_sc_hd__nor2_1
X_13115_ _09090_ _09095_ VSS VSS VDD VDD _09114_ sky130_fd_sc_hd__xnor2_1
X_13116_ _09086_ _09114_ VSS VSS VDD VDD _01676_ sky130_fd_sc_hd__nor2_1
X_13117_ _09102_ _09104_ VSS VSS VDD VDD _09115_ sky130_fd_sc_hd__xnor2_1
X_13118_ _09086_ _09115_ VSS VSS VDD VDD _01677_ sky130_fd_sc_hd__nor2_1
X_13119_ _09091_ _09093_ VSS VSS VDD VDD _09116_ sky130_fd_sc_hd__xnor2_1
X_13120_ _09086_ _09116_ VSS VSS VDD VDD _01678_ sky130_fd_sc_hd__nor2_1
X_13121_ _00456_ _00001_ VSS VSS VDD VDD _09117_ sky130_fd_sc_hd__xnor2_1
X_13122_ _09086_ _09117_ VSS VSS VDD VDD _01679_ sky130_fd_sc_hd__nor2_1
X_13123_ network.neuron_hid3.IF0.add_out\[1\] net365 _09085_
+ VSS VSS VDD VDD _01680_ sky130_fd_sc_hd__and3_1
X_13124_ network.neuron_hid3.IF0.add_out\[0\] net365 _09085_
+ VSS VSS VDD VDD _01681_ sky130_fd_sc_hd__and3_1
X_13125_ network.neuron_hid2.IF0.membrane_potential\[3\] network.neuron_hid2.IF0.membrane_potential\[5\]
+ network.neuron_hid2.IF0.membrane_potential\[0\] network.neuron_hid2.IF0.membrane_potential\[4\]
+ VSS VSS VDD VDD _09118_ sky130_fd_sc_hd__or4_1
X_13126_ network.neuron_hid2.IF0.membrane_potential\[1\] network.neuron_hid2.IF0.membrane_potential\[2\]
+ _09118_ network.neuron_hid2.IF0.membrane_potential\[6\] VSS
+ VSS VDD VDD _09119_ sky130_fd_sc_hd__o31a_1
X_13127_ network.neuron_hid2.IF0.membrane_potential\[7\] _09119_
+ network.neuron_hid2.IF0.membrane_potential\[8\] VSS VSS VDD
+ VDD _09120_ sky130_fd_sc_hd__o21a_1
X_13128_ network.neuron_hid2.IF0.membrane_potential\[9\] network.neuron_hid2.IF0.membrane_potential\[10\]
+ _09120_ _00156_ VSS VSS VDD VDD _09121_ sky130_fd_sc_hd__o31ai_1
X_13129_ net365 _09121_ VSS VSS VDD VDD _09122_ sky130_fd_sc_hd__nand2_1
Xplace363 net363 VSS VSS VDD VDD net362 sky130_fd_sc_hd__buf_4
X_13131_ _00156_ _08821_ VSS VSS VDD VDD _09124_ sky130_fd_sc_hd__nor2_1
X_13132_ network.neuron_hid2.IF0.ref_counter\[0\] _09124_
+ VSS VSS VDD VDD _09125_ sky130_fd_sc_hd__xnor2_1
X_13133_ _09122_ _09125_ VSS VSS VDD VDD _01682_ sky130_fd_sc_hd__nor2_1
X_13134_ _01240_ VSS VSS VDD VDD _09126_ sky130_fd_sc_hd__inv_1
X_13135_ _00879_ VSS VSS VDD VDD _09127_ sky130_fd_sc_hd__inv_1
X_13136_ _00022_ _00895_ _01238_ VSS VSS VDD VDD _09128_ sky130_fd_sc_hd__a21o_1
X_13137_ _00753_ _09128_ _00752_ VSS VSS VDD VDD _09129_ sky130_fd_sc_hd__a21oi_1
X_13138_ _09127_ _09129_ _00878_ VSS VSS VDD VDD _09130_ sky130_fd_sc_hd__o21bai_1
X_13139_ _01237_ _09130_ _01236_ VSS VSS VDD VDD _09131_ sky130_fd_sc_hd__a21oi_1
X_13140_ _09126_ _09131_ _01239_ VSS VSS VDD VDD _09132_ sky130_fd_sc_hd__o21bai_1
X_13141_ network.neuron_hid2.IF0.membrane_potential\[8\] _01148_
+ VSS VSS VDD VDD _09133_ sky130_fd_sc_hd__nand2_1
X_13142_ network.neuron_hid2.IF0.membrane_potential\[8\] _01149_
+ _00880_ VSS VSS VDD VDD _09134_ sky130_fd_sc_hd__nand3_1
X_13143_ _09133_ _09134_ VSS VSS VDD VDD _09135_ sky130_fd_sc_hd__nand2_1
X_13144_ network.neuron_hid2.IF0.membrane_potential\[8\] _01149_
+ _00881_ _09132_ _09135_ VSS VSS VDD VDD _09136_ sky130_fd_sc_hd__a41oi_1
X_13145_ network.neuron_hid2.IF0.membrane_potential\[9\] _09136_
+ VSS VSS VDD VDD _09137_ sky130_fd_sc_hd__xor2_1
X_13146_ _09122_ _09137_ VSS VSS VDD VDD _01683_ sky130_fd_sc_hd__nor2_1
X_13147_ _01237_ VSS VSS VDD VDD _09138_ sky130_fd_sc_hd__inv_1
X_13148_ _00753_ _00023_ _00752_ VSS VSS VDD VDD _09139_ sky130_fd_sc_hd__a21o_1
X_13149_ _00879_ _09139_ _00878_ VSS VSS VDD VDD _09140_ sky130_fd_sc_hd__a21oi_1
X_13150_ _09138_ _09140_ _01236_ VSS VSS VDD VDD _09141_ sky130_fd_sc_hd__o21bai_1
X_13151_ _01240_ _09141_ _01239_ VSS VSS VDD VDD _09142_ sky130_fd_sc_hd__a21oi_1
X_13152_ _01149_ _00881_ VSS VSS VDD VDD _09143_ sky130_fd_sc_hd__nand2_1
X_13153_ _01149_ _00880_ _01148_ VSS VSS VDD VDD _09144_ sky130_fd_sc_hd__a21oi_1
X_13154_ _09142_ _09143_ _09144_ VSS VSS VDD VDD _09145_ sky130_fd_sc_hd__o21ai_0
X_13155_ network.neuron_hid2.IF0.membrane_potential\[8\] _09145_
+ VSS VSS VDD VDD _09146_ sky130_fd_sc_hd__xnor2_1
X_13156_ _09122_ _09146_ VSS VSS VDD VDD _01684_ sky130_fd_sc_hd__nor2_1
X_13157_ _00881_ _09132_ _00880_ VSS VSS VDD VDD _09147_ sky130_fd_sc_hd__a21oi_1
X_13158_ _01149_ _09147_ VSS VSS VDD VDD _09148_ sky130_fd_sc_hd__xor2_1
X_13159_ _09122_ _09148_ VSS VSS VDD VDD _01685_ sky130_fd_sc_hd__nor2_1
X_13160_ _00881_ _09142_ VSS VSS VDD VDD _09149_ sky130_fd_sc_hd__xor2_1
X_13161_ _09122_ _09149_ VSS VSS VDD VDD _01686_ sky130_fd_sc_hd__nor2_1
X_13162_ _09126_ _09131_ VSS VSS VDD VDD _09150_ sky130_fd_sc_hd__xnor2_1
X_13163_ _09122_ _09150_ VSS VSS VDD VDD _01687_ sky130_fd_sc_hd__nor2_1
X_13164_ _09138_ _09140_ VSS VSS VDD VDD _09151_ sky130_fd_sc_hd__xnor2_1
X_13165_ _09122_ _09151_ VSS VSS VDD VDD _01688_ sky130_fd_sc_hd__nor2_1
X_13166_ _09127_ _09129_ VSS VSS VDD VDD _09152_ sky130_fd_sc_hd__xnor2_1
X_13167_ _09122_ _09152_ VSS VSS VDD VDD _01689_ sky130_fd_sc_hd__nor2_1
X_13168_ _00753_ _00023_ VSS VSS VDD VDD _09153_ sky130_fd_sc_hd__xnor2_1
X_13169_ _09122_ _09153_ VSS VSS VDD VDD _01690_ sky130_fd_sc_hd__nor2_1
X_13170_ network.neuron_hid2.IF0.add_out\[1\] net365 _09121_
+ VSS VSS VDD VDD _01691_ sky130_fd_sc_hd__and3_1
X_13171_ network.neuron_hid2.IF0.add_out\[0\] net365 _09121_
+ VSS VSS VDD VDD _01692_ sky130_fd_sc_hd__and3_1
X_13172_ network.neuron_hid1.IF0.membrane_potential\[5\] network.neuron_hid1.IF0.membrane_potential\[1\]
+ network.neuron_hid1.IF0.membrane_potential\[2\] network.neuron_hid1.IF0.membrane_potential\[3\]
+ VSS VSS VDD VDD _09154_ sky130_fd_sc_hd__or4_1
X_13173_ network.neuron_hid1.IF0.membrane_potential\[0\] network.neuron_hid1.IF0.membrane_potential\[4\]
+ _09154_ network.neuron_hid1.IF0.membrane_potential\[6\] VSS
+ VSS VDD VDD _09155_ sky130_fd_sc_hd__o31a_1
X_13174_ network.neuron_hid1.IF0.membrane_potential\[7\] _09155_
+ network.neuron_hid1.IF0.membrane_potential\[8\] VSS VSS VDD
+ VDD _09156_ sky130_fd_sc_hd__o21a_1
X_13175_ network.neuron_hid1.IF0.membrane_potential\[10\]
+ network.neuron_hid1.IF0.membrane_potential\[9\] _09156_ _01130_
+ VSS VSS VDD VDD _09157_ sky130_fd_sc_hd__o31ai_2
X_13176_ net362 _09157_ VSS VSS VDD VDD _09158_ sky130_fd_sc_hd__nand2_1
Xplace362 net364 VSS VSS VDD VDD net361 sky130_fd_sc_hd__buf_4
X_13178_ _01130_ _08821_ VSS VSS VDD VDD _09160_ sky130_fd_sc_hd__nor2_1
X_13179_ network.neuron_hid1.IF0.ref_counter\[0\] _09160_
+ VSS VSS VDD VDD _09161_ sky130_fd_sc_hd__xnor2_1
X_13180_ _09158_ _09161_ VSS VSS VDD VDD _01693_ sky130_fd_sc_hd__nor2_1
X_13181_ _00788_ _00024_ _00787_ VSS VSS VDD VDD _09162_ sky130_fd_sc_hd__a21o_1
X_13182_ _00778_ _09162_ _00777_ VSS VSS VDD VDD _09163_ sky130_fd_sc_hd__a21o_1
X_13183_ _00751_ _09163_ _00750_ VSS VSS VDD VDD _09164_ sky130_fd_sc_hd__a21o_1
X_13184_ _01019_ _09164_ _01018_ VSS VSS VDD VDD _09165_ sky130_fd_sc_hd__a21oi_1
X_13185_ network.neuron_hid1.IF0.membrane_potential\[5\] network.neuron_hid1.IF0.membrane_potential\[7\]
+ network.neuron_hid1.IF0.membrane_potential\[6\] network.neuron_hid1.IF0.membrane_potential\[8\]
+ VSS VSS VDD VDD _09166_ sky130_fd_sc_hd__nand4_1
X_13186_ _09165_ _09166_ network.neuron_hid1.IF0.membrane_potential\[9\]
+ VSS VSS VDD VDD _09167_ sky130_fd_sc_hd__o21ai_0
X_13187_ network.neuron_hid1.IF0.membrane_potential\[9\] _09165_
+ _09166_ VSS VSS VDD VDD _09168_ sky130_fd_sc_hd__or3_1
X_13188_ _09167_ _09168_ _09158_ VSS VSS VDD VDD _01694_ sky130_fd_sc_hd__a21oi_1
X_13189_ _00778_ _00025_ _00777_ VSS VSS VDD VDD _09169_ sky130_fd_sc_hd__a21o_1
X_13190_ _00751_ _09169_ _00750_ VSS VSS VDD VDD _09170_ sky130_fd_sc_hd__a21oi_1
X_13191_ _09170_ VSS VSS VDD VDD _09171_ sky130_fd_sc_hd__inv_1
X_13192_ _01019_ _09171_ _01018_ VSS VSS VDD VDD _09172_ sky130_fd_sc_hd__a21oi_1
X_13193_ network.neuron_hid1.IF0.membrane_potential\[5\] network.neuron_hid1.IF0.membrane_potential\[6\]
+ VSS VSS VDD VDD _09173_ sky130_fd_sc_hd__nand2_1
X_13194_ _09172_ _09173_ network.neuron_hid1.IF0.membrane_potential\[7\]
+ VSS VSS VDD VDD _09174_ sky130_fd_sc_hd__nor3b_1
X_13195_ network.neuron_hid1.IF0.membrane_potential\[8\] _09174_
+ VSS VSS VDD VDD _09175_ sky130_fd_sc_hd__xnor2_1
X_13196_ _09158_ _09175_ VSS VSS VDD VDD _01695_ sky130_fd_sc_hd__nor2_1
X_13197_ _09165_ _09173_ network.neuron_hid1.IF0.membrane_potential\[7\]
+ VSS VSS VDD VDD _09176_ sky130_fd_sc_hd__o21ai_0
X_13198_ network.neuron_hid1.IF0.membrane_potential\[7\] _09165_
+ _09173_ VSS VSS VDD VDD _09177_ sky130_fd_sc_hd__or3_1
X_13199_ _09176_ _09177_ _09158_ VSS VSS VDD VDD _01696_ sky130_fd_sc_hd__a21oi_1
X_13200_ _09172_ network.neuron_hid1.IF0.membrane_potential\[5\]
+ VSS VSS VDD VDD _09178_ sky130_fd_sc_hd__nor2b_1
X_13201_ network.neuron_hid1.IF0.membrane_potential\[6\] _09178_
+ VSS VSS VDD VDD _09179_ sky130_fd_sc_hd__xnor2_1
X_13202_ _09158_ _09179_ VSS VSS VDD VDD _01697_ sky130_fd_sc_hd__nor2_1
X_13203_ network.neuron_hid1.IF0.membrane_potential\[5\] _09165_
+ VSS VSS VDD VDD _09180_ sky130_fd_sc_hd__xor2_1
X_13204_ _09158_ _09180_ VSS VSS VDD VDD _01698_ sky130_fd_sc_hd__nor2_1
X_13205_ _01019_ _09170_ VSS VSS VDD VDD _09181_ sky130_fd_sc_hd__xor2_1
X_13206_ _09158_ _09181_ VSS VSS VDD VDD _01699_ sky130_fd_sc_hd__nor2_1
X_13207_ _00751_ _09163_ VSS VSS VDD VDD _09182_ sky130_fd_sc_hd__xnor2_1
X_13208_ _09158_ _09182_ VSS VSS VDD VDD _01700_ sky130_fd_sc_hd__nor2_1
X_13209_ _00778_ _00025_ VSS VSS VDD VDD _09183_ sky130_fd_sc_hd__xnor2_1
X_13210_ _09158_ _09183_ VSS VSS VDD VDD _01701_ sky130_fd_sc_hd__nor2_1
X_13211_ network.neuron_hid1.IF0.add_out\[1\] net362 _09157_
+ VSS VSS VDD VDD _01702_ sky130_fd_sc_hd__and3_1
X_13212_ network.neuron_hid1.IF0.add_out\[0\] net362 _09157_
+ VSS VSS VDD VDD _01703_ sky130_fd_sc_hd__and3_1
Xplace361 net365 VSS VSS VDD VDD net360 sky130_fd_sc_hd__buf_4
X_13214_ network.ctrl_addr\[6\] net348 VSS VSS VDD VDD _01704_
+ sky130_fd_sc_hd__and2_1
X_13215_ network.ctrl_addr\[5\] net348 VSS VSS VDD VDD _01705_
+ sky130_fd_sc_hd__and2_1
X_13216_ network.ctrl_addr\[4\] net348 VSS VSS VDD VDD _01706_
+ sky130_fd_sc_hd__and2_1
X_13217_ network.ctrl_addr\[3\] net348 VSS VSS VDD VDD _01707_
+ sky130_fd_sc_hd__and2_1
X_13218_ network.ctrl_addr\[2\] net361 VSS VSS VDD VDD _01708_
+ sky130_fd_sc_hd__and2_1
X_13219_ network.ctrl_addr\[1\] net361 VSS VSS VDD VDD _01709_
+ sky130_fd_sc_hd__and2_1
X_13220_ network.ctrl_addr\[0\] net361 VSS VSS VDD VDD _01710_
+ sky130_fd_sc_hd__and2_1
X_13221_ network.neuron_hid0.IF0.membrane_potential\[5\] network.neuron_hid0.IF0.membrane_potential\[0\]
+ network.neuron_hid0.IF0.membrane_potential\[2\] network.neuron_hid0.IF0.membrane_potential\[4\]
+ VSS VSS VDD VDD _09185_ sky130_fd_sc_hd__or4_1
X_13222_ network.neuron_hid0.IF0.membrane_potential\[3\] network.neuron_hid0.IF0.membrane_potential\[1\]
+ _09185_ network.neuron_hid0.IF0.membrane_potential\[6\] VSS
+ VSS VDD VDD _09186_ sky130_fd_sc_hd__o31a_1
X_13223_ network.neuron_hid0.IF0.membrane_potential\[7\] _09186_
+ network.neuron_hid0.IF0.membrane_potential\[8\] VSS VSS VDD
+ VDD _09187_ sky130_fd_sc_hd__o21a_1
X_13224_ network.neuron_hid0.IF0.membrane_potential\[9\] network.neuron_hid0.IF0.membrane_potential\[10\]
+ _09187_ _01046_ VSS VSS VDD VDD _09188_ sky130_fd_sc_hd__o31ai_2
X_13225_ net362 net318 VSS VSS VDD VDD _09189_ sky130_fd_sc_hd__nand2_1
Xplace360 net360 VSS VSS VDD VDD net359 sky130_fd_sc_hd__buf_4
X_13227_ _01046_ _08821_ VSS VSS VDD VDD _09191_ sky130_fd_sc_hd__nor2_1
X_13228_ network.neuron_hid0.IF0.ref_counter\[0\] _09191_
+ VSS VSS VDD VDD _09192_ sky130_fd_sc_hd__xnor2_1
X_13229_ _09189_ _09192_ VSS VSS VDD VDD _01711_ sky130_fd_sc_hd__nor2_1
X_13230_ _00194_ _00020_ _00193_ VSS VSS VDD VDD _09193_ sky130_fd_sc_hd__a21o_1
X_13231_ _00810_ _09193_ _00809_ VSS VSS VDD VDD _09194_ sky130_fd_sc_hd__a21o_1
X_13232_ _00887_ _09194_ _00886_ VSS VSS VDD VDD _09195_ sky130_fd_sc_hd__a21o_1
X_13233_ _00917_ _09195_ _00916_ VSS VSS VDD VDD _09196_ sky130_fd_sc_hd__a21oi_1
X_13234_ network.neuron_hid0.IF0.membrane_potential\[7\] network.neuron_hid0.IF0.membrane_potential\[5\]
+ network.neuron_hid0.IF0.membrane_potential\[8\] network.neuron_hid0.IF0.membrane_potential\[6\]
+ VSS VSS VDD VDD _09197_ sky130_fd_sc_hd__nand4_1
X_13235_ _09196_ _09197_ network.neuron_hid0.IF0.membrane_potential\[9\]
+ VSS VSS VDD VDD _09198_ sky130_fd_sc_hd__o21ai_0
X_13236_ network.neuron_hid0.IF0.membrane_potential\[9\] _09196_
+ _09197_ VSS VSS VDD VDD _09199_ sky130_fd_sc_hd__or3_1
X_13237_ _09198_ _09199_ _09189_ VSS VSS VDD VDD _01712_ sky130_fd_sc_hd__a21oi_1
X_13238_ _00810_ _00021_ _00809_ VSS VSS VDD VDD _09200_ sky130_fd_sc_hd__a21o_1
X_13239_ _00887_ _09200_ _00886_ VSS VSS VDD VDD _09201_ sky130_fd_sc_hd__a21oi_1
X_13240_ _09201_ VSS VSS VDD VDD _09202_ sky130_fd_sc_hd__inv_1
X_13241_ _00917_ _09202_ _00916_ VSS VSS VDD VDD _09203_ sky130_fd_sc_hd__a21oi_1
X_13242_ network.neuron_hid0.IF0.membrane_potential\[5\] network.neuron_hid0.IF0.membrane_potential\[6\]
+ VSS VSS VDD VDD _09204_ sky130_fd_sc_hd__nand2_1
X_13243_ _09203_ _09204_ network.neuron_hid0.IF0.membrane_potential\[7\]
+ VSS VSS VDD VDD _09205_ sky130_fd_sc_hd__nor3b_1
X_13244_ network.neuron_hid0.IF0.membrane_potential\[8\] _09205_
+ VSS VSS VDD VDD _09206_ sky130_fd_sc_hd__xnor2_1
X_13245_ _09189_ _09206_ VSS VSS VDD VDD _01713_ sky130_fd_sc_hd__nor2_1
X_13246_ _09196_ _09204_ network.neuron_hid0.IF0.membrane_potential\[7\]
+ VSS VSS VDD VDD _09207_ sky130_fd_sc_hd__o21ai_0
X_13247_ network.neuron_hid0.IF0.membrane_potential\[7\] _09196_
+ _09204_ VSS VSS VDD VDD _09208_ sky130_fd_sc_hd__or3_1
X_13248_ _09207_ _09208_ _09189_ VSS VSS VDD VDD _01714_ sky130_fd_sc_hd__a21oi_1
X_13249_ _09203_ network.neuron_hid0.IF0.membrane_potential\[5\]
+ VSS VSS VDD VDD _09209_ sky130_fd_sc_hd__nor2b_1
X_13250_ network.neuron_hid0.IF0.membrane_potential\[6\] _09209_
+ VSS VSS VDD VDD _09210_ sky130_fd_sc_hd__xnor2_1
X_13251_ _09189_ _09210_ VSS VSS VDD VDD _01715_ sky130_fd_sc_hd__nor2_1
X_13252_ network.neuron_hid0.IF0.membrane_potential\[5\] _09196_
+ VSS VSS VDD VDD _09211_ sky130_fd_sc_hd__xor2_1
X_13253_ _09189_ _09211_ VSS VSS VDD VDD _01716_ sky130_fd_sc_hd__nor2_1
X_13254_ _00917_ _09201_ VSS VSS VDD VDD _09212_ sky130_fd_sc_hd__xor2_1
X_13255_ _09189_ _09212_ VSS VSS VDD VDD _01717_ sky130_fd_sc_hd__nor2_1
X_13256_ _00887_ _09194_ VSS VSS VDD VDD _09213_ sky130_fd_sc_hd__xnor2_1
X_13257_ _09189_ _09213_ VSS VSS VDD VDD _01718_ sky130_fd_sc_hd__nor2_1
X_13258_ _00810_ _00021_ VSS VSS VDD VDD _09214_ sky130_fd_sc_hd__xnor2_1
X_13259_ _09189_ _09214_ VSS VSS VDD VDD _01719_ sky130_fd_sc_hd__nor2_1
X_13260_ network.neuron_hid0.IF0.add_out\[1\] net362 net318
+ VSS VSS VDD VDD _01720_ sky130_fd_sc_hd__and3_1
X_13261_ network.neuron_hid0.IF0.add_out\[0\] net362 net318
+ VSS VSS VDD VDD _01721_ sky130_fd_sc_hd__and3_1
X_13262_ network.in_spk04_07 network.in_spk05_07 network.in_spk06_07
+ network.in_spk07_07 VSS VSS VDD VDD _09215_ sky130_fd_sc_hd__nor4_1
X_13263_ network.in_spk00_07 network.in_spk01_07 network.in_spk02_07
+ network.in_spk03_07 VSS VSS VDD VDD _09216_ sky130_fd_sc_hd__nor4_1
X_13264_ network.in_spk08_07 network.in_spk09_07 network.in_spk10_07
+ network.in_spk11_07 VSS VSS VDD VDD _09217_ sky130_fd_sc_hd__nor4_1
X_13265_ network.in_spk12_07 network.in_spk13_07 network.in_spk14_07
+ network.in_spk15_07 VSS VSS VDD VDD _09218_ sky130_fd_sc_hd__nor4_1
X_13266_ _09215_ _09216_ _09217_ _09218_ VSS VSS VDD VDD _09219_
+ sky130_fd_sc_hd__and4_1
Xplace359 net359 VSS VSS VDD VDD net358 sky130_fd_sc_hd__buf_4
X_13268_ network.in_spk08_05 network.in_spk09_05 network.in_spk10_05
+ network.in_spk11_05 VSS VSS VDD VDD _09221_ sky130_fd_sc_hd__nor4_2
X_13269_ network.in_spk12_05 network.in_spk13_05 network.in_spk14_05
+ network.in_spk15_05 VSS VSS VDD VDD _09222_ sky130_fd_sc_hd__nor4_1
X_13270_ network.in_spk04_05 network.in_spk05_05 network.in_spk06_05
+ network.in_spk07_05 VSS VSS VDD VDD _09223_ sky130_fd_sc_hd__nor4_1
X_13271_ network.in_spk00_05 network.in_spk01_05 network.in_spk02_05
+ network.in_spk03_05 VSS VSS VDD VDD _09224_ sky130_fd_sc_hd__nor4_1
X_13272_ _09221_ _09222_ _09223_ _09224_ VSS VSS VDD VDD _09225_
+ sky130_fd_sc_hd__and4_1
Xplace358 net358 VSS VSS VDD VDD net357 sky130_fd_sc_hd__buf_4
X_13274_ network.in_spk02_06 network.in_spk03_06 network.in_spk00_06
+ network.in_spk01_06 VSS VSS VDD VDD _09227_ sky130_fd_sc_hd__nor4_1
X_13275_ network.in_spk04_06 network.in_spk05_06 network.in_spk06_06
+ network.in_spk07_06 VSS VSS VDD VDD _09228_ sky130_fd_sc_hd__nor4_1
X_13276_ network.in_spk12_06 network.in_spk13_06 network.in_spk14_06
+ network.in_spk15_06 VSS VSS VDD VDD _09229_ sky130_fd_sc_hd__nor4_1
X_13277_ network.in_spk08_06 network.in_spk09_06 network.in_spk10_06
+ network.in_spk11_06 VSS VSS VDD VDD _09230_ sky130_fd_sc_hd__nor4_1
X_13278_ _09227_ _09228_ _09229_ _09230_ VSS VSS VDD VDD _09231_
+ sky130_fd_sc_hd__and4_1
X_13279_ network.in_spk12_04 network.in_spk13_04 network.in_spk14_04
+ network.in_spk15_04 VSS VSS VDD VDD _09232_ sky130_fd_sc_hd__nor4_1
X_13280_ network.in_spk00_04 network.in_spk01_04 network.in_spk02_04
+ network.in_spk03_04 VSS VSS VDD VDD _09233_ sky130_fd_sc_hd__nor4_1
Xplace357 net358 VSS VSS VDD VDD net356 sky130_fd_sc_hd__buf_4
X_13282_ network.in_spk04_04 network.in_spk05_04 network.in_spk06_04
+ network.in_spk07_04 VSS VSS VDD VDD _09235_ sky130_fd_sc_hd__nor4_1
X_13283_ network.in_spk08_04 network.in_spk09_04 network.in_spk10_04
+ network.in_spk11_04 VSS VSS VDD VDD _09236_ sky130_fd_sc_hd__nor4_1
X_13284_ _09232_ _09233_ _09235_ _09236_ VSS VSS VDD VDD _09237_
+ sky130_fd_sc_hd__and4_1
Xplace356 net358 VSS VSS VDD VDD net355 sky130_fd_sc_hd__buf_4
X_13286_ _09219_ _09225_ _09231_ net330 VSS VSS VDD VDD _09239_
+ sky130_fd_sc_hd__nand4_1
X_13287_ network.in_spk00_12 network.in_spk01_12 network.in_spk02_12
+ network.in_spk03_12 VSS VSS VDD VDD _09240_ sky130_fd_sc_hd__nor4_1
X_13288_ network.in_spk04_12 network.in_spk05_12 network.in_spk06_12
+ network.in_spk07_12 VSS VSS VDD VDD _09241_ sky130_fd_sc_hd__nor4_1
X_13289_ network.in_spk08_12 network.in_spk09_12 network.in_spk10_12
+ network.in_spk11_12 VSS VSS VDD VDD _09242_ sky130_fd_sc_hd__nor4_1
Xplace355 net358 VSS VSS VDD VDD net354 sky130_fd_sc_hd__buf_4
X_13291_ network.in_spk12_12 network.in_spk13_12 network.in_spk14_12
+ network.in_spk15_12 VSS VSS VDD VDD _09244_ sky130_fd_sc_hd__nor4_1
X_13292_ net369 _09241_ _09242_ _09244_ VSS VSS VDD VDD _09245_
+ sky130_fd_sc_hd__nand4_1
X_13293_ network.in_spk00_13 network.in_spk01_13 network.in_spk02_13
+ network.in_spk03_13 VSS VSS VDD VDD _09246_ sky130_fd_sc_hd__nor4_1
X_13294_ network.in_spk04_13 network.in_spk05_13 network.in_spk06_13
+ network.in_spk07_13 VSS VSS VDD VDD _09247_ sky130_fd_sc_hd__nor4_1
X_13295_ _09246_ _09247_ VSS VSS VDD VDD _09248_ sky130_fd_sc_hd__nand2_1
Xplace354 net354 VSS VSS VDD VDD net353 sky130_fd_sc_hd__buf_4
X_13297_ network.in_spk08_13 network.in_spk09_13 network.in_spk10_13
+ network.in_spk11_13 VSS VSS VDD VDD _09250_ sky130_fd_sc_hd__nor4_1
X_13298_ network.in_spk12_13 network.in_spk13_13 network.in_spk14_13
+ network.in_spk15_13 VSS VSS VDD VDD _09251_ sky130_fd_sc_hd__nor4_1
X_13299_ _09250_ _09251_ VSS VSS VDD VDD _09252_ sky130_fd_sc_hd__nand2_1
X_13300_ _09245_ _09248_ _09252_ VSS VSS VDD VDD _09253_ sky130_fd_sc_hd__nor3_1
X_13301_ network.in_spk03_15 network.in_spk02_15 network.in_spk01_15
+ network.in_spk00_15 VSS VSS VDD VDD _09254_ sky130_fd_sc_hd__or4_1
X_13302_ network.in_spk06_15 network.in_spk05_15 network.in_spk04_15
+ _09254_ VSS VSS VDD VDD _09255_ sky130_fd_sc_hd__or4_1
X_13303_ network.in_spk10_15 network.in_spk09_15 network.in_spk08_15
+ VSS VSS VDD VDD _09256_ sky130_fd_sc_hd__or3_1
X_13304_ network.in_spk11_15 network.in_spk07_15 _09255_ _09256_
+ VSS VSS VDD VDD _09257_ sky130_fd_sc_hd__nor4_1
X_13305_ network.in_spk15_15 network.in_spk14_15 network.in_spk13_15
+ network.in_spk12_15 VSS VSS VDD VDD _09258_ sky130_fd_sc_hd__nor4_1
X_13306_ network.in_spk15_14 network.in_spk14_14 network.in_spk13_14
+ network.in_spk12_14 VSS VSS VDD VDD _09259_ sky130_fd_sc_hd__or4_1
X_13307_ network.in_spk04_14 network.in_spk05_14 network.in_spk06_14
+ network.in_spk07_14 VSS VSS VDD VDD _09260_ sky130_fd_sc_hd__nor4_1
X_13308_ network.in_spk02_14 network.in_spk03_14 network.in_spk00_14
+ network.in_spk01_14 VSS VSS VDD VDD _09261_ sky130_fd_sc_hd__nor4_1
X_13309_ network.in_spk10_14 network.in_spk09_14 network.in_spk08_14
+ network.in_spk11_14 VSS VSS VDD VDD _09262_ sky130_fd_sc_hd__nor4_1
X_13310_ _09260_ _09261_ _09262_ VSS VSS VDD VDD _09263_ sky130_fd_sc_hd__nand3_1
X_13311_ _09257_ _09258_ _09259_ _09263_ VSS VSS VDD VDD _09264_
+ sky130_fd_sc_hd__a211o_1
X_13312_ network.in_spk08_11 network.in_spk09_11 network.in_spk10_11
+ network.in_spk11_11 VSS VSS VDD VDD _09265_ sky130_fd_sc_hd__or4_1
Xplace353 net359 VSS VSS VDD VDD net352 sky130_fd_sc_hd__buf_4
X_13314_ network.in_spk00_11 network.in_spk01_11 network.in_spk02_11
+ network.in_spk03_11 VSS VSS VDD VDD _09267_ sky130_fd_sc_hd__nor4_1
X_13315_ network.in_spk04_11 network.in_spk05_11 network.in_spk06_11
+ network.in_spk07_11 VSS VSS VDD VDD _09268_ sky130_fd_sc_hd__nor4_1
X_13316_ network.in_spk12_11 network.in_spk13_11 network.in_spk14_11
+ network.in_spk15_11 VSS VSS VDD VDD _09269_ sky130_fd_sc_hd__nor4_1
X_13317_ _09265_ _09267_ _09268_ _09269_ VSS VSS VDD VDD _09270_
+ sky130_fd_sc_hd__nand4b_1
X_13318_ network.in_spk12_08 network.in_spk13_08 network.in_spk14_08
+ network.in_spk15_08 VSS VSS VDD VDD _09271_ sky130_fd_sc_hd__nor4_1
X_13319_ network.in_spk08_08 network.in_spk09_08 network.in_spk10_08
+ network.in_spk11_08 VSS VSS VDD VDD _09272_ sky130_fd_sc_hd__nor4_1
X_13320_ network.in_spk00_08 network.in_spk01_08 network.in_spk02_08
+ network.in_spk03_08 VSS VSS VDD VDD _09273_ sky130_fd_sc_hd__nor4_1
X_13321_ network.in_spk04_08 network.in_spk05_08 network.in_spk06_08
+ network.in_spk07_08 VSS VSS VDD VDD _09274_ sky130_fd_sc_hd__nor4_1
X_13322_ _09271_ _09272_ _09273_ _09274_ VSS VSS VDD VDD _09275_
+ sky130_fd_sc_hd__nand4_1
X_13323_ network.in_spk00_09 network.in_spk01_09 network.in_spk02_09
+ network.in_spk03_09 VSS VSS VDD VDD _09276_ sky130_fd_sc_hd__nor4_1
X_13324_ network.in_spk04_09 network.in_spk05_09 network.in_spk06_09
+ network.in_spk07_09 VSS VSS VDD VDD _09277_ sky130_fd_sc_hd__nor4_1
X_13325_ network.in_spk08_09 network.in_spk09_09 network.in_spk10_09
+ network.in_spk11_09 VSS VSS VDD VDD _09278_ sky130_fd_sc_hd__nor4_1
X_13326_ network.in_spk12_09 network.in_spk13_09 network.in_spk14_09
+ network.in_spk15_09 VSS VSS VDD VDD _09279_ sky130_fd_sc_hd__nor4_1
X_13327_ net368 _09277_ _09278_ _09279_ VSS VSS VDD VDD _09280_
+ sky130_fd_sc_hd__nand4_1
Xplace352 net352 VSS VSS VDD VDD net351 sky130_fd_sc_hd__buf_4
X_13329_ network.in_spk12_10 network.in_spk13_10 network.in_spk14_10
+ network.in_spk15_10 VSS VSS VDD VDD _09282_ sky130_fd_sc_hd__nor4_1
X_13330_ network.in_spk00_10 network.in_spk01_10 network.in_spk02_10
+ network.in_spk03_10 VSS VSS VDD VDD _09283_ sky130_fd_sc_hd__nor4_1
X_13331_ network.in_spk04_10 network.in_spk05_10 network.in_spk06_10
+ network.in_spk07_10 VSS VSS VDD VDD _09284_ sky130_fd_sc_hd__nor4_1
Xplace351 net352 VSS VSS VDD VDD net350 sky130_fd_sc_hd__buf_4
Xplace350 net350 VSS VSS VDD VDD net349 sky130_fd_sc_hd__buf_4
X_13334_ network.in_spk08_10 network.in_spk09_10 network.in_spk10_10
+ network.in_spk11_10 VSS VSS VDD VDD _09287_ sky130_fd_sc_hd__nor4_1
X_13335_ _09282_ _09283_ _09284_ _09287_ VSS VSS VDD VDD _09288_
+ sky130_fd_sc_hd__nand4_1
X_13336_ _09270_ net329 _09280_ _09288_ VSS VSS VDD VDD _09289_
+ sky130_fd_sc_hd__or4_1
Xplace349 net360 VSS VSS VDD VDD net348 sky130_fd_sc_hd__buf_4
X_13338_ net325 _09264_ _09289_ VSS VSS VDD VDD _09291_ sky130_fd_sc_hd__a21oi_1
X_13339_ network.in_spk00_03 network.in_spk01_03 network.in_spk02_03
+ network.in_spk03_03 VSS VSS VDD VDD _09292_ sky130_fd_sc_hd__nor4_1
Xplace348 net348 VSS VSS VDD VDD net347 sky130_fd_sc_hd__buf_4
X_13341_ network.in_spk04_03 network.in_spk05_03 network.in_spk06_03
+ network.in_spk07_03 VSS VSS VDD VDD _09294_ sky130_fd_sc_hd__nor4_1
X_13342_ network.in_spk08_03 network.in_spk09_03 network.in_spk10_03
+ network.in_spk11_03 VSS VSS VDD VDD _09295_ sky130_fd_sc_hd__nor4_1
X_13343_ network.in_spk12_03 network.in_spk13_03 network.in_spk14_03
+ network.in_spk15_03 VSS VSS VDD VDD _09296_ sky130_fd_sc_hd__nor4_1
X_13344_ _09292_ _09294_ _09295_ _09296_ VSS VSS VDD VDD _09297_
+ sky130_fd_sc_hd__nand4_1
X_13345_ network.in_spk12_00 network.in_spk13_00 network.in_spk14_00
+ network.in_spk15_00 VSS VSS VDD VDD _09298_ sky130_fd_sc_hd__nor4_1
X_13346_ network.in_spk08_00 network.in_spk09_00 network.in_spk10_00
+ network.in_spk11_00 VSS VSS VDD VDD _09299_ sky130_fd_sc_hd__nor4_1
X_13347_ network.in_spk00_00 network.in_spk01_00 network.in_spk02_00
+ network.in_spk03_00 VSS VSS VDD VDD _09300_ sky130_fd_sc_hd__nor4_1
X_13348_ network.in_spk04_00 network.in_spk05_00 network.in_spk06_00
+ network.in_spk07_00 VSS VSS VDD VDD _09301_ sky130_fd_sc_hd__nor4_1
X_13349_ _09298_ _09299_ _09300_ _09301_ VSS VSS VDD VDD _09302_
+ sky130_fd_sc_hd__nand4_1
X_13350_ network.in_spk00_01 network.in_spk01_01 network.in_spk02_01
+ network.in_spk03_01 VSS VSS VDD VDD _09303_ sky130_fd_sc_hd__or4_1
X_13351_ network.in_spk04_01 network.in_spk05_01 network.in_spk06_01
+ network.in_spk07_01 VSS VSS VDD VDD _09304_ sky130_fd_sc_hd__or4_1
X_13352_ network.in_spk08_01 network.in_spk09_01 network.in_spk10_01
+ network.in_spk11_01 VSS VSS VDD VDD _09305_ sky130_fd_sc_hd__or4_1
Xplace347 net347 VSS VSS VDD VDD net346 sky130_fd_sc_hd__buf_4
X_13354_ network.in_spk12_01 network.in_spk13_01 network.in_spk14_01
+ network.in_spk15_01 VSS VSS VDD VDD _09307_ sky130_fd_sc_hd__or4_1
X_13355_ _09303_ _09304_ _09305_ _09307_ VSS VSS VDD VDD _09308_
+ sky130_fd_sc_hd__or4_4
X_13356_ network.in_spk08_02 network.in_spk09_02 network.in_spk10_02
+ network.in_spk11_02 VSS VSS VDD VDD _09309_ sky130_fd_sc_hd__nor4_1
X_13357_ network.in_spk12_02 network.in_spk13_02 network.in_spk14_02
+ network.in_spk15_02 VSS VSS VDD VDD _09310_ sky130_fd_sc_hd__nor4_1
X_13358_ network.in_spk00_02 network.in_spk01_02 network.in_spk02_02
+ network.in_spk03_02 VSS VSS VDD VDD _09311_ sky130_fd_sc_hd__nor4_1
Xplace346 net346 VSS VSS VDD VDD net345 sky130_fd_sc_hd__buf_4
X_13360_ network.in_spk04_02 network.in_spk05_02 network.in_spk06_02
+ network.in_spk07_02 VSS VSS VDD VDD _09313_ sky130_fd_sc_hd__nor4_1
X_13361_ net367 _09310_ _09311_ _09313_ VSS VSS VDD VDD _09314_
+ sky130_fd_sc_hd__nand4_1
X_13362_ _09297_ _09302_ _09308_ _09314_ VSS VSS VDD VDD _09315_
+ sky130_fd_sc_hd__nor4_4
Xplace345 net366 VSS VSS VDD VDD net344 sky130_fd_sc_hd__buf_4
Xplace344 net344 VSS VSS VDD VDD net343 sky130_fd_sc_hd__buf_4
X_13365_ _09239_ _09291_ net324 VSS VSS VDD VDD _09318_ sky130_fd_sc_hd__o21ai_0
X_13366_ _09215_ _09216_ _09217_ _09218_ VSS VSS VDD VDD _09319_
+ sky130_fd_sc_hd__nand4_1
X_13367_ _09221_ _09222_ _09223_ _09224_ VSS VSS VDD VDD _09320_
+ sky130_fd_sc_hd__nand4_1
X_13368_ _09227_ _09228_ _09229_ _09230_ VSS VSS VDD VDD _09321_
+ sky130_fd_sc_hd__nand4_1
X_13369_ _09232_ _09233_ _09235_ _09236_ VSS VSS VDD VDD _09322_
+ sky130_fd_sc_hd__nand4_1
X_13370_ _09319_ _09320_ _09321_ _09322_ VSS VSS VDD VDD _09323_
+ sky130_fd_sc_hd__nor4_2
X_13371_ net324 net323 VSS VSS VDD VDD _09324_ sky130_fd_sc_hd__nand2_2
X_13372_ _09259_ _09263_ net325 VSS VSS VDD VDD _09325_ sky130_fd_sc_hd__o21ai_0
X_13373_ _09289_ _09324_ _09325_ VSS VSS VDD VDD _09326_ sky130_fd_sc_hd__or3_1
X_13374_ _09318_ _09326_ net417 VSS VSS VDD VDD _01722_ sky130_fd_sc_hd__a21oi_1
X_13375_ _09320_ _09321_ _09322_ VSS VSS VDD VDD _09327_ sky130_fd_sc_hd__nor3_1
X_13376_ net324 _09327_ VSS VSS VDD VDD _09328_ sky130_fd_sc_hd__nand2_1
X_13377_ _09219_ _09328_ VSS VSS VDD VDD _09329_ sky130_fd_sc_hd__nor2_1
X_13378_ _09246_ _09247_ _09250_ _09251_ VSS VSS VDD VDD _09330_
+ sky130_fd_sc_hd__and4_1
X_13379_ _09245_ _09330_ VSS VSS VDD VDD _09331_ sky130_fd_sc_hd__nand2b_1
X_13380_ _09270_ net329 _09280_ _09288_ VSS VSS VDD VDD _09332_
+ sky130_fd_sc_hd__nor4_1
X_13381_ net324 net323 _09332_ VSS VSS VDD VDD _09333_ sky130_fd_sc_hd__nand3_2
X_13382_ _09331_ _09264_ _09333_ VSS VSS VDD VDD _09334_ sky130_fd_sc_hd__nor3_1
X_13383_ network.in_spk12_00 network.in_spk13_00 network.in_spk14_00
+ network.in_spk15_00 VSS VSS VDD VDD _09335_ sky130_fd_sc_hd__or4_1
X_13384_ network.in_spk08_00 network.in_spk09_00 network.in_spk10_00
+ network.in_spk11_00 VSS VSS VDD VDD _09336_ sky130_fd_sc_hd__or4_1
X_13385_ network.in_spk00_00 network.in_spk01_00 network.in_spk02_00
+ network.in_spk03_00 VSS VSS VDD VDD _09337_ sky130_fd_sc_hd__or4_1
Xplace343 net343 VSS VSS VDD VDD net342 sky130_fd_sc_hd__buf_4
X_13387_ network.in_spk04_00 network.in_spk05_00 network.in_spk06_00
+ network.in_spk07_00 VSS VSS VDD VDD _09339_ sky130_fd_sc_hd__or4_1
X_13388_ _09335_ _09336_ _09337_ _09339_ VSS VSS VDD VDD _09340_
+ sky130_fd_sc_hd__nor4_1
X_13389_ _09303_ _09304_ _09305_ _09307_ VSS VSS VDD VDD _09341_
+ sky130_fd_sc_hd__nor4_1
X_13390_ net367 _09310_ _09311_ _09313_ VSS VSS VDD VDD _09342_
+ sky130_fd_sc_hd__and4_1
X_13391_ _09297_ net328 _09341_ _09342_ VSS VSS VDD VDD _09343_
+ sky130_fd_sc_hd__and4_1
X_13392_ net329 _09280_ _09288_ _09270_ VSS VSS VDD VDD _09344_
+ sky130_fd_sc_hd__nor4b_1
X_13393_ net324 net323 _09344_ VSS VSS VDD VDD _09345_ sky130_fd_sc_hd__and3_1
X_13394_ _09329_ _09334_ _09343_ _09345_ VSS VSS VDD VDD _09346_
+ sky130_fd_sc_hd__nor4_1
X_13395_ _09297_ _09302_ _09308_ _09314_ VSS VSS VDD VDD _09347_
+ sky130_fd_sc_hd__or4_4
Xplace342 net342 VSS VSS VDD VDD net341 sky130_fd_sc_hd__buf_4
X_13397_ _09347_ _09239_ VSS VSS VDD VDD _09349_ sky130_fd_sc_hd__nor2_2
Xplace341 net342 VSS VSS VDD VDD net340 sky130_fd_sc_hd__buf_4
X_13399_ _09282_ _09283_ _09284_ _09287_ VSS VSS VDD VDD _09351_
+ sky130_fd_sc_hd__and4_1
X_13400_ net329 _09280_ _09351_ VSS VSS VDD VDD _09352_ sky130_fd_sc_hd__nor3_1
X_13401_ _09349_ _09352_ VSS VSS VDD VDD _09353_ sky130_fd_sc_hd__nand2_1
X_13402_ net324 _09225_ _09321_ net330 VSS VSS VDD VDD _09354_
+ sky130_fd_sc_hd__nand4_1
X_13403_ net328 _09341_ _09314_ VSS VSS VDD VDD _09355_ sky130_fd_sc_hd__nand3_1
X_13404_ _09326_ _09353_ _09354_ _09355_ VSS VSS VDD VDD _09356_
+ sky130_fd_sc_hd__and4_1
X_13405_ net325 _09264_ VSS VSS VDD VDD _09357_ sky130_fd_sc_hd__nand2_1
X_13406_ _09289_ _09324_ _09325_ VSS VSS VDD VDD _09358_ sky130_fd_sc_hd__nor3_2
X_13407_ _09357_ _09358_ _09333_ VSS VSS VDD VDD _09359_ sky130_fd_sc_hd__nor3_1
X_13408_ net307 net359 VSS VSS VDD VDD _09360_ sky130_fd_sc_hd__nand2b_1
X_13409_ _09346_ _09356_ _09360_ VSS VSS VDD VDD _01723_ sky130_fd_sc_hd__a21oi_1
X_13410_ _09302_ _09341_ VSS VSS VDD VDD _09361_ sky130_fd_sc_hd__nor2_1
X_13411_ net324 net330 VSS VSS VDD VDD _09362_ sky130_fd_sc_hd__nand2_1
X_13412_ _09225_ _09362_ VSS VSS VDD VDD _09363_ sky130_fd_sc_hd__nor2_1
X_13413_ _09245_ _09330_ VSS VSS VDD VDD _09364_ sky130_fd_sc_hd__or2_2
X_13414_ _09347_ _09239_ _09289_ _09364_ VSS VSS VDD VDD _09365_
+ sky130_fd_sc_hd__nor4_4
X_13415_ network.in_spk00_08 network.in_spk01_08 network.in_spk02_08
+ network.in_spk03_08 VSS VSS VDD VDD _09366_ sky130_fd_sc_hd__or4_1
X_13416_ network.in_spk04_08 network.in_spk05_08 network.in_spk06_08
+ VSS VSS VDD VDD _09367_ sky130_fd_sc_hd__or3_1
X_13417_ network.in_spk07_08 _09366_ _09367_ VSS VSS VDD VDD
+ _09368_ sky130_fd_sc_hd__nor3_1
X_13418_ _09271_ _09272_ _09368_ VSS VSS VDD VDD _09369_ sky130_fd_sc_hd__and3_1
X_13419_ _09369_ _09280_ _09349_ VSS VSS VDD VDD _09370_ sky130_fd_sc_hd__and3_1
X_13420_ _09361_ _09363_ _09365_ _09370_ VSS VSS VDD VDD _09371_
+ sky130_fd_sc_hd__nor4_1
X_13421_ _09346_ _09371_ _09360_ VSS VSS VDD VDD _01724_ sky130_fd_sc_hd__a21oi_1
X_13422_ _09368_ _09349_ VSS VSS VDD VDD _09372_ sky130_fd_sc_hd__nand2_1
X_13423_ _09271_ _09272_ _09372_ VSS VSS VDD VDD _09373_ sky130_fd_sc_hd__a21oi_1
X_13424_ _09246_ _09247_ _09252_ net317 VSS VSS VDD VDD _09374_
+ sky130_fd_sc_hd__nand4_2
X_13425_ net369 _09241_ VSS VSS VDD VDD _09375_ sky130_fd_sc_hd__nand2_1
X_13426_ _09242_ _09244_ VSS VSS VDD VDD _09376_ sky130_fd_sc_hd__and2_1
X_13427_ _09375_ _09376_ _09333_ VSS VSS VDD VDD _09377_ sky130_fd_sc_hd__or3_1
X_13428_ _09302_ _09308_ VSS VSS VDD VDD _09378_ sky130_fd_sc_hd__nor2_1
X_13429_ _09311_ _09313_ VSS VSS VDD VDD _09379_ sky130_fd_sc_hd__and2_1
X_13430_ _09292_ _09294_ VSS VSS VDD VDD _09380_ sky130_fd_sc_hd__nand2_1
X_13431_ _09295_ _09296_ VSS VSS VDD VDD _09381_ sky130_fd_sc_hd__and2_1
X_13432_ _09380_ _09381_ net367 _09310_ VSS VSS VDD VDD _09382_
+ sky130_fd_sc_hd__o211ai_1
X_13433_ _09303_ _09304_ VSS VSS VDD VDD _09383_ sky130_fd_sc_hd__nor2_1
X_13434_ _09305_ _09307_ _09383_ VSS VSS VDD VDD _09384_ sky130_fd_sc_hd__o21ai_0
X_13435_ _09300_ _09301_ VSS VSS VDD VDD _09385_ sky130_fd_sc_hd__nand2_1
X_13436_ _09298_ _09299_ _09384_ _09385_ VSS VSS VDD VDD _09386_
+ sky130_fd_sc_hd__a31oi_1
X_13437_ _09378_ _09379_ _09382_ _09386_ VSS VSS VDD VDD _09387_
+ sky130_fd_sc_hd__a31oi_1
X_13438_ _09221_ _09222_ VSS VSS VDD VDD _09388_ sky130_fd_sc_hd__nand2_1
X_13439_ network.in_spk02_06 network.in_spk03_06 VSS VSS VDD
+ VDD _09389_ sky130_fd_sc_hd__nor2_1
X_13440_ network.in_spk00_06 network.in_spk01_06 VSS VSS VDD
+ VDD _09390_ sky130_fd_sc_hd__nor2_1
X_13441_ _09389_ _09390_ VSS VSS VDD VDD _09391_ sky130_fd_sc_hd__nand2_1
X_13442_ network.in_spk04_06 network.in_spk05_06 network.in_spk06_06
+ VSS VSS VDD VDD _09392_ sky130_fd_sc_hd__nor3_1
X_13443_ network.in_spk07_06 _09392_ VSS VSS VDD VDD _09393_
+ sky130_fd_sc_hd__nand2b_1
X_13444_ _09229_ _09230_ _09391_ _09393_ VSS VSS VDD VDD _09394_
+ sky130_fd_sc_hd__a211oi_1
X_13445_ _09223_ _09224_ VSS VSS VDD VDD _09395_ sky130_fd_sc_hd__and2_1
Xplace339 _07437_ VSS VSS VDD VDD net338 sky130_fd_sc_hd__buf_4
X_13447_ _09388_ _09394_ _09395_ VSS VSS VDD VDD _09397_ sky130_fd_sc_hd__o21ai_0
X_13448_ _09233_ _09235_ VSS VSS VDD VDD _09398_ sky130_fd_sc_hd__and2_1
X_13449_ net324 _09398_ VSS VSS VDD VDD _09399_ sky130_fd_sc_hd__nand2_1
X_13450_ _09232_ _09236_ _09397_ _09399_ VSS VSS VDD VDD _09400_
+ sky130_fd_sc_hd__a31o_2
X_13451_ _09374_ _09377_ _09387_ _09400_ VSS VSS VDD VDD _09401_
+ sky130_fd_sc_hd__nand4_1
X_13452_ network.in_spk04_07 network.in_spk05_07 VSS VSS VDD
+ VDD _09402_ sky130_fd_sc_hd__nor2_1
X_13453_ network.in_spk06_07 network.in_spk07_07 VSS VSS VDD
+ VDD _09403_ sky130_fd_sc_hd__nor2_1
X_13454_ _09402_ _09403_ VSS VSS VDD VDD _09404_ sky130_fd_sc_hd__nand2_1
X_13455_ network.in_spk02_07 network.in_spk03_07 VSS VSS VDD
+ VDD _09405_ sky130_fd_sc_hd__nor2_1
X_13456_ network.in_spk00_07 network.in_spk01_07 VSS VSS VDD
+ VDD _09406_ sky130_fd_sc_hd__nor2_1
X_13457_ _09405_ _09406_ VSS VSS VDD VDD _09407_ sky130_fd_sc_hd__nand2_1
X_13458_ net324 _09319_ _09327_ VSS VSS VDD VDD _09408_ sky130_fd_sc_hd__nand3_2
X_13459_ _09404_ _09407_ _09408_ VSS VSS VDD VDD _09409_ sky130_fd_sc_hd__or3_1
X_13460_ _09267_ _09268_ _09345_ VSS VSS VDD VDD _09410_ sky130_fd_sc_hd__nand3_1
X_13461_ net368 _09277_ VSS VSS VDD VDD _09411_ sky130_fd_sc_hd__nand2_1
X_13462_ _09278_ _09279_ _09411_ VSS VSS VDD VDD _09412_ sky130_fd_sc_hd__a21oi_1
X_13463_ _09369_ _09349_ _09412_ VSS VSS VDD VDD _09413_ sky130_fd_sc_hd__nand3_1
X_13464_ _09409_ _09410_ _09413_ VSS VSS VDD VDD _09414_ sky130_fd_sc_hd__nand3_1
X_13465_ _09373_ _09401_ _09414_ VSS VSS VDD VDD _09415_ sky130_fd_sc_hd__nor3_1
X_13466_ _09259_ _09262_ VSS VSS VDD VDD _09416_ sky130_fd_sc_hd__nand2b_1
X_13467_ _09260_ _09261_ _09416_ VSS VSS VDD VDD _09417_ sky130_fd_sc_hd__and3_1
X_13468_ _09358_ _09417_ VSS VSS VDD VDD _09418_ sky130_fd_sc_hd__nand2_1
X_13469_ _09283_ _09284_ VSS VSS VDD VDD _09419_ sky130_fd_sc_hd__and2_1
X_13470_ _09419_ _09349_ _09352_ VSS VSS VDD VDD _09420_ sky130_fd_sc_hd__nand3_1
X_13471_ _09331_ _09264_ _09333_ VSS VSS VDD VDD _09421_ sky130_fd_sc_hd__or3_1
X_13472_ network.in_spk07_15 _09255_ _09421_ VSS VSS VDD VDD
+ _09422_ sky130_fd_sc_hd__or3_1
X_13473_ _09415_ _09418_ _09420_ _09422_ _09360_ VSS VSS VDD
+ VDD _01725_ sky130_fd_sc_hd__a41oi_2
X_13474_ network.in_spk04_14 network.in_spk05_14 network.in_spk06_14
+ VSS VSS VDD VDD _09423_ sky130_fd_sc_hd__or3_1
X_13475_ network.in_spk07_14 _09423_ VSS VSS VDD VDD _09424_
+ sky130_fd_sc_hd__or2_2
X_13476_ _09259_ _09262_ _09424_ VSS VSS VDD VDD _09425_ sky130_fd_sc_hd__a21oi_1
X_13477_ _09261_ _09358_ VSS VSS VDD VDD _09426_ sky130_fd_sc_hd__nand2_1
X_13478_ network.in_spk08_10 network.in_spk09_10 VSS VSS VDD
+ VDD _09427_ sky130_fd_sc_hd__nor2_1
X_13479_ network.in_spk10_10 network.in_spk11_10 VSS VSS VDD
+ VDD _09428_ sky130_fd_sc_hd__nor2_1
X_13480_ _09427_ _09428_ VSS VSS VDD VDD _09429_ sky130_fd_sc_hd__nand2_1
X_13481_ _09282_ _09429_ _09284_ VSS VSS VDD VDD _09430_ sky130_fd_sc_hd__o21ai_0
X_13482_ _09283_ _09352_ _09430_ VSS VSS VDD VDD _09431_ sky130_fd_sc_hd__nand3_1
X_13483_ network.in_spk08_09 network.in_spk09_09 network.in_spk10_09
+ VSS VSS VDD VDD _09432_ sky130_fd_sc_hd__or3_1
X_13484_ network.in_spk11_09 _09432_ VSS VSS VDD VDD _09433_
+ sky130_fd_sc_hd__or2_2
X_13485_ _09433_ _09279_ _09277_ VSS VSS VDD VDD _09434_ sky130_fd_sc_hd__o21ai_0
X_13486_ _09369_ net368 _09434_ VSS VSS VDD VDD _09435_ sky130_fd_sc_hd__nand3_1
X_13487_ _09431_ _09435_ _09324_ VSS VSS VDD VDD _09436_ sky130_fd_sc_hd__a21oi_1
X_13488_ _09378_ _09311_ _09314_ VSS VSS VDD VDD _09437_ sky130_fd_sc_hd__nand3_1
X_13489_ network.in_spk08_02 network.in_spk09_02 VSS VSS VDD
+ VDD _09438_ sky130_fd_sc_hd__nor2_1
X_13490_ network.in_spk10_02 network.in_spk11_02 VSS VSS VDD
+ VDD _09439_ sky130_fd_sc_hd__nor2_1
X_13491_ _09438_ _09439_ VSS VSS VDD VDD _09440_ sky130_fd_sc_hd__nand2_1
X_13492_ _09440_ _09310_ _09313_ VSS VSS VDD VDD _09441_ sky130_fd_sc_hd__o21a_1
X_13493_ network.in_spk08_01 network.in_spk09_01 VSS VSS VDD
+ VDD _09442_ sky130_fd_sc_hd__nor2_1
X_13494_ network.in_spk10_01 network.in_spk11_01 VSS VSS VDD
+ VDD _09443_ sky130_fd_sc_hd__nor2_1
X_13495_ _09442_ _09443_ _09307_ _09304_ _09335_ VSS VSS VDD
+ VDD _09444_ sky130_fd_sc_hd__a311oi_1
X_13496_ _09298_ _09303_ _09336_ VSS VSS VDD VDD _09445_ sky130_fd_sc_hd__a21o_1
X_13497_ _09444_ _09445_ _09301_ VSS VSS VDD VDD _09446_ sky130_fd_sc_hd__o21ai_0
X_13498_ _09300_ _09446_ VSS VSS VDD VDD _09447_ sky130_fd_sc_hd__nand2_1
X_13499_ _09437_ _09441_ _09447_ VSS VSS VDD VDD _09448_ sky130_fd_sc_hd__o21ai_0
X_13500_ _09296_ _09295_ VSS VSS VDD VDD _09449_ sky130_fd_sc_hd__nand2b_1
X_13501_ _09292_ _09343_ VSS VSS VDD VDD _09450_ sky130_fd_sc_hd__nand2_1
X_13502_ _09294_ _09449_ _09450_ VSS VSS VDD VDD _09451_ sky130_fd_sc_hd__a21oi_1
X_13503_ network.in_spk08_07 network.in_spk09_07 VSS VSS VDD
+ VDD _09452_ sky130_fd_sc_hd__nor2_1
X_13504_ network.in_spk10_07 network.in_spk11_07 VSS VSS VDD
+ VDD _09453_ sky130_fd_sc_hd__nor2_1
X_13505_ _09452_ _09453_ VSS VSS VDD VDD _09454_ sky130_fd_sc_hd__nand2_1
X_13506_ _09454_ _09218_ _09215_ VSS VSS VDD VDD _09455_ sky130_fd_sc_hd__o21ai_0
X_13507_ _09216_ _09455_ VSS VSS VDD VDD _09456_ sky130_fd_sc_hd__nand2_1
X_13508_ _09328_ _09456_ VSS VSS VDD VDD _09457_ sky130_fd_sc_hd__nor2_1
X_13509_ _09436_ _09448_ _09451_ _09457_ VSS VSS VDD VDD _09458_
+ sky130_fd_sc_hd__nor4_1
X_13510_ network.in_spk08_04 network.in_spk09_04 VSS VSS VDD
+ VDD _09459_ sky130_fd_sc_hd__nor2_1
X_13511_ network.in_spk10_04 network.in_spk11_04 VSS VSS VDD
+ VDD _09460_ sky130_fd_sc_hd__nor2_1
X_13512_ _09459_ _09460_ VSS VSS VDD VDD _09461_ sky130_fd_sc_hd__nand2_1
X_13513_ _09232_ _09461_ _09235_ VSS VSS VDD VDD _09462_ sky130_fd_sc_hd__o21ai_0
X_13514_ network.in_spk08_13 network.in_spk09_13 network.in_spk10_13
+ network.in_spk11_13 VSS VSS VDD VDD _09463_ sky130_fd_sc_hd__or4_1
X_13515_ _09463_ _09251_ _09247_ VSS VSS VDD VDD _09464_ sky130_fd_sc_hd__o21ai_0
X_13516_ _09246_ _09464_ VSS VSS VDD VDD _09465_ sky130_fd_sc_hd__nand2_1
X_13517_ network.in_spk08_12 network.in_spk09_12 VSS VSS VDD
+ VDD _09466_ sky130_fd_sc_hd__nor2_1
X_13518_ network.in_spk10_12 network.in_spk11_12 VSS VSS VDD
+ VDD _09467_ sky130_fd_sc_hd__nor2_1
X_13519_ _09466_ _09467_ VSS VSS VDD VDD _09468_ sky130_fd_sc_hd__nand2_1
X_13520_ _09468_ _09376_ _09241_ VSS VSS VDD VDD _09469_ sky130_fd_sc_hd__o21ai_0
X_13521_ _09364_ _09465_ _09469_ net369 VSS VSS VDD VDD _09470_
+ sky130_fd_sc_hd__a2bb2oi_1
X_13522_ net324 net323 net329 VSS VSS VDD VDD _09471_ sky130_fd_sc_hd__nand3_1
X_13523_ _09272_ _09273_ _09274_ VSS VSS VDD VDD _09472_ sky130_fd_sc_hd__nand3_1
X_13524_ _09366_ _09274_ _09472_ _09271_ VSS VSS VDD VDD _09473_
+ sky130_fd_sc_hd__o22a_1
X_13525_ _09333_ _09470_ _09471_ _09473_ VSS VSS VDD VDD _09474_
+ sky130_fd_sc_hd__o22ai_1
X_13526_ net324 _09233_ _09322_ _09462_ _09474_ VSS VSS VDD
+ VDD _09475_ sky130_fd_sc_hd__a41oi_1
X_13527_ _09425_ _09426_ _09458_ _09475_ VSS VSS VDD VDD _09476_
+ sky130_fd_sc_hd__o211ai_1
X_13528_ _09222_ _09221_ VSS VSS VDD VDD _09477_ sky130_fd_sc_hd__nand2b_1
X_13529_ network.in_spk00_05 network.in_spk01_05 _09225_ _09362_
+ VSS VSS VDD VDD _09478_ sky130_fd_sc_hd__or4_1
X_13530_ network.in_spk02_05 network.in_spk03_05 _09478_ VSS
+ VSS VDD VDD _09479_ sky130_fd_sc_hd__or3_4
X_13531_ _09223_ _09477_ _09479_ VSS VSS VDD VDD _09480_ sky130_fd_sc_hd__a21oi_1
X_13532_ _09265_ _09269_ _09268_ VSS VSS VDD VDD _09481_ sky130_fd_sc_hd__o21a_1
X_13533_ _09267_ _09345_ VSS VSS VDD VDD _09482_ sky130_fd_sc_hd__nand2_1
X_13534_ net324 _09225_ _09321_ net330 VSS VSS VDD VDD _09483_
+ sky130_fd_sc_hd__nand4_2
X_13535_ network.in_spk08_06 network.in_spk09_06 _09391_ _09393_
+ VSS VSS VDD VDD _09484_ sky130_fd_sc_hd__or4_1
X_13536_ network.in_spk10_06 network.in_spk11_06 _09229_ _09484_
+ VSS VSS VDD VDD _09485_ sky130_fd_sc_hd__nor4_1
X_13537_ _09227_ _09393_ _09485_ VSS VSS VDD VDD _09486_ sky130_fd_sc_hd__a21oi_1
X_13538_ _09257_ VSS VSS VDD VDD _09487_ sky130_fd_sc_hd__inv_1
X_13539_ network.in_spk07_15 network.in_spk06_15 network.in_spk05_15
+ network.in_spk04_15 VSS VSS VDD VDD _09488_ sky130_fd_sc_hd__nor4_1
X_13540_ _09487_ _09258_ _09488_ _09254_ VSS VSS VDD VDD _09489_
+ sky130_fd_sc_hd__o22ai_1
X_13541_ net310 _09489_ VSS VSS VDD VDD _09490_ sky130_fd_sc_hd__nand2_1
X_13542_ _09481_ _09482_ _09483_ _09486_ _09490_ VSS VSS VDD
+ VDD _09491_ sky130_fd_sc_hd__o221ai_1
X_13543_ _09360_ VSS VSS VDD VDD _01902_ sky130_fd_sc_hd__inv_2
X_13544_ _09476_ _09480_ _09491_ _01902_ VSS VSS VDD VDD _01726_
+ sky130_fd_sc_hd__o31a_1
X_13545_ network.in_spk06_06 network.in_spk07_06 VSS VSS VDD
+ VDD _09492_ sky130_fd_sc_hd__nor2_1
X_13546_ network.in_spk04_06 network.in_spk05_06 _09492_ _09389_
+ VSS VSS VDD VDD _09493_ sky130_fd_sc_hd__o31ai_1
X_13547_ network.in_spk10_06 network.in_spk11_06 VSS VSS VDD
+ VDD _09494_ sky130_fd_sc_hd__nor2_1
X_13548_ network.in_spk12_06 network.in_spk13_06 VSS VSS VDD
+ VDD _09495_ sky130_fd_sc_hd__nor2_1
X_13549_ network.in_spk14_06 network.in_spk15_06 _09495_ VSS
+ VSS VDD VDD _09496_ sky130_fd_sc_hd__o21ai_0
X_13550_ _09494_ _09496_ _09484_ VSS VSS VDD VDD _09497_ sky130_fd_sc_hd__a21oi_1
X_13551_ _09390_ _09493_ _09497_ VSS VSS VDD VDD _09498_ sky130_fd_sc_hd__a21oi_1
X_13552_ network.in_spk08_07 network.in_spk09_07 _09453_ _09403_
+ VSS VSS VDD VDD _09499_ sky130_fd_sc_hd__o31ai_1
X_13553_ _09402_ _09499_ VSS VSS VDD VDD _09500_ sky130_fd_sc_hd__nand2_1
X_13554_ _09405_ _09500_ VSS VSS VDD VDD _09501_ sky130_fd_sc_hd__nand2_1
X_13555_ network.in_spk12_07 _09404_ _09407_ _09454_ VSS VSS
+ VDD VDD _09502_ sky130_fd_sc_hd__nor4_1
X_13556_ network.in_spk14_07 network.in_spk15_07 VSS VSS VDD
+ VDD _09503_ sky130_fd_sc_hd__nor2_1
X_13557_ network.in_spk13_07 _09503_ VSS VSS VDD VDD _09504_
+ sky130_fd_sc_hd__nor2_1
X_13558_ _09406_ _09501_ _09502_ _09504_ VSS VSS VDD VDD _09505_
+ sky130_fd_sc_hd__a22o_1
X_13559_ network.in_spk01_07 network.in_spk02_07 network.in_spk03_07
+ _09404_ VSS VSS VDD VDD _09506_ sky130_fd_sc_hd__nor4_1
X_13560_ _09217_ _09218_ _09506_ network.in_spk00_07 VSS VSS
+ VDD VDD _09507_ sky130_fd_sc_hd__a31oi_1
X_13561_ net324 _09327_ _09505_ _09507_ VSS VSS VDD VDD _09508_
+ sky130_fd_sc_hd__nand4_1
X_13562_ network.in_spk14_02 network.in_spk15_02 VSS VSS VDD
+ VDD _09509_ sky130_fd_sc_hd__nor2_1
X_13563_ network.in_spk12_02 network.in_spk13_02 _09509_ _09439_
+ VSS VSS VDD VDD _09510_ sky130_fd_sc_hd__o31ai_1
X_13564_ network.in_spk06_02 network.in_spk07_02 VSS VSS VDD
+ VDD _09511_ sky130_fd_sc_hd__nor2_1
X_13565_ network.in_spk02_02 network.in_spk03_02 VSS VSS VDD
+ VDD _09512_ sky130_fd_sc_hd__nor2_1
X_13566_ network.in_spk04_02 network.in_spk05_02 _09511_ _09512_
+ VSS VSS VDD VDD _09513_ sky130_fd_sc_hd__o31ai_1
X_13567_ network.in_spk01_02 VSS VSS VDD VDD _09514_ sky130_fd_sc_hd__inv_1
X_13568_ _09438_ _09379_ _09510_ _09513_ _09514_ VSS VSS VDD
+ VDD _09515_ sky130_fd_sc_hd__a32o_1
X_13569_ network.in_spk00_02 _09355_ VSS VSS VDD VDD _09516_
+ sky130_fd_sc_hd__nor2_1
X_13570_ network.in_spk14_00 network.in_spk15_00 VSS VSS VDD
+ VDD _09517_ sky130_fd_sc_hd__nor2_1
X_13571_ network.in_spk12_00 _09336_ _09385_ VSS VSS VDD VDD
+ _09518_ sky130_fd_sc_hd__or3_1
X_13572_ network.in_spk08_00 network.in_spk09_00 _09337_ _09339_
+ VSS VSS VDD VDD _09519_ sky130_fd_sc_hd__nor4_1
X_13573_ network.in_spk10_00 network.in_spk11_00 _09519_ VSS
+ VSS VDD VDD _09520_ sky130_fd_sc_hd__o21ai_0
X_13574_ network.in_spk06_00 network.in_spk07_00 VSS VSS VDD
+ VDD _09521_ sky130_fd_sc_hd__nor2_1
X_13575_ network.in_spk04_00 network.in_spk05_00 _09521_ VSS
+ VSS VDD VDD _09522_ sky130_fd_sc_hd__nor3_1
X_13576_ network.in_spk00_00 network.in_spk01_00 VSS VSS VDD
+ VDD _09523_ sky130_fd_sc_hd__nor2_1
X_13577_ network.in_spk02_00 network.in_spk03_00 _09522_ _09523_
+ VSS VSS VDD VDD _09524_ sky130_fd_sc_hd__o31ai_1
X_13578_ network.in_spk13_00 _09517_ _09518_ _09520_ _09524_
+ VSS VSS VDD VDD _09525_ sky130_fd_sc_hd__o311ai_0
X_13579_ network.in_spk14_01 network.in_spk15_01 VSS VSS VDD
+ VDD _09526_ sky130_fd_sc_hd__nor2_1
X_13580_ network.in_spk12_01 network.in_spk13_01 _09526_ _09305_
+ VSS VSS VDD VDD _09527_ sky130_fd_sc_hd__or4_1
X_13581_ network.in_spk02_01 network.in_spk03_01 network.in_spk06_01
+ network.in_spk07_01 VSS VSS VDD VDD _09528_ sky130_fd_sc_hd__nor4_1
X_13582_ network.in_spk04_01 network.in_spk05_01 VSS VSS VDD
+ VDD _09529_ sky130_fd_sc_hd__nor2_1
X_13583_ network.in_spk02_01 network.in_spk03_01 _09529_ VSS
+ VSS VDD VDD _09530_ sky130_fd_sc_hd__nor3_1
X_13584_ _09527_ _09528_ _09530_ network.in_spk01_01 VSS VSS
+ VDD VDD _09531_ sky130_fd_sc_hd__a211o_1
X_13585_ network.in_spk10_01 network.in_spk11_01 _09383_ _09442_
+ VSS VSS VDD VDD _09532_ sky130_fd_sc_hd__o211ai_1
X_13586_ network.in_spk00_01 _09302_ _09341_ VSS VSS VDD VDD
+ _09533_ sky130_fd_sc_hd__or3_1
X_13587_ _09531_ _09532_ _09533_ VSS VSS VDD VDD _09534_ sky130_fd_sc_hd__a21oi_1
X_13588_ network.in_spk12_03 network.in_spk13_03 VSS VSS VDD
+ VDD _09535_ sky130_fd_sc_hd__nor2_1
X_13589_ _09292_ _09294_ _09295_ VSS VSS VDD VDD _09536_ sky130_fd_sc_hd__and3_1
X_13590_ network.in_spk14_03 _09535_ _09536_ VSS VSS VDD VDD
+ _09537_ sky130_fd_sc_hd__nand3_1
X_13591_ network.in_spk14_03 VSS VSS VDD VDD _09538_ sky130_fd_sc_hd__inv_1
X_13592_ _09538_ network.in_spk15_03 _09535_ network.in_spk11_03
+ network.in_spk10_03 VSS VSS VDD VDD _09539_ sky130_fd_sc_hd__a311oi_1
X_13593_ network.in_spk08_03 network.in_spk09_03 _09380_ _09539_
+ VSS VSS VDD VDD _09540_ sky130_fd_sc_hd__or4_1
X_13594_ network.in_spk06_03 network.in_spk07_03 VSS VSS VDD
+ VDD _09541_ sky130_fd_sc_hd__nor2_1
X_13595_ network.in_spk04_03 network.in_spk05_03 _09541_ VSS
+ VSS VDD VDD _09542_ sky130_fd_sc_hd__nor3_1
X_13596_ network.in_spk00_03 network.in_spk01_03 VSS VSS VDD
+ VDD _09543_ sky130_fd_sc_hd__nor2_1
X_13597_ network.in_spk02_03 network.in_spk03_03 _09542_ _09543_
+ VSS VSS VDD VDD _09544_ sky130_fd_sc_hd__o31ai_1
X_13598_ network.in_spk01_03 network.in_spk02_03 network.in_spk03_03
+ VSS VSS VDD VDD _09545_ sky130_fd_sc_hd__nor3_1
X_13599_ _09294_ _09295_ _09296_ _09545_ network.in_spk00_03
+ VSS VSS VDD VDD _09546_ sky130_fd_sc_hd__a41oi_1
X_13600_ net328 _09341_ _09342_ _09546_ VSS VSS VDD VDD _09547_
+ sky130_fd_sc_hd__nand4_1
X_13601_ _09537_ _09540_ _09544_ _09547_ VSS VSS VDD VDD _09548_
+ sky130_fd_sc_hd__a31oi_1
X_13602_ _09515_ _09516_ _09525_ _09534_ _09548_ VSS VSS VDD
+ VDD _09549_ sky130_fd_sc_hd__a2111o_1
X_13603_ network.in_spk12_10 network.in_spk13_10 network.in_spk14_10
+ VSS VSS VDD VDD _09550_ sky130_fd_sc_hd__nor3_1
X_13604_ network.in_spk15_10 _09550_ network.in_spk11_10 VSS
+ VSS VDD VDD _09551_ sky130_fd_sc_hd__a21oi_1
X_13605_ network.in_spk08_10 network.in_spk09_10 network.in_spk10_10
+ _09551_ VSS VSS VDD VDD _09552_ sky130_fd_sc_hd__nor4_1
X_13606_ network.in_spk04_10 network.in_spk05_10 VSS VSS VDD
+ VDD _09553_ sky130_fd_sc_hd__nor2_1
X_13607_ network.in_spk06_10 _09283_ _09553_ VSS VSS VDD VDD
+ _09554_ sky130_fd_sc_hd__nand3b_1
X_13608_ network.in_spk07_10 _09552_ _09554_ VSS VSS VDD VDD
+ _09555_ sky130_fd_sc_hd__o21bai_1
X_13609_ network.in_spk12_10 network.in_spk13_10 VSS VSS VDD
+ VDD _09556_ sky130_fd_sc_hd__nor2_1
X_13610_ network.in_spk02_10 network.in_spk03_10 VSS VSS VDD
+ VDD _09557_ sky130_fd_sc_hd__nor2_1
X_13611_ network.in_spk07_10 network.in_spk08_10 network.in_spk09_10
+ network.in_spk10_10 VSS VSS VDD VDD _09558_ sky130_fd_sc_hd__nor4b_1
X_13612_ network.in_spk06_10 _09558_ _09553_ VSS VSS VDD VDD
+ _09559_ sky130_fd_sc_hd__o21ai_0
X_13613_ _09557_ _09559_ network.in_spk00_10 network.in_spk01_10
+ VSS VSS VDD VDD _09560_ sky130_fd_sc_hd__a211oi_1
X_13614_ network.in_spk14_10 _09556_ _09419_ _09287_ _09560_
+ VSS VSS VDD VDD _09561_ sky130_fd_sc_hd__a41oi_1
X_13615_ network.in_spk10_10 VSS VSS VDD VDD _09562_ sky130_fd_sc_hd__inv_1
X_13616_ network.in_spk11_10 _09282_ _09562_ VSS VSS VDD VDD
+ _09563_ sky130_fd_sc_hd__o21ai_0
X_13617_ _09419_ _09427_ _09563_ VSS VSS VDD VDD _09564_ sky130_fd_sc_hd__and3_1
X_13618_ _09562_ network.in_spk11_10 network.in_spk01_10 VSS
+ VSS VDD VDD _09565_ sky130_fd_sc_hd__a21oi_1
X_13619_ _09557_ _09284_ _09427_ _09565_ network.in_spk00_10
+ VSS VSS VDD VDD _09566_ sky130_fd_sc_hd__a41oi_1
X_13620_ _09564_ _09566_ net324 net323 _09352_ VSS VSS VDD
+ VDD _09567_ sky130_fd_sc_hd__o2111ai_1
X_13621_ _09555_ _09561_ _09567_ VSS VSS VDD VDD _09568_ sky130_fd_sc_hd__a21oi_1
X_13622_ network.in_spk12_04 network.in_spk13_04 VSS VSS VDD
+ VDD _09569_ sky130_fd_sc_hd__or2_2
X_13623_ network.in_spk14_04 network.in_spk15_04 VSS VSS VDD
+ VDD _09570_ sky130_fd_sc_hd__nor2_1
X_13624_ _09569_ _09570_ _09460_ VSS VSS VDD VDD _09571_ sky130_fd_sc_hd__o21ai_0
X_13625_ network.in_spk02_04 network.in_spk03_04 VSS VSS VDD
+ VDD _09572_ sky130_fd_sc_hd__nor2_1
X_13626_ network.in_spk04_04 network.in_spk05_04 VSS VSS VDD
+ VDD _09573_ sky130_fd_sc_hd__nor2_1
X_13627_ network.in_spk06_04 network.in_spk07_04 _09573_ VSS
+ VSS VDD VDD _09574_ sky130_fd_sc_hd__o21ai_0
X_13628_ _09572_ _09574_ network.in_spk01_04 VSS VSS VDD VDD
+ _09575_ sky130_fd_sc_hd__a21oi_1
X_13629_ _09398_ _09459_ _09571_ _09575_ VSS VSS VDD VDD _09576_
+ sky130_fd_sc_hd__a31oi_1
X_13630_ network.in_spk00_04 _09347_ net330 VSS VSS VDD VDD
+ _09577_ sky130_fd_sc_hd__or3_1
X_13631_ _09576_ _09577_ VSS VSS VDD VDD _09578_ sky130_fd_sc_hd__nor2_1
X_13632_ network.in_spk00_14 network.in_spk01_14 VSS VSS VDD
+ VDD _09579_ sky130_fd_sc_hd__nor2_1
X_13633_ network.in_spk09_14 network.in_spk08_14 network.in_spk07_14
+ network.in_spk10_14 VSS VSS VDD VDD _09580_ sky130_fd_sc_hd__nor4b_1
X_13634_ network.in_spk06_14 _09580_ VSS VSS VDD VDD _09581_
+ sky130_fd_sc_hd__nor2_1
X_13635_ network.in_spk02_14 network.in_spk03_14 VSS VSS VDD
+ VDD _09582_ sky130_fd_sc_hd__nor2_1
X_13636_ network.in_spk04_14 network.in_spk05_14 _09581_ _09582_
+ VSS VSS VDD VDD _09583_ sky130_fd_sc_hd__o31ai_1
X_13637_ _09582_ _09579_ VSS VSS VDD VDD _09584_ sky130_fd_sc_hd__nand2_1
X_13638_ network.in_spk10_14 network.in_spk09_14 network.in_spk08_14
+ VSS VSS VDD VDD _09585_ sky130_fd_sc_hd__nor3_1
X_13639_ network.in_spk11_14 _09585_ network.in_spk07_14 VSS
+ VSS VDD VDD _09586_ sky130_fd_sc_hd__a21oi_1
X_13640_ _09423_ _09584_ _09586_ VSS VSS VDD VDD _09587_ sky130_fd_sc_hd__or3_1
X_13641_ _09579_ _09583_ _09587_ VSS VSS VDD VDD _09588_ sky130_fd_sc_hd__a21boi_0
X_13642_ network.in_spk15_14 network.in_spk14_14 VSS VSS VDD
+ VDD _09589_ sky130_fd_sc_hd__nor2_1
X_13643_ network.in_spk13_14 network.in_spk12_14 _09263_ _09589_
+ VSS VSS VDD VDD _09590_ sky130_fd_sc_hd__or4_1
X_13644_ network.in_spk02_14 network.in_spk03_14 network.in_spk01_14
+ VSS VSS VDD VDD _09591_ sky130_fd_sc_hd__nor3_1
X_13645_ _09260_ _09591_ network.in_spk00_14 VSS VSS VDD VDD
+ _09592_ sky130_fd_sc_hd__a21oi_1
X_13646_ _09417_ _09592_ VSS VSS VDD VDD _09593_ sky130_fd_sc_hd__nor2_1
X_13647_ _09588_ _09590_ _09593_ _09333_ _09325_ VSS VSS VDD
+ VDD _09594_ sky130_fd_sc_hd__a2111oi_1
X_13648_ _09549_ _09568_ _09578_ _09594_ VSS VSS VDD VDD _09595_
+ sky130_fd_sc_hd__nor4_1
X_13649_ network.in_spk00_06 _09483_ _09498_ _09508_ _09595_
+ VSS VSS VDD VDD _09596_ sky130_fd_sc_hd__o311ai_1
X_13650_ _09289_ _09324_ VSS VSS VDD VDD _09597_ sky130_fd_sc_hd__nor2_1
X_13651_ network.in_spk14_12 VSS VSS VDD VDD _09598_ sky130_fd_sc_hd__inv_1
X_13652_ network.in_spk12_12 network.in_spk13_12 _09598_ VSS
+ VSS VDD VDD _09599_ sky130_fd_sc_hd__nor3_1
X_13653_ network.in_spk12_12 network.in_spk13_12 network.in_spk14_12
+ network.in_spk15_12 VSS VSS VDD VDD _09600_ sky130_fd_sc_hd__nor4b_1
X_13654_ network.in_spk10_12 network.in_spk11_12 _09599_ _09600_
+ _09466_ VSS VSS VDD VDD _09601_ sky130_fd_sc_hd__o41ai_1
X_13655_ network.in_spk06_12 network.in_spk07_12 VSS VSS VDD
+ VDD _09602_ sky130_fd_sc_hd__nor2_1
X_13656_ network.in_spk04_12 network.in_spk05_12 _09602_ VSS
+ VSS VDD VDD _09603_ sky130_fd_sc_hd__nor3_1
X_13657_ network.in_spk00_12 network.in_spk01_12 VSS VSS VDD
+ VDD _09604_ sky130_fd_sc_hd__nor2_1
X_13658_ network.in_spk02_12 network.in_spk03_12 _09603_ _09604_
+ VSS VSS VDD VDD _09605_ sky130_fd_sc_hd__o31ai_1
X_13659_ _09375_ _09601_ _09605_ VSS VSS VDD VDD _09606_ sky130_fd_sc_hd__o21ai_0
X_13660_ network.in_spk01_12 network.in_spk02_12 network.in_spk03_12
+ VSS VSS VDD VDD _09607_ sky130_fd_sc_hd__nor3_1
X_13661_ _09241_ _09376_ _09607_ network.in_spk00_12 VSS VSS
+ VDD VDD _09608_ sky130_fd_sc_hd__a31oi_1
X_13662_ network.in_spk04_09 network.in_spk05_09 VSS VSS VDD
+ VDD _09609_ sky130_fd_sc_hd__or2_2
X_13663_ network.in_spk08_09 network.in_spk09_09 VSS VSS VDD
+ VDD _09610_ sky130_fd_sc_hd__nor2_1
X_13664_ network.in_spk10_09 _09610_ network.in_spk06_09 network.in_spk07_09
+ VSS VSS VDD VDD _09611_ sky130_fd_sc_hd__a211oi_1
X_13665_ _09609_ _09611_ VSS VSS VDD VDD _09612_ sky130_fd_sc_hd__nor2_1
X_13666_ network.in_spk02_09 network.in_spk03_09 _09612_ VSS
+ VSS VDD VDD _09613_ sky130_fd_sc_hd__nor3_1
X_13667_ network.in_spk12_09 network.in_spk13_09 network.in_spk14_09
+ VSS VSS VDD VDD _09614_ sky130_fd_sc_hd__nor3_1
X_13668_ network.in_spk15_09 _09614_ network.in_spk11_09 VSS
+ VSS VDD VDD _09615_ sky130_fd_sc_hd__a21oi_1
X_13669_ _09411_ _09432_ _09615_ VSS VSS VDD VDD _09616_ sky130_fd_sc_hd__or3_1
X_13670_ network.in_spk12_09 network.in_spk13_09 VSS VSS VDD
+ VDD _09617_ sky130_fd_sc_hd__nor2_1
X_13671_ _09411_ _09433_ VSS VSS VDD VDD _09618_ sky130_fd_sc_hd__nor2_1
X_13672_ network.in_spk14_09 _09617_ _09618_ VSS VSS VDD VDD
+ _09619_ sky130_fd_sc_hd__nand3_1
X_13673_ network.in_spk00_09 network.in_spk01_09 _09613_ _09616_
+ _09619_ VSS VSS VDD VDD _09620_ sky130_fd_sc_hd__o311ai_1
X_13674_ _09597_ _09606_ _09608_ _09620_ _09370_ VSS VSS VDD
+ VDD _09621_ sky130_fd_sc_hd__a32oi_1
X_13675_ network.in_spk00_13 network.in_spk01_13 network.in_spk02_13
+ network.in_spk03_13 VSS VSS VDD VDD _09622_ sky130_fd_sc_hd__or4_1
X_13676_ network.in_spk04_13 network.in_spk05_13 _09622_ VSS
+ VSS VDD VDD _09623_ sky130_fd_sc_hd__or3_1
X_13677_ network.in_spk08_13 network.in_spk09_13 network.in_spk10_13
+ VSS VSS VDD VDD _09624_ sky130_fd_sc_hd__or3_1
X_13678_ network.in_spk12_13 network.in_spk13_13 network.in_spk14_13
+ VSS VSS VDD VDD _09625_ sky130_fd_sc_hd__nor3_1
X_13679_ network.in_spk15_13 _09625_ network.in_spk11_13 VSS
+ VSS VDD VDD _09626_ sky130_fd_sc_hd__a21oi_1
X_13680_ _09624_ _09626_ network.in_spk07_13 VSS VSS VDD VDD
+ _09627_ sky130_fd_sc_hd__o21bai_1
X_13681_ network.in_spk06_13 _09627_ VSS VSS VDD VDD _09628_
+ sky130_fd_sc_hd__nor2_1
X_13682_ network.in_spk12_13 network.in_spk13_13 VSS VSS VDD
+ VDD _09629_ sky130_fd_sc_hd__nor2_1
X_13683_ _09248_ _09463_ VSS VSS VDD VDD _09630_ sky130_fd_sc_hd__nor2_1
X_13684_ network.in_spk08_13 network.in_spk09_13 VSS VSS VDD
+ VDD _09631_ sky130_fd_sc_hd__nor2_1
X_13685_ network.in_spk10_13 _09247_ _09631_ network.in_spk03_13
+ network.in_spk02_13 VSS VSS VDD VDD _09632_ sky130_fd_sc_hd__a311oi_1
X_13686_ network.in_spk00_13 network.in_spk01_13 _09632_ VSS
+ VSS VDD VDD _09633_ sky130_fd_sc_hd__nor3_1
X_13687_ network.in_spk14_13 _09629_ _09630_ _09633_ VSS VSS
+ VDD VDD _09634_ sky130_fd_sc_hd__a31oi_1
X_13688_ _09623_ _09628_ _09634_ VSS VSS VDD VDD _09635_ sky130_fd_sc_hd__o21ai_0
X_13689_ net317 _09635_ VSS VSS VDD VDD _09636_ sky130_fd_sc_hd__nand2_1
X_13690_ network.in_spk14_15 network.in_spk13_15 network.in_spk12_15
+ VSS VSS VDD VDD _09637_ sky130_fd_sc_hd__nor3_1
X_13691_ network.in_spk15_15 _09637_ network.in_spk11_15 VSS
+ VSS VDD VDD _09638_ sky130_fd_sc_hd__a21oi_1
X_13692_ _09256_ _09638_ VSS VSS VDD VDD _09639_ sky130_fd_sc_hd__nor2_1
X_13693_ network.in_spk07_15 _09639_ _09255_ VSS VSS VDD VDD
+ _09640_ sky130_fd_sc_hd__o21bai_1
X_13694_ network.in_spk13_15 network.in_spk12_15 VSS VSS VDD
+ VDD _09641_ sky130_fd_sc_hd__nor2_1
X_13695_ network.in_spk05_15 network.in_spk04_15 VSS VSS VDD
+ VDD _09642_ sky130_fd_sc_hd__nor2_1
X_13696_ network.in_spk06_15 _09642_ network.in_spk02_15 network.in_spk03_15
+ VSS VSS VDD VDD _09643_ sky130_fd_sc_hd__a211oi_1
X_13697_ network.in_spk01_15 network.in_spk00_15 _09643_ VSS
+ VSS VDD VDD _09644_ sky130_fd_sc_hd__nor3_1
X_13698_ network.in_spk14_15 _09257_ _09641_ _09644_ VSS VSS
+ VDD VDD _09645_ sky130_fd_sc_hd__a31oi_1
X_13699_ network.in_spk08_15 network.in_spk07_15 _09255_ VSS
+ VSS VDD VDD _09646_ sky130_fd_sc_hd__nor3_1
X_13700_ network.in_spk09_15 _09646_ network.in_spk10_15 VSS
+ VSS VDD VDD _09647_ sky130_fd_sc_hd__nand3b_1
X_13701_ _09640_ _09645_ _09647_ VSS VSS VDD VDD _09648_ sky130_fd_sc_hd__nand3_1
X_13702_ network.in_spk00_08 _09471_ VSS VSS VDD VDD _09649_
+ sky130_fd_sc_hd__nor2_1
X_13703_ network.in_spk08_08 network.in_spk09_08 VSS VSS VDD
+ VDD _09650_ sky130_fd_sc_hd__nor2_1
X_13704_ _09650_ _09368_ VSS VSS VDD VDD _09651_ sky130_fd_sc_hd__nand2_1
X_13705_ network.in_spk14_08 network.in_spk15_08 VSS VSS VDD
+ VDD _09652_ sky130_fd_sc_hd__nor2_1
X_13706_ network.in_spk12_08 network.in_spk13_08 _09652_ VSS
+ VSS VDD VDD _09653_ sky130_fd_sc_hd__nor3_1
X_13707_ network.in_spk10_08 network.in_spk11_08 _09653_ VSS
+ VSS VDD VDD _09654_ sky130_fd_sc_hd__nor3_1
X_13708_ network.in_spk06_08 network.in_spk07_08 VSS VSS VDD
+ VDD _09655_ sky130_fd_sc_hd__nor2_1
X_13709_ network.in_spk04_08 network.in_spk05_08 _09655_ VSS
+ VSS VDD VDD _09656_ sky130_fd_sc_hd__nor3_1
X_13710_ network.in_spk02_08 network.in_spk03_08 _09656_ VSS
+ VSS VDD VDD _09657_ sky130_fd_sc_hd__nor3_1
X_13711_ _09651_ _09654_ _09657_ network.in_spk01_08 VSS VSS
+ VDD VDD _09658_ sky130_fd_sc_hd__o22ai_1
X_13712_ _09334_ _09648_ _09649_ _09658_ VSS VSS VDD VDD _09659_
+ sky130_fd_sc_hd__a22oi_1
X_13713_ network.in_spk00_05 VSS VSS VDD VDD _09660_ sky130_fd_sc_hd__inv_1
X_13714_ network.in_spk04_05 network.in_spk05_05 VSS VSS VDD
+ VDD _09661_ sky130_fd_sc_hd__nor2_1
X_13715_ network.in_spk06_05 network.in_spk07_05 VSS VSS VDD
+ VDD _09662_ sky130_fd_sc_hd__nor2_1
X_13716_ network.in_spk08_05 network.in_spk09_05 VSS VSS VDD
+ VDD _09663_ sky130_fd_sc_hd__nor2_1
X_13717_ network.in_spk10_05 _09663_ VSS VSS VDD VDD _09664_
+ sky130_fd_sc_hd__nand2_1
X_13718_ _09662_ _09664_ VSS VSS VDD VDD _09665_ sky130_fd_sc_hd__nand2_1
X_13719_ _09661_ _09665_ network.in_spk02_05 network.in_spk03_05
+ VSS VSS VDD VDD _09666_ sky130_fd_sc_hd__a211oi_1
X_13720_ network.in_spk14_05 network.in_spk15_05 VSS VSS VDD
+ VDD _09667_ sky130_fd_sc_hd__nor2_1
X_13721_ network.in_spk12_05 network.in_spk13_05 _09667_ VSS
+ VSS VDD VDD _09668_ sky130_fd_sc_hd__nor3_1
X_13722_ network.in_spk08_05 network.in_spk09_05 network.in_spk10_05
+ VSS VSS VDD VDD _09669_ sky130_fd_sc_hd__nor3_1
X_13723_ network.in_spk11_05 _09668_ _09395_ _09669_ VSS VSS
+ VDD VDD _09670_ sky130_fd_sc_hd__o211ai_1
X_13724_ network.in_spk01_05 _09666_ _09670_ VSS VSS VDD VDD
+ _09671_ sky130_fd_sc_hd__o21ai_0
X_13725_ network.in_spk12_11 _09265_ VSS VSS VDD VDD _09672_
+ sky130_fd_sc_hd__or2_2
X_13726_ _09267_ _09268_ VSS VSS VDD VDD _09673_ sky130_fd_sc_hd__nand2_1
X_13727_ network.in_spk13_11 _09672_ _09673_ VSS VSS VDD VDD
+ _09674_ sky130_fd_sc_hd__nor3_1
X_13728_ network.in_spk14_11 network.in_spk15_11 _09674_ VSS
+ VSS VDD VDD _09675_ sky130_fd_sc_hd__o21ai_0
X_13729_ network.in_spk04_11 network.in_spk05_11 VSS VSS VDD
+ VDD _09676_ sky130_fd_sc_hd__nor2_1
X_13730_ _09267_ _09676_ VSS VSS VDD VDD _09677_ sky130_fd_sc_hd__nand2_1
X_13731_ network.in_spk08_11 network.in_spk09_11 network.in_spk10_11
+ VSS VSS VDD VDD _09678_ sky130_fd_sc_hd__nor3_1
X_13732_ network.in_spk11_11 _09678_ network.in_spk07_11 VSS
+ VSS VDD VDD _09679_ sky130_fd_sc_hd__a21oi_1
X_13733_ network.in_spk06_11 _09677_ _09679_ VSS VSS VDD VDD
+ _09680_ sky130_fd_sc_hd__or3_1
X_13734_ network.in_spk02_11 network.in_spk03_11 VSS VSS VDD
+ VDD _09681_ sky130_fd_sc_hd__nor2_1
X_13735_ network.in_spk07_11 network.in_spk08_11 network.in_spk09_11
+ network.in_spk10_11 VSS VSS VDD VDD _09682_ sky130_fd_sc_hd__nor4b_1
X_13736_ network.in_spk06_11 _09682_ VSS VSS VDD VDD _09683_
+ sky130_fd_sc_hd__nor2_1
X_13737_ network.in_spk00_11 network.in_spk01_11 _09681_ _09677_
+ _09683_ VSS VSS VDD VDD _09684_ sky130_fd_sc_hd__o32a_1
X_13738_ net324 net323 _09344_ VSS VSS VDD VDD _09685_ sky130_fd_sc_hd__nand3_1
X_13739_ _09675_ _09680_ _09684_ _09685_ network.in_spk00_11
+ VSS VSS VDD VDD _09686_ sky130_fd_sc_hd__a311oi_1
X_13740_ _09660_ _09363_ _09671_ _09686_ VSS VSS VDD VDD _09687_
+ sky130_fd_sc_hd__a31oi_1
X_13741_ _09621_ _09636_ _09659_ net306 VSS VSS VDD VDD _09688_
+ sky130_fd_sc_hd__nand4_1
X_13742_ _09596_ _09688_ _01902_ VSS VSS VDD VDD _01727_ sky130_fd_sc_hd__o21a_1
X_13743_ _09660_ net324 _09320_ net330 VSS VSS VDD VDD _09689_
+ sky130_fd_sc_hd__nand4_1
X_13744_ network.in_spk14_05 VSS VSS VDD VDD _09690_ sky130_fd_sc_hd__inv_1
X_13745_ _09690_ network.in_spk15_05 network.in_spk13_05 VSS
+ VSS VDD VDD _09691_ sky130_fd_sc_hd__a21oi_1
X_13746_ network.in_spk12_05 _09691_ VSS VSS VDD VDD _09692_
+ sky130_fd_sc_hd__nor2_1
X_13747_ network.in_spk08_05 VSS VSS VDD VDD _09693_ sky130_fd_sc_hd__inv_1
X_13748_ _09693_ network.in_spk09_05 network.in_spk07_05 VSS
+ VSS VDD VDD _09694_ sky130_fd_sc_hd__a21oi_1
X_13749_ network.in_spk06_05 _09694_ VSS VSS VDD VDD _09695_
+ sky130_fd_sc_hd__nor2_1
X_13750_ network.in_spk05_05 _09695_ network.in_spk04_05 VSS
+ VSS VDD VDD _09696_ sky130_fd_sc_hd__o21bai_1
X_13751_ network.in_spk11_05 _09669_ _09223_ network.in_spk03_05
+ VSS VSS VDD VDD _09697_ sky130_fd_sc_hd__a31oi_1
X_13752_ _09696_ _09697_ network.in_spk02_05 VSS VSS VDD VDD
+ _09698_ sky130_fd_sc_hd__a21oi_1
X_13753_ _09221_ _09395_ _09692_ _09698_ network.in_spk01_05
+ VSS VSS VDD VDD _09699_ sky130_fd_sc_hd__a311oi_1
X_13754_ _09347_ _09320_ _09231_ _09322_ VSS VSS VDD VDD _09700_
+ sky130_fd_sc_hd__nor4_1
X_13755_ network.in_spk14_06 VSS VSS VDD VDD _09701_ sky130_fd_sc_hd__inv_1
X_13756_ _09701_ network.in_spk15_06 network.in_spk13_06 VSS
+ VSS VDD VDD _09702_ sky130_fd_sc_hd__a21oi_1
X_13757_ network.in_spk12_06 _09702_ VSS VSS VDD VDD _09703_
+ sky130_fd_sc_hd__nor2_1
X_13758_ network.in_spk11_06 _09703_ VSS VSS VDD VDD _09704_
+ sky130_fd_sc_hd__nor2_1
X_13759_ network.in_spk03_06 VSS VSS VDD VDD _09705_ sky130_fd_sc_hd__inv_1
X_13760_ network.in_spk04_06 network.in_spk05_06 VSS VSS VDD
+ VDD _09706_ sky130_fd_sc_hd__nand2b_1
X_13761_ _09705_ _09706_ network.in_spk02_06 VSS VSS VDD VDD
+ _09707_ sky130_fd_sc_hd__a21oi_1
X_13762_ network.in_spk01_06 _09707_ VSS VSS VDD VDD _09708_
+ sky130_fd_sc_hd__nor2_1
X_13763_ network.in_spk08_06 network.in_spk09_06 VSS VSS VDD
+ VDD _09709_ sky130_fd_sc_hd__nor2b_1
X_13764_ network.in_spk07_06 _09709_ _09392_ VSS VSS VDD VDD
+ _09710_ sky130_fd_sc_hd__o21ai_0
X_13765_ network.in_spk00_06 _09708_ _09710_ _09391_ VSS VSS
+ VDD VDD _09711_ sky130_fd_sc_hd__o22a_1
X_13766_ network.in_spk10_06 _09484_ _09704_ _09711_ VSS VSS
+ VDD VDD _09712_ sky130_fd_sc_hd__o31ai_1
X_13767_ network.in_spk14_07 network.in_spk15_07 VSS VSS VDD
+ VDD _09713_ sky130_fd_sc_hd__nor2b_1
X_13768_ network.in_spk13_07 _09713_ _09502_ VSS VSS VDD VDD
+ _09714_ sky130_fd_sc_hd__o21ai_0
X_13769_ network.in_spk04_07 VSS VSS VDD VDD _09715_ sky130_fd_sc_hd__inv_1
X_13770_ _09715_ network.in_spk05_07 network.in_spk03_07 VSS
+ VSS VDD VDD _09716_ sky130_fd_sc_hd__a21oi_1
X_13771_ network.in_spk02_07 _09716_ VSS VSS VDD VDD _09717_
+ sky130_fd_sc_hd__nor2_1
X_13772_ network.in_spk01_07 _09717_ network.in_spk00_07 VSS
+ VSS VDD VDD _09718_ sky130_fd_sc_hd__o21bai_1
X_13773_ network.in_spk10_07 VSS VSS VDD VDD _09719_ sky130_fd_sc_hd__inv_1
X_13774_ _09719_ network.in_spk11_07 network.in_spk09_07 VSS
+ VSS VDD VDD _09720_ sky130_fd_sc_hd__a21oi_1
X_13775_ network.in_spk08_07 _09720_ VSS VSS VDD VDD _09721_
+ sky130_fd_sc_hd__nor2_1
X_13776_ network.in_spk04_07 network.in_spk05_07 network.in_spk06_07
+ _09407_ VSS VSS VDD VDD _09722_ sky130_fd_sc_hd__nor4_1
X_13777_ network.in_spk07_07 _09721_ _09722_ VSS VSS VDD VDD
+ _09723_ sky130_fd_sc_hd__o21ai_0
X_13778_ _09714_ _09718_ _09723_ _09328_ VSS VSS VDD VDD _09724_
+ sky130_fd_sc_hd__a31oi_1
X_13779_ _09700_ _09712_ _09724_ VSS VSS VDD VDD _09725_ sky130_fd_sc_hd__a21oi_1
X_13780_ network.in_spk04_10 VSS VSS VDD VDD _09726_ sky130_fd_sc_hd__inv_1
X_13781_ _09726_ network.in_spk05_10 network.in_spk03_10 VSS
+ VSS VDD VDD _09727_ sky130_fd_sc_hd__a21oi_1
X_13782_ network.in_spk02_10 _09727_ VSS VSS VDD VDD _03343_
+ sky130_fd_sc_hd__nor2_1
X_13783_ network.in_spk01_10 _03343_ network.in_spk00_10 VSS
+ VSS VDD VDD _03344_ sky130_fd_sc_hd__o21bai_1
X_13784_ network.in_spk08_10 network.in_spk09_10 VSS VSS VDD
+ VDD _03345_ sky130_fd_sc_hd__nor2b_1
X_13785_ _09429_ network.in_spk12_10 network.in_spk13_10 VSS
+ VSS VDD VDD _03346_ sky130_fd_sc_hd__nor3b_1
X_13786_ _03345_ _03346_ _09419_ VSS VSS VDD VDD _03347_ sky130_fd_sc_hd__o21ai_0
X_13787_ _09555_ _03344_ _03347_ _09567_ VSS VSS VDD VDD _03348_
+ sky130_fd_sc_hd__a31oi_1
X_13788_ network.in_spk04_01 VSS VSS VDD VDD _03349_ sky130_fd_sc_hd__inv_1
X_13789_ _03349_ network.in_spk05_01 network.in_spk03_01 VSS
+ VSS VDD VDD _03350_ sky130_fd_sc_hd__a21oi_1
X_13790_ network.in_spk02_01 _03350_ VSS VSS VDD VDD _03351_
+ sky130_fd_sc_hd__nor2_1
X_13791_ network.in_spk01_01 _03351_ VSS VSS VDD VDD _03352_
+ sky130_fd_sc_hd__nor2_1
X_13792_ network.in_spk11_01 VSS VSS VDD VDD _03353_ sky130_fd_sc_hd__inv_1
X_13793_ network.in_spk14_01 network.in_spk15_01 VSS VSS VDD
+ VDD _03354_ sky130_fd_sc_hd__nor2b_1
X_13794_ network.in_spk13_01 _03354_ network.in_spk12_01 VSS
+ VSS VDD VDD _03355_ sky130_fd_sc_hd__o21bai_1
X_13795_ _03353_ _03355_ network.in_spk10_01 VSS VSS VDD VDD
+ _03356_ sky130_fd_sc_hd__a21oi_1
X_13796_ network.in_spk07_01 network.in_spk08_01 VSS VSS VDD
+ VDD _03357_ sky130_fd_sc_hd__nand2b_1
X_13797_ network.in_spk04_01 network.in_spk05_01 network.in_spk06_01
+ _09303_ VSS VSS VDD VDD _03358_ sky130_fd_sc_hd__nor4_1
X_13798_ network.in_spk07_01 network.in_spk09_01 _03356_ _03357_
+ _03358_ VSS VSS VDD VDD _03359_ sky130_fd_sc_hd__o311ai_0
X_13799_ _03352_ _03359_ _09533_ VSS VSS VDD VDD _03360_ sky130_fd_sc_hd__a21oi_1
X_13800_ _03348_ _03360_ VSS VSS VDD VDD _03361_ sky130_fd_sc_hd__nor2_1
X_13801_ _09369_ _09280_ _09349_ VSS VSS VDD VDD _03362_ sky130_fd_sc_hd__and3_1
X_13802_ network.in_spk04_09 VSS VSS VDD VDD _03363_ sky130_fd_sc_hd__inv_1
X_13803_ _03363_ network.in_spk05_09 network.in_spk03_09 VSS
+ VSS VDD VDD _03364_ sky130_fd_sc_hd__a21oi_1
X_13804_ network.in_spk02_09 _03364_ VSS VSS VDD VDD _03365_
+ sky130_fd_sc_hd__nor2_1
X_13805_ network.in_spk01_09 _03365_ network.in_spk00_09 VSS
+ VSS VDD VDD _03366_ sky130_fd_sc_hd__o21bai_1
X_13806_ network.in_spk08_09 network.in_spk09_09 VSS VSS VDD
+ VDD _03367_ sky130_fd_sc_hd__nor2b_1
X_13807_ network.in_spk06_09 _09609_ VSS VSS VDD VDD _03368_
+ sky130_fd_sc_hd__nor2_1
X_13808_ network.in_spk07_09 _03367_ _03368_ net368 VSS VSS
+ VDD VDD _03369_ sky130_fd_sc_hd__o211ai_1
X_13809_ network.in_spk12_09 network.in_spk13_09 _09618_ VSS
+ VSS VDD VDD _03370_ sky130_fd_sc_hd__nand3b_1
X_13810_ _09616_ _03366_ _03369_ _03370_ VSS VSS VDD VDD _03371_
+ sky130_fd_sc_hd__nand4_1
X_13811_ network.in_spk04_11 VSS VSS VDD VDD _03372_ sky130_fd_sc_hd__inv_1
X_13812_ _03372_ network.in_spk05_11 network.in_spk03_11 VSS
+ VSS VDD VDD _03373_ sky130_fd_sc_hd__a21oi_1
X_13813_ network.in_spk02_11 _03373_ VSS VSS VDD VDD _03374_
+ sky130_fd_sc_hd__nor2_1
X_13814_ network.in_spk01_11 _03374_ VSS VSS VDD VDD _03375_
+ sky130_fd_sc_hd__nor2_1
X_13815_ network.in_spk08_11 VSS VSS VDD VDD _03376_ sky130_fd_sc_hd__inv_1
X_13816_ network.in_spk14_11 VSS VSS VDD VDD _03377_ sky130_fd_sc_hd__inv_1
X_13817_ _03377_ network.in_spk15_11 network.in_spk13_11 VSS
+ VSS VDD VDD _03378_ sky130_fd_sc_hd__a21oi_1
X_13818_ _09672_ _03378_ VSS VSS VDD VDD _03379_ sky130_fd_sc_hd__nor2_1
X_13819_ _03376_ network.in_spk09_11 _03379_ VSS VSS VDD VDD
+ _03380_ sky130_fd_sc_hd__a21oi_1
X_13820_ network.in_spk00_11 _03375_ _03380_ _09673_ _09680_
+ VSS VSS VDD VDD _03381_ sky130_fd_sc_hd__o221ai_1
X_13821_ _09270_ _09351_ VSS VSS VDD VDD _03382_ sky130_fd_sc_hd__nand2_1
X_13822_ net329 _09280_ _09324_ _03382_ VSS VSS VDD VDD _03383_
+ sky130_fd_sc_hd__nor4_1
X_13823_ _03362_ _03371_ _03381_ _03383_ VSS VSS VDD VDD _03384_
+ sky130_fd_sc_hd__a22oi_1
X_13824_ _09689_ _09699_ _09725_ _03361_ _03384_ VSS VSS VDD
+ VDD _03385_ sky130_fd_sc_hd__o2111ai_1
X_13825_ network.in_spk04_00 VSS VSS VDD VDD _03386_ sky130_fd_sc_hd__inv_1
X_13826_ _03386_ network.in_spk05_00 network.in_spk03_00 VSS
+ VSS VDD VDD _03387_ sky130_fd_sc_hd__a21oi_1
X_13827_ network.in_spk02_00 _03387_ VSS VSS VDD VDD _03388_
+ sky130_fd_sc_hd__nor2_1
X_13828_ network.in_spk01_00 _03388_ VSS VSS VDD VDD _03389_
+ sky130_fd_sc_hd__nor2_1
X_13829_ network.in_spk14_00 VSS VSS VDD VDD _03390_ sky130_fd_sc_hd__inv_1
X_13830_ _03390_ network.in_spk15_00 network.in_spk13_00 VSS
+ VSS VDD VDD _03391_ sky130_fd_sc_hd__a21oi_1
X_13831_ network.in_spk10_00 VSS VSS VDD VDD _03392_ sky130_fd_sc_hd__inv_1
X_13832_ _03392_ network.in_spk11_00 network.in_spk09_00 VSS
+ VSS VDD VDD _03393_ sky130_fd_sc_hd__a21oi_1
X_13833_ network.in_spk08_00 _03393_ VSS VSS VDD VDD _03394_
+ sky130_fd_sc_hd__nor2_1
X_13834_ network.in_spk04_00 network.in_spk05_00 network.in_spk06_00
+ _09337_ VSS VSS VDD VDD _03395_ sky130_fd_sc_hd__nor4_1
X_13835_ network.in_spk07_00 _03394_ _03395_ VSS VSS VDD VDD
+ _03396_ sky130_fd_sc_hd__o21ai_0
X_13836_ network.in_spk00_00 _03389_ _03391_ _09518_ _03396_
+ VSS VSS VDD VDD _03397_ sky130_fd_sc_hd__o221ai_1
X_13837_ _09538_ network.in_spk15_03 network.in_spk13_03 VSS
+ VSS VDD VDD _03398_ sky130_fd_sc_hd__a21oi_1
X_13838_ network.in_spk12_03 _03398_ VSS VSS VDD VDD _03399_
+ sky130_fd_sc_hd__nor2_1
X_13839_ _09536_ _03399_ VSS VSS VDD VDD _03400_ sky130_fd_sc_hd__nand2_1
X_13840_ network.in_spk04_03 VSS VSS VDD VDD _03401_ sky130_fd_sc_hd__inv_1
X_13841_ _03401_ network.in_spk05_03 network.in_spk03_03 VSS
+ VSS VDD VDD _03402_ sky130_fd_sc_hd__a21oi_1
X_13842_ network.in_spk02_03 _03402_ VSS VSS VDD VDD _03403_
+ sky130_fd_sc_hd__nor2_1
X_13843_ network.in_spk01_03 _03403_ network.in_spk00_03 VSS
+ VSS VDD VDD _03404_ sky130_fd_sc_hd__o21bai_1
X_13844_ network.in_spk10_03 VSS VSS VDD VDD _03405_ sky130_fd_sc_hd__inv_1
X_13845_ _03405_ network.in_spk11_03 network.in_spk09_03 VSS
+ VSS VDD VDD _03406_ sky130_fd_sc_hd__a21oi_1
X_13846_ network.in_spk08_03 _03406_ VSS VSS VDD VDD _03407_
+ sky130_fd_sc_hd__nor2_1
X_13847_ network.in_spk04_03 network.in_spk05_03 network.in_spk06_03
+ VSS VSS VDD VDD _03408_ sky130_fd_sc_hd__nor3_1
X_13848_ network.in_spk07_03 _03407_ _03408_ _09292_ VSS VSS
+ VDD VDD _03409_ sky130_fd_sc_hd__o211ai_1
X_13849_ _03400_ _03404_ _03409_ _09547_ VSS VSS VDD VDD _03410_
+ sky130_fd_sc_hd__a31oi_1
X_13850_ network.in_spk04_02 network.in_spk05_02 network.in_spk06_02
+ VSS VSS VDD VDD _03411_ sky130_fd_sc_hd__nor3_1
X_13851_ network.in_spk14_02 network.in_spk15_02 VSS VSS VDD
+ VDD _03412_ sky130_fd_sc_hd__nor2b_1
X_13852_ network.in_spk13_02 _03412_ net367 VSS VSS VDD VDD
+ _03413_ sky130_fd_sc_hd__o21ai_0
X_13853_ network.in_spk08_02 VSS VSS VDD VDD _03414_ sky130_fd_sc_hd__inv_1
X_13854_ network.in_spk08_02 network.in_spk10_02 VSS VSS VDD
+ VDD _03415_ sky130_fd_sc_hd__nor2_1
X_13855_ _03414_ network.in_spk09_02 network.in_spk11_02 _03415_
+ network.in_spk07_02 VSS VSS VDD VDD _03416_ sky130_fd_sc_hd__a221oi_1
X_13856_ network.in_spk12_02 _03413_ _03416_ VSS VSS VDD VDD
+ _03417_ sky130_fd_sc_hd__o21ai_0
X_13857_ network.in_spk04_02 VSS VSS VDD VDD _03418_ sky130_fd_sc_hd__inv_1
X_13858_ _03418_ network.in_spk05_02 network.in_spk03_02 VSS
+ VSS VDD VDD _03419_ sky130_fd_sc_hd__a21oi_1
X_13859_ network.in_spk02_02 _03419_ _09514_ VSS VSS VDD VDD
+ _03420_ sky130_fd_sc_hd__o21ai_0
X_13860_ _09311_ _03411_ _03417_ _03420_ VSS VSS VDD VDD _03421_
+ sky130_fd_sc_hd__a31oi_1
X_13861_ network.in_spk00_02 _09355_ _03421_ VSS VSS VDD VDD
+ _03422_ sky130_fd_sc_hd__nor3_1
X_13862_ _03397_ _03410_ _03422_ VSS VSS VDD VDD _03423_ sky130_fd_sc_hd__nor3_1
X_13863_ network.in_spk00_04 _09347_ net330 VSS VSS VDD VDD
+ _03424_ sky130_fd_sc_hd__nor3_1
X_13864_ _09398_ _09236_ VSS VSS VDD VDD _03425_ sky130_fd_sc_hd__nand2_1
X_13865_ network.in_spk14_04 VSS VSS VDD VDD _03426_ sky130_fd_sc_hd__inv_1
X_13866_ _03426_ network.in_spk15_04 network.in_spk13_04 VSS
+ VSS VDD VDD _03427_ sky130_fd_sc_hd__a21oi_1
X_13867_ network.in_spk04_04 VSS VSS VDD VDD _03428_ sky130_fd_sc_hd__inv_1
X_13868_ _03428_ network.in_spk05_04 network.in_spk03_04 VSS
+ VSS VDD VDD _03429_ sky130_fd_sc_hd__a21oi_1
X_13869_ network.in_spk02_04 _03429_ VSS VSS VDD VDD _03430_
+ sky130_fd_sc_hd__nor2_1
X_13870_ network.in_spk01_04 _03430_ VSS VSS VDD VDD _03431_
+ sky130_fd_sc_hd__nor2_1
X_13871_ network.in_spk10_04 VSS VSS VDD VDD _03432_ sky130_fd_sc_hd__inv_1
X_13872_ _03432_ network.in_spk11_04 network.in_spk09_04 VSS
+ VSS VDD VDD _03433_ sky130_fd_sc_hd__a21oi_1
X_13873_ network.in_spk08_04 _03433_ VSS VSS VDD VDD _03434_
+ sky130_fd_sc_hd__nor2_1
X_13874_ network.in_spk04_04 network.in_spk05_04 network.in_spk06_04
+ VSS VSS VDD VDD _03435_ sky130_fd_sc_hd__nor3_1
X_13875_ network.in_spk07_04 _03434_ _03435_ _09233_ VSS VSS
+ VDD VDD _03436_ sky130_fd_sc_hd__o211ai_1
X_13876_ network.in_spk12_04 _03425_ _03427_ _03431_ _03436_
+ VSS VSS VDD VDD _03437_ sky130_fd_sc_hd__o311ai_0
X_13877_ network.in_spk14_08 VSS VSS VDD VDD _03438_ sky130_fd_sc_hd__inv_1
X_13878_ _03438_ network.in_spk15_08 network.in_spk13_08 VSS
+ VSS VDD VDD _03439_ sky130_fd_sc_hd__a21oi_1
X_13879_ network.in_spk12_08 _09472_ _03439_ VSS VSS VDD VDD
+ _03440_ sky130_fd_sc_hd__nor3_1
X_13880_ network.in_spk04_08 VSS VSS VDD VDD _03441_ sky130_fd_sc_hd__inv_1
X_13881_ _03441_ network.in_spk05_08 network.in_spk03_08 VSS
+ VSS VDD VDD _03442_ sky130_fd_sc_hd__a21oi_1
X_13882_ network.in_spk02_08 _03442_ VSS VSS VDD VDD _03443_
+ sky130_fd_sc_hd__nor2_1
X_13883_ network.in_spk08_08 VSS VSS VDD VDD _03444_ sky130_fd_sc_hd__inv_1
X_13884_ network.in_spk08_08 network.in_spk10_08 VSS VSS VDD
+ VDD _03445_ sky130_fd_sc_hd__nor2_1
X_13885_ _03444_ network.in_spk09_08 network.in_spk11_08 _03445_
+ network.in_spk07_08 VSS VSS VDD VDD _03446_ sky130_fd_sc_hd__a221oi_1
X_13886_ _09366_ _09367_ _03446_ VSS VSS VDD VDD _03447_ sky130_fd_sc_hd__nor3_1
X_13887_ network.in_spk01_08 _03440_ _03443_ _03447_ VSS VSS
+ VDD VDD _03448_ sky130_fd_sc_hd__nor4_1
X_13888_ network.in_spk00_08 _09369_ _09324_ _03448_ VSS VSS
+ VDD VDD _03449_ sky130_fd_sc_hd__nor4_1
X_13889_ _03424_ net309 _03449_ VSS VSS VDD VDD _03450_ sky130_fd_sc_hd__a21oi_1
X_13890_ network.in_spk10_12 VSS VSS VDD VDD _03451_ sky130_fd_sc_hd__inv_1
X_13891_ _09598_ network.in_spk15_12 network.in_spk13_12 VSS
+ VSS VDD VDD _03452_ sky130_fd_sc_hd__a21oi_1
X_13892_ network.in_spk12_12 _03452_ network.in_spk11_12 VSS
+ VSS VDD VDD _03453_ sky130_fd_sc_hd__o21bai_1
X_13893_ _03451_ _03453_ network.in_spk09_12 VSS VSS VDD VDD
+ _03454_ sky130_fd_sc_hd__a21oi_1
X_13894_ network.in_spk02_12 VSS VSS VDD VDD _03455_ sky130_fd_sc_hd__inv_1
X_13895_ network.in_spk06_12 VSS VSS VDD VDD _03456_ sky130_fd_sc_hd__inv_1
X_13896_ _03456_ network.in_spk07_12 network.in_spk05_12 VSS
+ VSS VDD VDD _03457_ sky130_fd_sc_hd__a21oi_1
X_13897_ network.in_spk04_12 _03457_ network.in_spk03_12 VSS
+ VSS VDD VDD _03458_ sky130_fd_sc_hd__o21bai_1
X_13898_ _03455_ _03458_ network.in_spk01_12 VSS VSS VDD VDD
+ _03459_ sky130_fd_sc_hd__a21oi_1
X_13899_ network.in_spk08_12 _09375_ _03454_ _03459_ network.in_spk00_12
+ VSS VSS VDD VDD _03460_ sky130_fd_sc_hd__o32ai_1
X_13900_ network.in_spk06_13 _09623_ VSS VSS VDD VDD _03461_
+ sky130_fd_sc_hd__nor2_1
X_13901_ network.in_spk13_13 VSS VSS VDD VDD _03462_ sky130_fd_sc_hd__inv_1
X_13902_ network.in_spk04_13 network.in_spk05_13 VSS VSS VDD
+ VDD _03463_ sky130_fd_sc_hd__nor2b_1
X_13903_ network.in_spk00_13 network.in_spk01_13 network.in_spk02_13
+ VSS VSS VDD VDD _03464_ sky130_fd_sc_hd__nor3_1
X_13904_ network.in_spk03_13 _03463_ _03464_ VSS VSS VDD VDD
+ _03465_ sky130_fd_sc_hd__o21ai_0
X_13905_ network.in_spk12_13 _03462_ _09248_ _09463_ _03465_
+ VSS VSS VDD VDD _03466_ sky130_fd_sc_hd__o41ai_1
X_13906_ network.in_spk09_13 VSS VSS VDD VDD _03467_ sky130_fd_sc_hd__inv_1
X_13907_ network.in_spk01_13 VSS VSS VDD VDD _03468_ sky130_fd_sc_hd__inv_1
X_13908_ network.in_spk08_13 _03467_ _09248_ _03468_ network.in_spk00_13
+ VSS VSS VDD VDD _03469_ sky130_fd_sc_hd__o32ai_1
X_13909_ _09627_ _03461_ _03466_ _03469_ VSS VSS VDD VDD _03470_
+ sky130_fd_sc_hd__a211oi_1
X_13910_ _09289_ _09324_ _09364_ net316 VSS VSS VDD VDD _03471_
+ sky130_fd_sc_hd__nor4_1
X_13911_ _09332_ _09349_ _09608_ net308 _03471_ VSS VSS VDD
+ VDD _03472_ sky130_fd_sc_hd__a41oi_1
X_13912_ _09289_ _09331_ _09264_ _09324_ VSS VSS VDD VDD _03473_
+ sky130_fd_sc_hd__nor4_1
X_13913_ network.in_spk04_15 VSS VSS VDD VDD _03474_ sky130_fd_sc_hd__inv_1
X_13914_ network.in_spk05_15 _03474_ network.in_spk03_15 VSS
+ VSS VDD VDD _03475_ sky130_fd_sc_hd__a21oi_1
X_13915_ network.in_spk02_15 _03475_ VSS VSS VDD VDD _03476_
+ sky130_fd_sc_hd__nor2_1
X_13916_ network.in_spk01_15 _03476_ VSS VSS VDD VDD _03477_
+ sky130_fd_sc_hd__nor2_1
X_13917_ network.in_spk12_15 VSS VSS VDD VDD _03478_ sky130_fd_sc_hd__inv_1
X_13918_ network.in_spk13_15 _03478_ _09257_ _09646_ network.in_spk09_15
+ VSS VSS VDD VDD _03479_ sky130_fd_sc_hd__a32oi_1
X_13919_ network.in_spk00_15 _03477_ _03479_ _09640_ VSS VSS
+ VDD VDD _03480_ sky130_fd_sc_hd__o211ai_1
X_13920_ network.in_spk08_14 _09260_ _09261_ network.in_spk09_14
+ VSS VSS VDD VDD _03481_ sky130_fd_sc_hd__nand4b_1
X_13921_ network.in_spk04_14 VSS VSS VDD VDD _03482_ sky130_fd_sc_hd__inv_1
X_13922_ _03482_ network.in_spk05_14 network.in_spk03_14 VSS
+ VSS VDD VDD _03483_ sky130_fd_sc_hd__a21oi_1
X_13923_ network.in_spk02_14 _03483_ VSS VSS VDD VDD _03484_
+ sky130_fd_sc_hd__nor2_1
X_13924_ network.in_spk01_14 _03484_ network.in_spk00_14 VSS
+ VSS VDD VDD _03485_ sky130_fd_sc_hd__o21bai_1
X_13925_ network.in_spk14_14 network.in_spk15_14 VSS VSS VDD
+ VDD _03486_ sky130_fd_sc_hd__nor2b_1
X_13926_ network.in_spk12_14 _09263_ VSS VSS VDD VDD _03487_
+ sky130_fd_sc_hd__nor2_1
X_13927_ network.in_spk13_14 _03486_ _03487_ VSS VSS VDD VDD
+ _03488_ sky130_fd_sc_hd__o21ai_0
X_13928_ _09587_ _03481_ _03485_ _03488_ VSS VSS VDD VDD _03489_
+ sky130_fd_sc_hd__nand4_1
X_13929_ _09347_ _09239_ _09289_ _09325_ VSS VSS VDD VDD _03490_
+ sky130_fd_sc_hd__nor4_1
X_13930_ _03473_ _03480_ _03489_ _03490_ VSS VSS VDD VDD _03491_
+ sky130_fd_sc_hd__a22oi_1
X_13931_ _03423_ _03450_ _03472_ _03491_ VSS VSS VDD VDD _03492_
+ sky130_fd_sc_hd__nand4_1
X_13932_ _03385_ _03492_ _01902_ VSS VSS VDD VDD _01728_ sky130_fd_sc_hd__o21a_1
X_13933_ network.in_period\[8\]\[1\] _08672_ VSS VSS VDD VDD
+ _03493_ sky130_fd_sc_hd__nand2_1
X_13934_ _00550_ _08672_ _03493_ VSS VSS VDD VDD _02096_ sky130_fd_sc_hd__o21ai_0
X_13935_ network.neuron_in139.counter\[3\] _01110_ VSS VSS
+ VDD VDD _03494_ sky130_fd_sc_hd__nand2b_1
X_13936_ network.neuron_in139.counter\[2\] _03494_ VSS VSS
+ VDD VDD _03495_ sky130_fd_sc_hd__or2_2
X_13937_ net352 _03495_ VSS VSS VDD VDD _03496_ sky130_fd_sc_hd__nand2_1
X_13938_ network.in_period\[139\]\[1\] _03496_ VSS VSS VDD
+ VDD _03497_ sky130_fd_sc_hd__nand2_1
X_13939_ _01111_ _03496_ _03497_ VSS VSS VDD VDD _02620_ sky130_fd_sc_hd__o21ai_0
X_13940_ network.neuron_in009.counter\[2\] VSS VSS VDD VDD
+ _03498_ sky130_fd_sc_hd__inv_1
X_13941_ network.neuron_in009.counter\[3\] network.in_period\[9\]\[2\]
+ _00545_ net422 VSS VSS VDD VDD _03499_ sky130_fd_sc_hd__o22ai_1
X_13942_ network.neuron_in009.counter\[2\] _00545_ net341
+ VSS VSS VDD VDD _03500_ sky130_fd_sc_hd__nand3_1
X_13943_ network.in_period\[9\]\[2\] net341 _03500_ VSS VSS
+ VDD VDD _03501_ sky130_fd_sc_hd__o21ai_0
X_13944_ _03498_ _03499_ _03501_ VSS VSS VDD VDD _02101_ sky130_fd_sc_hd__a21oi_1
X_13945_ network.neuron_in009.counter\[2\] network.neuron_in009.counter\[3\]
+ VSS VSS VDD VDD _03502_ sky130_fd_sc_hd__nor2_1
X_13946_ _00545_ _03502_ VSS VSS VDD VDD _03503_ sky130_fd_sc_hd__nand2_1
X_13947_ net341 _03503_ VSS VSS VDD VDD _03504_ sky130_fd_sc_hd__nand2_1
X_13948_ network.in_period\[9\]\[1\] _03504_ VSS VSS VDD VDD
+ _03505_ sky130_fd_sc_hd__nand2_1
X_13949_ _00546_ _03504_ _03505_ VSS VSS VDD VDD _02100_ sky130_fd_sc_hd__o21ai_0
X_13950_ network.in_period\[9\]\[0\] _03504_ VSS VSS VDD VDD
+ _03506_ sky130_fd_sc_hd__nand2_1
X_13951_ network.neuron_in009.counter\[0\] _03504_ _03506_
+ VSS VSS VDD VDD _02099_ sky130_fd_sc_hd__o21ai_0
X_13952_ network.neuron_in010.counter\[2\] VSS VSS VDD VDD
+ _03507_ sky130_fd_sc_hd__inv_1
X_13953_ network.in_period\[10\]\[2\] network.neuron_in010.counter\[3\]
+ _00539_ net424 VSS VSS VDD VDD _03508_ sky130_fd_sc_hd__o22ai_1
X_13954_ network.neuron_in010.counter\[2\] _00539_ net340
+ VSS VSS VDD VDD _03509_ sky130_fd_sc_hd__nand3_1
X_13955_ network.in_period\[10\]\[2\] net340 _03509_ VSS VSS
+ VDD VDD _03510_ sky130_fd_sc_hd__o21ai_0
X_13956_ _03507_ _03508_ _03510_ VSS VSS VDD VDD _02105_ sky130_fd_sc_hd__a21oi_1
X_13957_ network.neuron_in010.counter\[3\] _00539_ VSS VSS
+ VDD VDD _03511_ sky130_fd_sc_hd__nand2b_1
X_13958_ _03511_ _03507_ VSS VSS VDD VDD _03512_ sky130_fd_sc_hd__nand2b_1
X_13959_ net340 _03512_ VSS VSS VDD VDD _03513_ sky130_fd_sc_hd__nand2_1
X_13960_ network.in_period\[10\]\[1\] _03513_ VSS VSS VDD
+ VDD _03514_ sky130_fd_sc_hd__nand2_1
X_13961_ _00540_ _03513_ _03514_ VSS VSS VDD VDD _02104_ sky130_fd_sc_hd__o21ai_0
X_13962_ network.neuron_in010.counter\[0\] VSS VSS VDD VDD
+ _00537_ sky130_fd_sc_hd__inv_1
X_13963_ network.in_period\[10\]\[0\] _03513_ VSS VSS VDD
+ VDD _03515_ sky130_fd_sc_hd__nand2_1
X_13964_ network.neuron_in010.counter\[0\] _03513_ _03515_
+ VSS VSS VDD VDD _02103_ sky130_fd_sc_hd__o21ai_0
X_13965_ network.neuron_in084.counter\[0\] VSS VSS VDD VDD
+ _00046_ sky130_fd_sc_hd__inv_1
X_13966_ network.neuron_in011.counter\[2\] VSS VSS VDD VDD
+ _03516_ sky130_fd_sc_hd__inv_1
X_13967_ network.in_period\[11\]\[2\] network.neuron_in011.counter\[3\]
+ net423 _00523_ VSS VSS VDD VDD _03517_ sky130_fd_sc_hd__o22ai_1
X_13968_ network.neuron_in011.counter\[2\] _00523_ net342
+ VSS VSS VDD VDD _03518_ sky130_fd_sc_hd__nand3_1
X_13969_ network.in_period\[11\]\[2\] net342 _03518_ VSS VSS
+ VDD VDD _03519_ sky130_fd_sc_hd__o21ai_0
X_13970_ _03516_ _03517_ _03519_ VSS VSS VDD VDD _02109_ sky130_fd_sc_hd__a21oi_1
X_13971_ _03516_ _00523_ VSS VSS VDD VDD _03520_ sky130_fd_sc_hd__nand2_1
X_13972_ network.neuron_in011.counter\[3\] _03520_ VSS VSS
+ VDD VDD _03521_ sky130_fd_sc_hd__or2_2
X_13973_ net342 _03521_ VSS VSS VDD VDD _03522_ sky130_fd_sc_hd__nand2_1
X_13974_ network.in_period\[11\]\[1\] _03522_ VSS VSS VDD
+ VDD _03523_ sky130_fd_sc_hd__nand2_1
X_13975_ _00524_ _03522_ _03523_ VSS VSS VDD VDD _02108_ sky130_fd_sc_hd__o21ai_0
X_13976_ network.neuron_in011.counter\[0\] VSS VSS VDD VDD
+ _00521_ sky130_fd_sc_hd__inv_1
X_13977_ network.in_period\[11\]\[0\] _03522_ VSS VSS VDD
+ VDD _03524_ sky130_fd_sc_hd__nand2_1
X_13978_ network.neuron_in011.counter\[0\] _03522_ _03524_
+ VSS VSS VDD VDD _02107_ sky130_fd_sc_hd__o21ai_0
X_13979_ network.neuron_in012.counter\[2\] VSS VSS VDD VDD
+ _03525_ sky130_fd_sc_hd__inv_1
X_13980_ network.in_period\[12\]\[2\] network.neuron_in012.counter\[3\]
+ _00519_ net422 VSS VSS VDD VDD _03526_ sky130_fd_sc_hd__o22ai_1
Xplace319 _09188_ VSS VSS VDD VDD net318 sky130_fd_sc_hd__buf_4
X_13982_ network.neuron_in012.counter\[2\] _00519_ net341
+ VSS VSS VDD VDD _03528_ sky130_fd_sc_hd__nand3_1
X_13983_ network.in_period\[12\]\[2\] net341 _03528_ VSS VSS
+ VDD VDD _03529_ sky130_fd_sc_hd__o21ai_0
X_13984_ _03525_ _03526_ _03529_ VSS VSS VDD VDD _02113_ sky130_fd_sc_hd__a21oi_1
X_13985_ network.neuron_in120.counter\[1\] VSS VSS VDD VDD
+ _00967_ sky130_fd_sc_hd__inv_1
X_13986_ _03525_ _00519_ VSS VSS VDD VDD _03530_ sky130_fd_sc_hd__nand2_1
X_13987_ network.neuron_in012.counter\[3\] _03530_ VSS VSS
+ VDD VDD _03531_ sky130_fd_sc_hd__or2_2
X_13988_ net341 _03531_ VSS VSS VDD VDD _03532_ sky130_fd_sc_hd__nand2_1
X_13989_ network.in_period\[12\]\[1\] _03532_ VSS VSS VDD
+ VDD _03533_ sky130_fd_sc_hd__nand2_1
X_13990_ _00520_ _03532_ _03533_ VSS VSS VDD VDD _02112_ sky130_fd_sc_hd__o21ai_0
X_13991_ network.neuron_in012.counter\[0\] VSS VSS VDD VDD
+ _00517_ sky130_fd_sc_hd__inv_1
X_13992_ network.in_period\[12\]\[0\] _03532_ VSS VSS VDD
+ VDD _03534_ sky130_fd_sc_hd__nand2_1
X_13993_ network.neuron_in012.counter\[0\] _03532_ _03534_
+ VSS VSS VDD VDD _02111_ sky130_fd_sc_hd__o21ai_0
X_13994_ network.neuron_in013.counter\[2\] net342 VSS VSS
+ VDD VDD _03535_ sky130_fd_sc_hd__nand2_1
X_13995_ network.in_period\[13\]\[2\] network.neuron_in013.counter\[3\]
+ _03535_ VSS VSS VDD VDD _03536_ sky130_fd_sc_hd__o21ai_0
X_13996_ _00515_ network.neuron_in013.counter\[2\] net423
+ VSS VSS VDD VDD _03537_ sky130_fd_sc_hd__or3_1
X_13997_ network.in_period\[13\]\[2\] net342 _03537_ VSS VSS
+ VDD VDD _03538_ sky130_fd_sc_hd__o21ai_0
X_13998_ _00515_ _03536_ _03538_ VSS VSS VDD VDD _02117_ sky130_fd_sc_hd__a21oi_1
X_13999_ network.neuron_in014.counter\[3\] _00503_ VSS VSS
+ VDD VDD _03539_ sky130_fd_sc_hd__nand2b_1
X_14000_ network.neuron_in014.counter\[2\] VSS VSS VDD VDD
+ _03540_ sky130_fd_sc_hd__inv_1
X_14001_ _03539_ _03540_ VSS VSS VDD VDD _03541_ sky130_fd_sc_hd__nand2b_1
X_14002_ net351 _03541_ VSS VSS VDD VDD _03542_ sky130_fd_sc_hd__nand2_1
X_14003_ network.in_period\[14\]\[0\] _03542_ VSS VSS VDD
+ VDD _03543_ sky130_fd_sc_hd__nand2_1
X_14004_ network.neuron_in014.counter\[0\] _03542_ _03543_
+ VSS VSS VDD VDD _02119_ sky130_fd_sc_hd__o21ai_0
X_14005_ network.neuron_in013.counter\[2\] _00515_ VSS VSS
+ VDD VDD _03544_ sky130_fd_sc_hd__nand2b_1
X_14006_ network.neuron_in013.counter\[3\] _03544_ VSS VSS
+ VDD VDD _03545_ sky130_fd_sc_hd__or2_2
X_14007_ net342 _03545_ VSS VSS VDD VDD _03546_ sky130_fd_sc_hd__nand2_1
X_14008_ network.in_period\[13\]\[1\] _03546_ VSS VSS VDD
+ VDD _03547_ sky130_fd_sc_hd__nand2_1
X_14009_ _00516_ _03546_ _03547_ VSS VSS VDD VDD _02116_ sky130_fd_sc_hd__o21ai_0
X_14010_ network.in_period\[13\]\[0\] _03546_ VSS VSS VDD
+ VDD _03548_ sky130_fd_sc_hd__nand2_1
X_14011_ network.neuron_in013.counter\[0\] _03546_ _03548_
+ VSS VSS VDD VDD _02115_ sky130_fd_sc_hd__o21ai_0
X_14012_ network.in_period\[14\]\[2\] network.neuron_in014.counter\[3\]
+ _00503_ net423 VSS VSS VDD VDD _03549_ sky130_fd_sc_hd__o22ai_1
X_14013_ network.neuron_in014.counter\[2\] _00503_ net351
+ VSS VSS VDD VDD _03550_ sky130_fd_sc_hd__nand3_1
X_14014_ network.in_period\[14\]\[2\] net351 _03550_ VSS VSS
+ VDD VDD _03551_ sky130_fd_sc_hd__o21ai_0
X_14015_ _03540_ _03549_ _03551_ VSS VSS VDD VDD _02121_ sky130_fd_sc_hd__a21oi_1
X_14016_ network.neuron_in126.counter\[1\] VSS VSS VDD VDD
+ _00766_ sky130_fd_sc_hd__inv_1
X_14017_ network.in_period\[14\]\[1\] _03542_ VSS VSS VDD
+ VDD _03552_ sky130_fd_sc_hd__nand2_1
X_14018_ _00504_ _03542_ _03552_ VSS VSS VDD VDD _02120_ sky130_fd_sc_hd__o21ai_0
X_14019_ network.neuron_in139.counter\[2\] net352 VSS VSS
+ VDD VDD _03553_ sky130_fd_sc_hd__nand2_1
X_14020_ network.neuron_in139.counter\[3\] network.in_period\[139\]\[2\]
+ _03553_ VSS VSS VDD VDD _03554_ sky130_fd_sc_hd__o21ai_0
X_14021_ _01110_ network.neuron_in139.counter\[2\] net421
+ VSS VSS VDD VDD _03555_ sky130_fd_sc_hd__or3_1
X_14022_ network.in_period\[139\]\[2\] net352 _03555_ VSS
+ VSS VDD VDD _03556_ sky130_fd_sc_hd__o21ai_0
X_14023_ _01110_ _03554_ _03556_ VSS VSS VDD VDD _02621_ sky130_fd_sc_hd__a21oi_1
X_14024_ network.neuron_in015.counter\[2\] VSS VSS VDD VDD
+ _03557_ sky130_fd_sc_hd__inv_1
X_14025_ network.in_period\[15\]\[2\] network.neuron_in015.counter\[3\]
+ net423 _00507_ VSS VSS VDD VDD _03558_ sky130_fd_sc_hd__o22ai_1
X_14026_ network.neuron_in015.counter\[2\] _00507_ net342
+ VSS VSS VDD VDD _03559_ sky130_fd_sc_hd__nand3_1
X_14027_ network.in_period\[15\]\[2\] net342 _03559_ VSS VSS
+ VDD VDD _03560_ sky130_fd_sc_hd__o21ai_0
X_14028_ _03557_ _03558_ _03560_ VSS VSS VDD VDD _02125_ sky130_fd_sc_hd__a21oi_1
X_14029_ network.neuron_in015.counter\[3\] _00507_ VSS VSS
+ VDD VDD _03561_ sky130_fd_sc_hd__nand2b_1
X_14030_ _03561_ _03557_ VSS VSS VDD VDD _03562_ sky130_fd_sc_hd__nand2b_1
X_14031_ net342 _03562_ VSS VSS VDD VDD _03563_ sky130_fd_sc_hd__nand2_1
X_14032_ network.in_period\[15\]\[1\] _03563_ VSS VSS VDD
+ VDD _03564_ sky130_fd_sc_hd__nand2_1
X_14033_ _00508_ _03563_ _03564_ VSS VSS VDD VDD _02124_ sky130_fd_sc_hd__o21ai_0
X_14034_ network.neuron_in015.counter\[0\] VSS VSS VDD VDD
+ _00505_ sky130_fd_sc_hd__inv_1
X_14035_ network.in_period\[15\]\[0\] _03563_ VSS VSS VDD
+ VDD _03565_ sky130_fd_sc_hd__nand2_1
X_14036_ network.neuron_in015.counter\[0\] _03563_ _03565_
+ VSS VSS VDD VDD _02123_ sky130_fd_sc_hd__o21ai_0
X_14037_ network.neuron_in120.counter\[0\] VSS VSS VDD VDD
+ _00966_ sky130_fd_sc_hd__inv_1
X_14038_ network.neuron_in042.counter\[0\] VSS VSS VDD VDD
+ _00349_ sky130_fd_sc_hd__inv_1
X_14039_ network.neuron_in147.counter\[0\] VSS VSS VDD VDD
+ _01194_ sky130_fd_sc_hd__inv_1
X_14040_ network.neuron_in017.counter\[2\] VSS VSS VDD VDD
+ _03566_ sky130_fd_sc_hd__inv_1
Xplace318 _09365_ VSS VSS VDD VDD net317 sky130_fd_sc_hd__buf_4
X_14042_ network.in_period\[17\]\[2\] network.neuron_in017.counter\[3\]
+ net423 _00491_ VSS VSS VDD VDD _03568_ sky130_fd_sc_hd__o22ai_1
X_14043_ network.neuron_in017.counter\[2\] _00491_ net349
+ VSS VSS VDD VDD _03569_ sky130_fd_sc_hd__nand3_1
X_14044_ network.in_period\[17\]\[2\] net349 _03569_ VSS VSS
+ VDD VDD _03570_ sky130_fd_sc_hd__o21ai_0
X_14045_ _03566_ _03568_ _03570_ VSS VSS VDD VDD _02133_ sky130_fd_sc_hd__a21oi_1
X_14046_ network.neuron_in126.counter\[0\] VSS VSS VDD VDD
+ _00765_ sky130_fd_sc_hd__inv_1
X_14047_ network.neuron_in017.counter\[3\] _00491_ VSS VSS
+ VDD VDD _03571_ sky130_fd_sc_hd__nand2b_1
X_14048_ _03571_ _03566_ VSS VSS VDD VDD _03572_ sky130_fd_sc_hd__nand2b_1
X_14049_ net349 _03572_ VSS VSS VDD VDD _03573_ sky130_fd_sc_hd__nand2_1
X_14050_ network.in_period\[17\]\[1\] _03573_ VSS VSS VDD
+ VDD _03574_ sky130_fd_sc_hd__nand2_1
X_14051_ _00492_ _03573_ _03574_ VSS VSS VDD VDD _02132_ sky130_fd_sc_hd__o21ai_0
X_14052_ network.neuron_in017.counter\[0\] VSS VSS VDD VDD
+ _00489_ sky130_fd_sc_hd__inv_1
X_14053_ network.in_period\[17\]\[0\] _03573_ VSS VSS VDD
+ VDD _03575_ sky130_fd_sc_hd__nand2_1
X_14054_ network.neuron_in017.counter\[0\] _03573_ _03575_
+ VSS VSS VDD VDD _02131_ sky130_fd_sc_hd__o21ai_0
X_14055_ network.neuron_in138.counter\[2\] network.neuron_in138.counter\[3\]
+ VSS VSS VDD VDD _03576_ sky130_fd_sc_hd__nor2_1
X_14056_ _00657_ _03576_ VSS VSS VDD VDD _03577_ sky130_fd_sc_hd__nand2_1
X_14057_ net351 _03577_ VSS VSS VDD VDD _03578_ sky130_fd_sc_hd__nand2_1
X_14058_ network.in_period\[138\]\[1\] _03578_ VSS VSS VDD
+ VDD _03579_ sky130_fd_sc_hd__nand2_1
X_14059_ _00658_ _03578_ _03579_ VSS VSS VDD VDD _02616_ sky130_fd_sc_hd__o21ai_0
X_14060_ network.neuron_in016.counter\[2\] VSS VSS VDD VDD
+ _03580_ sky130_fd_sc_hd__inv_1
X_14061_ network.in_period\[16\]\[2\] network.neuron_in016.counter\[3\]
+ net423 _00499_ VSS VSS VDD VDD _03581_ sky130_fd_sc_hd__o22ai_1
Xplace317 _03470_ VSS VSS VDD VDD net316 sky130_fd_sc_hd__buf_4
X_14063_ network.neuron_in016.counter\[2\] _00499_ net351
+ VSS VSS VDD VDD _03583_ sky130_fd_sc_hd__nand3_1
X_14064_ network.in_period\[16\]\[2\] net351 _03583_ VSS VSS
+ VDD VDD _03584_ sky130_fd_sc_hd__o21ai_0
X_14065_ _03580_ _03581_ _03584_ VSS VSS VDD VDD _02129_ sky130_fd_sc_hd__a21oi_1
X_14066_ network.in_period\[148\]\[1\] _07012_ VSS VSS VDD
+ VDD _03585_ sky130_fd_sc_hd__nand2_1
X_14067_ _00594_ _07012_ _03585_ VSS VSS VDD VDD _02656_ sky130_fd_sc_hd__o21ai_0
Xplace316 _04109_ VSS VSS VDD VDD net315 sky130_fd_sc_hd__buf_4
X_14069_ _03580_ _00499_ VSS VSS VDD VDD _03587_ sky130_fd_sc_hd__nand2_1
X_14070_ network.neuron_in016.counter\[3\] _03587_ VSS VSS
+ VDD VDD _03588_ sky130_fd_sc_hd__or2_2
X_14071_ net351 _03588_ VSS VSS VDD VDD _03589_ sky130_fd_sc_hd__nand2_1
X_14072_ network.in_period\[16\]\[1\] _03589_ VSS VSS VDD
+ VDD _03590_ sky130_fd_sc_hd__nand2_1
X_14073_ _00500_ _03589_ _03590_ VSS VSS VDD VDD _02128_ sky130_fd_sc_hd__o21ai_0
X_14074_ network.neuron_in130.counter\[2\] VSS VSS VDD VDD
+ _03591_ sky130_fd_sc_hd__inv_1
X_14075_ network.neuron_in130.counter\[3\] network.in_period\[130\]\[2\]
+ _00914_ net417 VSS VSS VDD VDD _03592_ sky130_fd_sc_hd__o22ai_1
X_14076_ network.neuron_in130.counter\[2\] _00914_ net359
+ VSS VSS VDD VDD _03593_ sky130_fd_sc_hd__nand3_1
X_14077_ network.in_period\[130\]\[2\] net359 _03593_ VSS
+ VSS VDD VDD _03594_ sky130_fd_sc_hd__o21ai_0
X_14078_ _03591_ _03592_ _03594_ VSS VSS VDD VDD _02585_ sky130_fd_sc_hd__a21oi_1
X_14079_ network.neuron_in016.counter\[0\] VSS VSS VDD VDD
+ _00497_ sky130_fd_sc_hd__inv_1
X_14080_ network.in_period\[16\]\[0\] _03589_ VSS VSS VDD
+ VDD _03595_ sky130_fd_sc_hd__nand2_1
X_14081_ network.neuron_in016.counter\[0\] _03589_ _03595_
+ VSS VSS VDD VDD _02127_ sky130_fd_sc_hd__o21ai_0
X_14082_ network.neuron_in202.counter\[1\] VSS VSS VDD VDD
+ _00963_ sky130_fd_sc_hd__inv_1
X_14083_ network.neuron_in138.counter\[0\] VSS VSS VDD VDD
+ _00655_ sky130_fd_sc_hd__inv_1
X_14084_ network.in_period\[138\]\[0\] _03578_ VSS VSS VDD
+ VDD _03596_ sky130_fd_sc_hd__nand2_1
X_14085_ network.neuron_in138.counter\[0\] _03578_ _03596_
+ VSS VSS VDD VDD _02615_ sky130_fd_sc_hd__o21ai_0
X_14086_ network.neuron_in178.counter\[2\] VSS VSS VDD VDD
+ _03597_ sky130_fd_sc_hd__inv_1
X_14087_ network.neuron_in178.counter\[3\] network.in_period\[178\]\[2\]
+ _01152_ net415 VSS VSS VDD VDD _03598_ sky130_fd_sc_hd__o22ai_1
X_14088_ network.neuron_in178.counter\[2\] _01152_ net362
+ VSS VSS VDD VDD _03599_ sky130_fd_sc_hd__nand3_1
X_14089_ network.in_period\[178\]\[2\] net362 _03599_ VSS
+ VSS VDD VDD _03600_ sky130_fd_sc_hd__o21ai_0
X_14090_ _03597_ _03598_ _03600_ VSS VSS VDD VDD _02777_ sky130_fd_sc_hd__a21oi_1
X_14091_ network.neuron_in018.counter\[2\] VSS VSS VDD VDD
+ _03601_ sky130_fd_sc_hd__inv_1
Xplace306 _03784_ VSS VSS VDD VDD net305 sky130_fd_sc_hd__buf_4
X_14093_ network.in_period\[18\]\[2\] network.neuron_in018.counter\[3\]
+ _00495_ net418 VSS VSS VDD VDD _03603_ sky130_fd_sc_hd__o22ai_1
X_14094_ network.neuron_in018.counter\[2\] _00495_ net349
+ VSS VSS VDD VDD _03604_ sky130_fd_sc_hd__nand3_1
X_14095_ network.in_period\[18\]\[2\] net349 _03604_ VSS VSS
+ VDD VDD _03605_ sky130_fd_sc_hd__o21ai_0
X_14096_ _03601_ _03603_ _03605_ VSS VSS VDD VDD _02137_ sky130_fd_sc_hd__a21oi_1
X_14097_ network.neuron_in018.counter\[3\] _00495_ VSS VSS
+ VDD VDD _03606_ sky130_fd_sc_hd__nand2b_1
X_14098_ _03606_ _03601_ VSS VSS VDD VDD _03607_ sky130_fd_sc_hd__nand2b_1
X_14099_ net349 _03607_ VSS VSS VDD VDD _03608_ sky130_fd_sc_hd__nand2_1
X_14100_ network.in_period\[18\]\[1\] _03608_ VSS VSS VDD
+ VDD _03609_ sky130_fd_sc_hd__nand2_1
X_14101_ _00496_ _03608_ _03609_ VSS VSS VDD VDD _02136_ sky130_fd_sc_hd__o21ai_0
X_14102_ network.neuron_in018.counter\[0\] VSS VSS VDD VDD
+ _00493_ sky130_fd_sc_hd__inv_1
X_14103_ network.in_period\[18\]\[0\] _03608_ VSS VSS VDD
+ VDD _03610_ sky130_fd_sc_hd__nand2_1
X_14104_ network.neuron_in018.counter\[0\] _03608_ _03610_
+ VSS VSS VDD VDD _02135_ sky130_fd_sc_hd__o21ai_0
X_14105_ network.neuron_in088.counter\[1\] VSS VSS VDD VDD
+ _01213_ sky130_fd_sc_hd__inv_1
X_14106_ network.neuron_in019.counter\[2\] VSS VSS VDD VDD
+ _03611_ sky130_fd_sc_hd__inv_1
X_14107_ network.in_period\[19\]\[2\] network.neuron_in019.counter\[3\]
+ _00479_ net421 VSS VSS VDD VDD _03612_ sky130_fd_sc_hd__o22ai_1
Xplace305 net305 VSS VSS VDD VDD net304 sky130_fd_sc_hd__buf_4
X_14109_ network.neuron_in019.counter\[2\] _00479_ net351
+ VSS VSS VDD VDD _03614_ sky130_fd_sc_hd__nand3_1
X_14110_ network.in_period\[19\]\[2\] net351 _03614_ VSS VSS
+ VDD VDD _03615_ sky130_fd_sc_hd__o21ai_0
X_14111_ _03611_ _03612_ _03615_ VSS VSS VDD VDD _02141_ sky130_fd_sc_hd__a21oi_1
X_14112_ network.neuron_in019.counter\[3\] _00479_ VSS VSS
+ VDD VDD _03616_ sky130_fd_sc_hd__nand2b_1
X_14113_ _03616_ _03611_ VSS VSS VDD VDD _03617_ sky130_fd_sc_hd__nand2b_1
X_14114_ net351 _03617_ VSS VSS VDD VDD _03618_ sky130_fd_sc_hd__nand2_1
X_14115_ network.in_period\[19\]\[1\] _03618_ VSS VSS VDD
+ VDD _03619_ sky130_fd_sc_hd__nand2_1
X_14116_ _00480_ _03618_ _03619_ VSS VSS VDD VDD _02140_ sky130_fd_sc_hd__o21ai_0
X_14117_ network.neuron_in019.counter\[0\] VSS VSS VDD VDD
+ _00477_ sky130_fd_sc_hd__inv_1
X_14118_ network.in_period\[19\]\[0\] _03618_ VSS VSS VDD
+ VDD _03620_ sky130_fd_sc_hd__nand2_1
X_14119_ network.neuron_in019.counter\[0\] _03618_ _03620_
+ VSS VSS VDD VDD _02139_ sky130_fd_sc_hd__o21ai_0
Xplace304 net304 VSS VSS VDD VDD net303 sky130_fd_sc_hd__buf_4
X_14121_ network.neuron_in020.counter\[2\] net349 VSS VSS
+ VDD VDD _03622_ sky130_fd_sc_hd__nand2_1
X_14122_ network.in_period\[20\]\[2\] network.neuron_in020.counter\[3\]
+ _03622_ VSS VSS VDD VDD _03623_ sky130_fd_sc_hd__o21ai_0
X_14123_ _00459_ network.neuron_in020.counter\[2\] net422
+ VSS VSS VDD VDD _03624_ sky130_fd_sc_hd__or3_1
X_14124_ network.in_period\[20\]\[2\] net349 _03624_ VSS VSS
+ VDD VDD _03625_ sky130_fd_sc_hd__o21ai_0
X_14125_ _00459_ _03623_ _03625_ VSS VSS VDD VDD _02145_ sky130_fd_sc_hd__a21oi_1
X_14126_ network.neuron_in020.counter\[2\] _00459_ VSS VSS
+ VDD VDD _03626_ sky130_fd_sc_hd__nand2b_1
X_14127_ network.neuron_in020.counter\[3\] _03626_ VSS VSS
+ VDD VDD _03627_ sky130_fd_sc_hd__or2_2
X_14128_ net349 _03627_ VSS VSS VDD VDD _03628_ sky130_fd_sc_hd__nand2_1
X_14129_ network.in_period\[20\]\[1\] _03628_ VSS VSS VDD
+ VDD _03629_ sky130_fd_sc_hd__nand2_1
X_14130_ _00460_ _03628_ _03629_ VSS VSS VDD VDD _02144_ sky130_fd_sc_hd__o21ai_0
X_14131_ network.in_period\[20\]\[0\] _03628_ VSS VSS VDD
+ VDD _03630_ sky130_fd_sc_hd__nand2_1
X_14132_ network.neuron_in020.counter\[0\] _03628_ _03630_
+ VSS VSS VDD VDD _02143_ sky130_fd_sc_hd__o21ai_0
X_14133_ network.neuron_in027.counter\[0\] VSS VSS VDD VDD
+ _00529_ sky130_fd_sc_hd__inv_1
X_14134_ network.neuron_in251.counter\[1\] VSS VSS VDD VDD
+ _00474_ sky130_fd_sc_hd__inv_1
X_14135_ network.neuron_in021.counter\[2\] VSS VSS VDD VDD
+ _03631_ sky130_fd_sc_hd__inv_1
X_14136_ network.in_period\[21\]\[2\] network.neuron_in021.counter\[3\]
+ _00467_ net422 VSS VSS VDD VDD _03632_ sky130_fd_sc_hd__o22ai_1
X_14137_ network.neuron_in021.counter\[2\] _00467_ net349
+ VSS VSS VDD VDD _03633_ sky130_fd_sc_hd__nand3_1
X_14138_ network.in_period\[21\]\[2\] net349 _03633_ VSS VSS
+ VDD VDD _03634_ sky130_fd_sc_hd__o21ai_0
X_14139_ _03631_ _03632_ _03634_ VSS VSS VDD VDD _02149_ sky130_fd_sc_hd__a21oi_1
X_14140_ network.neuron_in021.counter\[2\] network.neuron_in021.counter\[3\]
+ VSS VSS VDD VDD _03635_ sky130_fd_sc_hd__nor2_1
X_14141_ _00467_ _03635_ VSS VSS VDD VDD _03636_ sky130_fd_sc_hd__nand2_1
X_14142_ net349 _03636_ VSS VSS VDD VDD _03637_ sky130_fd_sc_hd__nand2_1
X_14143_ network.in_period\[21\]\[1\] _03637_ VSS VSS VDD
+ VDD _03638_ sky130_fd_sc_hd__nand2_1
X_14144_ _00468_ _03637_ _03638_ VSS VSS VDD VDD _02148_ sky130_fd_sc_hd__o21ai_0
X_14145_ network.neuron_in021.counter\[0\] VSS VSS VDD VDD
+ _00465_ sky130_fd_sc_hd__inv_1
X_14146_ network.in_period\[21\]\[0\] _03637_ VSS VSS VDD
+ VDD _03639_ sky130_fd_sc_hd__nand2_1
X_14147_ network.neuron_in021.counter\[0\] _03637_ _03639_
+ VSS VSS VDD VDD _02147_ sky130_fd_sc_hd__o21ai_0
X_14148_ network.neuron_in022.counter\[2\] VSS VSS VDD VDD
+ _03640_ sky130_fd_sc_hd__inv_1
X_14149_ network.in_period\[22\]\[2\] network.neuron_in022.counter\[3\]
+ _00449_ net423 VSS VSS VDD VDD _03641_ sky130_fd_sc_hd__o22ai_1
X_14150_ network.neuron_in022.counter\[2\] _00449_ net349
+ VSS VSS VDD VDD _03642_ sky130_fd_sc_hd__nand3_1
X_14151_ network.in_period\[22\]\[2\] net349 _03642_ VSS VSS
+ VDD VDD _03643_ sky130_fd_sc_hd__o21ai_0
X_14152_ _03640_ _03641_ _03643_ VSS VSS VDD VDD _02153_ sky130_fd_sc_hd__a21oi_1
Xplace303 net305 VSS VSS VDD VDD net302 sky130_fd_sc_hd__buf_4
X_14154_ network.neuron_in022.counter\[2\] network.neuron_in022.counter\[3\]
+ VSS VSS VDD VDD _03645_ sky130_fd_sc_hd__nor2_1
X_14155_ _00449_ _03645_ VSS VSS VDD VDD _03646_ sky130_fd_sc_hd__nand2_1
X_14156_ net349 _03646_ VSS VSS VDD VDD _03647_ sky130_fd_sc_hd__nand2_1
X_14157_ network.in_period\[22\]\[1\] _03647_ VSS VSS VDD
+ VDD _03648_ sky130_fd_sc_hd__nand2_1
X_14158_ _00450_ _03647_ _03648_ VSS VSS VDD VDD _02152_ sky130_fd_sc_hd__o21ai_0
X_14159_ network.neuron_in022.counter\[0\] VSS VSS VDD VDD
+ _00447_ sky130_fd_sc_hd__inv_1
X_14160_ network.in_period\[22\]\[0\] _03647_ VSS VSS VDD
+ VDD _03649_ sky130_fd_sc_hd__nand2_1
X_14161_ network.neuron_in022.counter\[0\] _03647_ _03649_
+ VSS VSS VDD VDD _02151_ sky130_fd_sc_hd__o21ai_0
X_14162_ network.neuron_in023.counter\[2\] VSS VSS VDD VDD
+ _03650_ sky130_fd_sc_hd__inv_1
X_14163_ network.in_period\[23\]\[2\] network.neuron_in023.counter\[3\]
+ _00441_ net421 VSS VSS VDD VDD _03651_ sky130_fd_sc_hd__o22ai_1
X_14164_ network.neuron_in023.counter\[2\] _00441_ net351
+ VSS VSS VDD VDD _03652_ sky130_fd_sc_hd__nand3_1
X_14165_ network.in_period\[23\]\[2\] net351 _03652_ VSS VSS
+ VDD VDD _03653_ sky130_fd_sc_hd__o21ai_0
X_14166_ _03650_ _03651_ _03653_ VSS VSS VDD VDD _02157_ sky130_fd_sc_hd__a21oi_1
X_14167_ _03650_ _00441_ VSS VSS VDD VDD _03654_ sky130_fd_sc_hd__nand2_1
X_14168_ network.neuron_in023.counter\[3\] _03654_ VSS VSS
+ VDD VDD _03655_ sky130_fd_sc_hd__or2_2
X_14169_ net351 _03655_ VSS VSS VDD VDD _03656_ sky130_fd_sc_hd__nand2_1
X_14170_ network.in_period\[23\]\[1\] _03656_ VSS VSS VDD
+ VDD _03657_ sky130_fd_sc_hd__nand2_1
X_14171_ _00442_ _03656_ _03657_ VSS VSS VDD VDD _02156_ sky130_fd_sc_hd__o21ai_0
X_14172_ network.neuron_in023.counter\[0\] VSS VSS VDD VDD
+ _00439_ sky130_fd_sc_hd__inv_1
X_14173_ network.in_period\[23\]\[0\] _03656_ VSS VSS VDD
+ VDD _03658_ sky130_fd_sc_hd__nand2_1
X_14174_ network.neuron_in023.counter\[0\] _03656_ _03658_
+ VSS VSS VDD VDD _02155_ sky130_fd_sc_hd__o21ai_0
X_14175_ network.neuron_in024.counter\[2\] VSS VSS VDD VDD
+ _03659_ sky130_fd_sc_hd__inv_1
X_14176_ network.in_period\[24\]\[2\] network.neuron_in024.counter\[3\]
+ _00445_ net422 VSS VSS VDD VDD _03660_ sky130_fd_sc_hd__o22ai_1
X_14177_ network.neuron_in024.counter\[2\] _00445_ net349
+ VSS VSS VDD VDD _03661_ sky130_fd_sc_hd__nand3_1
X_14178_ network.in_period\[24\]\[2\] net349 _03661_ VSS VSS
+ VDD VDD _03662_ sky130_fd_sc_hd__o21ai_0
X_14179_ _03659_ _03660_ _03662_ VSS VSS VDD VDD _02161_ sky130_fd_sc_hd__a21oi_1
X_14180_ _03659_ _00445_ VSS VSS VDD VDD _03663_ sky130_fd_sc_hd__nand2_1
X_14181_ network.neuron_in024.counter\[3\] _03663_ VSS VSS
+ VDD VDD _03664_ sky130_fd_sc_hd__or2_2
X_14182_ net349 _03664_ VSS VSS VDD VDD _03665_ sky130_fd_sc_hd__nand2_1
X_14183_ network.in_period\[24\]\[1\] _03665_ VSS VSS VDD
+ VDD _03666_ sky130_fd_sc_hd__nand2_1
X_14184_ _00446_ _03665_ _03666_ VSS VSS VDD VDD _02160_ sky130_fd_sc_hd__o21ai_0
X_14185_ network.neuron_in024.counter\[0\] VSS VSS VDD VDD
+ _00443_ sky130_fd_sc_hd__inv_1
X_14186_ network.in_period\[24\]\[0\] _03665_ VSS VSS VDD
+ VDD _03667_ sky130_fd_sc_hd__nand2_1
X_14187_ network.neuron_in024.counter\[0\] _03665_ _03667_
+ VSS VSS VDD VDD _02159_ sky130_fd_sc_hd__o21ai_0
X_14188_ network.neuron_in130.counter\[0\] VSS VSS VDD VDD
+ _00912_ sky130_fd_sc_hd__inv_1
X_14189_ network.neuron_in130.counter\[3\] _00914_ VSS VSS
+ VDD VDD _03668_ sky130_fd_sc_hd__nand2b_1
X_14190_ _03668_ _03591_ VSS VSS VDD VDD _03669_ sky130_fd_sc_hd__nand2b_1
X_14191_ net359 _03669_ VSS VSS VDD VDD _03670_ sky130_fd_sc_hd__nand2_1
X_14192_ network.in_period\[130\]\[0\] _03670_ VSS VSS VDD
+ VDD _03671_ sky130_fd_sc_hd__nand2_1
X_14193_ network.neuron_in130.counter\[0\] _03670_ _03671_
+ VSS VSS VDD VDD _02583_ sky130_fd_sc_hd__o21ai_0
X_14194_ network.neuron_in131.counter\[2\] network.neuron_in131.counter\[3\]
+ VSS VSS VDD VDD _03672_ sky130_fd_sc_hd__nor2_1
X_14195_ net413 _03672_ VSS VSS VDD VDD _03673_ sky130_fd_sc_hd__nor2_1
X_14196_ network.neuron_in131.counter\[2\] _00902_ VSS VSS
+ VDD VDD _03674_ sky130_fd_sc_hd__xnor2_1
X_14197_ network.in_period\[131\]\[2\] _03673_ _03674_ net359
+ VSS VSS VDD VDD _02589_ sky130_fd_sc_hd__a2bb2oi_1
X_14198_ network.neuron_in030.counter\[3\] _00483_ VSS VSS
+ VDD VDD _03675_ sky130_fd_sc_hd__nand2b_1
X_14199_ network.neuron_in030.counter\[2\] VSS VSS VDD VDD
+ _03676_ sky130_fd_sc_hd__inv_1
X_14200_ _03675_ _03676_ VSS VSS VDD VDD _03677_ sky130_fd_sc_hd__nand2b_1
X_14201_ net341 _03677_ VSS VSS VDD VDD _03678_ sky130_fd_sc_hd__nand2_1
X_14202_ network.in_period\[30\]\[0\] _03678_ VSS VSS VDD
+ VDD _03679_ sky130_fd_sc_hd__nand2_1
X_14203_ network.neuron_in030.counter\[0\] _03678_ _03679_
+ VSS VSS VDD VDD _02183_ sky130_fd_sc_hd__o21ai_0
X_14204_ network.in_period\[30\]\[1\] _03678_ VSS VSS VDD
+ VDD _03680_ sky130_fd_sc_hd__nand2_1
X_14205_ _00484_ _03678_ _03680_ VSS VSS VDD VDD _02184_ sky130_fd_sc_hd__o21ai_0
X_14206_ network.neuron_in025.counter\[0\] VSS VSS VDD VDD
+ _00435_ sky130_fd_sc_hd__inv_1
X_14207_ network.neuron_in025.counter\[3\] _00437_ VSS VSS
+ VDD VDD _03681_ sky130_fd_sc_hd__nand2b_1
X_14208_ network.neuron_in025.counter\[2\] VSS VSS VDD VDD
+ _03682_ sky130_fd_sc_hd__inv_1
X_14209_ _03681_ _03682_ VSS VSS VDD VDD _03683_ sky130_fd_sc_hd__nand2b_1
X_14210_ net341 _03683_ VSS VSS VDD VDD _03684_ sky130_fd_sc_hd__nand2_1
X_14211_ network.in_period\[25\]\[0\] _03684_ VSS VSS VDD
+ VDD _03685_ sky130_fd_sc_hd__nand2_1
X_14212_ network.neuron_in025.counter\[0\] _03684_ _03685_
+ VSS VSS VDD VDD _02163_ sky130_fd_sc_hd__o21ai_0
X_14213_ network.neuron_in026.counter\[2\] VSS VSS VDD VDD
+ _03686_ sky130_fd_sc_hd__inv_1
X_14214_ network.in_period\[26\]\[2\] network.neuron_in026.counter\[3\]
+ _00535_ net422 VSS VSS VDD VDD _03687_ sky130_fd_sc_hd__o22ai_1
X_14215_ network.neuron_in026.counter\[2\] _00535_ net349
+ VSS VSS VDD VDD _03688_ sky130_fd_sc_hd__nand3_1
X_14216_ network.in_period\[26\]\[2\] net349 _03688_ VSS VSS
+ VDD VDD _03689_ sky130_fd_sc_hd__o21ai_0
X_14217_ _03686_ _03687_ _03689_ VSS VSS VDD VDD _02169_ sky130_fd_sc_hd__a21oi_1
X_14218_ network.neuron_in103.counter\[1\] VSS VSS VDD VDD
+ _00113_ sky130_fd_sc_hd__inv_1
X_14219_ network.neuron_in030.counter\[3\] network.in_period\[30\]\[2\]
+ net424 _00483_ VSS VSS VDD VDD _03690_ sky130_fd_sc_hd__o22ai_1
Xplace302 net302 VSS VSS VDD VDD net301 sky130_fd_sc_hd__buf_4
X_14221_ network.neuron_in030.counter\[2\] _00483_ net341
+ VSS VSS VDD VDD _03692_ sky130_fd_sc_hd__nand3_1
X_14222_ network.in_period\[30\]\[2\] net341 _03692_ VSS VSS
+ VDD VDD _03693_ sky130_fd_sc_hd__o21ai_0
X_14223_ _03676_ _03690_ _03693_ VSS VSS VDD VDD _02185_ sky130_fd_sc_hd__a21oi_1
X_14224_ network.neuron_in025.counter\[3\] network.in_period\[25\]\[2\]
+ _00437_ net424 VSS VSS VDD VDD _03694_ sky130_fd_sc_hd__o22ai_1
X_14225_ network.neuron_in025.counter\[2\] _00437_ net341
+ VSS VSS VDD VDD _03695_ sky130_fd_sc_hd__nand3_1
X_14226_ network.in_period\[25\]\[2\] net341 _03695_ VSS VSS
+ VDD VDD _03696_ sky130_fd_sc_hd__o21ai_0
X_14227_ _03682_ _03694_ _03696_ VSS VSS VDD VDD _02165_ sky130_fd_sc_hd__a21oi_1
X_14228_ network.in_period\[25\]\[1\] _03684_ VSS VSS VDD
+ VDD _03697_ sky130_fd_sc_hd__nand2_1
X_14229_ _00438_ _03684_ _03697_ VSS VSS VDD VDD _02164_ sky130_fd_sc_hd__o21ai_0
X_14230_ network.neuron_in026.counter\[2\] network.neuron_in026.counter\[3\]
+ VSS VSS VDD VDD _03698_ sky130_fd_sc_hd__nor2_1
X_14231_ _00535_ _03698_ VSS VSS VDD VDD _03699_ sky130_fd_sc_hd__nand2_1
X_14232_ net349 _03699_ VSS VSS VDD VDD _03700_ sky130_fd_sc_hd__nand2_1
X_14233_ network.in_period\[26\]\[1\] _03700_ VSS VSS VDD
+ VDD _03701_ sky130_fd_sc_hd__nand2_1
X_14234_ _00536_ _03700_ _03701_ VSS VSS VDD VDD _02168_ sky130_fd_sc_hd__o21ai_0
X_14235_ network.neuron_in026.counter\[0\] VSS VSS VDD VDD
+ _00533_ sky130_fd_sc_hd__inv_1
X_14236_ network.in_period\[26\]\[0\] _03700_ VSS VSS VDD
+ VDD _03702_ sky130_fd_sc_hd__nand2_1
X_14237_ network.neuron_in026.counter\[0\] _03700_ _03702_
+ VSS VSS VDD VDD _02167_ sky130_fd_sc_hd__o21ai_0
X_14238_ network.neuron_in031.counter\[0\] VSS VSS VDD VDD
+ _01198_ sky130_fd_sc_hd__inv_1
X_14239_ network.neuron_in031.counter\[3\] _01200_ VSS VSS
+ VDD VDD _03703_ sky130_fd_sc_hd__nand2b_1
X_14240_ network.neuron_in031.counter\[2\] VSS VSS VDD VDD
+ _03704_ sky130_fd_sc_hd__inv_1
X_14241_ _03703_ _03704_ VSS VSS VDD VDD _03705_ sky130_fd_sc_hd__nand2b_1
X_14242_ net349 _03705_ VSS VSS VDD VDD _03706_ sky130_fd_sc_hd__nand2_1
X_14243_ network.in_period\[31\]\[0\] _03706_ VSS VSS VDD
+ VDD _03707_ sky130_fd_sc_hd__nand2_1
X_14244_ network.neuron_in031.counter\[0\] _03706_ _03707_
+ VSS VSS VDD VDD _02187_ sky130_fd_sc_hd__o21ai_0
X_14245_ network.neuron_in032.counter\[0\] VSS VSS VDD VDD
+ _01134_ sky130_fd_sc_hd__inv_1
X_14246_ network.neuron_in032.counter\[2\] _01136_ VSS VSS
+ VDD VDD _03708_ sky130_fd_sc_hd__nand2b_1
Xplace301 net301 VSS VSS VDD VDD net300 sky130_fd_sc_hd__buf_4
X_14248_ network.neuron_in032.counter\[3\] _03708_ net351
+ VSS VSS VDD VDD _03710_ sky130_fd_sc_hd__o21ai_0
X_14249_ network.in_period\[32\]\[0\] _03710_ VSS VSS VDD
+ VDD _03711_ sky130_fd_sc_hd__nand2_1
X_14250_ network.neuron_in032.counter\[0\] _03710_ _03711_
+ VSS VSS VDD VDD _02191_ sky130_fd_sc_hd__o21ai_0
X_14251_ network.neuron_in103.counter\[0\] VSS VSS VDD VDD
+ _00112_ sky130_fd_sc_hd__inv_1
X_14252_ network.neuron_in031.counter\[3\] network.in_period\[31\]\[2\]
+ _01200_ net424 VSS VSS VDD VDD _03712_ sky130_fd_sc_hd__o22ai_1
X_14253_ network.neuron_in031.counter\[2\] _01200_ net341
+ VSS VSS VDD VDD _03713_ sky130_fd_sc_hd__nand3_1
X_14254_ network.in_period\[31\]\[2\] net341 _03713_ VSS VSS
+ VDD VDD _03714_ sky130_fd_sc_hd__o21ai_0
X_14255_ _03704_ _03712_ _03714_ VSS VSS VDD VDD _02189_ sky130_fd_sc_hd__a21oi_1
X_14256_ network.in_period\[31\]\[1\] _03706_ VSS VSS VDD
+ VDD _03715_ sky130_fd_sc_hd__nand2_1
X_14257_ _01201_ _03706_ _03715_ VSS VSS VDD VDD _02188_ sky130_fd_sc_hd__o21ai_0
X_14258_ _01136_ network.neuron_in032.counter\[2\] VSS VSS
+ VDD VDD _03716_ sky130_fd_sc_hd__nand2b_1
X_14259_ network.neuron_in032.counter\[3\] _01136_ VSS VSS
+ VDD VDD _03717_ sky130_fd_sc_hd__nand2b_1
X_14260_ net351 _03717_ network.in_period\[32\]\[2\] VSS VSS
+ VDD VDD _03718_ sky130_fd_sc_hd__a21oi_1
X_14261_ net351 _03708_ _03716_ _03718_ VSS VSS VDD VDD _02193_
+ sky130_fd_sc_hd__a31oi_1
X_14262_ network.in_period\[32\]\[1\] _03710_ VSS VSS VDD
+ VDD _03719_ sky130_fd_sc_hd__nand2_1
X_14263_ _01137_ _03710_ _03719_ VSS VSS VDD VDD _02192_ sky130_fd_sc_hd__o21ai_0
X_14264_ network.neuron_in034.counter\[0\] VSS VSS VDD VDD
+ _00411_ sky130_fd_sc_hd__inv_1
Xplace300 net300 VSS VSS VDD VDD net299 sky130_fd_sc_hd__buf_4
X_14266_ network.neuron_in034.counter\[3\] _00413_ VSS VSS
+ VDD VDD _03721_ sky130_fd_sc_hd__nand2b_1
X_14267_ network.neuron_in034.counter\[2\] VSS VSS VDD VDD
+ _03722_ sky130_fd_sc_hd__inv_1
X_14268_ _03721_ _03722_ VSS VSS VDD VDD _03723_ sky130_fd_sc_hd__nand2b_1
X_14269_ net351 _03723_ VSS VSS VDD VDD _03724_ sky130_fd_sc_hd__nand2_1
X_14270_ network.in_period\[34\]\[0\] _03724_ VSS VSS VDD
+ VDD _03725_ sky130_fd_sc_hd__nand2_1
X_14271_ network.neuron_in034.counter\[0\] _03724_ _03725_
+ VSS VSS VDD VDD _02199_ sky130_fd_sc_hd__o21ai_0
X_14272_ _00902_ _03672_ VSS VSS VDD VDD _03726_ sky130_fd_sc_hd__nand2_1
X_14273_ net359 _03726_ VSS VSS VDD VDD _03727_ sky130_fd_sc_hd__nand2_1
X_14274_ network.in_period\[131\]\[1\] _03727_ VSS VSS VDD
+ VDD _03728_ sky130_fd_sc_hd__nand2_1
X_14275_ _00903_ _03727_ _03728_ VSS VSS VDD VDD _02588_ sky130_fd_sc_hd__o21ai_0
X_14276_ network.in_period\[34\]\[1\] _03724_ VSS VSS VDD
+ VDD _03729_ sky130_fd_sc_hd__nand2_1
X_14277_ _00414_ _03724_ _03729_ VSS VSS VDD VDD _02200_ sky130_fd_sc_hd__o21ai_0
X_14278_ network.neuron_in137.counter\[0\] VSS VSS VDD VDD
+ _00722_ sky130_fd_sc_hd__inv_1
X_14279_ network.in_period\[137\]\[0\] _06822_ VSS VSS VDD
+ VDD _03730_ sky130_fd_sc_hd__nand2_1
X_14280_ network.neuron_in137.counter\[0\] _06822_ _03730_
+ VSS VSS VDD VDD _02611_ sky130_fd_sc_hd__o21ai_0
X_14281_ network.neuron_in035.counter\[0\] VSS VSS VDD VDD
+ _00415_ sky130_fd_sc_hd__inv_1
X_14282_ network.neuron_in035.counter\[3\] _00417_ VSS VSS
+ VDD VDD _03731_ sky130_fd_sc_hd__nand2b_1
X_14283_ network.neuron_in035.counter\[2\] VSS VSS VDD VDD
+ _03732_ sky130_fd_sc_hd__inv_1
X_14284_ _03731_ _03732_ VSS VSS VDD VDD _03733_ sky130_fd_sc_hd__nand2b_1
X_14285_ net351 _03733_ VSS VSS VDD VDD _03734_ sky130_fd_sc_hd__nand2_1
X_14286_ network.in_period\[35\]\[0\] _03734_ VSS VSS VDD
+ VDD _03735_ sky130_fd_sc_hd__nand2_1
X_14287_ network.neuron_in035.counter\[0\] _03734_ _03735_
+ VSS VSS VDD VDD _02203_ sky130_fd_sc_hd__o21ai_0
X_14288_ network.neuron_in131.counter\[0\] VSS VSS VDD VDD
+ _00900_ sky130_fd_sc_hd__inv_1
X_14289_ network.in_period\[131\]\[0\] _03727_ VSS VSS VDD
+ VDD _03736_ sky130_fd_sc_hd__nand2_1
X_14290_ network.neuron_in131.counter\[0\] _03727_ _03736_
+ VSS VSS VDD VDD _02587_ sky130_fd_sc_hd__o21ai_0
X_14291_ network.neuron_in033.counter\[3\] _00629_ VSS VSS
+ VDD VDD _03737_ sky130_fd_sc_hd__nand2b_1
X_14292_ network.neuron_in033.counter\[2\] VSS VSS VDD VDD
+ _03738_ sky130_fd_sc_hd__inv_1
X_14293_ _03737_ _03738_ VSS VSS VDD VDD _03739_ sky130_fd_sc_hd__nand2b_1
X_14294_ net351 _03739_ VSS VSS VDD VDD _03740_ sky130_fd_sc_hd__nand2_1
X_14295_ network.in_period\[33\]\[0\] _03740_ VSS VSS VDD
+ VDD _03741_ sky130_fd_sc_hd__nand2_1
X_14296_ network.neuron_in033.counter\[0\] _03740_ _03741_
+ VSS VSS VDD VDD _02195_ sky130_fd_sc_hd__o21ai_0
X_14297_ network.neuron_in132.counter\[2\] VSS VSS VDD VDD
+ _03742_ sky130_fd_sc_hd__inv_1
X_14298_ network.neuron_in132.counter\[3\] network.in_period\[132\]\[2\]
+ net421 _01168_ VSS VSS VDD VDD _03743_ sky130_fd_sc_hd__o22ai_1
Xplace299 net305 VSS VSS VDD VDD net298 sky130_fd_sc_hd__buf_4
X_14300_ network.neuron_in132.counter\[2\] _01168_ net352
+ VSS VSS VDD VDD _03745_ sky130_fd_sc_hd__nand3_1
X_14301_ network.in_period\[132\]\[2\] net352 _03745_ VSS
+ VSS VDD VDD _03746_ sky130_fd_sc_hd__o21ai_0
X_14302_ _03742_ _03743_ _03746_ VSS VSS VDD VDD _02593_ sky130_fd_sc_hd__a21oi_1
X_14303_ network.neuron_in034.counter\[3\] network.in_period\[34\]\[2\]
+ net424 _00413_ VSS VSS VDD VDD _03747_ sky130_fd_sc_hd__o22ai_1
X_14304_ network.neuron_in034.counter\[2\] _00413_ net351
+ VSS VSS VDD VDD _03748_ sky130_fd_sc_hd__nand3_1
X_14305_ network.in_period\[34\]\[2\] net351 _03748_ VSS VSS
+ VDD VDD _03749_ sky130_fd_sc_hd__o21ai_0
X_14306_ _03722_ _03747_ _03749_ VSS VSS VDD VDD _02201_ sky130_fd_sc_hd__a21oi_1
X_14307_ network.in_period\[35\]\[1\] _03734_ VSS VSS VDD
+ VDD _03750_ sky130_fd_sc_hd__nand2_1
X_14308_ _00418_ _03734_ _03750_ VSS VSS VDD VDD _02204_ sky130_fd_sc_hd__o21ai_0
X_14309_ network.neuron_in033.counter\[3\] network.in_period\[33\]\[2\]
+ net421 _00629_ VSS VSS VDD VDD _03751_ sky130_fd_sc_hd__o22ai_1
X_14310_ network.neuron_in033.counter\[2\] _00629_ net351
+ VSS VSS VDD VDD _03752_ sky130_fd_sc_hd__nand3_1
X_14311_ network.in_period\[33\]\[2\] net351 _03752_ VSS VSS
+ VDD VDD _03753_ sky130_fd_sc_hd__o21ai_0
X_14312_ _03738_ _03751_ _03753_ VSS VSS VDD VDD _02197_ sky130_fd_sc_hd__a21oi_1
X_14313_ network.in_period\[33\]\[1\] _03740_ VSS VSS VDD
+ VDD _03754_ sky130_fd_sc_hd__nand2_1
X_14314_ _00630_ _03740_ _03754_ VSS VSS VDD VDD _02196_ sky130_fd_sc_hd__o21ai_0
X_14315_ network.neuron_in138.counter\[2\] VSS VSS VDD VDD
+ _03755_ sky130_fd_sc_hd__inv_1
X_14316_ network.neuron_in138.counter\[3\] network.in_period\[138\]\[2\]
+ _00657_ net421 VSS VSS VDD VDD _03756_ sky130_fd_sc_hd__o22ai_1
X_14317_ network.neuron_in138.counter\[2\] _00657_ net351
+ VSS VSS VDD VDD _03757_ sky130_fd_sc_hd__nand3_1
X_14318_ network.in_period\[138\]\[2\] net351 _03757_ VSS
+ VSS VDD VDD _03758_ sky130_fd_sc_hd__o21ai_0
X_14319_ _03755_ _03756_ _03758_ VSS VSS VDD VDD _02617_ sky130_fd_sc_hd__a21oi_1
X_14320_ network.neuron_in207.counter\[1\] VSS VSS VDD VDD
+ _00955_ sky130_fd_sc_hd__inv_1
X_14321_ network.neuron_in105.counter\[0\] VSS VSS VDD VDD
+ _00555_ sky130_fd_sc_hd__inv_1
X_14322_ network.neuron_in114.counter\[1\] VSS VSS VDD VDD
+ _01246_ sky130_fd_sc_hd__inv_1
Xplace412 net412 VSS VSS VDD VDD net411 sky130_fd_sc_hd__buf_4
X_14324_ network.neuron_in035.counter\[3\] network.in_period\[35\]\[2\]
+ _00417_ net424 VSS VSS VDD VDD _03760_ sky130_fd_sc_hd__o22ai_1
X_14325_ network.neuron_in035.counter\[2\] _00417_ net351
+ VSS VSS VDD VDD _03761_ sky130_fd_sc_hd__nand3_1
X_14326_ network.in_period\[35\]\[2\] net351 _03761_ VSS VSS
+ VDD VDD _03762_ sky130_fd_sc_hd__o21ai_0
X_14327_ _03732_ _03760_ _03762_ VSS VSS VDD VDD _02205_ sky130_fd_sc_hd__a21oi_1
X_14328_ network.neuron_in039.counter\[0\] VSS VSS VDD VDD
+ _00367_ sky130_fd_sc_hd__inv_1
X_14329_ network.neuron_in039.counter\[2\] VSS VSS VDD VDD
+ _03763_ sky130_fd_sc_hd__inv_1
X_14330_ _03763_ _00369_ VSS VSS VDD VDD _03764_ sky130_fd_sc_hd__nand2_1
X_14331_ network.neuron_in039.counter\[3\] _03764_ VSS VSS
+ VDD VDD _03765_ sky130_fd_sc_hd__or2_2
X_14332_ net343 _03765_ VSS VSS VDD VDD _03766_ sky130_fd_sc_hd__nand2_1
X_14333_ network.in_period\[39\]\[0\] _03766_ VSS VSS VDD
+ VDD _03767_ sky130_fd_sc_hd__nand2_1
X_14334_ network.neuron_in039.counter\[0\] _03766_ _03767_
+ VSS VSS VDD VDD _02219_ sky130_fd_sc_hd__o21ai_0
X_14335_ network.neuron_in037.counter\[3\] _00393_ VSS VSS
+ VDD VDD _03768_ sky130_fd_sc_hd__nand2b_1
X_14336_ network.neuron_in037.counter\[2\] VSS VSS VDD VDD
+ _03769_ sky130_fd_sc_hd__inv_1
X_14337_ _03768_ _03769_ VSS VSS VDD VDD _03770_ sky130_fd_sc_hd__nand2b_1
X_14338_ net340 _03770_ VSS VSS VDD VDD _03771_ sky130_fd_sc_hd__nand2_1
X_14339_ network.in_period\[37\]\[1\] _03771_ VSS VSS VDD
+ VDD _03772_ sky130_fd_sc_hd__nand2_1
X_14340_ _00394_ _03771_ _03772_ VSS VSS VDD VDD _02212_ sky130_fd_sc_hd__o21ai_0
X_14341_ network.in_period\[39\]\[1\] _03766_ VSS VSS VDD
+ VDD _03773_ sky130_fd_sc_hd__nand2_1
X_14342_ _00370_ _03766_ _03773_ VSS VSS VDD VDD _02220_ sky130_fd_sc_hd__o21ai_0
X_14343_ network.neuron_in036.counter\[2\] VSS VSS VDD VDD
+ _03774_ sky130_fd_sc_hd__inv_1
X_14344_ network.in_period\[36\]\[2\] network.neuron_in036.counter\[3\]
+ net424 _00401_ VSS VSS VDD VDD _03775_ sky130_fd_sc_hd__o22ai_1
X_14345_ network.neuron_in036.counter\[2\] _00401_ net351
+ VSS VSS VDD VDD _03776_ sky130_fd_sc_hd__nand3_1
X_14346_ network.in_period\[36\]\[2\] net351 _03776_ VSS VSS
+ VDD VDD _03777_ sky130_fd_sc_hd__o21ai_0
X_14347_ _03774_ _03775_ _03777_ VSS VSS VDD VDD _02209_ sky130_fd_sc_hd__a21oi_1
X_14348_ network.neuron_in037.counter\[3\] network.in_period\[37\]\[2\]
+ _00393_ net425 VSS VSS VDD VDD _03778_ sky130_fd_sc_hd__o22ai_1
X_14349_ network.neuron_in037.counter\[2\] _00393_ net340
+ VSS VSS VDD VDD _03779_ sky130_fd_sc_hd__nand3_1
X_14350_ network.in_period\[37\]\[2\] net340 _03779_ VSS VSS
+ VDD VDD _03780_ sky130_fd_sc_hd__o21ai_0
X_14351_ _03769_ _03778_ _03780_ VSS VSS VDD VDD _02213_ sky130_fd_sc_hd__a21oi_1
X_14352_ net366 _08818_ VSS VSS VDD VDD _03781_ sky130_fd_sc_hd__nand2_1
X_14353_ network.cnt_main.counter\[11\] _08808_ _08810_ VSS
+ VSS VDD VDD _03782_ sky130_fd_sc_hd__nor3_1
X_14354_ network.cnt_main.counter\[12\] _03782_ VSS VSS VDD
+ VDD _03783_ sky130_fd_sc_hd__xnor2_1
X_14355_ _03781_ _03783_ VSS VSS VDD VDD _01729_ sky130_fd_sc_hd__nor2_1
X_14356_ _06673_ _08812_ VSS VSS VDD VDD _03784_ sky130_fd_sc_hd__nor2_1
Xplace410 _07329_ VSS VSS VDD VDD net409 sky130_fd_sc_hd__buf_4
Xplace406 _07377_ VSS VSS VDD VDD net405 sky130_fd_sc_hd__buf_4
X_14359_ network.cnt_main.counter\[0\] VSS VSS VDD VDD _00688_
+ sky130_fd_sc_hd__inv_1
X_14360_ _00689_ _00688_ _08806_ VSS VSS VDD VDD _03787_ sky130_fd_sc_hd__nand3_1
X_14361_ network.cnt_main.counter\[5\] network.cnt_main.counter\[6\]
+ _03787_ VSS VSS VDD VDD _03788_ sky130_fd_sc_hd__or3_1
X_14362_ network.cnt_main.counter\[7\] _08810_ _03788_ VSS
+ VSS VDD VDD _03789_ sky130_fd_sc_hd__nor3_1
X_14363_ network.cnt_main.counter\[11\] _03789_ VSS VSS VDD
+ VDD _03790_ sky130_fd_sc_hd__xnor2_1
X_14364_ _03784_ _03790_ VSS VSS VDD VDD _01730_ sky130_fd_sc_hd__nand2_1
X_14365_ network.cnt_main.counter\[9\] network.cnt_main.counter\[8\]
+ _08808_ VSS VSS VDD VDD _03791_ sky130_fd_sc_hd__nor3_1
X_14366_ network.cnt_main.counter\[10\] _03791_ VSS VSS VDD
+ VDD _03792_ sky130_fd_sc_hd__xnor2_1
X_14367_ _03781_ _03792_ VSS VSS VDD VDD _01731_ sky130_fd_sc_hd__nor2_1
X_14368_ network.cnt_main.counter\[7\] network.cnt_main.counter\[8\]
+ _03788_ VSS VSS VDD VDD _03793_ sky130_fd_sc_hd__nor3_1
X_14369_ network.cnt_main.counter\[9\] _03793_ VSS VSS VDD
+ VDD _03794_ sky130_fd_sc_hd__xnor2_1
X_14370_ _03781_ _03794_ VSS VSS VDD VDD _01732_ sky130_fd_sc_hd__nor2_1
X_14371_ network.cnt_main.counter\[8\] _08808_ VSS VSS VDD
+ VDD _03795_ sky130_fd_sc_hd__xor2_1
X_14372_ _03784_ _03795_ VSS VSS VDD VDD _01733_ sky130_fd_sc_hd__nand2_1
X_14373_ network.cnt_main.counter\[7\] _03788_ VSS VSS VDD
+ VDD _03796_ sky130_fd_sc_hd__xor2_1
X_14374_ _03784_ _03796_ VSS VSS VDD VDD _01734_ sky130_fd_sc_hd__nand2_1
X_14375_ network.cnt_main.counter\[6\] _08807_ VSS VSS VDD
+ VDD _03797_ sky130_fd_sc_hd__xor2_1
X_14376_ net366 _03797_ VSS VSS VDD VDD _01735_ sky130_fd_sc_hd__nand2_1
X_14377_ network.cnt_main.counter\[5\] _03787_ VSS VSS VDD
+ VDD _03798_ sky130_fd_sc_hd__xor2_1
X_14378_ _03781_ _03798_ VSS VSS VDD VDD _01736_ sky130_fd_sc_hd__nor2_1
X_14379_ network.cnt_main.counter\[2\] network.cnt_main.counter\[3\]
+ VSS VSS VDD VDD _03799_ sky130_fd_sc_hd__nor2_1
X_14380_ _00690_ _03799_ VSS VSS VDD VDD _03800_ sky130_fd_sc_hd__nand2_1
X_14381_ network.cnt_main.counter\[4\] _03800_ VSS VSS VDD
+ VDD _03801_ sky130_fd_sc_hd__xor2_1
X_14382_ _03781_ _03801_ VSS VSS VDD VDD _01737_ sky130_fd_sc_hd__nor2_1
X_14383_ network.cnt_main.counter\[2\] network.cnt_main.counter\[1\]
+ network.cnt_main.counter\[0\] VSS VSS VDD VDD _03802_ sky130_fd_sc_hd__nor3_1
X_14384_ network.cnt_main.counter\[3\] _03802_ VSS VSS VDD
+ VDD _03803_ sky130_fd_sc_hd__xnor2_1
X_14385_ _03781_ _03803_ VSS VSS VDD VDD _01738_ sky130_fd_sc_hd__nor2_1
X_14386_ network.cnt_main.counter\[2\] _00690_ VSS VSS VDD
+ VDD _03804_ sky130_fd_sc_hd__xnor2_1
X_14387_ _03784_ _03804_ VSS VSS VDD VDD _01739_ sky130_fd_sc_hd__nand2_1
X_14388_ _00691_ _03781_ VSS VSS VDD VDD _01740_ sky130_fd_sc_hd__nor2_1
X_14389_ network.cnt_main.counter\[0\] _03781_ VSS VSS VDD
+ VDD _01741_ sky130_fd_sc_hd__nor2_1
X_14390_ network.neuron_in038.counter\[3\] _00373_ VSS VSS
+ VDD VDD _03805_ sky130_fd_sc_hd__nand2b_1
X_14391_ network.neuron_in038.counter\[2\] VSS VSS VDD VDD
+ _03806_ sky130_fd_sc_hd__inv_1
X_14392_ _03805_ _03806_ VSS VSS VDD VDD _03807_ sky130_fd_sc_hd__nand2b_1
X_14393_ net342 _03807_ VSS VSS VDD VDD _03808_ sky130_fd_sc_hd__nand2_1
X_14394_ network.in_period\[38\]\[1\] _03808_ VSS VSS VDD
+ VDD _03809_ sky130_fd_sc_hd__nand2_1
X_14395_ _00374_ _03808_ _03809_ VSS VSS VDD VDD _02216_ sky130_fd_sc_hd__o21ai_0
X_14396_ network.neuron_in039.counter\[3\] network.in_period\[39\]\[2\]
+ _00369_ net424 VSS VSS VDD VDD _03810_ sky130_fd_sc_hd__o22ai_1
Xplace404 _07385_ VSS VSS VDD VDD net403 sky130_fd_sc_hd__buf_4
X_14398_ network.neuron_in039.counter\[2\] _00369_ net343
+ VSS VSS VDD VDD _03812_ sky130_fd_sc_hd__nand3_1
X_14399_ network.in_period\[39\]\[2\] net343 _03812_ VSS VSS
+ VDD VDD _03813_ sky130_fd_sc_hd__o21ai_0
X_14400_ _03763_ _03810_ _03813_ VSS VSS VDD VDD _02221_ sky130_fd_sc_hd__a21oi_1
X_14401_ network.neuron_in038.counter\[3\] network.in_period\[38\]\[2\]
+ _00373_ net425 VSS VSS VDD VDD _03814_ sky130_fd_sc_hd__o22ai_1
X_14402_ network.neuron_in038.counter\[2\] _00373_ net340
+ VSS VSS VDD VDD _03815_ sky130_fd_sc_hd__nand3_1
X_14403_ network.in_period\[38\]\[2\] net340 _03815_ VSS VSS
+ VDD VDD _03816_ sky130_fd_sc_hd__o21ai_0
X_14404_ _03806_ _03814_ _03816_ VSS VSS VDD VDD _02217_ sky130_fd_sc_hd__a21oi_1
X_14405_ network.neuron_in054.counter\[0\] VSS VSS VDD VDD
+ _00267_ sky130_fd_sc_hd__inv_1
X_14406_ network.neuron_in139.counter\[1\] VSS VSS VDD VDD
+ _01109_ sky130_fd_sc_hd__inv_1
X_14407_ network.neuron_in254.counter\[1\] VSS VSS VDD VDD
+ _00470_ sky130_fd_sc_hd__inv_1
X_14408_ network.neuron_in162.counter\[0\] VSS VSS VDD VDD
+ _00801_ sky130_fd_sc_hd__inv_1
X_14409_ network.in_period\[162\]\[0\] _06692_ VSS VSS VDD
+ VDD _03817_ sky130_fd_sc_hd__nand2_1
X_14410_ network.neuron_in162.counter\[0\] _06692_ _03817_
+ VSS VSS VDD VDD _02711_ sky130_fd_sc_hd__o21ai_0
Xplace403 _07389_ VSS VSS VDD VDD net402 sky130_fd_sc_hd__buf_4
X_14412_ network.neuron_in163.counter\[2\] _00829_ VSS VSS
+ VDD VDD _03819_ sky130_fd_sc_hd__xnor2_1
X_14413_ network.neuron_in163.counter\[2\] network.neuron_in163.counter\[3\]
+ VSS VSS VDD VDD _03820_ sky130_fd_sc_hd__nor2_1
X_14414_ net415 _03820_ VSS VSS VDD VDD _03821_ sky130_fd_sc_hd__nor2_1
X_14415_ network.in_period\[163\]\[2\] _03821_ VSS VSS VDD
+ VDD _03822_ sky130_fd_sc_hd__nor2_1
X_14416_ net363 _03819_ _03822_ VSS VSS VDD VDD _02717_ sky130_fd_sc_hd__a21oi_1
X_14417_ network.neuron_in163.counter\[3\] _00829_ VSS VSS
+ VDD VDD _03823_ sky130_fd_sc_hd__nand2b_1
X_14418_ network.neuron_in163.counter\[2\] _03823_ VSS VSS
+ VDD VDD _03824_ sky130_fd_sc_hd__or2_2
X_14419_ net363 _03824_ VSS VSS VDD VDD _03825_ sky130_fd_sc_hd__nand2_1
X_14420_ network.in_period\[163\]\[1\] _03825_ VSS VSS VDD
+ VDD _03826_ sky130_fd_sc_hd__nand2_1
X_14421_ _00830_ _03825_ _03826_ VSS VSS VDD VDD _02716_ sky130_fd_sc_hd__o21ai_0
X_14422_ network.neuron_in161.counter\[1\] VSS VSS VDD VDD
+ _00798_ sky130_fd_sc_hd__inv_1
X_14423_ network.neuron_in163.counter\[0\] VSS VSS VDD VDD
+ _00827_ sky130_fd_sc_hd__inv_1
X_14424_ network.in_period\[163\]\[0\] _03825_ VSS VSS VDD
+ VDD _03827_ sky130_fd_sc_hd__nand2_1
X_14425_ network.neuron_in163.counter\[0\] _03825_ _03827_
+ VSS VSS VDD VDD _02715_ sky130_fd_sc_hd__o21ai_0
X_14426_ _03774_ _00401_ VSS VSS VDD VDD _03828_ sky130_fd_sc_hd__nand2_1
X_14427_ network.neuron_in036.counter\[3\] _03828_ VSS VSS
+ VDD VDD _03829_ sky130_fd_sc_hd__or2_2
X_14428_ net351 _03829_ VSS VSS VDD VDD _03830_ sky130_fd_sc_hd__nand2_1
X_14429_ network.in_period\[36\]\[1\] _03830_ VSS VSS VDD
+ VDD _03831_ sky130_fd_sc_hd__nand2_1
X_14430_ _00402_ _03830_ _03831_ VSS VSS VDD VDD _02208_ sky130_fd_sc_hd__o21ai_0
X_14431_ network.neuron_in164.counter\[2\] VSS VSS VDD VDD
+ _03832_ sky130_fd_sc_hd__inv_1
X_14432_ network.neuron_in164.counter\[3\] network.in_period\[164\]\[2\]
+ _00862_ net414 VSS VSS VDD VDD _03833_ sky130_fd_sc_hd__o22ai_1
X_14433_ network.neuron_in164.counter\[2\] _00862_ net346
+ VSS VSS VDD VDD _03834_ sky130_fd_sc_hd__nand3_1
X_14434_ network.in_period\[164\]\[2\] net346 _03834_ VSS
+ VSS VDD VDD _03835_ sky130_fd_sc_hd__o21ai_0
X_14435_ _03832_ _03833_ _03835_ VSS VSS VDD VDD _02721_ sky130_fd_sc_hd__a21oi_1
X_14436_ network.neuron_in036.counter\[0\] VSS VSS VDD VDD
+ _00399_ sky130_fd_sc_hd__inv_1
X_14437_ network.in_period\[36\]\[0\] _03830_ VSS VSS VDD
+ VDD _03836_ sky130_fd_sc_hd__nand2_1
X_14438_ network.neuron_in036.counter\[0\] _03830_ _03836_
+ VSS VSS VDD VDD _02207_ sky130_fd_sc_hd__o21ai_0
X_14439_ network.neuron_in164.counter\[3\] _00862_ VSS VSS
+ VDD VDD _03837_ sky130_fd_sc_hd__nand2b_1
X_14440_ _03837_ _03832_ VSS VSS VDD VDD _03838_ sky130_fd_sc_hd__nand2b_1
X_14441_ net346 _03838_ VSS VSS VDD VDD _03839_ sky130_fd_sc_hd__nand2_1
X_14442_ network.in_period\[164\]\[1\] _03839_ VSS VSS VDD
+ VDD _03840_ sky130_fd_sc_hd__nand2_1
X_14443_ _00863_ _03839_ _03840_ VSS VSS VDD VDD _02720_ sky130_fd_sc_hd__o21ai_0
X_14444_ network.neuron_in081.counter\[0\] VSS VSS VDD VDD
+ _00080_ sky130_fd_sc_hd__inv_1
X_14445_ network.neuron_in037.counter\[0\] VSS VSS VDD VDD
+ _00391_ sky130_fd_sc_hd__inv_1
X_14446_ network.in_period\[37\]\[0\] _03771_ VSS VSS VDD
+ VDD _03841_ sky130_fd_sc_hd__nand2_1
X_14447_ network.neuron_in037.counter\[0\] _03771_ _03841_
+ VSS VSS VDD VDD _02211_ sky130_fd_sc_hd__o21ai_0
X_14448_ network.neuron_in164.counter\[0\] VSS VSS VDD VDD
+ _00860_ sky130_fd_sc_hd__inv_1
X_14449_ network.in_period\[164\]\[0\] _03839_ VSS VSS VDD
+ VDD _03842_ sky130_fd_sc_hd__nand2_1
X_14450_ network.neuron_in164.counter\[0\] _03839_ _03842_
+ VSS VSS VDD VDD _02719_ sky130_fd_sc_hd__o21ai_0
Xplace397 _07422_ VSS VSS VDD VDD net396 sky130_fd_sc_hd__buf_4
X_14452_ network.neuron_in165.counter\[2\] network.neuron_in165.counter\[3\]
+ VSS VSS VDD VDD _03844_ sky130_fd_sc_hd__nor2_1
X_14453_ net415 _03844_ VSS VSS VDD VDD _03845_ sky130_fd_sc_hd__nor2_1
X_14454_ network.neuron_in165.counter\[2\] _00884_ VSS VSS
+ VDD VDD _03846_ sky130_fd_sc_hd__xnor2_1
X_14455_ network.in_period\[165\]\[2\] _03845_ _03846_ net361
+ VSS VSS VDD VDD _02725_ sky130_fd_sc_hd__a2bb2oi_1
X_14456_ _00884_ _03844_ VSS VSS VDD VDD _03847_ sky130_fd_sc_hd__nand2_1
X_14457_ net361 _03847_ VSS VSS VDD VDD _03848_ sky130_fd_sc_hd__nand2_1
X_14458_ network.in_period\[165\]\[1\] _03848_ VSS VSS VDD
+ VDD _03849_ sky130_fd_sc_hd__nand2_1
X_14459_ _00885_ _03848_ _03849_ VSS VSS VDD VDD _02724_ sky130_fd_sc_hd__o21ai_0
X_14460_ network.neuron_in038.counter\[0\] VSS VSS VDD VDD
+ _00371_ sky130_fd_sc_hd__inv_1
X_14461_ network.in_period\[38\]\[0\] _03808_ VSS VSS VDD
+ VDD _03850_ sky130_fd_sc_hd__nand2_1
X_14462_ network.neuron_in038.counter\[0\] _03808_ _03850_
+ VSS VSS VDD VDD _02215_ sky130_fd_sc_hd__o21ai_0
X_14463_ network.neuron_in165.counter\[0\] VSS VSS VDD VDD
+ _00882_ sky130_fd_sc_hd__inv_1
X_14464_ network.in_period\[165\]\[0\] _03848_ VSS VSS VDD
+ VDD _03851_ sky130_fd_sc_hd__nand2_1
X_14465_ network.neuron_in165.counter\[0\] _03848_ _03851_
+ VSS VSS VDD VDD _02723_ sky130_fd_sc_hd__o21ai_0
X_14466_ network.neuron_in166.counter\[2\] VSS VSS VDD VDD
+ _03852_ sky130_fd_sc_hd__inv_1
X_14467_ network.neuron_in166.counter\[3\] network.in_period\[166\]\[2\]
+ _00898_ net414 VSS VSS VDD VDD _03853_ sky130_fd_sc_hd__o22ai_1
Xplace394 _07442_ VSS VSS VDD VDD net393 sky130_fd_sc_hd__buf_4
X_14469_ network.neuron_in166.counter\[2\] _00898_ net361
+ VSS VSS VDD VDD _03855_ sky130_fd_sc_hd__nand3_1
X_14470_ network.in_period\[166\]\[2\] net361 _03855_ VSS
+ VSS VDD VDD _03856_ sky130_fd_sc_hd__o21ai_0
X_14471_ _03852_ _03853_ _03856_ VSS VSS VDD VDD _02729_ sky130_fd_sc_hd__a21oi_1
Xplace393 _07478_ VSS VSS VDD VDD net392 sky130_fd_sc_hd__buf_4
X_14473_ network.neuron_in166.counter\[3\] _00898_ VSS VSS
+ VDD VDD _03858_ sky130_fd_sc_hd__nand2b_1
X_14474_ _03858_ _03852_ VSS VSS VDD VDD _03859_ sky130_fd_sc_hd__nand2b_1
X_14475_ net361 _03859_ VSS VSS VDD VDD _03860_ sky130_fd_sc_hd__nand2_1
X_14476_ network.in_period\[166\]\[1\] _03860_ VSS VSS VDD
+ VDD _03861_ sky130_fd_sc_hd__nand2_1
X_14477_ _00899_ _03860_ _03861_ VSS VSS VDD VDD _02728_ sky130_fd_sc_hd__o21ai_0
X_14478_ network.neuron_in166.counter\[0\] VSS VSS VDD VDD
+ _00896_ sky130_fd_sc_hd__inv_1
X_14479_ network.in_period\[166\]\[0\] _03860_ VSS VSS VDD
+ VDD _03862_ sky130_fd_sc_hd__nand2_1
X_14480_ network.neuron_in166.counter\[0\] _03860_ _03862_
+ VSS VSS VDD VDD _02727_ sky130_fd_sc_hd__o21ai_0
X_14481_ network.neuron_in167.counter\[2\] _00920_ VSS VSS
+ VDD VDD _03863_ sky130_fd_sc_hd__xnor2_1
X_14482_ network.neuron_in167.counter\[2\] network.neuron_in167.counter\[3\]
+ VSS VSS VDD VDD _03864_ sky130_fd_sc_hd__nor2_1
X_14483_ net417 _03864_ VSS VSS VDD VDD _03865_ sky130_fd_sc_hd__nor2_1
X_14484_ network.in_period\[167\]\[2\] _03865_ VSS VSS VDD
+ VDD _03866_ sky130_fd_sc_hd__nor2_1
X_14485_ net346 _03863_ _03866_ VSS VSS VDD VDD _02733_ sky130_fd_sc_hd__a21oi_1
X_14486_ network.neuron_in041.counter\[2\] VSS VSS VDD VDD
+ _03867_ sky130_fd_sc_hd__inv_1
X_14487_ network.neuron_in041.counter\[3\] network.in_period\[41\]\[2\]
+ _00355_ net423 VSS VSS VDD VDD _03868_ sky130_fd_sc_hd__o22ai_1
X_14488_ network.neuron_in041.counter\[2\] _00355_ net343
+ VSS VSS VDD VDD _03869_ sky130_fd_sc_hd__nand3_1
X_14489_ network.in_period\[41\]\[2\] net343 _03869_ VSS VSS
+ VDD VDD _03870_ sky130_fd_sc_hd__o21ai_0
X_14490_ _03867_ _03868_ _03870_ VSS VSS VDD VDD _02229_ sky130_fd_sc_hd__a21oi_1
X_14491_ network.neuron_in042.counter\[2\] network.neuron_in042.counter\[3\]
+ VSS VSS VDD VDD _03871_ sky130_fd_sc_hd__nor2_1
X_14492_ _00351_ _03871_ VSS VSS VDD VDD _03872_ sky130_fd_sc_hd__nand2_1
X_14493_ net342 _03872_ VSS VSS VDD VDD _03873_ sky130_fd_sc_hd__nand2_1
X_14494_ network.in_period\[42\]\[0\] _03873_ VSS VSS VDD
+ VDD _03874_ sky130_fd_sc_hd__nand2_1
X_14495_ network.neuron_in042.counter\[0\] _03873_ _03874_
+ VSS VSS VDD VDD _02231_ sky130_fd_sc_hd__o21ai_0
X_14496_ network.in_period\[167\]\[1\] _07852_ VSS VSS VDD
+ VDD _03875_ sky130_fd_sc_hd__nand2_1
X_14497_ _00921_ _07852_ _03875_ VSS VSS VDD VDD _02732_ sky130_fd_sc_hd__o21ai_0
X_14498_ network.neuron_in040.counter\[2\] VSS VSS VDD VDD
+ _03876_ sky130_fd_sc_hd__inv_1
X_14499_ network.in_period\[40\]\[2\] network.neuron_in040.counter\[3\]
+ _00363_ net424 VSS VSS VDD VDD _03877_ sky130_fd_sc_hd__o22ai_1
X_14500_ network.neuron_in040.counter\[2\] _00363_ net342
+ VSS VSS VDD VDD _03878_ sky130_fd_sc_hd__nand3_1
X_14501_ network.in_period\[40\]\[2\] net342 _03878_ VSS VSS
+ VDD VDD _03879_ sky130_fd_sc_hd__o21ai_0
X_14502_ _03876_ _03877_ _03879_ VSS VSS VDD VDD _02225_ sky130_fd_sc_hd__a21oi_1
X_14503_ network.neuron_in168.counter\[1\] VSS VSS VDD VDD
+ _00947_ sky130_fd_sc_hd__inv_1
X_14504_ network.neuron_in104.counter\[1\] VSS VSS VDD VDD
+ _00935_ sky130_fd_sc_hd__inv_1
X_14505_ network.neuron_in162.counter\[1\] VSS VSS VDD VDD
+ _00802_ sky130_fd_sc_hd__inv_1
X_14506_ network.neuron_in114.counter\[0\] VSS VSS VDD VDD
+ _01245_ sky130_fd_sc_hd__inv_1
X_14507_ network.neuron_in214.counter\[1\] VSS VSS VDD VDD
+ _00943_ sky130_fd_sc_hd__inv_1
X_14508_ network.neuron_in245.counter\[1\] VSS VSS VDD VDD
+ _00905_ sky130_fd_sc_hd__inv_1
X_14509_ network.neuron_in088.counter\[0\] VSS VSS VDD VDD
+ _01212_ sky130_fd_sc_hd__inv_1
X_14510_ network.neuron_in147.counter\[3\] _01196_ VSS VSS
+ VDD VDD _03880_ sky130_fd_sc_hd__nand2b_1
X_14511_ network.neuron_in147.counter\[2\] VSS VSS VDD VDD
+ _03881_ sky130_fd_sc_hd__inv_1
X_14512_ _03880_ _03881_ VSS VSS VDD VDD _03882_ sky130_fd_sc_hd__nand2b_1
X_14513_ net346 _03882_ VSS VSS VDD VDD _03883_ sky130_fd_sc_hd__nand2_1
X_14514_ network.in_period\[147\]\[1\] _03883_ VSS VSS VDD
+ VDD _03884_ sky130_fd_sc_hd__nand2_1
X_14515_ _01197_ _03883_ _03884_ VSS VSS VDD VDD _02652_ sky130_fd_sc_hd__o21ai_0
X_14516_ network.neuron_in058.counter\[0\] VSS VSS VDD VDD
+ _00243_ sky130_fd_sc_hd__inv_1
X_14517_ network.neuron_in226.counter\[1\] VSS VSS VDD VDD
+ _00816_ sky130_fd_sc_hd__inv_1
X_14518_ network.neuron_in119.counter\[0\] VSS VSS VDD VDD
+ _00651_ sky130_fd_sc_hd__inv_1
X_14519_ network.neuron_in140.counter\[2\] net352 VSS VSS
+ VDD VDD _03885_ sky130_fd_sc_hd__nand2_1
X_14520_ network.neuron_in140.counter\[3\] network.in_period\[140\]\[2\]
+ _03885_ VSS VSS VDD VDD _03886_ sky130_fd_sc_hd__o21ai_0
X_14521_ _01090_ network.neuron_in140.counter\[2\] net421
+ VSS VSS VDD VDD _03887_ sky130_fd_sc_hd__or3_1
X_14522_ network.in_period\[140\]\[2\] net352 _03887_ VSS
+ VSS VDD VDD _03888_ sky130_fd_sc_hd__o21ai_0
X_14523_ _01090_ _03886_ _03888_ VSS VSS VDD VDD _02625_ sky130_fd_sc_hd__a21oi_1
X_14524_ network.neuron_in163.counter\[1\] VSS VSS VDD VDD
+ _00828_ sky130_fd_sc_hd__inv_1
X_14525_ network.neuron_in181.counter\[1\] VSS VSS VDD VDD
+ _01191_ sky130_fd_sc_hd__inv_1
X_14526_ network.in_period\[147\]\[0\] _03883_ VSS VSS VDD
+ VDD _03889_ sky130_fd_sc_hd__nand2_1
X_14527_ network.neuron_in147.counter\[0\] _03883_ _03889_
+ VSS VSS VDD VDD _02651_ sky130_fd_sc_hd__o21ai_0
X_14528_ network.neuron_in148.counter\[2\] net346 VSS VSS
+ VDD VDD _03890_ sky130_fd_sc_hd__nand2_1
X_14529_ network.in_period\[148\]\[2\] network.neuron_in148.counter\[3\]
+ _03890_ VSS VSS VDD VDD _03891_ sky130_fd_sc_hd__o21ai_0
X_14530_ _00593_ network.neuron_in148.counter\[2\] net417
+ VSS VSS VDD VDD _03892_ sky130_fd_sc_hd__or3_1
X_14531_ network.in_period\[148\]\[2\] net346 _03892_ VSS
+ VSS VDD VDD _03893_ sky130_fd_sc_hd__o21ai_0
X_14532_ _00593_ _03891_ _03893_ VSS VSS VDD VDD _02657_ sky130_fd_sc_hd__a21oi_1
X_14533_ network.in_period\[146\]\[1\] _06964_ VSS VSS VDD
+ VDD _03894_ sky130_fd_sc_hd__nand2_1
X_14534_ _00348_ _06964_ _03894_ VSS VSS VDD VDD _02648_ sky130_fd_sc_hd__o21ai_0
X_14535_ network.neuron_in044.counter\[0\] VSS VSS VDD VDD
+ _00323_ sky130_fd_sc_hd__inv_1
X_14536_ network.neuron_in104.counter\[0\] VSS VSS VDD VDD
+ _00934_ sky130_fd_sc_hd__inv_1
X_14537_ network.neuron_in164.counter\[1\] VSS VSS VDD VDD
+ _00861_ sky130_fd_sc_hd__inv_1
X_14538_ network.neuron_in139.counter\[0\] VSS VSS VDD VDD
+ _01108_ sky130_fd_sc_hd__inv_1
X_14539_ network.neuron_in229.counter\[1\] VSS VSS VDD VDD
+ _00931_ sky130_fd_sc_hd__inv_1
X_14540_ network.neuron_in224.counter\[1\] VSS VSS VDD VDD
+ _00812_ sky130_fd_sc_hd__inv_1
X_14541_ network.neuron_in184.counter\[1\] VSS VSS VDD VDD
+ _01097_ sky130_fd_sc_hd__inv_1
X_14542_ network.neuron_in155.counter\[0\] VSS VSS VDD VDD
+ _01116_ sky130_fd_sc_hd__inv_1
X_14543_ network.in_period\[42\]\[1\] _03873_ VSS VSS VDD
+ VDD _03895_ sky130_fd_sc_hd__nand2_1
X_14544_ _00352_ _03873_ _03895_ VSS VSS VDD VDD _02232_ sky130_fd_sc_hd__o21ai_0
X_14545_ network.neuron_in165.counter\[1\] VSS VSS VDD VDD
+ _00883_ sky130_fd_sc_hd__inv_1
X_14546_ network.neuron_in154.counter\[2\] net358 VSS VSS
+ VDD VDD _03896_ sky130_fd_sc_hd__nand2_1
X_14547_ network.in_period\[154\]\[2\] network.neuron_in154.counter\[3\]
+ _03896_ VSS VSS VDD VDD _03897_ sky130_fd_sc_hd__o21ai_0
X_14548_ _01160_ network.neuron_in154.counter\[2\] net413
+ VSS VSS VDD VDD _03898_ sky130_fd_sc_hd__or3_1
X_14549_ network.in_period\[154\]\[2\] net358 _03898_ VSS
+ VSS VDD VDD _03899_ sky130_fd_sc_hd__o21ai_0
X_14550_ _01160_ _03897_ _03899_ VSS VSS VDD VDD _02681_ sky130_fd_sc_hd__a21oi_1
X_14551_ network.neuron_in220.counter\[1\] VSS VSS VDD VDD
+ _00923_ sky130_fd_sc_hd__inv_1
X_14552_ network.neuron_in166.counter\[1\] VSS VSS VDD VDD
+ _00897_ sky130_fd_sc_hd__inv_1
X_14553_ network.neuron_in134.counter\[1\] VSS VSS VDD VDD
+ _00892_ sky130_fd_sc_hd__inv_1
X_14554_ network.neuron_in167.counter\[1\] VSS VSS VDD VDD
+ _00919_ sky130_fd_sc_hd__inv_1
X_14555_ _03876_ _00363_ VSS VSS VDD VDD _03900_ sky130_fd_sc_hd__nand2_1
X_14556_ network.neuron_in040.counter\[3\] _03900_ VSS VSS
+ VDD VDD _03901_ sky130_fd_sc_hd__or2_2
X_14557_ net342 _03901_ VSS VSS VDD VDD _03902_ sky130_fd_sc_hd__nand2_1
X_14558_ network.in_period\[40\]\[1\] _03902_ VSS VSS VDD
+ VDD _03903_ sky130_fd_sc_hd__nand2_1
X_14559_ _00364_ _03902_ _03903_ VSS VSS VDD VDD _02224_ sky130_fd_sc_hd__o21ai_0
X_14560_ network.neuron_in040.counter\[0\] VSS VSS VDD VDD
+ _00361_ sky130_fd_sc_hd__inv_1
X_14561_ network.in_period\[40\]\[0\] _03902_ VSS VSS VDD
+ VDD _03904_ sky130_fd_sc_hd__nand2_1
X_14562_ network.neuron_in040.counter\[0\] _03902_ _03904_
+ VSS VSS VDD VDD _02223_ sky130_fd_sc_hd__o21ai_0
X_14563_ network.neuron_in124.counter\[0\] VSS VSS VDD VDD
+ _00403_ sky130_fd_sc_hd__inv_1
X_14564_ network.neuron_in241.counter\[1\] VSS VSS VDD VDD
+ _00909_ sky130_fd_sc_hd__inv_1
X_14565_ network.neuron_in130.counter\[1\] VSS VSS VDD VDD
+ _00913_ sky130_fd_sc_hd__inv_1
X_14566_ network.neuron_hid7.IF0.ref_counter\[1\] VSS VSS
+ VDD VDD _00685_ sky130_fd_sc_hd__inv_1
X_14567_ network.neuron_in154.counter\[1\] VSS VSS VDD VDD
+ _01159_ sky130_fd_sc_hd__inv_1
X_14568_ network.neuron_in156.counter\[2\] _01082_ VSS VSS
+ VDD VDD _03905_ sky130_fd_sc_hd__nand2b_1
X_14569_ network.neuron_in156.counter\[3\] _03905_ VSS VSS
+ VDD VDD _03906_ sky130_fd_sc_hd__or2_2
X_14570_ net354 _03906_ VSS VSS VDD VDD _03907_ sky130_fd_sc_hd__nand2_1
X_14571_ network.in_period\[156\]\[0\] _03907_ VSS VSS VDD
+ VDD _03908_ sky130_fd_sc_hd__nand2_1
X_14572_ network.neuron_in156.counter\[0\] _03907_ _03908_
+ VSS VSS VDD VDD _02687_ sky130_fd_sc_hd__o21ai_0
X_14573_ network.neuron_in146.counter\[3\] network.in_period\[146\]\[2\]
+ net414 _00347_ VSS VSS VDD VDD _03909_ sky130_fd_sc_hd__o22ai_1
X_14574_ network.neuron_in146.counter\[2\] _00347_ net345
+ VSS VSS VDD VDD _03910_ sky130_fd_sc_hd__nand3_1
X_14575_ network.in_period\[146\]\[2\] net345 _03910_ VSS
+ VSS VDD VDD _03911_ sky130_fd_sc_hd__o21ai_0
X_14576_ _06962_ _03909_ _03911_ VSS VSS VDD VDD _02649_ sky130_fd_sc_hd__a21oi_1
X_14577_ network.in_period\[156\]\[1\] _03907_ VSS VSS VDD
+ VDD _03912_ sky130_fd_sc_hd__nand2_1
X_14578_ _01083_ _03907_ _03912_ VSS VSS VDD VDD _02688_ sky130_fd_sc_hd__o21ai_0
X_14579_ network.neuron_in111.counter\[1\] VSS VSS VDD VDD
+ _00648_ sky130_fd_sc_hd__inv_1
X_14580_ network.in_period\[139\]\[0\] _03496_ VSS VSS VDD
+ VDD _03913_ sky130_fd_sc_hd__nand2_1
X_14581_ network.neuron_in139.counter\[0\] _03496_ _03913_
+ VSS VSS VDD VDD _02619_ sky130_fd_sc_hd__o21ai_0
X_14582_ network.neuron_in121.counter\[0\] VSS VSS VDD VDD
+ _00639_ sky130_fd_sc_hd__inv_1
X_14583_ network.neuron_in115.counter\[0\] VSS VSS VDD VDD
+ _01208_ sky130_fd_sc_hd__inv_1
X_14584_ network.neuron_in147.counter\[3\] network.in_period\[147\]\[2\]
+ net414 _01196_ VSS VSS VDD VDD _03914_ sky130_fd_sc_hd__o22ai_1
X_14585_ network.neuron_in147.counter\[2\] _01196_ net346
+ VSS VSS VDD VDD _03915_ sky130_fd_sc_hd__nand3_1
X_14586_ network.in_period\[147\]\[2\] net346 _03915_ VSS
+ VSS VDD VDD _03916_ sky130_fd_sc_hd__o21ai_0
X_14587_ _03881_ _03914_ _03916_ VSS VSS VDD VDD _02653_ sky130_fd_sc_hd__a21oi_1
X_14588_ network.neuron_in192.counter\[1\] VSS VSS VDD VDD
+ _01125_ sky130_fd_sc_hd__inv_1
X_14589_ network.neuron_in100.counter\[1\] VSS VSS VDD VDD
+ _00873_ sky130_fd_sc_hd__inv_1
X_14590_ network.neuron_in183.counter\[1\] VSS VSS VDD VDD
+ _00248_ sky130_fd_sc_hd__inv_1
X_14591_ network.neuron_in145.counter\[0\] VSS VSS VDD VDD
+ _00696_ sky130_fd_sc_hd__inv_1
X_14592_ network.in_period\[145\]\[0\] _06900_ VSS VSS VDD
+ VDD _03917_ sky130_fd_sc_hd__nand2_1
X_14593_ network.neuron_in145.counter\[0\] _06900_ _03917_
+ VSS VSS VDD VDD _02643_ sky130_fd_sc_hd__o21ai_0
X_14594_ network.neuron_in076.counter\[0\] VSS VSS VDD VDD
+ _00122_ sky130_fd_sc_hd__inv_1
X_14595_ network.neuron_in118.counter\[1\] VSS VSS VDD VDD
+ _00119_ sky130_fd_sc_hd__inv_1
X_14596_ network.neuron_in223.counter\[1\] VSS VSS VDD VDD
+ _00865_ sky130_fd_sc_hd__inv_1
X_14597_ network.neuron_in096.counter\[1\] VSS VSS VDD VDD
+ _01205_ sky130_fd_sc_hd__inv_1
X_14598_ network.neuron_in244.counter\[1\] VSS VSS VDD VDD
+ _00669_ sky130_fd_sc_hd__inv_1
X_14599_ network.in_period\[130\]\[1\] _03670_ VSS VSS VDD
+ VDD _03918_ sky130_fd_sc_hd__nand2_1
X_14600_ _00915_ _03670_ _03918_ VSS VSS VDD VDD _02584_ sky130_fd_sc_hd__o21ai_0
X_14601_ network.neuron_in199.counter\[1\] VSS VSS VDD VDD
+ _01155_ sky130_fd_sc_hd__inv_1
X_14602_ network.neuron_in041.counter\[2\] network.neuron_in041.counter\[3\]
+ VSS VSS VDD VDD _03919_ sky130_fd_sc_hd__nor2_1
X_14603_ _00355_ _03919_ VSS VSS VDD VDD _03920_ sky130_fd_sc_hd__nand2_1
X_14604_ net343 _03920_ VSS VSS VDD VDD _03921_ sky130_fd_sc_hd__nand2_1
X_14605_ network.in_period\[41\]\[1\] _03921_ VSS VSS VDD
+ VDD _03922_ sky130_fd_sc_hd__nand2_1
X_14606_ _00356_ _03921_ _03922_ VSS VSS VDD VDD _02228_ sky130_fd_sc_hd__o21ai_0
X_14607_ network.in_period\[41\]\[0\] _03921_ VSS VSS VDD
+ VDD _03923_ sky130_fd_sc_hd__nand2_1
X_14608_ network.neuron_in041.counter\[0\] _03921_ _03923_
+ VSS VSS VDD VDD _02227_ sky130_fd_sc_hd__o21ai_0
X_14609_ network.neuron_hid5.IF0.ref_counter\[1\] VSS VSS
+ VDD VDD _00051_ sky130_fd_sc_hd__inv_1
X_14610_ network.neuron_in042.counter\[2\] VSS VSS VDD VDD
+ _03924_ sky130_fd_sc_hd__inv_1
X_14611_ network.neuron_in042.counter\[3\] network.in_period\[42\]\[2\]
+ _00351_ net423 VSS VSS VDD VDD _03925_ sky130_fd_sc_hd__o22ai_1
X_14612_ network.neuron_in042.counter\[2\] _00351_ net342
+ VSS VSS VDD VDD _03926_ sky130_fd_sc_hd__nand3_1
X_14613_ network.in_period\[42\]\[2\] net342 _03926_ VSS VSS
+ VDD VDD _03927_ sky130_fd_sc_hd__o21ai_0
X_14614_ _03924_ _03925_ _03927_ VSS VSS VDD VDD _02233_ sky130_fd_sc_hd__a21oi_1
X_14615_ network.neuron_in100.counter\[0\] VSS VSS VDD VDD
+ _00872_ sky130_fd_sc_hd__inv_1
X_14616_ network.neuron_in189.counter\[1\] VSS VSS VDD VDD
+ _00836_ sky130_fd_sc_hd__inv_1
X_14617_ network.neuron_in117.counter\[1\] VSS VSS VDD VDD
+ _00063_ sky130_fd_sc_hd__inv_1
X_14618_ network.neuron_in096.counter\[0\] VSS VSS VDD VDD
+ _01204_ sky130_fd_sc_hd__inv_1
X_14619_ loaded\[1\] VSS VSS VDD VDD _00844_ sky130_fd_sc_hd__inv_1
X_14620_ network.neuron_in099.counter\[0\] VSS VSS VDD VDD
+ _00746_ sky130_fd_sc_hd__inv_1
X_14621_ network.neuron_in159.counter\[3\] network.in_period\[159\]\[2\]
+ net412 _00694_ VSS VSS VDD VDD _03928_ sky130_fd_sc_hd__o22ai_1
X_14622_ network.neuron_in159.counter\[2\] _00694_ net358
+ VSS VSS VDD VDD _03929_ sky130_fd_sc_hd__nand3_1
X_14623_ network.in_period\[159\]\[2\] net358 _03929_ VSS
+ VSS VDD VDD _03930_ sky130_fd_sc_hd__o21ai_0
X_14624_ _06663_ _03928_ _03930_ VSS VSS VDD VDD _02701_ sky130_fd_sc_hd__a21oi_1
X_14625_ network.neuron_in074.counter\[0\] VSS VSS VDD VDD
+ _00126_ sky130_fd_sc_hd__inv_1
X_14626_ network.neuron_in173.counter\[1\] VSS VSS VDD VDD
+ _00840_ sky130_fd_sc_hd__inv_1
X_14627_ network.neuron_in098.counter\[0\] VSS VSS VDD VDD
+ _00779_ sky130_fd_sc_hd__inv_1
X_14628_ network.neuron_in116.counter\[0\] VSS VSS VDD VDD
+ _00070_ sky130_fd_sc_hd__inv_1
X_14629_ net445 net400 _08023_ VSS VSS VDD VDD _03931_ sky130_fd_sc_hd__o21ai_0
X_14630_ net438 _07409_ net397 VSS VSS VDD VDD _03932_ sky130_fd_sc_hd__a21oi_1
X_14631_ _07477_ net378 _03932_ _07335_ VSS VSS VDD VDD _03933_
+ sky130_fd_sc_hd__o22ai_1
X_14632_ net384 _03931_ _03933_ VSS VSS VDD VDD _03934_ sky130_fd_sc_hd__a21oi_1
X_14633_ _07385_ net396 VSS VSS VDD VDD _03935_ sky130_fd_sc_hd__nand2_1
X_14634_ net432 _03934_ _03935_ _07608_ net427 VSS VSS VDD
+ VDD _03936_ sky130_fd_sc_hd__o221ai_1
X_14635_ _07474_ _03936_ VSS VSS VDD VDD _03937_ sky130_fd_sc_hd__nand2_1
X_14636_ _07557_ _08341_ VSS VSS VDD VDD _03938_ sky130_fd_sc_hd__nor2_1
X_14637_ net430 _03938_ _08516_ VSS VSS VDD VDD _03939_ sky130_fd_sc_hd__o21ai_0
X_14638_ net374 net337 VSS VSS VDD VDD _03940_ sky130_fd_sc_hd__nand2_1
X_14639_ _07646_ _07944_ VSS VSS VDD VDD _03941_ sky130_fd_sc_hd__nand2_1
X_14640_ _07612_ net381 _03941_ VSS VSS VDD VDD _03942_ sky130_fd_sc_hd__nand3_1
X_14641_ _03940_ _03942_ net447 VSS VSS VDD VDD _03943_ sky130_fd_sc_hd__a21oi_1
X_14642_ net392 _03939_ _03943_ net427 VSS VSS VDD VDD _03944_
+ sky130_fd_sc_hd__a211oi_1
X_14643_ net439 _07995_ _07666_ VSS VSS VDD VDD _03945_ sky130_fd_sc_hd__a21oi_1
X_14644_ _07307_ net336 _03945_ VSS VSS VDD VDD _03946_ sky130_fd_sc_hd__or3_1
X_14645_ _03937_ _03944_ _03946_ VSS VSS VDD VDD _01742_ sky130_fd_sc_hd__o21ai_0
X_14646_ _07562_ _07978_ _07520_ VSS VSS VDD VDD _03947_ sky130_fd_sc_hd__nand3_1
X_14647_ _07477_ _07691_ _08094_ VSS VSS VDD VDD _03948_ sky130_fd_sc_hd__nor3_1
X_14648_ net436 _08561_ _07626_ net449 VSS VSS VDD VDD _03949_
+ sky130_fd_sc_hd__o211ai_1
X_14649_ net379 _08021_ VSS VSS VDD VDD _03950_ sky130_fd_sc_hd__nand2_1
X_14650_ net436 _03950_ _08333_ net449 VSS VSS VDD VDD _03951_
+ sky130_fd_sc_hd__a211o_1
X_14651_ net446 _07539_ _07540_ _07698_ VSS VSS VDD VDD _03952_
+ sky130_fd_sc_hd__o22ai_1
X_14652_ net431 _03949_ _03951_ _03952_ net370 VSS VSS VDD
+ VDD _03953_ sky130_fd_sc_hd__a32oi_1
X_14653_ net435 _07409_ _08038_ VSS VSS VDD VDD _03954_ sky130_fd_sc_hd__nor3_1
X_14654_ _07662_ _07688_ _03954_ VSS VSS VDD VDD _03955_ sky130_fd_sc_hd__a21oi_1
X_14655_ net399 _03953_ _03955_ _08094_ VSS VSS VDD VDD _03956_
+ sky130_fd_sc_hd__o22ai_1
X_14656_ _03948_ _03956_ _07474_ VSS VSS VDD VDD _03957_ sky130_fd_sc_hd__o21ai_0
X_14657_ _03947_ _03957_ VSS VSS VDD VDD _03958_ sky130_fd_sc_hd__nand2_1
X_14658_ _07937_ _08522_ net435 VSS VSS VDD VDD _03959_ sky130_fd_sc_hd__o21ai_0
X_14659_ _08031_ net375 VSS VSS VDD VDD _03960_ sky130_fd_sc_hd__nand2_1
X_14660_ net385 _07474_ VSS VSS VDD VDD _03961_ sky130_fd_sc_hd__nand2_1
X_14661_ _07944_ _03959_ _03960_ _03961_ VSS VSS VDD VDD _03962_
+ sky130_fd_sc_hd__a31oi_1
X_14662_ _03958_ _03962_ VSS VSS VDD VDD _01743_ sky130_fd_sc_hd__or2_2
X_14663_ _07337_ _07557_ net446 VSS VSS VDD VDD _03963_ sky130_fd_sc_hd__o21ai_0
X_14664_ _07924_ _03963_ VSS VSS VDD VDD _03964_ sky130_fd_sc_hd__nand2_1
X_14665_ net450 _03964_ net432 VSS VSS VDD VDD _03965_ sky130_fd_sc_hd__a21oi_1
X_14666_ net447 _07393_ VSS VSS VDD VDD _03966_ sky130_fd_sc_hd__nand2_1
X_14667_ net379 net384 _03966_ VSS VSS VDD VDD _03967_ sky130_fd_sc_hd__o21ai_0
X_14668_ net447 net380 net375 VSS VSS VDD VDD _03968_ sky130_fd_sc_hd__a21oi_1
X_14669_ _08010_ _03968_ net432 VSS VSS VDD VDD _03969_ sky130_fd_sc_hd__o21ai_0
X_14670_ net402 _03967_ _03969_ VSS VSS VDD VDD _03970_ sky130_fd_sc_hd__a21oi_1
X_14671_ net445 net404 _07643_ VSS VSS VDD VDD _03971_ sky130_fd_sc_hd__nand3_1
X_14672_ _08012_ _07936_ _08018_ net335 VSS VSS VDD VDD _03972_
+ sky130_fd_sc_hd__a22oi_1
X_14673_ net449 net405 _08544_ _03972_ net444 VSS VSS VDD
+ VDD _03973_ sky130_fd_sc_hd__o32ai_1
X_14674_ net379 _08016_ _08147_ net430 _08021_ VSS VSS VDD
+ VDD _03974_ sky130_fd_sc_hd__o221a_2
X_14675_ net430 net405 _03974_ net436 VSS VSS VDD VDD _03975_
+ sky130_fd_sc_hd__o22ai_1
X_14676_ net437 _03973_ _03975_ net449 VSS VSS VDD VDD _03976_
+ sky130_fd_sc_hd__a22oi_1
X_14677_ _03971_ _03976_ _08159_ VSS VSS VDD VDD _03977_ sky130_fd_sc_hd__a21oi_1
X_14678_ net445 net434 VSS VSS VDD VDD _03978_ sky130_fd_sc_hd__nor2b_1
X_14679_ net394 _03978_ net372 net395 VSS VSS VDD VDD _03979_
+ sky130_fd_sc_hd__a22oi_1
X_14680_ net440 _07561_ _03979_ VSS VSS VDD VDD _03980_ sky130_fd_sc_hd__nor3_1
X_14681_ _03977_ _03980_ _07302_ VSS VSS VDD VDD _03981_ sky130_fd_sc_hd__o21ai_0
X_14682_ net428 _07344_ _03965_ _03970_ _03981_ VSS VSS VDD
+ VDD _01744_ sky130_fd_sc_hd__o41ai_1
X_14683_ net450 net408 net375 VSS VSS VDD VDD _03982_ sky130_fd_sc_hd__a21oi_1
X_14684_ net444 _03982_ _07645_ VSS VSS VDD VDD _03983_ sky130_fd_sc_hd__o21ai_0
X_14685_ net400 net381 _07995_ VSS VSS VDD VDD _03984_ sky130_fd_sc_hd__nor3_1
X_14686_ _07643_ _03983_ _03984_ net428 VSS VSS VDD VDD _03985_
+ sky130_fd_sc_hd__a211o_1
X_14687_ net402 net389 VSS VSS VDD VDD _03986_ sky130_fd_sc_hd__nand2_1
X_14688_ net390 _03986_ net434 VSS VSS VDD VDD _03987_ sky130_fd_sc_hd__a21oi_1
X_14689_ _07521_ _03987_ net448 VSS VSS VDD VDD _03988_ sky130_fd_sc_hd__o21ai_0
X_14690_ net410 _08070_ VSS VSS VDD VDD _03989_ sky130_fd_sc_hd__nand2_1
X_14691_ net450 net441 net443 VSS VSS VDD VDD _03990_ sky130_fd_sc_hd__nor3b_1
X_14692_ net370 _03990_ net434 VSS VSS VDD VDD _03991_ sky130_fd_sc_hd__o21ai_0
X_14693_ _03989_ _03991_ net448 VSS VSS VDD VDD _03992_ sky130_fd_sc_hd__a21oi_1
X_14694_ net410 _03978_ _03992_ VSS VSS VDD VDD _03993_ sky130_fd_sc_hd__a21oi_1
X_14695_ _03988_ _03993_ net430 VSS VSS VDD VDD _03994_ sky130_fd_sc_hd__a21oi_1
X_14696_ _07391_ net373 _08087_ _08544_ VSS VSS VDD VDD _03995_
+ sky130_fd_sc_hd__nor4_1
X_14697_ net408 _07512_ _08253_ _03995_ VSS VSS VDD VDD _03996_
+ sky130_fd_sc_hd__a31oi_1
X_14698_ net447 _08151_ _07484_ VSS VSS VDD VDD _03997_ sky130_fd_sc_hd__a21oi_1
X_14699_ net450 _03997_ _07645_ VSS VSS VDD VDD _03998_ sky130_fd_sc_hd__o21ai_0
X_14700_ net431 _03998_ _03985_ VSS VSS VDD VDD _03999_ sky130_fd_sc_hd__a21oi_1
X_14701_ net428 _03996_ _03999_ VSS VSS VDD VDD _04000_ sky130_fd_sc_hd__a21oi_1
X_14702_ _03985_ _03994_ _04000_ VSS VSS VDD VDD _04001_ sky130_fd_sc_hd__a21oi_1
X_14703_ net445 net447 _07945_ _08095_ VSS VSS VDD VDD _04002_
+ sky130_fd_sc_hd__a31oi_1
X_14704_ _07477_ _07513_ _04002_ net435 VSS VSS VDD VDD _04003_
+ sky130_fd_sc_hd__o22ai_1
X_14705_ _07562_ _04003_ VSS VSS VDD VDD _04004_ sky130_fd_sc_hd__nand2_1
X_14706_ _07344_ _04001_ _04004_ VSS VSS VDD VDD _01745_ sky130_fd_sc_hd__o21ai_0
X_14707_ net447 _08253_ net374 VSS VSS VDD VDD _04005_ sky130_fd_sc_hd__nor3_1
X_14708_ net392 _03939_ _03941_ _04005_ net427 VSS VSS VDD
+ VDD _04006_ sky130_fd_sc_hd__a221oi_1
X_14709_ _03937_ _04006_ _03946_ VSS VSS VDD VDD _01746_ sky130_fd_sc_hd__o21ai_0
X_14710_ net434 net379 _07929_ VSS VSS VDD VDD _04007_ sky130_fd_sc_hd__o21ai_0
X_14711_ net448 net370 VSS VSS VDD VDD _04008_ sky130_fd_sc_hd__nor2_1
X_14712_ net434 _04008_ VSS VSS VDD VDD _04009_ sky130_fd_sc_hd__nand2_1
X_14713_ _07924_ _04009_ net406 VSS VSS VDD VDD _04010_ sky130_fd_sc_hd__a21oi_1
X_14714_ net382 _04007_ _04010_ VSS VSS VDD VDD _04011_ sky130_fd_sc_hd__a21oi_1
X_14715_ net427 net432 _04011_ VSS VSS VDD VDD _04012_ sky130_fd_sc_hd__nor3_1
X_14716_ _07474_ _04012_ _03958_ VSS VSS VDD VDD _01747_ sky130_fd_sc_hd__a21o_1
X_14717_ net434 _08559_ net393 VSS VSS VDD VDD _04013_ sky130_fd_sc_hd__a21oi_1
X_14718_ _07986_ _08255_ net430 VSS VSS VDD VDD _04014_ sky130_fd_sc_hd__o21ai_0
X_14719_ _07965_ _07698_ _04014_ VSS VSS VDD VDD _04015_ sky130_fd_sc_hd__o21ai_0
X_14720_ net440 _04015_ VSS VSS VDD VDD _04016_ sky130_fd_sc_hd__nand2_1
X_14721_ net430 _04013_ _04016_ VSS VSS VDD VDD _04017_ sky130_fd_sc_hd__o21ai_0
X_14722_ _07936_ net372 _08147_ net434 VSS VSS VDD VDD _04018_
+ sky130_fd_sc_hd__a22oi_1
X_14723_ _07375_ _04018_ VSS VSS VDD VDD _04019_ sky130_fd_sc_hd__nor2_1
X_14724_ net449 _04017_ _04019_ VSS VSS VDD VDD _04020_ sky130_fd_sc_hd__a21oi_1
X_14725_ net428 _07344_ _04020_ _03981_ VSS VSS VDD VDD _01748_
+ sky130_fd_sc_hd__o31ai_1
X_14726_ net398 _08162_ VSS VSS VDD VDD _04021_ sky130_fd_sc_hd__nand2_1
X_14727_ net435 _07533_ _08544_ net375 VSS VSS VDD VDD _04022_
+ sky130_fd_sc_hd__a211oi_1
X_14728_ _04021_ _04022_ net399 _03994_ VSS VSS VDD VDD _04023_
+ sky130_fd_sc_hd__a211oi_1
X_14729_ _07483_ _07500_ _08151_ net400 VSS VSS VDD VDD _04024_
+ sky130_fd_sc_hd__o22ai_1
X_14730_ net450 _04024_ VSS VSS VDD VDD _04025_ sky130_fd_sc_hd__nand2_1
X_14731_ _03960_ _04025_ net431 VSS VSS VDD VDD _04026_ sky130_fd_sc_hd__a21oi_1
X_14732_ net431 _08151_ VSS VSS VDD VDD _04027_ sky130_fd_sc_hd__nand2_1
X_14733_ _08353_ _04027_ VSS VSS VDD VDD _04028_ sky130_fd_sc_hd__nand2_1
X_14734_ _07438_ _08253_ _04028_ net447 VSS VSS VDD VDD _04029_
+ sky130_fd_sc_hd__a22oi_1
X_14735_ net450 _04029_ VSS VSS VDD VDD _04030_ sky130_fd_sc_hd__nor2_1
X_14736_ _08343_ net381 _04026_ _04030_ net428 VSS VSS VDD
+ VDD _04031_ sky130_fd_sc_hd__a2111oi_0
X_14737_ _07344_ _04023_ _04031_ _04004_ VSS VSS VDD VDD _01749_
+ sky130_fd_sc_hd__o31ai_1
X_14738_ _07664_ _08164_ _08094_ _08171_ VSS VSS VDD VDD _04032_
+ sky130_fd_sc_hd__a211oi_1
X_14739_ _03956_ _04012_ _04032_ VSS VSS VDD VDD _04033_ sky130_fd_sc_hd__nor3_1
X_14740_ _07344_ _04033_ _03947_ VSS VSS VDD VDD _01750_ sky130_fd_sc_hd__o21ai_0
X_14741_ _07539_ _07489_ _07335_ VSS VSS VDD VDD _04034_ sky130_fd_sc_hd__a21oi_1
X_14742_ net439 _07500_ VSS VSS VDD VDD _04035_ sky130_fd_sc_hd__nand2_1
X_14743_ _07512_ _04035_ net432 VSS VSS VDD VDD _04036_ sky130_fd_sc_hd__a21oi_1
X_14744_ _07965_ _03938_ _04036_ VSS VSS VDD VDD _04037_ sky130_fd_sc_hd__o21ai_0
X_14745_ _03969_ _04034_ _04037_ net399 _07474_ VSS VSS VDD
+ VDD _04038_ sky130_fd_sc_hd__o2111ai_1
X_14746_ _03981_ _04038_ VSS VSS VDD VDD _01751_ sky130_fd_sc_hd__nand2_1
X_14747_ _08109_ net447 VSS VSS VDD VDD _04039_ sky130_fd_sc_hd__nor2b_1
X_14748_ _08095_ _04039_ VSS VSS VDD VDD _04040_ sky130_fd_sc_hd__nor2_1
X_14749_ _07477_ _07513_ _04040_ net435 VSS VSS VDD VDD _04041_
+ sky130_fd_sc_hd__o22ai_1
X_14750_ _08303_ _08010_ VSS VSS VDD VDD _04042_ sky130_fd_sc_hd__nand2_1
X_14751_ _07643_ _07986_ _04042_ net431 VSS VSS VDD VDD _04043_
+ sky130_fd_sc_hd__a22oi_1
X_14752_ net381 _07664_ _04043_ net450 VSS VSS VDD VDD _04044_
+ sky130_fd_sc_hd__o22ai_1
X_14753_ _07513_ _08314_ _08333_ VSS VSS VDD VDD _04045_ sky130_fd_sc_hd__a21oi_1
X_14754_ _07612_ _07961_ _04045_ net409 net399 VSS VSS VDD
+ VDD _04046_ sky130_fd_sc_hd__o221ai_1
X_14755_ net439 _04044_ _04046_ VSS VSS VDD VDD _04047_ sky130_fd_sc_hd__a21oi_1
X_14756_ _04023_ _04047_ _03948_ VSS VSS VDD VDD _04048_ sky130_fd_sc_hd__o21bai_1
X_14757_ _07562_ _04041_ _04048_ _07474_ VSS VSS VDD VDD _01752_
+ sky130_fd_sc_hd__a22o_1
X_14758_ network.neuron_in093.counter\[1\] VSS VSS VDD VDD
+ _01229_ sky130_fd_sc_hd__inv_1
X_14759_ _03742_ _01168_ VSS VSS VDD VDD _04049_ sky130_fd_sc_hd__nand2_1
X_14760_ network.neuron_in132.counter\[3\] _04049_ VSS VSS
+ VDD VDD _04050_ sky130_fd_sc_hd__or2_2
X_14761_ net352 _04050_ VSS VSS VDD VDD _04051_ sky130_fd_sc_hd__nand2_1
X_14762_ network.in_period\[132\]\[1\] _04051_ VSS VSS VDD
+ VDD _04052_ sky130_fd_sc_hd__nand2_1
X_14763_ _01169_ _04051_ _04052_ VSS VSS VDD VDD _02592_ sky130_fd_sc_hd__o21ai_0
X_14764_ network.in_period\[132\]\[0\] _04051_ VSS VSS VDD
+ VDD _04053_ sky130_fd_sc_hd__nand2_1
X_14765_ network.neuron_in132.counter\[0\] _04051_ _04053_
+ VSS VSS VDD VDD _02591_ sky130_fd_sc_hd__o21ai_0
X_14766_ network.neuron_in232.counter\[1\] VSS VSS VDD VDD
+ _00526_ sky130_fd_sc_hd__inv_1
X_14767_ loaded\[3\] loaded\[2\] VSS VSS VDD VDD _04054_ sky130_fd_sc_hd__nor2b_1
X_14768_ _00845_ _04054_ VSS VSS VDD VDD _04055_ sky130_fd_sc_hd__nand2_4
Xplace389 _07505_ VSS VSS VDD VDD net388 sky130_fd_sc_hd__buf_4
X_14770_ _08789_ _08782_ VSS VSS VDD VDD _04057_ sky130_fd_sc_hd__nor2_2
X_14771_ net454 net453 VSS VSS VDD VDD _04058_ sky130_fd_sc_hd__nor2b_1
X_14772_ net322 _04058_ VSS VSS VDD VDD _04059_ sky130_fd_sc_hd__nand2_1
Xplace374 _08000_ VSS VSS VDD VDD net373 sky130_fd_sc_hd__buf_4
X_14774_ _04055_ _04059_ VSS VSS VDD VDD _03176_ sky130_fd_sc_hd__nor2_1
Xplace415 net415 VSS VSS VDD VDD net414 sky130_fd_sc_hd__buf_4
X_14776_ _08782_ loaded\[4\] loaded\[5\] VSS VSS VDD VDD _04062_
+ sky130_fd_sc_hd__nor3b_2
X_14777_ _04058_ net321 VSS VSS VDD VDD _04063_ sky130_fd_sc_hd__nand2_1
Xplace413 net413 VSS VSS VDD VDD net412 sky130_fd_sc_hd__buf_4
X_14779_ _08790_ _04063_ VSS VSS VDD VDD _03170_ sky130_fd_sc_hd__nor2_1
X_14780_ loaded\[2\] loaded\[3\] VSS VSS VDD VDD _04065_ sky130_fd_sc_hd__nor2b_1
X_14781_ _00845_ _04065_ VSS VSS VDD VDD _04066_ sky130_fd_sc_hd__nand2_4
Xplace391 _07496_ VSS VSS VDD VDD net390 sky130_fd_sc_hd__buf_4
X_14783_ _04059_ _04066_ VSS VSS VDD VDD _03180_ sky130_fd_sc_hd__nor2_1
X_14784_ _00847_ _08784_ VSS VSS VDD VDD _04068_ sky130_fd_sc_hd__nand2_4
Xplace384 _07603_ VSS VSS VDD VDD net383 sky130_fd_sc_hd__buf_4
X_14786_ _04063_ _04068_ VSS VSS VDD VDD _03169_ sky130_fd_sc_hd__nor2_1
X_14787_ _00849_ _08721_ VSS VSS VDD VDD _04070_ sky130_fd_sc_hd__nand2_4
Xplace383 _07616_ VSS VSS VDD VDD net382 sky130_fd_sc_hd__buf_4
X_14789_ _04059_ _04070_ VSS VSS VDD VDD _03174_ sky130_fd_sc_hd__nor2_1
X_14790_ _00848_ _08784_ VSS VSS VDD VDD _04072_ sky130_fd_sc_hd__nand2_4
Xplace382 _07621_ VSS VSS VDD VDD net381 sky130_fd_sc_hd__buf_4
X_14792_ _04063_ _04072_ VSS VSS VDD VDD _03168_ sky130_fd_sc_hd__nor2_1
X_14793_ _08725_ net321 VSS VSS VDD VDD _04074_ sky130_fd_sc_hd__nand2_1
Xplace379 _07691_ VSS VSS VDD VDD net378 sky130_fd_sc_hd__buf_4
X_14795_ _04070_ _04074_ VSS VSS VDD VDD _03271_ sky130_fd_sc_hd__nor2_1
X_14796_ net435 net379 _07662_ net431 VSS VSS VDD VDD _04076_
+ sky130_fd_sc_hd__o22ai_1
X_14797_ net406 _04076_ VSS VSS VDD VDD _04077_ sky130_fd_sc_hd__nand2_1
X_14798_ net431 net439 VSS VSS VDD VDD _04078_ sky130_fd_sc_hd__nor2_1
X_14799_ net410 _04078_ VSS VSS VDD VDD _04079_ sky130_fd_sc_hd__nor2_1
X_14800_ net431 net450 net379 VSS VSS VDD VDD _04080_ sky130_fd_sc_hd__nand3_1
X_14801_ net436 _04079_ _04080_ VSS VSS VDD VDD _04081_ sky130_fd_sc_hd__o21ai_0
X_14802_ net436 net400 net379 net431 net402 VSS VSS VDD VDD
+ _04082_ sky130_fd_sc_hd__o221ai_1
X_14803_ net402 _04081_ _04082_ VSS VSS VDD VDD _04083_ sky130_fd_sc_hd__o21ai_0
X_14804_ net429 _07623_ VSS VSS VDD VDD _04084_ sky130_fd_sc_hd__nor2_1
X_14805_ _07396_ _04084_ VSS VSS VDD VDD _04085_ sky130_fd_sc_hd__nor2_1
X_14806_ net338 _08488_ net429 VSS VSS VDD VDD _04086_ sky130_fd_sc_hd__o21ai_0
X_14807_ net442 _04085_ _04086_ _07387_ VSS VSS VDD VDD _04087_
+ sky130_fd_sc_hd__o211ai_1
X_14808_ net436 _04087_ VSS VSS VDD VDD _04088_ sky130_fd_sc_hd__nand2_1
X_14809_ _07670_ _04077_ _04083_ _04088_ VSS VSS VDD VDD _04089_
+ sky130_fd_sc_hd__nand4_1
X_14810_ net391 net382 _07678_ VSS VSS VDD VDD _04090_ sky130_fd_sc_hd__o21ai_0
X_14811_ net403 net387 _07561_ VSS VSS VDD VDD _04091_ sky130_fd_sc_hd__a21oi_1
X_14812_ net439 net395 net435 VSS VSS VDD VDD _04092_ sky130_fd_sc_hd__o21ai_0
X_14813_ _07437_ _08087_ net444 VSS VSS VDD VDD _04093_ sky130_fd_sc_hd__o21ai_0
X_14814_ _04090_ _04091_ _04092_ _04093_ VSS VSS VDD VDD _04094_
+ sky130_fd_sc_hd__nand4_1
X_14815_ _07483_ _08353_ _07489_ VSS VSS VDD VDD _04095_ sky130_fd_sc_hd__a21oi_1
X_14816_ net407 _07984_ net441 VSS VSS VDD VDD _04096_ sky130_fd_sc_hd__o21ai_0
X_14817_ net379 _07657_ _07416_ net434 VSS VSS VDD VDD _04097_
+ sky130_fd_sc_hd__o211ai_1
X_14818_ net434 net389 _07478_ _04097_ VSS VSS VDD VDD _04098_
+ sky130_fd_sc_hd__o31ai_1
X_14819_ net443 net408 VSS VSS VDD VDD _04099_ sky130_fd_sc_hd__nor2_1
X_14820_ net434 _04099_ _08021_ VSS VSS VDD VDD _04100_ sky130_fd_sc_hd__o21ai_0
X_14821_ net450 _07936_ _08175_ net443 net434 VSS VSS VDD
+ VDD _04101_ sky130_fd_sc_hd__o221ai_1
X_14822_ net434 net401 _07984_ VSS VSS VDD VDD _04102_ sky130_fd_sc_hd__or3_1
X_14823_ net450 _04100_ _04101_ _04102_ net430 VSS VSS VDD
+ VDD _04103_ sky130_fd_sc_hd__a221oi_1
X_14824_ net430 _04096_ _04098_ _04103_ VSS VSS VDD VDD _04104_
+ sky130_fd_sc_hd__a31oi_1
X_14825_ _04095_ _04104_ _07702_ VSS VSS VDD VDD _04105_ sky130_fd_sc_hd__o21ai_0
X_14826_ _04089_ _04094_ _04105_ net327 VSS VSS VDD VDD _01753_
+ sky130_fd_sc_hd__a31oi_1
X_14827_ _07634_ _08023_ _03961_ VSS VSS VDD VDD _01754_ sky130_fd_sc_hd__nor3_1
X_14828_ net454 net453 net321 VSS VSS VDD VDD _04106_ sky130_fd_sc_hd__nand3_1
Xplace381 _07639_ VSS VSS VDD VDD net380 sky130_fd_sc_hd__buf_4
X_14830_ _04066_ _04106_ VSS VSS VDD VDD _03234_ sky130_fd_sc_hd__nor2_1
X_14831_ loaded\[5\] _08782_ loaded\[4\] VSS VSS VDD VDD _04108_
+ sky130_fd_sc_hd__nor3b_1
X_14832_ net454 net453 net320 VSS VSS VDD VDD _04109_ sky130_fd_sc_hd__nand3_1
Xplace380 _07684_ VSS VSS VDD VDD net379 sky130_fd_sc_hd__buf_4
X_14834_ _08790_ net315 VSS VSS VDD VDD _03224_ sky130_fd_sc_hd__nor2_1
X_14835_ _04072_ net315 VSS VSS VDD VDD _03222_ sky130_fd_sc_hd__nor2_1
X_14836_ _00849_ _04065_ VSS VSS VDD VDD _04111_ sky130_fd_sc_hd__nand2_4
Xplace390 _07498_ VSS VSS VDD VDD net389 sky130_fd_sc_hd__buf_4
X_14838_ net315 _04111_ VSS VSS VDD VDD _03219_ sky130_fd_sc_hd__nor2_1
X_14839_ _00849_ _04054_ VSS VSS VDD VDD _04113_ sky130_fd_sc_hd__nand2_4
Xplace388 _07523_ VSS VSS VDD VDD net387 sky130_fd_sc_hd__buf_4
X_14841_ _04074_ _04113_ VSS VSS VDD VDD _03275_ sky130_fd_sc_hd__nor2_1
X_14842_ _00848_ _04065_ VSS VSS VDD VDD _04115_ sky130_fd_sc_hd__nand2_4
Xplace386 _07560_ VSS VSS VDD VDD net385 sky130_fd_sc_hd__buf_4
X_14844_ net315 _04115_ VSS VSS VDD VDD _03217_ sky130_fd_sc_hd__nor2_1
X_14845_ _00847_ _04054_ VSS VSS VDD VDD _04117_ sky130_fd_sc_hd__nand2_4
Xplace385 _07600_ VSS VSS VDD VDD net384 sky130_fd_sc_hd__buf_4
X_14847_ _04074_ _04117_ VSS VSS VDD VDD _03274_ sky130_fd_sc_hd__nor2_1
X_14848_ loaded\[4\] loaded\[5\] _08782_ VSS VSS VDD VDD _04119_
+ sky130_fd_sc_hd__nor3_2
X_14849_ net454 net453 _04119_ VSS VSS VDD VDD _04120_ sky130_fd_sc_hd__nand3_1
Xplace387 _07557_ VSS VSS VDD VDD net386 sky130_fd_sc_hd__buf_4
X_14851_ _08790_ net314 VSS VSS VDD VDD _03206_ sky130_fd_sc_hd__nor2_1
X_14852_ _00848_ _04054_ VSS VSS VDD VDD _04122_ sky130_fd_sc_hd__nand2_4
Xplace411 _07326_ VSS VSS VDD VDD net410 sky130_fd_sc_hd__buf_4
X_14854_ _04074_ _04122_ VSS VSS VDD VDD _03273_ sky130_fd_sc_hd__nor2_1
X_14855_ _04115_ net314 VSS VSS VDD VDD _03200_ sky130_fd_sc_hd__nor2_1
X_14856_ _04066_ net314 VSS VSS VDD VDD _03199_ sky130_fd_sc_hd__nor2_1
X_14857_ _04055_ net314 VSS VSS VDD VDD _03193_ sky130_fd_sc_hd__nor2_1
X_14858_ _04070_ net314 VSS VSS VDD VDD _03192_ sky130_fd_sc_hd__nor2_1
X_14859_ _04059_ _04072_ VSS VSS VDD VDD _03185_ sky130_fd_sc_hd__nor2_1
X_14860_ _04063_ _04117_ VSS VSS VDD VDD _03160_ sky130_fd_sc_hd__nor2_1
Xplace401 _07398_ VSS VSS VDD VDD net400 sky130_fd_sc_hd__buf_4
X_14862_ net331 _04063_ VSS VSS VDD VDD _03154_ sky130_fd_sc_hd__nor2_1
X_14863_ _00845_ _08784_ VSS VSS VDD VDD _04125_ sky130_fd_sc_hd__nand2_4
Xplace315 _04120_ VSS VSS VDD VDD net314 sky130_fd_sc_hd__buf_4
X_14865_ _04058_ net320 VSS VSS VDD VDD _04127_ sky130_fd_sc_hd__nand2_1
Xplace314 _04138_ VSS VSS VDD VDD net313 sky130_fd_sc_hd__buf_4
X_14867_ _04125_ _04127_ VSS VSS VDD VDD _03149_ sky130_fd_sc_hd__nor2_1
X_14868_ _08790_ _04106_ VSS VSS VDD VDD _03241_ sky130_fd_sc_hd__nor2_1
X_14869_ _04115_ _04127_ VSS VSS VDD VDD _03146_ sky130_fd_sc_hd__nor2_1
X_14870_ _04058_ _04119_ VSS VSS VDD VDD _04129_ sky130_fd_sc_hd__nand2_1
Xplace307 _09687_ VSS VSS VDD VDD net306 sky130_fd_sc_hd__buf_4
X_14872_ _04070_ _04129_ VSS VSS VDD VDD _03122_ sky130_fd_sc_hd__nor2_1
X_14873_ _00847_ _08721_ VSS VSS VDD VDD _04131_ sky130_fd_sc_hd__nand2_4
Xplace310 _03437_ VSS VSS VDD VDD net309 sky130_fd_sc_hd__buf_4
X_14875_ _04129_ _04131_ VSS VSS VDD VDD _03121_ sky130_fd_sc_hd__nor2_1
X_14876_ _00848_ _08721_ VSS VSS VDD VDD _04133_ sky130_fd_sc_hd__nand2_4
Xplace309 _03460_ VSS VSS VDD VDD net308 sky130_fd_sc_hd__buf_4
X_14878_ _04129_ _04133_ VSS VSS VDD VDD _03119_ sky130_fd_sc_hd__nor2_1
X_14879_ net331 _04129_ VSS VSS VDD VDD _03118_ sky130_fd_sc_hd__nor2_1
X_14880_ net454 net453 net322 VSS VSS VDD VDD _04135_ sky130_fd_sc_hd__nand3_1
Xplace308 _09359_ VSS VSS VDD VDD net307 sky130_fd_sc_hd__buf_4
X_14882_ _08790_ _04135_ VSS VSS VDD VDD _03259_ sky130_fd_sc_hd__nor2_1
X_14883_ net453 net454 VSS VSS VDD VDD _04137_ sky130_fd_sc_hd__nor2b_1
X_14884_ net322 net452 VSS VSS VDD VDD _04138_ sky130_fd_sc_hd__nand2_1
Xplace323 _04057_ VSS VSS VDD VDD net322 sky130_fd_sc_hd__buf_4
X_14886_ _08790_ net313 VSS VSS VDD VDD _03117_ sky130_fd_sc_hd__nor2_1
X_14887_ _04068_ net313 VSS VSS VDD VDD _03116_ sky130_fd_sc_hd__nor2_1
X_14888_ _04125_ net313 VSS VSS VDD VDD _03114_ sky130_fd_sc_hd__nor2_1
X_14889_ _04111_ net313 VSS VSS VDD VDD _03113_ sky130_fd_sc_hd__nor2_1
X_14890_ _00847_ _04065_ VSS VSS VDD VDD _04140_ sky130_fd_sc_hd__nand2_4
Xplace321 _04108_ VSS VSS VDD VDD net320 sky130_fd_sc_hd__buf_4
X_14892_ net313 _04140_ VSS VSS VDD VDD _03112_ sky130_fd_sc_hd__nor2_1
X_14893_ _04115_ net313 VSS VSS VDD VDD _03111_ sky130_fd_sc_hd__nor2_1
X_14894_ _04066_ net313 VSS VSS VDD VDD _03110_ sky130_fd_sc_hd__nor2_1
X_14895_ _04113_ net313 VSS VSS VDD VDD _03108_ sky130_fd_sc_hd__nor2_1
X_14896_ _04117_ net313 VSS VSS VDD VDD _03107_ sky130_fd_sc_hd__nor2_1
X_14897_ _04122_ net313 VSS VSS VDD VDD _03106_ sky130_fd_sc_hd__nor2_1
X_14898_ _04055_ net313 VSS VSS VDD VDD _03105_ sky130_fd_sc_hd__nor2_1
X_14899_ _04070_ net313 VSS VSS VDD VDD _03104_ sky130_fd_sc_hd__nor2_1
X_14900_ _04131_ net313 VSS VSS VDD VDD _03103_ sky130_fd_sc_hd__nor2_1
X_14901_ _04133_ net313 VSS VSS VDD VDD _03102_ sky130_fd_sc_hd__nor2_1
X_14902_ _04106_ _04115_ VSS VSS VDD VDD _03235_ sky130_fd_sc_hd__nor2_1
X_14903_ _04106_ _04122_ VSS VSS VDD VDD _03230_ sky130_fd_sc_hd__nor2_1
X_14904_ net315 _04113_ VSS VSS VDD VDD _03215_ sky130_fd_sc_hd__nor2_1
X_14905_ net315 _04117_ VSS VSS VDD VDD _03214_ sky130_fd_sc_hd__nor2_1
X_14906_ net331 net315 VSS VSS VDD VDD _03207_ sky130_fd_sc_hd__nor2_1
X_14907_ _04117_ net314 VSS VSS VDD VDD _03195_ sky130_fd_sc_hd__nor2_1
X_14908_ net314 _04122_ VSS VSS VDD VDD _03194_ sky130_fd_sc_hd__nor2_1
X_14909_ network.neuron_in043.counter\[2\] VSS VSS VDD VDD
+ _04142_ sky130_fd_sc_hd__inv_1
X_14910_ network.neuron_in043.counter\[3\] network.in_period\[43\]\[2\]
+ _00337_ net423 VSS VSS VDD VDD _04143_ sky130_fd_sc_hd__o22ai_1
Xplace320 _08994_ VSS VSS VDD VDD net319 sky130_fd_sc_hd__buf_4
Xplace328 _07473_ VSS VSS VDD VDD net327 sky130_fd_sc_hd__buf_4
X_14913_ network.neuron_in043.counter\[2\] _00337_ net342
+ VSS VSS VDD VDD _04146_ sky130_fd_sc_hd__nand3_1
X_14914_ network.in_period\[43\]\[2\] net342 _04146_ VSS VSS
+ VDD VDD _04147_ sky130_fd_sc_hd__o21ai_0
X_14915_ _04142_ _04143_ _04147_ VSS VSS VDD VDD _02237_ sky130_fd_sc_hd__a21oi_1
X_14916_ _04059_ _04068_ VSS VSS VDD VDD _03187_ sky130_fd_sc_hd__nor2_1
X_14917_ _04113_ _04135_ VSS VSS VDD VDD _03250_ sky130_fd_sc_hd__nor2_1
X_14918_ _04127_ _04140_ VSS VSS VDD VDD _03147_ sky130_fd_sc_hd__nor2_1
X_14919_ _04068_ _04106_ VSS VSS VDD VDD _03240_ sky130_fd_sc_hd__nor2_1
X_14920_ _04113_ _04127_ VSS VSS VDD VDD _03144_ sky130_fd_sc_hd__nor2_1
X_14921_ network.neuron_in044.counter\[2\] VSS VSS VDD VDD
+ _04148_ sky130_fd_sc_hd__inv_1
Xplace311 _09334_ VSS VSS VDD VDD net310 sky130_fd_sc_hd__buf_4
X_14923_ network.neuron_in044.counter\[3\] network.in_period\[44\]\[2\]
+ net424 _00325_ VSS VSS VDD VDD _04150_ sky130_fd_sc_hd__o22ai_1
X_14924_ network.neuron_in044.counter\[2\] _00325_ net340
+ VSS VSS VDD VDD _04151_ sky130_fd_sc_hd__nand3_1
X_14925_ network.in_period\[44\]\[2\] net340 _04151_ VSS VSS
+ VDD VDD _04152_ sky130_fd_sc_hd__o21ai_0
X_14926_ _04148_ _04150_ _04152_ VSS VSS VDD VDD _02241_ sky130_fd_sc_hd__a21oi_1
X_14927_ network.neuron_in045.counter\[2\] network.neuron_in045.counter\[3\]
+ VSS VSS VDD VDD _04153_ sky130_fd_sc_hd__nor2_1
X_14928_ _00333_ _04153_ VSS VSS VDD VDD _04154_ sky130_fd_sc_hd__nand2_1
X_14929_ net340 _04154_ VSS VSS VDD VDD _04155_ sky130_fd_sc_hd__nand2_1
X_14930_ network.in_period\[45\]\[1\] _04155_ VSS VSS VDD
+ VDD _04156_ sky130_fd_sc_hd__nand2_1
X_14931_ _00334_ _04155_ _04156_ VSS VSS VDD VDD _02244_ sky130_fd_sc_hd__o21ai_0
X_14932_ network.neuron_in046.counter\[2\] _00317_ VSS VSS
+ VDD VDD _04157_ sky130_fd_sc_hd__nand2b_1
X_14933_ network.neuron_in046.counter\[3\] _04157_ VSS VSS
+ VDD VDD _04158_ sky130_fd_sc_hd__or2_2
X_14934_ net340 _04158_ VSS VSS VDD VDD _04159_ sky130_fd_sc_hd__nand2_1
X_14935_ network.in_period\[46\]\[0\] _04159_ VSS VSS VDD
+ VDD _04160_ sky130_fd_sc_hd__nand2_1
X_14936_ network.neuron_in046.counter\[0\] _04159_ _04160_
+ VSS VSS VDD VDD _02247_ sky130_fd_sc_hd__o21ai_0
X_14937_ _04142_ _00337_ VSS VSS VDD VDD _04161_ sky130_fd_sc_hd__nand2_1
X_14938_ network.neuron_in043.counter\[3\] _04161_ VSS VSS
+ VDD VDD _04162_ sky130_fd_sc_hd__or2_2
X_14939_ net342 _04162_ VSS VSS VDD VDD _04163_ sky130_fd_sc_hd__nand2_1
X_14940_ network.in_period\[43\]\[1\] _04163_ VSS VSS VDD
+ VDD _04164_ sky130_fd_sc_hd__nand2_1
X_14941_ _00338_ _04163_ _04164_ VSS VSS VDD VDD _02236_ sky130_fd_sc_hd__o21ai_0
X_14942_ network.in_period\[43\]\[0\] _04163_ VSS VSS VDD
+ VDD _04165_ sky130_fd_sc_hd__nand2_1
X_14943_ network.neuron_in043.counter\[0\] _04163_ _04165_
+ VSS VSS VDD VDD _02235_ sky130_fd_sc_hd__o21ai_0
X_14944_ network.neuron_in044.counter\[3\] _00325_ VSS VSS
+ VDD VDD _04166_ sky130_fd_sc_hd__nand2b_1
X_14945_ _04166_ _04148_ VSS VSS VDD VDD _04167_ sky130_fd_sc_hd__nand2b_1
X_14946_ net340 _04167_ VSS VSS VDD VDD _04168_ sky130_fd_sc_hd__nand2_1
X_14947_ network.in_period\[44\]\[1\] _04168_ VSS VSS VDD
+ VDD _04169_ sky130_fd_sc_hd__nand2_1
X_14948_ _00326_ _04168_ _04169_ VSS VSS VDD VDD _02240_ sky130_fd_sc_hd__o21ai_0
X_14949_ network.in_period\[44\]\[0\] _04168_ VSS VSS VDD
+ VDD _04170_ sky130_fd_sc_hd__nand2_1
X_14950_ network.neuron_in044.counter\[0\] _04168_ _04170_
+ VSS VSS VDD VDD _02239_ sky130_fd_sc_hd__o21ai_0
X_14951_ network.neuron_in045.counter\[2\] VSS VSS VDD VDD
+ _04171_ sky130_fd_sc_hd__inv_1
X_14952_ network.neuron_in045.counter\[3\] network.in_period\[45\]\[2\]
+ net424 _00333_ VSS VSS VDD VDD _04172_ sky130_fd_sc_hd__o22ai_1
X_14953_ network.neuron_in045.counter\[2\] _00333_ net340
+ VSS VSS VDD VDD _04173_ sky130_fd_sc_hd__nand3_1
X_14954_ network.in_period\[45\]\[2\] net340 _04173_ VSS VSS
+ VDD VDD _04174_ sky130_fd_sc_hd__o21ai_0
X_14955_ _04171_ _04172_ _04174_ VSS VSS VDD VDD _02245_ sky130_fd_sc_hd__a21oi_1
X_14956_ network.in_period\[45\]\[0\] _04155_ VSS VSS VDD
+ VDD _04175_ sky130_fd_sc_hd__nand2_1
X_14957_ network.neuron_in045.counter\[0\] _04155_ _04175_
+ VSS VSS VDD VDD _02243_ sky130_fd_sc_hd__o21ai_0
X_14958_ network.neuron_in178.counter\[0\] VSS VSS VDD VDD
+ _01150_ sky130_fd_sc_hd__inv_1
X_14959_ network.neuron_in046.counter\[2\] net340 VSS VSS
+ VDD VDD _04176_ sky130_fd_sc_hd__nand2_1
X_14960_ network.neuron_in046.counter\[3\] network.in_period\[46\]\[2\]
+ _04176_ VSS VSS VDD VDD _04177_ sky130_fd_sc_hd__o21ai_0
X_14961_ _00317_ network.neuron_in046.counter\[2\] net425
+ VSS VSS VDD VDD _04178_ sky130_fd_sc_hd__or3_1
X_14962_ network.in_period\[46\]\[2\] net340 _04178_ VSS VSS
+ VDD VDD _04179_ sky130_fd_sc_hd__o21ai_0
X_14963_ _00317_ _04177_ _04179_ VSS VSS VDD VDD _02249_ sky130_fd_sc_hd__a21oi_1
X_14964_ network.in_period\[46\]\[1\] _04159_ VSS VSS VDD
+ VDD _04180_ sky130_fd_sc_hd__nand2_1
X_14965_ _00318_ _04159_ _04180_ VSS VSS VDD VDD _02248_ sky130_fd_sc_hd__o21ai_0
X_14966_ network.neuron_in050.counter\[2\] VSS VSS VDD VDD
+ _04181_ sky130_fd_sc_hd__inv_1
X_14967_ network.neuron_in050.counter\[3\] network.in_period\[50\]\[2\]
+ net421 _00385_ VSS VSS VDD VDD _04182_ sky130_fd_sc_hd__o22ai_1
X_14968_ network.neuron_in050.counter\[2\] _00385_ net352
+ VSS VSS VDD VDD _04183_ sky130_fd_sc_hd__nand3_1
X_14969_ network.in_period\[50\]\[2\] net352 _04183_ VSS VSS
+ VDD VDD _04184_ sky130_fd_sc_hd__o21ai_0
X_14970_ _04181_ _04182_ _04184_ VSS VSS VDD VDD _02265_ sky130_fd_sc_hd__a21oi_1
X_14971_ network.neuron_in049.counter\[2\] _00293_ VSS VSS
+ VDD VDD _04185_ sky130_fd_sc_hd__nand2b_1
X_14972_ network.neuron_in049.counter\[3\] _04185_ VSS VSS
+ VDD VDD _04186_ sky130_fd_sc_hd__or2_2
X_14973_ net349 _04186_ VSS VSS VDD VDD _04187_ sky130_fd_sc_hd__nand2_1
X_14974_ network.in_period\[49\]\[0\] _04187_ VSS VSS VDD
+ VDD _04188_ sky130_fd_sc_hd__nand2_1
X_14975_ network.neuron_in049.counter\[0\] _04187_ _04188_
+ VSS VSS VDD VDD _02259_ sky130_fd_sc_hd__o21ai_0
X_14976_ network.neuron_in052.counter\[2\] VSS VSS VDD VDD
+ _04189_ sky130_fd_sc_hd__inv_1
X_14977_ network.neuron_in052.counter\[3\] network.in_period\[52\]\[2\]
+ net418 _00281_ VSS VSS VDD VDD _04190_ sky130_fd_sc_hd__o22ai_1
X_14978_ network.neuron_in052.counter\[2\] _00281_ net350
+ VSS VSS VDD VDD _04191_ sky130_fd_sc_hd__nand3_1
X_14979_ network.in_period\[52\]\[2\] net350 _04191_ VSS VSS
+ VDD VDD _04192_ sky130_fd_sc_hd__o21ai_0
X_14980_ _04189_ _04190_ _04192_ VSS VSS VDD VDD _02273_ sky130_fd_sc_hd__a21oi_1
X_14981_ network.neuron_in047.counter\[3\] _00305_ VSS VSS
+ VDD VDD _04193_ sky130_fd_sc_hd__nand2b_1
X_14982_ network.neuron_in047.counter\[2\] VSS VSS VDD VDD
+ _04194_ sky130_fd_sc_hd__inv_1
X_14983_ _04193_ _04194_ VSS VSS VDD VDD _04195_ sky130_fd_sc_hd__nand2b_1
X_14984_ net340 _04195_ VSS VSS VDD VDD _04196_ sky130_fd_sc_hd__nand2_1
X_14985_ network.in_period\[47\]\[1\] _04196_ VSS VSS VDD
+ VDD _04197_ sky130_fd_sc_hd__nand2_1
X_14986_ _00306_ _04196_ _04197_ VSS VSS VDD VDD _02252_ sky130_fd_sc_hd__o21ai_0
Xplace313 _04211_ VSS VSS VDD VDD net312 sky130_fd_sc_hd__buf_4
X_14988_ network.neuron_in048.counter\[2\] VSS VSS VDD VDD
+ _04199_ sky130_fd_sc_hd__inv_1
X_14989_ _04199_ _00301_ VSS VSS VDD VDD _04200_ sky130_fd_sc_hd__nand2_1
X_14990_ network.neuron_in048.counter\[3\] _04200_ VSS VSS
+ VDD VDD _04201_ sky130_fd_sc_hd__or2_2
X_14991_ net350 _04201_ VSS VSS VDD VDD _04202_ sky130_fd_sc_hd__nand2_1
X_14992_ network.in_period\[48\]\[1\] _04202_ VSS VSS VDD
+ VDD _04203_ sky130_fd_sc_hd__nand2_1
X_14993_ _00302_ _04202_ _04203_ VSS VSS VDD VDD _02256_ sky130_fd_sc_hd__o21ai_0
X_14994_ network.in_period\[49\]\[1\] _04187_ VSS VSS VDD
+ VDD _04204_ sky130_fd_sc_hd__nand2_1
X_14995_ _00294_ _04187_ _04204_ VSS VSS VDD VDD _02260_ sky130_fd_sc_hd__o21ai_0
X_14996_ network.neuron_in050.counter\[0\] VSS VSS VDD VDD
+ _00383_ sky130_fd_sc_hd__inv_1
X_14997_ _04181_ _00385_ VSS VSS VDD VDD _04205_ sky130_fd_sc_hd__nand2_1
X_14998_ network.neuron_in050.counter\[3\] _04205_ VSS VSS
+ VDD VDD _04206_ sky130_fd_sc_hd__or2_2
X_14999_ net352 _04206_ VSS VSS VDD VDD _04207_ sky130_fd_sc_hd__nand2_1
X_15000_ network.in_period\[50\]\[0\] _04207_ VSS VSS VDD
+ VDD _04208_ sky130_fd_sc_hd__nand2_1
X_15001_ network.neuron_in050.counter\[0\] _04207_ _04208_
+ VSS VSS VDD VDD _02263_ sky130_fd_sc_hd__o21ai_0
X_15002_ network.neuron_out0.ROM0.address\[1\] network.neuron_out0.ROM0.address\[0\]
+ _08449_ VSS VSS VDD VDD _01755_ sky130_fd_sc_hd__nor3_1
X_15003_ net321 net452 VSS VSS VDD VDD _04209_ sky130_fd_sc_hd__nand2_1
Xclkbuf_2_0__f_clk_regs clknet_0_clk_regs VSS VSS VDD VDD
+ clknet_2_0__leaf_clk_regs sky130_fd_sc_hd__clkbuf_16
X_15005_ _04133_ _04209_ VSS VSS VDD VDD _03339_ sky130_fd_sc_hd__nor2_1
X_15006_ net320 net452 VSS VSS VDD VDD _04211_ sky130_fd_sc_hd__nand2_1
Xclkbuf_0_clk clk VSS VSS VDD VDD clknet_0_clk sky130_fd_sc_hd__clkbuf_16
X_15008_ _08790_ net312 VSS VSS VDD VDD _03337_ sky130_fd_sc_hd__nor2_1
X_15009_ _04072_ net312 VSS VSS VDD VDD _03335_ sky130_fd_sc_hd__nor2_1
X_15010_ _04115_ net312 VSS VSS VDD VDD _03330_ sky130_fd_sc_hd__nor2_1
X_15011_ network.neuron_in051.counter\[0\] VSS VSS VDD VDD
+ _00387_ sky130_fd_sc_hd__inv_1
X_15012_ network.neuron_in051.counter\[2\] _00389_ VSS VSS
+ VDD VDD _04213_ sky130_fd_sc_hd__nand2b_1
X_15013_ network.neuron_in051.counter\[3\] _04213_ VSS VSS
+ VDD VDD _04214_ sky130_fd_sc_hd__or2_2
X_15014_ net350 _04214_ VSS VSS VDD VDD _04215_ sky130_fd_sc_hd__nand2_1
X_15015_ network.in_period\[51\]\[0\] _04215_ VSS VSS VDD
+ VDD _04216_ sky130_fd_sc_hd__nand2_1
X_15016_ network.neuron_in051.counter\[0\] _04215_ _04216_
+ VSS VSS VDD VDD _02267_ sky130_fd_sc_hd__o21ai_0
X_15017_ _08725_ net322 VSS VSS VDD VDD _04217_ sky130_fd_sc_hd__nand2_1
Xclkbuf_regs_0_core_clk delaynet_4_core_clk VSS VSS VDD VDD
+ clk_regs sky130_fd_sc_hd__clkbuf_16
X_15019_ net331 _04217_ VSS VSS VDD VDD _03285_ sky130_fd_sc_hd__nor2_1
X_15020_ _04068_ _04074_ VSS VSS VDD VDD _03283_ sky130_fd_sc_hd__nor2_1
X_15021_ _04055_ _04074_ VSS VSS VDD VDD _03272_ sky130_fd_sc_hd__nor2_1
X_15022_ net444 net409 _07393_ VSS VSS VDD VDD _04219_ sky130_fd_sc_hd__a21oi_1
X_15023_ net436 _07518_ VSS VSS VDD VDD _04220_ sky130_fd_sc_hd__nand2_1
X_15024_ net447 _04219_ _04220_ _07536_ VSS VSS VDD VDD _04221_
+ sky130_fd_sc_hd__o211ai_1
X_15025_ net400 _07634_ _07409_ VSS VSS VDD VDD _04222_ sky130_fd_sc_hd__o21ai_0
X_15026_ net432 _04035_ VSS VSS VDD VDD _04223_ sky130_fd_sc_hd__nor2_1
X_15027_ net432 _04222_ _04223_ _07526_ VSS VSS VDD VDD _04224_
+ sky130_fd_sc_hd__a211o_1
X_15028_ _07352_ _07409_ _07946_ net404 VSS VSS VDD VDD _04225_
+ sky130_fd_sc_hd__a22oi_1
X_15029_ net430 net395 VSS VSS VDD VDD _04226_ sky130_fd_sc_hd__nand2_1
X_15030_ _07429_ _04226_ VSS VSS VDD VDD _04227_ sky130_fd_sc_hd__nand2_1
X_15031_ net436 _04227_ VSS VSS VDD VDD _04228_ sky130_fd_sc_hd__nand2_1
X_15032_ _04225_ _04228_ net444 VSS VSS VDD VDD _04229_ sky130_fd_sc_hd__a21oi_1
X_15033_ net432 net410 net394 _07387_ VSS VSS VDD VDD _04230_
+ sky130_fd_sc_hd__o31a_1
X_15034_ _07539_ net405 _04230_ net436 VSS VSS VDD VDD _04231_
+ sky130_fd_sc_hd__o22ai_1
X_15035_ net444 _04224_ _04229_ _04231_ VSS VSS VDD VDD _04232_
+ sky130_fd_sc_hd__a211oi_1
X_15036_ _08064_ _08314_ VSS VSS VDD VDD _04233_ sky130_fd_sc_hd__nand2_1
X_15037_ net433 net379 _04233_ VSS VSS VDD VDD _04234_ sky130_fd_sc_hd__o21ai_0
X_15038_ net431 _07986_ VSS VSS VDD VDD _04235_ sky130_fd_sc_hd__nor2_1
X_15039_ net372 _04235_ VSS VSS VDD VDD _04236_ sky130_fd_sc_hd__nor2_1
X_15040_ net429 net439 _07678_ VSS VSS VDD VDD _04237_ sky130_fd_sc_hd__o21ai_0
X_15041_ net429 net437 _07593_ _07687_ VSS VSS VDD VDD _04238_
+ sky130_fd_sc_hd__nand4_1
X_15042_ net439 _04236_ _04237_ _04238_ net449 VSS VSS VDD
+ VDD _04239_ sky130_fd_sc_hd__o2111ai_1
X_15043_ net433 _07593_ _08104_ net429 VSS VSS VDD VDD _04240_
+ sky130_fd_sc_hd__o22ai_1
X_15044_ net436 net405 _08279_ VSS VSS VDD VDD _04241_ sky130_fd_sc_hd__o21ai_0
X_15045_ net402 _04240_ _04241_ net429 net449 VSS VSS VDD
+ VDD _04242_ sky130_fd_sc_hd__a221o_1
X_15046_ net442 _04234_ _04239_ _04242_ net427 VSS VSS VDD
+ VDD _04243_ sky130_fd_sc_hd__a221oi_1
X_15047_ net428 _04232_ _04243_ VSS VSS VDD VDD _04244_ sky130_fd_sc_hd__a21oi_1
X_15048_ _07307_ _04221_ _04244_ _07344_ VSS VSS VDD VDD _01756_
+ sky130_fd_sc_hd__o22ai_1
X_15049_ _04074_ _04133_ VSS VSS VDD VDD _03269_ sky130_fd_sc_hd__nor2_1
X_15050_ net331 _04074_ VSS VSS VDD VDD _03268_ sky130_fd_sc_hd__nor2_1
X_15051_ network.neuron_in047.counter\[3\] network.in_period\[47\]\[2\]
+ net424 _00305_ VSS VSS VDD VDD _04245_ sky130_fd_sc_hd__o22ai_1
X_15052_ network.neuron_in047.counter\[2\] _00305_ net340
+ VSS VSS VDD VDD _04246_ sky130_fd_sc_hd__nand3_1
X_15053_ network.in_period\[47\]\[2\] net340 _04246_ VSS VSS
+ VDD VDD _04247_ sky130_fd_sc_hd__o21ai_0
X_15054_ _04194_ _04245_ _04247_ VSS VSS VDD VDD _02253_ sky130_fd_sc_hd__a21oi_1
X_15055_ _08725_ net320 VSS VSS VDD VDD _04248_ sky130_fd_sc_hd__nand2_1
Xclkbuf_0_clk_regs clk_regs VSS VSS VDD VDD clknet_0_clk_regs
+ sky130_fd_sc_hd__clkbuf_16
X_15057_ _08790_ _04248_ VSS VSS VDD VDD _03267_ sky130_fd_sc_hd__nor2_1
X_15058_ network.in_period\[47\]\[0\] _04196_ VSS VSS VDD
+ VDD _04250_ sky130_fd_sc_hd__nand2_1
X_15059_ network.neuron_in047.counter\[0\] _04196_ _04250_
+ VSS VSS VDD VDD _02251_ sky130_fd_sc_hd__o21ai_0
X_15060_ _04068_ _04248_ VSS VSS VDD VDD _03266_ sky130_fd_sc_hd__nor2_1
X_15061_ _04072_ _04248_ VSS VSS VDD VDD _03264_ sky130_fd_sc_hd__nor2_1
X_15062_ _04125_ _04248_ VSS VSS VDD VDD _03263_ sky130_fd_sc_hd__nor2_1
X_15063_ network.neuron_in048.counter\[3\] network.in_period\[48\]\[2\]
+ net418 _00301_ VSS VSS VDD VDD _04251_ sky130_fd_sc_hd__o22ai_1
X_15064_ network.neuron_in048.counter\[2\] _00301_ net352
+ VSS VSS VDD VDD _04252_ sky130_fd_sc_hd__nand3_1
X_15065_ network.in_period\[48\]\[2\] net350 _04252_ VSS VSS
+ VDD VDD _04253_ sky130_fd_sc_hd__o21ai_0
X_15066_ _04199_ _04251_ _04253_ VSS VSS VDD VDD _02257_ sky130_fd_sc_hd__a21oi_1
X_15067_ _04111_ _04248_ VSS VSS VDD VDD _03262_ sky130_fd_sc_hd__nor2_1
X_15068_ network.in_period\[48\]\[0\] _04202_ VSS VSS VDD
+ VDD _04254_ sky130_fd_sc_hd__nand2_1
X_15069_ network.neuron_in048.counter\[0\] _04202_ _04254_
+ VSS VSS VDD VDD _02255_ sky130_fd_sc_hd__o21ai_0
X_15070_ _04140_ _04248_ VSS VSS VDD VDD _03261_ sky130_fd_sc_hd__nor2_1
X_15071_ _04115_ _04248_ VSS VSS VDD VDD _03260_ sky130_fd_sc_hd__nor2_1
X_15072_ network.neuron_in049.counter\[2\] net349 VSS VSS
+ VDD VDD _04255_ sky130_fd_sc_hd__nand2_1
X_15073_ network.neuron_in049.counter\[3\] network.in_period\[49\]\[2\]
+ _04255_ VSS VSS VDD VDD _04256_ sky130_fd_sc_hd__o21ai_0
X_15074_ _00293_ network.neuron_in049.counter\[2\] net418
+ VSS VSS VDD VDD _04257_ sky130_fd_sc_hd__or3_1
X_15075_ network.in_period\[49\]\[2\] net349 _04257_ VSS VSS
+ VDD VDD _04258_ sky130_fd_sc_hd__o21ai_0
X_15076_ _00293_ _04256_ _04258_ VSS VSS VDD VDD _02261_ sky130_fd_sc_hd__a21oi_1
X_15077_ network.in_period\[50\]\[1\] _04207_ VSS VSS VDD
+ VDD _04259_ sky130_fd_sc_hd__nand2_1
X_15078_ _00386_ _04207_ _04259_ VSS VSS VDD VDD _02264_ sky130_fd_sc_hd__o21ai_0
X_15079_ _04113_ _04248_ VSS VSS VDD VDD _03242_ sky130_fd_sc_hd__nor2_1
X_15080_ _04117_ _04248_ VSS VSS VDD VDD _03231_ sky130_fd_sc_hd__nor2_1
X_15081_ network.neuron_in051.counter\[2\] net350 VSS VSS
+ VDD VDD _04260_ sky130_fd_sc_hd__nand2_1
X_15082_ network.neuron_in051.counter\[3\] network.in_period\[51\]\[2\]
+ _04260_ VSS VSS VDD VDD _04261_ sky130_fd_sc_hd__o21ai_0
X_15083_ _00389_ network.neuron_in051.counter\[2\] net418
+ VSS VSS VDD VDD _04262_ sky130_fd_sc_hd__or3_1
X_15084_ network.in_period\[51\]\[2\] net350 _04262_ VSS VSS
+ VDD VDD _04263_ sky130_fd_sc_hd__o21ai_0
X_15085_ _00389_ _04261_ _04263_ VSS VSS VDD VDD _02269_ sky130_fd_sc_hd__a21oi_1
X_15086_ _04122_ _04248_ VSS VSS VDD VDD _03220_ sky130_fd_sc_hd__nor2_1
X_15087_ network.in_period\[51\]\[1\] _04215_ VSS VSS VDD
+ VDD _04264_ sky130_fd_sc_hd__nand2_1
X_15088_ _00390_ _04215_ _04264_ VSS VSS VDD VDD _02268_ sky130_fd_sc_hd__o21ai_0
X_15089_ _04055_ _04248_ VSS VSS VDD VDD _03209_ sky130_fd_sc_hd__nor2_1
X_15090_ _04070_ _04248_ VSS VSS VDD VDD _03197_ sky130_fd_sc_hd__nor2_1
X_15091_ network.neuron_in052.counter\[3\] _00281_ VSS VSS
+ VDD VDD _04265_ sky130_fd_sc_hd__nand2b_1
X_15092_ _04265_ _04189_ VSS VSS VDD VDD _04266_ sky130_fd_sc_hd__nand2b_1
X_15093_ net350 _04266_ VSS VSS VDD VDD _04267_ sky130_fd_sc_hd__nand2_1
X_15094_ network.in_period\[52\]\[1\] _04267_ VSS VSS VDD
+ VDD _04268_ sky130_fd_sc_hd__nand2_1
X_15095_ _00282_ _04267_ _04268_ VSS VSS VDD VDD _02272_ sky130_fd_sc_hd__o21ai_0
X_15096_ _04133_ _04248_ VSS VSS VDD VDD _03175_ sky130_fd_sc_hd__nor2_1
X_15097_ network.in_period\[52\]\[0\] _04267_ VSS VSS VDD
+ VDD _04269_ sky130_fd_sc_hd__nand2_1
X_15098_ network.neuron_in052.counter\[0\] _04267_ _04269_
+ VSS VSS VDD VDD _02271_ sky130_fd_sc_hd__o21ai_0
X_15099_ net331 net313 VSS VSS VDD VDD _03101_ sky130_fd_sc_hd__nor2_1
X_15100_ _08790_ _04209_ VSS VSS VDD VDD _03100_ sky130_fd_sc_hd__nor2_1
X_15101_ _08725_ _04119_ VSS VSS VDD VDD _04270_ sky130_fd_sc_hd__nand2_1
Xclkbuf_1_1__f_clk clknet_0_clk VSS VSS VDD VDD clknet_1_1__leaf_clk
+ sky130_fd_sc_hd__clkbuf_16
X_15103_ _04113_ _04270_ VSS VSS VDD VDD _03320_ sky130_fd_sc_hd__nor2_1
X_15104_ _04068_ _04209_ VSS VSS VDD VDD _03099_ sky130_fd_sc_hd__nor2_1
X_15105_ _04070_ _04270_ VSS VSS VDD VDD _03276_ sky130_fd_sc_hd__nor2_1
X_15106_ network.neuron_in057.counter\[3\] _00257_ VSS VSS
+ VDD VDD _04272_ sky130_fd_sc_hd__nand2b_1
X_15107_ network.neuron_in057.counter\[2\] VSS VSS VDD VDD
+ _04273_ sky130_fd_sc_hd__inv_1
X_15108_ _04272_ _04273_ VSS VSS VDD VDD _04274_ sky130_fd_sc_hd__nand2b_1
X_15109_ net350 _04274_ VSS VSS VDD VDD _04275_ sky130_fd_sc_hd__nand2_1
X_15110_ network.in_period\[57\]\[1\] _04275_ VSS VSS VDD
+ VDD _04276_ sky130_fd_sc_hd__nand2_1
X_15111_ _00258_ _04275_ _04276_ VSS VSS VDD VDD _02292_ sky130_fd_sc_hd__o21ai_0
X_15112_ _04072_ _04209_ VSS VSS VDD VDD _03097_ sky130_fd_sc_hd__nor2_1
X_15113_ _04072_ _04135_ VSS VSS VDD VDD _03257_ sky130_fd_sc_hd__nor2_1
X_15114_ _04133_ _04270_ VSS VSS VDD VDD _03198_ sky130_fd_sc_hd__nor2_1
X_15115_ _04111_ _04209_ VSS VSS VDD VDD _03095_ sky130_fd_sc_hd__nor2_1
X_15116_ network.neuron_in057.counter\[3\] network.in_period\[57\]\[2\]
+ net418 _00257_ VSS VSS VDD VDD _04277_ sky130_fd_sc_hd__o22ai_1
Xclkbuf_1_0__f_clk delaynet_0_core_clk VSS VSS VDD VDD clknet_1_0__leaf_clk
+ sky130_fd_sc_hd__clkbuf_16
X_15118_ network.neuron_in057.counter\[2\] _00257_ net350
+ VSS VSS VDD VDD _04279_ sky130_fd_sc_hd__nand3_1
X_15119_ network.in_period\[57\]\[2\] net350 _04279_ VSS VSS
+ VDD VDD _04280_ sky130_fd_sc_hd__o21ai_0
X_15120_ _04273_ _04277_ _04280_ VSS VSS VDD VDD _02293_ sky130_fd_sc_hd__a21oi_1
X_15121_ net331 _04270_ VSS VSS VDD VDD _03087_ sky130_fd_sc_hd__nor2_1
X_15122_ network.neuron_in054.counter\[2\] VSS VSS VDD VDD
+ _04281_ sky130_fd_sc_hd__inv_1
Xplace481 net481 VSS VSS VDD VDD net480 sky130_fd_sc_hd__buf_4
X_15124_ network.neuron_in054.counter\[3\] network.in_period\[54\]\[2\]
+ _00269_ net418 VSS VSS VDD VDD _04283_ sky130_fd_sc_hd__o22ai_1
X_15125_ network.neuron_in054.counter\[2\] _00269_ net350
+ VSS VSS VDD VDD _04284_ sky130_fd_sc_hd__nand3_1
X_15126_ network.in_period\[54\]\[2\] net350 _04284_ VSS VSS
+ VDD VDD _04285_ sky130_fd_sc_hd__o21ai_0
X_15127_ _04281_ _04283_ _04285_ VSS VSS VDD VDD _02281_ sky130_fd_sc_hd__a21oi_1
X_15128_ network.neuron_in053.counter\[0\] VSS VSS VDD VDD
+ _00271_ sky130_fd_sc_hd__inv_1
X_15129_ network.neuron_in053.counter\[3\] _00273_ VSS VSS
+ VDD VDD _04286_ sky130_fd_sc_hd__nand2b_1
X_15130_ network.neuron_in053.counter\[2\] VSS VSS VDD VDD
+ _04287_ sky130_fd_sc_hd__inv_1
X_15131_ _04286_ _04287_ VSS VSS VDD VDD _04288_ sky130_fd_sc_hd__nand2b_1
X_15132_ net350 _04288_ VSS VSS VDD VDD _04289_ sky130_fd_sc_hd__nand2_1
X_15133_ network.in_period\[53\]\[0\] _04289_ VSS VSS VDD
+ VDD _04290_ sky130_fd_sc_hd__nand2_1
X_15134_ network.neuron_in053.counter\[0\] _04289_ _04290_
+ VSS VSS VDD VDD _02275_ sky130_fd_sc_hd__o21ai_0
X_15135_ network.neuron_in133.counter\[2\] VSS VSS VDD VDD
+ _04291_ sky130_fd_sc_hd__inv_1
X_15136_ network.neuron_in133.counter\[3\] network.in_period\[133\]\[2\]
+ _00100_ net420 VSS VSS VDD VDD _04292_ sky130_fd_sc_hd__o22ai_1
X_15137_ network.neuron_in133.counter\[2\] _00100_ net352
+ VSS VSS VDD VDD _04293_ sky130_fd_sc_hd__nand3_1
X_15138_ network.in_period\[133\]\[2\] net352 _04293_ VSS
+ VSS VDD VDD _04294_ sky130_fd_sc_hd__o21ai_0
X_15139_ _04291_ _04292_ _04294_ VSS VSS VDD VDD _02597_ sky130_fd_sc_hd__a21oi_1
X_15140_ network.neuron_in055.counter\[3\] _00265_ VSS VSS
+ VDD VDD _04295_ sky130_fd_sc_hd__nand2b_1
X_15141_ network.neuron_in055.counter\[2\] VSS VSS VDD VDD
+ _04296_ sky130_fd_sc_hd__inv_1
X_15142_ _04295_ _04296_ VSS VSS VDD VDD _04297_ sky130_fd_sc_hd__nand2b_1
X_15143_ net350 _04297_ VSS VSS VDD VDD _04298_ sky130_fd_sc_hd__nand2_1
X_15144_ network.in_period\[55\]\[0\] _04298_ VSS VSS VDD
+ VDD _04299_ sky130_fd_sc_hd__nand2_1
X_15145_ network.neuron_in055.counter\[0\] _04298_ _04299_
+ VSS VSS VDD VDD _02283_ sky130_fd_sc_hd__o21ai_0
X_15146_ network.neuron_in056.counter\[2\] VSS VSS VDD VDD
+ _04300_ sky130_fd_sc_hd__inv_1
X_15147_ _04300_ _00253_ VSS VSS VDD VDD _04301_ sky130_fd_sc_hd__nand2_1
X_15148_ network.neuron_in056.counter\[3\] _04301_ VSS VSS
+ VDD VDD _04302_ sky130_fd_sc_hd__or2_2
X_15149_ net350 _04302_ VSS VSS VDD VDD _04303_ sky130_fd_sc_hd__nand2_1
X_15150_ network.in_period\[56\]\[0\] _04303_ VSS VSS VDD
+ VDD _04304_ sky130_fd_sc_hd__nand2_1
X_15151_ network.neuron_in056.counter\[0\] _04303_ _04304_
+ VSS VSS VDD VDD _02287_ sky130_fd_sc_hd__o21ai_0
X_15152_ network.neuron_in053.counter\[3\] network.in_period\[53\]\[2\]
+ net418 _00273_ VSS VSS VDD VDD _04305_ sky130_fd_sc_hd__o22ai_1
Xplace480 net480 VSS VSS VDD VDD net479 sky130_fd_sc_hd__buf_4
X_15154_ network.neuron_in053.counter\[2\] _00273_ net350
+ VSS VSS VDD VDD _04307_ sky130_fd_sc_hd__nand3_1
X_15155_ network.in_period\[53\]\[2\] net350 _04307_ VSS VSS
+ VDD VDD _04308_ sky130_fd_sc_hd__o21ai_0
X_15156_ _04287_ _04305_ _04308_ VSS VSS VDD VDD _02277_ sky130_fd_sc_hd__a21oi_1
X_15157_ network.in_period\[53\]\[1\] _04289_ VSS VSS VDD
+ VDD _04309_ sky130_fd_sc_hd__nand2_1
X_15158_ _00274_ _04289_ _04309_ VSS VSS VDD VDD _02276_ sky130_fd_sc_hd__o21ai_0
X_15159_ network.neuron_in054.counter\[2\] network.neuron_in054.counter\[3\]
+ VSS VSS VDD VDD _04310_ sky130_fd_sc_hd__nor2_1
X_15160_ _00269_ _04310_ VSS VSS VDD VDD _04311_ sky130_fd_sc_hd__nand2_1
X_15161_ net350 _04311_ VSS VSS VDD VDD _04312_ sky130_fd_sc_hd__nand2_1
X_15162_ network.in_period\[54\]\[1\] _04312_ VSS VSS VDD
+ VDD _04313_ sky130_fd_sc_hd__nand2_1
X_15163_ _00270_ _04312_ _04313_ VSS VSS VDD VDD _02280_ sky130_fd_sc_hd__o21ai_0
X_15164_ network.in_period\[54\]\[0\] _04312_ VSS VSS VDD
+ VDD _04314_ sky130_fd_sc_hd__nand2_1
X_15165_ network.neuron_in054.counter\[0\] _04312_ _04314_
+ VSS VSS VDD VDD _02279_ sky130_fd_sc_hd__o21ai_0
X_15166_ network.neuron_in055.counter\[3\] network.in_period\[55\]\[2\]
+ net418 _00265_ VSS VSS VDD VDD _04315_ sky130_fd_sc_hd__o22ai_1
X_15167_ network.neuron_in055.counter\[2\] _00265_ net350
+ VSS VSS VDD VDD _04316_ sky130_fd_sc_hd__nand3_1
X_15168_ network.in_period\[55\]\[2\] net350 _04316_ VSS VSS
+ VDD VDD _04317_ sky130_fd_sc_hd__o21ai_0
X_15169_ _04296_ _04315_ _04317_ VSS VSS VDD VDD _02285_ sky130_fd_sc_hd__a21oi_1
X_15170_ network.in_period\[55\]\[1\] _04298_ VSS VSS VDD
+ VDD _04318_ sky130_fd_sc_hd__nand2_1
X_15171_ _00266_ _04298_ _04318_ VSS VSS VDD VDD _02284_ sky130_fd_sc_hd__o21ai_0
X_15172_ network.neuron_in056.counter\[3\] network.in_period\[56\]\[2\]
+ net418 _00253_ VSS VSS VDD VDD _04319_ sky130_fd_sc_hd__o22ai_1
X_15173_ network.neuron_in056.counter\[2\] _00253_ net350
+ VSS VSS VDD VDD _04320_ sky130_fd_sc_hd__nand3_1
X_15174_ network.in_period\[56\]\[2\] net350 _04320_ VSS VSS
+ VDD VDD _04321_ sky130_fd_sc_hd__o21ai_0
X_15175_ _04300_ _04319_ _04321_ VSS VSS VDD VDD _02289_ sky130_fd_sc_hd__a21oi_1
X_15176_ network.in_period\[56\]\[1\] _04303_ VSS VSS VDD
+ VDD _04322_ sky130_fd_sc_hd__nand2_1
X_15177_ _00254_ _04303_ _04322_ VSS VSS VDD VDD _02288_ sky130_fd_sc_hd__o21ai_0
X_15178_ network.neuron_in060.counter\[2\] VSS VSS VDD VDD
+ _04323_ sky130_fd_sc_hd__inv_1
X_15179_ _04323_ _00211_ VSS VSS VDD VDD _04324_ sky130_fd_sc_hd__nand2_1
X_15180_ network.neuron_in060.counter\[3\] _04324_ VSS VSS
+ VDD VDD _04325_ sky130_fd_sc_hd__or2_2
X_15181_ net349 _04325_ VSS VSS VDD VDD _04326_ sky130_fd_sc_hd__nand2_1
X_15182_ network.in_period\[60\]\[0\] _04326_ VSS VSS VDD
+ VDD _04327_ sky130_fd_sc_hd__nand2_1
X_15183_ network.neuron_in060.counter\[0\] _04326_ _04327_
+ VSS VSS VDD VDD _02303_ sky130_fd_sc_hd__o21ai_0
X_15184_ network.neuron_in059.counter\[2\] VSS VSS VDD VDD
+ _04328_ sky130_fd_sc_hd__inv_1
X_15185_ _04328_ _00237_ VSS VSS VDD VDD _04329_ sky130_fd_sc_hd__nand2_1
X_15186_ network.neuron_in059.counter\[3\] _04329_ VSS VSS
+ VDD VDD _04330_ sky130_fd_sc_hd__or2_2
X_15187_ net350 _04330_ VSS VSS VDD VDD _04331_ sky130_fd_sc_hd__nand2_1
X_15188_ network.in_period\[59\]\[0\] _04331_ VSS VSS VDD
+ VDD _04332_ sky130_fd_sc_hd__nand2_1
X_15189_ network.neuron_in059.counter\[0\] _04331_ _04332_
+ VSS VSS VDD VDD _02299_ sky130_fd_sc_hd__o21ai_0
X_15190_ network.in_period\[60\]\[1\] _04326_ VSS VSS VDD
+ VDD _04333_ sky130_fd_sc_hd__nand2_1
X_15191_ _00212_ _04326_ _04333_ VSS VSS VDD VDD _02304_ sky130_fd_sc_hd__o21ai_0
X_15192_ network.neuron_in150.counter\[2\] net358 VSS VSS
+ VDD VDD _04334_ sky130_fd_sc_hd__nand2_1
X_15193_ network.neuron_in150.counter\[3\] network.in_period\[150\]\[2\]
+ _04334_ VSS VSS VDD VDD _04335_ sky130_fd_sc_hd__o21ai_0
Xplace479 net480 VSS VSS VDD VDD net478 sky130_fd_sc_hd__buf_4
X_15195_ _00577_ network.neuron_in150.counter\[2\] net417
+ VSS VSS VDD VDD _04337_ sky130_fd_sc_hd__or3_1
X_15196_ network.in_period\[150\]\[2\] net358 _04337_ VSS
+ VSS VDD VDD _04338_ sky130_fd_sc_hd__o21ai_0
X_15197_ _00577_ _04335_ _04338_ VSS VSS VDD VDD _02665_ sky130_fd_sc_hd__a21oi_1
X_15198_ net428 _08481_ VSS VSS VDD VDD _04339_ sky130_fd_sc_hd__nand2_1
X_15199_ net428 _08298_ _04339_ VSS VSS VDD VDD _04340_ sky130_fd_sc_hd__o21ai_0
X_15200_ _08031_ _07396_ _04340_ _03948_ VSS VSS VDD VDD _04341_
+ sky130_fd_sc_hd__a31oi_1
X_15201_ _07344_ _04341_ VSS VSS VDD VDD _01757_ sky130_fd_sc_hd__nor2_1
X_15202_ _04106_ _04133_ VSS VSS VDD VDD _03226_ sky130_fd_sc_hd__nor2_1
X_15203_ net331 _04106_ VSS VSS VDD VDD _03225_ sky130_fd_sc_hd__nor2_1
X_15204_ _04070_ net315 VSS VSS VDD VDD _03211_ sky130_fd_sc_hd__nor2_1
X_15205_ net315 _04131_ VSS VSS VDD VDD _03210_ sky130_fd_sc_hd__nor2_1
X_15206_ _04068_ net314 VSS VSS VDD VDD _03205_ sky130_fd_sc_hd__nor2_1
X_15207_ _04072_ net314 VSS VSS VDD VDD _03204_ sky130_fd_sc_hd__nor2_1
X_15208_ net314 _04125_ VSS VSS VDD VDD _03203_ sky130_fd_sc_hd__nor2_1
X_15209_ _04111_ net314 VSS VSS VDD VDD _03202_ sky130_fd_sc_hd__nor2_1
X_15210_ net331 _04135_ VSS VSS VDD VDD _03243_ sky130_fd_sc_hd__nor2_1
X_15211_ _04106_ _04111_ VSS VSS VDD VDD _03237_ sky130_fd_sc_hd__nor2_1
X_15212_ _04106_ _04117_ VSS VSS VDD VDD _03232_ sky130_fd_sc_hd__nor2_1
X_15213_ net315 _04125_ VSS VSS VDD VDD _03221_ sky130_fd_sc_hd__nor2_1
X_15214_ _04066_ net315 VSS VSS VDD VDD _03216_ sky130_fd_sc_hd__nor2_1
X_15215_ _04113_ net314 VSS VSS VDD VDD _03196_ sky130_fd_sc_hd__nor2_1
X_15216_ _08790_ _04059_ VSS VSS VDD VDD _03188_ sky130_fd_sc_hd__nor2_1
X_15217_ _04111_ _04135_ VSS VSS VDD VDD _03255_ sky130_fd_sc_hd__nor2_1
X_15218_ _04059_ _04113_ VSS VSS VDD VDD _03179_ sky130_fd_sc_hd__nor2_1
X_15219_ _04063_ _04122_ VSS VSS VDD VDD _03159_ sky130_fd_sc_hd__nor2_1
X_15220_ _04055_ _04063_ VSS VSS VDD VDD _03158_ sky130_fd_sc_hd__nor2_1
X_15221_ _04122_ _04135_ VSS VSS VDD VDD _03248_ sky130_fd_sc_hd__nor2_1
X_15222_ _04140_ _04209_ VSS VSS VDD VDD _03094_ sky130_fd_sc_hd__nor2_1
X_15223_ net404 _07431_ _08167_ VSS VSS VDD VDD _04342_ sky130_fd_sc_hd__a21oi_1
X_15224_ net431 _07507_ VSS VSS VDD VDD _04343_ sky130_fd_sc_hd__nand2_1
X_15225_ net390 net392 net436 VSS VSS VDD VDD _04344_ sky130_fd_sc_hd__a21oi_1
X_15226_ net431 _04342_ _04343_ _04344_ VSS VSS VDD VDD _04345_
+ sky130_fd_sc_hd__o211ai_1
X_15227_ _07420_ net387 _08083_ net431 VSS VSS VDD VDD _04346_
+ sky130_fd_sc_hd__a22oi_1
X_15228_ net431 _07483_ _08484_ VSS VSS VDD VDD _04347_ sky130_fd_sc_hd__o21a_1
X_15229_ net431 _07944_ _04347_ net450 net436 VSS VSS VDD
+ VDD _04348_ sky130_fd_sc_hd__o221a_2
X_15230_ net398 _04346_ _04348_ VSS VSS VDD VDD _04349_ sky130_fd_sc_hd__o21ai_0
X_15231_ net431 net373 _07674_ _08314_ VSS VSS VDD VDD _04350_
+ sky130_fd_sc_hd__a22o_1
X_15232_ _07539_ _04078_ net371 VSS VSS VDD VDD _04351_ sky130_fd_sc_hd__a21oi_1
X_15233_ net431 _08157_ net437 VSS VSS VDD VDD _04352_ sky130_fd_sc_hd__o21ai_0
X_15234_ _07352_ _07635_ net389 _08184_ VSS VSS VDD VDD _04353_
+ sky130_fd_sc_hd__a22oi_1
X_15235_ net446 _04351_ _04352_ _04353_ _07670_ VSS VSS VDD
+ VDD _04354_ sky130_fd_sc_hd__o2111ai_1
X_15236_ net444 _04350_ _04354_ VSS VSS VDD VDD _04355_ sky130_fd_sc_hd__a21oi_1
X_15237_ net444 net395 net436 VSS VSS VDD VDD _04356_ sky130_fd_sc_hd__a21oi_1
X_15238_ _07399_ net375 net402 VSS VSS VDD VDD _04357_ sky130_fd_sc_hd__o21ai_0
X_15239_ net404 net396 _07431_ net436 _07561_ VSS VSS VDD
+ VDD _04358_ sky130_fd_sc_hd__a221oi_1
X_15240_ net398 _04356_ _04357_ _04358_ VSS VSS VDD VDD _04359_
+ sky130_fd_sc_hd__o211ai_1
X_15241_ _07959_ net395 net444 VSS VSS VDD VDD _04360_ sky130_fd_sc_hd__o21ai_0
X_15242_ net446 _07554_ _04360_ VSS VSS VDD VDD _04361_ sky130_fd_sc_hd__o21ai_0
X_15243_ _08157_ _04361_ net431 net436 _07670_ VSS VSS VDD
+ VDD _04362_ sky130_fd_sc_hd__o2111ai_1
X_15244_ _04359_ _04362_ VSS VSS VDD VDD _04363_ sky130_fd_sc_hd__nand2_1
X_15245_ _07702_ _04345_ _04349_ _04355_ _04363_ VSS VSS VDD
+ VDD _04364_ sky130_fd_sc_hd__a311oi_1
X_15246_ net327 _04364_ VSS VSS VDD VDD _01758_ sky130_fd_sc_hd__nor2_1
X_15247_ _04063_ _04133_ VSS VSS VDD VDD _03155_ sky130_fd_sc_hd__nor2_1
X_15248_ _04115_ _04209_ VSS VSS VDD VDD _03093_ sky130_fd_sc_hd__nor2_1
X_15249_ _04066_ _04209_ VSS VSS VDD VDD _03092_ sky130_fd_sc_hd__nor2_1
X_15250_ _04113_ _04209_ VSS VSS VDD VDD _03091_ sky130_fd_sc_hd__nor2_1
X_15251_ _04055_ _04135_ VSS VSS VDD VDD _03247_ sky130_fd_sc_hd__nor2_1
X_15252_ _04117_ _04209_ VSS VSS VDD VDD _03090_ sky130_fd_sc_hd__nor2_1
Xplace478 net481 VSS VSS VDD VDD net477 sky130_fd_sc_hd__buf_4
X_15254_ network.neuron_in058.counter\[3\] _00245_ VSS VSS
+ VDD VDD _04366_ sky130_fd_sc_hd__nand2b_1
X_15255_ network.neuron_in058.counter\[2\] VSS VSS VDD VDD
+ _04367_ sky130_fd_sc_hd__inv_1
X_15256_ _04366_ _04367_ VSS VSS VDD VDD _04368_ sky130_fd_sc_hd__nand2b_1
X_15257_ net350 _04368_ VSS VSS VDD VDD _04369_ sky130_fd_sc_hd__nand2_1
X_15258_ network.in_period\[58\]\[1\] _04369_ VSS VSS VDD
+ VDD _04370_ sky130_fd_sc_hd__nand2_1
X_15259_ _00246_ _04369_ _04370_ VSS VSS VDD VDD _02296_ sky130_fd_sc_hd__o21ai_0
X_15260_ _04122_ _04209_ VSS VSS VDD VDD _03089_ sky130_fd_sc_hd__nor2_1
X_15261_ _08790_ _04127_ VSS VSS VDD VDD _03152_ sky130_fd_sc_hd__nor2_1
X_15262_ _04068_ _04127_ VSS VSS VDD VDD _03151_ sky130_fd_sc_hd__nor2_1
X_15263_ _04055_ _04209_ VSS VSS VDD VDD _03088_ sky130_fd_sc_hd__nor2_1
X_15264_ _04070_ _04209_ VSS VSS VDD VDD _03341_ sky130_fd_sc_hd__nor2_1
X_15265_ _04131_ _04209_ VSS VSS VDD VDD _03340_ sky130_fd_sc_hd__nor2_1
X_15266_ _04131_ _04135_ VSS VSS VDD VDD _03245_ sky130_fd_sc_hd__nor2_1
X_15267_ _04111_ _04127_ VSS VSS VDD VDD _03148_ sky130_fd_sc_hd__nor2_1
X_15268_ _04115_ _04135_ VSS VSS VDD VDD _03252_ sky130_fd_sc_hd__nor2_1
X_15269_ net331 _04209_ VSS VSS VDD VDD _03338_ sky130_fd_sc_hd__nor2_1
X_15270_ _04133_ _04135_ VSS VSS VDD VDD _03244_ sky130_fd_sc_hd__nor2_1
X_15271_ _04070_ _04106_ VSS VSS VDD VDD _03228_ sky130_fd_sc_hd__nor2_1
X_15272_ _04106_ _04131_ VSS VSS VDD VDD _03227_ sky130_fd_sc_hd__nor2_1
X_15273_ net315 _04122_ VSS VSS VDD VDD _03213_ sky130_fd_sc_hd__nor2_1
X_15274_ _04055_ net315 VSS VSS VDD VDD _03212_ sky130_fd_sc_hd__nor2_1
X_15275_ _04055_ _04106_ VSS VSS VDD VDD _03229_ sky130_fd_sc_hd__nor2_1
X_15276_ net314 _04131_ VSS VSS VDD VDD _03191_ sky130_fd_sc_hd__nor2_1
X_15277_ net314 _04133_ VSS VSS VDD VDD _03190_ sky130_fd_sc_hd__nor2_1
X_15278_ _04059_ _04133_ VSS VSS VDD VDD _03172_ sky130_fd_sc_hd__nor2_1
X_15279_ _04063_ _04125_ VSS VSS VDD VDD _03167_ sky130_fd_sc_hd__nor2_1
X_15280_ _04125_ _04135_ VSS VSS VDD VDD _03256_ sky130_fd_sc_hd__nor2_1
X_15281_ _04063_ _04111_ VSS VSS VDD VDD _03166_ sky130_fd_sc_hd__nor2_1
X_15282_ _04063_ _04140_ VSS VSS VDD VDD _03165_ sky130_fd_sc_hd__nor2_1
X_15283_ _04063_ _04066_ VSS VSS VDD VDD _03162_ sky130_fd_sc_hd__nor2_1
X_15284_ _04063_ _04113_ VSS VSS VDD VDD _03161_ sky130_fd_sc_hd__nor2_1
X_15285_ net445 _07593_ net405 VSS VSS VDD VDD _04371_ sky130_fd_sc_hd__o21ai_0
X_15286_ net408 net372 _04371_ net435 VSS VSS VDD VDD _04372_
+ sky130_fd_sc_hd__a22oi_1
X_15287_ _07303_ net435 net445 _07593_ VSS VSS VDD VDD _04373_
+ sky130_fd_sc_hd__or4_1
X_15288_ network.neuron_hid0.ROM0.address\[7\] _04372_ _04373_
+ VSS VSS VDD VDD _04374_ sky130_fd_sc_hd__o21ai_0
X_15289_ net397 net334 net432 VSS VSS VDD VDD _04375_ sky130_fd_sc_hd__o21ai_0
X_15290_ net379 _08298_ _04375_ VSS VSS VDD VDD _04376_ sky130_fd_sc_hd__o21ai_0
X_15291_ net450 _07385_ _08184_ _04376_ net445 VSS VSS VDD
+ VDD _04377_ sky130_fd_sc_hd__a32oi_1
X_15292_ _07387_ _08544_ _04377_ net435 VSS VSS VDD VDD _04378_
+ sky130_fd_sc_hd__o22ai_1
X_15293_ net450 net385 _04374_ _04378_ _07702_ VSS VSS VDD
+ VDD _04379_ sky130_fd_sc_hd__a32oi_1
X_15294_ net327 _04379_ VSS VSS VDD VDD _01759_ sky130_fd_sc_hd__nor2_1
X_15295_ _04117_ _04135_ VSS VSS VDD VDD _03249_ sky130_fd_sc_hd__nor2_1
X_15296_ _04063_ _04131_ VSS VSS VDD VDD _03156_ sky130_fd_sc_hd__nor2_1
X_15297_ _04070_ _04135_ VSS VSS VDD VDD _03246_ sky130_fd_sc_hd__nor2_1
X_15298_ _04072_ _04127_ VSS VSS VDD VDD _03150_ sky130_fd_sc_hd__nor2_1
X_15299_ _04059_ _04117_ VSS VSS VDD VDD _03178_ sky130_fd_sc_hd__nor2_1
X_15300_ _04066_ _04217_ VSS VSS VDD VDD _03294_ sky130_fd_sc_hd__nor2_1
X_15301_ _04059_ _04122_ VSS VSS VDD VDD _03177_ sky130_fd_sc_hd__nor2_1
X_15302_ _04113_ _04217_ VSS VSS VDD VDD _03293_ sky130_fd_sc_hd__nor2_1
X_15303_ _04117_ _04217_ VSS VSS VDD VDD _03292_ sky130_fd_sc_hd__nor2_1
X_15304_ network.in_period\[59\]\[1\] _04331_ VSS VSS VDD
+ VDD _04380_ sky130_fd_sc_hd__nand2_1
X_15305_ _00238_ _04331_ _04380_ VSS VSS VDD VDD _02300_ sky130_fd_sc_hd__o21ai_0
X_15306_ _04122_ _04217_ VSS VSS VDD VDD _03291_ sky130_fd_sc_hd__nor2_1
X_15307_ net314 _04140_ VSS VSS VDD VDD _03201_ sky130_fd_sc_hd__nor2_1
X_15308_ _04063_ _04115_ VSS VSS VDD VDD _03163_ sky130_fd_sc_hd__nor2_1
X_15309_ _04063_ _04070_ VSS VSS VDD VDD _03157_ sky130_fd_sc_hd__nor2_1
X_15310_ _08790_ _04074_ VSS VSS VDD VDD _03284_ sky130_fd_sc_hd__nor2_1
Xplace477 net481 VSS VSS VDD VDD net476 sky130_fd_sc_hd__buf_4
X_15312_ network.neuron_in060.counter\[3\] network.in_period\[60\]\[2\]
+ net422 _00211_ VSS VSS VDD VDD _04382_ sky130_fd_sc_hd__o22ai_1
X_15313_ network.neuron_in060.counter\[2\] _00211_ net349
+ VSS VSS VDD VDD _04383_ sky130_fd_sc_hd__nand3_1
X_15314_ network.in_period\[60\]\[2\] net349 _04383_ VSS VSS
+ VDD VDD _04384_ sky130_fd_sc_hd__o21ai_0
X_15315_ _04323_ _04382_ _04384_ VSS VSS VDD VDD _02305_ sky130_fd_sc_hd__a21oi_1
X_15316_ network.in_period\[57\]\[0\] _04275_ VSS VSS VDD
+ VDD _04385_ sky130_fd_sc_hd__nand2_1
X_15317_ network.neuron_in057.counter\[0\] _04275_ _04385_
+ VSS VSS VDD VDD _02291_ sky130_fd_sc_hd__o21ai_0
X_15318_ network.neuron_in058.counter\[3\] network.in_period\[58\]\[2\]
+ net418 _00245_ VSS VSS VDD VDD _04386_ sky130_fd_sc_hd__o22ai_1
X_15319_ network.neuron_in058.counter\[2\] _00245_ net350
+ VSS VSS VDD VDD _04387_ sky130_fd_sc_hd__nand3_1
X_15320_ network.in_period\[58\]\[2\] net350 _04387_ VSS VSS
+ VDD VDD _04388_ sky130_fd_sc_hd__o21ai_0
X_15321_ _04367_ _04386_ _04388_ VSS VSS VDD VDD _02297_ sky130_fd_sc_hd__a21oi_1
X_15322_ network.in_period\[58\]\[0\] _04369_ VSS VSS VDD
+ VDD _04389_ sky130_fd_sc_hd__nand2_1
X_15323_ network.neuron_in058.counter\[0\] _04369_ _04389_
+ VSS VSS VDD VDD _02295_ sky130_fd_sc_hd__o21ai_0
X_15324_ network.neuron_in149.counter\[2\] network.neuron_in149.counter\[3\]
+ VSS VSS VDD VDD _04390_ sky130_fd_sc_hd__nor2_1
X_15325_ _00585_ _04390_ VSS VSS VDD VDD _04391_ sky130_fd_sc_hd__nand2_1
X_15326_ net346 _04391_ VSS VSS VDD VDD _04392_ sky130_fd_sc_hd__nand2_1
X_15327_ network.in_period\[149\]\[0\] _04392_ VSS VSS VDD
+ VDD _04393_ sky130_fd_sc_hd__nand2_1
X_15328_ network.neuron_in149.counter\[0\] _04392_ _04393_
+ VSS VSS VDD VDD _02659_ sky130_fd_sc_hd__o21ai_0
X_15329_ network.neuron_in059.counter\[3\] network.in_period\[59\]\[2\]
+ net418 _00237_ VSS VSS VDD VDD _04394_ sky130_fd_sc_hd__o22ai_1
X_15330_ network.neuron_in059.counter\[2\] _00237_ net350
+ VSS VSS VDD VDD _04395_ sky130_fd_sc_hd__nand3_1
X_15331_ network.in_period\[59\]\[2\] net350 _04395_ VSS VSS
+ VDD VDD _04396_ sky130_fd_sc_hd__o21ai_0
X_15332_ _04328_ _04394_ _04396_ VSS VSS VDD VDD _02301_ sky130_fd_sc_hd__a21oi_1
X_15333_ net315 _04133_ VSS VSS VDD VDD _03208_ sky130_fd_sc_hd__nor2_1
X_15334_ net331 net314 VSS VSS VDD VDD _03189_ sky130_fd_sc_hd__nor2_1
X_15335_ _04135_ _04140_ VSS VSS VDD VDD _03254_ sky130_fd_sc_hd__nor2_1
X_15336_ network.neuron_in064.counter\[0\] VSS VSS VDD VDD
+ _00201_ sky130_fd_sc_hd__inv_1
X_15337_ network.neuron_in064.counter\[2\] VSS VSS VDD VDD
+ _04397_ sky130_fd_sc_hd__inv_1
X_15338_ _04397_ _00203_ VSS VSS VDD VDD _04398_ sky130_fd_sc_hd__nand2_1
X_15339_ network.neuron_in064.counter\[3\] _04398_ VSS VSS
+ VDD VDD _04399_ sky130_fd_sc_hd__or2_2
X_15340_ net354 _04399_ VSS VSS VDD VDD _04400_ sky130_fd_sc_hd__nand2_1
X_15341_ network.in_period\[64\]\[0\] _04400_ VSS VSS VDD
+ VDD _04401_ sky130_fd_sc_hd__nand2_1
X_15342_ network.neuron_in064.counter\[0\] _04400_ _04401_
+ VSS VSS VDD VDD _02319_ sky130_fd_sc_hd__o21ai_0
X_15343_ network.neuron_in062.counter\[2\] network.neuron_in062.counter\[3\]
+ VSS VSS VDD VDD _04402_ sky130_fd_sc_hd__nor2_1
X_15344_ _00633_ _04402_ VSS VSS VDD VDD _04403_ sky130_fd_sc_hd__nand2_1
X_15345_ net349 _04403_ VSS VSS VDD VDD _04404_ sky130_fd_sc_hd__nand2_1
X_15346_ network.in_period\[62\]\[1\] _04404_ VSS VSS VDD
+ VDD _04405_ sky130_fd_sc_hd__nand2_1
X_15347_ _00634_ _04404_ _04405_ VSS VSS VDD VDD _02312_ sky130_fd_sc_hd__o21ai_0
X_15348_ _04066_ _04127_ VSS VSS VDD VDD _03145_ sky130_fd_sc_hd__nor2_1
X_15349_ _04074_ _04111_ VSS VSS VDD VDD _03280_ sky130_fd_sc_hd__nor2_1
X_15350_ _04072_ _04106_ VSS VSS VDD VDD _03239_ sky130_fd_sc_hd__nor2_1
X_15351_ _04122_ _04127_ VSS VSS VDD VDD _03141_ sky130_fd_sc_hd__nor2_1
X_15352_ _04106_ _04125_ VSS VSS VDD VDD _03238_ sky130_fd_sc_hd__nor2_1
X_15353_ _04055_ _04127_ VSS VSS VDD VDD _03140_ sky130_fd_sc_hd__nor2_1
X_15354_ _04070_ _04127_ VSS VSS VDD VDD _03139_ sky130_fd_sc_hd__nor2_1
X_15355_ _04127_ _04131_ VSS VSS VDD VDD _03138_ sky130_fd_sc_hd__nor2_1
X_15356_ _04127_ _04133_ VSS VSS VDD VDD _03137_ sky130_fd_sc_hd__nor2_1
X_15357_ _04106_ _04113_ VSS VSS VDD VDD _03233_ sky130_fd_sc_hd__nor2_1
X_15358_ net331 _04127_ VSS VSS VDD VDD _03136_ sky130_fd_sc_hd__nor2_1
X_15359_ _08790_ _04129_ VSS VSS VDD VDD _03135_ sky130_fd_sc_hd__nor2_1
X_15360_ _04068_ _04129_ VSS VSS VDD VDD _03134_ sky130_fd_sc_hd__nor2_1
X_15361_ _04072_ _04129_ VSS VSS VDD VDD _03133_ sky130_fd_sc_hd__nor2_1
X_15362_ _04068_ net315 VSS VSS VDD VDD _03223_ sky130_fd_sc_hd__nor2_1
X_15363_ _04125_ _04129_ VSS VSS VDD VDD _03132_ sky130_fd_sc_hd__nor2_1
X_15364_ _04111_ _04129_ VSS VSS VDD VDD _03130_ sky130_fd_sc_hd__nor2_1
X_15365_ _04106_ _04140_ VSS VSS VDD VDD _03236_ sky130_fd_sc_hd__nor2_1
X_15366_ _04129_ _04140_ VSS VSS VDD VDD _03129_ sky130_fd_sc_hd__nor2_1
X_15367_ net315 _04140_ VSS VSS VDD VDD _03218_ sky130_fd_sc_hd__nor2_1
X_15368_ _04115_ _04129_ VSS VSS VDD VDD _03128_ sky130_fd_sc_hd__nor2_1
X_15369_ _04066_ _04129_ VSS VSS VDD VDD _03127_ sky130_fd_sc_hd__nor2_1
X_15370_ _04113_ _04129_ VSS VSS VDD VDD _03126_ sky130_fd_sc_hd__nor2_1
X_15371_ _04117_ _04129_ VSS VSS VDD VDD _03125_ sky130_fd_sc_hd__nor2_1
X_15372_ _04122_ _04129_ VSS VSS VDD VDD _03124_ sky130_fd_sc_hd__nor2_1
X_15373_ net331 _04059_ VSS VSS VDD VDD _03171_ sky130_fd_sc_hd__nor2_1
X_15374_ _04070_ _04217_ VSS VSS VDD VDD _03289_ sky130_fd_sc_hd__nor2_1
X_15375_ _04131_ _04217_ VSS VSS VDD VDD _03288_ sky130_fd_sc_hd__nor2_1
X_15376_ _04133_ _04217_ VSS VSS VDD VDD _03286_ sky130_fd_sc_hd__nor2_1
X_15377_ _04072_ net313 VSS VSS VDD VDD _03115_ sky130_fd_sc_hd__nor2_1
X_15378_ network.in_period\[64\]\[1\] _04400_ VSS VSS VDD
+ VDD _04406_ sky130_fd_sc_hd__nand2_1
X_15379_ _00204_ _04400_ _04406_ VSS VSS VDD VDD _02320_ sky130_fd_sc_hd__o21ai_0
X_15380_ network.in_period\[149\]\[1\] _04392_ VSS VSS VDD
+ VDD _04407_ sky130_fd_sc_hd__nand2_1
X_15381_ _00586_ _04392_ _04407_ VSS VSS VDD VDD _02660_ sky130_fd_sc_hd__o21ai_0
X_15382_ _04068_ net312 VSS VSS VDD VDD _03336_ sky130_fd_sc_hd__nor2_1
X_15383_ network.neuron_out0.ROM0.address\[1\] _08445_ _08449_
+ VSS VSS VDD VDD _01761_ sky130_fd_sc_hd__a21oi_1
X_15384_ _08461_ _01761_ VSS VSS VDD VDD _01760_ sky130_fd_sc_hd__and2_1
X_15385_ _04111_ net312 VSS VSS VDD VDD _03333_ sky130_fd_sc_hd__nor2_1
X_15386_ _04140_ net312 VSS VSS VDD VDD _03332_ sky130_fd_sc_hd__nor2_1
X_15387_ network.neuron_in062.counter\[2\] VSS VSS VDD VDD
+ _04408_ sky130_fd_sc_hd__inv_1
X_15388_ network.neuron_in062.counter\[3\] network.in_period\[62\]\[2\]
+ _00633_ net422 VSS VSS VDD VDD _04409_ sky130_fd_sc_hd__o22ai_1
Xplace476 net476 VSS VSS VDD VDD net475 sky130_fd_sc_hd__buf_4
X_15390_ network.neuron_in062.counter\[2\] _00633_ net349
+ VSS VSS VDD VDD _04411_ sky130_fd_sc_hd__nand3_1
X_15391_ network.in_period\[62\]\[2\] net349 _04411_ VSS VSS
+ VDD VDD _04412_ sky130_fd_sc_hd__o21ai_0
X_15392_ _04408_ _04409_ _04412_ VSS VSS VDD VDD _02313_ sky130_fd_sc_hd__a21oi_1
X_15393_ network.neuron_in063.counter\[2\] VSS VSS VDD VDD
+ _04413_ sky130_fd_sc_hd__inv_1
X_15394_ network.neuron_in063.counter\[3\] network.in_period\[63\]\[2\]
+ net418 _00207_ VSS VSS VDD VDD _04414_ sky130_fd_sc_hd__o22ai_1
X_15395_ network.neuron_in063.counter\[2\] _00207_ net350
+ VSS VSS VDD VDD _04415_ sky130_fd_sc_hd__nand3_1
X_15396_ network.in_period\[63\]\[2\] net350 _04415_ VSS VSS
+ VDD VDD _04416_ sky130_fd_sc_hd__o21ai_0
X_15397_ _04413_ _04414_ _04416_ VSS VSS VDD VDD _02317_ sky130_fd_sc_hd__a21oi_1
X_15398_ network.neuron_in064.counter\[3\] network.in_period\[64\]\[2\]
+ _00203_ net420 VSS VSS VDD VDD _04417_ sky130_fd_sc_hd__o22ai_1
X_15399_ network.neuron_in064.counter\[2\] _00203_ net354
+ VSS VSS VDD VDD _04418_ sky130_fd_sc_hd__nand3_1
X_15400_ network.in_period\[64\]\[2\] net354 _04418_ VSS VSS
+ VDD VDD _04419_ sky130_fd_sc_hd__o21ai_0
X_15401_ _04397_ _04417_ _04419_ VSS VSS VDD VDD _02321_ sky130_fd_sc_hd__a21oi_1
X_15402_ network.neuron_in061.counter\[2\] network.neuron_in061.counter\[3\]
+ VSS VSS VDD VDD _04420_ sky130_fd_sc_hd__nor2_1
X_15403_ _00637_ _04420_ VSS VSS VDD VDD _04421_ sky130_fd_sc_hd__nand2_1
X_15404_ net350 _04421_ VSS VSS VDD VDD _04422_ sky130_fd_sc_hd__nand2_1
X_15405_ network.in_period\[61\]\[0\] _04422_ VSS VSS VDD
+ VDD _04423_ sky130_fd_sc_hd__nand2_1
X_15406_ network.neuron_in061.counter\[0\] _04422_ _04423_
+ VSS VSS VDD VDD _02307_ sky130_fd_sc_hd__o21ai_0
X_15407_ network.neuron_in061.counter\[2\] VSS VSS VDD VDD
+ _04424_ sky130_fd_sc_hd__inv_1
X_15408_ network.neuron_in061.counter\[3\] network.in_period\[61\]\[2\]
+ _00637_ net418 VSS VSS VDD VDD _04425_ sky130_fd_sc_hd__o22ai_1
X_15409_ network.neuron_in061.counter\[2\] _00637_ net350
+ VSS VSS VDD VDD _04426_ sky130_fd_sc_hd__nand3_1
X_15410_ network.in_period\[61\]\[2\] net350 _04426_ VSS VSS
+ VDD VDD _04427_ sky130_fd_sc_hd__o21ai_0
X_15411_ _04424_ _04425_ _04427_ VSS VSS VDD VDD _02309_ sky130_fd_sc_hd__a21oi_1
X_15412_ network.in_period\[61\]\[1\] _04422_ VSS VSS VDD
+ VDD _04428_ sky130_fd_sc_hd__nand2_1
X_15413_ _00638_ _04422_ _04428_ VSS VSS VDD VDD _02308_ sky130_fd_sc_hd__o21ai_0
X_15414_ _04125_ _04209_ VSS VSS VDD VDD _03096_ sky130_fd_sc_hd__nor2_1
X_15415_ _04055_ net312 VSS VSS VDD VDD _03325_ sky130_fd_sc_hd__nor2_1
X_15416_ _04070_ net312 VSS VSS VDD VDD _03324_ sky130_fd_sc_hd__nor2_1
X_15417_ network.in_period\[62\]\[0\] _04404_ VSS VSS VDD
+ VDD _04429_ sky130_fd_sc_hd__nand2_1
X_15418_ network.neuron_in062.counter\[0\] _04404_ _04429_
+ VSS VSS VDD VDD _02311_ sky130_fd_sc_hd__o21ai_0
X_15419_ _04059_ _04131_ VSS VSS VDD VDD _03173_ sky130_fd_sc_hd__nor2_1
X_15420_ _04072_ _04074_ VSS VSS VDD VDD _03282_ sky130_fd_sc_hd__nor2_1
X_15421_ _04074_ _04125_ VSS VSS VDD VDD _03281_ sky130_fd_sc_hd__nor2_1
X_15422_ _04133_ net312 VSS VSS VDD VDD _03322_ sky130_fd_sc_hd__nor2_1
X_15423_ net331 net312 VSS VSS VDD VDD _03321_ sky130_fd_sc_hd__nor2_1
X_15424_ _04074_ _04140_ VSS VSS VDD VDD _03279_ sky130_fd_sc_hd__nor2_1
X_15425_ _04074_ _04115_ VSS VSS VDD VDD _03278_ sky130_fd_sc_hd__nor2_1
X_15426_ _04125_ net312 VSS VSS VDD VDD _03334_ sky130_fd_sc_hd__nor2_1
X_15427_ _04066_ net312 VSS VSS VDD VDD _03329_ sky130_fd_sc_hd__nor2_1
X_15428_ _04113_ net312 VSS VSS VDD VDD _03328_ sky130_fd_sc_hd__nor2_1
X_15429_ _04117_ net312 VSS VSS VDD VDD _03327_ sky130_fd_sc_hd__nor2_1
X_15430_ _04122_ net312 VSS VSS VDD VDD _03326_ sky130_fd_sc_hd__nor2_1
X_15431_ _04131_ net312 VSS VSS VDD VDD _03323_ sky130_fd_sc_hd__nor2_1
X_15432_ _04119_ net452 VSS VSS VDD VDD _04430_ sky130_fd_sc_hd__nand2_1
Xplace475 net19 VSS VSS VDD VDD net474 sky130_fd_sc_hd__buf_4
X_15434_ _08790_ _04430_ VSS VSS VDD VDD _03319_ sky130_fd_sc_hd__nor2_1
X_15435_ _08439_ _08446_ VSS VSS VDD VDD _01762_ sky130_fd_sc_hd__nor2_1
X_15436_ _04125_ _04430_ VSS VSS VDD VDD _03316_ sky130_fd_sc_hd__nor2_1
X_15437_ _04413_ _00207_ VSS VSS VDD VDD _04432_ sky130_fd_sc_hd__nand2_1
X_15438_ network.neuron_in063.counter\[3\] _04432_ VSS VSS
+ VDD VDD _04433_ sky130_fd_sc_hd__or2_2
X_15439_ net350 _04433_ VSS VSS VDD VDD _04434_ sky130_fd_sc_hd__nand2_1
X_15440_ network.in_period\[63\]\[1\] _04434_ VSS VSS VDD
+ VDD _04435_ sky130_fd_sc_hd__nand2_1
X_15441_ _00208_ _04434_ _04435_ VSS VSS VDD VDD _02316_ sky130_fd_sc_hd__o21ai_0
X_15442_ network.neuron_in063.counter\[0\] VSS VSS VDD VDD
+ _00205_ sky130_fd_sc_hd__inv_1
X_15443_ network.in_period\[63\]\[0\] _04434_ VSS VSS VDD
+ VDD _04436_ sky130_fd_sc_hd__nand2_1
X_15444_ network.neuron_in063.counter\[0\] _04434_ _04436_
+ VSS VSS VDD VDD _02315_ sky130_fd_sc_hd__o21ai_0
X_15445_ network.neuron_in067.counter\[2\] _00187_ VSS VSS
+ VDD VDD _04437_ sky130_fd_sc_hd__nand2b_1
X_15446_ network.neuron_in067.counter\[3\] _04437_ VSS VSS
+ VDD VDD _04438_ sky130_fd_sc_hd__or2_2
X_15447_ net354 _04438_ VSS VSS VDD VDD _04439_ sky130_fd_sc_hd__nand2_1
X_15448_ network.in_period\[67\]\[0\] _04439_ VSS VSS VDD
+ VDD _04440_ sky130_fd_sc_hd__nand2_1
X_15449_ network.neuron_in067.counter\[0\] _04439_ _04440_
+ VSS VSS VDD VDD _02331_ sky130_fd_sc_hd__o21ai_0
X_15450_ network.in_period\[67\]\[1\] _04439_ VSS VSS VDD
+ VDD _04441_ sky130_fd_sc_hd__nand2_1
X_15451_ _00188_ _04439_ _04441_ VSS VSS VDD VDD _02332_ sky130_fd_sc_hd__o21ai_0
X_15452_ network.neuron_in186.counter\[1\] VSS VSS VDD VDD
+ _01105_ sky130_fd_sc_hd__inv_1
X_15453_ network.neuron_in067.counter\[2\] net354 VSS VSS
+ VDD VDD _04442_ sky130_fd_sc_hd__nand2_1
X_15454_ network.neuron_in067.counter\[3\] network.in_period\[67\]\[2\]
+ _04442_ VSS VSS VDD VDD _04443_ sky130_fd_sc_hd__o21ai_0
X_15455_ _00187_ network.neuron_in067.counter\[2\] net420
+ VSS VSS VDD VDD _04444_ sky130_fd_sc_hd__or3_1
X_15456_ network.in_period\[67\]\[2\] net354 _04444_ VSS VSS
+ VDD VDD _04445_ sky130_fd_sc_hd__o21ai_0
X_15457_ _00187_ _04443_ _04445_ VSS VSS VDD VDD _02333_ sky130_fd_sc_hd__a21oi_1
X_15458_ network.neuron_in065.counter\[2\] VSS VSS VDD VDD
+ _04446_ sky130_fd_sc_hd__inv_1
X_15459_ network.neuron_in065.counter\[3\] network.in_period\[65\]\[2\]
+ _00197_ net420 VSS VSS VDD VDD _04447_ sky130_fd_sc_hd__o22ai_1
Xplace474 net474 VSS VSS VDD VDD net473 sky130_fd_sc_hd__buf_4
X_15461_ network.neuron_in065.counter\[2\] _00197_ net354
+ VSS VSS VDD VDD _04449_ sky130_fd_sc_hd__nand3_1
X_15462_ network.in_period\[65\]\[2\] net354 _04449_ VSS VSS
+ VDD VDD _04450_ sky130_fd_sc_hd__o21ai_0
X_15463_ _04446_ _04447_ _04450_ VSS VSS VDD VDD _02325_ sky130_fd_sc_hd__a21oi_1
X_15464_ network.neuron_in066.counter\[2\] net354 VSS VSS
+ VDD VDD _04451_ sky130_fd_sc_hd__nand2_1
X_15465_ network.neuron_in066.counter\[3\] network.in_period\[66\]\[2\]
+ _04451_ VSS VSS VDD VDD _04452_ sky130_fd_sc_hd__o21ai_0
X_15466_ _00191_ network.neuron_in066.counter\[2\] net420
+ VSS VSS VDD VDD _04453_ sky130_fd_sc_hd__or3_1
X_15467_ network.in_period\[66\]\[2\] net354 _04453_ VSS VSS
+ VDD VDD _04454_ sky130_fd_sc_hd__o21ai_0
X_15468_ _00191_ _04452_ _04454_ VSS VSS VDD VDD _02329_ sky130_fd_sc_hd__a21oi_1
X_15469_ _04446_ _00197_ VSS VSS VDD VDD _04455_ sky130_fd_sc_hd__nand2_1
X_15470_ network.neuron_in065.counter\[3\] _04455_ VSS VSS
+ VDD VDD _04456_ sky130_fd_sc_hd__or2_2
X_15471_ net354 _04456_ VSS VSS VDD VDD _04457_ sky130_fd_sc_hd__nand2_1
X_15472_ network.in_period\[65\]\[1\] _04457_ VSS VSS VDD
+ VDD _04458_ sky130_fd_sc_hd__nand2_1
X_15473_ _00198_ _04457_ _04458_ VSS VSS VDD VDD _02324_ sky130_fd_sc_hd__o21ai_0
X_15474_ network.neuron_in065.counter\[0\] VSS VSS VDD VDD
+ _00195_ sky130_fd_sc_hd__inv_1
X_15475_ network.in_period\[65\]\[0\] _04457_ VSS VSS VDD
+ VDD _04459_ sky130_fd_sc_hd__nand2_1
X_15476_ network.neuron_in065.counter\[0\] _04457_ _04459_
+ VSS VSS VDD VDD _02323_ sky130_fd_sc_hd__o21ai_0
X_15477_ network.neuron_in066.counter\[2\] _00191_ VSS VSS
+ VDD VDD _04460_ sky130_fd_sc_hd__nand2b_1
X_15478_ network.neuron_in066.counter\[3\] _04460_ VSS VSS
+ VDD VDD _04461_ sky130_fd_sc_hd__or2_2
X_15479_ net354 _04461_ VSS VSS VDD VDD _04462_ sky130_fd_sc_hd__nand2_1
X_15480_ network.in_period\[66\]\[1\] _04462_ VSS VSS VDD
+ VDD _04463_ sky130_fd_sc_hd__nand2_1
X_15481_ _00192_ _04462_ _04463_ VSS VSS VDD VDD _02328_ sky130_fd_sc_hd__o21ai_0
X_15482_ network.in_period\[66\]\[0\] _04462_ VSS VSS VDD
+ VDD _04464_ sky130_fd_sc_hd__nand2_1
X_15483_ network.neuron_in066.counter\[0\] _04462_ _04464_
+ VSS VSS VDD VDD _02327_ sky130_fd_sc_hd__o21ai_0
X_15484_ _04059_ _04140_ VSS VSS VDD VDD _03182_ sky130_fd_sc_hd__nor2_1
X_15485_ _04111_ _04217_ VSS VSS VDD VDD _03297_ sky130_fd_sc_hd__nor2_1
X_15486_ _04059_ _04115_ VSS VSS VDD VDD _03181_ sky130_fd_sc_hd__nor2_1
X_15487_ _04140_ _04217_ VSS VSS VDD VDD _03296_ sky130_fd_sc_hd__nor2_1
X_15488_ _04115_ _04217_ VSS VSS VDD VDD _03295_ sky130_fd_sc_hd__nor2_1
X_15489_ _04055_ _04217_ VSS VSS VDD VDD _03290_ sky130_fd_sc_hd__nor2_1
X_15490_ _04066_ _04135_ VSS VSS VDD VDD _03251_ sky130_fd_sc_hd__nor2_1
X_15491_ _07646_ net381 _07944_ _07612_ VSS VSS VDD VDD _04465_
+ sky130_fd_sc_hd__o22ai_1
X_15492_ net447 _07302_ _07702_ _04465_ VSS VSS VDD VDD _01763_
+ sky130_fd_sc_hd__and4_1
X_15493_ _04066_ _04074_ VSS VSS VDD VDD _03277_ sky130_fd_sc_hd__nor2_1
X_15494_ _04066_ _04248_ VSS VSS VDD VDD _03253_ sky130_fd_sc_hd__nor2_1
X_15495_ net442 _07551_ _07416_ VSS VSS VDD VDD _04466_ sky130_fd_sc_hd__o21a_1
X_15496_ net433 net402 net373 VSS VSS VDD VDD _04467_ sky130_fd_sc_hd__nor3_1
X_15497_ net433 _08100_ _04467_ VSS VSS VDD VDD _04468_ sky130_fd_sc_hd__a21oi_1
X_15498_ net433 _04466_ _04468_ net439 VSS VSS VDD VDD _04469_
+ sky130_fd_sc_hd__o22ai_1
X_15499_ _07306_ _04469_ VSS VSS VDD VDD _04470_ sky130_fd_sc_hd__nand2_1
X_15500_ net429 net394 _08314_ _07329_ VSS VSS VDD VDD _04471_
+ sky130_fd_sc_hd__a22oi_1
X_15501_ net440 _07644_ net429 VSS VSS VDD VDD _04472_ sky130_fd_sc_hd__o21ai_0
X_15502_ _08023_ _04472_ VSS VSS VDD VDD _04473_ sky130_fd_sc_hd__nand2_1
X_15503_ net429 _07984_ VSS VSS VDD VDD _04474_ sky130_fd_sc_hd__nor2_1
X_15504_ net440 _04474_ net449 VSS VSS VDD VDD _04475_ sky130_fd_sc_hd__o21ai_0
X_15505_ net449 _04473_ _04475_ VSS VSS VDD VDD _04476_ sky130_fd_sc_hd__o21ai_0
X_15506_ net442 _04471_ _04476_ VSS VSS VDD VDD _04477_ sky130_fd_sc_hd__o21ai_0
X_15507_ net402 net440 net394 _07533_ VSS VSS VDD VDD _04478_
+ sky130_fd_sc_hd__o31ai_1
X_15508_ net403 _07422_ _08184_ _07342_ net430 _04478_ VSS
+ VSS VDD VDD _04479_ sky130_fd_sc_hd__a222oi_1
X_15509_ net433 _04479_ VSS VSS VDD VDD _04480_ sky130_fd_sc_hd__nor2_1
X_15510_ net429 net410 _07937_ VSS VSS VDD VDD _04481_ sky130_fd_sc_hd__a21oi_1
X_15511_ net442 _04481_ net427 VSS VSS VDD VDD _04482_ sky130_fd_sc_hd__o21ai_0
X_15512_ net433 _04477_ _04480_ _04482_ VSS VSS VDD VDD _04483_
+ sky130_fd_sc_hd__a211oi_1
X_15513_ net404 _08481_ net437 VSS VSS VDD VDD _04484_ sky130_fd_sc_hd__o21ai_0
X_15514_ _07477_ _04484_ net442 VSS VSS VDD VDD _04485_ sky130_fd_sc_hd__a21oi_1
X_15515_ net429 _08531_ net386 VSS VSS VDD VDD _04486_ sky130_fd_sc_hd__a21oi_1
X_15516_ net436 net338 net337 VSS VSS VDD VDD _04487_ sky130_fd_sc_hd__nor3_1
X_15517_ net436 _07429_ _07958_ _04487_ VSS VSS VDD VDD _04488_
+ sky130_fd_sc_hd__a31oi_1
X_15518_ net427 _04485_ _04486_ _04488_ VSS VSS VDD VDD _04489_
+ sky130_fd_sc_hd__nor4_1
X_15519_ net449 _07965_ _08104_ net427 net429 VSS VSS VDD
+ VDD _04490_ sky130_fd_sc_hd__a2111oi_0
X_15520_ net442 net446 net391 net410 VSS VSS VDD VDD _04491_
+ sky130_fd_sc_hd__nor4_1
X_15521_ net442 _08061_ _04491_ _07698_ net427 VSS VSS VDD
+ VDD _04492_ sky130_fd_sc_hd__a2111oi_0
X_15522_ _04483_ _04489_ _04490_ _04492_ _07303_ VSS VSS VDD
+ VDD _04493_ sky130_fd_sc_hd__o41ai_1
X_15523_ _04470_ _04493_ net327 VSS VSS VDD VDD _01764_ sky130_fd_sc_hd__a21oi_1
X_15524_ _04131_ _04248_ VSS VSS VDD VDD _03186_ sky130_fd_sc_hd__nor2_1
X_15525_ net331 _04248_ VSS VSS VDD VDD _03164_ sky130_fd_sc_hd__nor2_1
X_15526_ _04068_ _04135_ VSS VSS VDD VDD _03258_ sky130_fd_sc_hd__nor2_1
X_15527_ _08790_ _04270_ VSS VSS VDD VDD _03153_ sky130_fd_sc_hd__nor2_1
X_15528_ _04068_ _04270_ VSS VSS VDD VDD _03142_ sky130_fd_sc_hd__nor2_1
X_15529_ _04072_ _04270_ VSS VSS VDD VDD _03131_ sky130_fd_sc_hd__nor2_1
X_15530_ _04125_ _04270_ VSS VSS VDD VDD _03120_ sky130_fd_sc_hd__nor2_1
X_15531_ network.neuron_in068.counter\[2\] VSS VSS VDD VDD
+ _04494_ sky130_fd_sc_hd__inv_1
X_15532_ _04494_ _00174_ VSS VSS VDD VDD _04495_ sky130_fd_sc_hd__nand2_1
X_15533_ network.neuron_in068.counter\[3\] _04495_ VSS VSS
+ VDD VDD _04496_ sky130_fd_sc_hd__or2_2
X_15534_ net355 _04496_ VSS VSS VDD VDD _04497_ sky130_fd_sc_hd__nand2_1
X_15535_ network.in_period\[68\]\[1\] _04497_ VSS VSS VDD
+ VDD _04498_ sky130_fd_sc_hd__nand2_1
X_15536_ _00175_ _04497_ _04498_ VSS VSS VDD VDD _02336_ sky130_fd_sc_hd__o21ai_0
X_15537_ _04111_ _04270_ VSS VSS VDD VDD _03109_ sky130_fd_sc_hd__nor2_1
X_15538_ _04140_ _04270_ VSS VSS VDD VDD _03098_ sky130_fd_sc_hd__nor2_1
X_15539_ _04115_ _04270_ VSS VSS VDD VDD _03342_ sky130_fd_sc_hd__nor2_1
X_15540_ _04066_ _04270_ VSS VSS VDD VDD _03331_ sky130_fd_sc_hd__nor2_1
X_15541_ network.neuron_in068.counter\[3\] network.in_period\[68\]\[2\]
+ net411 _00174_ VSS VSS VDD VDD _04499_ sky130_fd_sc_hd__o22ai_1
X_15542_ network.neuron_in068.counter\[2\] _00174_ net355
+ VSS VSS VDD VDD _04500_ sky130_fd_sc_hd__nand3_1
X_15543_ network.in_period\[68\]\[2\] net355 _04500_ VSS VSS
+ VDD VDD _04501_ sky130_fd_sc_hd__o21ai_0
X_15544_ _04494_ _04499_ _04501_ VSS VSS VDD VDD _02337_ sky130_fd_sc_hd__a21oi_1
X_15545_ _04117_ _04270_ VSS VSS VDD VDD _03309_ sky130_fd_sc_hd__nor2_1
X_15546_ _04122_ _04270_ VSS VSS VDD VDD _03298_ sky130_fd_sc_hd__nor2_1
X_15547_ _04055_ _04270_ VSS VSS VDD VDD _03287_ sky130_fd_sc_hd__nor2_1
Xplace471 net474 VSS VSS VDD VDD net470 sky130_fd_sc_hd__buf_4
X_15549_ network.neuron_in069.counter\[2\] VSS VSS VDD VDD
+ _04503_ sky130_fd_sc_hd__inv_1
X_15550_ network.neuron_in069.counter\[3\] VSS VSS VDD VDD
+ _04504_ sky130_fd_sc_hd__inv_1
X_15551_ _04503_ _00170_ _04504_ VSS VSS VDD VDD _04505_ sky130_fd_sc_hd__nand3_1
X_15552_ net355 _04505_ VSS VSS VDD VDD _04506_ sky130_fd_sc_hd__nand2_1
X_15553_ network.in_period\[69\]\[1\] _04506_ VSS VSS VDD
+ VDD _04507_ sky130_fd_sc_hd__nand2_1
X_15554_ _00171_ _04506_ _04507_ VSS VSS VDD VDD _02340_ sky130_fd_sc_hd__o21ai_0
X_15555_ _04131_ _04270_ VSS VSS VDD VDD _03265_ sky130_fd_sc_hd__nor2_1
X_15556_ _04072_ _04430_ VSS VSS VDD VDD _03317_ sky130_fd_sc_hd__nor2_1
X_15557_ _04111_ _04430_ VSS VSS VDD VDD _03315_ sky130_fd_sc_hd__nor2_1
X_15558_ _04140_ _04430_ VSS VSS VDD VDD _03314_ sky130_fd_sc_hd__nor2_1
X_15559_ network.neuron_in070.counter\[2\] VSS VSS VDD VDD
+ _04508_ sky130_fd_sc_hd__inv_1
X_15560_ network.neuron_in070.counter\[3\] VSS VSS VDD VDD
+ _04509_ sky130_fd_sc_hd__inv_1
X_15561_ _04508_ _00164_ _04509_ VSS VSS VDD VDD _04510_ sky130_fd_sc_hd__nand3_1
X_15562_ net356 _04510_ VSS VSS VDD VDD _04511_ sky130_fd_sc_hd__nand2_1
X_15563_ network.in_period\[70\]\[0\] _04511_ VSS VSS VDD
+ VDD _04512_ sky130_fd_sc_hd__nand2_1
X_15564_ network.neuron_in070.counter\[0\] _04511_ _04512_
+ VSS VSS VDD VDD _02343_ sky130_fd_sc_hd__o21ai_0
X_15565_ _04115_ _04430_ VSS VSS VDD VDD _03313_ sky130_fd_sc_hd__nor2_1
X_15566_ _04066_ _04430_ VSS VSS VDD VDD _03312_ sky130_fd_sc_hd__nor2_1
X_15567_ _08449_ _08459_ VSS VSS VDD VDD _01765_ sky130_fd_sc_hd__nor2_1
X_15568_ _04113_ _04430_ VSS VSS VDD VDD _03311_ sky130_fd_sc_hd__nor2_1
X_15569_ _04117_ _04430_ VSS VSS VDD VDD _03310_ sky130_fd_sc_hd__nor2_1
X_15570_ _04122_ _04430_ VSS VSS VDD VDD _03308_ sky130_fd_sc_hd__nor2_1
X_15571_ _04055_ _04430_ VSS VSS VDD VDD _03307_ sky130_fd_sc_hd__nor2_1
X_15572_ _04070_ _04430_ VSS VSS VDD VDD _03306_ sky130_fd_sc_hd__nor2_1
X_15573_ _04131_ _04430_ VSS VSS VDD VDD _03305_ sky130_fd_sc_hd__nor2_1
X_15574_ _04133_ _04430_ VSS VSS VDD VDD _03304_ sky130_fd_sc_hd__nor2_1
X_15575_ _08439_ _08447_ VSS VSS VDD VDD _01766_ sky130_fd_sc_hd__nor2_1
X_15576_ net331 _04430_ VSS VSS VDD VDD _03303_ sky130_fd_sc_hd__nor2_1
X_15577_ _04059_ _04125_ VSS VSS VDD VDD _03184_ sky130_fd_sc_hd__nor2_1
X_15578_ _08790_ _04217_ VSS VSS VDD VDD _03302_ sky130_fd_sc_hd__nor2_1
X_15579_ _04068_ _04217_ VSS VSS VDD VDD _03301_ sky130_fd_sc_hd__nor2_1
X_15580_ _04072_ _04217_ VSS VSS VDD VDD _03300_ sky130_fd_sc_hd__nor2_1
X_15581_ _04059_ _04111_ VSS VSS VDD VDD _03183_ sky130_fd_sc_hd__nor2_1
X_15582_ network.in_period\[68\]\[0\] _04497_ VSS VSS VDD
+ VDD _04513_ sky130_fd_sc_hd__nand2_1
X_15583_ network.neuron_in068.counter\[0\] _04497_ _04513_
+ VSS VSS VDD VDD _02335_ sky130_fd_sc_hd__o21ai_0
X_15584_ network.neuron_in069.counter\[3\] network.in_period\[69\]\[2\]
+ net411 _00170_ VSS VSS VDD VDD _04514_ sky130_fd_sc_hd__o22ai_1
X_15585_ network.neuron_in069.counter\[2\] _00170_ net355
+ VSS VSS VDD VDD _04515_ sky130_fd_sc_hd__nand3_1
X_15586_ network.in_period\[69\]\[2\] net355 _04515_ VSS VSS
+ VDD VDD _04516_ sky130_fd_sc_hd__o21ai_0
X_15587_ _04503_ _04514_ _04516_ VSS VSS VDD VDD _02341_ sky130_fd_sc_hd__a21oi_1
X_15588_ network.in_period\[69\]\[0\] _04506_ VSS VSS VDD
+ VDD _04517_ sky130_fd_sc_hd__nand2_1
X_15589_ network.neuron_in069.counter\[0\] _04506_ _04517_
+ VSS VSS VDD VDD _02339_ sky130_fd_sc_hd__o21ai_0
X_15590_ network.neuron_in070.counter\[3\] network.in_period\[70\]\[2\]
+ net411 _00164_ VSS VSS VDD VDD _04518_ sky130_fd_sc_hd__o22ai_1
X_15591_ network.neuron_in070.counter\[2\] _00164_ net356
+ VSS VSS VDD VDD _04519_ sky130_fd_sc_hd__nand3_1
X_15592_ network.in_period\[70\]\[2\] net356 _04519_ VSS VSS
+ VDD VDD _04520_ sky130_fd_sc_hd__o21ai_0
X_15593_ _04508_ _04518_ _04520_ VSS VSS VDD VDD _02345_ sky130_fd_sc_hd__a21oi_1
X_15594_ network.in_period\[70\]\[1\] _04511_ VSS VSS VDD
+ VDD _04521_ sky130_fd_sc_hd__nand2_1
X_15595_ _00165_ _04511_ _04521_ VSS VSS VDD VDD _02344_ sky130_fd_sc_hd__o21ai_0
X_15596_ network.neuron_in074.counter\[3\] _00128_ VSS VSS
+ VDD VDD _04522_ sky130_fd_sc_hd__nand2b_1
X_15597_ network.neuron_in074.counter\[2\] VSS VSS VDD VDD
+ _04523_ sky130_fd_sc_hd__inv_1
X_15598_ _04522_ _04523_ VSS VSS VDD VDD _04524_ sky130_fd_sc_hd__nand2b_1
X_15599_ net355 _04524_ VSS VSS VDD VDD _04525_ sky130_fd_sc_hd__nand2_1
X_15600_ network.in_period\[74\]\[0\] _04525_ VSS VSS VDD
+ VDD _04526_ sky130_fd_sc_hd__nand2_1
X_15601_ network.neuron_in074.counter\[0\] _04525_ _04526_
+ VSS VSS VDD VDD _02359_ sky130_fd_sc_hd__o21ai_0
X_15602_ network.neuron_in072.counter\[2\] VSS VSS VDD VDD
+ _04527_ sky130_fd_sc_hd__inv_1
X_15603_ _04527_ _00229_ VSS VSS VDD VDD _04528_ sky130_fd_sc_hd__nand2_1
X_15604_ network.neuron_in072.counter\[3\] _04528_ VSS VSS
+ VDD VDD _04529_ sky130_fd_sc_hd__or2_2
X_15605_ net355 _04529_ VSS VSS VDD VDD _04530_ sky130_fd_sc_hd__nand2_1
X_15606_ network.in_period\[72\]\[0\] _04530_ VSS VSS VDD
+ VDD _04531_ sky130_fd_sc_hd__nand2_1
X_15607_ network.neuron_in072.counter\[0\] _04530_ _04531_
+ VSS VSS VDD VDD _02351_ sky130_fd_sc_hd__o21ai_0
X_15608_ network.in_period\[74\]\[1\] _04525_ VSS VSS VDD
+ VDD _04532_ sky130_fd_sc_hd__nand2_1
X_15609_ _00129_ _04525_ _04532_ VSS VSS VDD VDD _02360_ sky130_fd_sc_hd__o21ai_0
X_15610_ network.neuron_in071.counter\[3\] _00149_ VSS VSS
+ VDD VDD _04533_ sky130_fd_sc_hd__nand2b_1
X_15611_ network.neuron_in071.counter\[2\] VSS VSS VDD VDD
+ _04534_ sky130_fd_sc_hd__inv_1
X_15612_ _04533_ _04534_ VSS VSS VDD VDD _04535_ sky130_fd_sc_hd__nand2b_1
X_15613_ net354 _04535_ VSS VSS VDD VDD _04536_ sky130_fd_sc_hd__nand2_1
X_15614_ network.in_period\[71\]\[0\] _04536_ VSS VSS VDD
+ VDD _04537_ sky130_fd_sc_hd__nand2_1
X_15615_ network.neuron_in071.counter\[0\] _04536_ _04537_
+ VSS VSS VDD VDD _02347_ sky130_fd_sc_hd__o21ai_0
X_15616_ network.in_period\[72\]\[1\] _04530_ VSS VSS VDD
+ VDD _04538_ sky130_fd_sc_hd__nand2_1
X_15617_ _00230_ _04530_ _04538_ VSS VSS VDD VDD _02352_ sky130_fd_sc_hd__o21ai_0
Xplace470 net474 VSS VSS VDD VDD net469 sky130_fd_sc_hd__buf_4
X_15619_ network.neuron_in073.counter\[3\] _00139_ VSS VSS
+ VDD VDD _04540_ sky130_fd_sc_hd__nand2b_1
X_15620_ network.neuron_in073.counter\[2\] VSS VSS VDD VDD
+ _04541_ sky130_fd_sc_hd__inv_1
X_15621_ _04540_ _04541_ VSS VSS VDD VDD _04542_ sky130_fd_sc_hd__nand2b_1
X_15622_ net355 _04542_ VSS VSS VDD VDD _04543_ sky130_fd_sc_hd__nand2_1
X_15623_ network.in_period\[73\]\[0\] _04543_ VSS VSS VDD
+ VDD _04544_ sky130_fd_sc_hd__nand2_1
X_15624_ network.neuron_in073.counter\[0\] _04543_ _04544_
+ VSS VSS VDD VDD _02355_ sky130_fd_sc_hd__o21ai_0
X_15625_ network.neuron_in074.counter\[3\] network.in_period\[74\]\[2\]
+ net411 _00128_ VSS VSS VDD VDD _04545_ sky130_fd_sc_hd__o22ai_1
Xplace473 net473 VSS VSS VDD VDD net472 sky130_fd_sc_hd__buf_4
X_15627_ network.neuron_in074.counter\[2\] _00128_ net355
+ VSS VSS VDD VDD _04547_ sky130_fd_sc_hd__nand3_1
X_15628_ network.in_period\[74\]\[2\] net355 _04547_ VSS VSS
+ VDD VDD _04548_ sky130_fd_sc_hd__o21ai_0
X_15629_ _04523_ _04545_ _04548_ VSS VSS VDD VDD _02361_ sky130_fd_sc_hd__a21oi_1
X_15630_ network.in_period\[71\]\[1\] _04536_ VSS VSS VDD
+ VDD _04549_ sky130_fd_sc_hd__nand2_1
X_15631_ _00150_ _04536_ _04549_ VSS VSS VDD VDD _02348_ sky130_fd_sc_hd__o21ai_0
X_15632_ network.neuron_in072.counter\[3\] network.in_period\[72\]\[2\]
+ net420 _00229_ VSS VSS VDD VDD _04550_ sky130_fd_sc_hd__o22ai_1
X_15633_ network.neuron_in072.counter\[2\] _00229_ net355
+ VSS VSS VDD VDD _04551_ sky130_fd_sc_hd__nand3_1
X_15634_ network.in_period\[72\]\[2\] net355 _04551_ VSS VSS
+ VDD VDD _04552_ sky130_fd_sc_hd__o21ai_0
X_15635_ _04527_ _04550_ _04552_ VSS VSS VDD VDD _02353_ sky130_fd_sc_hd__a21oi_1
X_15636_ network.in_period\[73\]\[1\] _04543_ VSS VSS VDD
+ VDD _04553_ sky130_fd_sc_hd__nand2_1
X_15637_ _00140_ _04543_ _04553_ VSS VSS VDD VDD _02356_ sky130_fd_sc_hd__o21ai_0
X_15638_ network.neuron_in071.counter\[3\] network.in_period\[71\]\[2\]
+ net419 _00149_ VSS VSS VDD VDD _04554_ sky130_fd_sc_hd__o22ai_1
X_15639_ network.neuron_in071.counter\[2\] _00149_ net354
+ VSS VSS VDD VDD _04555_ sky130_fd_sc_hd__nand3_1
X_15640_ network.in_period\[71\]\[2\] net354 _04555_ VSS VSS
+ VDD VDD _04556_ sky130_fd_sc_hd__o21ai_0
X_15641_ _04534_ _04554_ _04556_ VSS VSS VDD VDD _02349_ sky130_fd_sc_hd__a21oi_1
X_15642_ network.neuron_in031.counter\[1\] VSS VSS VDD VDD
+ _01199_ sky130_fd_sc_hd__inv_1
X_15643_ net449 net403 _08147_ _07429_ VSS VSS VDD VDD _04557_
+ sky130_fd_sc_hd__o31a_1
X_15644_ _07593_ _07634_ _04557_ net434 VSS VSS VDD VDD _04558_
+ sky130_fd_sc_hd__o22ai_1
X_15645_ net449 net446 net370 _07965_ net380 VSS VSS VDD VDD
+ _04559_ sky130_fd_sc_hd__o32ai_1
X_15646_ _07698_ net337 _04559_ VSS VSS VDD VDD _04560_ sky130_fd_sc_hd__nor3_1
X_15647_ net427 _04560_ VSS VSS VDD VDD _04561_ sky130_fd_sc_hd__nor2_1
X_15648_ net388 _07416_ VSS VSS VDD VDD _04562_ sky130_fd_sc_hd__nand2_1
X_15649_ _07534_ _04562_ net374 VSS VSS VDD VDD _04563_ sky130_fd_sc_hd__o21ai_0
X_15650_ _07431_ _07958_ net434 VSS VSS VDD VDD _04564_ sky130_fd_sc_hd__a21oi_1
X_15651_ _07521_ _04564_ VSS VSS VDD VDD _04565_ sky130_fd_sc_hd__nor2_1
X_15652_ net396 _07553_ net434 VSS VSS VDD VDD _04566_ sky130_fd_sc_hd__o21ai_0
X_15653_ net442 net407 net441 VSS VSS VDD VDD _04567_ sky130_fd_sc_hd__o21ai_0
X_15654_ _03986_ _04566_ _04567_ VSS VSS VDD VDD _04568_ sky130_fd_sc_hd__nand3_1
X_15655_ net448 _04568_ VSS VSS VDD VDD _04569_ sky130_fd_sc_hd__nand2_1
X_15656_ net448 _04565_ _04569_ _08281_ net430 VSS VSS VDD
+ VDD _04570_ sky130_fd_sc_hd__o2111ai_1
X_15657_ net394 _08522_ VSS VSS VDD VDD _04571_ sky130_fd_sc_hd__nor2_1
X_15658_ _07483_ net395 _04571_ net441 VSS VSS VDD VDD _04572_
+ sky130_fd_sc_hd__o22ai_1
X_15659_ net444 net380 VSS VSS VDD VDD _04573_ sky130_fd_sc_hd__nor2_1
X_15660_ net444 _07536_ _04573_ VSS VSS VDD VDD _04574_ sky130_fd_sc_hd__a21oi_1
X_15661_ net445 _07673_ _07961_ net374 VSS VSS VDD VDD _04575_
+ sky130_fd_sc_hd__o211ai_1
X_15662_ net447 net388 VSS VSS VDD VDD _04576_ sky130_fd_sc_hd__nand2_1
X_15663_ _07643_ _04576_ _08023_ VSS VSS VDD VDD _04577_ sky130_fd_sc_hd__nand3_1
X_15664_ _07612_ _04574_ _04575_ net427 _04577_ VSS VSS VDD
+ VDD _04578_ sky130_fd_sc_hd__o2111ai_1
X_15665_ net430 net438 _04572_ _04578_ VSS VSS VDD VDD _04579_
+ sky130_fd_sc_hd__a31oi_1
X_15666_ _04561_ _04563_ _04570_ _04579_ network.neuron_hid0.ROM0.address\[7\]
+ VSS VSS VDD VDD _04580_ sky130_fd_sc_hd__a311oi_1
X_15667_ _07306_ _04558_ _04580_ VSS VSS VDD VDD _04581_ sky130_fd_sc_hd__a21oi_1
X_15668_ net327 _04581_ VSS VSS VDD VDD _01767_ sky130_fd_sc_hd__nor2_1
X_15669_ network.neuron_in097.counter\[2\] VSS VSS VDD VDD
+ _04582_ sky130_fd_sc_hd__inv_1
X_15670_ _04582_ _00078_ VSS VSS VDD VDD _04583_ sky130_fd_sc_hd__nand2_1
X_15671_ network.neuron_in097.counter\[3\] _04583_ VSS VSS
+ VDD VDD _04584_ sky130_fd_sc_hd__or2_2
X_15672_ network.in_spk00_06 _09483_ network.in_spk01_06 VSS
+ VSS VDD VDD _04585_ sky130_fd_sc_hd__o21ai_0
Xplace472 net473 VSS VSS VDD VDD net471 sky130_fd_sc_hd__buf_4
X_15674_ _04584_ _04585_ net412 VSS VSS VDD VDD _01768_ sky130_fd_sc_hd__a21oi_1
X_15675_ network.neuron_in096.counter\[3\] _01206_ VSS VSS
+ VDD VDD _04587_ sky130_fd_sc_hd__nand2b_1
X_15676_ network.neuron_in096.counter\[2\] VSS VSS VDD VDD
+ _04588_ sky130_fd_sc_hd__inv_1
X_15677_ _04587_ _04588_ VSS VSS VDD VDD _04589_ sky130_fd_sc_hd__nand2b_1
X_15678_ network.in_spk00_06 _09483_ VSS VSS VDD VDD _04590_
+ sky130_fd_sc_hd__nand2_1
X_15679_ _04589_ _04590_ net412 VSS VSS VDD VDD _01769_ sky130_fd_sc_hd__a21oi_1
X_15680_ network.neuron_in095.counter\[3\] _01243_ VSS VSS
+ VDD VDD _04591_ sky130_fd_sc_hd__nand2b_1
X_15681_ network.neuron_in095.counter\[2\] VSS VSS VDD VDD
+ _04592_ sky130_fd_sc_hd__inv_1
X_15682_ _04591_ _04592_ VSS VSS VDD VDD _04593_ sky130_fd_sc_hd__nand2b_1
X_15683_ network.in_spk12_05 network.in_spk13_05 VSS VSS VDD
+ VDD _04594_ sky130_fd_sc_hd__nor2_1
X_15684_ _09221_ _04594_ _09395_ _09363_ VSS VSS VDD VDD _04595_
+ sky130_fd_sc_hd__nand4_1
X_15685_ network.in_spk14_05 _04595_ network.in_spk15_05 VSS
+ VSS VDD VDD _04596_ sky130_fd_sc_hd__o21ai_0
X_15686_ _04593_ _04596_ net414 VSS VSS VDD VDD _01770_ sky130_fd_sc_hd__a21oi_1
X_15687_ network.neuron_in094.counter\[2\] VSS VSS VDD VDD
+ _04597_ sky130_fd_sc_hd__inv_1
X_15688_ _04597_ _01234_ VSS VSS VDD VDD _04598_ sky130_fd_sc_hd__nand2_1
X_15689_ network.neuron_in094.counter\[3\] _04598_ VSS VSS
+ VDD VDD _04599_ sky130_fd_sc_hd__or2_2
X_15690_ network.in_spk14_05 _04595_ VSS VSS VDD VDD _04600_
+ sky130_fd_sc_hd__nand2_1
X_15691_ _04599_ _04600_ net414 VSS VSS VDD VDD _01771_ sky130_fd_sc_hd__a21oi_1
X_15692_ network.neuron_in093.counter\[2\] network.neuron_in093.counter\[3\]
+ VSS VSS VDD VDD _04601_ sky130_fd_sc_hd__nor2_1
X_15693_ _01230_ _04601_ VSS VSS VDD VDD _04602_ sky130_fd_sc_hd__nand2_1
X_15694_ _09221_ _09395_ _09363_ VSS VSS VDD VDD _04603_ sky130_fd_sc_hd__nand3_1
X_15695_ network.in_spk12_05 _04603_ network.in_spk13_05 VSS
+ VSS VDD VDD _04604_ sky130_fd_sc_hd__o21ai_0
X_15696_ _04602_ _04604_ net412 VSS VSS VDD VDD _01772_ sky130_fd_sc_hd__a21oi_1
X_15697_ network.neuron_in092.counter\[2\] _01226_ VSS VSS
+ VDD VDD _04605_ sky130_fd_sc_hd__nand2b_1
X_15698_ network.neuron_in092.counter\[3\] _04605_ VSS VSS
+ VDD VDD _04606_ sky130_fd_sc_hd__or2_2
X_15699_ network.in_spk12_05 _04603_ VSS VSS VDD VDD _04607_
+ sky130_fd_sc_hd__nand2_1
X_15700_ _04606_ _04607_ net412 VSS VSS VDD VDD _01773_ sky130_fd_sc_hd__a21oi_1
X_15701_ network.neuron_in091.counter\[2\] _00145_ VSS VSS
+ VDD VDD _04608_ sky130_fd_sc_hd__nand2b_1
X_15702_ network.neuron_in091.counter\[3\] _04608_ VSS VSS
+ VDD VDD _04609_ sky130_fd_sc_hd__or2_2
X_15703_ net324 _09388_ _09395_ net330 VSS VSS VDD VDD _04610_
+ sky130_fd_sc_hd__nand4_1
X_15704_ network.in_spk08_05 network.in_spk09_05 network.in_spk10_05
+ _04610_ network.in_spk11_05 VSS VSS VDD VDD _04611_ sky130_fd_sc_hd__o41ai_1
X_15705_ _04609_ _04611_ net414 VSS VSS VDD VDD _01774_ sky130_fd_sc_hd__a21oi_1
X_15706_ network.neuron_in090.counter\[2\] network.neuron_in090.counter\[3\]
+ VSS VSS VDD VDD _04612_ sky130_fd_sc_hd__nor2_1
X_15707_ _00645_ _04612_ VSS VSS VDD VDD _04613_ sky130_fd_sc_hd__nand2_1
X_15708_ network.in_spk08_05 network.in_spk09_05 _04610_ network.in_spk10_05
+ VSS VSS VDD VDD _04614_ sky130_fd_sc_hd__o31ai_1
X_15709_ _04613_ _04614_ net414 VSS VSS VDD VDD _01775_ sky130_fd_sc_hd__a21oi_1
X_15710_ network.neuron_in089.counter\[3\] _01218_ VSS VSS
+ VDD VDD _04615_ sky130_fd_sc_hd__nand2b_1
X_15711_ network.neuron_in089.counter\[2\] VSS VSS VDD VDD
+ _04616_ sky130_fd_sc_hd__inv_1
X_15712_ _04615_ _04616_ VSS VSS VDD VDD _04617_ sky130_fd_sc_hd__nand2b_1
X_15713_ network.in_spk08_05 _04610_ network.in_spk09_05 VSS
+ VSS VDD VDD _04618_ sky130_fd_sc_hd__o21ai_0
X_15714_ _04617_ _04618_ net414 VSS VSS VDD VDD _01776_ sky130_fd_sc_hd__a21oi_1
X_15715_ network.neuron_in088.counter\[3\] _01214_ VSS VSS
+ VDD VDD _04619_ sky130_fd_sc_hd__nand2b_1
X_15716_ network.neuron_in088.counter\[2\] VSS VSS VDD VDD
+ _04620_ sky130_fd_sc_hd__inv_1
X_15717_ _04619_ _04620_ VSS VSS VDD VDD _04621_ sky130_fd_sc_hd__nand2b_1
X_15718_ network.in_spk08_05 _04610_ VSS VSS VDD VDD _04622_
+ sky130_fd_sc_hd__nand2_1
X_15719_ _04621_ _04622_ net414 VSS VSS VDD VDD _01777_ sky130_fd_sc_hd__a21oi_1
X_15720_ network.neuron_in087.counter\[2\] _00036_ VSS VSS
+ VDD VDD _04623_ sky130_fd_sc_hd__nand2b_1
X_15721_ network.neuron_in087.counter\[3\] _04623_ VSS VSS
+ VDD VDD _04624_ sky130_fd_sc_hd__or2_2
X_15722_ network.in_spk04_05 network.in_spk05_05 network.in_spk06_05
+ _09479_ network.in_spk07_05 VSS VSS VDD VDD _04625_ sky130_fd_sc_hd__o41ai_2
Xplace464 net468 VSS VSS VDD VDD net463 sky130_fd_sc_hd__buf_4
X_15724_ _04624_ _04625_ net414 VSS VSS VDD VDD _01778_ sky130_fd_sc_hd__a21oi_1
X_15725_ network.neuron_in086.counter\[2\] network.neuron_in086.counter\[3\]
+ VSS VSS VDD VDD _04627_ sky130_fd_sc_hd__nor2_1
X_15726_ _00040_ _04627_ VSS VSS VDD VDD _04628_ sky130_fd_sc_hd__nand2_1
X_15727_ network.in_spk04_05 network.in_spk05_05 _09479_ network.in_spk06_05
+ VSS VSS VDD VDD _04629_ sky130_fd_sc_hd__o31ai_1
X_15728_ _04628_ _04629_ net414 VSS VSS VDD VDD _01779_ sky130_fd_sc_hd__a21oi_1
X_15729_ network.neuron_in085.counter\[2\] network.neuron_in085.counter\[3\]
+ VSS VSS VDD VDD _04630_ sky130_fd_sc_hd__nor2_1
X_15730_ _00044_ _04630_ VSS VSS VDD VDD _04631_ sky130_fd_sc_hd__nand2_1
X_15731_ network.in_spk04_05 _09479_ network.in_spk05_05 VSS
+ VSS VDD VDD _04632_ sky130_fd_sc_hd__o21ai_1
X_15732_ _04631_ _04632_ net414 VSS VSS VDD VDD _01780_ sky130_fd_sc_hd__a21oi_1
X_15733_ network.neuron_in084.counter\[3\] _00048_ VSS VSS
+ VDD VDD _04633_ sky130_fd_sc_hd__nand2b_1
X_15734_ network.neuron_in084.counter\[2\] VSS VSS VDD VDD
+ _04634_ sky130_fd_sc_hd__inv_1
X_15735_ _04633_ _04634_ VSS VSS VDD VDD _04635_ sky130_fd_sc_hd__nand2b_1
X_15736_ network.in_spk04_05 _09479_ VSS VSS VDD VDD _04636_
+ sky130_fd_sc_hd__nand2_1
X_15737_ _04635_ _04636_ net414 VSS VSS VDD VDD _01781_ sky130_fd_sc_hd__a21oi_1
X_15738_ network.neuron_in083.counter\[2\] network.neuron_in083.counter\[3\]
+ VSS VSS VDD VDD _04637_ sky130_fd_sc_hd__nor2_1
X_15739_ _00060_ _04637_ VSS VSS VDD VDD _04638_ sky130_fd_sc_hd__nand2_1
X_15740_ network.in_spk02_05 _09478_ network.in_spk03_05 VSS
+ VSS VDD VDD _04639_ sky130_fd_sc_hd__o21ai_0
X_15741_ _04638_ _04639_ net414 VSS VSS VDD VDD _01782_ sky130_fd_sc_hd__a21oi_1
X_15742_ network.neuron_in082.counter\[2\] VSS VSS VDD VDD
+ _04640_ sky130_fd_sc_hd__inv_1
X_15743_ _04640_ _00056_ VSS VSS VDD VDD _04641_ sky130_fd_sc_hd__nand2_1
X_15744_ network.neuron_in082.counter\[3\] _04641_ VSS VSS
+ VDD VDD _04642_ sky130_fd_sc_hd__or2_2
X_15745_ network.in_spk02_05 _09478_ VSS VSS VDD VDD _04643_
+ sky130_fd_sc_hd__nand2_1
X_15746_ _04642_ _04643_ net414 VSS VSS VDD VDD _01783_ sky130_fd_sc_hd__a21oi_1
X_15747_ network.neuron_in081.counter\[3\] _00082_ VSS VSS
+ VDD VDD _04644_ sky130_fd_sc_hd__nand2b_1
X_15748_ network.neuron_in081.counter\[2\] _04644_ VSS VSS
+ VDD VDD _04645_ sky130_fd_sc_hd__or2_2
X_15749_ network.in_spk01_05 _09689_ VSS VSS VDD VDD _04646_
+ sky130_fd_sc_hd__nand2_1
X_15750_ _04645_ _04646_ net414 VSS VSS VDD VDD _01784_ sky130_fd_sc_hd__a21oi_1
X_15751_ network.neuron_in080.counter\[2\] VSS VSS VDD VDD
+ _04647_ sky130_fd_sc_hd__inv_1
X_15752_ _04647_ _00086_ VSS VSS VDD VDD _04648_ sky130_fd_sc_hd__nand2_1
X_15753_ network.neuron_in080.counter\[3\] _04648_ VSS VSS
+ VDD VDD _04649_ sky130_fd_sc_hd__or2_2
X_15754_ network.in_spk00_05 _09362_ VSS VSS VDD VDD _04650_
+ sky130_fd_sc_hd__nand2_1
X_15755_ _04649_ _04650_ net414 VSS VSS VDD VDD _01785_ sky130_fd_sc_hd__a21oi_1
X_15756_ network.neuron_in079.counter\[2\] VSS VSS VDD VDD
+ _04651_ sky130_fd_sc_hd__inv_1
X_15757_ _04651_ _00096_ VSS VSS VDD VDD _04652_ sky130_fd_sc_hd__nand2_1
X_15758_ network.neuron_in079.counter\[3\] _04652_ VSS VSS
+ VDD VDD _04653_ sky130_fd_sc_hd__or2_2
X_15759_ network.in_spk14_04 _09347_ _09569_ _03425_ network.in_spk15_04
+ VSS VSS VDD VDD _04654_ sky130_fd_sc_hd__o41ai_1
X_15760_ _04653_ _04654_ net419 VSS VSS VDD VDD _01786_ sky130_fd_sc_hd__a21oi_1
X_15761_ network.neuron_in078.counter\[2\] _00104_ VSS VSS
+ VDD VDD _04655_ sky130_fd_sc_hd__nand2b_1
X_15762_ network.neuron_in078.counter\[3\] _04655_ VSS VSS
+ VDD VDD _04656_ sky130_fd_sc_hd__or2_2
X_15763_ _09347_ _09569_ _03425_ network.in_spk14_04 VSS VSS
+ VDD VDD _04657_ sky130_fd_sc_hd__o31ai_1
X_15764_ _04656_ _04657_ net419 VSS VSS VDD VDD _01787_ sky130_fd_sc_hd__a21oi_1
X_15765_ network.neuron_in077.counter\[2\] VSS VSS VDD VDD
+ _04658_ sky130_fd_sc_hd__inv_1
X_15766_ network.neuron_in077.counter\[3\] VSS VSS VDD VDD
+ _04659_ sky130_fd_sc_hd__inv_1
X_15767_ _04658_ _00110_ _04659_ VSS VSS VDD VDD _04660_ sky130_fd_sc_hd__nand3_1
X_15768_ net324 _09398_ _09236_ VSS VSS VDD VDD _04661_ sky130_fd_sc_hd__nand3_1
X_15769_ network.in_spk12_04 _04661_ network.in_spk13_04 VSS
+ VSS VDD VDD _04662_ sky130_fd_sc_hd__o21ai_0
Xplace457 net462 VSS VSS VDD VDD net456 sky130_fd_sc_hd__buf_4
X_15771_ _04660_ _04662_ net419 VSS VSS VDD VDD _01788_ sky130_fd_sc_hd__a21oi_1
X_15772_ network.neuron_in076.counter\[3\] _00124_ VSS VSS
+ VDD VDD _04664_ sky130_fd_sc_hd__nand2b_1
X_15773_ network.neuron_in076.counter\[2\] VSS VSS VDD VDD
+ _04665_ sky130_fd_sc_hd__inv_1
X_15774_ _04664_ _04665_ VSS VSS VDD VDD _04666_ sky130_fd_sc_hd__nand2b_1
X_15775_ network.in_spk12_04 _04661_ VSS VSS VDD VDD _04667_
+ sky130_fd_sc_hd__nand2_1
X_15776_ _04666_ _04667_ net419 VSS VSS VDD VDD _01789_ sky130_fd_sc_hd__a21oi_1
X_15777_ network.neuron_in075.counter\[2\] VSS VSS VDD VDD
+ _04668_ sky130_fd_sc_hd__inv_1
X_15778_ _04668_ _00132_ VSS VSS VDD VDD _04669_ sky130_fd_sc_hd__nand2_1
X_15779_ network.neuron_in075.counter\[3\] _04669_ VSS VSS
+ VDD VDD _04670_ sky130_fd_sc_hd__or2_2
X_15780_ net324 _09398_ _09459_ VSS VSS VDD VDD _04671_ sky130_fd_sc_hd__nand3_1
X_15781_ network.in_spk10_04 _04671_ network.in_spk11_04 VSS
+ VSS VDD VDD _04672_ sky130_fd_sc_hd__o21ai_0
X_15782_ _04670_ _04672_ net419 VSS VSS VDD VDD _01790_ sky130_fd_sc_hd__a21oi_1
X_15783_ network.in_spk10_04 _04671_ VSS VSS VDD VDD _04673_
+ sky130_fd_sc_hd__nand2_1
X_15784_ _04524_ _04673_ net419 VSS VSS VDD VDD _01791_ sky130_fd_sc_hd__a21oi_1
X_15785_ network.in_spk08_04 _09399_ network.in_spk09_04 VSS
+ VSS VDD VDD _04674_ sky130_fd_sc_hd__o21ai_0
X_15786_ _04542_ _04674_ net419 VSS VSS VDD VDD _01792_ sky130_fd_sc_hd__a21oi_1
X_15787_ network.in_spk08_04 _09399_ VSS VSS VDD VDD _04675_
+ sky130_fd_sc_hd__nand2_1
X_15788_ _04529_ _04675_ net420 VSS VSS VDD VDD _01793_ sky130_fd_sc_hd__a21oi_1
X_15789_ net324 _09233_ _09322_ VSS VSS VDD VDD _04676_ sky130_fd_sc_hd__nand3_1
X_15790_ network.in_spk04_04 network.in_spk05_04 network.in_spk06_04
+ _04676_ network.in_spk07_04 VSS VSS VDD VDD _04677_ sky130_fd_sc_hd__o41ai_1
X_15791_ _04535_ _04677_ net419 VSS VSS VDD VDD _01794_ sky130_fd_sc_hd__a21oi_1
X_15792_ network.in_spk04_04 network.in_spk05_04 _04676_ network.in_spk06_04
+ VSS VSS VDD VDD _04678_ sky130_fd_sc_hd__o31ai_1
X_15793_ _04510_ _04678_ net419 VSS VSS VDD VDD _01795_ sky130_fd_sc_hd__a21oi_1
X_15794_ network.in_spk04_04 _04676_ network.in_spk05_04 VSS
+ VSS VDD VDD _04679_ sky130_fd_sc_hd__o21ai_0
X_15795_ _04505_ _04679_ net419 VSS VSS VDD VDD _01796_ sky130_fd_sc_hd__a21oi_1
X_15796_ network.in_spk04_04 _04676_ VSS VSS VDD VDD _04680_
+ sky130_fd_sc_hd__nand2_1
X_15797_ _04496_ _04680_ net419 VSS VSS VDD VDD _01797_ sky130_fd_sc_hd__a21oi_1
X_15798_ network.in_spk01_04 network.in_spk02_04 _09577_ network.in_spk03_04
+ VSS VSS VDD VDD _04681_ sky130_fd_sc_hd__o31ai_1
Xplace454 loaded\[7\] VSS VSS VDD VDD net453 sky130_fd_sc_hd__buf_4
X_15800_ _04438_ _04681_ net420 VSS VSS VDD VDD _01798_ sky130_fd_sc_hd__a21oi_1
X_15801_ network.in_spk01_04 _09577_ network.in_spk02_04 VSS
+ VSS VDD VDD _04683_ sky130_fd_sc_hd__o21ai_0
X_15802_ _04461_ _04683_ net420 VSS VSS VDD VDD _01799_ sky130_fd_sc_hd__a21oi_1
X_15803_ network.in_spk01_04 _09577_ VSS VSS VDD VDD _04684_
+ sky130_fd_sc_hd__nand2_1
X_15804_ _04456_ _04684_ net420 VSS VSS VDD VDD _01800_ sky130_fd_sc_hd__a21oi_1
X_15805_ _09347_ net330 network.in_spk00_04 VSS VSS VDD VDD
+ _04685_ sky130_fd_sc_hd__o21ai_0
X_15806_ _04399_ _04685_ net412 VSS VSS VDD VDD _01801_ sky130_fd_sc_hd__a21oi_1
X_15807_ _09343_ _09536_ VSS VSS VDD VDD _04686_ sky130_fd_sc_hd__nand2_1
X_15808_ network.in_spk12_03 network.in_spk13_03 network.in_spk14_03
+ _04686_ network.in_spk15_03 VSS VSS VDD VDD _04687_ sky130_fd_sc_hd__o41ai_1
X_15809_ _04433_ _04687_ net418 VSS VSS VDD VDD _01802_ sky130_fd_sc_hd__a21oi_1
X_15810_ network.in_spk12_03 network.in_spk13_03 _04686_ network.in_spk14_03
+ VSS VSS VDD VDD _04688_ sky130_fd_sc_hd__o31ai_1
X_15811_ _04403_ _04688_ net418 VSS VSS VDD VDD _01803_ sky130_fd_sc_hd__a21oi_1
X_15812_ network.in_spk12_03 _04686_ network.in_spk13_03 VSS
+ VSS VDD VDD _04689_ sky130_fd_sc_hd__o21ai_0
X_15813_ _04421_ _04689_ net418 VSS VSS VDD VDD _01804_ sky130_fd_sc_hd__a21oi_1
X_15814_ network.in_spk12_03 _04686_ VSS VSS VDD VDD _04690_
+ sky130_fd_sc_hd__nand2_1
X_15815_ _04325_ _04690_ net418 VSS VSS VDD VDD _01805_ sky130_fd_sc_hd__a21oi_1
X_15816_ _09380_ _09381_ VSS VSS VDD VDD _04691_ sky130_fd_sc_hd__nor2_1
X_15817_ _09378_ _09342_ _04691_ VSS VSS VDD VDD _04692_ sky130_fd_sc_hd__nand3_1
X_15818_ network.in_spk08_03 network.in_spk09_03 _04692_ VSS
+ VSS VDD VDD _04693_ sky130_fd_sc_hd__or3_1
X_15819_ network.in_spk10_03 _04693_ network.in_spk11_03 VSS
+ VSS VDD VDD _04694_ sky130_fd_sc_hd__o21ai_0
X_15820_ _04330_ _04694_ net418 VSS VSS VDD VDD _01806_ sky130_fd_sc_hd__a21oi_1
X_15821_ network.in_spk10_03 _04693_ VSS VSS VDD VDD _04695_
+ sky130_fd_sc_hd__nand2_1
X_15822_ _04368_ _04695_ net418 VSS VSS VDD VDD _01807_ sky130_fd_sc_hd__a21oi_1
X_15823_ network.in_spk08_03 _04692_ network.in_spk09_03 VSS
+ VSS VDD VDD _04696_ sky130_fd_sc_hd__o21ai_0
Xplace453 _04137_ VSS VSS VDD VDD net452 sky130_fd_sc_hd__buf_4
X_15825_ _04274_ _04696_ net418 VSS VSS VDD VDD _01808_ sky130_fd_sc_hd__a21oi_1
X_15826_ network.in_spk08_03 _04692_ VSS VSS VDD VDD _04698_
+ sky130_fd_sc_hd__nand2_1
X_15827_ _04302_ _04698_ net418 VSS VSS VDD VDD _01809_ sky130_fd_sc_hd__a21oi_1
X_15828_ network.in_spk04_03 network.in_spk05_03 network.in_spk06_03
+ _09450_ network.in_spk07_03 VSS VSS VDD VDD _04699_ sky130_fd_sc_hd__o41ai_1
X_15829_ _04297_ _04699_ net418 VSS VSS VDD VDD _01810_ sky130_fd_sc_hd__a21oi_1
X_15830_ network.in_spk04_03 network.in_spk05_03 _09450_ network.in_spk06_03
+ VSS VSS VDD VDD _04700_ sky130_fd_sc_hd__o31ai_1
X_15831_ _04311_ _04700_ net418 VSS VSS VDD VDD _01811_ sky130_fd_sc_hd__a21oi_1
X_15832_ network.in_spk04_03 _09450_ network.in_spk05_03 VSS
+ VSS VDD VDD _04701_ sky130_fd_sc_hd__o21ai_0
X_15833_ _04288_ _04701_ net418 VSS VSS VDD VDD _01812_ sky130_fd_sc_hd__a21oi_1
X_15834_ network.in_spk04_03 _09450_ VSS VSS VDD VDD _04702_
+ sky130_fd_sc_hd__nand2_1
X_15835_ _04266_ _04702_ net418 VSS VSS VDD VDD _01813_ sky130_fd_sc_hd__a21oi_1
X_15836_ _09543_ _09343_ VSS VSS VDD VDD _04703_ sky130_fd_sc_hd__nand2_1
X_15837_ network.in_spk02_03 _04703_ network.in_spk03_03 VSS
+ VSS VDD VDD _04704_ sky130_fd_sc_hd__o21ai_0
X_15838_ _04214_ _04704_ net418 VSS VSS VDD VDD _01814_ sky130_fd_sc_hd__a21oi_1
X_15839_ network.in_spk02_03 _04703_ VSS VSS VDD VDD _04705_
+ sky130_fd_sc_hd__nand2_1
X_15840_ _04206_ _04705_ net418 VSS VSS VDD VDD _01815_ sky130_fd_sc_hd__a21oi_1
X_15841_ network.in_spk01_03 _09547_ VSS VSS VDD VDD _04706_
+ sky130_fd_sc_hd__nand2_1
X_15842_ _04186_ _04706_ net418 VSS VSS VDD VDD _01816_ sky130_fd_sc_hd__a21oi_1
X_15843_ _09343_ network.in_spk00_03 VSS VSS VDD VDD _04707_
+ sky130_fd_sc_hd__nand2b_1
X_15844_ _04201_ _04707_ net418 VSS VSS VDD VDD _01817_ sky130_fd_sc_hd__a21oi_1
X_15845_ _09378_ net367 _09379_ _09314_ VSS VSS VDD VDD _04708_
+ sky130_fd_sc_hd__nand4_1
X_15846_ network.in_spk12_02 network.in_spk13_02 _04708_ VSS
+ VSS VDD VDD _04709_ sky130_fd_sc_hd__or3_1
X_15847_ network.in_spk14_02 _04709_ network.in_spk15_02 VSS
+ VSS VDD VDD _04710_ sky130_fd_sc_hd__o21ai_0
Xplace455 loaded\[6\] VSS VSS VDD VDD net454 sky130_fd_sc_hd__buf_4
X_15849_ _04195_ _04710_ net423 VSS VSS VDD VDD _01818_ sky130_fd_sc_hd__a21oi_1
X_15850_ network.in_spk14_02 _04709_ VSS VSS VDD VDD _04712_
+ sky130_fd_sc_hd__nand2_1
X_15851_ _04158_ _04712_ net423 VSS VSS VDD VDD _01819_ sky130_fd_sc_hd__a21oi_1
X_15852_ network.in_spk12_02 _04708_ network.in_spk13_02 VSS
+ VSS VDD VDD _04713_ sky130_fd_sc_hd__o21ai_0
X_15853_ _04154_ _04713_ net423 VSS VSS VDD VDD _01820_ sky130_fd_sc_hd__a21oi_1
X_15854_ network.in_spk12_02 _04708_ VSS VSS VDD VDD _04714_
+ sky130_fd_sc_hd__nand2_1
X_15855_ _04167_ _04714_ net423 VSS VSS VDD VDD _01821_ sky130_fd_sc_hd__a21oi_1
X_15856_ _09378_ _09438_ _09379_ _09314_ VSS VSS VDD VDD _04715_
+ sky130_fd_sc_hd__nand4_1
X_15857_ network.in_spk10_02 _04715_ network.in_spk11_02 VSS
+ VSS VDD VDD _04716_ sky130_fd_sc_hd__o21ai_0
X_15858_ _04162_ _04716_ net423 VSS VSS VDD VDD _01822_ sky130_fd_sc_hd__a21oi_1
X_15859_ network.in_spk10_02 _04715_ VSS VSS VDD VDD _04717_
+ sky130_fd_sc_hd__nand2_1
X_15860_ _03872_ _04717_ net423 VSS VSS VDD VDD _01823_ sky130_fd_sc_hd__a21oi_1
X_15861_ _09378_ _09379_ _09314_ VSS VSS VDD VDD _04718_ sky130_fd_sc_hd__nand3_1
X_15862_ network.in_spk08_02 _04718_ network.in_spk09_02 VSS
+ VSS VDD VDD _04719_ sky130_fd_sc_hd__o21ai_0
X_15863_ _03920_ _04719_ net423 VSS VSS VDD VDD _01824_ sky130_fd_sc_hd__a21oi_1
X_15864_ network.in_spk08_02 _04718_ VSS VSS VDD VDD _04720_
+ sky130_fd_sc_hd__nand2_1
X_15865_ _03901_ _04720_ net423 VSS VSS VDD VDD _01825_ sky130_fd_sc_hd__a21oi_1
X_15866_ network.in_spk04_02 network.in_spk05_02 network.in_spk06_02
+ _09437_ network.in_spk07_02 VSS VSS VDD VDD _04721_ sky130_fd_sc_hd__o41ai_1
X_15867_ _03765_ _04721_ net423 VSS VSS VDD VDD _01826_ sky130_fd_sc_hd__a21oi_1
X_15868_ network.in_spk04_02 network.in_spk05_02 _09437_ network.in_spk06_02
+ VSS VSS VDD VDD _04722_ sky130_fd_sc_hd__o31ai_1
X_15869_ _03807_ _04722_ net423 VSS VSS VDD VDD _01827_ sky130_fd_sc_hd__a21oi_1
X_15870_ network.in_spk04_02 _09437_ network.in_spk05_02 VSS
+ VSS VDD VDD _04723_ sky130_fd_sc_hd__o21ai_0
Xplace451 net451 VSS VSS VDD VDD net450 sky130_fd_sc_hd__buf_4
X_15872_ _03770_ _04723_ net423 VSS VSS VDD VDD _01828_ sky130_fd_sc_hd__a21oi_1
X_15873_ network.in_spk04_02 _09437_ VSS VSS VDD VDD _04725_
+ sky130_fd_sc_hd__nand2_1
X_15874_ _03829_ _04725_ net423 VSS VSS VDD VDD _01829_ sky130_fd_sc_hd__a21oi_1
X_15875_ network.in_spk00_02 network.in_spk01_02 network.in_spk02_02
+ _09355_ network.in_spk03_02 VSS VSS VDD VDD _04726_ sky130_fd_sc_hd__o41ai_1
X_15876_ _03733_ _04726_ net423 VSS VSS VDD VDD _01830_ sky130_fd_sc_hd__a21oi_1
X_15877_ network.in_spk00_02 network.in_spk01_02 _09355_ network.in_spk02_02
+ VSS VSS VDD VDD _04727_ sky130_fd_sc_hd__o31ai_1
X_15878_ _03723_ _04727_ net423 VSS VSS VDD VDD _01831_ sky130_fd_sc_hd__a21oi_1
X_15879_ _09514_ _09516_ _03739_ VSS VSS VDD VDD _04728_ sky130_fd_sc_hd__o21a_1
X_15880_ net423 _04728_ VSS VSS VDD VDD _01832_ sky130_fd_sc_hd__nor2_1
X_15881_ network.neuron_in032.counter\[3\] _03708_ VSS VSS
+ VDD VDD _04729_ sky130_fd_sc_hd__nor2_1
X_15882_ network.in_spk00_02 _09355_ _04729_ VSS VSS VDD VDD
+ _04730_ sky130_fd_sc_hd__a21oi_1
X_15883_ net423 _04730_ VSS VSS VDD VDD _01833_ sky130_fd_sc_hd__nor2_1
X_15884_ network.in_spk12_01 network.in_spk13_01 _09305_ VSS
+ VSS VDD VDD _04731_ sky130_fd_sc_hd__or3_1
X_15885_ _09383_ _09361_ VSS VSS VDD VDD _04732_ sky130_fd_sc_hd__nand2_1
X_15886_ network.in_spk14_01 _04731_ _04732_ network.in_spk15_01
+ VSS VSS VDD VDD _04733_ sky130_fd_sc_hd__o31ai_1
X_15887_ _03705_ _04733_ net422 VSS VSS VDD VDD _01834_ sky130_fd_sc_hd__a21oi_1
X_15888_ _04731_ _04732_ network.in_spk14_01 VSS VSS VDD VDD
+ _04734_ sky130_fd_sc_hd__o21ai_0
X_15889_ _03677_ _04734_ net422 VSS VSS VDD VDD _01835_ sky130_fd_sc_hd__a21oi_1
X_15890_ network.in_spk12_01 _09305_ _04732_ network.in_spk13_01
+ VSS VSS VDD VDD _04735_ sky130_fd_sc_hd__o31ai_1
X_15891_ _07904_ _04735_ net422 VSS VSS VDD VDD _01836_ sky130_fd_sc_hd__a21oi_1
X_15892_ _09305_ _04732_ network.in_spk12_01 VSS VSS VDD VDD
+ _04736_ sky130_fd_sc_hd__o21ai_0
X_15893_ _07892_ _04736_ net422 VSS VSS VDD VDD _01837_ sky130_fd_sc_hd__a21oi_1
X_15894_ network.neuron_in027.counter\[3\] _00531_ VSS VSS
+ VDD VDD _04737_ sky130_fd_sc_hd__nand2b_1
X_15895_ network.neuron_in027.counter\[2\] _04737_ VSS VSS
+ VDD VDD _04738_ sky130_fd_sc_hd__or2_2
X_15896_ network.in_spk08_01 network.in_spk09_01 network.in_spk10_01
+ _04732_ network.in_spk11_01 VSS VSS VDD VDD _04739_ sky130_fd_sc_hd__o41ai_1
X_15897_ _04738_ _04739_ net422 VSS VSS VDD VDD _01838_ sky130_fd_sc_hd__a21oi_1
X_15898_ network.in_spk08_01 network.in_spk09_01 _04732_ network.in_spk10_01
+ VSS VSS VDD VDD _04740_ sky130_fd_sc_hd__o31ai_1
X_15899_ _03699_ _04740_ net422 VSS VSS VDD VDD _01839_ sky130_fd_sc_hd__a21oi_1
X_15900_ network.in_spk08_01 _04732_ network.in_spk09_01 VSS
+ VSS VDD VDD _04741_ sky130_fd_sc_hd__o21ai_0
Xplace450 net450 VSS VSS VDD VDD net449 sky130_fd_sc_hd__buf_4
X_15902_ _03683_ _04741_ net422 VSS VSS VDD VDD _01840_ sky130_fd_sc_hd__a21oi_1
X_15903_ network.in_spk08_01 _04732_ VSS VSS VDD VDD _04743_
+ sky130_fd_sc_hd__nand2_1
X_15904_ _03664_ _04743_ net422 VSS VSS VDD VDD _01841_ sky130_fd_sc_hd__a21oi_1
X_15905_ net328 _03358_ VSS VSS VDD VDD _04744_ sky130_fd_sc_hd__nand2_1
X_15906_ network.in_spk07_01 _04744_ VSS VSS VDD VDD _04745_
+ sky130_fd_sc_hd__nand2_1
X_15907_ _03655_ _04745_ net422 VSS VSS VDD VDD _01842_ sky130_fd_sc_hd__a21oi_1
X_15908_ network.in_spk01_01 network.in_spk02_01 network.in_spk03_01
+ _09533_ VSS VSS VDD VDD _04746_ sky130_fd_sc_hd__or4_1
X_15909_ network.in_spk04_01 network.in_spk05_01 _04746_ network.in_spk06_01
+ VSS VSS VDD VDD _04747_ sky130_fd_sc_hd__o31ai_1
X_15910_ _03646_ _04747_ net423 VSS VSS VDD VDD _01843_ sky130_fd_sc_hd__a21oi_1
X_15911_ network.in_spk04_01 _04746_ network.in_spk05_01 VSS
+ VSS VDD VDD _04748_ sky130_fd_sc_hd__o21ai_0
X_15912_ _03636_ _04748_ net423 VSS VSS VDD VDD _01844_ sky130_fd_sc_hd__a21oi_1
X_15913_ network.in_spk04_01 _04746_ VSS VSS VDD VDD _04749_
+ sky130_fd_sc_hd__nand2_1
X_15914_ _03627_ _04749_ net423 VSS VSS VDD VDD _01845_ sky130_fd_sc_hd__a21oi_1
X_15915_ network.in_spk01_01 network.in_spk02_01 _09533_ network.in_spk03_01
+ VSS VSS VDD VDD _04750_ sky130_fd_sc_hd__o31ai_1
X_15916_ _03617_ _04750_ net423 VSS VSS VDD VDD _01846_ sky130_fd_sc_hd__a21oi_1
X_15917_ network.in_spk01_01 _09533_ network.in_spk02_01 VSS
+ VSS VDD VDD _04751_ sky130_fd_sc_hd__o21ai_0
X_15918_ _03607_ _04751_ net423 VSS VSS VDD VDD _01847_ sky130_fd_sc_hd__a21oi_1
X_15919_ network.in_spk01_01 _09533_ VSS VSS VDD VDD _04752_
+ sky130_fd_sc_hd__nand2_1
X_15920_ _03572_ _04752_ net423 VSS VSS VDD VDD _01848_ sky130_fd_sc_hd__a21oi_1
X_15921_ _09302_ _09341_ network.in_spk00_01 VSS VSS VDD VDD
+ _04753_ sky130_fd_sc_hd__o21ai_0
X_15922_ _03588_ _04753_ net422 VSS VSS VDD VDD _01849_ sky130_fd_sc_hd__a21oi_1
X_15923_ network.in_spk13_00 _09518_ VSS VSS VDD VDD _04754_
+ sky130_fd_sc_hd__or2_2
X_15924_ network.in_spk14_00 _04754_ network.in_spk15_00 VSS
+ VSS VDD VDD _04755_ sky130_fd_sc_hd__o21ai_0
Xplace448 net448 VSS VSS VDD VDD net447 sky130_fd_sc_hd__buf_4
X_15926_ _03562_ _04755_ net422 VSS VSS VDD VDD _01850_ sky130_fd_sc_hd__a21oi_1
X_15927_ net307 _04754_ network.in_spk14_00 VSS VSS VDD VDD
+ _04757_ sky130_fd_sc_hd__o21ai_0
X_15928_ _03541_ _04757_ net423 VSS VSS VDD VDD _01851_ sky130_fd_sc_hd__a21oi_1
X_15929_ network.in_spk13_00 _09518_ VSS VSS VDD VDD _04758_
+ sky130_fd_sc_hd__nand2_1
X_15930_ _03545_ _04758_ net422 VSS VSS VDD VDD _01852_ sky130_fd_sc_hd__a21oi_1
X_15931_ _09336_ _09385_ network.in_spk12_00 VSS VSS VDD VDD
+ _04759_ sky130_fd_sc_hd__o21ai_0
X_15932_ _03531_ _04759_ net422 VSS VSS VDD VDD _01853_ sky130_fd_sc_hd__a21oi_1
X_15933_ network.in_spk08_00 network.in_spk09_00 network.in_spk10_00
+ _09385_ network.in_spk11_00 VSS VSS VDD VDD _04760_ sky130_fd_sc_hd__o41ai_1
X_15934_ _03521_ _04760_ net422 VSS VSS VDD VDD _01854_ sky130_fd_sc_hd__a21oi_1
X_15935_ _09519_ network.in_spk10_00 VSS VSS VDD VDD _04761_
+ sky130_fd_sc_hd__nand2b_1
X_15936_ _03512_ _04761_ net422 VSS VSS VDD VDD _01855_ sky130_fd_sc_hd__a21oi_1
X_15937_ network.in_spk08_00 _09385_ network.in_spk09_00 VSS
+ VSS VDD VDD _04762_ sky130_fd_sc_hd__o21ai_0
X_15938_ _03503_ _04762_ net422 VSS VSS VDD VDD _01856_ sky130_fd_sc_hd__a21oi_1
X_15939_ network.in_spk08_00 _09385_ VSS VSS VDD VDD _04763_
+ sky130_fd_sc_hd__nand2_1
X_15940_ _08671_ _04763_ net422 VSS VSS VDD VDD _01857_ sky130_fd_sc_hd__a21oi_1
X_15941_ _03395_ network.in_spk07_00 VSS VSS VDD VDD _04764_
+ sky130_fd_sc_hd__nand2b_1
X_15942_ _08665_ _04764_ net422 VSS VSS VDD VDD _01858_ sky130_fd_sc_hd__a21oi_1
X_15943_ network.in_spk04_00 network.in_spk05_00 _09337_ network.in_spk06_00
+ VSS VSS VDD VDD _04765_ sky130_fd_sc_hd__o31ai_1
X_15944_ _08638_ _04765_ net422 VSS VSS VDD VDD _01859_ sky130_fd_sc_hd__a21oi_1
X_15945_ network.in_spk04_00 _09337_ network.in_spk05_00 VSS
+ VSS VDD VDD _04766_ sky130_fd_sc_hd__o21ai_0
Xplace447 net447 VSS VSS VDD VDD net446 sky130_fd_sc_hd__buf_4
Xplace466 net466 VSS VSS VDD VDD net465 sky130_fd_sc_hd__buf_4
X_15948_ _08648_ _04766_ net422 VSS VSS VDD VDD _01860_ sky130_fd_sc_hd__a21oi_1
X_15949_ network.in_spk04_00 _09337_ VSS VSS VDD VDD _04769_
+ sky130_fd_sc_hd__nand2_1
X_15950_ _08630_ _04769_ net422 VSS VSS VDD VDD _01861_ sky130_fd_sc_hd__a21oi_1
X_15951_ network.in_spk00_00 network.in_spk01_00 network.in_spk02_00
+ network.in_spk03_00 VSS VSS VDD VDD _04770_ sky130_fd_sc_hd__o31ai_1
X_15952_ _08590_ _04770_ net422 VSS VSS VDD VDD _01862_ sky130_fd_sc_hd__a21oi_1
X_15953_ network.in_spk00_00 network.in_spk01_00 network.in_spk02_00
+ VSS VSS VDD VDD _04771_ sky130_fd_sc_hd__o21ai_0
X_15954_ _08604_ _04771_ net422 VSS VSS VDD VDD _01863_ sky130_fd_sc_hd__a21oi_1
X_15955_ network.in_spk00_00 network.in_spk01_00 VSS VSS VDD
+ VDD _04772_ sky130_fd_sc_hd__nand2_1
X_15956_ _08613_ _04772_ net422 VSS VSS VDD VDD _01864_ sky130_fd_sc_hd__a21oi_1
X_15957_ net422 _08608_ VSS VSS VDD VDD _01865_ sky130_fd_sc_hd__nor2_1
X_15958_ network.cnt_main.counter\[7\] _08811_ _03788_ VSS
+ VSS VDD VDD _04773_ sky130_fd_sc_hd__nor3_1
X_15959_ network.cnt_main.counter\[13\] _04773_ VSS VSS VDD
+ VDD _04774_ sky130_fd_sc_hd__xnor2_1
X_15960_ _03781_ _04774_ VSS VSS VDD VDD _01866_ sky130_fd_sc_hd__nor2_1
Xplace465 net468 VSS VSS VDD VDD net464 sky130_fd_sc_hd__buf_4
Xplace444 net445 VSS VSS VDD VDD net443 sky130_fd_sc_hd__buf_4
X_15963_ _08409_ net305 VSS VSS VDD VDD _01249_ sky130_fd_sc_hd__nand2_1
X_15964_ _08405_ net305 VSS VSS VDD VDD _01250_ sky130_fd_sc_hd__nand2_1
X_15965_ _08400_ net305 VSS VSS VDD VDD _01251_ sky130_fd_sc_hd__nand2_1
Xplace443 net443 VSS VSS VDD VDD net442 sky130_fd_sc_hd__buf_4
X_15967_ _08396_ net302 VSS VSS VDD VDD _01252_ sky130_fd_sc_hd__nand2_1
X_15968_ _08390_ net305 VSS VSS VDD VDD _01253_ sky130_fd_sc_hd__nand2_1
X_15969_ _08385_ net305 VSS VSS VDD VDD _01254_ sky130_fd_sc_hd__nand2_1
X_15970_ _08223_ net304 VSS VSS VDD VDD _01255_ sky130_fd_sc_hd__nand2_1
X_15971_ _08218_ net304 VSS VSS VDD VDD _01256_ sky130_fd_sc_hd__nand2_1
X_15972_ _08213_ net305 VSS VSS VDD VDD _01257_ sky130_fd_sc_hd__nand2_1
X_15973_ _08208_ net305 VSS VSS VDD VDD _01258_ sky130_fd_sc_hd__nand2_1
X_15974_ _08194_ net303 VSS VSS VDD VDD _01259_ sky130_fd_sc_hd__nand2_1
X_15975_ _07918_ net303 VSS VSS VDD VDD _01260_ sky130_fd_sc_hd__nand2_1
X_15976_ _07768_ net305 VSS VSS VDD VDD _01261_ sky130_fd_sc_hd__nand2_1
Xplace468 net468 VSS VSS VDD VDD net467 sky130_fd_sc_hd__buf_4
X_15978_ _07786_ net305 VSS VSS VDD VDD _01262_ sky130_fd_sc_hd__nand2_1
X_15979_ _07781_ net305 VSS VSS VDD VDD _01263_ sky130_fd_sc_hd__nand2_1
X_15980_ _07731_ net305 VSS VSS VDD VDD _01264_ sky130_fd_sc_hd__nand2_1
X_15981_ _07726_ net301 VSS VSS VDD VDD _01265_ sky130_fd_sc_hd__nand2_1
X_15982_ _07722_ net301 VSS VSS VDD VDD _01266_ sky130_fd_sc_hd__nand2_1
X_15983_ _07717_ net299 VSS VSS VDD VDD _01267_ sky130_fd_sc_hd__nand2_1
X_15984_ _07565_ net301 VSS VSS VDD VDD _01268_ sky130_fd_sc_hd__nand2_1
X_15985_ _07469_ net301 VSS VSS VDD VDD _01269_ sky130_fd_sc_hd__nand2_1
X_15986_ _07464_ net303 VSS VSS VDD VDD _01270_ sky130_fd_sc_hd__nand2_1
X_15987_ _07299_ net303 VSS VSS VDD VDD _01271_ sky130_fd_sc_hd__nand2_1
Xplace449 network.neuron_hid0.ROM0.address\[1\] VSS VSS VDD
+ VDD net448 sky130_fd_sc_hd__buf_4
X_15989_ _07459_ net303 VSS VSS VDD VDD _01272_ sky130_fd_sc_hd__nand2_1
X_15990_ _07294_ net299 VSS VSS VDD VDD _01273_ sky130_fd_sc_hd__nand2_1
X_15991_ _07574_ net303 VSS VSS VDD VDD _01274_ sky130_fd_sc_hd__nand2_1
X_15992_ _07569_ net299 VSS VSS VDD VDD _01275_ sky130_fd_sc_hd__nand2_1
X_15993_ _07179_ net303 VSS VSS VDD VDD _01276_ sky130_fd_sc_hd__nand2_1
X_15994_ _07284_ net303 VSS VSS VDD VDD _01277_ sky130_fd_sc_hd__nand2_1
X_15995_ _07268_ net303 VSS VSS VDD VDD _01278_ sky130_fd_sc_hd__nand2_1
X_15996_ _07217_ net303 VSS VSS VDD VDD _01279_ sky130_fd_sc_hd__nand2_1
X_15997_ _07254_ net303 VSS VSS VDD VDD _01280_ sky130_fd_sc_hd__nand2_1
X_15998_ _07188_ net298 VSS VSS VDD VDD _01281_ sky130_fd_sc_hd__nand2_1
Xplace446 network.neuron_hid0.ROM0.address\[2\] VSS VSS VDD
+ VDD net445 sky130_fd_sc_hd__buf_4
X_16000_ _07206_ net298 VSS VSS VDD VDD _01282_ sky130_fd_sc_hd__nand2_1
X_16001_ _07183_ net298 VSS VSS VDD VDD _01283_ sky130_fd_sc_hd__nand2_1
X_16002_ _07236_ net298 VSS VSS VDD VDD _01284_ sky130_fd_sc_hd__nand2_1
X_16003_ _07231_ net298 VSS VSS VDD VDD _01285_ sky130_fd_sc_hd__nand2_1
X_16004_ _07069_ net298 VSS VSS VDD VDD _01286_ sky130_fd_sc_hd__nand2_1
X_16005_ _07166_ net302 VSS VSS VDD VDD _01287_ sky130_fd_sc_hd__nand2_1
X_16006_ _07161_ net302 VSS VSS VDD VDD _01288_ sky130_fd_sc_hd__nand2_1
X_16007_ _07117_ net302 VSS VSS VDD VDD _01289_ sky130_fd_sc_hd__nand2_1
X_16008_ _07149_ net298 VSS VSS VDD VDD _01290_ sky130_fd_sc_hd__nand2_1
X_16009_ _07081_ net298 VSS VSS VDD VDD _01291_ sky130_fd_sc_hd__nand2_1
Xplace442 network.neuron_hid0.ROM0.address\[3\] VSS VSS VDD
+ VDD net441 sky130_fd_sc_hd__buf_4
X_16011_ _07103_ net298 VSS VSS VDD VDD _01292_ sky130_fd_sc_hd__nand2_1
X_16012_ _07076_ net298 VSS VSS VDD VDD _01293_ sky130_fd_sc_hd__nand2_1
X_16013_ _07135_ net298 VSS VSS VDD VDD _01294_ sky130_fd_sc_hd__nand2_1
X_16014_ _07130_ net298 VSS VSS VDD VDD _01295_ sky130_fd_sc_hd__nand2_1
X_16015_ _06938_ net298 VSS VSS VDD VDD _01296_ sky130_fd_sc_hd__nand2_1
X_16016_ _07056_ net298 VSS VSS VDD VDD _01297_ sky130_fd_sc_hd__nand2_1
X_16017_ _06953_ net298 VSS VSS VDD VDD _01298_ sky130_fd_sc_hd__nand2_1
X_16018_ _07034_ net298 VSS VSS VDD VDD _01299_ sky130_fd_sc_hd__nand2_1
X_16019_ _07029_ net298 VSS VSS VDD VDD _01300_ sky130_fd_sc_hd__nand2_1
X_16020_ _06948_ net298 VSS VSS VDD VDD _01301_ sky130_fd_sc_hd__nand2_1
Xplace441 net441 VSS VSS VDD VDD net440 sky130_fd_sc_hd__buf_4
X_16022_ _06972_ net298 VSS VSS VDD VDD _01302_ sky130_fd_sc_hd__nand2_1
X_16023_ _06943_ net298 VSS VSS VDD VDD _01303_ sky130_fd_sc_hd__nand2_1
X_16024_ _07016_ net298 VSS VSS VDD VDD _01304_ sky130_fd_sc_hd__nand2_1
X_16025_ _06994_ net298 VSS VSS VDD VDD _01305_ sky130_fd_sc_hd__nand2_1
X_16026_ _06825_ net298 VSS VSS VDD VDD _01306_ sky130_fd_sc_hd__nand2_1
X_16027_ _06923_ net298 VSS VSS VDD VDD _01307_ sky130_fd_sc_hd__nand2_1
X_16028_ _06844_ net305 VSS VSS VDD VDD _01308_ sky130_fd_sc_hd__nand2_1
X_16029_ _06917_ net298 VSS VSS VDD VDD _01309_ sky130_fd_sc_hd__nand2_1
X_16030_ _06912_ net305 VSS VSS VDD VDD _01310_ sky130_fd_sc_hd__nand2_1
X_16031_ _06840_ net302 VSS VSS VDD VDD _01311_ sky130_fd_sc_hd__nand2_1
Xplace440 net440 VSS VSS VDD VDD net439 sky130_fd_sc_hd__buf_4
X_16033_ _06859_ net302 VSS VSS VDD VDD _01312_ sky130_fd_sc_hd__nand2_1
X_16034_ _06830_ net304 VSS VSS VDD VDD _01313_ sky130_fd_sc_hd__nand2_1
X_16035_ _06888_ net304 VSS VSS VDD VDD _01314_ sky130_fd_sc_hd__nand2_1
X_16036_ _06882_ net304 VSS VSS VDD VDD _01315_ sky130_fd_sc_hd__nand2_1
X_16037_ _06706_ net304 VSS VSS VDD VDD _01316_ sky130_fd_sc_hd__nand2_1
X_16038_ _06752_ net304 VSS VSS VDD VDD _01317_ sky130_fd_sc_hd__nand2_1
X_16039_ _06718_ net304 VSS VSS VDD VDD _01318_ sky130_fd_sc_hd__nand2_1
X_16040_ _06798_ net304 VSS VSS VDD VDD _01319_ sky130_fd_sc_hd__nand2_1
X_16041_ _06793_ net304 VSS VSS VDD VDD _01320_ sky130_fd_sc_hd__nand2_1
X_16042_ _06714_ net304 VSS VSS VDD VDD _01321_ sky130_fd_sc_hd__nand2_1
Xplace334 _08693_ VSS VSS VDD VDD net333 sky130_fd_sc_hd__buf_4
X_16044_ _06738_ net304 VSS VSS VDD VDD _01322_ sky130_fd_sc_hd__nand2_1
X_16045_ _06710_ net304 VSS VSS VDD VDD _01323_ sky130_fd_sc_hd__nand2_1
X_16046_ _06776_ net304 VSS VSS VDD VDD _01324_ sky130_fd_sc_hd__nand2_1
X_16047_ _06771_ net304 VSS VSS VDD VDD _01325_ sky130_fd_sc_hd__nand2_1
X_16048_ network.neuron_in178.counter\[3\] _01152_ VSS VSS
+ VDD VDD _04785_ sky130_fd_sc_hd__nand2b_1
X_16049_ _04785_ _03597_ VSS VSS VDD VDD _04786_ sky130_fd_sc_hd__nand2b_1
X_16050_ net304 _04786_ VSS VSS VDD VDD _01326_ sky130_fd_sc_hd__nand2_1
X_16051_ _07791_ net304 VSS VSS VDD VDD _01327_ sky130_fd_sc_hd__nand2_1
X_16052_ _07845_ net304 VSS VSS VDD VDD _01328_ sky130_fd_sc_hd__nand2_1
X_16053_ _07840_ net303 VSS VSS VDD VDD _01329_ sky130_fd_sc_hd__nand2_1
X_16054_ _07812_ net304 VSS VSS VDD VDD _01330_ sky130_fd_sc_hd__nand2_1
X_16055_ _07834_ net304 VSS VSS VDD VDD _01331_ sky130_fd_sc_hd__nand2_1
X_16056_ _07796_ net304 VSS VSS VDD VDD _01332_ sky130_fd_sc_hd__nand2_1
Xplace436 net438 VSS VSS VDD VDD net435 sky130_fd_sc_hd__buf_4
X_16058_ _07830_ net304 VSS VSS VDD VDD _01333_ sky130_fd_sc_hd__nand2_1
X_16059_ _07825_ net304 VSS VSS VDD VDD _01334_ sky130_fd_sc_hd__nand2_1
X_16060_ _07802_ net303 VSS VSS VDD VDD _01335_ sky130_fd_sc_hd__nand2_1
X_16061_ _07820_ net303 VSS VSS VDD VDD _01336_ sky130_fd_sc_hd__nand2_1
X_16062_ _07851_ net303 VSS VSS VDD VDD _01337_ sky130_fd_sc_hd__nand2_1
X_16063_ net304 _03859_ VSS VSS VDD VDD _01338_ sky130_fd_sc_hd__nand2_1
X_16064_ net304 _03847_ VSS VSS VDD VDD _01339_ sky130_fd_sc_hd__nand2_1
X_16065_ net304 _03838_ VSS VSS VDD VDD _01340_ sky130_fd_sc_hd__nand2_1
X_16066_ net304 _03824_ VSS VSS VDD VDD _01341_ sky130_fd_sc_hd__nand2_1
X_16067_ _06691_ net304 VSS VSS VDD VDD _01342_ sky130_fd_sc_hd__nand2_1
X_16068_ _06686_ net303 VSS VSS VDD VDD _01343_ sky130_fd_sc_hd__nand2_1
X_16069_ _06681_ net304 VSS VSS VDD VDD _01344_ sky130_fd_sc_hd__nand2_1
X_16070_ _06665_ net299 VSS VSS VDD VDD _01345_ sky130_fd_sc_hd__nand2_1
X_16071_ network.neuron_in158.counter\[3\] _00712_ VSS VSS
+ VDD VDD _04788_ sky130_fd_sc_hd__nand2b_1
X_16072_ network.neuron_in158.counter\[2\] VSS VSS VDD VDD
+ _04789_ sky130_fd_sc_hd__inv_1
X_16073_ _04788_ _04789_ VSS VSS VDD VDD _04790_ sky130_fd_sc_hd__nand2b_1
X_16074_ net299 _04790_ VSS VSS VDD VDD _01346_ sky130_fd_sc_hd__nand2_1
X_16075_ _07242_ net299 VSS VSS VDD VDD _01347_ sky130_fd_sc_hd__nand2_1
Xplace435 net438 VSS VSS VDD VDD net434 sky130_fd_sc_hd__buf_4
X_16077_ net300 _03906_ VSS VSS VDD VDD _01348_ sky130_fd_sc_hd__nand2_1
Xplace434 net434 VSS VSS VDD VDD net433 sky130_fd_sc_hd__buf_4
X_16079_ _06835_ net303 VSS VSS VDD VDD _01349_ sky130_fd_sc_hd__nand2_1
X_16080_ _07051_ net303 VSS VSS VDD VDD _01350_ sky130_fd_sc_hd__nand2_1
X_16081_ _07040_ net299 VSS VSS VDD VDD _01351_ sky130_fd_sc_hd__nand2_1
X_16082_ network.neuron_in152.counter\[2\] _00565_ VSS VSS
+ VDD VDD _04793_ sky130_fd_sc_hd__nand2b_1
X_16083_ network.neuron_in152.counter\[3\] _04793_ VSS VSS
+ VDD VDD _04794_ sky130_fd_sc_hd__or2_2
X_16084_ net299 _04794_ VSS VSS VDD VDD _01352_ sky130_fd_sc_hd__nand2_1
X_16085_ network.neuron_in151.counter\[3\] VSS VSS VDD VDD
+ _04795_ sky130_fd_sc_hd__inv_1
X_16086_ _08230_ _00573_ _04795_ VSS VSS VDD VDD _04796_ sky130_fd_sc_hd__nand3_1
X_16087_ net303 _04796_ VSS VSS VDD VDD _01353_ sky130_fd_sc_hd__nand2_1
X_16088_ _08363_ net303 VSS VSS VDD VDD _01354_ sky130_fd_sc_hd__nand2_1
X_16089_ net303 _04391_ VSS VSS VDD VDD _01355_ sky130_fd_sc_hd__nand2_1
X_16090_ _07011_ net303 VSS VSS VDD VDD _01356_ sky130_fd_sc_hd__nand2_1
X_16091_ net303 _03882_ VSS VSS VDD VDD _01357_ sky130_fd_sc_hd__nand2_1
X_16092_ _06963_ net304 VSS VSS VDD VDD _01358_ sky130_fd_sc_hd__nand2_1
X_16093_ _06899_ net303 VSS VSS VDD VDD _01359_ sky130_fd_sc_hd__nand2_1
X_16094_ _06999_ net303 VSS VSS VDD VDD _01360_ sky130_fd_sc_hd__nand2_1
X_16095_ _07003_ net302 VSS VSS VDD VDD _01361_ sky130_fd_sc_hd__nand2_1
X_16096_ _07047_ net302 VSS VSS VDD VDD _01362_ sky130_fd_sc_hd__nand2_1
Xplace430 net430 VSS VSS VDD VDD net429 sky130_fd_sc_hd__buf_4
X_16098_ _07155_ net301 VSS VSS VDD VDD _01363_ sky130_fd_sc_hd__nand2_1
X_16099_ _06756_ net301 VSS VSS VDD VDD _01364_ sky130_fd_sc_hd__nand2_1
X_16100_ _03495_ net301 VSS VSS VDD VDD _01365_ sky130_fd_sc_hd__nand2_1
X_16101_ _03577_ net301 VSS VSS VDD VDD _01366_ sky130_fd_sc_hd__nand2_1
X_16102_ _06821_ net301 VSS VSS VDD VDD _01367_ sky130_fd_sc_hd__nand2_1
X_16103_ _06727_ net301 VSS VSS VDD VDD _01368_ sky130_fd_sc_hd__nand2_1
X_16104_ _08199_ net301 VSS VSS VDD VDD _01369_ sky130_fd_sc_hd__nand2_1
X_16105_ _07263_ net301 VSS VSS VDD VDD _01370_ sky130_fd_sc_hd__nand2_1
X_16106_ _07090_ net301 VSS VSS VDD VDD _01371_ sky130_fd_sc_hd__nand2_1
X_16107_ net301 _04050_ VSS VSS VDD VDD _01372_ sky130_fd_sc_hd__nand2_1
X_16108_ _03726_ net301 VSS VSS VDD VDD _01373_ sky130_fd_sc_hd__nand2_1
Xplace335 _07976_ VSS VSS VDD VDD net334 sky130_fd_sc_hd__buf_4
X_16110_ _03669_ net301 VSS VSS VDD VDD _01374_ sky130_fd_sc_hd__nand2_1
X_16111_ _06908_ net301 VSS VSS VDD VDD _01375_ sky130_fd_sc_hd__nand2_1
X_16112_ _07279_ net300 VSS VSS VDD VDD _01376_ sky130_fd_sc_hd__nand2_1
X_16113_ network.neuron_in127.counter\[2\] network.neuron_in127.counter\[3\]
+ VSS VSS VDD VDD _04799_ sky130_fd_sc_hd__nor2_1
X_16114_ _01114_ _04799_ VSS VSS VDD VDD _04800_ sky130_fd_sc_hd__nand2_1
X_16115_ net300 _04800_ VSS VSS VDD VDD _01377_ sky130_fd_sc_hd__nand2_1
X_16116_ network.neuron_in126.counter\[3\] _00767_ VSS VSS
+ VDD VDD _04801_ sky130_fd_sc_hd__nand2b_1
X_16117_ network.neuron_in126.counter\[2\] VSS VSS VDD VDD
+ _04802_ sky130_fd_sc_hd__inv_1
X_16118_ _04801_ _04802_ VSS VSS VDD VDD _04803_ sky130_fd_sc_hd__nand2b_1
X_16119_ net300 _04803_ VSS VSS VDD VDD _01378_ sky130_fd_sc_hd__nand2_1
X_16120_ network.neuron_in125.counter\[2\] _00597_ VSS VSS
+ VDD VDD _04804_ sky130_fd_sc_hd__nand2b_1
X_16121_ network.neuron_in125.counter\[3\] _04804_ VSS VSS
+ VDD VDD _04805_ sky130_fd_sc_hd__or2_2
X_16122_ net300 _04805_ VSS VSS VDD VDD _01379_ sky130_fd_sc_hd__nand2_1
X_16123_ network.neuron_in124.counter\[3\] _00405_ VSS VSS
+ VDD VDD _04806_ sky130_fd_sc_hd__nand2b_1
X_16124_ network.neuron_in124.counter\[2\] VSS VSS VDD VDD
+ _04807_ sky130_fd_sc_hd__inv_1
X_16125_ _04806_ _04807_ VSS VSS VDD VDD _04808_ sky130_fd_sc_hd__nand2b_1
X_16126_ net300 _04808_ VSS VSS VDD VDD _01380_ sky130_fd_sc_hd__nand2_1
Xplace437 net437 VSS VSS VDD VDD net436 sky130_fd_sc_hd__buf_4
X_16128_ network.neuron_in123.counter\[2\] VSS VSS VDD VDD
+ _04810_ sky130_fd_sc_hd__inv_1
X_16129_ _04810_ _00241_ VSS VSS VDD VDD _04811_ sky130_fd_sc_hd__nand2_1
X_16130_ network.neuron_in123.counter\[3\] _04811_ VSS VSS
+ VDD VDD _04812_ sky130_fd_sc_hd__or2_2
X_16131_ net300 _04812_ VSS VSS VDD VDD _01381_ sky130_fd_sc_hd__nand2_1
X_16132_ network.neuron_in122.counter\[3\] _01052_ VSS VSS
+ VDD VDD _04813_ sky130_fd_sc_hd__nand2b_1
X_16133_ network.neuron_in122.counter\[2\] VSS VSS VDD VDD
+ _04814_ sky130_fd_sc_hd__inv_1
X_16134_ _04813_ _04814_ VSS VSS VDD VDD _04815_ sky130_fd_sc_hd__nand2b_1
X_16135_ net300 _04815_ VSS VSS VDD VDD _01382_ sky130_fd_sc_hd__nand2_1
X_16136_ network.neuron_in121.counter\[2\] network.neuron_in121.counter\[3\]
+ VSS VSS VDD VDD _04816_ sky130_fd_sc_hd__nor2_1
X_16137_ _00641_ _04816_ VSS VSS VDD VDD _04817_ sky130_fd_sc_hd__nand2_1
X_16138_ net300 _04817_ VSS VSS VDD VDD _01383_ sky130_fd_sc_hd__nand2_1
X_16139_ network.neuron_in120.counter\[3\] _00968_ VSS VSS
+ VDD VDD _04818_ sky130_fd_sc_hd__nand2b_1
X_16140_ network.neuron_in120.counter\[2\] VSS VSS VDD VDD
+ _04819_ sky130_fd_sc_hd__inv_1
X_16141_ _04818_ _04819_ VSS VSS VDD VDD _04820_ sky130_fd_sc_hd__nand2b_1
X_16142_ net300 _04820_ VSS VSS VDD VDD _01384_ sky130_fd_sc_hd__nand2_1
X_16143_ network.neuron_in119.counter\[3\] _00653_ VSS VSS
+ VDD VDD _04821_ sky130_fd_sc_hd__nand2b_1
X_16144_ network.neuron_in119.counter\[2\] VSS VSS VDD VDD
+ _04822_ sky130_fd_sc_hd__inv_1
X_16145_ _04821_ _04822_ VSS VSS VDD VDD _04823_ sky130_fd_sc_hd__nand2b_1
X_16146_ net299 _04823_ VSS VSS VDD VDD _01385_ sky130_fd_sc_hd__nand2_1
X_16147_ network.neuron_in118.counter\[2\] VSS VSS VDD VDD
+ _04824_ sky130_fd_sc_hd__inv_1
X_16148_ _04824_ _00120_ VSS VSS VDD VDD _04825_ sky130_fd_sc_hd__nand2_1
X_16149_ network.neuron_in118.counter\[3\] _04825_ VSS VSS
+ VDD VDD _04826_ sky130_fd_sc_hd__or2_2
X_16150_ net300 _04826_ VSS VSS VDD VDD _01386_ sky130_fd_sc_hd__nand2_1
X_16151_ network.neuron_in117.counter\[2\] network.neuron_in117.counter\[3\]
+ VSS VSS VDD VDD _04827_ sky130_fd_sc_hd__nor2_1
X_16152_ _00064_ _04827_ VSS VSS VDD VDD _04828_ sky130_fd_sc_hd__nand2_1
X_16153_ net299 _04828_ VSS VSS VDD VDD _01387_ sky130_fd_sc_hd__nand2_1
X_16154_ network.neuron_in116.counter\[3\] _00072_ VSS VSS
+ VDD VDD _04829_ sky130_fd_sc_hd__nand2b_1
X_16155_ network.neuron_in116.counter\[2\] _04829_ VSS VSS
+ VDD VDD _04830_ sky130_fd_sc_hd__or2_2
X_16156_ net299 _04830_ VSS VSS VDD VDD _01388_ sky130_fd_sc_hd__nand2_1
X_16157_ network.neuron_in115.counter\[3\] _01210_ VSS VSS
+ VDD VDD _04831_ sky130_fd_sc_hd__nand2b_1
X_16158_ network.neuron_in115.counter\[2\] VSS VSS VDD VDD
+ _04832_ sky130_fd_sc_hd__inv_1
X_16159_ _04831_ _04832_ VSS VSS VDD VDD _04833_ sky130_fd_sc_hd__nand2b_1
X_16160_ net299 _04833_ VSS VSS VDD VDD _01389_ sky130_fd_sc_hd__nand2_1
X_16161_ network.neuron_in114.counter\[3\] _01247_ VSS VSS
+ VDD VDD _04834_ sky130_fd_sc_hd__nand2b_1
X_16162_ network.neuron_in114.counter\[2\] _04834_ VSS VSS
+ VDD VDD _04835_ sky130_fd_sc_hd__or2_2
X_16163_ net299 _04835_ VSS VSS VDD VDD _01390_ sky130_fd_sc_hd__nand2_1
Xplace336 _07959_ VSS VSS VDD VDD net335 sky130_fd_sc_hd__buf_4
X_16165_ network.neuron_in113.counter\[3\] _01004_ VSS VSS
+ VDD VDD _04837_ sky130_fd_sc_hd__nand2b_1
X_16166_ network.neuron_in113.counter\[2\] VSS VSS VDD VDD
+ _04838_ sky130_fd_sc_hd__inv_1
X_16167_ _04837_ _04838_ VSS VSS VDD VDD _04839_ sky130_fd_sc_hd__nand2b_1
X_16168_ net299 _04839_ VSS VSS VDD VDD _01391_ sky130_fd_sc_hd__nand2_1
X_16169_ network.neuron_in112.counter\[2\] VSS VSS VDD VDD
+ _04840_ sky130_fd_sc_hd__inv_1
X_16170_ _04840_ _00771_ VSS VSS VDD VDD _04841_ sky130_fd_sc_hd__nand2_1
X_16171_ network.neuron_in112.counter\[3\] _04841_ VSS VSS
+ VDD VDD _04842_ sky130_fd_sc_hd__or2_2
X_16172_ net299 _04842_ VSS VSS VDD VDD _01392_ sky130_fd_sc_hd__nand2_1
X_16173_ network.neuron_in111.counter\[3\] _00649_ VSS VSS
+ VDD VDD _04843_ sky130_fd_sc_hd__nand2b_1
X_16174_ network.neuron_in111.counter\[2\] VSS VSS VDD VDD
+ _04844_ sky130_fd_sc_hd__inv_1
X_16175_ _04843_ _04844_ VSS VSS VDD VDD _04845_ sky130_fd_sc_hd__nand2b_1
X_16176_ net299 _04845_ VSS VSS VDD VDD _01393_ sky130_fd_sc_hd__nand2_1
X_16177_ network.neuron_in110.counter\[3\] _00160_ VSS VSS
+ VDD VDD _04846_ sky130_fd_sc_hd__nand2b_1
X_16178_ network.neuron_in110.counter\[2\] VSS VSS VDD VDD
+ _04847_ sky130_fd_sc_hd__inv_1
X_16179_ _04846_ _04847_ VSS VSS VDD VDD _04848_ sky130_fd_sc_hd__nand2b_1
X_16180_ net299 _04848_ VSS VSS VDD VDD _01394_ sky130_fd_sc_hd__nand2_1
X_16181_ network.neuron_in109.counter\[2\] network.neuron_in109.counter\[3\]
+ VSS VSS VDD VDD _04849_ sky130_fd_sc_hd__nor2_1
X_16182_ _00223_ _04849_ VSS VSS VDD VDD _04850_ sky130_fd_sc_hd__nand2_1
X_16183_ net299 _04850_ VSS VSS VDD VDD _01395_ sky130_fd_sc_hd__nand2_1
X_16184_ network.neuron_in108.counter\[3\] _01022_ VSS VSS
+ VDD VDD _04851_ sky130_fd_sc_hd__nand2b_1
X_16185_ network.neuron_in108.counter\[2\] VSS VSS VDD VDD
+ _04852_ sky130_fd_sc_hd__inv_1
X_16186_ _04851_ _04852_ VSS VSS VDD VDD _04853_ sky130_fd_sc_hd__nand2b_1
X_16187_ net299 _04853_ VSS VSS VDD VDD _01396_ sky130_fd_sc_hd__nand2_1
X_16188_ network.neuron_in107.counter\[3\] _00605_ VSS VSS
+ VDD VDD _04854_ sky130_fd_sc_hd__nand2b_1
X_16189_ network.neuron_in107.counter\[2\] VSS VSS VDD VDD
+ _04855_ sky130_fd_sc_hd__inv_1
X_16190_ _04854_ _04855_ VSS VSS VDD VDD _04856_ sky130_fd_sc_hd__nand2b_1
X_16191_ net299 _04856_ VSS VSS VDD VDD _01397_ sky130_fd_sc_hd__nand2_1
X_16192_ network.neuron_in106.counter\[3\] _00716_ VSS VSS
+ VDD VDD _04857_ sky130_fd_sc_hd__nand2b_1
X_16193_ network.neuron_in106.counter\[2\] VSS VSS VDD VDD
+ _04858_ sky130_fd_sc_hd__inv_1
X_16194_ _04857_ _04858_ VSS VSS VDD VDD _04859_ sky130_fd_sc_hd__nand2b_1
X_16195_ net299 _04859_ VSS VSS VDD VDD _01398_ sky130_fd_sc_hd__nand2_1
X_16196_ network.neuron_in105.counter\[2\] VSS VSS VDD VDD
+ _04860_ sky130_fd_sc_hd__inv_1
X_16197_ _04860_ _00557_ VSS VSS VDD VDD _04861_ sky130_fd_sc_hd__nand2_1
X_16198_ network.neuron_in105.counter\[3\] _04861_ VSS VSS
+ VDD VDD _04862_ sky130_fd_sc_hd__or2_2
X_16199_ net303 _04862_ VSS VSS VDD VDD _01399_ sky130_fd_sc_hd__nand2_1
X_16200_ network.neuron_in104.counter\[3\] _00936_ VSS VSS
+ VDD VDD _04863_ sky130_fd_sc_hd__nand2b_1
X_16201_ network.neuron_in104.counter\[2\] VSS VSS VDD VDD
+ _04864_ sky130_fd_sc_hd__inv_1
X_16202_ _04863_ _04864_ VSS VSS VDD VDD _04865_ sky130_fd_sc_hd__nand2b_1
X_16203_ net299 _04865_ VSS VSS VDD VDD _01400_ sky130_fd_sc_hd__nand2_1
Xplace452 network.neuron_hid0.ROM0.address\[0\] VSS VSS VDD
+ VDD net451 sky130_fd_sc_hd__buf_4
X_16205_ network.neuron_in103.counter\[3\] _00114_ VSS VSS
+ VDD VDD _04867_ sky130_fd_sc_hd__nand2b_1
X_16206_ network.neuron_in103.counter\[2\] VSS VSS VDD VDD
+ _04868_ sky130_fd_sc_hd__inv_1
X_16207_ _04867_ _04868_ VSS VSS VDD VDD _04869_ sky130_fd_sc_hd__nand2b_1
X_16208_ net299 _04869_ VSS VSS VDD VDD _01401_ sky130_fd_sc_hd__nand2_1
X_16209_ network.neuron_in102.counter\[3\] _00215_ VSS VSS
+ VDD VDD _04870_ sky130_fd_sc_hd__nand2b_1
X_16210_ network.neuron_in102.counter\[2\] VSS VSS VDD VDD
+ _04871_ sky130_fd_sc_hd__inv_1
X_16211_ _04870_ _04871_ VSS VSS VDD VDD _04872_ sky130_fd_sc_hd__nand2b_1
X_16212_ net303 _04872_ VSS VSS VDD VDD _01402_ sky130_fd_sc_hd__nand2_1
X_16213_ network.neuron_in101.counter\[2\] network.neuron_in101.counter\[3\]
+ VSS VSS VDD VDD _04873_ sky130_fd_sc_hd__nor2_1
X_16214_ _01176_ _04873_ VSS VSS VDD VDD _04874_ sky130_fd_sc_hd__nand2_1
X_16215_ net303 _04874_ VSS VSS VDD VDD _01403_ sky130_fd_sc_hd__nand2_1
X_16216_ network.neuron_in100.counter\[3\] _00874_ VSS VSS
+ VDD VDD _04875_ sky130_fd_sc_hd__nand2b_1
X_16217_ network.neuron_in100.counter\[2\] VSS VSS VDD VDD
+ _04876_ sky130_fd_sc_hd__inv_1
X_16218_ _04875_ _04876_ VSS VSS VDD VDD _04877_ sky130_fd_sc_hd__nand2b_1
X_16219_ net303 _04877_ VSS VSS VDD VDD _01404_ sky130_fd_sc_hd__nand2_1
X_16220_ network.neuron_in099.counter\[3\] _00748_ VSS VSS
+ VDD VDD _04878_ sky130_fd_sc_hd__nand2b_1
X_16221_ network.neuron_in099.counter\[2\] VSS VSS VDD VDD
+ _04879_ sky130_fd_sc_hd__inv_1
X_16222_ _04878_ _04879_ VSS VSS VDD VDD _04880_ sky130_fd_sc_hd__nand2b_1
X_16223_ net303 _04880_ VSS VSS VDD VDD _01405_ sky130_fd_sc_hd__nand2_1
X_16224_ network.neuron_in098.counter\[3\] _00781_ VSS VSS
+ VDD VDD _04881_ sky130_fd_sc_hd__nand2b_1
X_16225_ network.neuron_in098.counter\[2\] VSS VSS VDD VDD
+ _04882_ sky130_fd_sc_hd__inv_1
X_16226_ _04881_ _04882_ VSS VSS VDD VDD _04883_ sky130_fd_sc_hd__nand2b_1
X_16227_ net303 _04883_ VSS VSS VDD VDD _01406_ sky130_fd_sc_hd__nand2_1
X_16228_ net299 _04584_ VSS VSS VDD VDD _01407_ sky130_fd_sc_hd__nand2_1
X_16229_ net299 _04589_ VSS VSS VDD VDD _01408_ sky130_fd_sc_hd__nand2_1
X_16230_ net303 _04593_ VSS VSS VDD VDD _01409_ sky130_fd_sc_hd__nand2_1
X_16231_ net303 _04599_ VSS VSS VDD VDD _01410_ sky130_fd_sc_hd__nand2_1
Xplace445 net445 VSS VSS VDD VDD net444 sky130_fd_sc_hd__buf_4
X_16233_ net299 _04602_ VSS VSS VDD VDD _01411_ sky130_fd_sc_hd__nand2_1
X_16234_ net299 _04606_ VSS VSS VDD VDD _01412_ sky130_fd_sc_hd__nand2_1
X_16235_ net304 _04609_ VSS VSS VDD VDD _01413_ sky130_fd_sc_hd__nand2_1
X_16236_ net303 _04613_ VSS VSS VDD VDD _01414_ sky130_fd_sc_hd__nand2_1
X_16237_ net304 _04617_ VSS VSS VDD VDD _01415_ sky130_fd_sc_hd__nand2_1
X_16238_ net303 _04621_ VSS VSS VDD VDD _01416_ sky130_fd_sc_hd__nand2_1
X_16239_ net304 _04624_ VSS VSS VDD VDD _01417_ sky130_fd_sc_hd__nand2_1
X_16240_ net304 _04628_ VSS VSS VDD VDD _01418_ sky130_fd_sc_hd__nand2_1
X_16241_ net304 _04631_ VSS VSS VDD VDD _01419_ sky130_fd_sc_hd__nand2_1
X_16242_ net304 _04635_ VSS VSS VDD VDD _01420_ sky130_fd_sc_hd__nand2_1
Xplace337 _07931_ VSS VSS VDD VDD net336 sky130_fd_sc_hd__buf_4
X_16244_ net304 _04638_ VSS VSS VDD VDD _01421_ sky130_fd_sc_hd__nand2_1
X_16245_ net304 _04642_ VSS VSS VDD VDD _01422_ sky130_fd_sc_hd__nand2_1
X_16246_ net303 _04645_ VSS VSS VDD VDD _01423_ sky130_fd_sc_hd__nand2_1
X_16247_ net303 _04649_ VSS VSS VDD VDD _01424_ sky130_fd_sc_hd__nand2_1
X_16248_ net300 _04653_ VSS VSS VDD VDD _01425_ sky130_fd_sc_hd__nand2_1
X_16249_ net300 _04656_ VSS VSS VDD VDD _01426_ sky130_fd_sc_hd__nand2_1
X_16250_ net300 _04660_ VSS VSS VDD VDD _01427_ sky130_fd_sc_hd__nand2_1
X_16251_ net300 _04666_ VSS VSS VDD VDD _01428_ sky130_fd_sc_hd__nand2_1
X_16252_ net300 _04670_ VSS VSS VDD VDD _01429_ sky130_fd_sc_hd__nand2_1
X_16253_ net299 _04524_ VSS VSS VDD VDD _01430_ sky130_fd_sc_hd__nand2_1
Xplace338 _07688_ VSS VSS VDD VDD net337 sky130_fd_sc_hd__buf_4
X_16255_ net300 _04542_ VSS VSS VDD VDD _01431_ sky130_fd_sc_hd__nand2_1
X_16256_ net299 _04529_ VSS VSS VDD VDD _01432_ sky130_fd_sc_hd__nand2_1
X_16257_ net300 _04535_ VSS VSS VDD VDD _01433_ sky130_fd_sc_hd__nand2_1
X_16258_ net299 _04510_ VSS VSS VDD VDD _01434_ sky130_fd_sc_hd__nand2_1
X_16259_ net299 _04505_ VSS VSS VDD VDD _01435_ sky130_fd_sc_hd__nand2_1
X_16260_ net299 _04496_ VSS VSS VDD VDD _01436_ sky130_fd_sc_hd__nand2_1
X_16261_ net300 _04438_ VSS VSS VDD VDD _01437_ sky130_fd_sc_hd__nand2_1
X_16262_ net300 _04461_ VSS VSS VDD VDD _01438_ sky130_fd_sc_hd__nand2_1
X_16263_ net300 _04456_ VSS VSS VDD VDD _01439_ sky130_fd_sc_hd__nand2_1
X_16264_ net300 _04399_ VSS VSS VDD VDD _01440_ sky130_fd_sc_hd__nand2_1
Xplace469 net20 VSS VSS VDD VDD net468 sky130_fd_sc_hd__buf_4
X_16266_ net301 _04433_ VSS VSS VDD VDD _01441_ sky130_fd_sc_hd__nand2_1
X_16267_ net301 _04403_ VSS VSS VDD VDD _01442_ sky130_fd_sc_hd__nand2_1
X_16268_ net300 _04421_ VSS VSS VDD VDD _01443_ sky130_fd_sc_hd__nand2_1
X_16269_ net301 _04325_ VSS VSS VDD VDD _01444_ sky130_fd_sc_hd__nand2_1
X_16270_ net300 _04330_ VSS VSS VDD VDD _01445_ sky130_fd_sc_hd__nand2_1
X_16271_ net300 _04368_ VSS VSS VDD VDD _01446_ sky130_fd_sc_hd__nand2_1
X_16272_ net301 _04274_ VSS VSS VDD VDD _01447_ sky130_fd_sc_hd__nand2_1
X_16273_ net300 _04302_ VSS VSS VDD VDD _01448_ sky130_fd_sc_hd__nand2_1
X_16274_ net300 _04297_ VSS VSS VDD VDD _01449_ sky130_fd_sc_hd__nand2_1
X_16275_ net300 _04311_ VSS VSS VDD VDD _01450_ sky130_fd_sc_hd__nand2_1
Xplace467 net467 VSS VSS VDD VDD net466 sky130_fd_sc_hd__buf_4
X_16277_ net300 _04288_ VSS VSS VDD VDD _01451_ sky130_fd_sc_hd__nand2_1
X_16278_ net300 _04266_ VSS VSS VDD VDD _01452_ sky130_fd_sc_hd__nand2_1
X_16279_ net300 _04214_ VSS VSS VDD VDD _01453_ sky130_fd_sc_hd__nand2_1
X_16280_ net301 _04206_ VSS VSS VDD VDD _01454_ sky130_fd_sc_hd__nand2_1
X_16281_ net301 _04186_ VSS VSS VDD VDD _01455_ sky130_fd_sc_hd__nand2_1
X_16282_ net300 _04201_ VSS VSS VDD VDD _01456_ sky130_fd_sc_hd__nand2_1
X_16283_ net298 _04195_ VSS VSS VDD VDD _01457_ sky130_fd_sc_hd__nand2_1
X_16284_ net298 _04158_ VSS VSS VDD VDD _01458_ sky130_fd_sc_hd__nand2_1
X_16285_ net298 _04154_ VSS VSS VDD VDD _01459_ sky130_fd_sc_hd__nand2_1
X_16286_ net298 _04167_ VSS VSS VDD VDD _01460_ sky130_fd_sc_hd__nand2_1
X_16287_ net302 _04162_ VSS VSS VDD VDD _01461_ sky130_fd_sc_hd__nand2_1
X_16288_ net298 _03872_ VSS VSS VDD VDD _01462_ sky130_fd_sc_hd__nand2_1
X_16289_ net302 _03920_ VSS VSS VDD VDD _01463_ sky130_fd_sc_hd__nand2_1
X_16290_ net298 _03901_ VSS VSS VDD VDD _01464_ sky130_fd_sc_hd__nand2_1
X_16291_ _03765_ net302 VSS VSS VDD VDD _01465_ sky130_fd_sc_hd__nand2_1
X_16292_ net298 _03807_ VSS VSS VDD VDD _01466_ sky130_fd_sc_hd__nand2_1
X_16293_ _03770_ net298 VSS VSS VDD VDD _01467_ sky130_fd_sc_hd__nand2_1
X_16294_ net302 _03829_ VSS VSS VDD VDD _01468_ sky130_fd_sc_hd__nand2_1
X_16295_ _03733_ net302 VSS VSS VDD VDD _01469_ sky130_fd_sc_hd__nand2_1
X_16296_ _03723_ net302 VSS VSS VDD VDD _01470_ sky130_fd_sc_hd__nand2_1
X_16297_ _03739_ net301 VSS VSS VDD VDD _01471_ sky130_fd_sc_hd__nand2_1
Xplace324 _09323_ VSS VSS VDD VDD net323 sky130_fd_sc_hd__buf_4
X_16299_ network.neuron_in032.counter\[3\] _03708_ net301
+ VSS VSS VDD VDD _01472_ sky130_fd_sc_hd__o21ai_0
X_16300_ _03705_ net302 VSS VSS VDD VDD _01473_ sky130_fd_sc_hd__nand2_1
X_16301_ _03677_ net302 VSS VSS VDD VDD _01474_ sky130_fd_sc_hd__nand2_1
Xclkbuf_2_1__f_clk_regs clknet_0_clk_regs VSS VSS VDD VDD
+ clknet_2_1__leaf_clk_regs sky130_fd_sc_hd__clkbuf_16
X_16303_ _07904_ net301 VSS VSS VDD VDD _01475_ sky130_fd_sc_hd__nand2_1
X_16304_ _07892_ net302 VSS VSS VDD VDD _01476_ sky130_fd_sc_hd__nand2_1
X_16305_ net301 _04738_ VSS VSS VDD VDD _01477_ sky130_fd_sc_hd__nand2_1
X_16306_ _03699_ net301 VSS VSS VDD VDD _01478_ sky130_fd_sc_hd__nand2_1
X_16307_ _03683_ net302 VSS VSS VDD VDD _01479_ sky130_fd_sc_hd__nand2_1
X_16308_ _03664_ net302 VSS VSS VDD VDD _01480_ sky130_fd_sc_hd__nand2_1
X_16309_ _03655_ net301 VSS VSS VDD VDD _01481_ sky130_fd_sc_hd__nand2_1
X_16310_ _03646_ net301 VSS VSS VDD VDD _01482_ sky130_fd_sc_hd__nand2_1
X_16311_ _03636_ net301 VSS VSS VDD VDD _01483_ sky130_fd_sc_hd__nand2_1
X_16312_ _03627_ net301 VSS VSS VDD VDD _01484_ sky130_fd_sc_hd__nand2_1
X_16313_ _03617_ net301 VSS VSS VDD VDD _01485_ sky130_fd_sc_hd__nand2_1
Xplace460 net462 VSS VSS VDD VDD net459 sky130_fd_sc_hd__buf_4
X_16315_ _03607_ net301 VSS VSS VDD VDD _01486_ sky130_fd_sc_hd__nand2_1
X_16316_ _03572_ net301 VSS VSS VDD VDD _01487_ sky130_fd_sc_hd__nand2_1
X_16317_ _03588_ net301 VSS VSS VDD VDD _01488_ sky130_fd_sc_hd__nand2_1
X_16318_ _03562_ net302 VSS VSS VDD VDD _01489_ sky130_fd_sc_hd__nand2_1
X_16319_ _03541_ net301 VSS VSS VDD VDD _01490_ sky130_fd_sc_hd__nand2_1
X_16320_ _03545_ net302 VSS VSS VDD VDD _01491_ sky130_fd_sc_hd__nand2_1
X_16321_ _03531_ net302 VSS VSS VDD VDD _01492_ sky130_fd_sc_hd__nand2_1
X_16322_ _03521_ net302 VSS VSS VDD VDD _01493_ sky130_fd_sc_hd__nand2_1
X_16323_ _03512_ net298 VSS VSS VDD VDD _01494_ sky130_fd_sc_hd__nand2_1
X_16324_ _03503_ net302 VSS VSS VDD VDD _01495_ sky130_fd_sc_hd__nand2_1
X_16325_ _08671_ net298 VSS VSS VDD VDD _01496_ sky130_fd_sc_hd__nand2_1
X_16326_ _08665_ net298 VSS VSS VDD VDD _01497_ sky130_fd_sc_hd__nand2_1
X_16327_ _08638_ net302 VSS VSS VDD VDD _01498_ sky130_fd_sc_hd__nand2_1
X_16328_ _08648_ net302 VSS VSS VDD VDD _01499_ sky130_fd_sc_hd__nand2_1
X_16329_ _08630_ net302 VSS VSS VDD VDD _01500_ sky130_fd_sc_hd__nand2_1
X_16330_ _08590_ net302 VSS VSS VDD VDD _01501_ sky130_fd_sc_hd__nand2_1
X_16331_ _08604_ net301 VSS VSS VDD VDD _01502_ sky130_fd_sc_hd__nand2_1
X_16332_ _08613_ net302 VSS VSS VDD VDD _01503_ sky130_fd_sc_hd__nand2_1
X_16333_ _08608_ net298 VSS VSS VDD VDD _01504_ sky130_fd_sc_hd__nand2_1
X_16334_ network.in_spk10_14 network.in_spk09_14 network.in_spk08_14
+ _09418_ network.in_spk11_14 VSS VSS VDD VDD _04892_ sky130_fd_sc_hd__o41ai_1
X_16335_ _07469_ _04892_ net413 VSS VSS VDD VDD _01867_ sky130_fd_sc_hd__a21oi_1
X_16336_ _09263_ _09326_ network.in_spk12_14 VSS VSS VDD VDD
+ _04893_ sky130_fd_sc_hd__o21ai_0
X_16337_ _07565_ _04893_ net413 VSS VSS VDD VDD _01868_ sky130_fd_sc_hd__a21oi_1
X_16338_ _09423_ _09426_ network.in_spk07_14 VSS VSS VDD VDD
+ _04894_ sky130_fd_sc_hd__o21ai_0
X_16339_ _07294_ _04894_ net413 VSS VSS VDD VDD _01869_ sky130_fd_sc_hd__a21oi_1
X_16340_ network.neuron_hid6.IF0.ref_counter\[1\] VSS VSS
+ VDD VDD _00090_ sky130_fd_sc_hd__inv_1
X_16341_ _04117_ _04127_ VSS VSS VDD VDD _03143_ sky130_fd_sc_hd__nor2_1
X_16342_ network.in_spk08_14 _09418_ VSS VSS VDD VDD _04895_
+ sky130_fd_sc_hd__nand2_1
X_16343_ _07459_ _04895_ net417 VSS VSS VDD VDD _01870_ sky130_fd_sc_hd__a21oi_1
X_16344_ _04074_ _04131_ VSS VSS VDD VDD _03270_ sky130_fd_sc_hd__nor2_1
X_16345_ network.in_spk08_14 _09418_ network.in_spk09_14 VSS
+ VSS VDD VDD _04896_ sky130_fd_sc_hd__o21ai_0
X_16346_ _07299_ _04896_ net417 VSS VSS VDD VDD _01871_ sky130_fd_sc_hd__a21oi_1
X_16347_ network.neuron_in075.counter\[0\] VSS VSS VDD VDD
+ _00130_ sky130_fd_sc_hd__inv_1
X_16348_ network.in_spk09_14 network.in_spk08_14 _09418_ network.in_spk10_14
+ VSS VSS VDD VDD _04897_ sky130_fd_sc_hd__o31ai_1
Xplace376 _07972_ VSS VSS VDD VDD net375 sky130_fd_sc_hd__buf_4
X_16350_ _07464_ _04897_ net417 VSS VSS VDD VDD _01872_ sky130_fd_sc_hd__a21oi_1
X_16351_ _04068_ _04430_ VSS VSS VDD VDD _03318_ sky130_fd_sc_hd__nor2_1
X_16352_ _04055_ _04129_ VSS VSS VDD VDD _03123_ sky130_fd_sc_hd__nor2_1
Xplace369 _09276_ VSS VSS VDD VDD net368 sky130_fd_sc_hd__buf_4
X_16354_ network.neuron_in073.counter\[3\] network.in_period\[73\]\[2\]
+ net419 _00139_ VSS VSS VDD VDD _04900_ sky130_fd_sc_hd__o22ai_1
X_16355_ network.neuron_in073.counter\[2\] _00139_ net355
+ VSS VSS VDD VDD _04901_ sky130_fd_sc_hd__nand3_1
X_16356_ network.in_period\[73\]\[2\] net355 _04901_ VSS VSS
+ VDD VDD _04902_ sky130_fd_sc_hd__o21ai_0
X_16357_ _04541_ _04900_ _04902_ VSS VSS VDD VDD _02357_ sky130_fd_sc_hd__a21oi_1
X_16358_ _09358_ _03487_ VSS VSS VDD VDD _04903_ sky130_fd_sc_hd__nand2_1
X_16359_ network.in_spk13_14 _04903_ VSS VSS VDD VDD _04904_
+ sky130_fd_sc_hd__nand2_1
X_16360_ _07717_ _04904_ net413 VSS VSS VDD VDD _01873_ sky130_fd_sc_hd__a21oi_1
X_16361_ _09326_ _09593_ network.in_spk01_14 VSS VSS VDD VDD
+ _04905_ sky130_fd_sc_hd__o21ai_0
X_16362_ _07217_ _04905_ net417 VSS VSS VDD VDD _01874_ sky130_fd_sc_hd__a21oi_1
X_16363_ network.neuron_in000.counter\[1\] network.neuron_in000.counter\[2\]
+ network.neuron_in000.counter\[0\] net424 VSS VSS VDD VDD _04906_
+ sky130_fd_sc_hd__nor4_1
X_16364_ network.in_period\[0\]\[3\] _04906_ _08607_ VSS VSS
+ VDD VDD _04907_ sky130_fd_sc_hd__mux2i_1
X_16365_ network.neuron_in000.counter\[1\] network.neuron_in000.counter\[2\]
+ network.neuron_in000.counter\[0\] network.neuron_in000.counter\[3\]
+ net340 VSS VSS VDD VDD _04908_ sky130_fd_sc_hd__o311a_1
X_16366_ network.in_period\[0\]\[3\] net424 _04908_ VSS VSS
+ VDD VDD _04909_ sky130_fd_sc_hd__a21oi_1
X_16367_ network.neuron_in000.counter\[3\] _04907_ _04909_
+ VSS VSS VDD VDD _02066_ sky130_fd_sc_hd__o21ai_0
X_16368_ network.in_spk13_14 _04903_ network.in_spk14_14 VSS
+ VSS VDD VDD _04910_ sky130_fd_sc_hd__o21ai_0
X_16369_ _07722_ _04910_ net413 VSS VSS VDD VDD _01875_ sky130_fd_sc_hd__a21oi_1
X_16370_ network.neuron_in001.counter\[0\] network.neuron_in001.counter\[1\]
+ network.neuron_in001.counter\[2\] net424 VSS VSS VDD VDD _04911_
+ sky130_fd_sc_hd__nor4_1
X_16371_ network.in_period\[1\]\[3\] _04911_ _08612_ VSS VSS
+ VDD VDD _04912_ sky130_fd_sc_hd__mux2i_1
X_16372_ network.neuron_in001.counter\[0\] network.neuron_in001.counter\[1\]
+ network.neuron_in001.counter\[2\] network.neuron_in001.counter\[3\]
+ net341 VSS VSS VDD VDD _04913_ sky130_fd_sc_hd__o311a_1
X_16373_ network.in_period\[1\]\[3\] net424 _04913_ VSS VSS
+ VDD VDD _04914_ sky130_fd_sc_hd__a21oi_1
X_16374_ network.neuron_in001.counter\[3\] _04912_ _04914_
+ VSS VSS VDD VDD _02070_ sky130_fd_sc_hd__o21ai_0
X_16375_ network.in_spk14_14 network.in_spk13_14 _04903_ network.in_spk15_14
+ VSS VSS VDD VDD _04915_ sky130_fd_sc_hd__o31ai_1
X_16376_ _07726_ _04915_ net413 VSS VSS VDD VDD _01876_ sky130_fd_sc_hd__a21oi_1
X_16377_ network.in_spk00_14 _09326_ VSS VSS VDD VDD _04916_
+ sky130_fd_sc_hd__nand2_1
X_16378_ _07254_ _04916_ net417 VSS VSS VDD VDD _01877_ sky130_fd_sc_hd__a21oi_1
Xplace375 _07988_ VSS VSS VDD VDD net374 sky130_fd_sc_hd__buf_4
X_16380_ network.neuron_in002.counter\[0\] network.neuron_in002.counter\[2\]
+ network.neuron_in002.counter\[1\] net423 VSS VSS VDD VDD _04918_
+ sky130_fd_sc_hd__nor4_1
X_16381_ network.in_period\[2\]\[3\] _04918_ _08603_ VSS VSS
+ VDD VDD _04919_ sky130_fd_sc_hd__mux2i_1
Xplace371 _08274_ VSS VSS VDD VDD net370 sky130_fd_sc_hd__buf_4
X_16383_ network.neuron_in002.counter\[0\] network.neuron_in002.counter\[2\]
+ network.neuron_in002.counter\[1\] net343 network.neuron_in002.counter\[3\]
+ VSS VSS VDD VDD _04921_ sky130_fd_sc_hd__o311a_1
X_16384_ network.in_period\[2\]\[3\] net423 _04921_ VSS VSS
+ VDD VDD _04922_ sky130_fd_sc_hd__a21oi_1
X_16385_ network.neuron_in002.counter\[3\] _04919_ _04922_
+ VSS VSS VDD VDD _02074_ sky130_fd_sc_hd__o21ai_0
X_16386_ network.in_spk00_15 _09421_ VSS VSS VDD VDD _04923_
+ sky130_fd_sc_hd__nand2_1
X_16387_ _07731_ _04923_ net416 VSS VSS VDD VDD _01878_ sky130_fd_sc_hd__a21oi_1
X_16388_ network.neuron_in003.counter\[1\] network.neuron_in003.counter\[2\]
+ network.neuron_in003.counter\[0\] VSS VSS VDD VDD _04924_
+ sky130_fd_sc_hd__nor3_1
X_16389_ network.neuron_in003.counter\[3\] _04924_ VSS VSS
+ VDD VDD _04925_ sky130_fd_sc_hd__xnor2_1
X_16390_ network.in_period\[3\]\[3\] _08591_ VSS VSS VDD VDD
+ _04926_ sky130_fd_sc_hd__nand2_1
X_16391_ _08591_ _04925_ _04926_ VSS VSS VDD VDD _02078_ sky130_fd_sc_hd__o21ai_0
X_16392_ network.in_spk00_15 _09421_ network.in_spk01_15 VSS
+ VSS VDD VDD _04927_ sky130_fd_sc_hd__o21ai_0
X_16393_ _07781_ _04927_ net416 VSS VSS VDD VDD _01879_ sky130_fd_sc_hd__a21oi_1
X_16394_ _09625_ net317 _09630_ VSS VSS VDD VDD _04928_ sky130_fd_sc_hd__nand3_1
X_16395_ network.in_spk15_13 _04928_ VSS VSS VDD VDD _04929_
+ sky130_fd_sc_hd__nand2_1
X_16396_ _07188_ _04929_ net425 VSS VSS VDD VDD _01880_ sky130_fd_sc_hd__a21oi_1
X_16397_ network.neuron_in004.counter\[0\] network.neuron_in004.counter\[1\]
+ network.neuron_in004.counter\[2\] net422 VSS VSS VDD VDD _04930_
+ sky130_fd_sc_hd__nor4_1
X_16398_ network.in_period\[4\]\[3\] _04930_ _08629_ VSS VSS
+ VDD VDD _04931_ sky130_fd_sc_hd__mux2i_1
X_16399_ network.neuron_in004.counter\[0\] network.neuron_in004.counter\[1\]
+ network.neuron_in004.counter\[2\] network.neuron_in004.counter\[3\]
+ net341 VSS VSS VDD VDD _04932_ sky130_fd_sc_hd__o311a_1
X_16400_ network.in_period\[4\]\[3\] net422 _04932_ VSS VSS
+ VDD VDD _04933_ sky130_fd_sc_hd__a21oi_1
X_16401_ network.neuron_in004.counter\[3\] _04931_ _04933_
+ VSS VSS VDD VDD _02082_ sky130_fd_sc_hd__o21ai_0
X_16402_ network.in_spk01_15 network.in_spk00_15 _09421_ network.in_spk02_15
+ VSS VSS VDD VDD _04934_ sky130_fd_sc_hd__o31ai_1
X_16403_ _07786_ _04934_ net416 VSS VSS VDD VDD _01881_ sky130_fd_sc_hd__a21oi_1
X_16404_ network.neuron_in005.counter\[1\] network.neuron_in005.counter\[0\]
+ _00662_ VSS VSS VDD VDD _04935_ sky130_fd_sc_hd__o21bai_1
X_16405_ _08633_ _04935_ network.neuron_in005.counter\[3\]
+ VSS VSS VDD VDD _04936_ sky130_fd_sc_hd__a21oi_1
X_16406_ _08633_ _00661_ _00660_ network.neuron_in005.counter\[3\]
+ _04936_ VSS VSS VDD VDD _04937_ sky130_fd_sc_hd__a41o_1
X_16407_ net341 _08647_ network.in_period\[5\]\[3\] VSS VSS
+ VDD VDD _04938_ sky130_fd_sc_hd__a21oi_1
X_16408_ net341 _04937_ _04938_ VSS VSS VDD VDD _02086_ sky130_fd_sc_hd__a21oi_1
X_16409_ net354 _04653_ VSS VSS VDD VDD _04939_ sky130_fd_sc_hd__nand2_1
X_16410_ network.in_period\[79\]\[0\] _04939_ VSS VSS VDD
+ VDD _04940_ sky130_fd_sc_hd__nand2_1
X_16411_ network.neuron_in079.counter\[0\] _04939_ _04940_
+ VSS VSS VDD VDD _02379_ sky130_fd_sc_hd__o21ai_0
X_16412_ network.in_spk02_15 network.in_spk01_15 network.in_spk00_15
+ _09421_ network.in_spk03_15 VSS VSS VDD VDD _04941_ sky130_fd_sc_hd__o41ai_1
Xplace368 _09309_ VSS VSS VDD VDD net367 sky130_fd_sc_hd__buf_4
X_16414_ _07768_ _04941_ net416 VSS VSS VDD VDD _01882_ sky130_fd_sc_hd__a21oi_1
X_16415_ net317 _09630_ VSS VSS VDD VDD _04943_ sky130_fd_sc_hd__nand2_1
X_16416_ network.in_spk12_13 network.in_spk13_13 _04943_ network.in_spk14_13
+ VSS VSS VDD VDD _04944_ sky130_fd_sc_hd__o31ai_1
X_16417_ _07206_ _04944_ net425 VSS VSS VDD VDD _01883_ sky130_fd_sc_hd__a21oi_1
X_16418_ network.neuron_in006.counter\[1\] network.neuron_in006.counter\[0\]
+ network.neuron_in006.counter\[2\] VSS VSS VDD VDD _04945_
+ sky130_fd_sc_hd__nor3_1
X_16419_ network.neuron_in006.counter\[3\] _04945_ VSS VSS
+ VDD VDD _04946_ sky130_fd_sc_hd__xnor2_1
X_16420_ network.in_period\[6\]\[3\] _08639_ VSS VSS VDD VDD
+ _04947_ sky130_fd_sc_hd__nand2_1
X_16421_ _08639_ _04946_ _04947_ VSS VSS VDD VDD _02090_ sky130_fd_sc_hd__o21ai_0
X_16422_ _09254_ net310 VSS VSS VDD VDD _04948_ sky130_fd_sc_hd__nand2b_1
X_16423_ network.in_spk04_15 _04948_ VSS VSS VDD VDD _04949_
+ sky130_fd_sc_hd__nand2_1
X_16424_ _07918_ _04949_ net416 VSS VSS VDD VDD _01884_ sky130_fd_sc_hd__a21oi_1
X_16425_ network.neuron_in007.counter\[0\] network.neuron_in007.counter\[1\]
+ network.neuron_in007.counter\[2\] net424 VSS VSS VDD VDD _04950_
+ sky130_fd_sc_hd__nor4_1
X_16426_ network.in_period\[7\]\[3\] _04950_ _08664_ VSS VSS
+ VDD VDD _04951_ sky130_fd_sc_hd__mux2i_1
X_16427_ network.neuron_in007.counter\[0\] network.neuron_in007.counter\[1\]
+ network.neuron_in007.counter\[2\] network.neuron_in007.counter\[3\]
+ net340 VSS VSS VDD VDD _04952_ sky130_fd_sc_hd__o311a_1
X_16428_ network.in_period\[7\]\[3\] net424 _04952_ VSS VSS
+ VDD VDD _04953_ sky130_fd_sc_hd__a21oi_1
X_16429_ network.neuron_in007.counter\[3\] _04951_ _04953_
+ VSS VSS VDD VDD _02094_ sky130_fd_sc_hd__o21ai_0
X_16430_ network.in_period\[79\]\[1\] _04939_ VSS VSS VDD
+ VDD _04954_ sky130_fd_sc_hd__nand2_1
X_16431_ _00097_ _04939_ _04954_ VSS VSS VDD VDD _02380_ sky130_fd_sc_hd__o21ai_0
X_16432_ network.in_spk04_15 _04948_ network.in_spk05_15 VSS
+ VSS VDD VDD _04955_ sky130_fd_sc_hd__o21ai_0
X_16433_ _08194_ _04955_ net416 VSS VSS VDD VDD _01885_ sky130_fd_sc_hd__a21oi_1
X_16434_ network.in_spk12_13 _04943_ network.in_spk13_13 VSS
+ VSS VDD VDD _04956_ sky130_fd_sc_hd__o21ai_1
X_16435_ _07183_ _04956_ net425 VSS VSS VDD VDD _01886_ sky130_fd_sc_hd__a21oi_1
X_16436_ network.neuron_in008.counter\[1\] network.neuron_in008.counter\[0\]
+ network.neuron_in008.counter\[2\] net424 VSS VSS VDD VDD _04957_
+ sky130_fd_sc_hd__nor4_1
X_16437_ network.in_period\[8\]\[3\] _04957_ _08670_ VSS VSS
+ VDD VDD _04958_ sky130_fd_sc_hd__mux2i_1
X_16438_ network.neuron_in008.counter\[1\] network.neuron_in008.counter\[0\]
+ network.neuron_in008.counter\[2\] network.neuron_in008.counter\[3\]
+ net340 VSS VSS VDD VDD _04959_ sky130_fd_sc_hd__o311a_1
X_16439_ network.in_period\[8\]\[3\] net424 _04959_ VSS VSS
+ VDD VDD _04960_ sky130_fd_sc_hd__a21oi_1
X_16440_ network.neuron_in008.counter\[3\] _04958_ _04960_
+ VSS VSS VDD VDD _02098_ sky130_fd_sc_hd__o21ai_0
X_16441_ net354 _04670_ VSS VSS VDD VDD _04961_ sky130_fd_sc_hd__nand2_1
X_16442_ network.in_period\[75\]\[0\] _04961_ VSS VSS VDD
+ VDD _04962_ sky130_fd_sc_hd__nand2_1
X_16443_ network.neuron_in075.counter\[0\] _04961_ _04962_
+ VSS VSS VDD VDD _02363_ sky130_fd_sc_hd__o21ai_0
X_16444_ network.in_spk05_15 network.in_spk04_15 _04948_ network.in_spk06_15
+ VSS VSS VDD VDD _04963_ sky130_fd_sc_hd__o31ai_1
X_16445_ _08208_ _04963_ net416 VSS VSS VDD VDD _01887_ sky130_fd_sc_hd__a21oi_1
X_16446_ network.neuron_in009.counter\[0\] network.neuron_in009.counter\[2\]
+ network.neuron_in009.counter\[1\] VSS VSS VDD VDD _04964_
+ sky130_fd_sc_hd__nor3_1
X_16447_ network.neuron_in009.counter\[3\] _04964_ VSS VSS
+ VDD VDD _04965_ sky130_fd_sc_hd__xnor2_1
X_16448_ network.in_period\[9\]\[3\] _03504_ VSS VSS VDD VDD
+ _04966_ sky130_fd_sc_hd__nand2_1
X_16449_ _03504_ _04965_ _04966_ VSS VSS VDD VDD _02102_ sky130_fd_sc_hd__o21ai_0
X_16450_ _09255_ _09421_ network.in_spk07_15 VSS VSS VDD VDD
+ _04967_ sky130_fd_sc_hd__o21ai_0
X_16451_ _08213_ _04967_ net416 VSS VSS VDD VDD _01888_ sky130_fd_sc_hd__a21oi_1
X_16452_ network.in_spk12_13 _04943_ VSS VSS VDD VDD _04968_
+ sky130_fd_sc_hd__nand2_1
X_16453_ _07236_ _04968_ net425 VSS VSS VDD VDD _01889_ sky130_fd_sc_hd__a21oi_1
X_16454_ network.neuron_in010.counter\[0\] network.neuron_in010.counter\[1\]
+ _00539_ VSS VSS VDD VDD _04969_ sky130_fd_sc_hd__o21bai_1
X_16455_ _03507_ _04969_ network.neuron_in010.counter\[3\]
+ VSS VSS VDD VDD _04970_ sky130_fd_sc_hd__a21oi_1
X_16456_ _03507_ _00537_ _00538_ network.neuron_in010.counter\[3\]
+ _04970_ VSS VSS VDD VDD _04971_ sky130_fd_sc_hd__a41o_1
Xplace377 _07963_ VSS VSS VDD VDD net376 sky130_fd_sc_hd__buf_4
Xplace330 _09275_ VSS VSS VDD VDD net329 sky130_fd_sc_hd__buf_4
X_16459_ net340 _03511_ network.in_period\[10\]\[3\] VSS VSS
+ VDD VDD _04974_ sky130_fd_sc_hd__a21oi_1
X_16460_ net340 _04971_ _04974_ VSS VSS VDD VDD _02106_ sky130_fd_sc_hd__a21oi_1
Xplace378 _07926_ VSS VSS VDD VDD net377 sky130_fd_sc_hd__buf_4
X_16462_ network.neuron_in078.counter\[2\] net354 VSS VSS
+ VDD VDD _04976_ sky130_fd_sc_hd__nand2_1
X_16463_ network.neuron_in078.counter\[3\] network.in_period\[78\]\[2\]
+ _04976_ VSS VSS VDD VDD _04977_ sky130_fd_sc_hd__o21ai_0
X_16464_ _00104_ network.neuron_in078.counter\[2\] net420
+ VSS VSS VDD VDD _04978_ sky130_fd_sc_hd__or3_1
X_16465_ network.in_period\[78\]\[2\] net354 _04978_ VSS VSS
+ VDD VDD _04979_ sky130_fd_sc_hd__o21ai_0
X_16466_ _00104_ _04977_ _04979_ VSS VSS VDD VDD _02377_ sky130_fd_sc_hd__a21oi_1
X_16467_ network.in_spk08_15 _09422_ VSS VSS VDD VDD _04980_
+ sky130_fd_sc_hd__nand2_1
X_16468_ _08218_ _04980_ net416 VSS VSS VDD VDD _01890_ sky130_fd_sc_hd__a21oi_1
X_16469_ network.neuron_in011.counter\[1\] network.neuron_in011.counter\[2\]
+ network.neuron_in011.counter\[0\] net423 VSS VSS VDD VDD _04981_
+ sky130_fd_sc_hd__nor4_1
X_16470_ network.in_period\[11\]\[3\] _04981_ _03520_ VSS
+ VSS VDD VDD _04982_ sky130_fd_sc_hd__mux2i_1
Xplace340 net366 VSS VSS VDD VDD net339 sky130_fd_sc_hd__buf_4
X_16472_ network.neuron_in011.counter\[1\] network.neuron_in011.counter\[2\]
+ network.neuron_in011.counter\[0\] network.neuron_in011.counter\[3\]
+ net342 VSS VSS VDD VDD _04984_ sky130_fd_sc_hd__o311a_1
X_16473_ network.in_period\[11\]\[3\] net423 _04984_ VSS VSS
+ VDD VDD _04985_ sky130_fd_sc_hd__a21oi_1
X_16474_ network.neuron_in011.counter\[3\] _04982_ _04985_
+ VSS VSS VDD VDD _02110_ sky130_fd_sc_hd__o21ai_0
X_16475_ network.neuron_in079.counter\[3\] network.in_period\[79\]\[2\]
+ _00096_ net420 VSS VSS VDD VDD _04986_ sky130_fd_sc_hd__o22ai_1
X_16476_ network.neuron_in079.counter\[2\] _00096_ net353
+ VSS VSS VDD VDD _04987_ sky130_fd_sc_hd__nand3_1
X_16477_ network.in_period\[79\]\[2\] net353 _04987_ VSS VSS
+ VDD VDD _04988_ sky130_fd_sc_hd__o21ai_0
X_16478_ _04651_ _04986_ _04988_ VSS VSS VDD VDD _02381_ sky130_fd_sc_hd__a21oi_1
X_16479_ _03473_ _09646_ VSS VSS VDD VDD _04989_ sky130_fd_sc_hd__nand2_1
X_16480_ network.in_spk09_15 _04989_ VSS VSS VDD VDD _04990_
+ sky130_fd_sc_hd__nand2_1
X_16481_ _08223_ _04990_ net417 VSS VSS VDD VDD _01891_ sky130_fd_sc_hd__a21oi_1
X_16482_ _09624_ _09374_ network.in_spk11_13 VSS VSS VDD VDD
+ _04991_ sky130_fd_sc_hd__o21ai_1
Xplace331 _09237_ VSS VSS VDD VDD net330 sky130_fd_sc_hd__buf_4
X_16484_ _07231_ _04991_ net424 VSS VSS VDD VDD _01892_ sky130_fd_sc_hd__a21oi_1
X_16485_ network.neuron_in012.counter\[1\] network.neuron_in012.counter\[0\]
+ network.neuron_in012.counter\[2\] net422 VSS VSS VDD VDD _04993_
+ sky130_fd_sc_hd__nor4_1
X_16486_ network.in_period\[12\]\[3\] _04993_ _03530_ VSS
+ VSS VDD VDD _04994_ sky130_fd_sc_hd__mux2i_1
X_16487_ network.neuron_in012.counter\[1\] network.neuron_in012.counter\[0\]
+ network.neuron_in012.counter\[2\] network.neuron_in012.counter\[3\]
+ net341 VSS VSS VDD VDD _04995_ sky130_fd_sc_hd__o311a_1
X_16488_ network.in_period\[12\]\[3\] net422 _04995_ VSS VSS
+ VDD VDD _04996_ sky130_fd_sc_hd__a21oi_1
X_16489_ network.neuron_in012.counter\[3\] _04994_ _04996_
+ VSS VSS VDD VDD _02114_ sky130_fd_sc_hd__o21ai_0
X_16490_ network.in_spk09_15 _04989_ network.in_spk10_15 VSS
+ VSS VDD VDD _04997_ sky130_fd_sc_hd__o21ai_0
X_16491_ _08385_ _04997_ net417 VSS VSS VDD VDD _01893_ sky130_fd_sc_hd__a21oi_1
X_16492_ network.neuron_in013.counter\[0\] network.neuron_in013.counter\[1\]
+ network.neuron_in013.counter\[2\] net423 VSS VSS VDD VDD _04998_
+ sky130_fd_sc_hd__nor4_1
X_16493_ network.in_period\[13\]\[3\] _04998_ _03544_ VSS
+ VSS VDD VDD _04999_ sky130_fd_sc_hd__mux2i_1
X_16494_ network.neuron_in013.counter\[0\] network.neuron_in013.counter\[1\]
+ network.neuron_in013.counter\[2\] network.neuron_in013.counter\[3\]
+ net342 VSS VSS VDD VDD _05000_ sky130_fd_sc_hd__o311a_1
X_16495_ network.in_period\[13\]\[3\] net423 _05000_ VSS VSS
+ VDD VDD _05001_ sky130_fd_sc_hd__a21oi_1
X_16496_ network.neuron_in013.counter\[3\] _04999_ _05001_
+ VSS VSS VDD VDD _02118_ sky130_fd_sc_hd__o21ai_0
X_16497_ network.in_period\[75\]\[1\] _04961_ VSS VSS VDD
+ VDD _05002_ sky130_fd_sc_hd__nand2_1
X_16498_ _00133_ _04961_ _05002_ VSS VSS VDD VDD _02364_ sky130_fd_sc_hd__o21ai_0
X_16499_ _09256_ _09422_ network.in_spk11_15 VSS VSS VDD VDD
+ _05003_ sky130_fd_sc_hd__o21ai_1
X_16500_ _08390_ _05003_ net416 VSS VSS VDD VDD _01894_ sky130_fd_sc_hd__a21oi_1
X_16501_ network.in_spk08_13 network.in_spk09_13 _09374_ network.in_spk10_13
+ VSS VSS VDD VDD _05004_ sky130_fd_sc_hd__o31ai_2
X_16502_ _07069_ _05004_ net424 VSS VSS VDD VDD _01895_ sky130_fd_sc_hd__a21oi_1
X_16503_ network.neuron_in014.counter\[1\] network.neuron_in014.counter\[0\]
+ _00503_ VSS VSS VDD VDD _05005_ sky130_fd_sc_hd__o21bai_1
X_16504_ _03540_ _05005_ network.neuron_in014.counter\[3\]
+ VSS VSS VDD VDD _05006_ sky130_fd_sc_hd__a21oi_1
X_16505_ _03540_ _00502_ _00501_ network.neuron_in014.counter\[3\]
+ _05006_ VSS VSS VDD VDD _05007_ sky130_fd_sc_hd__a41o_1
X_16506_ net351 _03539_ network.in_period\[14\]\[3\] VSS VSS
+ VDD VDD _05008_ sky130_fd_sc_hd__a21oi_1
X_16507_ net351 _05007_ _05008_ VSS VSS VDD VDD _02122_ sky130_fd_sc_hd__a21oi_1
X_16508_ _09257_ net310 VSS VSS VDD VDD _05009_ sky130_fd_sc_hd__nand2_1
X_16509_ network.in_spk12_15 _05009_ VSS VSS VDD VDD _05010_
+ sky130_fd_sc_hd__nand2_1
X_16510_ _08396_ _05010_ net416 VSS VSS VDD VDD _01896_ sky130_fd_sc_hd__a21oi_1
X_16511_ network.neuron_in015.counter\[1\] network.neuron_in015.counter\[0\]
+ _00507_ VSS VSS VDD VDD _05011_ sky130_fd_sc_hd__o21bai_1
X_16512_ _03557_ _05011_ network.neuron_in015.counter\[3\]
+ VSS VSS VDD VDD _05012_ sky130_fd_sc_hd__a21oi_1
X_16513_ _03557_ _00506_ _00505_ network.neuron_in015.counter\[3\]
+ _05012_ VSS VSS VDD VDD _05013_ sky130_fd_sc_hd__a41o_1
X_16514_ net342 _03561_ network.in_period\[15\]\[3\] VSS VSS
+ VDD VDD _05014_ sky130_fd_sc_hd__a21oi_1
X_16515_ net342 _05013_ _05014_ VSS VSS VDD VDD _02126_ sky130_fd_sc_hd__a21oi_1
X_16516_ net352 _04666_ VSS VSS VDD VDD _05015_ sky130_fd_sc_hd__nand2_1
X_16517_ network.in_period\[76\]\[0\] _05015_ VSS VSS VDD
+ VDD _05016_ sky130_fd_sc_hd__nand2_1
X_16518_ network.neuron_in076.counter\[0\] _05015_ _05016_
+ VSS VSS VDD VDD _02367_ sky130_fd_sc_hd__o21ai_0
X_16519_ network.in_spk12_15 _05009_ network.in_spk13_15 VSS
+ VSS VDD VDD _05017_ sky130_fd_sc_hd__o21ai_0
X_16520_ _08400_ _05017_ net416 VSS VSS VDD VDD _01897_ sky130_fd_sc_hd__a21oi_1
X_16521_ network.in_spk08_13 _09374_ network.in_spk09_13 VSS
+ VSS VDD VDD _05018_ sky130_fd_sc_hd__o21ai_1
X_16522_ _07166_ _05018_ net424 VSS VSS VDD VDD _01898_ sky130_fd_sc_hd__a21oi_1
X_16523_ network.neuron_in016.counter\[1\] network.neuron_in016.counter\[0\]
+ network.neuron_in016.counter\[2\] net423 VSS VSS VDD VDD _05019_
+ sky130_fd_sc_hd__nor4_1
X_16524_ network.in_period\[16\]\[3\] _05019_ _03587_ VSS
+ VSS VDD VDD _05020_ sky130_fd_sc_hd__mux2i_1
Xplace373 _08070_ VSS VSS VDD VDD net372 sky130_fd_sc_hd__buf_4
Xplace332 _08722_ VSS VSS VDD VDD net331 sky130_fd_sc_hd__buf_4
X_16527_ network.neuron_in016.counter\[1\] network.neuron_in016.counter\[0\]
+ network.neuron_in016.counter\[2\] network.neuron_in016.counter\[3\]
+ net351 VSS VSS VDD VDD _05023_ sky130_fd_sc_hd__o311a_1
X_16528_ network.in_period\[16\]\[3\] net423 _05023_ VSS VSS
+ VDD VDD _05024_ sky130_fd_sc_hd__a21oi_1
X_16529_ network.neuron_in016.counter\[3\] _05020_ _05024_
+ VSS VSS VDD VDD _02130_ sky130_fd_sc_hd__o21ai_0
X_16530_ net353 _04660_ VSS VSS VDD VDD _05025_ sky130_fd_sc_hd__nand2_1
X_16531_ network.in_period\[77\]\[1\] _05025_ VSS VSS VDD
+ VDD _05026_ sky130_fd_sc_hd__nand2_1
X_16532_ _00111_ _05025_ _05026_ VSS VSS VDD VDD _02372_ sky130_fd_sc_hd__o21ai_0
X_16533_ network.in_spk13_15 network.in_spk12_15 _05009_ network.in_spk14_15
+ VSS VSS VDD VDD _05027_ sky130_fd_sc_hd__o31ai_1
X_16534_ _08405_ _05027_ net416 VSS VSS VDD VDD _01899_ sky130_fd_sc_hd__a21oi_1
X_16535_ network.neuron_in017.counter\[1\] network.neuron_in017.counter\[0\]
+ _00491_ VSS VSS VDD VDD _05028_ sky130_fd_sc_hd__o21bai_1
X_16536_ _03566_ _05028_ network.neuron_in017.counter\[3\]
+ VSS VSS VDD VDD _05029_ sky130_fd_sc_hd__a21oi_1
X_16537_ _03566_ _00490_ _00489_ network.neuron_in017.counter\[3\]
+ _05029_ VSS VSS VDD VDD _05030_ sky130_fd_sc_hd__a41o_1
X_16538_ net349 _03571_ network.in_period\[17\]\[3\] VSS VSS
+ VDD VDD _05031_ sky130_fd_sc_hd__a21oi_1
X_16539_ net349 _05030_ _05031_ VSS VSS VDD VDD _02134_ sky130_fd_sc_hd__a21oi_1
X_16540_ _09257_ _09637_ net310 VSS VSS VDD VDD _05032_ sky130_fd_sc_hd__nand3_1
X_16541_ network.in_spk15_15 _05032_ VSS VSS VDD VDD _05033_
+ sky130_fd_sc_hd__nand2_1
X_16542_ _08409_ _05033_ net416 VSS VSS VDD VDD _01900_ sky130_fd_sc_hd__a21oi_1
X_16543_ network.in_spk08_13 _09374_ VSS VSS VDD VDD _05034_
+ sky130_fd_sc_hd__nand2_1
X_16544_ _07161_ _05034_ net424 VSS VSS VDD VDD _01901_ sky130_fd_sc_hd__a21oi_1
X_16545_ network.neuron_in018.counter\[1\] network.neuron_in018.counter\[0\]
+ _00495_ VSS VSS VDD VDD _05035_ sky130_fd_sc_hd__o21bai_1
X_16546_ _03601_ _05035_ network.neuron_in018.counter\[3\]
+ VSS VSS VDD VDD _05036_ sky130_fd_sc_hd__a21oi_1
X_16547_ _03601_ _00494_ _00493_ network.neuron_in018.counter\[3\]
+ _05036_ VSS VSS VDD VDD _05037_ sky130_fd_sc_hd__a41o_1
X_16548_ net349 _03606_ network.in_period\[18\]\[3\] VSS VSS
+ VDD VDD _05038_ sky130_fd_sc_hd__a21oi_1
X_16549_ net349 _05037_ _05038_ VSS VSS VDD VDD _02138_ sky130_fd_sc_hd__a21oi_1
X_16550_ _09289_ _09357_ _09349_ VSS VSS VDD VDD _05039_ sky130_fd_sc_hd__o21ai_0
Xclkbuf_2_3__f_clk_regs clknet_0_clk_regs VSS VSS VDD VDD
+ clknet_2_3__leaf_clk_regs sky130_fd_sc_hd__clkbuf_16
X_16552_ _09326_ _05039_ net417 VSS VSS VDD VDD _01903_ sky130_fd_sc_hd__a21oi_1
X_16553_ network.neuron_in019.counter\[0\] network.neuron_in019.counter\[1\]
+ _00479_ VSS VSS VDD VDD _05041_ sky130_fd_sc_hd__o21bai_1
X_16554_ _03611_ _05041_ network.neuron_in019.counter\[3\]
+ VSS VSS VDD VDD _05042_ sky130_fd_sc_hd__a21oi_1
X_16555_ _03611_ _00477_ _00478_ network.neuron_in019.counter\[3\]
+ _05042_ VSS VSS VDD VDD _05043_ sky130_fd_sc_hd__a41o_1
X_16556_ net351 _03616_ network.in_period\[19\]\[3\] VSS VSS
+ VDD VDD _05044_ sky130_fd_sc_hd__a21oi_1
X_16557_ net351 _05043_ _05044_ VSS VSS VDD VDD _02142_ sky130_fd_sc_hd__a21oi_1
X_16558_ network.neuron_hid0.IF0.ref_counter\[1\] _09191_
+ VSS VSS VDD VDD _05045_ sky130_fd_sc_hd__nor2_1
X_16559_ _01047_ _09191_ _05045_ _09189_ VSS VSS VDD VDD _01904_
+ sky130_fd_sc_hd__a211oi_1
X_16560_ net317 _03461_ VSS VSS VDD VDD _05046_ sky130_fd_sc_hd__nand2_1
X_16561_ network.in_spk07_13 _05046_ VSS VSS VDD VDD _05047_
+ sky130_fd_sc_hd__nand2_1
X_16562_ _07117_ _05047_ net424 VSS VSS VDD VDD _01905_ sky130_fd_sc_hd__a21oi_1
X_16563_ _09203_ _09197_ network.neuron_hid0.IF0.membrane_potential\[9\]
+ VSS VSS VDD VDD _05048_ sky130_fd_sc_hd__nor3b_1
X_16564_ network.neuron_hid0.IF0.membrane_potential\[10\]
+ _05048_ VSS VSS VDD VDD _05049_ sky130_fd_sc_hd__xnor2_1
X_16565_ _09189_ _05049_ VSS VSS VDD VDD _01906_ sky130_fd_sc_hd__nor2_1
X_16566_ network.neuron_in020.counter\[0\] network.neuron_in020.counter\[2\]
+ network.neuron_in020.counter\[1\] net422 VSS VSS VDD VDD _05050_
+ sky130_fd_sc_hd__nor4_1
X_16567_ network.in_period\[20\]\[3\] _05050_ _03626_ VSS
+ VSS VDD VDD _05051_ sky130_fd_sc_hd__mux2i_1
X_16568_ network.neuron_in020.counter\[0\] network.neuron_in020.counter\[2\]
+ network.neuron_in020.counter\[1\] network.neuron_in020.counter\[3\]
+ net349 VSS VSS VDD VDD _05052_ sky130_fd_sc_hd__o311a_1
X_16569_ network.in_period\[20\]\[3\] net422 _05052_ VSS VSS
+ VDD VDD _05053_ sky130_fd_sc_hd__a21oi_1
X_16570_ network.neuron_in020.counter\[3\] _05051_ _05053_
+ VSS VSS VDD VDD _02146_ sky130_fd_sc_hd__o21ai_0
X_16571_ _09579_ _03490_ VSS VSS VDD VDD _05054_ sky130_fd_sc_hd__nand2_1
X_16572_ network.in_spk02_14 _05054_ network.in_spk03_14 VSS
+ VSS VDD VDD _05055_ sky130_fd_sc_hd__o21ai_0
X_16573_ _07284_ _05055_ net417 VSS VSS VDD VDD _01907_ sky130_fd_sc_hd__a21oi_1
X_16574_ net426 net318 VSS VSS VDD VDD _01908_ sky130_fd_sc_hd__nor2_1
X_16575_ network.neuron_in021.counter\[0\] network.neuron_in021.counter\[1\]
+ network.neuron_in021.counter\[2\] VSS VSS VDD VDD _05056_
+ sky130_fd_sc_hd__nor3_1
X_16576_ network.neuron_in021.counter\[3\] _05056_ VSS VSS
+ VDD VDD _05057_ sky130_fd_sc_hd__xnor2_1
X_16577_ network.in_period\[21\]\[3\] _03637_ VSS VSS VDD
+ VDD _05058_ sky130_fd_sc_hd__nand2_1
X_16578_ _03637_ _05057_ _05058_ VSS VSS VDD VDD _02150_ sky130_fd_sc_hd__o21ai_0
X_16579_ network.ctrl_addr\[7\] net364 VSS VSS VDD VDD _01909_
+ sky130_fd_sc_hd__and2_1
X_16580_ _09333_ _09364_ VSS VSS VDD VDD _05059_ sky130_fd_sc_hd__or2_2
Xclkbuf_2_2__f_clk_regs clknet_0_clk_regs VSS VSS VDD VDD
+ clknet_2_2__leaf_clk_regs sky130_fd_sc_hd__clkbuf_16
X_16582_ _05059_ _09623_ network.in_spk06_13 VSS VSS VDD VDD
+ _05061_ sky130_fd_sc_hd__o21ai_0
X_16583_ _07149_ _05061_ net425 VSS VSS VDD VDD _01910_ sky130_fd_sc_hd__a21oi_1
X_16584_ network.ctrl_spk net361 VSS VSS VDD VDD _01911_ sky130_fd_sc_hd__and2_1
X_16585_ network.neuron_in022.counter\[1\] network.neuron_in022.counter\[0\]
+ network.neuron_in022.counter\[2\] VSS VSS VDD VDD _05062_
+ sky130_fd_sc_hd__nor3_1
X_16586_ network.neuron_in022.counter\[3\] _05062_ VSS VSS
+ VDD VDD _05063_ sky130_fd_sc_hd__xnor2_1
X_16587_ network.in_period\[22\]\[3\] _03647_ VSS VSS VDD
+ VDD _05064_ sky130_fd_sc_hd__nand2_1
X_16588_ _03647_ _05063_ _05064_ VSS VSS VDD VDD _02154_ sky130_fd_sc_hd__o21ai_0
X_16589_ network.neuron_hid1.IF0.ref_counter\[1\] _09160_
+ VSS VSS VDD VDD _05065_ sky130_fd_sc_hd__nor2_1
X_16590_ _01131_ _09160_ _05065_ _09158_ VSS VSS VDD VDD _01912_
+ sky130_fd_sc_hd__a211oi_1
X_16591_ _09172_ _09166_ network.neuron_hid1.IF0.membrane_potential\[9\]
+ VSS VSS VDD VDD _05066_ sky130_fd_sc_hd__nor3b_1
X_16592_ network.neuron_hid1.IF0.membrane_potential\[10\]
+ _05066_ VSS VSS VDD VDD _05067_ sky130_fd_sc_hd__xnor2_1
X_16593_ _09158_ _05067_ VSS VSS VDD VDD _01913_ sky130_fd_sc_hd__nor2_1
X_16594_ network.neuron_in023.counter\[1\] network.neuron_in023.counter\[0\]
+ network.neuron_in023.counter\[2\] net421 VSS VSS VDD VDD _05068_
+ sky130_fd_sc_hd__nor4_1
X_16595_ network.in_period\[23\]\[3\] _05068_ _03654_ VSS
+ VSS VDD VDD _05069_ sky130_fd_sc_hd__mux2i_1
X_16596_ network.neuron_in023.counter\[1\] network.neuron_in023.counter\[0\]
+ network.neuron_in023.counter\[2\] network.neuron_in023.counter\[3\]
+ net351 VSS VSS VDD VDD _05070_ sky130_fd_sc_hd__o311a_1
X_16597_ network.in_period\[23\]\[3\] net421 _05070_ VSS VSS
+ VDD VDD _05071_ sky130_fd_sc_hd__a21oi_1
X_16598_ network.neuron_in023.counter\[3\] _05069_ _05071_
+ VSS VSS VDD VDD _02158_ sky130_fd_sc_hd__o21ai_0
X_16599_ network.neuron_in075.counter\[3\] network.in_period\[75\]\[2\]
+ net419 _00132_ VSS VSS VDD VDD _05072_ sky130_fd_sc_hd__o22ai_1
X_16600_ network.neuron_in075.counter\[2\] _00132_ net354
+ VSS VSS VDD VDD _05073_ sky130_fd_sc_hd__nand3_1
X_16601_ network.in_period\[75\]\[2\] net354 _05073_ VSS VSS
+ VDD VDD _05074_ sky130_fd_sc_hd__o21ai_0
X_16602_ _04668_ _05072_ _05074_ VSS VSS VDD VDD _02365_ sky130_fd_sc_hd__a21oi_1
X_16603_ network.in_spk04_13 _09622_ _05059_ network.in_spk05_13
+ VSS VSS VDD VDD _05075_ sky130_fd_sc_hd__o31ai_1
X_16604_ _07081_ _05075_ net425 VSS VSS VDD VDD _01914_ sky130_fd_sc_hd__a21oi_1
X_16605_ network.hid_spk1 network.hid_spk0 VSS VSS VDD VDD
+ _05076_ sky130_fd_sc_hd__nand2_1
X_16606_ _09157_ _05076_ net426 VSS VSS VDD VDD _01915_ sky130_fd_sc_hd__a21oi_1
Xplace459 net459 VSS VSS VDD VDD net458 sky130_fd_sc_hd__buf_4
X_16608_ network.neuron_in024.counter\[0\] network.neuron_in024.counter\[2\]
+ network.neuron_in024.counter\[1\] net422 VSS VSS VDD VDD _05078_
+ sky130_fd_sc_hd__nor4_1
X_16609_ network.in_period\[24\]\[3\] _05078_ _03663_ VSS
+ VSS VDD VDD _05079_ sky130_fd_sc_hd__mux2i_1
X_16610_ network.neuron_in024.counter\[0\] network.neuron_in024.counter\[2\]
+ network.neuron_in024.counter\[1\] network.neuron_in024.counter\[3\]
+ net349 VSS VSS VDD VDD _05080_ sky130_fd_sc_hd__o311a_1
X_16611_ network.in_period\[24\]\[3\] net422 _05080_ VSS VSS
+ VDD VDD _05081_ sky130_fd_sc_hd__a21oi_1
X_16612_ network.neuron_in024.counter\[3\] _05079_ _05081_
+ VSS VSS VDD VDD _02162_ sky130_fd_sc_hd__o21ai_0
X_16613_ network.neuron_hid2.IF0.ref_counter\[1\] _09124_
+ VSS VSS VDD VDD _05082_ sky130_fd_sc_hd__nor2_1
X_16614_ _00157_ _09124_ _05082_ _09122_ VSS VSS VDD VDD _01916_
+ sky130_fd_sc_hd__a211oi_1
X_16615_ network.neuron_hid2.IF0.membrane_potential\[8\] network.neuron_hid2.IF0.membrane_potential\[9\]
+ _09145_ VSS VSS VDD VDD _05083_ sky130_fd_sc_hd__nand3_1
X_16616_ network.neuron_hid2.IF0.membrane_potential\[10\]
+ _05083_ VSS VSS VDD VDD _05084_ sky130_fd_sc_hd__xor2_1
X_16617_ _09122_ _05084_ VSS VSS VDD VDD _01917_ sky130_fd_sc_hd__nor2_1
X_16618_ network.neuron_in025.counter\[0\] network.neuron_in025.counter\[1\]
+ _00437_ VSS VSS VDD VDD _05085_ sky130_fd_sc_hd__o21bai_1
X_16619_ _03682_ _05085_ network.neuron_in025.counter\[3\]
+ VSS VSS VDD VDD _05086_ sky130_fd_sc_hd__a21oi_1
X_16620_ _03682_ _00435_ _00436_ network.neuron_in025.counter\[3\]
+ _05086_ VSS VSS VDD VDD _05087_ sky130_fd_sc_hd__a41o_1
X_16621_ net341 _03681_ network.in_period\[25\]\[3\] VSS VSS
+ VDD VDD _05088_ sky130_fd_sc_hd__a21oi_1
X_16622_ net341 _05087_ _05088_ VSS VSS VDD VDD _02166_ sky130_fd_sc_hd__a21oi_1
X_16623_ network.neuron_hid3.IF0.membrane_potential\[8\] network.neuron_hid3.IF0.membrane_potential\[9\]
+ _09109_ VSS VSS VDD VDD _05089_ sky130_fd_sc_hd__nand3_1
X_16624_ network.neuron_hid3.IF0.membrane_potential\[10\]
+ _05089_ VSS VSS VDD VDD _05090_ sky130_fd_sc_hd__xor2_1
X_16625_ _09086_ _05090_ VSS VSS VDD VDD _01918_ sky130_fd_sc_hd__nor2_1
X_16626_ _09622_ _05059_ network.in_spk04_13 VSS VSS VDD VDD
+ _05091_ sky130_fd_sc_hd__o21ai_0
X_16627_ _07103_ _05091_ net425 VSS VSS VDD VDD _01919_ sky130_fd_sc_hd__a21oi_1
X_16628_ network.hid_spk1 network.hid_spk0 network.hid_spk2
+ VSS VSS VDD VDD _05092_ sky130_fd_sc_hd__o21ai_0
X_16629_ _09121_ _05092_ net426 VSS VSS VDD VDD _01920_ sky130_fd_sc_hd__a21oi_1
X_16630_ network.neuron_in026.counter\[0\] network.neuron_in026.counter\[2\]
+ network.neuron_in026.counter\[1\] VSS VSS VDD VDD _05093_
+ sky130_fd_sc_hd__nor3_1
X_16631_ network.neuron_in026.counter\[3\] _05093_ VSS VSS
+ VDD VDD _05094_ sky130_fd_sc_hd__xnor2_1
X_16632_ network.in_period\[26\]\[3\] _03700_ VSS VSS VDD
+ VDD _05095_ sky130_fd_sc_hd__nand2_1
X_16633_ _03700_ _05094_ _05095_ VSS VSS VDD VDD _02170_ sky130_fd_sc_hd__o21ai_0
X_16634_ network.neuron_in076.counter\[3\] network.in_period\[76\]\[2\]
+ _00124_ net418 VSS VSS VDD VDD _05096_ sky130_fd_sc_hd__o22ai_1
Xplace372 _08240_ VSS VSS VDD VDD net371 sky130_fd_sc_hd__buf_4
X_16636_ network.neuron_in076.counter\[2\] _00124_ net352
+ VSS VSS VDD VDD _05098_ sky130_fd_sc_hd__nand3_1
X_16637_ network.in_period\[76\]\[2\] net352 _05098_ VSS VSS
+ VDD VDD _05099_ sky130_fd_sc_hd__o21ai_0
X_16638_ _04665_ _05096_ _05099_ VSS VSS VDD VDD _02369_ sky130_fd_sc_hd__a21oi_1
X_16639_ network.hid_spk2 network.hid_spk1 network.hid_spk0
+ network.hid_spk3 VSS VSS VDD VDD _05100_ sky130_fd_sc_hd__o31ai_1
X_16640_ _09085_ _05100_ net426 VSS VSS VDD VDD _01921_ sky130_fd_sc_hd__a21oi_1
X_16641_ network.neuron_hid3.IF0.ref_counter\[1\] _09088_
+ VSS VSS VDD VDD _05101_ sky130_fd_sc_hd__nor2_1
X_16642_ _00675_ _09088_ _05101_ _09086_ VSS VSS VDD VDD _01922_
+ sky130_fd_sc_hd__a211oi_1
Xplace370 _09240_ VSS VSS VDD VDD net369 sky130_fd_sc_hd__buf_4
X_16644_ network.neuron_in027.counter\[0\] network.neuron_in027.counter\[1\]
+ VSS VSS VDD VDD _05103_ sky130_fd_sc_hd__nor2_1
X_16645_ _00531_ _05103_ VSS VSS VDD VDD _05104_ sky130_fd_sc_hd__nor2_1
X_16646_ network.neuron_in027.counter\[2\] _05104_ VSS VSS
+ VDD VDD _05105_ sky130_fd_sc_hd__nor2_1
X_16647_ network.neuron_in027.counter\[2\] network.neuron_in027.counter\[3\]
+ _05103_ VSS VSS VDD VDD _05106_ sky130_fd_sc_hd__nand3b_1
X_16648_ network.neuron_in027.counter\[3\] _05105_ _05106_
+ VSS VSS VDD VDD _05107_ sky130_fd_sc_hd__o21ai_0
X_16649_ net349 _04737_ network.in_period\[27\]\[3\] VSS VSS
+ VDD VDD _05108_ sky130_fd_sc_hd__a21oi_1
X_16650_ net349 _05107_ _05108_ VSS VSS VDD VDD _02174_ sky130_fd_sc_hd__a21oi_1
X_16651_ network.in_period\[76\]\[1\] _05015_ VSS VSS VDD
+ VDD _05109_ sky130_fd_sc_hd__nand2_1
X_16652_ _00125_ _05015_ _05109_ VSS VSS VDD VDD _02368_ sky130_fd_sc_hd__o21ai_0
X_16653_ network.neuron_hid4.IF0.ref_counter\[1\] _09058_
+ VSS VSS VDD VDD _05110_ sky130_fd_sc_hd__nor2_1
X_16654_ _01223_ _09058_ _05110_ _09056_ VSS VSS VDD VDD _01923_
+ sky130_fd_sc_hd__a211oi_1
X_16655_ _03464_ net317 VSS VSS VDD VDD _05111_ sky130_fd_sc_hd__nand2_1
X_16656_ network.in_spk03_13 _05111_ VSS VSS VDD VDD _05112_
+ sky130_fd_sc_hd__nand2_1
X_16657_ _07076_ _05112_ net425 VSS VSS VDD VDD _01924_ sky130_fd_sc_hd__a21oi_1
X_16658_ _09070_ _09064_ network.neuron_hid4.IF0.membrane_potential\[9\]
+ VSS VSS VDD VDD _05113_ sky130_fd_sc_hd__nor3b_1
X_16659_ network.neuron_hid4.IF0.membrane_potential\[10\]
+ _05113_ VSS VSS VDD VDD _05114_ sky130_fd_sc_hd__xnor2_1
X_16660_ _09056_ _05114_ VSS VSS VDD VDD _01925_ sky130_fd_sc_hd__nor2_1
X_16661_ network.neuron_in028.counter\[0\] network.neuron_in028.counter\[1\]
+ network.neuron_in028.counter\[2\] net424 VSS VSS VDD VDD _05115_
+ sky130_fd_sc_hd__nor4_1
X_16662_ network.in_period\[28\]\[3\] _05115_ _07891_ VSS
+ VSS VDD VDD _05116_ sky130_fd_sc_hd__mux2i_1
X_16663_ network.neuron_in028.counter\[0\] network.neuron_in028.counter\[1\]
+ network.neuron_in028.counter\[2\] network.neuron_in028.counter\[3\]
+ net341 VSS VSS VDD VDD _05117_ sky130_fd_sc_hd__o311a_1
X_16664_ network.in_period\[28\]\[3\] net424 _05117_ VSS VSS
+ VDD VDD _05118_ sky130_fd_sc_hd__a21oi_1
X_16665_ network.neuron_in028.counter\[3\] _05116_ _05118_
+ VSS VSS VDD VDD _02178_ sky130_fd_sc_hd__o21ai_0
X_16666_ network.in_spk04_14 network.in_spk05_14 _09426_ network.in_spk06_14
+ VSS VSS VDD VDD _05119_ sky130_fd_sc_hd__o31ai_1
Xplace439 network.neuron_hid0.ROM0.address\[4\] VSS VSS VDD
+ VDD net438 sky130_fd_sc_hd__buf_4
X_16668_ _07574_ _05119_ net413 VSS VSS VDD VDD _01926_ sky130_fd_sc_hd__a21oi_1
X_16669_ network.hid_spk4 _08948_ VSS VSS VDD VDD _05121_
+ sky130_fd_sc_hd__nand2_1
X_16670_ _09055_ _05121_ net426 VSS VSS VDD VDD _01927_ sky130_fd_sc_hd__a21oi_1
X_16671_ network.neuron_in029.counter\[0\] network.neuron_in029.counter\[1\]
+ _00409_ VSS VSS VDD VDD _05122_ sky130_fd_sc_hd__o21bai_1
X_16672_ _07896_ _05122_ network.neuron_in029.counter\[3\]
+ VSS VSS VDD VDD _05123_ sky130_fd_sc_hd__a21oi_1
X_16673_ _07896_ _00407_ _00408_ network.neuron_in029.counter\[3\]
+ _05123_ VSS VSS VDD VDD _05124_ sky130_fd_sc_hd__a41o_1
X_16674_ net349 _07903_ network.in_period\[29\]\[3\] VSS VSS
+ VDD VDD _05125_ sky130_fd_sc_hd__a21oi_1
X_16675_ net349 _05124_ _05125_ VSS VSS VDD VDD _02182_ sky130_fd_sc_hd__a21oi_1
X_16676_ network.neuron_in077.counter\[3\] network.in_period\[77\]\[2\]
+ net420 _00110_ VSS VSS VDD VDD _05126_ sky130_fd_sc_hd__o22ai_1
X_16677_ network.neuron_in077.counter\[2\] _00110_ net353
+ VSS VSS VDD VDD _05127_ sky130_fd_sc_hd__nand3_1
X_16678_ network.in_period\[77\]\[2\] net353 _05127_ VSS VSS
+ VDD VDD _05128_ sky130_fd_sc_hd__o21ai_0
X_16679_ _04658_ _05126_ _05128_ VSS VSS VDD VDD _02373_ sky130_fd_sc_hd__a21oi_1
X_16680_ network.neuron_hid5.IF0.ref_counter\[1\] _09028_
+ VSS VSS VDD VDD _05129_ sky130_fd_sc_hd__nor2_1
X_16681_ _00053_ _09028_ _05129_ _09026_ VSS VSS VDD VDD _01928_
+ sky130_fd_sc_hd__a211oi_1
X_16682_ network.in_spk00_13 network.in_spk01_13 _05059_ network.in_spk02_13
+ VSS VSS VDD VDD _05130_ sky130_fd_sc_hd__o31ai_1
X_16683_ _07135_ _05130_ net424 VSS VSS VDD VDD _01929_ sky130_fd_sc_hd__a21oi_1
X_16684_ _09040_ _09034_ network.neuron_hid5.IF0.membrane_potential\[9\]
+ VSS VSS VDD VDD _05131_ sky130_fd_sc_hd__nor3b_1
X_16685_ network.neuron_hid5.IF0.membrane_potential\[10\]
+ _05131_ VSS VSS VDD VDD _05132_ sky130_fd_sc_hd__xnor2_1
X_16686_ _09026_ _05132_ VSS VSS VDD VDD _01930_ sky130_fd_sc_hd__nor2_1
X_16687_ network.neuron_in030.counter\[1\] network.neuron_in030.counter\[0\]
+ _00483_ VSS VSS VDD VDD _05133_ sky130_fd_sc_hd__o21bai_1
X_16688_ _03676_ _05133_ network.neuron_in030.counter\[3\]
+ VSS VSS VDD VDD _05134_ sky130_fd_sc_hd__a21oi_1
X_16689_ _03676_ network.neuron_in030.counter\[3\] _00482_
+ _00481_ _05134_ VSS VSS VDD VDD _05135_ sky130_fd_sc_hd__a41o_1
X_16690_ net341 _03675_ network.in_period\[30\]\[3\] VSS VSS
+ VDD VDD _05136_ sky130_fd_sc_hd__a21oi_1
X_16691_ net341 _05135_ _05136_ VSS VSS VDD VDD _02186_ sky130_fd_sc_hd__a21oi_1
X_16692_ network.neuron_in077.counter\[0\] VSS VSS VDD VDD
+ _00108_ sky130_fd_sc_hd__inv_1
X_16693_ network.in_period\[77\]\[0\] _05025_ VSS VSS VDD
+ VDD _05137_ sky130_fd_sc_hd__nand2_1
X_16694_ network.neuron_in077.counter\[0\] _05025_ _05137_
+ VSS VSS VDD VDD _02371_ sky130_fd_sc_hd__o21ai_0
X_16695_ network.hid_spk4 _08948_ network.hid_spk5 VSS VSS
+ VDD VDD _05138_ sky130_fd_sc_hd__o21ai_0
X_16696_ _09025_ _05138_ net426 VSS VSS VDD VDD _01931_ sky130_fd_sc_hd__a21oi_1
X_16697_ network.neuron_in031.counter\[1\] network.neuron_in031.counter\[0\]
+ _01200_ VSS VSS VDD VDD _05139_ sky130_fd_sc_hd__o21bai_1
X_16698_ _03704_ _05139_ network.neuron_in031.counter\[3\]
+ VSS VSS VDD VDD _05140_ sky130_fd_sc_hd__a21oi_1
X_16699_ _03704_ network.neuron_in031.counter\[3\] _01199_
+ _01198_ _05140_ VSS VSS VDD VDD _05141_ sky130_fd_sc_hd__a41o_1
Xplace461 net462 VSS VSS VDD VDD net460 sky130_fd_sc_hd__buf_4
X_16701_ net341 _03703_ network.in_period\[31\]\[3\] VSS VSS
+ VDD VDD _05143_ sky130_fd_sc_hd__a21oi_1
X_16702_ net341 _05141_ _05143_ VSS VSS VDD VDD _02190_ sky130_fd_sc_hd__a21oi_1
X_16703_ network.neuron_hid6.IF0.ref_counter\[1\] _08997_
+ VSS VSS VDD VDD _05144_ sky130_fd_sc_hd__nor2_1
X_16704_ _00092_ _08997_ _05144_ _08995_ VSS VSS VDD VDD _01932_
+ sky130_fd_sc_hd__a211oi_1
X_16705_ network.in_spk08_13 network.in_spk09_13 network.in_spk10_13
+ VSS VSS VDD VDD _05145_ sky130_fd_sc_hd__nor3_1
X_16706_ network.in_spk11_13 _05145_ network.in_spk08_13 VSS
+ VSS VDD VDD _05146_ sky130_fd_sc_hd__a21oi_1
X_16707_ _09248_ _05146_ _09633_ VSS VSS VDD VDD _05147_ sky130_fd_sc_hd__o21bai_1
X_16708_ _03469_ _05147_ _09465_ VSS VSS VDD VDD _05148_ sky130_fd_sc_hd__nor3b_1
X_16709_ _05059_ _05148_ network.in_spk01_13 VSS VSS VDD VDD
+ _05149_ sky130_fd_sc_hd__o21ai_0
X_16710_ _07130_ _05149_ net425 VSS VSS VDD VDD _01933_ sky130_fd_sc_hd__a21oi_1
X_16711_ _09009_ _09003_ network.neuron_hid6.IF0.membrane_potential\[9\]
+ VSS VSS VDD VDD _05150_ sky130_fd_sc_hd__nor3b_1
X_16712_ network.neuron_hid6.IF0.membrane_potential\[10\]
+ _05150_ VSS VSS VDD VDD _05151_ sky130_fd_sc_hd__xnor2_1
X_16713_ _08995_ _05151_ VSS VSS VDD VDD _01934_ sky130_fd_sc_hd__nor2_1
X_16714_ network.neuron_in032.counter\[1\] network.neuron_in032.counter\[0\]
+ network.neuron_in032.counter\[2\] net423 VSS VSS VDD VDD _05152_
+ sky130_fd_sc_hd__nor4_1
X_16715_ network.in_period\[32\]\[3\] _05152_ _03708_ VSS
+ VSS VDD VDD _05153_ sky130_fd_sc_hd__mux2i_1
X_16716_ network.neuron_in032.counter\[1\] network.neuron_in032.counter\[0\]
+ network.neuron_in032.counter\[2\] net351 network.neuron_in032.counter\[3\]
+ VSS VSS VDD VDD _05154_ sky130_fd_sc_hd__o311a_1
X_16717_ network.in_period\[32\]\[3\] net423 _05154_ VSS VSS
+ VDD VDD _05155_ sky130_fd_sc_hd__a21oi_1
X_16718_ network.neuron_in032.counter\[3\] _05153_ _05155_
+ VSS VSS VDD VDD _02194_ sky130_fd_sc_hd__o21ai_0
X_16719_ net354 _04656_ VSS VSS VDD VDD _05156_ sky130_fd_sc_hd__nand2_1
X_16720_ network.in_period\[78\]\[1\] _05156_ VSS VSS VDD
+ VDD _05157_ sky130_fd_sc_hd__nand2_1
X_16721_ _00105_ _05156_ _05157_ VSS VSS VDD VDD _02376_ sky130_fd_sc_hd__o21ai_0
X_16722_ network.in_spk04_14 _09426_ network.in_spk05_14 VSS
+ VSS VDD VDD _05158_ sky130_fd_sc_hd__o21ai_0
X_16723_ _07569_ _05158_ net413 VSS VSS VDD VDD _01935_ sky130_fd_sc_hd__a21oi_1
X_16724_ network.hid_spk6 _08949_ VSS VSS VDD VDD _05159_
+ sky130_fd_sc_hd__nand2_1
X_16725_ net319 _05159_ net426 VSS VSS VDD VDD _01936_ sky130_fd_sc_hd__a21oi_1
X_16726_ network.neuron_in033.counter\[1\] network.neuron_in033.counter\[0\]
+ _00629_ VSS VSS VDD VDD _05160_ sky130_fd_sc_hd__o21bai_1
X_16727_ _03738_ _05160_ network.neuron_in033.counter\[3\]
+ VSS VSS VDD VDD _05161_ sky130_fd_sc_hd__a21oi_1
X_16728_ _03738_ network.neuron_in033.counter\[3\] _00628_
+ _00627_ _05161_ VSS VSS VDD VDD _05162_ sky130_fd_sc_hd__a41o_1
X_16729_ net351 _03737_ network.in_period\[33\]\[3\] VSS VSS
+ VDD VDD _05163_ sky130_fd_sc_hd__a21oi_1
X_16730_ net351 _05162_ _05163_ VSS VSS VDD VDD _02198_ sky130_fd_sc_hd__a21oi_1
X_16731_ network.in_period\[78\]\[0\] _05156_ VSS VSS VDD
+ VDD _05164_ sky130_fd_sc_hd__nand2_1
X_16732_ network.neuron_in078.counter\[0\] _05156_ _05164_
+ VSS VSS VDD VDD _02375_ sky130_fd_sc_hd__o21ai_0
X_16733_ network.neuron_hid7.IF0.ref_counter\[1\] _08961_
+ VSS VSS VDD VDD _05165_ sky130_fd_sc_hd__nor2_1
X_16734_ _00687_ _08961_ _05165_ _08959_ VSS VSS VDD VDD _01937_
+ sky130_fd_sc_hd__a211oi_1
X_16735_ network.in_spk00_13 _05059_ VSS VSS VDD VDD _05166_
+ sky130_fd_sc_hd__nand2_1
X_16736_ _06938_ _05166_ net425 VSS VSS VDD VDD _01938_ sky130_fd_sc_hd__a21oi_1
X_16737_ network.neuron_hid7.IF0.membrane_potential\[8\] network.neuron_hid7.IF0.membrane_potential\[9\]
+ _08982_ VSS VSS VDD VDD _05167_ sky130_fd_sc_hd__nand3_1
X_16738_ network.neuron_hid7.IF0.membrane_potential\[10\]
+ _05167_ VSS VSS VDD VDD _05168_ sky130_fd_sc_hd__xor2_1
X_16739_ _08959_ _05168_ VSS VSS VDD VDD _01939_ sky130_fd_sc_hd__nor2_1
X_16740_ network.neuron_in034.counter\[1\] network.neuron_in034.counter\[0\]
+ _00413_ VSS VSS VDD VDD _05169_ sky130_fd_sc_hd__o21bai_1
X_16741_ _03722_ _05169_ network.neuron_in034.counter\[3\]
+ VSS VSS VDD VDD _05170_ sky130_fd_sc_hd__a21oi_1
X_16742_ _03722_ network.neuron_in034.counter\[3\] _00412_
+ _00411_ _05170_ VSS VSS VDD VDD _05171_ sky130_fd_sc_hd__a41o_1
X_16743_ net351 _03721_ network.in_period\[34\]\[3\] VSS VSS
+ VDD VDD _05172_ sky130_fd_sc_hd__a21oi_1
X_16744_ net351 _05171_ _05172_ VSS VSS VDD VDD _02202_ sky130_fd_sc_hd__a21oi_1
X_16745_ network.hid_spk7 network.hid_spk6 network.hid_spk5
+ network.hid_spk4 VSS VSS VDD VDD _05173_ sky130_fd_sc_hd__nor4_1
X_16746_ net426 _08948_ _05173_ VSS VSS VDD VDD _01940_ sky130_fd_sc_hd__nor3_1
X_16747_ network.hid_spk6 _08949_ VSS VSS VDD VDD _05174_
+ sky130_fd_sc_hd__or2_2
X_16748_ network.hid_spk7 _05174_ VSS VSS VDD VDD _05175_
+ sky130_fd_sc_hd__nand2_1
X_16749_ _08958_ _05175_ net426 VSS VSS VDD VDD _01941_ sky130_fd_sc_hd__a21oi_1
X_16750_ network.neuron_in035.counter\[1\] network.neuron_in035.counter\[0\]
+ _00417_ VSS VSS VDD VDD _05176_ sky130_fd_sc_hd__o21bai_1
X_16751_ _03732_ _05176_ network.neuron_in035.counter\[3\]
+ VSS VSS VDD VDD _05177_ sky130_fd_sc_hd__a21oi_1
X_16752_ _03732_ network.neuron_in035.counter\[3\] _00416_
+ _00415_ _05177_ VSS VSS VDD VDD _05178_ sky130_fd_sc_hd__a41o_1
X_16753_ net351 _03731_ network.in_period\[35\]\[3\] VSS VSS
+ VDD VDD _05179_ sky130_fd_sc_hd__a21oi_1
X_16754_ net351 _05178_ _05179_ VSS VSS VDD VDD _02206_ sky130_fd_sc_hd__a21oi_1
X_16755_ _09375_ _09376_ _09333_ VSS VSS VDD VDD _05180_ sky130_fd_sc_hd__nor3_1
X_16756_ _09242_ _05180_ VSS VSS VDD VDD _05181_ sky130_fd_sc_hd__nand2_1
X_16757_ network.in_spk12_12 network.in_spk13_12 network.in_spk14_12
+ _05181_ network.in_spk15_12 VSS VSS VDD VDD _05182_ sky130_fd_sc_hd__o41ai_1
X_16758_ _07056_ _05182_ net425 VSS VSS VDD VDD _01942_ sky130_fd_sc_hd__a21oi_1
X_16759_ network.hid_spk7 _05174_ VSS VSS VDD VDD _05183_
+ sky130_fd_sc_hd__nor2_1
X_16760_ net426 _05183_ VSS VSS VDD VDD _01943_ sky130_fd_sc_hd__nor2_1
X_16761_ network.neuron_in036.counter\[1\] network.neuron_in036.counter\[2\]
+ network.neuron_in036.counter\[0\] net424 VSS VSS VDD VDD _05184_
+ sky130_fd_sc_hd__nor4_1
X_16762_ network.in_period\[36\]\[3\] _05184_ _03828_ VSS
+ VSS VDD VDD _05185_ sky130_fd_sc_hd__mux2i_1
X_16763_ network.neuron_in036.counter\[1\] network.neuron_in036.counter\[2\]
+ network.neuron_in036.counter\[0\] network.neuron_in036.counter\[3\]
+ net351 VSS VSS VDD VDD _05186_ sky130_fd_sc_hd__o311a_1
X_16764_ network.in_period\[36\]\[3\] net424 _05186_ VSS VSS
+ VDD VDD _05187_ sky130_fd_sc_hd__a21oi_1
X_16765_ network.neuron_in036.counter\[3\] _05185_ _05187_
+ VSS VSS VDD VDD _02210_ sky130_fd_sc_hd__o21ai_0
X_16766_ network.neuron_in037.counter\[1\] network.neuron_in037.counter\[0\]
+ _00393_ VSS VSS VDD VDD _05188_ sky130_fd_sc_hd__o21bai_1
X_16767_ _03769_ _05188_ network.neuron_in037.counter\[3\]
+ VSS VSS VDD VDD _05189_ sky130_fd_sc_hd__a21oi_1
X_16768_ _03769_ network.neuron_in037.counter\[3\] _00392_
+ _00391_ _05189_ VSS VSS VDD VDD _05190_ sky130_fd_sc_hd__a41o_1
X_16769_ net340 _03768_ network.in_period\[37\]\[3\] VSS VSS
+ VDD VDD _05191_ sky130_fd_sc_hd__a21oi_1
X_16770_ net340 _05190_ _05191_ VSS VSS VDD VDD _02214_ sky130_fd_sc_hd__a21oi_1
X_16771_ network.neuron_in089.counter\[3\] network.in_period\[89\]\[2\]
+ net414 _01218_ VSS VSS VDD VDD _05192_ sky130_fd_sc_hd__o22ai_1
X_16772_ network.neuron_in089.counter\[2\] _01218_ net345
+ VSS VSS VDD VDD _05193_ sky130_fd_sc_hd__nand3_1
X_16773_ network.in_period\[89\]\[2\] net345 _05193_ VSS VSS
+ VDD VDD _05194_ sky130_fd_sc_hd__o21ai_0
X_16774_ _04616_ _05192_ _05194_ VSS VSS VDD VDD _02421_ sky130_fd_sc_hd__a21oi_1
X_16775_ network.in_spk12_12 network.in_spk13_12 _05181_ network.in_spk14_12
+ VSS VSS VDD VDD _05195_ sky130_fd_sc_hd__o31ai_1
Xplace432 net432 VSS VSS VDD VDD net431 sky130_fd_sc_hd__buf_4
X_16777_ _06953_ _05195_ net425 VSS VSS VDD VDD _01944_ sky130_fd_sc_hd__a21oi_1
X_16778_ network.in_spk02_14 _05054_ VSS VSS VDD VDD _05197_
+ sky130_fd_sc_hd__nand2_1
X_16779_ _07268_ _05197_ net417 VSS VSS VDD VDD _01945_ sky130_fd_sc_hd__a21oi_1
X_16780_ network.neuron_in038.counter\[1\] network.neuron_in038.counter\[0\]
+ _00373_ VSS VSS VDD VDD _05198_ sky130_fd_sc_hd__o21bai_1
X_16781_ _03806_ _05198_ network.neuron_in038.counter\[3\]
+ VSS VSS VDD VDD _05199_ sky130_fd_sc_hd__a21oi_1
X_16782_ _03806_ _00372_ _00371_ network.neuron_in038.counter\[3\]
+ _05199_ VSS VSS VDD VDD _05200_ sky130_fd_sc_hd__a41o_1
X_16783_ net342 _03805_ network.in_period\[38\]\[3\] VSS VSS
+ VDD VDD _05201_ sky130_fd_sc_hd__a21oi_1
X_16784_ net340 _05200_ _05201_ VSS VSS VDD VDD _02218_ sky130_fd_sc_hd__a21oi_1
X_16785_ net345 _04638_ VSS VSS VDD VDD _05202_ sky130_fd_sc_hd__nand2_1
X_16786_ network.in_period\[83\]\[0\] _05202_ VSS VSS VDD
+ VDD _05203_ sky130_fd_sc_hd__nand2_1
X_16787_ network.neuron_in083.counter\[0\] _05202_ _05203_
+ VSS VSS VDD VDD _02395_ sky130_fd_sc_hd__o21ai_0
X_16788_ network.neuron_in039.counter\[1\] network.neuron_in039.counter\[2\]
+ network.neuron_in039.counter\[0\] net424 VSS VSS VDD VDD _05204_
+ sky130_fd_sc_hd__nor4_1
X_16789_ network.in_period\[39\]\[3\] _05204_ _03764_ VSS
+ VSS VDD VDD _05205_ sky130_fd_sc_hd__mux2i_1
X_16790_ network.neuron_in039.counter\[1\] network.neuron_in039.counter\[2\]
+ network.neuron_in039.counter\[0\] network.neuron_in039.counter\[3\]
+ net343 VSS VSS VDD VDD _05206_ sky130_fd_sc_hd__o311a_1
X_16791_ network.in_period\[39\]\[3\] net424 _05206_ VSS VSS
+ VDD VDD _05207_ sky130_fd_sc_hd__a21oi_1
X_16792_ network.neuron_in039.counter\[3\] _05205_ _05207_
+ VSS VSS VDD VDD _02222_ sky130_fd_sc_hd__o21ai_0
X_16793_ net357 _04621_ VSS VSS VDD VDD _05208_ sky130_fd_sc_hd__nand2_1
X_16794_ network.in_period\[88\]\[0\] _05208_ VSS VSS VDD
+ VDD _05209_ sky130_fd_sc_hd__nand2_1
X_16795_ network.neuron_in088.counter\[0\] _05208_ _05209_
+ VSS VSS VDD VDD _02415_ sky130_fd_sc_hd__o21ai_0
X_16796_ network.in_spk12_12 _05181_ network.in_spk13_12 VSS
+ VSS VDD VDD _05210_ sky130_fd_sc_hd__o21ai_0
X_16797_ _07034_ _05210_ net425 VSS VSS VDD VDD _01946_ sky130_fd_sc_hd__a21oi_1
X_16798_ network.in_spk04_14 _09426_ VSS VSS VDD VDD _05211_
+ sky130_fd_sc_hd__nand2_1
X_16799_ _07179_ _05211_ net413 VSS VSS VDD VDD _01947_ sky130_fd_sc_hd__a21oi_1
X_16800_ network.neuron_in040.counter\[0\] network.neuron_in040.counter\[1\]
+ network.neuron_in040.counter\[2\] net424 VSS VSS VDD VDD _05212_
+ sky130_fd_sc_hd__nor4_1
X_16801_ network.in_period\[40\]\[3\] _05212_ _03900_ VSS
+ VSS VDD VDD _05213_ sky130_fd_sc_hd__mux2i_1
Xplace462 net462 VSS VSS VDD VDD net461 sky130_fd_sc_hd__buf_4
X_16803_ network.neuron_in040.counter\[0\] network.neuron_in040.counter\[1\]
+ network.neuron_in040.counter\[2\] network.neuron_in040.counter\[3\]
+ net342 VSS VSS VDD VDD _05215_ sky130_fd_sc_hd__o311a_1
X_16804_ network.in_period\[40\]\[3\] net424 _05215_ VSS VSS
+ VDD VDD _05216_ sky130_fd_sc_hd__a21oi_1
X_16805_ network.neuron_in040.counter\[3\] _05213_ _05216_
+ VSS VSS VDD VDD _02226_ sky130_fd_sc_hd__o21ai_0
X_16806_ network.neuron_in081.counter\[2\] net345 VSS VSS
+ VDD VDD _05217_ sky130_fd_sc_hd__nand2_1
X_16807_ network.neuron_in081.counter\[3\] network.in_period\[81\]\[2\]
+ _05217_ VSS VSS VDD VDD _05218_ sky130_fd_sc_hd__o21ai_0
Xplace429 network.neuron_hid0.ROM0.address\[6\] VSS VSS VDD
+ VDD net428 sky130_fd_sc_hd__buf_4
X_16809_ _00082_ network.neuron_in081.counter\[2\] net414
+ VSS VSS VDD VDD _05220_ sky130_fd_sc_hd__or3_1
X_16810_ network.in_period\[81\]\[2\] net345 _05220_ VSS VSS
+ VDD VDD _05221_ sky130_fd_sc_hd__o21ai_0
X_16811_ _00082_ _05218_ _05221_ VSS VSS VDD VDD _02389_ sky130_fd_sc_hd__a21oi_1
X_16812_ network.neuron_in041.counter\[0\] network.neuron_in041.counter\[1\]
+ network.neuron_in041.counter\[2\] VSS VSS VDD VDD _05222_
+ sky130_fd_sc_hd__nor3_1
X_16813_ network.neuron_in041.counter\[3\] _05222_ VSS VSS
+ VDD VDD _05223_ sky130_fd_sc_hd__xnor2_1
X_16814_ network.in_period\[41\]\[3\] _03921_ VSS VSS VDD
+ VDD _05224_ sky130_fd_sc_hd__nand2_1
X_16815_ _03921_ _05223_ _05224_ VSS VSS VDD VDD _02230_ sky130_fd_sc_hd__o21ai_0
X_16816_ network.in_period\[83\]\[1\] _05202_ VSS VSS VDD
+ VDD _05225_ sky130_fd_sc_hd__nand2_1
X_16817_ _00061_ _05202_ _05225_ VSS VSS VDD VDD _02396_ sky130_fd_sc_hd__o21ai_0
X_16818_ network.arbit.counter\[0\] network.arbit.counter\[1\]
+ network.arbit.counter\[2\] _08818_ VSS VSS VDD VDD _05226_
+ sky130_fd_sc_hd__nor4_1
X_16819_ network.arbit.counter\[3\] _05226_ VSS VSS VDD VDD
+ _05227_ sky130_fd_sc_hd__xnor2_1
X_16820_ net366 _05227_ VSS VSS VDD VDD _01948_ sky130_fd_sc_hd__nand2_1
X_16821_ network.in_spk12_12 _05181_ VSS VSS VDD VDD _05228_
+ sky130_fd_sc_hd__nand2_1
X_16822_ _07029_ _05228_ net425 VSS VSS VDD VDD _01949_ sky130_fd_sc_hd__a21oi_1
X_16823_ network.neuron_in042.counter\[1\] network.neuron_in042.counter\[2\]
+ network.neuron_in042.counter\[0\] VSS VSS VDD VDD _05229_
+ sky130_fd_sc_hd__nor3_1
X_16824_ network.neuron_in042.counter\[3\] _05229_ VSS VSS
+ VDD VDD _05230_ sky130_fd_sc_hd__xnor2_1
X_16825_ network.in_period\[42\]\[3\] _03873_ VSS VSS VDD
+ VDD _05231_ sky130_fd_sc_hd__nand2_1
X_16826_ _03873_ _05230_ _05231_ VSS VSS VDD VDD _02234_ sky130_fd_sc_hd__o21ai_0
X_16827_ network.neuron_in086.counter\[2\] VSS VSS VDD VDD
+ _05232_ sky130_fd_sc_hd__inv_1
X_16828_ network.neuron_in086.counter\[3\] network.in_period\[86\]\[2\]
+ net414 _00040_ VSS VSS VDD VDD _05233_ sky130_fd_sc_hd__o22ai_1
X_16829_ network.neuron_in086.counter\[2\] _00040_ net345
+ VSS VSS VDD VDD _05234_ sky130_fd_sc_hd__nand3_1
X_16830_ network.in_period\[86\]\[2\] net345 _05234_ VSS VSS
+ VDD VDD _05235_ sky130_fd_sc_hd__o21ai_0
X_16831_ _05232_ _05233_ _05235_ VSS VSS VDD VDD _02409_ sky130_fd_sc_hd__a21oi_1
X_16832_ net454 net453 _08791_ loaded\[8\] VSS VSS VDD VDD
+ _05236_ sky130_fd_sc_hd__a31oi_1
X_16833_ _08779_ _05236_ VSS VSS VDD VDD _01950_ sky130_fd_sc_hd__nor2_1
X_16834_ _06672_ _06658_ _08779_ VSS VSS VDD VDD _01951_ sky130_fd_sc_hd__a21oi_1
X_16835_ network.neuron_in043.counter\[1\] network.neuron_in043.counter\[2\]
+ network.neuron_in043.counter\[0\] net423 VSS VSS VDD VDD _05237_
+ sky130_fd_sc_hd__nor4_1
X_16836_ network.in_period\[43\]\[3\] _05237_ _04161_ VSS
+ VSS VDD VDD _05238_ sky130_fd_sc_hd__mux2i_1
X_16837_ network.neuron_in043.counter\[1\] network.neuron_in043.counter\[2\]
+ network.neuron_in043.counter\[0\] network.neuron_in043.counter\[3\]
+ net342 VSS VSS VDD VDD _05239_ sky130_fd_sc_hd__o311a_1
X_16838_ network.in_period\[43\]\[3\] net423 _05239_ VSS VSS
+ VDD VDD _05240_ sky130_fd_sc_hd__a21oi_1
X_16839_ network.neuron_in043.counter\[3\] _05238_ _05240_
+ VSS VSS VDD VDD _02238_ sky130_fd_sc_hd__o21ai_0
X_16840_ network.in_period\[88\]\[1\] _05208_ VSS VSS VDD
+ VDD _05241_ sky130_fd_sc_hd__nand2_1
X_16841_ _01215_ _05208_ _05241_ VSS VSS VDD VDD _02416_ sky130_fd_sc_hd__o21ai_0
X_16842_ net45 _08705_ _08707_ VSS VSS VDD VDD _05242_ sky130_fd_sc_hd__mux2i_1
X_16843_ net455 _05242_ VSS VSS VDD VDD _01952_ sky130_fd_sc_hd__nor2_1
X_16844_ _09466_ _05180_ VSS VSS VDD VDD _05243_ sky130_fd_sc_hd__nand2_1
X_16845_ network.in_spk10_12 _05243_ network.in_spk11_12 VSS
+ VSS VDD VDD _05244_ sky130_fd_sc_hd__o21ai_0
X_16846_ _06948_ _05244_ net425 VSS VSS VDD VDD _01953_ sky130_fd_sc_hd__a21oi_1
X_16847_ net33 _08727_ VSS VSS VDD VDD _05245_ sky130_fd_sc_hd__nand2_1
X_16848_ net32 _08718_ _08739_ VSS VSS VDD VDD _05246_ sky130_fd_sc_hd__nand3_1
X_16849_ net33 _05245_ _05246_ VSS VSS VDD VDD _05247_ sky130_fd_sc_hd__mux2_2
X_16850_ net455 _05247_ VSS VSS VDD VDD _01954_ sky130_fd_sc_hd__nor2_1
X_16851_ network.neuron_in044.counter\[1\] network.neuron_in044.counter\[0\]
+ _00325_ VSS VSS VDD VDD _05248_ sky130_fd_sc_hd__o21bai_1
X_16852_ _04148_ _05248_ network.neuron_in044.counter\[3\]
+ VSS VSS VDD VDD _05249_ sky130_fd_sc_hd__a21oi_1
X_16853_ _04148_ _00324_ _00323_ network.neuron_in044.counter\[3\]
+ _05249_ VSS VSS VDD VDD _05250_ sky130_fd_sc_hd__a41o_1
X_16854_ net340 _04166_ network.in_period\[44\]\[3\] VSS VSS
+ VDD VDD _05251_ sky130_fd_sc_hd__a21oi_1
X_16855_ net340 _05250_ _05251_ VSS VSS VDD VDD _02242_ sky130_fd_sc_hd__a21oi_1
X_16856_ net455 _08707_ VSS VSS VDD VDD _01955_ sky130_fd_sc_hd__nor2b_1
X_16857_ _08684_ net333 _08688_ VSS VSS VDD VDD _05252_ sky130_fd_sc_hd__o21bai_1
X_16858_ _08707_ net47 VSS VSS VDD VDD _05253_ sky130_fd_sc_hd__nor2b_1
X_16859_ _08704_ _08707_ _05252_ _05253_ net455 VSS VSS VDD
+ VDD _01956_ sky130_fd_sc_hd__a311o_1
X_16860_ network.neuron_in045.counter\[0\] network.neuron_in045.counter\[1\]
+ network.neuron_in045.counter\[2\] VSS VSS VDD VDD _05254_
+ sky130_fd_sc_hd__nor3_1
X_16861_ network.neuron_in045.counter\[3\] _05254_ VSS VSS
+ VDD VDD _05255_ sky130_fd_sc_hd__xnor2_1
X_16862_ network.in_period\[45\]\[3\] _04155_ VSS VSS VDD
+ VDD _05256_ sky130_fd_sc_hd__nand2_1
X_16863_ _04155_ _05255_ _05256_ VSS VSS VDD VDD _02246_ sky130_fd_sc_hd__o21ai_0
X_16864_ network.neuron_in080.counter\[0\] VSS VSS VDD VDD
+ _00084_ sky130_fd_sc_hd__inv_1
X_16865_ net357 _04649_ VSS VSS VDD VDD _05257_ sky130_fd_sc_hd__nand2_1
X_16866_ network.in_period\[80\]\[0\] _05257_ VSS VSS VDD
+ VDD _05258_ sky130_fd_sc_hd__nand2_1
X_16867_ network.neuron_in080.counter\[0\] _05257_ _05258_
+ VSS VSS VDD VDD _02383_ sky130_fd_sc_hd__o21ai_0
X_16868_ network.in_spk10_12 _05243_ VSS VSS VDD VDD _05259_
+ sky130_fd_sc_hd__nand2_1
X_16869_ _06972_ _05259_ net421 VSS VSS VDD VDD _01957_ sky130_fd_sc_hd__a21oi_1
X_16870_ net25 _01573_ VSS VSS VDD VDD _05260_ sky130_fd_sc_hd__nor2_1
X_16871_ _08779_ _05260_ VSS VSS VDD VDD _01958_ sky130_fd_sc_hd__nor2_1
X_16872_ network.neuron_in046.counter\[1\] network.neuron_in046.counter\[0\]
+ network.neuron_in046.counter\[2\] net425 VSS VSS VDD VDD _05261_
+ sky130_fd_sc_hd__nor4_1
X_16873_ network.in_period\[46\]\[3\] _05261_ _04157_ VSS
+ VSS VDD VDD _05262_ sky130_fd_sc_hd__mux2i_1
Xplace428 net428 VSS VSS VDD VDD net427 sky130_fd_sc_hd__buf_4
X_16875_ network.neuron_in046.counter\[1\] network.neuron_in046.counter\[0\]
+ network.neuron_in046.counter\[2\] network.neuron_in046.counter\[3\]
+ net340 VSS VSS VDD VDD _05264_ sky130_fd_sc_hd__o311a_1
X_16876_ network.in_period\[46\]\[3\] net425 _05264_ VSS VSS
+ VDD VDD _05265_ sky130_fd_sc_hd__a21oi_1
X_16877_ network.neuron_in046.counter\[3\] _05262_ _05265_
+ VSS VSS VDD VDD _02250_ sky130_fd_sc_hd__o21ai_0
X_16878_ network.neuron_in082.counter\[3\] network.in_period\[82\]\[2\]
+ net414 _00056_ VSS VSS VDD VDD _05266_ sky130_fd_sc_hd__o22ai_1
X_16879_ network.neuron_in082.counter\[2\] _00056_ net345
+ VSS VSS VDD VDD _05267_ sky130_fd_sc_hd__nand3_1
X_16880_ network.in_period\[82\]\[2\] net345 _05267_ VSS VSS
+ VDD VDD _05268_ sky130_fd_sc_hd__o21ai_0
X_16881_ _04640_ _05266_ _05268_ VSS VSS VDD VDD _02393_ sky130_fd_sc_hd__a21oi_1
Xplace431 net432 VSS VSS VDD VDD net430 sky130_fd_sc_hd__buf_4
X_16883_ network.neuron_in047.counter\[1\] network.neuron_in047.counter\[0\]
+ _00305_ VSS VSS VDD VDD _05270_ sky130_fd_sc_hd__o21bai_1
X_16884_ _04194_ _05270_ network.neuron_in047.counter\[3\]
+ VSS VSS VDD VDD _05271_ sky130_fd_sc_hd__a21oi_1
X_16885_ _04194_ _00304_ _00303_ network.neuron_in047.counter\[3\]
+ _05271_ VSS VSS VDD VDD _05272_ sky130_fd_sc_hd__a41o_1
X_16886_ net340 _04193_ network.in_period\[47\]\[3\] VSS VSS
+ VDD VDD _05273_ sky130_fd_sc_hd__a21oi_1
X_16887_ net340 _05272_ _05273_ VSS VSS VDD VDD _02254_ sky130_fd_sc_hd__a21oi_1
X_16888_ network.neuron_in083.counter\[2\] VSS VSS VDD VDD
+ _05274_ sky130_fd_sc_hd__inv_1
X_16889_ network.neuron_in083.counter\[3\] network.in_period\[83\]\[2\]
+ net414 _00060_ VSS VSS VDD VDD _05275_ sky130_fd_sc_hd__o22ai_1
X_16890_ network.neuron_in083.counter\[2\] _00060_ net345
+ VSS VSS VDD VDD _05276_ sky130_fd_sc_hd__nand3_1
X_16891_ network.in_period\[83\]\[2\] net345 _05276_ VSS VSS
+ VDD VDD _05277_ sky130_fd_sc_hd__o21ai_0
X_16892_ _05274_ _05275_ _05277_ VSS VSS VDD VDD _02397_ sky130_fd_sc_hd__a21oi_1
X_16893_ network.in_spk08_12 _09377_ network.in_spk09_12 VSS
+ VSS VDD VDD _05278_ sky130_fd_sc_hd__o21ai_0
X_16894_ _06943_ _05278_ net421 VSS VSS VDD VDD _01959_ sky130_fd_sc_hd__a21oi_1
X_16895_ network.neuron_in048.counter\[0\] network.neuron_in048.counter\[2\]
+ network.neuron_in048.counter\[1\] net418 VSS VSS VDD VDD _05279_
+ sky130_fd_sc_hd__nor4_1
X_16896_ network.in_period\[48\]\[3\] _05279_ _04200_ VSS
+ VSS VDD VDD _05280_ sky130_fd_sc_hd__mux2i_1
X_16897_ network.neuron_in048.counter\[0\] network.neuron_in048.counter\[2\]
+ network.neuron_in048.counter\[1\] network.neuron_in048.counter\[3\]
+ net352 VSS VSS VDD VDD _05281_ sky130_fd_sc_hd__o311a_1
X_16898_ network.in_period\[48\]\[3\] net418 _05281_ VSS VSS
+ VDD VDD _05282_ sky130_fd_sc_hd__a21oi_1
X_16899_ network.neuron_in048.counter\[3\] _05280_ _05282_
+ VSS VSS VDD VDD _02258_ sky130_fd_sc_hd__o21ai_0
X_16900_ net345 _04635_ VSS VSS VDD VDD _05283_ sky130_fd_sc_hd__nand2_1
X_16901_ network.in_period\[84\]\[0\] _05283_ VSS VSS VDD
+ VDD _05284_ sky130_fd_sc_hd__nand2_1
X_16902_ network.neuron_in084.counter\[0\] _05283_ _05284_
+ VSS VSS VDD VDD _02399_ sky130_fd_sc_hd__o21ai_0
X_16903_ network.neuron_in049.counter\[0\] network.neuron_in049.counter\[1\]
+ network.neuron_in049.counter\[2\] net418 VSS VSS VDD VDD _05285_
+ sky130_fd_sc_hd__nor4_1
X_16904_ network.in_period\[49\]\[3\] _05285_ _04185_ VSS
+ VSS VDD VDD _05286_ sky130_fd_sc_hd__mux2i_1
X_16905_ network.neuron_in049.counter\[0\] network.neuron_in049.counter\[1\]
+ network.neuron_in049.counter\[2\] network.neuron_in049.counter\[3\]
+ net349 VSS VSS VDD VDD _05287_ sky130_fd_sc_hd__o311a_1
X_16906_ network.in_period\[49\]\[3\] net418 _05287_ VSS VSS
+ VDD VDD _05288_ sky130_fd_sc_hd__a21oi_1
X_16907_ network.neuron_in049.counter\[3\] _05286_ _05288_
+ VSS VSS VDD VDD _02262_ sky130_fd_sc_hd__o21ai_0
X_16908_ net345 _04631_ VSS VSS VDD VDD _05289_ sky130_fd_sc_hd__nand2_1
X_16909_ network.in_period\[85\]\[0\] _05289_ VSS VSS VDD
+ VDD _05290_ sky130_fd_sc_hd__nand2_1
X_16910_ network.neuron_in085.counter\[0\] _05289_ _05290_
+ VSS VSS VDD VDD _02403_ sky130_fd_sc_hd__o21ai_0
X_16911_ network.in_spk08_12 _09377_ VSS VSS VDD VDD _05291_
+ sky130_fd_sc_hd__nand2_1
X_16912_ _07016_ _05291_ net421 VSS VSS VDD VDD _01960_ sky130_fd_sc_hd__a21oi_1
Xplace438 net438 VSS VSS VDD VDD net437 sky130_fd_sc_hd__buf_4
X_16914_ network.neuron_in050.counter\[1\] network.neuron_in050.counter\[2\]
+ network.neuron_in050.counter\[0\] net421 VSS VSS VDD VDD _05293_
+ sky130_fd_sc_hd__nor4_1
X_16915_ network.in_period\[50\]\[3\] _05293_ _04205_ VSS
+ VSS VDD VDD _05294_ sky130_fd_sc_hd__mux2i_1
X_16916_ network.neuron_in050.counter\[1\] network.neuron_in050.counter\[2\]
+ network.neuron_in050.counter\[0\] network.neuron_in050.counter\[3\]
+ net352 VSS VSS VDD VDD _05295_ sky130_fd_sc_hd__o311a_1
X_16917_ network.in_period\[50\]\[3\] net421 _05295_ VSS VSS
+ VDD VDD _05296_ sky130_fd_sc_hd__a21oi_1
X_16918_ network.neuron_in050.counter\[3\] _05294_ _05296_
+ VSS VSS VDD VDD _02266_ sky130_fd_sc_hd__o21ai_0
X_16919_ network.neuron_in087.counter\[2\] net345 VSS VSS
+ VDD VDD _05297_ sky130_fd_sc_hd__nand2_1
X_16920_ network.neuron_in087.counter\[3\] network.in_period\[87\]\[2\]
+ _05297_ VSS VSS VDD VDD _05298_ sky130_fd_sc_hd__o21ai_0
X_16921_ _00036_ network.neuron_in087.counter\[2\] net414
+ VSS VSS VDD VDD _05299_ sky130_fd_sc_hd__or3_1
X_16922_ network.in_period\[87\]\[2\] net345 _05299_ VSS VSS
+ VDD VDD _05300_ sky130_fd_sc_hd__o21ai_0
X_16923_ _00036_ _05298_ _05300_ VSS VSS VDD VDD _02413_ sky130_fd_sc_hd__a21oi_1
X_16924_ network.neuron_in051.counter\[0\] network.neuron_in051.counter\[2\]
+ network.neuron_in051.counter\[1\] net418 VSS VSS VDD VDD _05301_
+ sky130_fd_sc_hd__nor4_1
X_16925_ network.in_period\[51\]\[3\] _05301_ _04213_ VSS
+ VSS VDD VDD _05302_ sky130_fd_sc_hd__mux2i_1
X_16926_ network.neuron_in051.counter\[0\] network.neuron_in051.counter\[2\]
+ network.neuron_in051.counter\[1\] net350 network.neuron_in051.counter\[3\]
+ VSS VSS VDD VDD _05303_ sky130_fd_sc_hd__o311a_1
X_16927_ network.in_period\[51\]\[3\] net418 _05303_ VSS VSS
+ VDD VDD _05304_ sky130_fd_sc_hd__a21oi_1
X_16928_ network.neuron_in051.counter\[3\] _05302_ _05304_
+ VSS VSS VDD VDD _02270_ sky130_fd_sc_hd__o21ai_0
X_16929_ network.neuron_in088.counter\[3\] network.in_period\[88\]\[2\]
+ net414 _01214_ VSS VSS VDD VDD _05305_ sky130_fd_sc_hd__o22ai_1
X_16930_ network.neuron_in088.counter\[2\] _01214_ net357
+ VSS VSS VDD VDD _05306_ sky130_fd_sc_hd__nand3_1
X_16931_ network.in_period\[88\]\[2\] net357 _05306_ VSS VSS
+ VDD VDD _05307_ sky130_fd_sc_hd__o21ai_0
X_16932_ _04620_ _05305_ _05307_ VSS VSS VDD VDD _02417_ sky130_fd_sc_hd__a21oi_1
X_16933_ net369 _09245_ _09597_ VSS VSS VDD VDD _05308_ sky130_fd_sc_hd__nand3_1
X_16934_ network.in_spk04_12 network.in_spk05_12 _05308_ VSS
+ VSS VDD VDD _05309_ sky130_fd_sc_hd__nor3_1
X_16935_ network.in_spk07_12 _06994_ VSS VSS VDD VDD _05310_
+ sky130_fd_sc_hd__nand2b_1
X_16936_ net344 _05310_ VSS VSS VDD VDD _05311_ sky130_fd_sc_hd__nand2_1
X_16937_ _03456_ _06994_ _05309_ _05311_ VSS VSS VDD VDD _01961_
+ sky130_fd_sc_hd__a31oi_1
X_16938_ network.neuron_in052.counter\[0\] network.neuron_in052.counter\[1\]
+ _00281_ VSS VSS VDD VDD _05312_ sky130_fd_sc_hd__o21bai_1
X_16939_ _04189_ _05312_ network.neuron_in052.counter\[3\]
+ VSS VSS VDD VDD _05313_ sky130_fd_sc_hd__a21oi_1
X_16940_ _04189_ _00279_ _00280_ network.neuron_in052.counter\[3\]
+ _05313_ VSS VSS VDD VDD _05314_ sky130_fd_sc_hd__a41o_1
X_16941_ net350 _04265_ network.in_period\[52\]\[3\] VSS VSS
+ VDD VDD _05315_ sky130_fd_sc_hd__a21oi_1
X_16942_ net350 _05314_ _05315_ VSS VSS VDD VDD _02274_ sky130_fd_sc_hd__a21oi_1
X_16943_ network.neuron_in053.counter\[0\] network.neuron_in053.counter\[1\]
+ _00273_ VSS VSS VDD VDD _05316_ sky130_fd_sc_hd__o21bai_1
X_16944_ _04287_ _05316_ network.neuron_in053.counter\[3\]
+ VSS VSS VDD VDD _05317_ sky130_fd_sc_hd__a21oi_1
X_16945_ _04287_ _00271_ _00272_ network.neuron_in053.counter\[3\]
+ _05317_ VSS VSS VDD VDD _05318_ sky130_fd_sc_hd__a41o_1
X_16946_ net350 _04286_ network.in_period\[53\]\[3\] VSS VSS
+ VDD VDD _05319_ sky130_fd_sc_hd__a21oi_1
X_16947_ net350 _05318_ _05319_ VSS VSS VDD VDD _02278_ sky130_fd_sc_hd__a21oi_1
X_16948_ network.in_spk04_12 network.in_spk05_12 _05308_ network.in_spk06_12
+ VSS VSS VDD VDD _05320_ sky130_fd_sc_hd__o31ai_1
X_16949_ _06825_ _05320_ net426 VSS VSS VDD VDD _01962_ sky130_fd_sc_hd__a21oi_1
X_16950_ network.neuron_in054.counter\[0\] network.neuron_in054.counter\[1\]
+ network.neuron_in054.counter\[2\] VSS VSS VDD VDD _05321_
+ sky130_fd_sc_hd__nor3_1
X_16951_ network.neuron_in054.counter\[3\] _05321_ VSS VSS
+ VDD VDD _05322_ sky130_fd_sc_hd__xnor2_1
X_16952_ network.in_period\[54\]\[3\] _04312_ VSS VSS VDD
+ VDD _05323_ sky130_fd_sc_hd__nand2_1
X_16953_ _04312_ _05322_ _05323_ VSS VSS VDD VDD _02282_ sky130_fd_sc_hd__o21ai_0
X_16954_ network.neuron_in080.counter\[3\] network.in_period\[80\]\[2\]
+ net414 _00086_ VSS VSS VDD VDD _05324_ sky130_fd_sc_hd__o22ai_1
X_16955_ network.neuron_in080.counter\[2\] _00086_ net357
+ VSS VSS VDD VDD _05325_ sky130_fd_sc_hd__nand3_1
X_16956_ network.in_period\[80\]\[2\] net357 _05325_ VSS VSS
+ VDD VDD _05326_ sky130_fd_sc_hd__o21ai_0
X_16957_ _04647_ _05324_ _05326_ VSS VSS VDD VDD _02385_ sky130_fd_sc_hd__a21oi_1
X_16958_ network.neuron_in055.counter\[1\] network.neuron_in055.counter\[0\]
+ _00265_ VSS VSS VDD VDD _05327_ sky130_fd_sc_hd__o21bai_1
X_16959_ _04296_ _05327_ network.neuron_in055.counter\[3\]
+ VSS VSS VDD VDD _05328_ sky130_fd_sc_hd__a21oi_1
X_16960_ _04296_ _00264_ _00263_ network.neuron_in055.counter\[3\]
+ _05328_ VSS VSS VDD VDD _05329_ sky130_fd_sc_hd__a41o_1
Xplace433 network.neuron_hid0.ROM0.address\[5\] VSS VSS VDD
+ VDD net432 sky130_fd_sc_hd__buf_4
X_16962_ net350 _04295_ network.in_period\[55\]\[3\] VSS VSS
+ VDD VDD _05331_ sky130_fd_sc_hd__a21oi_1
X_16963_ net350 _05329_ _05331_ VSS VSS VDD VDD _02286_ sky130_fd_sc_hd__a21oi_1
X_16964_ network.in_period\[80\]\[1\] _05257_ VSS VSS VDD
+ VDD _05332_ sky130_fd_sc_hd__nand2_1
X_16965_ _00087_ _05257_ _05332_ VSS VSS VDD VDD _02384_ sky130_fd_sc_hd__o21ai_0
X_16966_ network.in_spk04_12 _05308_ network.in_spk05_12 VSS
+ VSS VDD VDD _05333_ sky130_fd_sc_hd__o21ai_0
Xplace482 net18 VSS VSS VDD VDD net481 sky130_fd_sc_hd__buf_4
X_16968_ _06923_ _05333_ net426 VSS VSS VDD VDD _01963_ sky130_fd_sc_hd__a21oi_1
X_16969_ network.neuron_in056.counter\[1\] network.neuron_in056.counter\[2\]
+ network.neuron_in056.counter\[0\] net418 VSS VSS VDD VDD _05335_
+ sky130_fd_sc_hd__nor4_1
X_16970_ network.in_period\[56\]\[3\] _05335_ _04301_ VSS
+ VSS VDD VDD _05336_ sky130_fd_sc_hd__mux2i_1
X_16971_ network.neuron_in056.counter\[1\] network.neuron_in056.counter\[2\]
+ network.neuron_in056.counter\[0\] network.neuron_in056.counter\[3\]
+ net350 VSS VSS VDD VDD _05337_ sky130_fd_sc_hd__o311a_1
X_16972_ network.in_period\[56\]\[3\] net418 _05337_ VSS VSS
+ VDD VDD _05338_ sky130_fd_sc_hd__a21oi_1
X_16973_ network.neuron_in056.counter\[3\] _05336_ _05338_
+ VSS VSS VDD VDD _02290_ sky130_fd_sc_hd__o21ai_0
X_16974_ net345 _04645_ VSS VSS VDD VDD _05339_ sky130_fd_sc_hd__nand2_1
X_16975_ network.in_period\[81\]\[1\] _05339_ VSS VSS VDD
+ VDD _05340_ sky130_fd_sc_hd__nand2_1
X_16976_ _00083_ _05339_ _05340_ VSS VSS VDD VDD _02388_ sky130_fd_sc_hd__o21ai_0
X_16977_ network.neuron_in057.counter\[0\] network.neuron_in057.counter\[1\]
+ _00257_ VSS VSS VDD VDD _05341_ sky130_fd_sc_hd__o21bai_1
X_16978_ _04273_ _05341_ network.neuron_in057.counter\[3\]
+ VSS VSS VDD VDD _05342_ sky130_fd_sc_hd__a21oi_1
X_16979_ _04273_ _00255_ _00256_ network.neuron_in057.counter\[3\]
+ _05342_ VSS VSS VDD VDD _05343_ sky130_fd_sc_hd__a41o_1
X_16980_ net350 _04272_ network.in_period\[57\]\[3\] VSS VSS
+ VDD VDD _05344_ sky130_fd_sc_hd__a21oi_1
X_16981_ net350 _05343_ _05344_ VSS VSS VDD VDD _02294_ sky130_fd_sc_hd__a21oi_1
X_16982_ network.in_period\[81\]\[0\] _05339_ VSS VSS VDD
+ VDD _05345_ sky130_fd_sc_hd__nand2_1
X_16983_ network.neuron_in081.counter\[0\] _05339_ _05345_
+ VSS VSS VDD VDD _02387_ sky130_fd_sc_hd__o21ai_0
X_16984_ network.in_spk04_12 _05308_ VSS VSS VDD VDD _05346_
+ sky130_fd_sc_hd__nand2_1
X_16985_ _06844_ _05346_ net426 VSS VSS VDD VDD _01964_ sky130_fd_sc_hd__a21oi_1
X_16986_ network.neuron_in058.counter\[1\] network.neuron_in058.counter\[0\]
+ _00245_ VSS VSS VDD VDD _05347_ sky130_fd_sc_hd__o21bai_1
X_16987_ _04367_ _05347_ network.neuron_in058.counter\[3\]
+ VSS VSS VDD VDD _05348_ sky130_fd_sc_hd__a21oi_1
X_16988_ _04367_ _00244_ _00243_ network.neuron_in058.counter\[3\]
+ _05348_ VSS VSS VDD VDD _05349_ sky130_fd_sc_hd__a41o_1
X_16989_ net350 _04366_ network.in_period\[58\]\[3\] VSS VSS
+ VDD VDD _05350_ sky130_fd_sc_hd__a21oi_1
X_16990_ net350 _05349_ _05350_ VSS VSS VDD VDD _02298_ sky130_fd_sc_hd__a21oi_1
X_16991_ net345 _04642_ VSS VSS VDD VDD _05351_ sky130_fd_sc_hd__nand2_1
X_16992_ network.in_period\[82\]\[1\] _05351_ VSS VSS VDD
+ VDD _05352_ sky130_fd_sc_hd__nand2_1
X_16993_ _00057_ _05351_ _05352_ VSS VSS VDD VDD _02392_ sky130_fd_sc_hd__o21ai_0
X_16994_ network.neuron_in059.counter\[0\] network.neuron_in059.counter\[1\]
+ network.neuron_in059.counter\[2\] net418 VSS VSS VDD VDD _05353_
+ sky130_fd_sc_hd__nor4_1
X_16995_ network.in_period\[59\]\[3\] _05353_ _04329_ VSS
+ VSS VDD VDD _05354_ sky130_fd_sc_hd__mux2i_1
X_16996_ network.neuron_in059.counter\[0\] network.neuron_in059.counter\[1\]
+ network.neuron_in059.counter\[2\] network.neuron_in059.counter\[3\]
+ net350 VSS VSS VDD VDD _05355_ sky130_fd_sc_hd__o311a_1
X_16997_ network.in_period\[59\]\[3\] net418 _05355_ VSS VSS
+ VDD VDD _05356_ sky130_fd_sc_hd__a21oi_1
X_16998_ network.neuron_in059.counter\[3\] _05354_ _05356_
+ VSS VSS VDD VDD _02302_ sky130_fd_sc_hd__o21ai_0
X_16999_ network.in_period\[82\]\[0\] _05351_ VSS VSS VDD
+ VDD _05357_ sky130_fd_sc_hd__nand2_1
X_17000_ network.neuron_in082.counter\[0\] _05351_ _05357_
+ VSS VSS VDD VDD _02391_ sky130_fd_sc_hd__o21ai_0
X_17001_ _09604_ _09597_ VSS VSS VDD VDD _05358_ sky130_fd_sc_hd__nand2_1
X_17002_ network.in_spk02_12 _05358_ network.in_spk03_12 VSS
+ VSS VDD VDD _05359_ sky130_fd_sc_hd__o21ai_0
X_17003_ _06917_ _05359_ net426 VSS VSS VDD VDD _01965_ sky130_fd_sc_hd__a21oi_1
X_17004_ network.neuron_in060.counter\[0\] network.neuron_in060.counter\[2\]
+ network.neuron_in060.counter\[1\] net422 VSS VSS VDD VDD _05360_
+ sky130_fd_sc_hd__nor4_1
X_17005_ network.in_period\[60\]\[3\] _05360_ _04324_ VSS
+ VSS VDD VDD _05361_ sky130_fd_sc_hd__mux2i_1
X_17006_ network.neuron_in060.counter\[0\] network.neuron_in060.counter\[2\]
+ network.neuron_in060.counter\[1\] network.neuron_in060.counter\[3\]
+ net349 VSS VSS VDD VDD _05362_ sky130_fd_sc_hd__o311a_1
X_17007_ network.in_period\[60\]\[3\] net422 _05362_ VSS VSS
+ VDD VDD _05363_ sky130_fd_sc_hd__a21oi_1
X_17008_ network.neuron_in060.counter\[3\] _05361_ _05363_
+ VSS VSS VDD VDD _02306_ sky130_fd_sc_hd__o21ai_0
X_17009_ network.neuron_in084.counter\[3\] network.in_period\[84\]\[2\]
+ net414 _00048_ VSS VSS VDD VDD _05364_ sky130_fd_sc_hd__o22ai_1
X_17010_ network.neuron_in084.counter\[2\] _00048_ net345
+ VSS VSS VDD VDD _05365_ sky130_fd_sc_hd__nand3_1
X_17011_ network.in_period\[84\]\[2\] net345 _05365_ VSS VSS
+ VDD VDD _05366_ sky130_fd_sc_hd__o21ai_0
X_17012_ _04634_ _05364_ _05366_ VSS VSS VDD VDD _02401_ sky130_fd_sc_hd__a21oi_1
X_17013_ network.neuron_in061.counter\[1\] network.neuron_in061.counter\[2\]
+ network.neuron_in061.counter\[0\] VSS VSS VDD VDD _05367_
+ sky130_fd_sc_hd__nor3_1
X_17014_ network.neuron_in061.counter\[3\] _05367_ VSS VSS
+ VDD VDD _05368_ sky130_fd_sc_hd__xnor2_1
X_17015_ network.in_period\[61\]\[3\] _04422_ VSS VSS VDD
+ VDD _05369_ sky130_fd_sc_hd__nand2_1
X_17016_ _04422_ _05368_ _05369_ VSS VSS VDD VDD _02310_ sky130_fd_sc_hd__o21ai_0
X_17017_ network.in_period\[84\]\[1\] _05283_ VSS VSS VDD
+ VDD _05370_ sky130_fd_sc_hd__nand2_1
X_17018_ _00049_ _05283_ _05370_ VSS VSS VDD VDD _02400_ sky130_fd_sc_hd__o21ai_0
X_17019_ network.in_spk02_12 _05358_ VSS VSS VDD VDD _05371_
+ sky130_fd_sc_hd__nand2_1
X_17020_ _06912_ _05371_ net426 VSS VSS VDD VDD _01966_ sky130_fd_sc_hd__a21oi_1
X_17021_ network.neuron_in062.counter\[0\] network.neuron_in062.counter\[2\]
+ network.neuron_in062.counter\[1\] VSS VSS VDD VDD _05372_
+ sky130_fd_sc_hd__nor3_1
X_17022_ network.neuron_in062.counter\[3\] _05372_ VSS VSS
+ VDD VDD _05373_ sky130_fd_sc_hd__xnor2_1
X_17023_ network.in_period\[62\]\[3\] _04404_ VSS VSS VDD
+ VDD _05374_ sky130_fd_sc_hd__nand2_1
X_17024_ _04404_ _05373_ _05374_ VSS VSS VDD VDD _02314_ sky130_fd_sc_hd__o21ai_0
X_17025_ network.neuron_in085.counter\[2\] VSS VSS VDD VDD
+ _05375_ sky130_fd_sc_hd__inv_1
Xplace458 net458 VSS VSS VDD VDD net457 sky130_fd_sc_hd__buf_4
X_17027_ network.neuron_in085.counter\[3\] network.in_period\[85\]\[2\]
+ net414 _00044_ VSS VSS VDD VDD _05377_ sky130_fd_sc_hd__o22ai_1
X_17028_ network.neuron_in085.counter\[2\] _00044_ net345
+ VSS VSS VDD VDD _05378_ sky130_fd_sc_hd__nand3_1
X_17029_ network.in_period\[85\]\[2\] net345 _05378_ VSS VSS
+ VDD VDD _05379_ sky130_fd_sc_hd__o21ai_0
X_17030_ _05375_ _05377_ _05379_ VSS VSS VDD VDD _02405_ sky130_fd_sc_hd__a21oi_1
X_17031_ network.neuron_in063.counter\[1\] network.neuron_in063.counter\[2\]
+ network.neuron_in063.counter\[0\] net418 VSS VSS VDD VDD _05380_
+ sky130_fd_sc_hd__nor4_1
X_17032_ network.in_period\[63\]\[3\] _05380_ _04432_ VSS
+ VSS VDD VDD _05381_ sky130_fd_sc_hd__mux2i_1
X_17033_ network.neuron_in063.counter\[1\] network.neuron_in063.counter\[2\]
+ network.neuron_in063.counter\[0\] network.neuron_in063.counter\[3\]
+ net350 VSS VSS VDD VDD _05382_ sky130_fd_sc_hd__o311a_1
X_17034_ network.in_period\[63\]\[3\] net418 _05382_ VSS VSS
+ VDD VDD _05383_ sky130_fd_sc_hd__a21oi_1
X_17035_ network.neuron_in063.counter\[3\] _05381_ _05383_
+ VSS VSS VDD VDD _02318_ sky130_fd_sc_hd__o21ai_0
X_17036_ network.in_period\[85\]\[1\] _05289_ VSS VSS VDD
+ VDD _05384_ sky130_fd_sc_hd__nand2_1
X_17037_ _00045_ _05289_ _05384_ VSS VSS VDD VDD _02404_ sky130_fd_sc_hd__o21ai_0
X_17038_ network.in_spk00_12 _09333_ network.in_spk01_12 VSS
+ VSS VDD VDD _05385_ sky130_fd_sc_hd__o21ai_0
X_17039_ _06840_ _05385_ net426 VSS VSS VDD VDD _01967_ sky130_fd_sc_hd__a21oi_1
X_17040_ network.neuron_in064.counter\[0\] network.neuron_in064.counter\[1\]
+ network.neuron_in064.counter\[2\] net420 VSS VSS VDD VDD _05386_
+ sky130_fd_sc_hd__nor4_1
X_17041_ network.in_period\[64\]\[3\] _05386_ _04398_ VSS
+ VSS VDD VDD _05387_ sky130_fd_sc_hd__mux2i_1
Xplace456 net483 VSS VSS VDD VDD net455 sky130_fd_sc_hd__buf_4
X_17043_ network.neuron_in064.counter\[0\] network.neuron_in064.counter\[1\]
+ network.neuron_in064.counter\[2\] network.neuron_in064.counter\[3\]
+ net354 VSS VSS VDD VDD _05389_ sky130_fd_sc_hd__o311a_1
X_17044_ network.in_period\[64\]\[3\] net420 _05389_ VSS VSS
+ VDD VDD _05390_ sky130_fd_sc_hd__a21oi_1
X_17045_ network.neuron_in064.counter\[3\] _05387_ _05390_
+ VSS VSS VDD VDD _02322_ sky130_fd_sc_hd__o21ai_0
X_17046_ net345 _04628_ VSS VSS VDD VDD _05391_ sky130_fd_sc_hd__nand2_1
X_17047_ network.in_period\[86\]\[1\] _05391_ VSS VSS VDD
+ VDD _05392_ sky130_fd_sc_hd__nand2_1
X_17048_ _00041_ _05391_ _05392_ VSS VSS VDD VDD _02408_ sky130_fd_sc_hd__o21ai_0
X_17049_ network.neuron_in065.counter\[1\] network.neuron_in065.counter\[2\]
+ network.neuron_in065.counter\[0\] net420 VSS VSS VDD VDD _05393_
+ sky130_fd_sc_hd__nor4_1
X_17050_ network.in_period\[65\]\[3\] _05393_ _04455_ VSS
+ VSS VDD VDD _05394_ sky130_fd_sc_hd__mux2i_1
Xplace463 net21 VSS VSS VDD VDD net462 sky130_fd_sc_hd__buf_4
X_17052_ network.neuron_in065.counter\[1\] network.neuron_in065.counter\[2\]
+ network.neuron_in065.counter\[0\] network.neuron_in065.counter\[3\]
+ net354 VSS VSS VDD VDD _05396_ sky130_fd_sc_hd__o311a_1
X_17053_ network.in_period\[65\]\[3\] net420 _05396_ VSS VSS
+ VDD VDD _05397_ sky130_fd_sc_hd__a21oi_1
X_17054_ network.neuron_in065.counter\[3\] _05394_ _05397_
+ VSS VSS VDD VDD _02326_ sky130_fd_sc_hd__o21ai_0
X_17055_ network.in_period\[86\]\[0\] _05391_ VSS VSS VDD
+ VDD _05398_ sky130_fd_sc_hd__nand2_1
X_17056_ network.neuron_in086.counter\[0\] _05391_ _05398_
+ VSS VSS VDD VDD _02407_ sky130_fd_sc_hd__o21ai_0
X_17057_ network.in_spk00_12 _09333_ VSS VSS VDD VDD _05399_
+ sky130_fd_sc_hd__nand2_1
X_17058_ _06859_ _05399_ net426 VSS VSS VDD VDD _01968_ sky130_fd_sc_hd__a21oi_1
X_17059_ network.neuron_in066.counter\[1\] network.neuron_in066.counter\[0\]
+ network.neuron_in066.counter\[2\] net420 VSS VSS VDD VDD _05400_
+ sky130_fd_sc_hd__nor4_1
X_17060_ network.in_period\[66\]\[3\] _05400_ _04460_ VSS
+ VSS VDD VDD _05401_ sky130_fd_sc_hd__mux2i_1
X_17061_ network.neuron_in066.counter\[1\] network.neuron_in066.counter\[0\]
+ network.neuron_in066.counter\[2\] network.neuron_in066.counter\[3\]
+ net354 VSS VSS VDD VDD _05402_ sky130_fd_sc_hd__o311a_1
X_17062_ network.in_period\[66\]\[3\] net420 _05402_ VSS VSS
+ VDD VDD _05403_ sky130_fd_sc_hd__a21oi_1
X_17063_ network.neuron_in066.counter\[3\] _05401_ _05403_
+ VSS VSS VDD VDD _02330_ sky130_fd_sc_hd__o21ai_0
Xplace414 net426 VSS VSS VDD VDD net413 sky130_fd_sc_hd__buf_4
X_17065_ net345 _04624_ VSS VSS VDD VDD _05405_ sky130_fd_sc_hd__nand2_1
X_17066_ network.in_period\[87\]\[1\] _05405_ VSS VSS VDD
+ VDD _05406_ sky130_fd_sc_hd__nand2_1
X_17067_ _00037_ _05405_ _05406_ VSS VSS VDD VDD _02412_ sky130_fd_sc_hd__o21ai_0
X_17068_ network.neuron_in067.counter\[1\] network.neuron_in067.counter\[0\]
+ network.neuron_in067.counter\[2\] net420 VSS VSS VDD VDD _05407_
+ sky130_fd_sc_hd__nor4_1
X_17069_ network.in_period\[67\]\[3\] _05407_ _04437_ VSS
+ VSS VDD VDD _05408_ sky130_fd_sc_hd__mux2i_1
X_17070_ network.neuron_in067.counter\[1\] network.neuron_in067.counter\[0\]
+ network.neuron_in067.counter\[2\] network.neuron_in067.counter\[3\]
+ net354 VSS VSS VDD VDD _05409_ sky130_fd_sc_hd__o311a_1
X_17071_ network.in_period\[67\]\[3\] net420 _05409_ VSS VSS
+ VDD VDD _05410_ sky130_fd_sc_hd__a21oi_1
X_17072_ network.neuron_in067.counter\[3\] _05408_ _05410_
+ VSS VSS VDD VDD _02334_ sky130_fd_sc_hd__o21ai_0
X_17073_ network.in_period\[87\]\[0\] _05405_ VSS VSS VDD
+ VDD _05411_ sky130_fd_sc_hd__nand2_1
X_17074_ network.neuron_in087.counter\[0\] _05405_ _05411_
+ VSS VSS VDD VDD _02411_ sky130_fd_sc_hd__o21ai_0
X_17075_ _09674_ _09345_ VSS VSS VDD VDD _05412_ sky130_fd_sc_hd__nand2_1
X_17076_ network.in_spk14_11 _05412_ network.in_spk15_11 VSS
+ VSS VDD VDD _05413_ sky130_fd_sc_hd__o21ai_0
X_17077_ _06830_ _05413_ net415 VSS VSS VDD VDD _01969_ sky130_fd_sc_hd__a21oi_1
Xplace329 _09340_ VSS VSS VDD VDD net328 sky130_fd_sc_hd__buf_4
X_17079_ network.neuron_in068.counter\[1\] network.neuron_in068.counter\[2\]
+ network.neuron_in068.counter\[0\] net411 VSS VSS VDD VDD _05415_
+ sky130_fd_sc_hd__nor4_1
X_17080_ network.in_period\[68\]\[3\] _05415_ _04495_ VSS
+ VSS VDD VDD _05416_ sky130_fd_sc_hd__mux2i_1
X_17081_ network.neuron_in068.counter\[1\] network.neuron_in068.counter\[2\]
+ network.neuron_in068.counter\[0\] network.neuron_in068.counter\[3\]
+ net355 VSS VSS VDD VDD _05417_ sky130_fd_sc_hd__o311a_1
X_17082_ network.in_period\[68\]\[3\] net411 _05417_ VSS VSS
+ VDD VDD _05418_ sky130_fd_sc_hd__a21oi_1
X_17083_ network.neuron_in068.counter\[3\] _05416_ _05418_
+ VSS VSS VDD VDD _02338_ sky130_fd_sc_hd__o21ai_0
X_17084_ network.neuron_in069.counter\[0\] network.neuron_in069.counter\[1\]
+ network.neuron_in069.counter\[2\] VSS VSS VDD VDD _05419_
+ sky130_fd_sc_hd__nor3_1
X_17085_ network.neuron_in069.counter\[3\] _05419_ VSS VSS
+ VDD VDD _05420_ sky130_fd_sc_hd__xnor2_1
X_17086_ network.in_period\[69\]\[3\] _04506_ VSS VSS VDD
+ VDD _05421_ sky130_fd_sc_hd__nand2_1
X_17087_ _04506_ _05420_ _05421_ VSS VSS VDD VDD _02342_ sky130_fd_sc_hd__o21ai_0
X_17088_ network.in_spk14_11 _05412_ VSS VSS VDD VDD _05422_
+ sky130_fd_sc_hd__nand2_1
X_17089_ _06888_ _05422_ net415 VSS VSS VDD VDD _01970_ sky130_fd_sc_hd__a21oi_1
X_17090_ network.neuron_in070.counter\[1\] network.neuron_in070.counter\[2\]
+ network.neuron_in070.counter\[0\] VSS VSS VDD VDD _05423_
+ sky130_fd_sc_hd__nor3_1
X_17091_ network.neuron_in070.counter\[3\] _05423_ VSS VSS
+ VDD VDD _05424_ sky130_fd_sc_hd__xnor2_1
X_17092_ network.in_period\[70\]\[3\] _04511_ VSS VSS VDD
+ VDD _05425_ sky130_fd_sc_hd__nand2_1
X_17093_ _04511_ _05424_ _05425_ VSS VSS VDD VDD _02346_ sky130_fd_sc_hd__o21ai_0
X_17094_ net357 _04606_ VSS VSS VDD VDD _05426_ sky130_fd_sc_hd__nand2_1
X_17095_ network.in_period\[92\]\[1\] _05426_ VSS VSS VDD
+ VDD _05427_ sky130_fd_sc_hd__nand2_1
X_17096_ _01227_ _05426_ _05427_ VSS VSS VDD VDD _02432_ sky130_fd_sc_hd__o21ai_0
X_17097_ network.neuron_in071.counter\[1\] network.neuron_in071.counter\[0\]
+ _00149_ VSS VSS VDD VDD _05428_ sky130_fd_sc_hd__o21bai_1
X_17098_ _04534_ _05428_ network.neuron_in071.counter\[3\]
+ VSS VSS VDD VDD _05429_ sky130_fd_sc_hd__a21oi_1
X_17099_ _04534_ _00148_ _00147_ network.neuron_in071.counter\[3\]
+ _05429_ VSS VSS VDD VDD _05430_ sky130_fd_sc_hd__a41o_1
X_17100_ net354 _04533_ network.in_period\[71\]\[3\] VSS VSS
+ VDD VDD _05431_ sky130_fd_sc_hd__a21oi_1
X_17101_ net354 _05430_ _05431_ VSS VSS VDD VDD _02350_ sky130_fd_sc_hd__a21oi_1
X_17102_ net357 _04589_ VSS VSS VDD VDD _05432_ sky130_fd_sc_hd__nand2_1
X_17103_ network.in_period\[96\]\[0\] _05432_ VSS VSS VDD
+ VDD _05433_ sky130_fd_sc_hd__nand2_1
X_17104_ network.neuron_in096.counter\[0\] _05432_ _05433_
+ VSS VSS VDD VDD _02447_ sky130_fd_sc_hd__o21ai_0
X_17105_ _09672_ _09410_ network.in_spk13_11 VSS VSS VDD VDD
+ _05434_ sky130_fd_sc_hd__o21ai_0
X_17106_ _06882_ _05434_ net415 VSS VSS VDD VDD _01971_ sky130_fd_sc_hd__a21oi_1
X_17107_ network.neuron_in072.counter\[0\] network.neuron_in072.counter\[2\]
+ network.neuron_in072.counter\[1\] net420 VSS VSS VDD VDD _05435_
+ sky130_fd_sc_hd__nor4_1
X_17108_ network.in_period\[72\]\[3\] _05435_ _04528_ VSS
+ VSS VDD VDD _05436_ sky130_fd_sc_hd__mux2i_1
X_17109_ network.neuron_in072.counter\[0\] network.neuron_in072.counter\[2\]
+ network.neuron_in072.counter\[1\] network.neuron_in072.counter\[3\]
+ net355 VSS VSS VDD VDD _05437_ sky130_fd_sc_hd__o311a_1
X_17110_ network.in_period\[72\]\[3\] net420 _05437_ VSS VSS
+ VDD VDD _05438_ sky130_fd_sc_hd__a21oi_1
X_17111_ network.neuron_in072.counter\[3\] _05436_ _05438_
+ VSS VSS VDD VDD _02354_ sky130_fd_sc_hd__o21ai_0
X_17112_ net357 _04613_ VSS VSS VDD VDD _05439_ sky130_fd_sc_hd__nand2_1
X_17113_ network.in_period\[90\]\[1\] _05439_ VSS VSS VDD
+ VDD _05440_ sky130_fd_sc_hd__nand2_1
X_17114_ _00646_ _05439_ _05440_ VSS VSS VDD VDD _02424_ sky130_fd_sc_hd__o21ai_0
X_17115_ network.neuron_in073.counter\[1\] network.neuron_in073.counter\[0\]
+ _00139_ VSS VSS VDD VDD _05441_ sky130_fd_sc_hd__o21bai_1
X_17116_ _04541_ _05441_ network.neuron_in073.counter\[3\]
+ VSS VSS VDD VDD _05442_ sky130_fd_sc_hd__a21oi_1
X_17117_ _04541_ _00138_ _00137_ network.neuron_in073.counter\[3\]
+ _05442_ VSS VSS VDD VDD _05443_ sky130_fd_sc_hd__a41o_1
X_17118_ net355 _04540_ network.in_period\[73\]\[3\] VSS VSS
+ VDD VDD _05444_ sky130_fd_sc_hd__a21oi_1
X_17119_ net355 _05443_ _05444_ VSS VSS VDD VDD _02358_ sky130_fd_sc_hd__a21oi_1
X_17120_ network.neuron_in092.counter\[2\] net357 VSS VSS
+ VDD VDD _05445_ sky130_fd_sc_hd__nand2_1
X_17121_ network.neuron_in092.counter\[3\] network.in_period\[92\]\[2\]
+ _05445_ VSS VSS VDD VDD _05446_ sky130_fd_sc_hd__o21ai_0
X_17122_ _01226_ network.neuron_in092.counter\[2\] net412
+ VSS VSS VDD VDD _05447_ sky130_fd_sc_hd__or3_1
X_17123_ network.in_period\[92\]\[2\] net357 _05447_ VSS VSS
+ VDD VDD _05448_ sky130_fd_sc_hd__o21ai_0
X_17124_ _01226_ _05446_ _05448_ VSS VSS VDD VDD _02433_ sky130_fd_sc_hd__a21oi_1
X_17125_ _09265_ _09410_ network.in_spk12_11 VSS VSS VDD VDD
+ _05449_ sky130_fd_sc_hd__o21ai_0
X_17126_ _06706_ _05449_ net415 VSS VSS VDD VDD _01972_ sky130_fd_sc_hd__a21oi_1
X_17127_ network.neuron_in074.counter\[1\] network.neuron_in074.counter\[0\]
+ _00128_ VSS VSS VDD VDD _05450_ sky130_fd_sc_hd__o21bai_1
X_17128_ _04523_ _05450_ network.neuron_in074.counter\[3\]
+ VSS VSS VDD VDD _05451_ sky130_fd_sc_hd__a21oi_1
X_17129_ _04523_ _00127_ _00126_ network.neuron_in074.counter\[3\]
+ _05451_ VSS VSS VDD VDD _05452_ sky130_fd_sc_hd__a41o_1
X_17130_ net355 _04522_ network.in_period\[74\]\[3\] VSS VSS
+ VDD VDD _05453_ sky130_fd_sc_hd__a21oi_1
X_17131_ net355 _05452_ _05453_ VSS VSS VDD VDD _02362_ sky130_fd_sc_hd__a21oi_1
X_17132_ net357 _04599_ VSS VSS VDD VDD _05454_ sky130_fd_sc_hd__nand2_1
X_17133_ network.in_period\[94\]\[1\] _05454_ VSS VSS VDD
+ VDD _05455_ sky130_fd_sc_hd__nand2_1
X_17134_ _01235_ _05454_ _05455_ VSS VSS VDD VDD _02440_ sky130_fd_sc_hd__o21ai_0
X_17135_ network.neuron_in075.counter\[0\] network.neuron_in075.counter\[2\]
+ network.neuron_in075.counter\[1\] net419 VSS VSS VDD VDD _05456_
+ sky130_fd_sc_hd__nor4_1
X_17136_ network.in_period\[75\]\[3\] _05456_ _04669_ VSS
+ VSS VDD VDD _05457_ sky130_fd_sc_hd__mux2i_1
X_17137_ network.neuron_in075.counter\[0\] network.neuron_in075.counter\[2\]
+ network.neuron_in075.counter\[1\] network.neuron_in075.counter\[3\]
+ net354 VSS VSS VDD VDD _05458_ sky130_fd_sc_hd__o311a_1
X_17138_ network.in_period\[75\]\[3\] net419 _05458_ VSS VSS
+ VDD VDD _05459_ sky130_fd_sc_hd__a21oi_1
X_17139_ network.neuron_in075.counter\[3\] _05457_ _05459_
+ VSS VSS VDD VDD _02366_ sky130_fd_sc_hd__o21ai_0
X_17140_ network.in_period\[96\]\[1\] _05432_ VSS VSS VDD
+ VDD _05460_ sky130_fd_sc_hd__nand2_1
X_17141_ _01207_ _05432_ _05460_ VSS VSS VDD VDD _02448_ sky130_fd_sc_hd__o21ai_0
X_17142_ network.in_spk08_11 network.in_spk09_11 network.in_spk10_11
+ _09410_ network.in_spk11_11 VSS VSS VDD VDD _05461_ sky130_fd_sc_hd__o41ai_1
Xplace333 _08702_ VSS VSS VDD VDD net332 sky130_fd_sc_hd__buf_4
X_17144_ _06752_ _05461_ net415 VSS VSS VDD VDD _01973_ sky130_fd_sc_hd__a21oi_1
X_17145_ network.neuron_in076.counter\[1\] network.neuron_in076.counter\[0\]
+ _00124_ VSS VSS VDD VDD _05463_ sky130_fd_sc_hd__o21bai_1
X_17146_ _04665_ _05463_ network.neuron_in076.counter\[3\]
+ VSS VSS VDD VDD _05464_ sky130_fd_sc_hd__a21oi_1
X_17147_ _04665_ _00123_ _00122_ network.neuron_in076.counter\[3\]
+ _05464_ VSS VSS VDD VDD _05465_ sky130_fd_sc_hd__a41o_1
X_17148_ net352 _04664_ network.in_period\[76\]\[3\] VSS VSS
+ VDD VDD _05466_ sky130_fd_sc_hd__a21oi_1
X_17149_ net352 _05465_ _05466_ VSS VSS VDD VDD _02370_ sky130_fd_sc_hd__a21oi_1
X_17150_ net345 _04617_ VSS VSS VDD VDD _05467_ sky130_fd_sc_hd__nand2_1
X_17151_ network.in_period\[89\]\[0\] _05467_ VSS VSS VDD
+ VDD _05468_ sky130_fd_sc_hd__nand2_1
X_17152_ network.neuron_in089.counter\[0\] _05467_ _05468_
+ VSS VSS VDD VDD _02419_ sky130_fd_sc_hd__o21ai_0
X_17153_ network.neuron_in077.counter\[1\] network.neuron_in077.counter\[2\]
+ network.neuron_in077.counter\[0\] VSS VSS VDD VDD _05469_
+ sky130_fd_sc_hd__nor3_1
X_17154_ network.neuron_in077.counter\[3\] _05469_ VSS VSS
+ VDD VDD _05470_ sky130_fd_sc_hd__xnor2_1
X_17155_ network.in_period\[77\]\[3\] _05025_ VSS VSS VDD
+ VDD _05471_ sky130_fd_sc_hd__nand2_1
X_17156_ _05025_ _05470_ _05471_ VSS VSS VDD VDD _02374_ sky130_fd_sc_hd__o21ai_0
X_17157_ network.neuron_in090.counter\[2\] VSS VSS VDD VDD
+ _05472_ sky130_fd_sc_hd__inv_1
X_17158_ network.neuron_in090.counter\[3\] network.in_period\[90\]\[2\]
+ net414 _00645_ VSS VSS VDD VDD _05473_ sky130_fd_sc_hd__o22ai_1
Xplace409 _07341_ VSS VSS VDD VDD net408 sky130_fd_sc_hd__buf_4
Xplace407 _07363_ VSS VSS VDD VDD net406 sky130_fd_sc_hd__buf_4
X_17161_ network.neuron_in090.counter\[2\] _00645_ net357
+ VSS VSS VDD VDD _05476_ sky130_fd_sc_hd__nand3_1
X_17162_ network.in_period\[90\]\[2\] net357 _05476_ VSS VSS
+ VDD VDD _05477_ sky130_fd_sc_hd__o21ai_0
X_17163_ _05472_ _05473_ _05477_ VSS VSS VDD VDD _02425_ sky130_fd_sc_hd__a21oi_1
X_17164_ network.in_spk08_11 network.in_spk09_11 _09410_ network.in_spk10_11
+ VSS VSS VDD VDD _05478_ sky130_fd_sc_hd__o31ai_1
X_17165_ _06718_ _05478_ net415 VSS VSS VDD VDD _01974_ sky130_fd_sc_hd__a21oi_1
X_17166_ network.neuron_in078.counter\[1\] network.neuron_in078.counter\[0\]
+ network.neuron_in078.counter\[2\] net420 VSS VSS VDD VDD _05479_
+ sky130_fd_sc_hd__nor4_1
X_17167_ network.in_period\[78\]\[3\] _05479_ _04655_ VSS
+ VSS VDD VDD _05480_ sky130_fd_sc_hd__mux2i_1
X_17168_ network.neuron_in078.counter\[1\] network.neuron_in078.counter\[0\]
+ network.neuron_in078.counter\[2\] network.neuron_in078.counter\[3\]
+ net354 VSS VSS VDD VDD _05481_ sky130_fd_sc_hd__o311a_1
X_17169_ network.in_period\[78\]\[3\] net420 _05481_ VSS VSS
+ VDD VDD _05482_ sky130_fd_sc_hd__a21oi_1
X_17170_ network.neuron_in078.counter\[3\] _05480_ _05482_
+ VSS VSS VDD VDD _02378_ sky130_fd_sc_hd__o21ai_0
X_17171_ net345 _04609_ VSS VSS VDD VDD _05483_ sky130_fd_sc_hd__nand2_1
X_17172_ network.in_period\[91\]\[1\] _05483_ VSS VSS VDD
+ VDD _05484_ sky130_fd_sc_hd__nand2_1
X_17173_ _00146_ _05483_ _05484_ VSS VSS VDD VDD _02428_ sky130_fd_sc_hd__o21ai_0
X_17174_ network.neuron_in079.counter\[0\] network.neuron_in079.counter\[2\]
+ network.neuron_in079.counter\[1\] net420 VSS VSS VDD VDD _05485_
+ sky130_fd_sc_hd__nor4_1
X_17175_ network.in_period\[79\]\[3\] _05485_ _04652_ VSS
+ VSS VDD VDD _05486_ sky130_fd_sc_hd__mux2i_1
X_17176_ network.neuron_in079.counter\[0\] network.neuron_in079.counter\[2\]
+ network.neuron_in079.counter\[1\] net354 network.neuron_in079.counter\[3\]
+ VSS VSS VDD VDD _05487_ sky130_fd_sc_hd__o311a_1
X_17177_ network.in_period\[79\]\[3\] net420 _05487_ VSS VSS
+ VDD VDD _05488_ sky130_fd_sc_hd__a21oi_1
X_17178_ network.neuron_in079.counter\[3\] _05486_ _05488_
+ VSS VSS VDD VDD _02382_ sky130_fd_sc_hd__o21ai_0
X_17179_ network.in_spk08_11 _09410_ network.in_spk09_11 VSS
+ VSS VDD VDD _05489_ sky130_fd_sc_hd__o21ai_0
X_17180_ _06798_ _05489_ net415 VSS VSS VDD VDD _01975_ sky130_fd_sc_hd__a21oi_1
X_17181_ network.neuron_in080.counter\[1\] network.neuron_in080.counter\[2\]
+ network.neuron_in080.counter\[0\] net414 VSS VSS VDD VDD _05490_
+ sky130_fd_sc_hd__nor4_1
X_17182_ network.in_period\[80\]\[3\] _05490_ _04648_ VSS
+ VSS VDD VDD _05491_ sky130_fd_sc_hd__mux2i_1
X_17183_ network.neuron_in080.counter\[1\] network.neuron_in080.counter\[2\]
+ network.neuron_in080.counter\[0\] net357 network.neuron_in080.counter\[3\]
+ VSS VSS VDD VDD _05492_ sky130_fd_sc_hd__o311a_1
X_17184_ network.in_period\[80\]\[3\] net414 _05492_ VSS VSS
+ VDD VDD _05493_ sky130_fd_sc_hd__a21oi_1
X_17185_ network.neuron_in080.counter\[3\] _05491_ _05493_
+ VSS VSS VDD VDD _02386_ sky130_fd_sc_hd__o21ai_0
X_17186_ net356 _04602_ VSS VSS VDD VDD _05494_ sky130_fd_sc_hd__nand2_1
X_17187_ network.in_period\[93\]\[1\] _05494_ VSS VSS VDD
+ VDD _05495_ sky130_fd_sc_hd__nand2_1
X_17188_ _01231_ _05494_ _05495_ VSS VSS VDD VDD _02436_ sky130_fd_sc_hd__o21ai_0
Xplace402 _07396_ VSS VSS VDD VDD net401 sky130_fd_sc_hd__buf_4
X_17190_ network.neuron_in081.counter\[1\] network.neuron_in081.counter\[0\]
+ VSS VSS VDD VDD _05497_ sky130_fd_sc_hd__nor2_1
X_17191_ _00082_ _05497_ VSS VSS VDD VDD _05498_ sky130_fd_sc_hd__nor2_1
X_17192_ network.neuron_in081.counter\[2\] _05498_ VSS VSS
+ VDD VDD _05499_ sky130_fd_sc_hd__nor2_1
X_17193_ network.neuron_in081.counter\[2\] network.neuron_in081.counter\[3\]
+ _05497_ VSS VSS VDD VDD _05500_ sky130_fd_sc_hd__nand3b_1
X_17194_ network.neuron_in081.counter\[3\] _05499_ _05500_
+ VSS VSS VDD VDD _05501_ sky130_fd_sc_hd__o21ai_0
X_17195_ net345 _04644_ network.in_period\[81\]\[3\] VSS VSS
+ VDD VDD _05502_ sky130_fd_sc_hd__a21oi_1
X_17196_ net345 _05501_ _05502_ VSS VSS VDD VDD _02390_ sky130_fd_sc_hd__a21oi_1
X_17197_ network.neuron_in094.counter\[3\] network.in_period\[94\]\[2\]
+ _01234_ net412 VSS VSS VDD VDD _05503_ sky130_fd_sc_hd__o22ai_1
X_17198_ network.neuron_in094.counter\[2\] _01234_ net357
+ VSS VSS VDD VDD _05504_ sky130_fd_sc_hd__nand3_1
X_17199_ network.in_period\[94\]\[2\] net357 _05504_ VSS VSS
+ VDD VDD _05505_ sky130_fd_sc_hd__o21ai_0
X_17200_ _04597_ _05503_ _05505_ VSS VSS VDD VDD _02441_ sky130_fd_sc_hd__a21oi_1
X_17201_ network.in_spk08_11 _09410_ VSS VSS VDD VDD _05506_
+ sky130_fd_sc_hd__nand2_1
X_17202_ _06793_ _05506_ net415 VSS VSS VDD VDD _01976_ sky130_fd_sc_hd__a21oi_1
X_17203_ network.neuron_in095.counter\[3\] network.in_period\[95\]\[2\]
+ net412 _01243_ VSS VSS VDD VDD _05507_ sky130_fd_sc_hd__o22ai_1
X_17204_ network.neuron_in095.counter\[2\] _01243_ net357
+ VSS VSS VDD VDD _05508_ sky130_fd_sc_hd__nand3_1
X_17205_ network.in_period\[95\]\[2\] net357 _05508_ VSS VSS
+ VDD VDD _05509_ sky130_fd_sc_hd__o21ai_0
X_17206_ _04592_ _05507_ _05509_ VSS VSS VDD VDD _02445_ sky130_fd_sc_hd__a21oi_1
X_17207_ network.neuron_in082.counter\[0\] network.neuron_in082.counter\[1\]
+ network.neuron_in082.counter\[2\] net414 VSS VSS VDD VDD _05510_
+ sky130_fd_sc_hd__nor4_1
X_17208_ network.in_period\[82\]\[3\] _05510_ _04641_ VSS
+ VSS VDD VDD _05511_ sky130_fd_sc_hd__mux2i_1
X_17209_ network.neuron_in082.counter\[0\] network.neuron_in082.counter\[1\]
+ network.neuron_in082.counter\[2\] network.neuron_in082.counter\[3\]
+ net345 VSS VSS VDD VDD _05512_ sky130_fd_sc_hd__o311a_1
X_17210_ network.in_period\[82\]\[3\] net414 _05512_ VSS VSS
+ VDD VDD _05513_ sky130_fd_sc_hd__a21oi_1
X_17211_ network.neuron_in082.counter\[3\] _05511_ _05513_
+ VSS VSS VDD VDD _02394_ sky130_fd_sc_hd__o21ai_0
X_17212_ network.neuron_in096.counter\[3\] network.in_period\[96\]\[2\]
+ net411 _01206_ VSS VSS VDD VDD _05514_ sky130_fd_sc_hd__o22ai_1
X_17213_ network.neuron_in096.counter\[2\] _01206_ net357
+ VSS VSS VDD VDD _05515_ sky130_fd_sc_hd__nand3_1
X_17214_ network.in_period\[96\]\[2\] net357 _05515_ VSS VSS
+ VDD VDD _05516_ sky130_fd_sc_hd__o21ai_0
X_17215_ _04588_ _05514_ _05516_ VSS VSS VDD VDD _02449_ sky130_fd_sc_hd__a21oi_1
X_17216_ network.neuron_in118.counter\[0\] VSS VSS VDD VDD
+ _00118_ sky130_fd_sc_hd__inv_1
X_17217_ network.neuron_in083.counter\[0\] network.neuron_in083.counter\[2\]
+ network.neuron_in083.counter\[1\] VSS VSS VDD VDD _05517_
+ sky130_fd_sc_hd__nor3_1
X_17218_ network.neuron_in083.counter\[3\] _05517_ VSS VSS
+ VDD VDD _05518_ sky130_fd_sc_hd__xnor2_1
X_17219_ network.in_period\[83\]\[3\] _05202_ VSS VSS VDD
+ VDD _05519_ sky130_fd_sc_hd__nand2_1
X_17220_ _05202_ _05518_ _05519_ VSS VSS VDD VDD _02398_ sky130_fd_sc_hd__o21ai_0
X_17221_ network.in_spk06_11 _09685_ _09677_ network.in_spk07_11
+ VSS VSS VDD VDD _05520_ sky130_fd_sc_hd__o31ai_1
X_17222_ _06714_ _05520_ net415 VSS VSS VDD VDD _01977_ sky130_fd_sc_hd__a21oi_1
X_17223_ network.neuron_in084.counter\[0\] network.neuron_in084.counter\[1\]
+ _00048_ VSS VSS VDD VDD _05521_ sky130_fd_sc_hd__o21bai_1
X_17224_ _04634_ _05521_ network.neuron_in084.counter\[3\]
+ VSS VSS VDD VDD _05522_ sky130_fd_sc_hd__a21oi_1
X_17225_ _04634_ network.neuron_in084.counter\[3\] _00046_
+ _00047_ _05522_ VSS VSS VDD VDD _05523_ sky130_fd_sc_hd__a41o_1
X_17226_ net345 _04633_ network.in_period\[84\]\[3\] VSS VSS
+ VDD VDD _05524_ sky130_fd_sc_hd__a21oi_1
X_17227_ net345 _05523_ _05524_ VSS VSS VDD VDD _02402_ sky130_fd_sc_hd__a21oi_1
X_17228_ network.in_period\[89\]\[1\] _05467_ VSS VSS VDD
+ VDD _05525_ sky130_fd_sc_hd__nand2_1
X_17229_ _01219_ _05467_ _05525_ VSS VSS VDD VDD _02420_ sky130_fd_sc_hd__o21ai_0
X_17230_ network.neuron_in085.counter\[0\] network.neuron_in085.counter\[1\]
+ network.neuron_in085.counter\[2\] VSS VSS VDD VDD _05526_
+ sky130_fd_sc_hd__nor3_1
X_17231_ network.neuron_in085.counter\[3\] _05526_ VSS VSS
+ VDD VDD _05527_ sky130_fd_sc_hd__xnor2_1
X_17232_ network.in_period\[85\]\[3\] _05289_ VSS VSS VDD
+ VDD _05528_ sky130_fd_sc_hd__nand2_1
X_17233_ _05289_ _05527_ _05528_ VSS VSS VDD VDD _02406_ sky130_fd_sc_hd__o21ai_0
X_17234_ _09685_ _09677_ network.in_spk06_11 VSS VSS VDD VDD
+ _05529_ sky130_fd_sc_hd__o21ai_0
X_17235_ _06738_ _05529_ net415 VSS VSS VDD VDD _01978_ sky130_fd_sc_hd__a21oi_1
X_17236_ network.neuron_in086.counter\[0\] network.neuron_in086.counter\[2\]
+ network.neuron_in086.counter\[1\] VSS VSS VDD VDD _05530_
+ sky130_fd_sc_hd__nor3_1
X_17237_ network.neuron_in086.counter\[3\] _05530_ VSS VSS
+ VDD VDD _05531_ sky130_fd_sc_hd__xnor2_1
X_17238_ network.in_period\[86\]\[3\] _05391_ VSS VSS VDD
+ VDD _05532_ sky130_fd_sc_hd__nand2_1
X_17239_ _05391_ _05531_ _05532_ VSS VSS VDD VDD _02410_ sky130_fd_sc_hd__o21ai_0
X_17240_ network.neuron_in087.counter\[0\] network.neuron_in087.counter\[1\]
+ network.neuron_in087.counter\[2\] net414 VSS VSS VDD VDD _05533_
+ sky130_fd_sc_hd__nor4_1
X_17241_ network.in_period\[87\]\[3\] _05533_ _04623_ VSS
+ VSS VDD VDD _05534_ sky130_fd_sc_hd__mux2i_1
Xplace405 _07379_ VSS VSS VDD VDD net404 sky130_fd_sc_hd__buf_4
X_17243_ network.neuron_in087.counter\[0\] network.neuron_in087.counter\[1\]
+ network.neuron_in087.counter\[2\] network.neuron_in087.counter\[3\]
+ net345 VSS VSS VDD VDD _05536_ sky130_fd_sc_hd__o311a_1
X_17244_ network.in_period\[87\]\[3\] net414 _05536_ VSS VSS
+ VDD VDD _05537_ sky130_fd_sc_hd__a21oi_1
X_17245_ network.neuron_in087.counter\[3\] _05534_ _05537_
+ VSS VSS VDD VDD _02414_ sky130_fd_sc_hd__o21ai_0
X_17246_ network.in_period\[90\]\[0\] _05439_ VSS VSS VDD
+ VDD _05538_ sky130_fd_sc_hd__nand2_1
X_17247_ network.neuron_in090.counter\[0\] _05439_ _05538_
+ VSS VSS VDD VDD _02423_ sky130_fd_sc_hd__o21ai_0
X_17248_ network.in_spk04_11 _09482_ network.in_spk05_11 VSS
+ VSS VDD VDD _05539_ sky130_fd_sc_hd__o21ai_0
X_17249_ _06710_ _05539_ net415 VSS VSS VDD VDD _01979_ sky130_fd_sc_hd__a21oi_1
X_17250_ network.neuron_in088.counter\[1\] network.neuron_in088.counter\[0\]
+ _01214_ VSS VSS VDD VDD _05540_ sky130_fd_sc_hd__o21bai_1
X_17251_ _04620_ _05540_ network.neuron_in088.counter\[3\]
+ VSS VSS VDD VDD _05541_ sky130_fd_sc_hd__a21oi_1
X_17252_ _04620_ network.neuron_in088.counter\[3\] _01213_
+ _01212_ _05541_ VSS VSS VDD VDD _05542_ sky130_fd_sc_hd__a41o_1
X_17253_ net357 _04619_ network.in_period\[88\]\[3\] VSS VSS
+ VDD VDD _05543_ sky130_fd_sc_hd__a21oi_1
X_17254_ net357 _05542_ _05543_ VSS VSS VDD VDD _02418_ sky130_fd_sc_hd__a21oi_1
X_17255_ network.neuron_in091.counter\[2\] net345 VSS VSS
+ VDD VDD _05544_ sky130_fd_sc_hd__nand2_1
X_17256_ network.neuron_in091.counter\[3\] network.in_period\[91\]\[2\]
+ _05544_ VSS VSS VDD VDD _05545_ sky130_fd_sc_hd__o21ai_0
X_17257_ _00145_ network.neuron_in091.counter\[2\] net414
+ VSS VSS VDD VDD _05546_ sky130_fd_sc_hd__or3_1
X_17258_ network.in_period\[91\]\[2\] net345 _05546_ VSS VSS
+ VDD VDD _05547_ sky130_fd_sc_hd__o21ai_0
X_17259_ _00145_ _05545_ _05547_ VSS VSS VDD VDD _02429_ sky130_fd_sc_hd__a21oi_1
X_17260_ network.neuron_in089.counter\[1\] network.neuron_in089.counter\[0\]
+ _01218_ VSS VSS VDD VDD _05548_ sky130_fd_sc_hd__o21bai_1
X_17261_ _04616_ _05548_ network.neuron_in089.counter\[3\]
+ VSS VSS VDD VDD _05549_ sky130_fd_sc_hd__a21oi_1
X_17262_ _04616_ network.neuron_in089.counter\[3\] _01217_
+ _01216_ _05549_ VSS VSS VDD VDD _05550_ sky130_fd_sc_hd__a41o_1
Xplace408 _07353_ VSS VSS VDD VDD net407 sky130_fd_sc_hd__buf_4
X_17264_ net345 _04615_ network.in_period\[89\]\[3\] VSS VSS
+ VDD VDD _05552_ sky130_fd_sc_hd__a21oi_1
X_17265_ net345 _05550_ _05552_ VSS VSS VDD VDD _02422_ sky130_fd_sc_hd__a21oi_1
X_17266_ network.in_period\[91\]\[0\] _05483_ VSS VSS VDD
+ VDD _05553_ sky130_fd_sc_hd__nand2_1
X_17267_ network.neuron_in091.counter\[0\] _05483_ _05553_
+ VSS VSS VDD VDD _02427_ sky130_fd_sc_hd__o21ai_0
X_17268_ network.in_spk04_11 _09482_ VSS VSS VDD VDD _05554_
+ sky130_fd_sc_hd__nand2_1
X_17269_ _06776_ _05554_ net415 VSS VSS VDD VDD _01980_ sky130_fd_sc_hd__a21oi_1
X_17270_ network.neuron_in090.counter\[0\] network.neuron_in090.counter\[2\]
+ network.neuron_in090.counter\[1\] VSS VSS VDD VDD _05555_
+ sky130_fd_sc_hd__nor3_1
X_17271_ network.neuron_in090.counter\[3\] _05555_ VSS VSS
+ VDD VDD _05556_ sky130_fd_sc_hd__xnor2_1
X_17272_ network.in_period\[90\]\[3\] _05439_ VSS VSS VDD
+ VDD _05557_ sky130_fd_sc_hd__nand2_1
X_17273_ _05439_ _05556_ _05557_ VSS VSS VDD VDD _02426_ sky130_fd_sc_hd__o21ai_0
X_17274_ network.neuron_in091.counter\[1\] network.neuron_in091.counter\[2\]
+ network.neuron_in091.counter\[0\] net414 VSS VSS VDD VDD _05558_
+ sky130_fd_sc_hd__nor4_1
X_17275_ network.in_period\[91\]\[3\] _05558_ _04608_ VSS
+ VSS VDD VDD _05559_ sky130_fd_sc_hd__mux2i_1
X_17276_ network.neuron_in091.counter\[1\] network.neuron_in091.counter\[2\]
+ network.neuron_in091.counter\[0\] net345 network.neuron_in091.counter\[3\]
+ VSS VSS VDD VDD _05560_ sky130_fd_sc_hd__o311a_1
X_17277_ network.in_period\[91\]\[3\] net414 _05560_ VSS VSS
+ VDD VDD _05561_ sky130_fd_sc_hd__a21oi_1
X_17278_ network.neuron_in091.counter\[3\] _05559_ _05561_
+ VSS VSS VDD VDD _02430_ sky130_fd_sc_hd__o21ai_0
X_17279_ network.in_period\[92\]\[0\] _05426_ VSS VSS VDD
+ VDD _05562_ sky130_fd_sc_hd__nand2_1
X_17280_ network.neuron_in092.counter\[0\] _05426_ _05562_
+ VSS VSS VDD VDD _02431_ sky130_fd_sc_hd__o21ai_0
X_17281_ network.neuron_in093.counter\[2\] VSS VSS VDD VDD
+ _05563_ sky130_fd_sc_hd__inv_1
X_17282_ network.neuron_in093.counter\[3\] network.in_period\[93\]\[2\]
+ net411 _01230_ VSS VSS VDD VDD _05564_ sky130_fd_sc_hd__o22ai_1
X_17283_ network.neuron_in093.counter\[2\] _01230_ net356
+ VSS VSS VDD VDD _05565_ sky130_fd_sc_hd__nand3_1
X_17284_ network.in_period\[93\]\[2\] net356 _05565_ VSS VSS
+ VDD VDD _05566_ sky130_fd_sc_hd__o21ai_0
X_17285_ _05563_ _05564_ _05566_ VSS VSS VDD VDD _02437_ sky130_fd_sc_hd__a21oi_1
X_17286_ network.in_spk00_11 network.in_spk01_11 network.in_spk02_11
+ _09685_ network.in_spk03_11 VSS VSS VDD VDD _05567_ sky130_fd_sc_hd__o41ai_1
X_17287_ _06771_ _05567_ net415 VSS VSS VDD VDD _01981_ sky130_fd_sc_hd__a21oi_1
X_17288_ network.neuron_in092.counter\[1\] network.neuron_in092.counter\[0\]
+ network.neuron_in092.counter\[2\] net412 VSS VSS VDD VDD _05568_
+ sky130_fd_sc_hd__nor4_1
X_17289_ network.in_period\[92\]\[3\] _05568_ _04605_ VSS
+ VSS VDD VDD _05569_ sky130_fd_sc_hd__mux2i_1
Xplace399 _07406_ VSS VSS VDD VDD net398 sky130_fd_sc_hd__buf_4
X_17291_ network.neuron_in092.counter\[1\] network.neuron_in092.counter\[0\]
+ network.neuron_in092.counter\[2\] network.neuron_in092.counter\[3\]
+ net357 VSS VSS VDD VDD _05571_ sky130_fd_sc_hd__o311a_1
X_17292_ network.in_period\[92\]\[3\] net412 _05571_ VSS VSS
+ VDD VDD _05572_ sky130_fd_sc_hd__a21oi_1
X_17293_ network.neuron_in092.counter\[3\] _05569_ _05572_
+ VSS VSS VDD VDD _02434_ sky130_fd_sc_hd__o21ai_0
X_17294_ network.in_period\[93\]\[0\] _05494_ VSS VSS VDD
+ VDD _05573_ sky130_fd_sc_hd__nand2_1
X_17295_ network.neuron_in093.counter\[0\] _05494_ _05573_
+ VSS VSS VDD VDD _02435_ sky130_fd_sc_hd__o21ai_0
X_17296_ network.neuron_in093.counter\[0\] network.neuron_in093.counter\[2\]
+ network.neuron_in093.counter\[1\] VSS VSS VDD VDD _05574_
+ sky130_fd_sc_hd__nor3_1
X_17297_ network.neuron_in093.counter\[3\] _05574_ VSS VSS
+ VDD VDD _05575_ sky130_fd_sc_hd__xnor2_1
X_17298_ network.in_period\[93\]\[3\] _05494_ VSS VSS VDD
+ VDD _05576_ sky130_fd_sc_hd__nand2_1
X_17299_ _05494_ _05575_ _05576_ VSS VSS VDD VDD _02438_ sky130_fd_sc_hd__o21ai_0
X_17300_ network.in_spk00_11 network.in_spk01_11 _09685_ network.in_spk02_11
+ VSS VSS VDD VDD _05577_ sky130_fd_sc_hd__o31ai_1
X_17301_ _04786_ _05577_ net415 VSS VSS VDD VDD _01982_ sky130_fd_sc_hd__a21oi_1
Xplace395 _07426_ VSS VSS VDD VDD net394 sky130_fd_sc_hd__buf_4
X_17303_ network.neuron_in094.counter\[1\] network.neuron_in094.counter\[0\]
+ network.neuron_in094.counter\[2\] net412 VSS VSS VDD VDD _05579_
+ sky130_fd_sc_hd__nor4_1
X_17304_ network.in_period\[94\]\[3\] _05579_ _04598_ VSS
+ VSS VDD VDD _05580_ sky130_fd_sc_hd__mux2i_1
X_17305_ network.neuron_in094.counter\[1\] network.neuron_in094.counter\[0\]
+ network.neuron_in094.counter\[2\] network.neuron_in094.counter\[3\]
+ net357 VSS VSS VDD VDD _05581_ sky130_fd_sc_hd__o311a_1
X_17306_ network.in_period\[94\]\[3\] net412 _05581_ VSS VSS
+ VDD VDD _05582_ sky130_fd_sc_hd__a21oi_1
X_17307_ network.neuron_in094.counter\[3\] _05580_ _05582_
+ VSS VSS VDD VDD _02442_ sky130_fd_sc_hd__o21ai_0
X_17308_ network.in_period\[94\]\[0\] _05454_ VSS VSS VDD
+ VDD _05583_ sky130_fd_sc_hd__nand2_1
X_17309_ network.neuron_in094.counter\[0\] _05454_ _05583_
+ VSS VSS VDD VDD _02439_ sky130_fd_sc_hd__o21ai_0
X_17310_ network.neuron_in095.counter\[1\] VSS VSS VDD VDD
+ _01242_ sky130_fd_sc_hd__inv_1
X_17311_ network.neuron_in095.counter\[0\] network.neuron_in095.counter\[1\]
+ _01243_ VSS VSS VDD VDD _05584_ sky130_fd_sc_hd__o21bai_1
X_17312_ _04592_ _05584_ network.neuron_in095.counter\[3\]
+ VSS VSS VDD VDD _05585_ sky130_fd_sc_hd__a21oi_1
X_17313_ _04592_ network.neuron_in095.counter\[3\] _01241_
+ _01242_ _05585_ VSS VSS VDD VDD _05586_ sky130_fd_sc_hd__a41o_1
X_17314_ net357 _04591_ network.in_period\[95\]\[3\] VSS VSS
+ VDD VDD _05587_ sky130_fd_sc_hd__a21oi_1
X_17315_ net357 _05586_ _05587_ VSS VSS VDD VDD _02446_ sky130_fd_sc_hd__a21oi_1
X_17316_ network.in_spk00_11 _09685_ network.in_spk01_11 VSS
+ VSS VDD VDD _05588_ sky130_fd_sc_hd__o21ai_0
Xplace396 _07425_ VSS VSS VDD VDD net395 sky130_fd_sc_hd__buf_4
X_17318_ _07791_ _05588_ net415 VSS VSS VDD VDD _01983_ sky130_fd_sc_hd__a21oi_1
X_17319_ network.neuron_in096.counter\[1\] network.neuron_in096.counter\[0\]
+ _01206_ VSS VSS VDD VDD _05590_ sky130_fd_sc_hd__o21bai_1
X_17320_ _04588_ _05590_ network.neuron_in096.counter\[3\]
+ VSS VSS VDD VDD _05591_ sky130_fd_sc_hd__a21oi_1
X_17321_ _04588_ network.neuron_in096.counter\[3\] _01205_
+ _01204_ _05591_ VSS VSS VDD VDD _05592_ sky130_fd_sc_hd__a41o_1
X_17322_ net357 _04587_ network.in_period\[96\]\[3\] VSS VSS
+ VDD VDD _05593_ sky130_fd_sc_hd__a21oi_1
X_17323_ net357 _05592_ _05593_ VSS VSS VDD VDD _02450_ sky130_fd_sc_hd__a21oi_1
X_17324_ net357 _04593_ VSS VSS VDD VDD _05594_ sky130_fd_sc_hd__nand2_1
X_17325_ network.in_period\[95\]\[1\] _05594_ VSS VSS VDD
+ VDD _05595_ sky130_fd_sc_hd__nand2_1
X_17326_ _01244_ _05594_ _05595_ VSS VSS VDD VDD _02444_ sky130_fd_sc_hd__o21ai_0
X_17327_ network.neuron_in136.counter\[1\] VSS VSS VDD VDD
+ _00761_ sky130_fd_sc_hd__inv_1
X_17328_ network.neuron_in097.counter\[1\] network.neuron_in097.counter\[2\]
+ network.neuron_in097.counter\[0\] net412 VSS VSS VDD VDD _05596_
+ sky130_fd_sc_hd__nor4_1
X_17329_ network.in_period\[97\]\[3\] _05596_ _04583_ VSS
+ VSS VDD VDD _05597_ sky130_fd_sc_hd__mux2i_1
X_17330_ network.neuron_in097.counter\[1\] network.neuron_in097.counter\[2\]
+ network.neuron_in097.counter\[0\] net358 network.neuron_in097.counter\[3\]
+ VSS VSS VDD VDD _05598_ sky130_fd_sc_hd__o311a_1
X_17331_ network.in_period\[97\]\[3\] net412 _05598_ VSS VSS
+ VDD VDD _05599_ sky130_fd_sc_hd__a21oi_1
X_17332_ network.neuron_in097.counter\[3\] _05597_ _05599_
+ VSS VSS VDD VDD _02454_ sky130_fd_sc_hd__o21ai_0
X_17333_ network.in_period\[95\]\[0\] _05594_ VSS VSS VDD
+ VDD _05600_ sky130_fd_sc_hd__nand2_1
X_17334_ network.neuron_in095.counter\[0\] _05594_ _05600_
+ VSS VSS VDD VDD _02443_ sky130_fd_sc_hd__o21ai_0
X_17335_ network.in_spk00_11 _09685_ VSS VSS VDD VDD _05601_
+ sky130_fd_sc_hd__nand2_1
X_17336_ _07845_ _05601_ net415 VSS VSS VDD VDD _01984_ sky130_fd_sc_hd__a21oi_1
X_17337_ network.neuron_in098.counter\[1\] network.neuron_in098.counter\[0\]
+ _00781_ VSS VSS VDD VDD _05602_ sky130_fd_sc_hd__o21bai_1
X_17338_ _04882_ _05602_ network.neuron_in098.counter\[3\]
+ VSS VSS VDD VDD _05603_ sky130_fd_sc_hd__a21oi_1
X_17339_ _04882_ network.neuron_in098.counter\[3\] _00780_
+ _00779_ _05603_ VSS VSS VDD VDD _05604_ sky130_fd_sc_hd__a41o_1
X_17340_ net357 _04881_ network.in_period\[98\]\[3\] VSS VSS
+ VDD VDD _05605_ sky130_fd_sc_hd__a21oi_1
X_17341_ net357 _05604_ _05605_ VSS VSS VDD VDD _02458_ sky130_fd_sc_hd__a21oi_1
X_17342_ network.neuron_in099.counter\[1\] network.neuron_in099.counter\[0\]
+ _00748_ VSS VSS VDD VDD _05606_ sky130_fd_sc_hd__o21bai_1
X_17343_ _04879_ _05606_ network.neuron_in099.counter\[3\]
+ VSS VSS VDD VDD _05607_ sky130_fd_sc_hd__a21oi_1
X_17344_ _04879_ network.neuron_in099.counter\[3\] _00747_
+ _00746_ _05607_ VSS VSS VDD VDD _05608_ sky130_fd_sc_hd__a41o_1
X_17345_ net357 _04878_ network.in_period\[99\]\[3\] VSS VSS
+ VDD VDD _05609_ sky130_fd_sc_hd__a21oi_1
X_17346_ net357 _05608_ _05609_ VSS VSS VDD VDD _02462_ sky130_fd_sc_hd__a21oi_1
X_17347_ _09419_ _09287_ _09349_ _09352_ VSS VSS VDD VDD _05610_
+ sky130_fd_sc_hd__nand4_1
X_17348_ network.in_spk12_10 network.in_spk13_10 network.in_spk14_10
+ _05610_ network.in_spk15_10 VSS VSS VDD VDD _05611_ sky130_fd_sc_hd__o41ai_1
X_17349_ _07840_ _05611_ net416 VSS VSS VDD VDD _01985_ sky130_fd_sc_hd__a21oi_1
X_17350_ network.neuron_in100.counter\[1\] network.neuron_in100.counter\[0\]
+ _00874_ VSS VSS VDD VDD _05612_ sky130_fd_sc_hd__o21bai_1
X_17351_ _04876_ _05612_ network.neuron_in100.counter\[3\]
+ VSS VSS VDD VDD _05613_ sky130_fd_sc_hd__a21oi_1
X_17352_ _04876_ network.neuron_in100.counter\[3\] _00873_
+ _00872_ _05613_ VSS VSS VDD VDD _05614_ sky130_fd_sc_hd__a41o_1
X_17353_ net357 _04875_ network.in_period\[100\]\[3\] VSS
+ VSS VDD VDD _05615_ sky130_fd_sc_hd__a21oi_1
X_17354_ net357 _05614_ _05615_ VSS VSS VDD VDD _02466_ sky130_fd_sc_hd__a21oi_1
X_17355_ net345 _04874_ VSS VSS VDD VDD _05616_ sky130_fd_sc_hd__nand2_1
X_17356_ network.neuron_in101.counter\[0\] network.neuron_in101.counter\[2\]
+ network.neuron_in101.counter\[1\] VSS VSS VDD VDD _05617_
+ sky130_fd_sc_hd__nor3_1
X_17357_ network.neuron_in101.counter\[3\] _05617_ VSS VSS
+ VDD VDD _05618_ sky130_fd_sc_hd__xnor2_1
X_17358_ network.in_period\[101\]\[3\] _05616_ VSS VSS VDD
+ VDD _05619_ sky130_fd_sc_hd__nand2_1
X_17359_ _05616_ _05618_ _05619_ VSS VSS VDD VDD _02470_ sky130_fd_sc_hd__o21ai_0
X_17360_ network.in_spk12_10 network.in_spk13_10 _05610_ network.in_spk14_10
+ VSS VSS VDD VDD _05620_ sky130_fd_sc_hd__o31ai_1
X_17361_ _07812_ _05620_ net416 VSS VSS VDD VDD _01986_ sky130_fd_sc_hd__a21oi_1
X_17362_ network.neuron_in102.counter\[1\] network.neuron_in102.counter\[0\]
+ _00215_ VSS VSS VDD VDD _05621_ sky130_fd_sc_hd__o21bai_1
X_17363_ _04871_ _05621_ network.neuron_in102.counter\[3\]
+ VSS VSS VDD VDD _05622_ sky130_fd_sc_hd__a21oi_1
X_17364_ _04871_ _00214_ network.neuron_in102.counter\[3\]
+ _00213_ _05622_ VSS VSS VDD VDD _05623_ sky130_fd_sc_hd__a41o_1
X_17365_ net345 _04870_ network.in_period\[102\]\[3\] VSS
+ VSS VDD VDD _05624_ sky130_fd_sc_hd__a21oi_1
X_17366_ net345 _05623_ _05624_ VSS VSS VDD VDD _02474_ sky130_fd_sc_hd__a21oi_1
Xplace326 _09253_ VSS VSS VDD VDD net325 sky130_fd_sc_hd__buf_4
X_17368_ network.neuron_in103.counter\[0\] network.neuron_in103.counter\[1\]
+ _00114_ VSS VSS VDD VDD _05626_ sky130_fd_sc_hd__o21bai_1
X_17369_ _04868_ _05626_ network.neuron_in103.counter\[3\]
+ VSS VSS VDD VDD _05627_ sky130_fd_sc_hd__a21oi_1
X_17370_ _04868_ network.neuron_in103.counter\[3\] _00112_
+ _00113_ _05627_ VSS VSS VDD VDD _05628_ sky130_fd_sc_hd__a41o_1
X_17371_ net356 _04867_ network.in_period\[103\]\[3\] VSS
+ VSS VDD VDD _05629_ sky130_fd_sc_hd__a21oi_1
X_17372_ net356 _05628_ _05629_ VSS VSS VDD VDD _02478_ sky130_fd_sc_hd__a21oi_1
X_17373_ network.in_spk12_10 _05610_ network.in_spk13_10 VSS
+ VSS VDD VDD _05630_ sky130_fd_sc_hd__o21ai_0
X_17374_ _07834_ _05630_ net416 VSS VSS VDD VDD _01987_ sky130_fd_sc_hd__a21oi_1
X_17375_ network.neuron_in104.counter\[1\] network.neuron_in104.counter\[0\]
+ _00936_ VSS VSS VDD VDD _05631_ sky130_fd_sc_hd__o21bai_1
X_17376_ _04864_ _05631_ network.neuron_in104.counter\[3\]
+ VSS VSS VDD VDD _05632_ sky130_fd_sc_hd__a21oi_1
X_17377_ _04864_ network.neuron_in104.counter\[3\] _00935_
+ _00934_ _05632_ VSS VSS VDD VDD _05633_ sky130_fd_sc_hd__a41o_1
X_17378_ net356 _04863_ network.in_period\[104\]\[3\] VSS
+ VSS VDD VDD _05634_ sky130_fd_sc_hd__a21oi_1
X_17379_ net358 _05633_ _05634_ VSS VSS VDD VDD _02482_ sky130_fd_sc_hd__a21oi_1
X_17380_ network.neuron_in105.counter\[1\] network.neuron_in105.counter\[2\]
+ network.neuron_in105.counter\[0\] net414 VSS VSS VDD VDD _05635_
+ sky130_fd_sc_hd__nor4_1
X_17381_ network.in_period\[105\]\[3\] _05635_ _04861_ VSS
+ VSS VDD VDD _05636_ sky130_fd_sc_hd__mux2i_1
X_17382_ network.neuron_in105.counter\[1\] network.neuron_in105.counter\[2\]
+ network.neuron_in105.counter\[0\] net357 network.neuron_in105.counter\[3\]
+ VSS VSS VDD VDD _05637_ sky130_fd_sc_hd__o311a_1
X_17383_ network.in_period\[105\]\[3\] net414 _05637_ VSS
+ VSS VDD VDD _05638_ sky130_fd_sc_hd__a21oi_1
X_17384_ network.neuron_in105.counter\[3\] _05636_ _05638_
+ VSS VSS VDD VDD _02486_ sky130_fd_sc_hd__o21ai_0
X_17385_ network.in_spk12_10 _05610_ VSS VSS VDD VDD _05639_
+ sky130_fd_sc_hd__nand2_1
X_17386_ _07796_ _05639_ net416 VSS VSS VDD VDD _01988_ sky130_fd_sc_hd__a21oi_1
X_17387_ network.neuron_in106.counter\[1\] network.neuron_in106.counter\[0\]
+ _00716_ VSS VSS VDD VDD _05640_ sky130_fd_sc_hd__o21bai_1
X_17388_ _04858_ _05640_ network.neuron_in106.counter\[3\]
+ VSS VSS VDD VDD _05641_ sky130_fd_sc_hd__a21oi_1
X_17389_ _04858_ network.neuron_in106.counter\[3\] _00715_
+ _00714_ _05641_ VSS VSS VDD VDD _05642_ sky130_fd_sc_hd__a41o_1
X_17390_ net356 _04857_ network.in_period\[106\]\[3\] VSS
+ VSS VDD VDD _05643_ sky130_fd_sc_hd__a21oi_1
X_17391_ net356 _05642_ _05643_ VSS VSS VDD VDD _02490_ sky130_fd_sc_hd__a21oi_1
X_17392_ network.neuron_in107.counter\[0\] network.neuron_in107.counter\[1\]
+ _00605_ VSS VSS VDD VDD _05644_ sky130_fd_sc_hd__o21bai_1
X_17393_ _04855_ _05644_ network.neuron_in107.counter\[3\]
+ VSS VSS VDD VDD _05645_ sky130_fd_sc_hd__a21oi_1
X_17394_ _04855_ network.neuron_in107.counter\[3\] _00603_
+ _00604_ _05645_ VSS VSS VDD VDD _05646_ sky130_fd_sc_hd__a41o_1
Xplace392 _07486_ VSS VSS VDD VDD net391 sky130_fd_sc_hd__buf_4
X_17396_ net356 _04854_ network.in_period\[107\]\[3\] VSS
+ VSS VDD VDD _05648_ sky130_fd_sc_hd__a21oi_1
X_17397_ net356 _05646_ _05648_ VSS VSS VDD VDD _02494_ sky130_fd_sc_hd__a21oi_1
X_17398_ network.in_spk08_10 network.in_spk09_10 network.in_spk10_10
+ _09420_ network.in_spk11_10 VSS VSS VDD VDD _05649_ sky130_fd_sc_hd__o41ai_1
X_17399_ _07830_ _05649_ net416 VSS VSS VDD VDD _01989_ sky130_fd_sc_hd__a21oi_1
X_17400_ network.neuron_in108.counter\[1\] network.neuron_in108.counter\[0\]
+ _01022_ VSS VSS VDD VDD _05650_ sky130_fd_sc_hd__o21bai_1
X_17401_ _04852_ _05650_ network.neuron_in108.counter\[3\]
+ VSS VSS VDD VDD _05651_ sky130_fd_sc_hd__a21oi_1
X_17402_ _04852_ network.neuron_in108.counter\[3\] _01021_
+ _01020_ _05651_ VSS VSS VDD VDD _05652_ sky130_fd_sc_hd__a41o_1
X_17403_ net355 _04851_ network.in_period\[108\]\[3\] VSS
+ VSS VDD VDD _05653_ sky130_fd_sc_hd__a21oi_1
X_17404_ net355 _05652_ _05653_ VSS VSS VDD VDD _02498_ sky130_fd_sc_hd__a21oi_1
X_17405_ net356 _04850_ VSS VSS VDD VDD _05654_ sky130_fd_sc_hd__nand2_1
X_17406_ network.neuron_in109.counter\[0\] network.neuron_in109.counter\[2\]
+ network.neuron_in109.counter\[1\] VSS VSS VDD VDD _05655_
+ sky130_fd_sc_hd__nor3_1
X_17407_ network.neuron_in109.counter\[3\] _05655_ VSS VSS
+ VDD VDD _05656_ sky130_fd_sc_hd__xnor2_1
X_17408_ network.in_period\[109\]\[3\] _05654_ VSS VSS VDD
+ VDD _05657_ sky130_fd_sc_hd__nand2_1
X_17409_ _05654_ _05656_ _05657_ VSS VSS VDD VDD _02502_ sky130_fd_sc_hd__o21ai_0
X_17410_ network.in_spk08_10 network.in_spk09_10 _09420_ network.in_spk10_10
+ VSS VSS VDD VDD _05658_ sky130_fd_sc_hd__o31ai_1
X_17411_ _07825_ _05658_ net416 VSS VSS VDD VDD _01990_ sky130_fd_sc_hd__a21oi_1
X_17412_ network.neuron_in110.counter\[1\] network.neuron_in110.counter\[0\]
+ _00160_ VSS VSS VDD VDD _05659_ sky130_fd_sc_hd__o21bai_1
X_17413_ _04847_ _05659_ network.neuron_in110.counter\[3\]
+ VSS VSS VDD VDD _05660_ sky130_fd_sc_hd__a21oi_1
X_17414_ _04847_ network.neuron_in110.counter\[3\] _00159_
+ _00158_ _05660_ VSS VSS VDD VDD _05661_ sky130_fd_sc_hd__a41o_1
X_17415_ net356 _04846_ network.in_period\[110\]\[3\] VSS
+ VSS VDD VDD _05662_ sky130_fd_sc_hd__a21oi_1
X_17416_ net356 _05661_ _05662_ VSS VSS VDD VDD _02506_ sky130_fd_sc_hd__a21oi_1
X_17417_ network.neuron_in111.counter\[0\] VSS VSS VDD VDD
+ _00647_ sky130_fd_sc_hd__inv_1
X_17418_ network.neuron_in111.counter\[1\] network.neuron_in111.counter\[0\]
+ _00649_ VSS VSS VDD VDD _05663_ sky130_fd_sc_hd__o21bai_1
X_17419_ _04844_ _05663_ network.neuron_in111.counter\[3\]
+ VSS VSS VDD VDD _05664_ sky130_fd_sc_hd__a21oi_1
X_17420_ _04844_ network.neuron_in111.counter\[3\] _00648_
+ _00647_ _05664_ VSS VSS VDD VDD _05665_ sky130_fd_sc_hd__a41o_1
X_17421_ net356 _04843_ network.in_period\[111\]\[3\] VSS
+ VSS VDD VDD _05666_ sky130_fd_sc_hd__a21oi_1
X_17422_ net356 _05665_ _05666_ VSS VSS VDD VDD _02510_ sky130_fd_sc_hd__a21oi_1
X_17423_ network.in_spk08_10 _09420_ network.in_spk09_10 VSS
+ VSS VDD VDD _05667_ sky130_fd_sc_hd__o21ai_0
X_17424_ _07802_ _05667_ net416 VSS VSS VDD VDD _01991_ sky130_fd_sc_hd__a21oi_1
X_17425_ network.neuron_in112.counter\[0\] network.neuron_in112.counter\[2\]
+ network.neuron_in112.counter\[1\] net419 VSS VSS VDD VDD _05668_
+ sky130_fd_sc_hd__nor4_1
X_17426_ network.in_period\[112\]\[3\] _05668_ _04841_ VSS
+ VSS VDD VDD _05669_ sky130_fd_sc_hd__mux2i_1
Xplace400 _07402_ VSS VSS VDD VDD net399 sky130_fd_sc_hd__buf_4
X_17428_ network.neuron_in112.counter\[0\] network.neuron_in112.counter\[2\]
+ network.neuron_in112.counter\[1\] net353 network.neuron_in112.counter\[3\]
+ VSS VSS VDD VDD _05671_ sky130_fd_sc_hd__o311a_1
X_17429_ network.in_period\[112\]\[3\] net419 _05671_ VSS
+ VSS VDD VDD _05672_ sky130_fd_sc_hd__a21oi_1
X_17430_ network.neuron_in112.counter\[3\] _05669_ _05672_
+ VSS VSS VDD VDD _02514_ sky130_fd_sc_hd__o21ai_0
X_17431_ network.neuron_in113.counter\[0\] network.neuron_in113.counter\[1\]
+ _01004_ VSS VSS VDD VDD _05673_ sky130_fd_sc_hd__o21bai_1
X_17432_ _04838_ _05673_ network.neuron_in113.counter\[3\]
+ VSS VSS VDD VDD _05674_ sky130_fd_sc_hd__a21oi_1
X_17433_ _04838_ network.neuron_in113.counter\[3\] _01002_
+ _01003_ _05674_ VSS VSS VDD VDD _05675_ sky130_fd_sc_hd__a41o_1
X_17434_ net355 _04837_ network.in_period\[113\]\[3\] VSS
+ VSS VDD VDD _05676_ sky130_fd_sc_hd__a21oi_1
X_17435_ net355 _05675_ _05676_ VSS VSS VDD VDD _02518_ sky130_fd_sc_hd__a21oi_1
X_17436_ network.in_spk08_10 _09420_ VSS VSS VDD VDD _05677_
+ sky130_fd_sc_hd__nand2_1
X_17437_ _07820_ _05677_ net416 VSS VSS VDD VDD _01992_ sky130_fd_sc_hd__a21oi_1
X_17438_ network.neuron_in114.counter\[0\] network.neuron_in114.counter\[1\]
+ VSS VSS VDD VDD _05678_ sky130_fd_sc_hd__nor2_1
X_17439_ _01247_ _05678_ VSS VSS VDD VDD _05679_ sky130_fd_sc_hd__nor2_1
X_17440_ network.neuron_in114.counter\[2\] _05679_ VSS VSS
+ VDD VDD _05680_ sky130_fd_sc_hd__nor2_1
X_17441_ network.neuron_in114.counter\[2\] network.neuron_in114.counter\[3\]
+ _05678_ VSS VSS VDD VDD _05681_ sky130_fd_sc_hd__nand3b_1
X_17442_ network.neuron_in114.counter\[3\] _05680_ _05681_
+ VSS VSS VDD VDD _05682_ sky130_fd_sc_hd__o21ai_0
X_17443_ net356 _04834_ network.in_period\[114\]\[3\] VSS
+ VSS VDD VDD _05683_ sky130_fd_sc_hd__a21oi_1
X_17444_ net356 _05682_ _05683_ VSS VSS VDD VDD _02522_ sky130_fd_sc_hd__a21oi_1
X_17445_ network.neuron_in115.counter\[1\] network.neuron_in115.counter\[0\]
+ _01210_ VSS VSS VDD VDD _05684_ sky130_fd_sc_hd__o21bai_1
X_17446_ _04832_ _05684_ network.neuron_in115.counter\[3\]
+ VSS VSS VDD VDD _05685_ sky130_fd_sc_hd__a21oi_1
X_17447_ _04832_ network.neuron_in115.counter\[3\] _01209_
+ _01208_ _05685_ VSS VSS VDD VDD _05686_ sky130_fd_sc_hd__a41o_1
X_17448_ net355 _04831_ network.in_period\[115\]\[3\] VSS
+ VSS VDD VDD _05687_ sky130_fd_sc_hd__a21oi_1
X_17449_ net355 _05686_ _05687_ VSS VSS VDD VDD _02526_ sky130_fd_sc_hd__a21oi_1
X_17450_ _09353_ _09554_ network.in_spk07_10 VSS VSS VDD VDD
+ _05688_ sky130_fd_sc_hd__o21ai_0
Xplace398 _07414_ VSS VSS VDD VDD net397 sky130_fd_sc_hd__buf_4
X_17452_ _07851_ _05688_ net416 VSS VSS VDD VDD _01993_ sky130_fd_sc_hd__a21oi_1
X_17453_ network.neuron_in204.counter\[1\] VSS VSS VDD VDD
+ _00824_ sky130_fd_sc_hd__inv_1
Xplace327 net43 VSS VSS VDD VDD net326 sky130_fd_sc_hd__buf_4
X_17455_ network.neuron_in116.counter\[0\] network.neuron_in116.counter\[1\]
+ VSS VSS VDD VDD _05691_ sky130_fd_sc_hd__nor2_1
X_17456_ _00072_ _05691_ VSS VSS VDD VDD _05692_ sky130_fd_sc_hd__nor2_1
X_17457_ network.neuron_in116.counter\[2\] _05692_ VSS VSS
+ VDD VDD _05693_ sky130_fd_sc_hd__nor2_1
X_17458_ network.neuron_in116.counter\[2\] network.neuron_in116.counter\[3\]
+ _05691_ VSS VSS VDD VDD _05694_ sky130_fd_sc_hd__nand3b_1
X_17459_ network.neuron_in116.counter\[3\] _05693_ _05694_
+ VSS VSS VDD VDD _05695_ sky130_fd_sc_hd__o21ai_0
X_17460_ net353 _04829_ network.in_period\[116\]\[3\] VSS
+ VSS VDD VDD _05696_ sky130_fd_sc_hd__a21oi_1
X_17461_ net353 _05695_ _05696_ VSS VSS VDD VDD _02530_ sky130_fd_sc_hd__a21oi_1
X_17462_ net355 _04828_ VSS VSS VDD VDD _05697_ sky130_fd_sc_hd__nand2_1
X_17463_ network.neuron_in117.counter\[0\] network.neuron_in117.counter\[2\]
+ network.neuron_in117.counter\[1\] VSS VSS VDD VDD _05698_
+ sky130_fd_sc_hd__nor3_1
X_17464_ network.neuron_in117.counter\[3\] _05698_ VSS VSS
+ VDD VDD _05699_ sky130_fd_sc_hd__xnor2_1
X_17465_ network.in_period\[117\]\[3\] _05697_ VSS VSS VDD
+ VDD _05700_ sky130_fd_sc_hd__nand2_1
X_17466_ _05697_ _05699_ _05700_ VSS VSS VDD VDD _02534_ sky130_fd_sc_hd__o21ai_0
X_17467_ _09283_ _09349_ _09352_ VSS VSS VDD VDD _05701_ sky130_fd_sc_hd__nand3_1
X_17468_ network.in_spk04_10 network.in_spk05_10 _05701_ network.in_spk06_10
+ VSS VSS VDD VDD _05702_ sky130_fd_sc_hd__o31ai_1
X_17469_ _03859_ _05702_ net416 VSS VSS VDD VDD _01994_ sky130_fd_sc_hd__a21oi_1
X_17470_ network.neuron_in118.counter\[0\] network.neuron_in118.counter\[2\]
+ network.neuron_in118.counter\[1\] net419 VSS VSS VDD VDD _05703_
+ sky130_fd_sc_hd__nor4_1
X_17471_ network.in_period\[118\]\[3\] _05703_ _04825_ VSS
+ VSS VDD VDD _05704_ sky130_fd_sc_hd__mux2i_1
X_17472_ network.neuron_in118.counter\[0\] network.neuron_in118.counter\[2\]
+ network.neuron_in118.counter\[1\] net354 network.neuron_in118.counter\[3\]
+ VSS VSS VDD VDD _05705_ sky130_fd_sc_hd__o311a_1
X_17473_ network.in_period\[118\]\[3\] net419 _05705_ VSS
+ VSS VDD VDD _05706_ sky130_fd_sc_hd__a21oi_1
X_17474_ network.neuron_in118.counter\[3\] _05704_ _05706_
+ VSS VSS VDD VDD _02538_ sky130_fd_sc_hd__o21ai_0
X_17475_ network.neuron_in119.counter\[1\] network.neuron_in119.counter\[0\]
+ _00653_ VSS VSS VDD VDD _05707_ sky130_fd_sc_hd__o21bai_1
X_17476_ _04822_ _05707_ network.neuron_in119.counter\[3\]
+ VSS VSS VDD VDD _05708_ sky130_fd_sc_hd__a21oi_1
X_17477_ _04822_ _00652_ _00651_ network.neuron_in119.counter\[3\]
+ _05708_ VSS VSS VDD VDD _05709_ sky130_fd_sc_hd__a41o_1
X_17478_ net355 _04821_ network.in_period\[119\]\[3\] VSS
+ VSS VDD VDD _05710_ sky130_fd_sc_hd__a21oi_1
X_17479_ net355 _05709_ _05710_ VSS VSS VDD VDD _02542_ sky130_fd_sc_hd__a21oi_1
X_17480_ network.in_spk04_10 _05701_ network.in_spk05_10 VSS
+ VSS VDD VDD _05711_ sky130_fd_sc_hd__o21ai_0
X_17481_ _03847_ _05711_ net416 VSS VSS VDD VDD _01995_ sky130_fd_sc_hd__a21oi_1
X_17482_ network.neuron_in120.counter\[0\] network.neuron_in120.counter\[1\]
+ _00968_ VSS VSS VDD VDD _05712_ sky130_fd_sc_hd__o21bai_1
X_17483_ _04819_ _05712_ network.neuron_in120.counter\[3\]
+ VSS VSS VDD VDD _05713_ sky130_fd_sc_hd__a21oi_1
X_17484_ _04819_ network.neuron_in120.counter\[3\] _00966_
+ _00967_ _05713_ VSS VSS VDD VDD _05714_ sky130_fd_sc_hd__a41o_1
X_17485_ net353 _04818_ network.in_period\[120\]\[3\] VSS
+ VSS VDD VDD _05715_ sky130_fd_sc_hd__a21oi_1
X_17486_ net353 _05714_ _05715_ VSS VSS VDD VDD _02546_ sky130_fd_sc_hd__a21oi_1
X_17487_ net353 _04817_ VSS VSS VDD VDD _05716_ sky130_fd_sc_hd__nand2_1
X_17488_ network.neuron_in121.counter\[1\] network.neuron_in121.counter\[0\]
+ network.neuron_in121.counter\[2\] VSS VSS VDD VDD _05717_
+ sky130_fd_sc_hd__nor3_1
X_17489_ network.neuron_in121.counter\[3\] _05717_ VSS VSS
+ VDD VDD _05718_ sky130_fd_sc_hd__xnor2_1
X_17490_ network.in_period\[121\]\[3\] _05716_ VSS VSS VDD
+ VDD _05719_ sky130_fd_sc_hd__nand2_1
X_17491_ _05716_ _05718_ _05719_ VSS VSS VDD VDD _02550_ sky130_fd_sc_hd__o21ai_0
X_17492_ network.in_spk04_10 _05701_ VSS VSS VDD VDD _05720_
+ sky130_fd_sc_hd__nand2_1
X_17493_ _03838_ _05720_ net416 VSS VSS VDD VDD _01996_ sky130_fd_sc_hd__a21oi_1
X_17494_ network.neuron_in122.counter\[1\] network.neuron_in122.counter\[0\]
+ _01052_ VSS VSS VDD VDD _05721_ sky130_fd_sc_hd__o21bai_1
X_17495_ _04814_ _05721_ network.neuron_in122.counter\[3\]
+ VSS VSS VDD VDD _05722_ sky130_fd_sc_hd__a21oi_1
X_17496_ _04814_ network.neuron_in122.counter\[3\] _01051_
+ _01050_ _05722_ VSS VSS VDD VDD _05723_ sky130_fd_sc_hd__a41o_1
Xplace325 _09315_ VSS VSS VDD VDD net324 sky130_fd_sc_hd__buf_4
X_17498_ net353 _04813_ network.in_period\[122\]\[3\] VSS
+ VSS VDD VDD _05725_ sky130_fd_sc_hd__a21oi_1
X_17499_ net353 _05723_ _05725_ VSS VSS VDD VDD _02554_ sky130_fd_sc_hd__a21oi_1
X_17500_ network.neuron_in123.counter\[1\] network.neuron_in123.counter\[0\]
+ network.neuron_in123.counter\[2\] net419 VSS VSS VDD VDD _05726_
+ sky130_fd_sc_hd__nor4_1
X_17501_ network.in_period\[123\]\[3\] _05726_ _04811_ VSS
+ VSS VDD VDD _05727_ sky130_fd_sc_hd__mux2i_1
X_17502_ network.neuron_in123.counter\[1\] network.neuron_in123.counter\[0\]
+ network.neuron_in123.counter\[2\] network.neuron_in123.counter\[3\]
+ net353 VSS VSS VDD VDD _05728_ sky130_fd_sc_hd__o311a_1
X_17503_ network.in_period\[123\]\[3\] net419 _05728_ VSS
+ VSS VDD VDD _05729_ sky130_fd_sc_hd__a21oi_1
X_17504_ network.neuron_in123.counter\[3\] _05727_ _05729_
+ VSS VSS VDD VDD _02558_ sky130_fd_sc_hd__o21ai_0
X_17505_ network.in_spk00_10 network.in_spk01_10 _09353_ VSS
+ VSS VDD VDD _05730_ sky130_fd_sc_hd__or3_1
X_17506_ network.in_spk02_10 _05730_ network.in_spk03_10 VSS
+ VSS VDD VDD _05731_ sky130_fd_sc_hd__o21ai_1
X_17507_ _03824_ _05731_ net416 VSS VSS VDD VDD _01997_ sky130_fd_sc_hd__a21oi_1
X_17508_ network.neuron_in124.counter\[0\] network.neuron_in124.counter\[1\]
+ _00405_ VSS VSS VDD VDD _05732_ sky130_fd_sc_hd__o21bai_1
X_17509_ _04807_ _05732_ network.neuron_in124.counter\[3\]
+ VSS VSS VDD VDD _05733_ sky130_fd_sc_hd__a21oi_1
X_17510_ _04807_ network.neuron_in124.counter\[3\] _00403_
+ _00404_ _05733_ VSS VSS VDD VDD _05734_ sky130_fd_sc_hd__a41o_1
X_17511_ net354 _04806_ network.in_period\[124\]\[3\] VSS
+ VSS VDD VDD _05735_ sky130_fd_sc_hd__a21oi_1
X_17512_ net354 _05734_ _05735_ VSS VSS VDD VDD _02562_ sky130_fd_sc_hd__a21oi_1
X_17513_ network.neuron_in125.counter\[0\] network.neuron_in125.counter\[1\]
+ network.neuron_in125.counter\[2\] net420 VSS VSS VDD VDD _05736_
+ sky130_fd_sc_hd__nor4_1
X_17514_ network.in_period\[125\]\[3\] _05736_ _04804_ VSS
+ VSS VDD VDD _05737_ sky130_fd_sc_hd__mux2i_1
X_17515_ network.neuron_in125.counter\[0\] network.neuron_in125.counter\[1\]
+ network.neuron_in125.counter\[2\] network.neuron_in125.counter\[3\]
+ net353 VSS VSS VDD VDD _05738_ sky130_fd_sc_hd__o311a_1
X_17516_ network.in_period\[125\]\[3\] net420 _05738_ VSS
+ VSS VDD VDD _05739_ sky130_fd_sc_hd__a21oi_1
X_17517_ network.neuron_in125.counter\[3\] _05737_ _05739_
+ VSS VSS VDD VDD _02566_ sky130_fd_sc_hd__o21ai_0
X_17518_ network.in_spk02_10 _05730_ VSS VSS VDD VDD _05740_
+ sky130_fd_sc_hd__nand2_1
X_17519_ _06691_ _05740_ net416 VSS VSS VDD VDD _01998_ sky130_fd_sc_hd__a21oi_1
X_17520_ network.neuron_in126.counter\[0\] network.neuron_in126.counter\[1\]
+ _00767_ VSS VSS VDD VDD _05741_ sky130_fd_sc_hd__o21bai_1
X_17521_ _04802_ _05741_ network.neuron_in126.counter\[3\]
+ VSS VSS VDD VDD _05742_ sky130_fd_sc_hd__a21oi_1
X_17522_ _04802_ network.neuron_in126.counter\[3\] _00765_
+ _00766_ _05742_ VSS VSS VDD VDD _05743_ sky130_fd_sc_hd__a41o_1
X_17523_ net353 _04801_ network.in_period\[126\]\[3\] VSS
+ VSS VDD VDD _05744_ sky130_fd_sc_hd__a21oi_1
X_17524_ net353 _05743_ _05744_ VSS VSS VDD VDD _02570_ sky130_fd_sc_hd__a21oi_1
X_17525_ network.neuron_in116.counter\[1\] VSS VSS VDD VDD
+ _00071_ sky130_fd_sc_hd__inv_1
X_17526_ net353 _04800_ VSS VSS VDD VDD _05745_ sky130_fd_sc_hd__nand2_1
X_17527_ network.neuron_in127.counter\[1\] network.neuron_in127.counter\[0\]
+ network.neuron_in127.counter\[2\] VSS VSS VDD VDD _05746_
+ sky130_fd_sc_hd__nor3_1
X_17528_ network.neuron_in127.counter\[3\] _05746_ VSS VSS
+ VDD VDD _05747_ sky130_fd_sc_hd__xnor2_1
X_17529_ network.in_period\[127\]\[3\] _05745_ VSS VSS VDD
+ VDD _05748_ sky130_fd_sc_hd__nand2_1
X_17530_ _05745_ _05747_ _05748_ VSS VSS VDD VDD _02574_ sky130_fd_sc_hd__o21ai_0
X_17531_ network.in_spk01_10 _09567_ VSS VSS VDD VDD _05749_
+ sky130_fd_sc_hd__nand2_1
X_17532_ _06686_ _05749_ net416 VSS VSS VDD VDD _01999_ sky130_fd_sc_hd__a21oi_1
X_17533_ network.neuron_in128.counter\[1\] network.neuron_in128.counter\[0\]
+ network.neuron_in128.counter\[2\] net420 VSS VSS VDD VDD _05750_
+ sky130_fd_sc_hd__nor4_1
X_17534_ network.in_period\[128\]\[3\] _05750_ _07278_ VSS
+ VSS VDD VDD _05751_ sky130_fd_sc_hd__mux2i_1
Xplace322 _04062_ VSS VSS VDD VDD net321 sky130_fd_sc_hd__buf_4
X_17536_ network.neuron_in128.counter\[1\] network.neuron_in128.counter\[0\]
+ network.neuron_in128.counter\[2\] network.neuron_in128.counter\[3\]
+ net358 VSS VSS VDD VDD _05753_ sky130_fd_sc_hd__o311a_1
X_17537_ network.in_period\[128\]\[3\] net420 _05753_ VSS
+ VSS VDD VDD _05754_ sky130_fd_sc_hd__a21oi_1
X_17538_ network.neuron_in128.counter\[3\] _05751_ _05754_
+ VSS VSS VDD VDD _02578_ sky130_fd_sc_hd__o21ai_0
X_17539_ network.neuron_in129.counter\[0\] network.neuron_in129.counter\[1\]
+ network.neuron_in129.counter\[2\] net421 VSS VSS VDD VDD _05755_
+ sky130_fd_sc_hd__nor4_1
X_17540_ network.in_period\[129\]\[3\] _05755_ _06907_ VSS
+ VSS VDD VDD _05756_ sky130_fd_sc_hd__mux2i_1
X_17541_ network.neuron_in129.counter\[0\] network.neuron_in129.counter\[1\]
+ network.neuron_in129.counter\[2\] network.neuron_in129.counter\[3\]
+ net351 VSS VSS VDD VDD _05757_ sky130_fd_sc_hd__o311a_1
X_17542_ network.in_period\[129\]\[3\] net421 _05757_ VSS
+ VSS VDD VDD _05758_ sky130_fd_sc_hd__a21oi_1
X_17543_ network.neuron_in129.counter\[3\] _05756_ _05758_
+ VSS VSS VDD VDD _02582_ sky130_fd_sc_hd__o21ai_0
X_17544_ network.in_spk00_10 _09353_ VSS VSS VDD VDD _05759_
+ sky130_fd_sc_hd__nand2_1
X_17545_ _06681_ _05759_ net416 VSS VSS VDD VDD _02000_ sky130_fd_sc_hd__a21oi_1
X_17546_ network.neuron_in130.counter\[1\] network.neuron_in130.counter\[0\]
+ _00914_ VSS VSS VDD VDD _05760_ sky130_fd_sc_hd__o21bai_1
X_17547_ _03591_ _05760_ network.neuron_in130.counter\[3\]
+ VSS VSS VDD VDD _05761_ sky130_fd_sc_hd__a21oi_1
X_17548_ _03591_ network.neuron_in130.counter\[3\] _00913_
+ _00912_ _05761_ VSS VSS VDD VDD _05762_ sky130_fd_sc_hd__a41o_1
X_17549_ net359 _03668_ network.in_period\[130\]\[3\] VSS
+ VSS VDD VDD _05763_ sky130_fd_sc_hd__a21oi_1
X_17550_ net359 _05762_ _05763_ VSS VSS VDD VDD _02586_ sky130_fd_sc_hd__a21oi_1
X_17551_ network.neuron_in131.counter\[2\] VSS VSS VDD VDD
+ _05764_ sky130_fd_sc_hd__inv_1
X_17552_ _00901_ _05764_ _00900_ net359 VSS VSS VDD VDD _05765_
+ sky130_fd_sc_hd__nand4_1
X_17553_ _05764_ _00902_ _05765_ VSS VSS VDD VDD _05766_ sky130_fd_sc_hd__a21oi_1
X_17554_ _05764_ _00902_ network.in_period\[131\]\[3\] _05766_
+ VSS VSS VDD VDD _05767_ sky130_fd_sc_hd__a31oi_1
X_17555_ network.neuron_in131.counter\[1\] network.neuron_in131.counter\[2\]
+ network.neuron_in131.counter\[0\] net359 network.neuron_in131.counter\[3\]
+ VSS VSS VDD VDD _05768_ sky130_fd_sc_hd__o311a_1
X_17556_ network.in_period\[131\]\[3\] net413 _05768_ VSS
+ VSS VDD VDD _05769_ sky130_fd_sc_hd__a21oi_1
X_17557_ network.neuron_in131.counter\[3\] _05767_ _05769_
+ VSS VSS VDD VDD _02590_ sky130_fd_sc_hd__o21ai_0
X_17558_ network.neuron_in027.counter\[2\] net349 VSS VSS
+ VDD VDD _05770_ sky130_fd_sc_hd__nand2_1
X_17559_ network.neuron_in027.counter\[3\] network.in_period\[27\]\[2\]
+ _05770_ VSS VSS VDD VDD _05771_ sky130_fd_sc_hd__o21ai_0
X_17560_ _00531_ network.neuron_in027.counter\[2\] net422
+ VSS VSS VDD VDD _05772_ sky130_fd_sc_hd__or3_1
X_17561_ network.in_period\[27\]\[2\] net349 _05772_ VSS VSS
+ VDD VDD _05773_ sky130_fd_sc_hd__o21ai_0
X_17562_ _00531_ _05771_ _05773_ VSS VSS VDD VDD _02173_ sky130_fd_sc_hd__a21oi_1
X_17563_ _09370_ _09618_ VSS VSS VDD VDD _05774_ sky130_fd_sc_hd__nand2_1
X_17564_ network.in_spk12_09 network.in_spk13_09 network.in_spk14_09
+ _05774_ network.in_spk15_09 VSS VSS VDD VDD _05775_ sky130_fd_sc_hd__o41ai_1
X_17565_ _06665_ _05775_ net413 VSS VSS VDD VDD _02001_ sky130_fd_sc_hd__a21oi_1
X_17566_ network.neuron_in132.counter\[1\] network.neuron_in132.counter\[2\]
+ network.neuron_in132.counter\[0\] net421 VSS VSS VDD VDD _05776_
+ sky130_fd_sc_hd__nor4_1
X_17567_ network.in_period\[132\]\[3\] _05776_ _04049_ VSS
+ VSS VDD VDD _05777_ sky130_fd_sc_hd__mux2i_1
X_17568_ network.neuron_in132.counter\[1\] network.neuron_in132.counter\[2\]
+ network.neuron_in132.counter\[0\] network.neuron_in132.counter\[3\]
+ net352 VSS VSS VDD VDD _05778_ sky130_fd_sc_hd__o311a_1
X_17569_ network.in_period\[132\]\[3\] net421 _05778_ VSS
+ VSS VDD VDD _05779_ sky130_fd_sc_hd__a21oi_1
X_17570_ network.neuron_in132.counter\[3\] _05777_ _05779_
+ VSS VSS VDD VDD _02594_ sky130_fd_sc_hd__o21ai_0
X_17571_ net349 _04738_ VSS VSS VDD VDD _05780_ sky130_fd_sc_hd__nand2_1
X_17572_ network.in_period\[27\]\[1\] _05780_ VSS VSS VDD
+ VDD _05781_ sky130_fd_sc_hd__nand2_1
X_17573_ _00532_ _05780_ _05781_ VSS VSS VDD VDD _02172_ sky130_fd_sc_hd__o21ai_0
X_17574_ network.neuron_in133.counter\[1\] network.neuron_in133.counter\[0\]
+ network.neuron_in133.counter\[2\] VSS VSS VDD VDD _05782_
+ sky130_fd_sc_hd__nor3_1
X_17575_ network.neuron_in133.counter\[3\] _05782_ VSS VSS
+ VDD VDD _05783_ sky130_fd_sc_hd__xnor2_1
X_17576_ network.in_period\[133\]\[3\] _07091_ VSS VSS VDD
+ VDD _05784_ sky130_fd_sc_hd__nand2_1
X_17577_ _07091_ _05783_ _05784_ VSS VSS VDD VDD _02598_ sky130_fd_sc_hd__o21ai_0
X_17578_ network.in_period\[27\]\[0\] _05780_ VSS VSS VDD
+ VDD _05785_ sky130_fd_sc_hd__nand2_1
X_17579_ network.neuron_in027.counter\[0\] _05780_ _05785_
+ VSS VSS VDD VDD _02171_ sky130_fd_sc_hd__o21ai_0
X_17580_ network.in_spk12_09 network.in_spk13_09 _05774_ network.in_spk14_09
+ VSS VSS VDD VDD _05786_ sky130_fd_sc_hd__o31ai_1
X_17581_ _04790_ _05786_ net412 VSS VSS VDD VDD _02002_ sky130_fd_sc_hd__a21oi_1
X_17582_ network.neuron_in134.counter\[1\] network.neuron_in134.counter\[0\]
+ VSS VSS VDD VDD _05787_ sky130_fd_sc_hd__nor2_1
X_17583_ _00893_ _05787_ VSS VSS VDD VDD _05788_ sky130_fd_sc_hd__nor2_1
X_17584_ network.neuron_in134.counter\[2\] _05788_ VSS VSS
+ VDD VDD _05789_ sky130_fd_sc_hd__nor2_1
X_17585_ network.neuron_in134.counter\[2\] network.neuron_in134.counter\[3\]
+ _05787_ VSS VSS VDD VDD _05790_ sky130_fd_sc_hd__nand3b_1
X_17586_ network.neuron_in134.counter\[3\] _05789_ _05790_
+ VSS VSS VDD VDD _05791_ sky130_fd_sc_hd__o21ai_0
X_17587_ net352 _07262_ network.in_period\[134\]\[3\] VSS
+ VSS VDD VDD _05792_ sky130_fd_sc_hd__a21oi_1
X_17588_ net352 _05791_ _05792_ VSS VSS VDD VDD _02602_ sky130_fd_sc_hd__a21oi_1
Xplace312 _08026_ VSS VSS VDD VDD net311 sky130_fd_sc_hd__buf_4
X_17590_ network.neuron_in135.counter\[0\] network.neuron_in135.counter\[2\]
+ network.neuron_in135.counter\[1\] net421 VSS VSS VDD VDD _05794_
+ sky130_fd_sc_hd__nor4_1
X_17591_ network.in_period\[135\]\[3\] _05794_ _08198_ VSS
+ VSS VDD VDD _05795_ sky130_fd_sc_hd__mux2i_1
X_17592_ network.neuron_in135.counter\[0\] network.neuron_in135.counter\[2\]
+ network.neuron_in135.counter\[1\] net352 network.neuron_in135.counter\[3\]
+ VSS VSS VDD VDD _05796_ sky130_fd_sc_hd__o311a_1
X_17593_ network.in_period\[135\]\[3\] net421 _05796_ VSS
+ VSS VDD VDD _05797_ sky130_fd_sc_hd__a21oi_1
X_17594_ network.neuron_in135.counter\[3\] _05795_ _05797_
+ VSS VSS VDD VDD _02606_ sky130_fd_sc_hd__o21ai_0
X_17595_ network.in_spk12_09 _05774_ network.in_spk13_09 VSS
+ VSS VDD VDD _05798_ sky130_fd_sc_hd__o21ai_0
Xoutput48 net47 VSS VSS VDD VDD result_class[1] sky130_fd_sc_hd__buf_1
X_17597_ _07242_ _05798_ net412 VSS VSS VDD VDD _02003_ sky130_fd_sc_hd__a21oi_1
X_17598_ network.neuron_in136.counter\[1\] network.neuron_in136.counter\[0\]
+ VSS VSS VDD VDD _05800_ sky130_fd_sc_hd__nor2_1
X_17599_ _00762_ _05800_ VSS VSS VDD VDD _05801_ sky130_fd_sc_hd__nor2_1
X_17600_ network.neuron_in136.counter\[2\] _05801_ VSS VSS
+ VDD VDD _05802_ sky130_fd_sc_hd__nor2_1
X_17601_ network.neuron_in136.counter\[2\] network.neuron_in136.counter\[3\]
+ _05800_ VSS VSS VDD VDD _05803_ sky130_fd_sc_hd__nand3b_1
X_17602_ network.neuron_in136.counter\[3\] _05802_ _05803_
+ VSS VSS VDD VDD _05804_ sky130_fd_sc_hd__o21ai_0
X_17603_ net359 _06726_ network.in_period\[136\]\[3\] VSS
+ VSS VDD VDD _05805_ sky130_fd_sc_hd__a21oi_1
X_17604_ net359 _05804_ _05805_ VSS VSS VDD VDD _02610_ sky130_fd_sc_hd__a21oi_1
X_17605_ network.neuron_in137.counter\[0\] network.neuron_in137.counter\[1\]
+ _00724_ VSS VSS VDD VDD _05806_ sky130_fd_sc_hd__o21bai_1
X_17606_ _06820_ _05806_ network.neuron_in137.counter\[3\]
+ VSS VSS VDD VDD _05807_ sky130_fd_sc_hd__a21oi_1
X_17607_ _06820_ _00722_ _00723_ network.neuron_in137.counter\[3\]
+ _05807_ VSS VSS VDD VDD _05808_ sky130_fd_sc_hd__a41o_1
X_17608_ net352 _06819_ network.in_period\[137\]\[3\] VSS
+ VSS VDD VDD _05809_ sky130_fd_sc_hd__a21oi_1
X_17609_ net352 _05808_ _05809_ VSS VSS VDD VDD _02614_ sky130_fd_sc_hd__a21oi_1
X_17610_ network.in_spk12_09 _05774_ VSS VSS VDD VDD _05810_
+ sky130_fd_sc_hd__nand2_1
X_17611_ _03906_ _05810_ net412 VSS VSS VDD VDD _02004_ sky130_fd_sc_hd__a21oi_1
X_17612_ network.neuron_in138.counter\[1\] network.neuron_in138.counter\[2\]
+ network.neuron_in138.counter\[0\] VSS VSS VDD VDD _05811_
+ sky130_fd_sc_hd__nor3_1
X_17613_ network.neuron_in138.counter\[3\] _05811_ VSS VSS
+ VDD VDD _05812_ sky130_fd_sc_hd__xnor2_1
X_17614_ network.in_period\[138\]\[3\] _03578_ VSS VSS VDD
+ VDD _05813_ sky130_fd_sc_hd__nand2_1
X_17615_ _03578_ _05812_ _05813_ VSS VSS VDD VDD _02618_ sky130_fd_sc_hd__o21ai_0
Xoutput47 net46 VSS VSS VDD VDD result_class[0] sky130_fd_sc_hd__buf_1
X_17617_ network.neuron_in139.counter\[1\] network.neuron_in139.counter\[0\]
+ VSS VSS VDD VDD _05815_ sky130_fd_sc_hd__nor2_1
X_17618_ _01110_ _05815_ VSS VSS VDD VDD _05816_ sky130_fd_sc_hd__nor2_1
X_17619_ network.neuron_in139.counter\[2\] _05816_ VSS VSS
+ VDD VDD _05817_ sky130_fd_sc_hd__nor2_1
X_17620_ network.neuron_in139.counter\[2\] network.neuron_in139.counter\[3\]
+ _05815_ VSS VSS VDD VDD _05818_ sky130_fd_sc_hd__nand3b_1
X_17621_ network.neuron_in139.counter\[3\] _05817_ _05818_
+ VSS VSS VDD VDD _05819_ sky130_fd_sc_hd__o21ai_0
X_17622_ net352 _03494_ network.in_period\[139\]\[3\] VSS
+ VSS VDD VDD _05820_ sky130_fd_sc_hd__a21oi_1
X_17623_ net352 _05819_ _05820_ VSS VSS VDD VDD _02622_ sky130_fd_sc_hd__a21oi_1
X_17624_ _09432_ _09413_ network.in_spk11_09 VSS VSS VDD VDD
+ _05821_ sky130_fd_sc_hd__o21ai_0
X_17625_ _06835_ _05821_ net413 VSS VSS VDD VDD _02005_ sky130_fd_sc_hd__a21oi_1
X_17626_ network.neuron_in140.counter\[0\] network.neuron_in140.counter\[1\]
+ network.neuron_in140.counter\[2\] net421 VSS VSS VDD VDD _05822_
+ sky130_fd_sc_hd__nor4_1
X_17627_ network.in_period\[140\]\[3\] _05822_ _06755_ VSS
+ VSS VDD VDD _05823_ sky130_fd_sc_hd__mux2i_1
X_17628_ network.neuron_in140.counter\[0\] network.neuron_in140.counter\[1\]
+ network.neuron_in140.counter\[2\] network.neuron_in140.counter\[3\]
+ net352 VSS VSS VDD VDD _05824_ sky130_fd_sc_hd__o311a_1
X_17629_ network.in_period\[140\]\[3\] net421 _05824_ VSS
+ VSS VDD VDD _05825_ sky130_fd_sc_hd__a21oi_1
X_17630_ network.neuron_in140.counter\[3\] _05823_ _05825_
+ VSS VSS VDD VDD _02626_ sky130_fd_sc_hd__o21ai_0
X_17631_ network.neuron_in141.counter\[1\] network.neuron_in141.counter\[0\]
+ network.neuron_in141.counter\[2\] VSS VSS VDD VDD _05826_
+ sky130_fd_sc_hd__nor3_1
X_17632_ network.neuron_in141.counter\[3\] _05826_ VSS VSS
+ VDD VDD _05827_ sky130_fd_sc_hd__xnor2_1
X_17633_ network.in_period\[141\]\[3\] _07156_ VSS VSS VDD
+ VDD _05828_ sky130_fd_sc_hd__nand2_1
X_17634_ _07156_ _05827_ _05828_ VSS VSS VDD VDD _02630_ sky130_fd_sc_hd__o21ai_0
X_17635_ network.in_spk08_09 network.in_spk09_09 _09413_ network.in_spk10_09
+ VSS VSS VDD VDD _05829_ sky130_fd_sc_hd__o31ai_1
X_17636_ _07051_ _05829_ net413 VSS VSS VDD VDD _02006_ sky130_fd_sc_hd__a21oi_1
X_17637_ network.neuron_in142.counter\[2\] VSS VSS VDD VDD
+ _05830_ sky130_fd_sc_hd__inv_1
X_17638_ _00607_ _05830_ _00608_ net360 VSS VSS VDD VDD _05831_
+ sky130_fd_sc_hd__nand4_1
X_17639_ _05830_ _00609_ _05831_ VSS VSS VDD VDD _05832_ sky130_fd_sc_hd__a21oi_1
X_17640_ _05830_ _00609_ network.in_period\[142\]\[3\] _05832_
+ VSS VSS VDD VDD _05833_ sky130_fd_sc_hd__a31oi_1
X_17641_ network.neuron_in142.counter\[0\] network.neuron_in142.counter\[2\]
+ network.neuron_in142.counter\[1\] network.neuron_in142.counter\[3\]
+ net360 VSS VSS VDD VDD _05834_ sky130_fd_sc_hd__o311a_1
X_17642_ network.in_period\[142\]\[3\] net421 _05834_ VSS
+ VSS VDD VDD _05835_ sky130_fd_sc_hd__a21oi_1
X_17643_ network.neuron_in142.counter\[3\] _05833_ _05835_
+ VSS VSS VDD VDD _02634_ sky130_fd_sc_hd__o21ai_0
X_17644_ net345 _04872_ VSS VSS VDD VDD _05836_ sky130_fd_sc_hd__nand2_1
X_17645_ network.in_period\[102\]\[0\] _05836_ VSS VSS VDD
+ VDD _05837_ sky130_fd_sc_hd__nand2_1
X_17646_ network.neuron_in102.counter\[0\] _05836_ _05837_
+ VSS VSS VDD VDD _02471_ sky130_fd_sc_hd__o21ai_0
X_17647_ network.neuron_in143.counter\[1\] network.neuron_in143.counter\[0\]
+ network.neuron_in143.counter\[2\] net421 VSS VSS VDD VDD _05838_
+ sky130_fd_sc_hd__nor4_1
X_17648_ network.in_period\[143\]\[3\] _05838_ _07044_ VSS
+ VSS VDD VDD _05839_ sky130_fd_sc_hd__mux2i_1
X_17649_ network.neuron_in143.counter\[1\] network.neuron_in143.counter\[0\]
+ network.neuron_in143.counter\[2\] network.neuron_in143.counter\[3\]
+ net360 VSS VSS VDD VDD _05840_ sky130_fd_sc_hd__o311a_1
X_17650_ network.in_period\[143\]\[3\] net421 _05840_ VSS
+ VSS VDD VDD _05841_ sky130_fd_sc_hd__a21oi_1
X_17651_ network.neuron_in143.counter\[3\] _05839_ _05841_
+ VSS VSS VDD VDD _02638_ sky130_fd_sc_hd__o21ai_0
X_17652_ net357 _04877_ VSS VSS VDD VDD _05842_ sky130_fd_sc_hd__nand2_1
X_17653_ network.in_period\[100\]\[1\] _05842_ VSS VSS VDD
+ VDD _05843_ sky130_fd_sc_hd__nand2_1
X_17654_ _00875_ _05842_ _05843_ VSS VSS VDD VDD _02464_ sky130_fd_sc_hd__o21ai_0
X_17655_ network.in_spk08_09 _09413_ network.in_spk09_09 VSS
+ VSS VDD VDD _05844_ sky130_fd_sc_hd__o21ai_0
X_17656_ _07040_ _05844_ net413 VSS VSS VDD VDD _02007_ sky130_fd_sc_hd__a21oi_1
X_17657_ network.neuron_in144.counter\[2\] VSS VSS VDD VDD
+ _05845_ sky130_fd_sc_hd__inv_1
X_17658_ _00706_ _05845_ _00707_ net358 VSS VSS VDD VDD _05846_
+ sky130_fd_sc_hd__nand4_1
X_17659_ _05845_ _00708_ _05846_ VSS VSS VDD VDD _05847_ sky130_fd_sc_hd__a21oi_1
X_17660_ _05845_ _00708_ network.in_period\[144\]\[3\] _05847_
+ VSS VSS VDD VDD _05848_ sky130_fd_sc_hd__a31oi_1
Xoutput46 net45 VSS VSS VDD VDD no_spike sky130_fd_sc_hd__buf_1
X_17662_ network.neuron_in144.counter\[0\] network.neuron_in144.counter\[2\]
+ network.neuron_in144.counter\[1\] network.neuron_in144.counter\[3\]
+ net358 VSS VSS VDD VDD _05850_ sky130_fd_sc_hd__o311a_1
X_17663_ network.in_period\[144\]\[3\] net417 _05850_ VSS
+ VSS VDD VDD _05851_ sky130_fd_sc_hd__a21oi_1
X_17664_ network.neuron_in144.counter\[3\] _05848_ _05851_
+ VSS VSS VDD VDD _02642_ sky130_fd_sc_hd__o21ai_0
X_17665_ network.neuron_in145.counter\[1\] network.neuron_in145.counter\[0\]
+ VSS VSS VDD VDD _05852_ sky130_fd_sc_hd__nor2_1
X_17666_ _00698_ _05852_ VSS VSS VDD VDD _05853_ sky130_fd_sc_hd__nor2_1
X_17667_ network.neuron_in145.counter\[2\] _05853_ VSS VSS
+ VDD VDD _05854_ sky130_fd_sc_hd__nor2_1
X_17668_ network.neuron_in145.counter\[2\] network.neuron_in145.counter\[3\]
+ _05852_ VSS VSS VDD VDD _05855_ sky130_fd_sc_hd__nand3b_1
X_17669_ network.neuron_in145.counter\[3\] _05854_ _05855_
+ VSS VSS VDD VDD _05856_ sky130_fd_sc_hd__o21ai_0
X_17670_ network.neuron_in145.counter\[3\] _00698_ VSS VSS
+ VDD VDD _05857_ sky130_fd_sc_hd__nand2b_1
X_17671_ net346 _05857_ network.in_period\[145\]\[3\] VSS
+ VSS VDD VDD _05858_ sky130_fd_sc_hd__a21oi_1
X_17672_ net346 _05856_ _05858_ VSS VSS VDD VDD _02646_ sky130_fd_sc_hd__a21oi_1
Xoutput45 net44 VSS VSS VDD VDD load_ready sky130_fd_sc_hd__buf_1
X_17674_ net357 _04883_ VSS VSS VDD VDD _05860_ sky130_fd_sc_hd__nand2_1
X_17675_ network.in_period\[98\]\[1\] _05860_ VSS VSS VDD
+ VDD _05861_ sky130_fd_sc_hd__nand2_1
X_17676_ _00782_ _05860_ _05861_ VSS VSS VDD VDD _02456_ sky130_fd_sc_hd__o21ai_0
X_17677_ network.in_spk08_09 _09413_ VSS VSS VDD VDD _05862_
+ sky130_fd_sc_hd__nand2_1
X_17678_ _04794_ _05862_ net412 VSS VSS VDD VDD _02008_ sky130_fd_sc_hd__a21oi_1
X_17679_ network.neuron_in146.counter\[0\] network.neuron_in146.counter\[1\]
+ _00347_ VSS VSS VDD VDD _05863_ sky130_fd_sc_hd__o21bai_1
X_17680_ _06962_ _05863_ network.neuron_in146.counter\[3\]
+ VSS VSS VDD VDD _05864_ sky130_fd_sc_hd__a21oi_1
X_17681_ _06962_ _00345_ _00346_ network.neuron_in146.counter\[3\]
+ _05864_ VSS VSS VDD VDD _05865_ sky130_fd_sc_hd__a41o_1
X_17682_ net345 _06961_ network.in_period\[146\]\[3\] VSS
+ VSS VDD VDD _05866_ sky130_fd_sc_hd__a21oi_1
X_17683_ net345 _05865_ _05866_ VSS VSS VDD VDD _02650_ sky130_fd_sc_hd__a21oi_1
X_17684_ network.neuron_in100.counter\[3\] network.in_period\[100\]\[2\]
+ net414 _00874_ VSS VSS VDD VDD _05867_ sky130_fd_sc_hd__o22ai_1
X_17685_ network.neuron_in100.counter\[2\] _00874_ net357
+ VSS VSS VDD VDD _05868_ sky130_fd_sc_hd__nand3_1
X_17686_ network.in_period\[100\]\[2\] net357 _05868_ VSS
+ VSS VDD VDD _05869_ sky130_fd_sc_hd__o21ai_0
X_17687_ _04876_ _05867_ _05869_ VSS VSS VDD VDD _02465_ sky130_fd_sc_hd__a21oi_1
X_17688_ network.neuron_in147.counter\[1\] network.neuron_in147.counter\[0\]
+ _01196_ VSS VSS VDD VDD _05870_ sky130_fd_sc_hd__o21bai_1
X_17689_ _03881_ _05870_ network.neuron_in147.counter\[3\]
+ VSS VSS VDD VDD _05871_ sky130_fd_sc_hd__a21oi_1
X_17690_ _03881_ _01195_ _01194_ network.neuron_in147.counter\[3\]
+ _05871_ VSS VSS VDD VDD _05872_ sky130_fd_sc_hd__a41o_1
Xoutput44 net326 VSS VSS VDD VDD input_complete sky130_fd_sc_hd__buf_1
X_17692_ net346 _03880_ network.in_period\[147\]\[3\] VSS
+ VSS VDD VDD _05874_ sky130_fd_sc_hd__a21oi_1
X_17693_ net346 _05872_ _05874_ VSS VSS VDD VDD _02654_ sky130_fd_sc_hd__a21oi_1
X_17694_ _09369_ _09280_ _09349_ VSS VSS VDD VDD _05875_ sky130_fd_sc_hd__nand3_1
X_17695_ net368 _03368_ VSS VSS VDD VDD _05876_ sky130_fd_sc_hd__nand2_1
X_17696_ _05875_ _05876_ network.in_spk07_09 VSS VSS VDD VDD
+ _05877_ sky130_fd_sc_hd__o21ai_0
X_17697_ _04796_ _05877_ net417 VSS VSS VDD VDD _02009_ sky130_fd_sc_hd__a21oi_1
X_17698_ network.neuron_in148.counter\[0\] network.neuron_in148.counter\[1\]
+ network.neuron_in148.counter\[2\] net417 VSS VSS VDD VDD _05878_
+ sky130_fd_sc_hd__nor4_1
X_17699_ network.in_period\[148\]\[3\] _05878_ _07010_ VSS
+ VSS VDD VDD _05879_ sky130_fd_sc_hd__mux2i_1
X_17700_ network.neuron_in148.counter\[0\] network.neuron_in148.counter\[1\]
+ network.neuron_in148.counter\[2\] network.neuron_in148.counter\[3\]
+ net346 VSS VSS VDD VDD _05880_ sky130_fd_sc_hd__o311a_1
X_17701_ network.in_period\[148\]\[3\] net417 _05880_ VSS
+ VSS VDD VDD _05881_ sky130_fd_sc_hd__a21oi_1
X_17702_ network.neuron_in148.counter\[3\] _05879_ _05881_
+ VSS VSS VDD VDD _02658_ sky130_fd_sc_hd__o21ai_0
X_17703_ network.neuron_in097.counter\[0\] VSS VSS VDD VDD
+ _00076_ sky130_fd_sc_hd__inv_1
X_17704_ net357 _04584_ VSS VSS VDD VDD _05882_ sky130_fd_sc_hd__nand2_1
X_17705_ network.in_period\[97\]\[0\] _05882_ VSS VSS VDD
+ VDD _05883_ sky130_fd_sc_hd__nand2_1
X_17706_ network.neuron_in097.counter\[0\] _05882_ _05883_
+ VSS VSS VDD VDD _02451_ sky130_fd_sc_hd__o21ai_0
X_17707_ network.neuron_in149.counter\[1\] network.neuron_in149.counter\[0\]
+ network.neuron_in149.counter\[2\] VSS VSS VDD VDD _05884_
+ sky130_fd_sc_hd__nor3_1
X_17708_ network.neuron_in149.counter\[3\] _05884_ VSS VSS
+ VDD VDD _05885_ sky130_fd_sc_hd__xnor2_1
X_17709_ network.in_period\[149\]\[3\] _04392_ VSS VSS VDD
+ VDD _05886_ sky130_fd_sc_hd__nand2_1
X_17710_ _04392_ _05885_ _05886_ VSS VSS VDD VDD _02662_ sky130_fd_sc_hd__o21ai_0
X_17711_ net357 _04880_ VSS VSS VDD VDD _05887_ sky130_fd_sc_hd__nand2_1
X_17712_ network.in_period\[99\]\[0\] _05887_ VSS VSS VDD
+ VDD _05888_ sky130_fd_sc_hd__nand2_1
X_17713_ network.neuron_in099.counter\[0\] _05887_ _05888_
+ VSS VSS VDD VDD _02459_ sky130_fd_sc_hd__o21ai_0
X_17714_ net368 _09370_ VSS VSS VDD VDD _05889_ sky130_fd_sc_hd__nand2_1
X_17715_ _09609_ _05889_ network.in_spk06_09 VSS VSS VDD VDD
+ _05890_ sky130_fd_sc_hd__o21ai_0
X_17716_ _08363_ _05890_ net417 VSS VSS VDD VDD _02010_ sky130_fd_sc_hd__a21oi_1
X_17717_ network.neuron_in150.counter\[0\] network.neuron_in150.counter\[1\]
+ network.neuron_in150.counter\[2\] VSS VSS VDD VDD _05891_
+ sky130_fd_sc_hd__nor3_1
X_17718_ network.neuron_in150.counter\[3\] _05891_ VSS VSS
+ VDD VDD _05892_ sky130_fd_sc_hd__xnor2_1
X_17719_ network.in_period\[150\]\[3\] _08364_ VSS VSS VDD
+ VDD _05893_ sky130_fd_sc_hd__nand2_1
X_17720_ _08364_ _05892_ _05893_ VSS VSS VDD VDD _02666_ sky130_fd_sc_hd__o21ai_0
X_17721_ net358 _04796_ VSS VSS VDD VDD _05894_ sky130_fd_sc_hd__nand2_1
X_17722_ network.neuron_in151.counter\[1\] network.neuron_in151.counter\[0\]
+ network.neuron_in151.counter\[2\] VSS VSS VDD VDD _05895_
+ sky130_fd_sc_hd__nor3_1
X_17723_ network.neuron_in151.counter\[3\] _05895_ VSS VSS
+ VDD VDD _05896_ sky130_fd_sc_hd__xnor2_1
X_17724_ network.in_period\[151\]\[3\] _05894_ VSS VSS VDD
+ VDD _05897_ sky130_fd_sc_hd__nand2_1
X_17725_ _05894_ _05896_ _05897_ VSS VSS VDD VDD _02670_ sky130_fd_sc_hd__o21ai_0
X_17726_ network.in_spk04_09 _05889_ network.in_spk05_09 VSS
+ VSS VDD VDD _05898_ sky130_fd_sc_hd__o21ai_0
X_17727_ _04391_ _05898_ net417 VSS VSS VDD VDD _02011_ sky130_fd_sc_hd__a21oi_1
X_17728_ network.neuron_in098.counter\[3\] network.in_period\[98\]\[2\]
+ net414 _00781_ VSS VSS VDD VDD _05899_ sky130_fd_sc_hd__o22ai_1
X_17729_ network.neuron_in098.counter\[2\] _00781_ net357
+ VSS VSS VDD VDD _05900_ sky130_fd_sc_hd__nand3_1
X_17730_ network.in_period\[98\]\[2\] net357 _05900_ VSS VSS
+ VDD VDD _05901_ sky130_fd_sc_hd__o21ai_0
X_17731_ _04882_ _05899_ _05901_ VSS VSS VDD VDD _02457_ sky130_fd_sc_hd__a21oi_1
X_17732_ network.neuron_in152.counter\[0\] network.neuron_in152.counter\[1\]
+ network.neuron_in152.counter\[2\] net412 VSS VSS VDD VDD _05902_
+ sky130_fd_sc_hd__nor4_1
X_17733_ network.in_period\[152\]\[3\] _05902_ _04793_ VSS
+ VSS VDD VDD _05903_ sky130_fd_sc_hd__mux2i_1
Xoutput43 net42 VSS VSS VDD VDD inference_cycles[9] sky130_fd_sc_hd__buf_1
X_17735_ network.neuron_in152.counter\[0\] network.neuron_in152.counter\[1\]
+ network.neuron_in152.counter\[2\] network.neuron_in152.counter\[3\]
+ net356 VSS VSS VDD VDD _05905_ sky130_fd_sc_hd__o311a_1
X_17736_ network.in_period\[152\]\[3\] net412 _05905_ VSS
+ VSS VDD VDD _05906_ sky130_fd_sc_hd__a21oi_1
X_17737_ network.neuron_in152.counter\[3\] _05903_ _05906_
+ VSS VSS VDD VDD _02674_ sky130_fd_sc_hd__o21ai_0
X_17738_ network.neuron_in097.counter\[3\] network.in_period\[97\]\[2\]
+ _00078_ net412 VSS VSS VDD VDD _05907_ sky130_fd_sc_hd__o22ai_1
X_17739_ network.neuron_in097.counter\[2\] _00078_ net358
+ VSS VSS VDD VDD _05908_ sky130_fd_sc_hd__nand3_1
X_17740_ network.in_period\[97\]\[2\] net358 _05908_ VSS VSS
+ VDD VDD _05909_ sky130_fd_sc_hd__o21ai_0
X_17741_ _04582_ _05907_ _05909_ VSS VSS VDD VDD _02453_ sky130_fd_sc_hd__a21oi_1
X_17742_ network.in_period\[97\]\[1\] _05882_ VSS VSS VDD
+ VDD _05910_ sky130_fd_sc_hd__nand2_1
X_17743_ _00079_ _05882_ _05910_ VSS VSS VDD VDD _02452_ sky130_fd_sc_hd__o21ai_0
X_17744_ network.in_period\[98\]\[0\] _05860_ VSS VSS VDD
+ VDD _05911_ sky130_fd_sc_hd__nand2_1
X_17745_ network.neuron_in098.counter\[0\] _05860_ _05911_
+ VSS VSS VDD VDD _02455_ sky130_fd_sc_hd__o21ai_0
X_17746_ network.neuron_in153.counter\[0\] network.neuron_in153.counter\[1\]
+ _00553_ VSS VSS VDD VDD _05912_ sky130_fd_sc_hd__o21bai_1
X_17747_ _07039_ _05912_ network.neuron_in153.counter\[3\]
+ VSS VSS VDD VDD _05913_ sky130_fd_sc_hd__a21oi_1
X_17748_ _07039_ network.neuron_in153.counter\[3\] _00551_
+ _00552_ _05913_ VSS VSS VDD VDD _05914_ sky130_fd_sc_hd__a41o_1
X_17749_ net358 _07038_ network.in_period\[153\]\[3\] VSS
+ VSS VDD VDD _05915_ sky130_fd_sc_hd__a21oi_1
X_17750_ net358 _05914_ _05915_ VSS VSS VDD VDD _02678_ sky130_fd_sc_hd__a21oi_1
X_17751_ network.neuron_in099.counter\[3\] network.in_period\[99\]\[2\]
+ net414 _00748_ VSS VSS VDD VDD _05916_ sky130_fd_sc_hd__o22ai_1
Xoutput42 net41 VSS VSS VDD VDD inference_cycles[8] sky130_fd_sc_hd__buf_1
X_17753_ network.neuron_in099.counter\[2\] _00748_ net357
+ VSS VSS VDD VDD _05918_ sky130_fd_sc_hd__nand3_1
X_17754_ network.in_period\[99\]\[2\] net357 _05918_ VSS VSS
+ VDD VDD _05919_ sky130_fd_sc_hd__o21ai_0
X_17755_ _04879_ _05916_ _05919_ VSS VSS VDD VDD _02461_ sky130_fd_sc_hd__a21oi_1
X_17756_ network.in_spk04_09 _05889_ VSS VSS VDD VDD _05920_
+ sky130_fd_sc_hd__nand2_1
X_17757_ _07011_ _05920_ net417 VSS VSS VDD VDD _02012_ sky130_fd_sc_hd__a21oi_1
X_17758_ network.in_period\[99\]\[1\] _05887_ VSS VSS VDD
+ VDD _05921_ sky130_fd_sc_hd__nand2_1
X_17759_ _00749_ _05887_ _05921_ VSS VSS VDD VDD _02460_ sky130_fd_sc_hd__o21ai_0
X_17760_ network.neuron_in154.counter\[0\] network.neuron_in154.counter\[2\]
+ network.neuron_in154.counter\[1\] VSS VSS VDD VDD _05922_
+ sky130_fd_sc_hd__nor3_1
X_17761_ network.neuron_in154.counter\[3\] _05922_ VSS VSS
+ VDD VDD _05923_ sky130_fd_sc_hd__xnor2_1
X_17762_ network.in_period\[154\]\[3\] _07052_ VSS VSS VDD
+ VDD _05924_ sky130_fd_sc_hd__nand2_1
X_17763_ _07052_ _05923_ _05924_ VSS VSS VDD VDD _02682_ sky130_fd_sc_hd__o21ai_0
X_17764_ network.in_period\[100\]\[0\] _05842_ VSS VSS VDD
+ VDD _05925_ sky130_fd_sc_hd__nand2_1
X_17765_ network.neuron_in100.counter\[0\] _05842_ _05925_
+ VSS VSS VDD VDD _02463_ sky130_fd_sc_hd__o21ai_0
X_17766_ network.neuron_in101.counter\[2\] VSS VSS VDD VDD
+ _05926_ sky130_fd_sc_hd__inv_1
X_17767_ network.neuron_in101.counter\[3\] network.in_period\[101\]\[2\]
+ net414 _01176_ VSS VSS VDD VDD _05927_ sky130_fd_sc_hd__o22ai_1
X_17768_ network.neuron_in101.counter\[2\] _01176_ net345
+ VSS VSS VDD VDD _05928_ sky130_fd_sc_hd__nand3_1
X_17769_ network.in_period\[101\]\[2\] net345 _05928_ VSS
+ VSS VDD VDD _05929_ sky130_fd_sc_hd__o21ai_0
X_17770_ _05926_ _05927_ _05929_ VSS VSS VDD VDD _02469_ sky130_fd_sc_hd__a21oi_1
X_17771_ network.neuron_in155.counter\[1\] network.neuron_in155.counter\[0\]
+ _01118_ VSS VSS VDD VDD _05930_ sky130_fd_sc_hd__o21bai_1
X_17772_ _06834_ _05930_ network.neuron_in155.counter\[3\]
+ VSS VSS VDD VDD _05931_ sky130_fd_sc_hd__a21oi_1
X_17773_ _06834_ network.neuron_in155.counter\[3\] _01117_
+ _01116_ _05931_ VSS VSS VDD VDD _05932_ sky130_fd_sc_hd__a41o_1
X_17774_ net358 _06833_ network.in_period\[155\]\[3\] VSS
+ VSS VDD VDD _05933_ sky130_fd_sc_hd__a21oi_1
X_17775_ net355 _05932_ _05933_ VSS VSS VDD VDD _02686_ sky130_fd_sc_hd__a21oi_1
X_17776_ network.in_period\[101\]\[1\] _05616_ VSS VSS VDD
+ VDD _05934_ sky130_fd_sc_hd__nand2_1
X_17777_ _01177_ _05616_ _05934_ VSS VSS VDD VDD _02468_ sky130_fd_sc_hd__o21ai_0
X_17778_ network.in_period\[101\]\[0\] _05616_ VSS VSS VDD
+ VDD _05935_ sky130_fd_sc_hd__nand2_1
X_17779_ network.neuron_in101.counter\[0\] _05616_ _05935_
+ VSS VSS VDD VDD _02467_ sky130_fd_sc_hd__o21ai_0
X_17780_ network.in_spk00_09 network.in_spk01_09 _05875_ VSS
+ VSS VDD VDD _05936_ sky130_fd_sc_hd__or3_1
X_17781_ network.in_spk02_09 _05936_ network.in_spk03_09 VSS
+ VSS VDD VDD _05937_ sky130_fd_sc_hd__o21ai_1
Xoutput41 net40 VSS VSS VDD VDD inference_cycles[7] sky130_fd_sc_hd__buf_1
X_17783_ _03882_ _05937_ net417 VSS VSS VDD VDD _02013_ sky130_fd_sc_hd__a21oi_1
X_17784_ network.neuron_in156.counter\[1\] network.neuron_in156.counter\[0\]
+ network.neuron_in156.counter\[2\] net420 VSS VSS VDD VDD _05939_
+ sky130_fd_sc_hd__nor4_1
X_17785_ network.in_period\[156\]\[3\] _05939_ _03905_ VSS
+ VSS VDD VDD _05940_ sky130_fd_sc_hd__mux2i_1
X_17786_ network.neuron_in156.counter\[1\] network.neuron_in156.counter\[0\]
+ network.neuron_in156.counter\[2\] network.neuron_in156.counter\[3\]
+ net354 VSS VSS VDD VDD _05941_ sky130_fd_sc_hd__o311a_1
X_17787_ network.in_period\[156\]\[3\] net420 _05941_ VSS
+ VSS VDD VDD _05942_ sky130_fd_sc_hd__a21oi_1
X_17788_ network.neuron_in156.counter\[3\] _05940_ _05942_
+ VSS VSS VDD VDD _02690_ sky130_fd_sc_hd__o21ai_0
X_17789_ network.neuron_in102.counter\[3\] network.in_period\[102\]\[2\]
+ net414 _00215_ VSS VSS VDD VDD _05943_ sky130_fd_sc_hd__o22ai_1
Xoutput40 net39 VSS VSS VDD VDD inference_cycles[6] sky130_fd_sc_hd__buf_1
X_17791_ network.neuron_in102.counter\[2\] _00215_ net345
+ VSS VSS VDD VDD _05945_ sky130_fd_sc_hd__nand3_1
X_17792_ network.in_period\[102\]\[2\] net345 _05945_ VSS
+ VSS VDD VDD _05946_ sky130_fd_sc_hd__o21ai_0
X_17793_ _04871_ _05943_ _05946_ VSS VSS VDD VDD _02473_ sky130_fd_sc_hd__a21oi_1
X_17794_ network.neuron_in157.counter\[0\] network.neuron_in157.counter\[1\]
+ _00736_ VSS VSS VDD VDD _05947_ sky130_fd_sc_hd__o21bai_1
X_17795_ _07241_ _05947_ network.neuron_in157.counter\[3\]
+ VSS VSS VDD VDD _05948_ sky130_fd_sc_hd__a21oi_1
X_17796_ _07241_ network.neuron_in157.counter\[3\] _00734_
+ _00735_ _05948_ VSS VSS VDD VDD _05949_ sky130_fd_sc_hd__a41o_1
X_17797_ net354 _07240_ network.in_period\[157\]\[3\] VSS
+ VSS VDD VDD _05950_ sky130_fd_sc_hd__a21oi_1
X_17798_ net354 _05949_ _05950_ VSS VSS VDD VDD _02694_ sky130_fd_sc_hd__a21oi_1
X_17799_ network.in_period\[102\]\[1\] _05836_ VSS VSS VDD
+ VDD _05951_ sky130_fd_sc_hd__nand2_1
X_17800_ _00216_ _05836_ _05951_ VSS VSS VDD VDD _02472_ sky130_fd_sc_hd__o21ai_0
X_17801_ network.in_spk02_09 _05936_ VSS VSS VDD VDD _05952_
+ sky130_fd_sc_hd__nand2_1
X_17802_ _06963_ _05952_ net417 VSS VSS VDD VDD _02014_ sky130_fd_sc_hd__a21oi_1
X_17803_ network.neuron_in158.counter\[0\] VSS VSS VDD VDD
+ _00710_ sky130_fd_sc_hd__inv_1
X_17804_ network.neuron_in158.counter\[0\] network.neuron_in158.counter\[1\]
+ _00712_ VSS VSS VDD VDD _05953_ sky130_fd_sc_hd__o21bai_1
X_17805_ _04789_ _05953_ network.neuron_in158.counter\[3\]
+ VSS VSS VDD VDD _05954_ sky130_fd_sc_hd__a21oi_1
X_17806_ _04789_ network.neuron_in158.counter\[3\] _00710_
+ _00711_ _05954_ VSS VSS VDD VDD _05955_ sky130_fd_sc_hd__a41o_1
X_17807_ net355 _04788_ network.in_period\[158\]\[3\] VSS
+ VSS VDD VDD _05956_ sky130_fd_sc_hd__a21oi_1
X_17808_ net355 _05955_ _05956_ VSS VSS VDD VDD _02698_ sky130_fd_sc_hd__a21oi_1
X_17809_ net357 _04862_ VSS VSS VDD VDD _05957_ sky130_fd_sc_hd__nand2_1
X_17810_ network.in_period\[105\]\[0\] _05957_ VSS VSS VDD
+ VDD _05958_ sky130_fd_sc_hd__nand2_1
X_17811_ network.neuron_in105.counter\[0\] _05957_ _05958_
+ VSS VSS VDD VDD _02483_ sky130_fd_sc_hd__o21ai_0
X_17812_ network.neuron_in159.counter\[1\] network.neuron_in159.counter\[0\]
+ network.neuron_in159.counter\[2\] net413 VSS VSS VDD VDD _05959_
+ sky130_fd_sc_hd__nor4_1
X_17813_ network.in_period\[159\]\[3\] _05959_ _06664_ VSS
+ VSS VDD VDD _05960_ sky130_fd_sc_hd__mux2i_1
X_17814_ network.neuron_in159.counter\[1\] network.neuron_in159.counter\[0\]
+ network.neuron_in159.counter\[2\] network.neuron_in159.counter\[3\]
+ net358 VSS VSS VDD VDD _05961_ sky130_fd_sc_hd__o311a_1
X_17815_ network.in_period\[159\]\[3\] net412 _05961_ VSS
+ VSS VDD VDD _05962_ sky130_fd_sc_hd__a21oi_1
X_17816_ network.neuron_in159.counter\[3\] _05960_ _05962_
+ VSS VSS VDD VDD _02702_ sky130_fd_sc_hd__o21ai_0
X_17817_ network.in_spk00_09 _05875_ network.in_spk01_09 VSS
+ VSS VDD VDD _05963_ sky130_fd_sc_hd__o21ai_0
X_17818_ _06899_ _05963_ net417 VSS VSS VDD VDD _02015_ sky130_fd_sc_hd__a21oi_1
X_17819_ network.neuron_in160.counter\[1\] network.neuron_in160.counter\[0\]
+ VSS VSS VDD VDD _05964_ sky130_fd_sc_hd__nor2_1
X_17820_ _01102_ _05964_ VSS VSS VDD VDD _05965_ sky130_fd_sc_hd__nor2_1
X_17821_ network.neuron_in160.counter\[2\] _05965_ VSS VSS
+ VDD VDD _05966_ sky130_fd_sc_hd__nor2_1
X_17822_ network.neuron_in160.counter\[2\] network.neuron_in160.counter\[3\]
+ _05964_ VSS VSS VDD VDD _05967_ sky130_fd_sc_hd__nand3b_1
X_17823_ network.neuron_in160.counter\[3\] _05966_ _05967_
+ VSS VSS VDD VDD _05968_ sky130_fd_sc_hd__o21ai_0
X_17824_ net361 _06680_ network.in_period\[160\]\[3\] VSS
+ VSS VDD VDD _05969_ sky130_fd_sc_hd__a21oi_1
X_17825_ net361 _05968_ _05969_ VSS VSS VDD VDD _02706_ sky130_fd_sc_hd__a21oi_1
Xoutput39 net38 VSS VSS VDD VDD inference_cycles[5] sky130_fd_sc_hd__buf_1
X_17827_ network.neuron_in104.counter\[3\] network.in_period\[104\]\[2\]
+ net411 _00936_ VSS VSS VDD VDD _05971_ sky130_fd_sc_hd__o22ai_1
X_17828_ network.neuron_in104.counter\[2\] _00936_ net356
+ VSS VSS VDD VDD _05972_ sky130_fd_sc_hd__nand3_1
X_17829_ network.in_period\[104\]\[2\] net356 _05972_ VSS
+ VSS VDD VDD _05973_ sky130_fd_sc_hd__o21ai_0
X_17830_ _04864_ _05971_ _05973_ VSS VSS VDD VDD _02481_ sky130_fd_sc_hd__a21oi_1
X_17831_ network.neuron_in161.counter\[0\] network.neuron_in161.counter\[1\]
+ _00799_ VSS VSS VDD VDD _05974_ sky130_fd_sc_hd__o21bai_1
X_17832_ _06685_ _05974_ network.neuron_in161.counter\[3\]
+ VSS VSS VDD VDD _05975_ sky130_fd_sc_hd__a21oi_1
X_17833_ _06685_ network.neuron_in161.counter\[3\] _00797_
+ _00798_ _05975_ VSS VSS VDD VDD _05976_ sky130_fd_sc_hd__a41o_1
X_17834_ net346 _06684_ network.in_period\[161\]\[3\] VSS
+ VSS VDD VDD _05977_ sky130_fd_sc_hd__a21oi_1
X_17835_ net346 _05976_ _05977_ VSS VSS VDD VDD _02710_ sky130_fd_sc_hd__a21oi_1
X_17836_ network.in_spk00_09 _05875_ VSS VSS VDD VDD _05978_
+ sky130_fd_sc_hd__nand2_1
X_17837_ _06999_ _05978_ net417 VSS VSS VDD VDD _02016_ sky130_fd_sc_hd__a21oi_1
Xoutput38 net37 VSS VSS VDD VDD inference_cycles[4] sky130_fd_sc_hd__buf_1
X_17839_ network.neuron_in162.counter\[0\] network.neuron_in162.counter\[1\]
+ VSS VSS VDD VDD _05980_ sky130_fd_sc_hd__nor2_1
X_17840_ _00803_ _05980_ VSS VSS VDD VDD _05981_ sky130_fd_sc_hd__nor2_1
X_17841_ network.neuron_in162.counter\[2\] _05981_ VSS VSS
+ VDD VDD _05982_ sky130_fd_sc_hd__nor2_1
X_17842_ network.neuron_in162.counter\[2\] network.neuron_in162.counter\[3\]
+ _05980_ VSS VSS VDD VDD _05983_ sky130_fd_sc_hd__nand3b_1
X_17843_ network.neuron_in162.counter\[3\] _05982_ _05983_
+ VSS VSS VDD VDD _05984_ sky130_fd_sc_hd__o21ai_0
X_17844_ net361 _06690_ network.in_period\[162\]\[3\] VSS
+ VSS VDD VDD _05985_ sky130_fd_sc_hd__a21oi_1
X_17845_ net361 _05984_ _05985_ VSS VSS VDD VDD _02714_ sky130_fd_sc_hd__a21oi_1
X_17846_ net356 _04856_ VSS VSS VDD VDD _05986_ sky130_fd_sc_hd__nand2_1
X_17847_ network.in_period\[107\]\[1\] _05986_ VSS VSS VDD
+ VDD _05987_ sky130_fd_sc_hd__nand2_1
X_17848_ _00606_ _05986_ _05987_ VSS VSS VDD VDD _02492_ sky130_fd_sc_hd__o21ai_0
X_17849_ network.neuron_in163.counter\[0\] network.neuron_in163.counter\[1\]
+ VSS VSS VDD VDD _05988_ sky130_fd_sc_hd__nor2_1
X_17850_ _00829_ _05988_ VSS VSS VDD VDD _05989_ sky130_fd_sc_hd__nor2_1
X_17851_ network.neuron_in163.counter\[2\] _05989_ VSS VSS
+ VDD VDD _05990_ sky130_fd_sc_hd__nor2_1
X_17852_ network.neuron_in163.counter\[2\] network.neuron_in163.counter\[3\]
+ _05988_ VSS VSS VDD VDD _05991_ sky130_fd_sc_hd__nand3b_1
X_17853_ network.neuron_in163.counter\[3\] _05990_ _05991_
+ VSS VSS VDD VDD _05992_ sky130_fd_sc_hd__o21ai_0
X_17854_ net363 _03823_ network.in_period\[163\]\[3\] VSS
+ VSS VDD VDD _05993_ sky130_fd_sc_hd__a21oi_1
X_17855_ net363 _05992_ _05993_ VSS VSS VDD VDD _02718_ sky130_fd_sc_hd__a21oi_1
X_17856_ net356 _04869_ VSS VSS VDD VDD _05994_ sky130_fd_sc_hd__nand2_1
X_17857_ network.in_period\[103\]\[0\] _05994_ VSS VSS VDD
+ VDD _05995_ sky130_fd_sc_hd__nand2_1
X_17858_ network.neuron_in103.counter\[0\] _05994_ _05995_
+ VSS VSS VDD VDD _02475_ sky130_fd_sc_hd__o21ai_0
X_17859_ _09471_ _09472_ VSS VSS VDD VDD _05996_ sky130_fd_sc_hd__or2_1
X_17860_ network.in_spk12_08 network.in_spk13_08 _05996_ VSS
+ VSS VDD VDD _05997_ sky130_fd_sc_hd__or3_1
X_17861_ network.in_spk14_08 _05997_ network.in_spk15_08 VSS
+ VSS VDD VDD _05998_ sky130_fd_sc_hd__o21ai_1
X_17862_ _07003_ _05998_ net421 VSS VSS VDD VDD _02017_ sky130_fd_sc_hd__a21oi_1
X_17863_ network.neuron_in164.counter\[0\] network.neuron_in164.counter\[1\]
+ _00862_ VSS VSS VDD VDD _05999_ sky130_fd_sc_hd__o21bai_1
X_17864_ _03832_ _05999_ network.neuron_in164.counter\[3\]
+ VSS VSS VDD VDD _06000_ sky130_fd_sc_hd__a21oi_1
X_17865_ _03832_ network.neuron_in164.counter\[3\] _00860_
+ _00861_ _06000_ VSS VSS VDD VDD _06001_ sky130_fd_sc_hd__a41o_1
X_17866_ net346 _03837_ network.in_period\[164\]\[3\] VSS
+ VSS VDD VDD _06002_ sky130_fd_sc_hd__a21oi_1
X_17867_ net346 _06001_ _06002_ VSS VSS VDD VDD _02722_ sky130_fd_sc_hd__a21oi_1
X_17868_ network.neuron_in165.counter\[0\] network.neuron_in165.counter\[2\]
+ network.neuron_in165.counter\[1\] VSS VSS VDD VDD _06003_
+ sky130_fd_sc_hd__nor3_1
X_17869_ network.neuron_in165.counter\[3\] _06003_ VSS VSS
+ VDD VDD _06004_ sky130_fd_sc_hd__xnor2_1
X_17870_ network.in_period\[165\]\[3\] _03848_ VSS VSS VDD
+ VDD _06005_ sky130_fd_sc_hd__nand2_1
X_17871_ _03848_ _06004_ _06005_ VSS VSS VDD VDD _02726_ sky130_fd_sc_hd__o21ai_0
X_17872_ net356 _04859_ VSS VSS VDD VDD _06006_ sky130_fd_sc_hd__nand2_1
X_17873_ network.in_period\[106\]\[0\] _06006_ VSS VSS VDD
+ VDD _06007_ sky130_fd_sc_hd__nand2_1
X_17874_ network.neuron_in106.counter\[0\] _06006_ _06007_
+ VSS VSS VDD VDD _02487_ sky130_fd_sc_hd__o21ai_0
X_17875_ network.in_spk14_08 _05997_ VSS VSS VDD VDD _06008_
+ sky130_fd_sc_hd__nand2_1
X_17876_ _07047_ _06008_ net421 VSS VSS VDD VDD _02018_ sky130_fd_sc_hd__a21oi_1
X_17877_ network.neuron_in166.counter\[0\] network.neuron_in166.counter\[1\]
+ _00898_ VSS VSS VDD VDD _06009_ sky130_fd_sc_hd__o21bai_1
X_17878_ _03852_ _06009_ network.neuron_in166.counter\[3\]
+ VSS VSS VDD VDD _06010_ sky130_fd_sc_hd__a21oi_1
X_17879_ _03852_ network.neuron_in166.counter\[3\] _00896_
+ _00897_ _06010_ VSS VSS VDD VDD _06011_ sky130_fd_sc_hd__a41o_1
Xoutput37 net36 VSS VSS VDD VDD inference_cycles[3] sky130_fd_sc_hd__buf_1
X_17881_ net361 _03858_ network.in_period\[166\]\[3\] VSS
+ VSS VDD VDD _06013_ sky130_fd_sc_hd__a21oi_1
X_17882_ net361 _06011_ _06013_ VSS VSS VDD VDD _02730_ sky130_fd_sc_hd__a21oi_1
X_17883_ network.neuron_in107.counter\[3\] network.in_period\[107\]\[2\]
+ net411 _00605_ VSS VSS VDD VDD _06014_ sky130_fd_sc_hd__o22ai_1
X_17884_ network.neuron_in107.counter\[2\] _00605_ net356
+ VSS VSS VDD VDD _06015_ sky130_fd_sc_hd__nand3_1
X_17885_ network.in_period\[107\]\[2\] net356 _06015_ VSS
+ VSS VDD VDD _06016_ sky130_fd_sc_hd__o21ai_0
X_17886_ _04855_ _06014_ _06016_ VSS VSS VDD VDD _02493_ sky130_fd_sc_hd__a21oi_1
X_17887_ network.neuron_in167.counter\[1\] network.neuron_in167.counter\[0\]
+ VSS VSS VDD VDD _06017_ sky130_fd_sc_hd__nor2_1
X_17888_ _00920_ _06017_ VSS VSS VDD VDD _06018_ sky130_fd_sc_hd__nor2_1
X_17889_ network.neuron_in167.counter\[2\] _06018_ VSS VSS
+ VDD VDD _06019_ sky130_fd_sc_hd__nor2_1
X_17890_ network.neuron_in167.counter\[2\] network.neuron_in167.counter\[3\]
+ _06017_ VSS VSS VDD VDD _06020_ sky130_fd_sc_hd__nand3b_1
X_17891_ network.neuron_in167.counter\[3\] _06019_ _06020_
+ VSS VSS VDD VDD _06021_ sky130_fd_sc_hd__o21ai_0
X_17892_ net346 _07850_ network.in_period\[167\]\[3\] VSS
+ VSS VDD VDD _06022_ sky130_fd_sc_hd__a21oi_1
X_17893_ net346 _06021_ _06022_ VSS VSS VDD VDD _02734_ sky130_fd_sc_hd__a21oi_1
X_17894_ network.in_spk12_08 _05996_ network.in_spk13_08 VSS
+ VSS VDD VDD _06023_ sky130_fd_sc_hd__o21ai_0
X_17895_ _07155_ _06023_ net421 VSS VSS VDD VDD _02019_ sky130_fd_sc_hd__a21oi_1
X_17896_ network.neuron_in168.counter\[1\] network.neuron_in168.counter\[0\]
+ _00948_ VSS VSS VDD VDD _06024_ sky130_fd_sc_hd__o21bai_1
X_17897_ _07819_ _06024_ network.neuron_in168.counter\[3\]
+ VSS VSS VDD VDD _06025_ sky130_fd_sc_hd__a21oi_1
X_17898_ _07819_ network.neuron_in168.counter\[3\] _00947_
+ _00946_ _06025_ VSS VSS VDD VDD _06026_ sky130_fd_sc_hd__a41o_1
X_17899_ net346 _07818_ network.in_period\[168\]\[3\] VSS
+ VSS VDD VDD _06027_ sky130_fd_sc_hd__a21oi_1
X_17900_ net346 _06026_ _06027_ VSS VSS VDD VDD _02738_ sky130_fd_sc_hd__a21oi_1
X_17901_ network.neuron_in169.counter\[1\] network.neuron_in169.counter\[0\]
+ _00984_ VSS VSS VDD VDD _06028_ sky130_fd_sc_hd__o21bai_1
X_17902_ _07801_ _06028_ network.neuron_in169.counter\[3\]
+ VSS VSS VDD VDD _06029_ sky130_fd_sc_hd__a21oi_1
X_17903_ _07801_ network.neuron_in169.counter\[3\] _00983_
+ _00982_ _06029_ VSS VSS VDD VDD _06030_ sky130_fd_sc_hd__a41o_1
X_17904_ net346 _07800_ network.in_period\[169\]\[3\] VSS
+ VSS VDD VDD _06031_ sky130_fd_sc_hd__a21oi_1
X_17905_ net346 _06030_ _06031_ VSS VSS VDD VDD _02742_ sky130_fd_sc_hd__a21oi_1
X_17906_ network.in_spk12_08 _05996_ VSS VSS VDD VDD _06032_
+ sky130_fd_sc_hd__nand2_1
X_17907_ _06756_ _06032_ net421 VSS VSS VDD VDD _02020_ sky130_fd_sc_hd__a21oi_1
X_17908_ network.neuron_in170.counter\[1\] network.neuron_in170.counter\[0\]
+ network.neuron_in170.counter\[2\] VSS VSS VDD VDD _06033_
+ sky130_fd_sc_hd__nor3_1
X_17909_ network.neuron_in170.counter\[3\] _06033_ VSS VSS
+ VDD VDD _06034_ sky130_fd_sc_hd__xnor2_1
X_17910_ network.in_period\[170\]\[3\] _07826_ VSS VSS VDD
+ VDD _06035_ sky130_fd_sc_hd__nand2_1
X_17911_ _07826_ _06034_ _06035_ VSS VSS VDD VDD _02746_ sky130_fd_sc_hd__o21ai_0
X_17912_ network.neuron_in103.counter\[3\] network.in_period\[103\]\[2\]
+ net411 _00114_ VSS VSS VDD VDD _06036_ sky130_fd_sc_hd__o22ai_1
X_17913_ network.neuron_in103.counter\[2\] _00114_ net356
+ VSS VSS VDD VDD _06037_ sky130_fd_sc_hd__nand3_1
X_17914_ network.in_period\[103\]\[2\] net356 _06037_ VSS
+ VSS VDD VDD _06038_ sky130_fd_sc_hd__o21ai_0
X_17915_ _04868_ _06036_ _06038_ VSS VSS VDD VDD _02477_ sky130_fd_sc_hd__a21oi_1
X_17916_ network.neuron_in171.counter\[1\] network.neuron_in171.counter\[0\]
+ _01030_ VSS VSS VDD VDD _06039_ sky130_fd_sc_hd__o21bai_1
X_17917_ _07829_ _06039_ network.neuron_in171.counter\[3\]
+ VSS VSS VDD VDD _06040_ sky130_fd_sc_hd__a21oi_1
X_17918_ _07829_ network.neuron_in171.counter\[3\] _01029_
+ _01028_ _06040_ VSS VSS VDD VDD _06041_ sky130_fd_sc_hd__a41o_1
X_17919_ net361 _07828_ network.in_period\[171\]\[3\] VSS
+ VSS VDD VDD _06042_ sky130_fd_sc_hd__a21oi_1
X_17920_ net361 _06041_ _06042_ VSS VSS VDD VDD _02750_ sky130_fd_sc_hd__a21oi_1
X_17921_ network.in_period\[103\]\[1\] _05994_ VSS VSS VDD
+ VDD _06043_ sky130_fd_sc_hd__nand2_1
X_17922_ _00115_ _05994_ _06043_ VSS VSS VDD VDD _02476_ sky130_fd_sc_hd__o21ai_0
X_17923_ network.in_spk10_08 _09324_ _09651_ network.in_spk11_08
+ VSS VSS VDD VDD _06044_ sky130_fd_sc_hd__o31ai_1
X_17924_ _03495_ _06044_ net421 VSS VSS VDD VDD _02021_ sky130_fd_sc_hd__a21oi_1
X_17925_ network.neuron_in172.counter\[1\] network.neuron_in172.counter\[0\]
+ _01060_ VSS VSS VDD VDD _06045_ sky130_fd_sc_hd__o21bai_1
X_17926_ _07795_ _06045_ network.neuron_in172.counter\[3\]
+ VSS VSS VDD VDD _06046_ sky130_fd_sc_hd__a21oi_1
X_17927_ _07795_ network.neuron_in172.counter\[3\] _01059_
+ _01058_ _06046_ VSS VSS VDD VDD _06047_ sky130_fd_sc_hd__a41o_1
X_17928_ net364 _07794_ network.in_period\[172\]\[3\] VSS
+ VSS VDD VDD _06048_ sky130_fd_sc_hd__a21oi_1
X_17929_ net364 _06047_ _06048_ VSS VSS VDD VDD _02754_ sky130_fd_sc_hd__a21oi_1
X_17930_ net356 _04865_ VSS VSS VDD VDD _06049_ sky130_fd_sc_hd__nand2_1
X_17931_ network.in_period\[104\]\[1\] _06049_ VSS VSS VDD
+ VDD _06050_ sky130_fd_sc_hd__nand2_1
X_17932_ _00937_ _06049_ _06050_ VSS VSS VDD VDD _02480_ sky130_fd_sc_hd__o21ai_0
X_17933_ network.neuron_in173.counter\[0\] network.neuron_in173.counter\[2\]
+ network.neuron_in173.counter\[1\] VSS VSS VDD VDD _06051_
+ sky130_fd_sc_hd__nor3_1
X_17934_ network.neuron_in173.counter\[3\] _06051_ VSS VSS
+ VDD VDD _06052_ sky130_fd_sc_hd__xnor2_1
X_17935_ network.in_period\[173\]\[3\] _07835_ VSS VSS VDD
+ VDD _06053_ sky130_fd_sc_hd__nand2_1
X_17936_ _07835_ _06052_ _06053_ VSS VSS VDD VDD _02758_ sky130_fd_sc_hd__o21ai_0
X_17937_ network.in_period\[104\]\[0\] _06049_ VSS VSS VDD
+ VDD _06054_ sky130_fd_sc_hd__nand2_1
X_17938_ network.neuron_in104.counter\[0\] _06049_ _06054_
+ VSS VSS VDD VDD _02479_ sky130_fd_sc_hd__o21ai_0
X_17939_ _09324_ _09651_ network.in_spk10_08 VSS VSS VDD VDD
+ _06055_ sky130_fd_sc_hd__o21ai_0
X_17940_ _03577_ _06055_ net421 VSS VSS VDD VDD _02022_ sky130_fd_sc_hd__a21oi_1
X_17941_ network.neuron_in174.counter\[1\] network.neuron_in174.counter\[0\]
+ _00329_ VSS VSS VDD VDD _06056_ sky130_fd_sc_hd__o21bai_1
X_17942_ _07811_ _06056_ network.neuron_in174.counter\[3\]
+ VSS VSS VDD VDD _06057_ sky130_fd_sc_hd__a21oi_1
X_17943_ _07811_ network.neuron_in174.counter\[3\] _00328_
+ _00327_ _06057_ VSS VSS VDD VDD _06058_ sky130_fd_sc_hd__a41o_1
X_17944_ net363 _07810_ network.in_period\[174\]\[3\] VSS
+ VSS VDD VDD _06059_ sky130_fd_sc_hd__a21oi_1
X_17945_ net363 _06058_ _06059_ VSS VSS VDD VDD _02762_ sky130_fd_sc_hd__a21oi_1
X_17946_ network.neuron_in105.counter\[3\] network.in_period\[105\]\[2\]
+ net414 _00557_ VSS VSS VDD VDD _06060_ sky130_fd_sc_hd__o22ai_1
X_17947_ network.neuron_in105.counter\[2\] _00557_ net357
+ VSS VSS VDD VDD _06061_ sky130_fd_sc_hd__nand3_1
X_17948_ network.in_period\[105\]\[2\] net357 _06061_ VSS
+ VSS VDD VDD _06062_ sky130_fd_sc_hd__o21ai_0
X_17949_ _04860_ _06060_ _06062_ VSS VSS VDD VDD _02485_ sky130_fd_sc_hd__a21oi_1
Xoutput36 net35 VSS VSS VDD VDD inference_cycles[2] sky130_fd_sc_hd__buf_1
X_17951_ network.neuron_in175.counter\[0\] network.neuron_in175.counter\[1\]
+ _00992_ VSS VSS VDD VDD _06064_ sky130_fd_sc_hd__o21bai_1
X_17952_ _07839_ _06064_ network.neuron_in175.counter\[3\]
+ VSS VSS VDD VDD _06065_ sky130_fd_sc_hd__a21oi_1
X_17953_ _07839_ network.neuron_in175.counter\[3\] _00990_
+ _00991_ _06065_ VSS VSS VDD VDD _06066_ sky130_fd_sc_hd__a41o_1
X_17954_ net364 _07838_ network.in_period\[175\]\[3\] VSS
+ VSS VDD VDD _06067_ sky130_fd_sc_hd__a21oi_1
X_17955_ net364 _06066_ _06067_ VSS VSS VDD VDD _02766_ sky130_fd_sc_hd__a21oi_1
X_17956_ network.in_period\[105\]\[1\] _05957_ VSS VSS VDD
+ VDD _06068_ sky130_fd_sc_hd__nand2_1
X_17957_ _00558_ _05957_ _06068_ VSS VSS VDD VDD _02484_ sky130_fd_sc_hd__o21ai_0
X_17958_ network.in_spk08_08 _09372_ network.in_spk09_08 VSS
+ VSS VDD VDD _06069_ sky130_fd_sc_hd__o21ai_0
Xoutput35 net34 VSS VSS VDD VDD inference_cycles[1] sky130_fd_sc_hd__buf_1
X_17960_ _06821_ _06069_ net421 VSS VSS VDD VDD _02023_ sky130_fd_sc_hd__a21oi_1
X_17961_ network.neuron_in176.counter\[1\] network.neuron_in176.counter\[0\]
+ _00617_ VSS VSS VDD VDD _06071_ sky130_fd_sc_hd__o21bai_1
X_17962_ _07844_ _06071_ network.neuron_in176.counter\[3\]
+ VSS VSS VDD VDD _06072_ sky130_fd_sc_hd__a21oi_1
X_17963_ _07844_ network.neuron_in176.counter\[3\] _00616_
+ _00615_ _06072_ VSS VSS VDD VDD _06073_ sky130_fd_sc_hd__a41o_1
X_17964_ net362 _07843_ network.in_period\[176\]\[3\] VSS
+ VSS VDD VDD _06074_ sky130_fd_sc_hd__a21oi_1
X_17965_ net362 _06073_ _06074_ VSS VSS VDD VDD _02770_ sky130_fd_sc_hd__a21oi_1
X_17966_ network.neuron_in106.counter\[3\] network.in_period\[106\]\[2\]
+ net411 _00716_ VSS VSS VDD VDD _06075_ sky130_fd_sc_hd__o22ai_1
X_17967_ network.neuron_in106.counter\[2\] _00716_ net356
+ VSS VSS VDD VDD _06076_ sky130_fd_sc_hd__nand3_1
X_17968_ network.in_period\[106\]\[2\] net356 _06076_ VSS
+ VSS VDD VDD _06077_ sky130_fd_sc_hd__o21ai_0
X_17969_ _04858_ _06075_ _06077_ VSS VSS VDD VDD _02489_ sky130_fd_sc_hd__a21oi_1
X_17970_ network.neuron_in177.counter\[1\] network.neuron_in177.counter\[0\]
+ _00952_ VSS VSS VDD VDD _06078_ sky130_fd_sc_hd__o21bai_1
X_17971_ _07790_ _06078_ network.neuron_in177.counter\[3\]
+ VSS VSS VDD VDD _06079_ sky130_fd_sc_hd__a21oi_1
X_17972_ _07790_ network.neuron_in177.counter\[3\] _00951_
+ _00950_ _06079_ VSS VSS VDD VDD _06080_ sky130_fd_sc_hd__a41o_1
X_17973_ net361 _07789_ network.in_period\[177\]\[3\] VSS
+ VSS VDD VDD _06081_ sky130_fd_sc_hd__a21oi_1
X_17974_ net361 _06080_ _06081_ VSS VSS VDD VDD _02774_ sky130_fd_sc_hd__a21oi_1
X_17975_ network.in_period\[106\]\[1\] _06006_ VSS VSS VDD
+ VDD _06082_ sky130_fd_sc_hd__nand2_1
X_17976_ _00717_ _06006_ _06082_ VSS VSS VDD VDD _02488_ sky130_fd_sc_hd__o21ai_0
X_17977_ network.in_spk08_08 _09372_ VSS VSS VDD VDD _06083_
+ sky130_fd_sc_hd__nand2_1
X_17978_ _06727_ _06083_ net413 VSS VSS VDD VDD _02024_ sky130_fd_sc_hd__a21oi_1
X_17979_ network.neuron_in178.counter\[1\] network.neuron_in178.counter\[0\]
+ _01152_ VSS VSS VDD VDD _06084_ sky130_fd_sc_hd__o21bai_1
X_17980_ _03597_ _06084_ network.neuron_in178.counter\[3\]
+ VSS VSS VDD VDD _06085_ sky130_fd_sc_hd__a21oi_1
X_17981_ _03597_ network.neuron_in178.counter\[3\] _01151_
+ _01150_ _06085_ VSS VSS VDD VDD _06086_ sky130_fd_sc_hd__a41o_1
Xoutput34 net33 VSS VSS VDD VDD inference_cycles[15] sky130_fd_sc_hd__buf_1
X_17983_ net362 _04785_ network.in_period\[178\]\[3\] VSS
+ VSS VDD VDD _06088_ sky130_fd_sc_hd__a21oi_1
X_17984_ net362 _06086_ _06088_ VSS VSS VDD VDD _02778_ sky130_fd_sc_hd__a21oi_1
X_17985_ network.neuron_in179.counter\[0\] network.neuron_in179.counter\[1\]
+ _00219_ VSS VSS VDD VDD _06089_ sky130_fd_sc_hd__o21bai_1
X_17986_ _06770_ _06089_ network.neuron_in179.counter\[3\]
+ VSS VSS VDD VDD _06090_ sky130_fd_sc_hd__a21oi_1
X_17987_ _06770_ network.neuron_in179.counter\[3\] _00217_
+ _00218_ _06090_ VSS VSS VDD VDD _06091_ sky130_fd_sc_hd__a41o_1
X_17988_ net363 _06769_ network.in_period\[179\]\[3\] VSS
+ VSS VDD VDD _06092_ sky130_fd_sc_hd__a21oi_1
X_17989_ net363 _06091_ _06092_ VSS VSS VDD VDD _02782_ sky130_fd_sc_hd__a21oi_1
X_17990_ _09273_ net329 _09349_ VSS VSS VDD VDD _06093_ sky130_fd_sc_hd__nand3_1
X_17991_ _09367_ _06093_ network.in_spk07_08 VSS VSS VDD VDD
+ _06094_ sky130_fd_sc_hd__o21ai_0
X_17992_ _08199_ _06094_ net421 VSS VSS VDD VDD _02025_ sky130_fd_sc_hd__a21oi_1
X_17993_ network.neuron_in180.counter\[1\] network.neuron_in180.counter\[0\]
+ VSS VSS VDD VDD _06095_ sky130_fd_sc_hd__nor2_1
X_17994_ _00988_ _06095_ VSS VSS VDD VDD _06096_ sky130_fd_sc_hd__nor2_1
X_17995_ network.neuron_in180.counter\[2\] _06096_ VSS VSS
+ VDD VDD _06097_ sky130_fd_sc_hd__nor2_1
X_17996_ network.neuron_in180.counter\[2\] network.neuron_in180.counter\[3\]
+ _06095_ VSS VSS VDD VDD _06098_ sky130_fd_sc_hd__nand3b_1
X_17997_ network.neuron_in180.counter\[3\] _06097_ _06098_
+ VSS VSS VDD VDD _06099_ sky130_fd_sc_hd__o21ai_0
X_17998_ net361 _06775_ network.in_period\[180\]\[3\] VSS
+ VSS VDD VDD _06100_ sky130_fd_sc_hd__a21oi_1
X_17999_ net361 _06099_ _06100_ VSS VSS VDD VDD _02786_ sky130_fd_sc_hd__a21oi_1
X_18000_ network.in_period\[107\]\[0\] _05986_ VSS VSS VDD
+ VDD _06101_ sky130_fd_sc_hd__nand2_1
X_18001_ network.neuron_in107.counter\[0\] _05986_ _06101_
+ VSS VSS VDD VDD _02491_ sky130_fd_sc_hd__o21ai_0
X_18002_ network.neuron_in181.counter\[0\] network.neuron_in181.counter\[1\]
+ VSS VSS VDD VDD _06102_ sky130_fd_sc_hd__nor2_1
X_18003_ _01192_ _06102_ VSS VSS VDD VDD _06103_ sky130_fd_sc_hd__nor2_1
X_18004_ network.neuron_in181.counter\[2\] _06103_ VSS VSS
+ VDD VDD _06104_ sky130_fd_sc_hd__nor2_1
X_18005_ network.neuron_in181.counter\[2\] network.neuron_in181.counter\[3\]
+ _06102_ VSS VSS VDD VDD _06105_ sky130_fd_sc_hd__nand3b_1
X_18006_ network.neuron_in181.counter\[3\] _06104_ _06105_
+ VSS VSS VDD VDD _06106_ sky130_fd_sc_hd__o21ai_0
X_18007_ net361 _06709_ network.in_period\[181\]\[3\] VSS
+ VSS VDD VDD _06107_ sky130_fd_sc_hd__a21oi_1
X_18008_ net361 _06106_ _06107_ VSS VSS VDD VDD _02790_ sky130_fd_sc_hd__a21oi_1
X_18009_ network.neuron_in108.counter\[3\] network.in_period\[108\]\[2\]
+ net411 _01022_ VSS VSS VDD VDD _06108_ sky130_fd_sc_hd__o22ai_1
X_18010_ network.neuron_in108.counter\[2\] _01022_ net355
+ VSS VSS VDD VDD _06109_ sky130_fd_sc_hd__nand3_1
X_18011_ network.in_period\[108\]\[2\] net355 _06109_ VSS
+ VSS VDD VDD _06110_ sky130_fd_sc_hd__o21ai_0
X_18012_ _04852_ _06108_ _06110_ VSS VSS VDD VDD _02497_ sky130_fd_sc_hd__a21oi_1
X_18013_ network.in_spk04_08 network.in_spk05_08 _06093_ network.in_spk06_08
+ VSS VSS VDD VDD _06111_ sky130_fd_sc_hd__o31ai_1
X_18014_ _07263_ _06111_ net421 VSS VSS VDD VDD _02026_ sky130_fd_sc_hd__a21oi_1
X_18015_ network.neuron_in182.counter\[0\] network.neuron_in182.counter\[1\]
+ VSS VSS VDD VDD _06112_ sky130_fd_sc_hd__nor2_1
X_18016_ _00960_ _06112_ VSS VSS VDD VDD _06113_ sky130_fd_sc_hd__nor2_1
X_18017_ network.neuron_in182.counter\[2\] _06113_ VSS VSS
+ VDD VDD _06114_ sky130_fd_sc_hd__nor2_1
X_18018_ network.neuron_in182.counter\[2\] network.neuron_in182.counter\[3\]
+ _06112_ VSS VSS VDD VDD _06115_ sky130_fd_sc_hd__nand3b_1
X_18019_ network.neuron_in182.counter\[3\] _06114_ _06115_
+ VSS VSS VDD VDD _06116_ sky130_fd_sc_hd__o21ai_0
X_18020_ net362 _06737_ network.in_period\[182\]\[3\] VSS
+ VSS VDD VDD _06117_ sky130_fd_sc_hd__a21oi_1
X_18021_ net362 _06116_ _06117_ VSS VSS VDD VDD _02794_ sky130_fd_sc_hd__a21oi_1
X_18022_ net355 _04853_ VSS VSS VDD VDD _06118_ sky130_fd_sc_hd__nand2_1
X_18023_ network.in_period\[108\]\[1\] _06118_ VSS VSS VDD
+ VDD _06119_ sky130_fd_sc_hd__nand2_1
X_18024_ _01023_ _06118_ _06119_ VSS VSS VDD VDD _02496_ sky130_fd_sc_hd__o21ai_0
X_18025_ network.neuron_in183.counter\[0\] network.neuron_in183.counter\[1\]
+ VSS VSS VDD VDD _06120_ sky130_fd_sc_hd__nor2_1
X_18026_ _00249_ _06120_ VSS VSS VDD VDD _06121_ sky130_fd_sc_hd__nor2_1
X_18027_ network.neuron_in183.counter\[2\] _06121_ VSS VSS
+ VDD VDD _06122_ sky130_fd_sc_hd__nor2_1
X_18028_ network.neuron_in183.counter\[2\] network.neuron_in183.counter\[3\]
+ _06120_ VSS VSS VDD VDD _06123_ sky130_fd_sc_hd__nand3b_1
X_18029_ network.neuron_in183.counter\[3\] _06122_ _06123_
+ VSS VSS VDD VDD _06124_ sky130_fd_sc_hd__o21ai_0
X_18030_ net361 _06713_ network.in_period\[183\]\[3\] VSS
+ VSS VDD VDD _06125_ sky130_fd_sc_hd__a21oi_1
X_18031_ net361 _06124_ _06125_ VSS VSS VDD VDD _02798_ sky130_fd_sc_hd__a21oi_1
X_18032_ network.in_period\[108\]\[0\] _06118_ VSS VSS VDD
+ VDD _06126_ sky130_fd_sc_hd__nand2_1
X_18033_ network.neuron_in108.counter\[0\] _06118_ _06126_
+ VSS VSS VDD VDD _02495_ sky130_fd_sc_hd__o21ai_0
X_18034_ network.in_spk04_08 _06093_ network.in_spk05_08 VSS
+ VSS VDD VDD _06127_ sky130_fd_sc_hd__o21ai_0
X_18035_ _07090_ _06127_ net420 VSS VSS VDD VDD _02027_ sky130_fd_sc_hd__a21oi_1
X_18036_ network.neuron_in184.counter\[1\] network.neuron_in184.counter\[0\]
+ VSS VSS VDD VDD _06128_ sky130_fd_sc_hd__nor2_1
X_18037_ _01098_ _06128_ VSS VSS VDD VDD _06129_ sky130_fd_sc_hd__nor2_1
X_18038_ network.neuron_in184.counter\[2\] _06129_ VSS VSS
+ VDD VDD _06130_ sky130_fd_sc_hd__nor2_1
X_18039_ network.neuron_in184.counter\[2\] network.neuron_in184.counter\[3\]
+ _06128_ VSS VSS VDD VDD _06131_ sky130_fd_sc_hd__nand3b_1
X_18040_ network.neuron_in184.counter\[3\] _06130_ _06131_
+ VSS VSS VDD VDD _06132_ sky130_fd_sc_hd__o21ai_0
X_18041_ net362 _06792_ network.in_period\[184\]\[3\] VSS
+ VSS VDD VDD _06133_ sky130_fd_sc_hd__a21oi_1
X_18042_ net362 _06132_ _06133_ VSS VSS VDD VDD _02802_ sky130_fd_sc_hd__a21oi_1
Xoutput33 net32 VSS VSS VDD VDD inference_cycles[14] sky130_fd_sc_hd__buf_1
X_18044_ network.neuron_in185.counter\[0\] network.neuron_in185.counter\[1\]
+ VSS VSS VDD VDD _06135_ sky130_fd_sc_hd__nor2_1
X_18045_ _00277_ _06135_ VSS VSS VDD VDD _06136_ sky130_fd_sc_hd__nor2_1
X_18046_ network.neuron_in185.counter\[2\] _06136_ VSS VSS
+ VDD VDD _06137_ sky130_fd_sc_hd__nor2_1
X_18047_ network.neuron_in185.counter\[2\] network.neuron_in185.counter\[3\]
+ _06135_ VSS VSS VDD VDD _06138_ sky130_fd_sc_hd__nand3b_1
X_18048_ network.neuron_in185.counter\[3\] _06137_ _06138_
+ VSS VSS VDD VDD _06139_ sky130_fd_sc_hd__o21ai_0
X_18049_ net362 _06797_ network.in_period\[185\]\[3\] VSS
+ VSS VDD VDD _06140_ sky130_fd_sc_hd__a21oi_1
X_18050_ net362 _06139_ _06140_ VSS VSS VDD VDD _02806_ sky130_fd_sc_hd__a21oi_1
X_18051_ network.in_spk04_08 _06093_ VSS VSS VDD VDD _06141_
+ sky130_fd_sc_hd__nand2_1
X_18052_ _04050_ _06141_ net421 VSS VSS VDD VDD _02028_ sky130_fd_sc_hd__a21oi_1
X_18053_ network.neuron_in186.counter\[0\] network.neuron_in186.counter\[1\]
+ VSS VSS VDD VDD _06142_ sky130_fd_sc_hd__nor2_1
X_18054_ _01106_ _06142_ VSS VSS VDD VDD _06143_ sky130_fd_sc_hd__nor2_1
X_18055_ network.neuron_in186.counter\[2\] _06143_ VSS VSS
+ VDD VDD _06144_ sky130_fd_sc_hd__nor2_1
X_18056_ network.neuron_in186.counter\[2\] network.neuron_in186.counter\[3\]
+ _06142_ VSS VSS VDD VDD _06145_ sky130_fd_sc_hd__nand3b_1
X_18057_ network.neuron_in186.counter\[3\] _06144_ _06145_
+ VSS VSS VDD VDD _06146_ sky130_fd_sc_hd__o21ai_0
X_18058_ net362 _06717_ network.in_period\[186\]\[3\] VSS
+ VSS VDD VDD _06147_ sky130_fd_sc_hd__a21oi_1
X_18059_ net362 _06146_ _06147_ VSS VSS VDD VDD _02810_ sky130_fd_sc_hd__a21oi_1
X_18060_ network.neuron_in187.counter\[0\] network.neuron_in187.counter\[1\]
+ _00980_ VSS VSS VDD VDD _06148_ sky130_fd_sc_hd__o21bai_1
X_18061_ _06751_ _06148_ network.neuron_in187.counter\[3\]
+ VSS VSS VDD VDD _06149_ sky130_fd_sc_hd__a21oi_1
X_18062_ _06751_ network.neuron_in187.counter\[3\] _00978_
+ _00979_ _06149_ VSS VSS VDD VDD _06150_ sky130_fd_sc_hd__a41o_1
X_18063_ net363 _06750_ network.in_period\[187\]\[3\] VSS
+ VSS VDD VDD _06151_ sky130_fd_sc_hd__a21oi_1
X_18064_ net363 _06150_ _06151_ VSS VSS VDD VDD _02814_ sky130_fd_sc_hd__a21oi_1
X_18065_ network.in_spk00_08 network.in_spk01_08 _09471_ VSS
+ VSS VDD VDD _06152_ sky130_fd_sc_hd__or3_1
X_18066_ network.in_spk02_08 _06152_ network.in_spk03_08 VSS
+ VSS VDD VDD _06153_ sky130_fd_sc_hd__o21ai_0
X_18067_ _03726_ _06153_ net413 VSS VSS VDD VDD _02029_ sky130_fd_sc_hd__a21oi_1
X_18068_ network.neuron_in188.counter\[0\] network.neuron_in188.counter\[1\]
+ VSS VSS VDD VDD _06154_ sky130_fd_sc_hd__nor2_1
X_18069_ _01180_ _06154_ VSS VSS VDD VDD _06155_ sky130_fd_sc_hd__nor2_1
X_18070_ network.neuron_in188.counter\[2\] _06155_ VSS VSS
+ VDD VDD _06156_ sky130_fd_sc_hd__nor2_1
X_18071_ network.neuron_in188.counter\[2\] network.neuron_in188.counter\[3\]
+ _06154_ VSS VSS VDD VDD _06157_ sky130_fd_sc_hd__nand3b_1
X_18072_ network.neuron_in188.counter\[3\] _06156_ _06157_
+ VSS VSS VDD VDD _06158_ sky130_fd_sc_hd__o21ai_0
Xoutput32 net31 VSS VSS VDD VDD inference_cycles[13] sky130_fd_sc_hd__buf_1
X_18074_ net363 _06705_ network.in_period\[188\]\[3\] VSS
+ VSS VDD VDD _06160_ sky130_fd_sc_hd__a21oi_1
X_18075_ net363 _06158_ _06160_ VSS VSS VDD VDD _02818_ sky130_fd_sc_hd__a21oi_1
X_18076_ network.neuron_in189.counter\[1\] network.neuron_in189.counter\[0\]
+ VSS VSS VDD VDD _06161_ sky130_fd_sc_hd__nor2_1
X_18077_ _00837_ _06161_ VSS VSS VDD VDD _06162_ sky130_fd_sc_hd__nor2_1
X_18078_ network.neuron_in189.counter\[2\] _06162_ VSS VSS
+ VDD VDD _06163_ sky130_fd_sc_hd__nor2_1
X_18079_ network.neuron_in189.counter\[2\] network.neuron_in189.counter\[3\]
+ _06161_ VSS VSS VDD VDD _06164_ sky130_fd_sc_hd__nand3b_1
X_18080_ network.neuron_in189.counter\[3\] _06163_ _06164_
+ VSS VSS VDD VDD _06165_ sky130_fd_sc_hd__o21ai_0
X_18081_ net363 _06881_ network.in_period\[189\]\[3\] VSS
+ VSS VDD VDD _06166_ sky130_fd_sc_hd__a21oi_1
X_18082_ net363 _06165_ _06166_ VSS VSS VDD VDD _02822_ sky130_fd_sc_hd__a21oi_1
X_18083_ net356 _04848_ VSS VSS VDD VDD _06167_ sky130_fd_sc_hd__nand2_1
X_18084_ network.in_period\[110\]\[0\] _06167_ VSS VSS VDD
+ VDD _06168_ sky130_fd_sc_hd__nand2_1
X_18085_ network.neuron_in110.counter\[0\] _06167_ _06168_
+ VSS VSS VDD VDD _02503_ sky130_fd_sc_hd__o21ai_0
X_18086_ network.in_spk02_08 _06152_ VSS VSS VDD VDD _06169_
+ sky130_fd_sc_hd__nand2_1
X_18087_ _03669_ _06169_ net413 VSS VSS VDD VDD _02030_ sky130_fd_sc_hd__a21oi_1
X_18088_ network.neuron_in190.counter\[1\] network.neuron_in190.counter\[0\]
+ _00285_ VSS VSS VDD VDD _06170_ sky130_fd_sc_hd__o21bai_1
X_18089_ _06848_ _06170_ network.neuron_in190.counter\[3\]
+ VSS VSS VDD VDD _06171_ sky130_fd_sc_hd__a21oi_1
X_18090_ _06848_ network.neuron_in190.counter\[3\] _00284_
+ _00283_ _06171_ VSS VSS VDD VDD _06172_ sky130_fd_sc_hd__a41o_1
X_18091_ net363 _06887_ network.in_period\[190\]\[3\] VSS
+ VSS VDD VDD _06173_ sky130_fd_sc_hd__a21oi_1
X_18092_ net363 _06172_ _06173_ VSS VSS VDD VDD _02826_ sky130_fd_sc_hd__a21oi_1
Xoutput31 net30 VSS VSS VDD VDD inference_cycles[12] sky130_fd_sc_hd__buf_1
X_18094_ net353 _04842_ VSS VSS VDD VDD _06175_ sky130_fd_sc_hd__nand2_1
X_18095_ network.in_period\[112\]\[0\] _06175_ VSS VSS VDD
+ VDD _06176_ sky130_fd_sc_hd__nand2_1
X_18096_ network.neuron_in112.counter\[0\] _06175_ _06176_
+ VSS VSS VDD VDD _02511_ sky130_fd_sc_hd__o21ai_0
X_18097_ network.neuron_in191.counter\[1\] network.neuron_in191.counter\[0\]
+ _00976_ VSS VSS VDD VDD _06177_ sky130_fd_sc_hd__o21bai_1
X_18098_ _06829_ _06177_ network.neuron_in191.counter\[3\]
+ VSS VSS VDD VDD _06178_ sky130_fd_sc_hd__a21oi_1
X_18099_ _06829_ network.neuron_in191.counter\[3\] _00975_
+ _00974_ _06178_ VSS VSS VDD VDD _06179_ sky130_fd_sc_hd__a41o_1
X_18100_ net363 _06828_ network.in_period\[191\]\[3\] VSS
+ VSS VDD VDD _06180_ sky130_fd_sc_hd__a21oi_1
X_18101_ net363 _06179_ _06180_ VSS VSS VDD VDD _02830_ sky130_fd_sc_hd__a21oi_1
X_18102_ net356 _04835_ VSS VSS VDD VDD _06181_ sky130_fd_sc_hd__nand2_1
X_18103_ network.in_period\[114\]\[1\] _06181_ VSS VSS VDD
+ VDD _06182_ sky130_fd_sc_hd__nand2_1
X_18104_ _01248_ _06181_ _06182_ VSS VSS VDD VDD _02520_ sky130_fd_sc_hd__o21ai_0
X_18105_ network.in_spk00_08 _09471_ network.in_spk01_08 VSS
+ VSS VDD VDD _06183_ sky130_fd_sc_hd__o21ai_0
X_18106_ _06908_ _06183_ net421 VSS VSS VDD VDD _02031_ sky130_fd_sc_hd__a21oi_1
X_18107_ network.neuron_in192.counter\[0\] network.neuron_in192.counter\[1\]
+ _01126_ VSS VSS VDD VDD _06184_ sky130_fd_sc_hd__o21bai_1
X_18108_ _06858_ _06184_ network.neuron_in192.counter\[3\]
+ VSS VSS VDD VDD _06185_ sky130_fd_sc_hd__a21oi_1
X_18109_ _06858_ network.neuron_in192.counter\[3\] _01124_
+ _01125_ _06185_ VSS VSS VDD VDD _06186_ sky130_fd_sc_hd__a41o_1
X_18110_ net360 _06857_ network.in_period\[192\]\[3\] VSS
+ VSS VDD VDD _06187_ sky130_fd_sc_hd__a21oi_1
X_18111_ net360 _06186_ _06187_ VSS VSS VDD VDD _02834_ sky130_fd_sc_hd__a21oi_1
X_18112_ network.neuron_in193.counter\[1\] network.neuron_in193.counter\[0\]
+ _00972_ VSS VSS VDD VDD _06188_ sky130_fd_sc_hd__o21bai_1
X_18113_ _06839_ _06188_ network.neuron_in193.counter\[3\]
+ VSS VSS VDD VDD _06189_ sky130_fd_sc_hd__a21oi_1
X_18114_ _06839_ network.neuron_in193.counter\[3\] _00971_
+ _00970_ _06189_ VSS VSS VDD VDD _06190_ sky130_fd_sc_hd__a41o_1
X_18115_ net360 _06838_ network.in_period\[193\]\[3\] VSS
+ VSS VDD VDD _06191_ sky130_fd_sc_hd__a21oi_1
X_18116_ net360 _06190_ _06191_ VSS VSS VDD VDD _02838_ sky130_fd_sc_hd__a21oi_1
X_18117_ network.in_spk00_08 _09471_ VSS VSS VDD VDD _06192_
+ sky130_fd_sc_hd__nand2_1
X_18118_ _07279_ _06192_ net421 VSS VSS VDD VDD _02032_ sky130_fd_sc_hd__a21oi_1
X_18119_ network.neuron_in194.counter\[1\] network.neuron_in194.counter\[0\]
+ VSS VSS VDD VDD _06193_ sky130_fd_sc_hd__nor2_1
X_18120_ _00289_ _06193_ VSS VSS VDD VDD _06194_ sky130_fd_sc_hd__nor2_1
X_18121_ network.neuron_in194.counter\[2\] _06194_ VSS VSS
+ VDD VDD _06195_ sky130_fd_sc_hd__nor2_1
X_18122_ network.neuron_in194.counter\[2\] network.neuron_in194.counter\[3\]
+ _06193_ VSS VSS VDD VDD _06196_ sky130_fd_sc_hd__nand3b_1
X_18123_ network.neuron_in194.counter\[3\] _06195_ _06196_
+ VSS VSS VDD VDD _06197_ sky130_fd_sc_hd__o21ai_0
X_18124_ net366 _06911_ network.in_period\[194\]\[3\] VSS
+ VSS VDD VDD _06198_ sky130_fd_sc_hd__a21oi_1
X_18125_ net366 _06197_ _06198_ VSS VSS VDD VDD _02842_ sky130_fd_sc_hd__a21oi_1
Xoutput30 net29 VSS VSS VDD VDD inference_cycles[11] sky130_fd_sc_hd__buf_1
X_18127_ network.neuron_in195.counter\[0\] network.neuron_in195.counter\[1\]
+ VSS VSS VDD VDD _06200_ sky130_fd_sc_hd__nor2_1
X_18128_ _00377_ _06200_ VSS VSS VDD VDD _06201_ sky130_fd_sc_hd__nor2_1
X_18129_ network.neuron_in195.counter\[2\] _06201_ VSS VSS
+ VDD VDD _06202_ sky130_fd_sc_hd__nor2_1
X_18130_ network.neuron_in195.counter\[2\] network.neuron_in195.counter\[3\]
+ _06200_ VSS VSS VDD VDD _06203_ sky130_fd_sc_hd__nand3b_1
X_18131_ network.neuron_in195.counter\[3\] _06202_ _06203_
+ VSS VSS VDD VDD _06204_ sky130_fd_sc_hd__o21ai_0
X_18132_ net366 _06916_ network.in_period\[195\]\[3\] VSS
+ VSS VDD VDD _06205_ sky130_fd_sc_hd__a21oi_1
X_18133_ net366 _06204_ _06205_ VSS VSS VDD VDD _02846_ sky130_fd_sc_hd__a21oi_1
X_18134_ net356 _04845_ VSS VSS VDD VDD _06206_ sky130_fd_sc_hd__nand2_1
X_18135_ network.in_period\[111\]\[0\] _06206_ VSS VSS VDD
+ VDD _06207_ sky130_fd_sc_hd__nand2_1
X_18136_ network.neuron_in111.counter\[0\] _06206_ _06207_
+ VSS VSS VDD VDD _02507_ sky130_fd_sc_hd__o21ai_0
X_18137_ net324 _09319_ _09327_ _09502_ VSS VSS VDD VDD _06208_
+ sky130_fd_sc_hd__nand4_1
X_18138_ network.in_spk13_07 _06208_ VSS VSS VDD VDD _06209_
+ sky130_fd_sc_hd__or2_2
X_18139_ network.in_spk14_07 _06209_ network.in_spk15_07 VSS
+ VSS VDD VDD _06210_ sky130_fd_sc_hd__o21ai_0
Xoutput29 net28 VSS VSS VDD VDD inference_cycles[10] sky130_fd_sc_hd__buf_1
X_18141_ _04800_ _06210_ net419 VSS VSS VDD VDD _02033_ sky130_fd_sc_hd__a21oi_1
X_18142_ network.neuron_in196.counter\[2\] VSS VSS VDD VDD
+ _06212_ sky130_fd_sc_hd__inv_1
X_18143_ _00727_ _06212_ _00726_ net365 VSS VSS VDD VDD _06213_
+ sky130_fd_sc_hd__nand4_1
X_18144_ _06212_ _00728_ _06213_ VSS VSS VDD VDD _06214_ sky130_fd_sc_hd__a21oi_1
X_18145_ _06212_ _00728_ network.in_period\[196\]\[3\] _06214_
+ VSS VSS VDD VDD _06215_ sky130_fd_sc_hd__a31oi_1
X_18146_ network.neuron_in196.counter\[1\] network.neuron_in196.counter\[2\]
+ network.neuron_in196.counter\[0\] net365 network.neuron_in196.counter\[3\]
+ VSS VSS VDD VDD _06216_ sky130_fd_sc_hd__o311a_1
X_18147_ network.in_period\[196\]\[3\] net417 _06216_ VSS
+ VSS VDD VDD _06217_ sky130_fd_sc_hd__a21oi_1
X_18148_ network.neuron_in196.counter\[3\] _06215_ _06217_
+ VSS VSS VDD VDD _02850_ sky130_fd_sc_hd__o21ai_0
X_18149_ network.neuron_in197.counter\[0\] network.neuron_in197.counter\[1\]
+ VSS VSS VDD VDD _06218_ sky130_fd_sc_hd__nor2_1
X_18150_ _00833_ _06218_ VSS VSS VDD VDD _06219_ sky130_fd_sc_hd__nor2_1
X_18151_ network.neuron_in197.counter\[2\] _06219_ VSS VSS
+ VDD VDD _06220_ sky130_fd_sc_hd__nor2_1
X_18152_ network.neuron_in197.counter\[2\] network.neuron_in197.counter\[3\]
+ _06218_ VSS VSS VDD VDD _06221_ sky130_fd_sc_hd__nand3b_1
X_18153_ network.neuron_in197.counter\[3\] _06220_ _06221_
+ VSS VSS VDD VDD _06222_ sky130_fd_sc_hd__o21ai_0
X_18154_ net366 _06922_ network.in_period\[197\]\[3\] VSS
+ VSS VDD VDD _06223_ sky130_fd_sc_hd__a21oi_1
X_18155_ net366 _06222_ _06223_ VSS VSS VDD VDD _02854_ sky130_fd_sc_hd__a21oi_1
X_18156_ net355 _04839_ VSS VSS VDD VDD _06224_ sky130_fd_sc_hd__nand2_1
X_18157_ network.in_period\[113\]\[1\] _06224_ VSS VSS VDD
+ VDD _06225_ sky130_fd_sc_hd__nand2_1
X_18158_ _01005_ _06224_ _06225_ VSS VSS VDD VDD _02516_ sky130_fd_sc_hd__o21ai_0
X_18159_ network.in_spk14_07 _06209_ VSS VSS VDD VDD _06226_
+ sky130_fd_sc_hd__nand2_1
X_18160_ _04803_ _06226_ net419 VSS VSS VDD VDD _02034_ sky130_fd_sc_hd__a21oi_1
X_18161_ network.neuron_in198.counter\[0\] network.neuron_in198.counter\[1\]
+ VSS VSS VDD VDD _06227_ sky130_fd_sc_hd__nor2_1
X_18162_ _00381_ _06227_ VSS VSS VDD VDD _06228_ sky130_fd_sc_hd__nor2_1
X_18163_ network.neuron_in198.counter\[2\] _06228_ VSS VSS
+ VDD VDD _06229_ sky130_fd_sc_hd__nor2_1
X_18164_ network.neuron_in198.counter\[2\] network.neuron_in198.counter\[3\]
+ _06227_ VSS VSS VDD VDD _06230_ sky130_fd_sc_hd__nand3b_1
X_18165_ network.neuron_in198.counter\[3\] _06229_ _06230_
+ VSS VSS VDD VDD _06231_ sky130_fd_sc_hd__o21ai_0
X_18166_ net366 _06824_ network.in_period\[198\]\[3\] VSS
+ VSS VDD VDD _06232_ sky130_fd_sc_hd__a21oi_1
X_18167_ net366 _06231_ _06232_ VSS VSS VDD VDD _02858_ sky130_fd_sc_hd__a21oi_1
X_18168_ network.neuron_in199.counter\[1\] network.neuron_in199.counter\[0\]
+ VSS VSS VDD VDD _06233_ sky130_fd_sc_hd__nor2_1
X_18169_ _01156_ _06233_ VSS VSS VDD VDD _06234_ sky130_fd_sc_hd__nor2_1
X_18170_ network.neuron_in199.counter\[2\] _06234_ VSS VSS
+ VDD VDD _06235_ sky130_fd_sc_hd__nor2_1
X_18171_ network.neuron_in199.counter\[2\] network.neuron_in199.counter\[3\]
+ _06233_ VSS VSS VDD VDD _06236_ sky130_fd_sc_hd__nand3b_1
X_18172_ network.neuron_in199.counter\[3\] _06235_ _06236_
+ VSS VSS VDD VDD _06237_ sky130_fd_sc_hd__o21ai_0
Xoutput28 net27 VSS VSS VDD VDD inference_cycles[0] sky130_fd_sc_hd__buf_1
X_18174_ net344 _06993_ network.in_period\[199\]\[3\] VSS
+ VSS VDD VDD _06239_ sky130_fd_sc_hd__a21oi_1
X_18175_ net344 _06237_ _06239_ VSS VSS VDD VDD _02862_ sky130_fd_sc_hd__a21oi_1
X_18176_ network.in_period\[109\]\[0\] _05654_ VSS VSS VDD
+ VDD _06240_ sky130_fd_sc_hd__nand2_1
X_18177_ network.neuron_in109.counter\[0\] _05654_ _06240_
+ VSS VSS VDD VDD _02499_ sky130_fd_sc_hd__o21ai_0
X_18178_ network.in_spk13_07 _06208_ VSS VSS VDD VDD _06241_
+ sky130_fd_sc_hd__nand2_1
X_18179_ _04805_ _06241_ net419 VSS VSS VDD VDD _02035_ sky130_fd_sc_hd__a21oi_1
X_18180_ network.neuron_in200.counter\[1\] network.neuron_in200.counter\[0\]
+ _00297_ VSS VSS VDD VDD _06242_ sky130_fd_sc_hd__o21bai_1
X_18181_ _06957_ _06242_ network.neuron_in200.counter\[3\]
+ VSS VSS VDD VDD _06243_ sky130_fd_sc_hd__a21oi_1
X_18182_ _06957_ network.neuron_in200.counter\[3\] _00296_
+ _00295_ _06243_ VSS VSS VDD VDD _06244_ sky130_fd_sc_hd__a41o_1
X_18183_ net344 _07015_ network.in_period\[200\]\[3\] VSS
+ VSS VDD VDD _06245_ sky130_fd_sc_hd__a21oi_1
X_18184_ net344 _06244_ _06245_ VSS VSS VDD VDD _02866_ sky130_fd_sc_hd__a21oi_1
X_18185_ network.neuron_in109.counter\[2\] net356 VSS VSS
+ VDD VDD _06246_ sky130_fd_sc_hd__nand2_1
X_18186_ network.neuron_in109.counter\[3\] network.in_period\[109\]\[2\]
+ _06246_ VSS VSS VDD VDD _06247_ sky130_fd_sc_hd__o21ai_0
X_18187_ _00223_ network.neuron_in109.counter\[2\] net411
+ VSS VSS VDD VDD _06248_ sky130_fd_sc_hd__or3_1
X_18188_ network.in_period\[109\]\[2\] net356 _06248_ VSS
+ VSS VDD VDD _06249_ sky130_fd_sc_hd__o21ai_0
X_18189_ _00223_ _06247_ _06249_ VSS VSS VDD VDD _02501_ sky130_fd_sc_hd__a21oi_1
X_18190_ network.neuron_in201.counter\[0\] network.neuron_in201.counter\[1\]
+ _01122_ VSS VSS VDD VDD _06250_ sky130_fd_sc_hd__o21bai_1
X_18191_ _06942_ _06250_ network.neuron_in201.counter\[3\]
+ VSS VSS VDD VDD _06251_ sky130_fd_sc_hd__a21oi_1
X_18192_ _06942_ network.neuron_in201.counter\[3\] _01120_
+ _01121_ _06251_ VSS VSS VDD VDD _06252_ sky130_fd_sc_hd__a41o_1
X_18193_ net360 _06941_ network.in_period\[201\]\[3\] VSS
+ VSS VDD VDD _06253_ sky130_fd_sc_hd__a21oi_1
X_18194_ net360 _06252_ _06253_ VSS VSS VDD VDD _02870_ sky130_fd_sc_hd__a21oi_1
X_18195_ network.in_period\[109\]\[1\] _05654_ VSS VSS VDD
+ VDD _06254_ sky130_fd_sc_hd__nand2_1
X_18196_ _00224_ _05654_ _06254_ VSS VSS VDD VDD _02500_ sky130_fd_sc_hd__o21ai_0
X_18197_ _09454_ _09409_ network.in_spk12_07 VSS VSS VDD VDD
+ _06255_ sky130_fd_sc_hd__o21ai_0
X_18198_ _04808_ _06255_ net419 VSS VSS VDD VDD _02036_ sky130_fd_sc_hd__a21oi_1
X_18199_ network.neuron_in202.counter\[1\] network.neuron_in202.counter\[0\]
+ _00964_ VSS VSS VDD VDD _06256_ sky130_fd_sc_hd__o21bai_1
X_18200_ _06971_ _06256_ network.neuron_in202.counter\[3\]
+ VSS VSS VDD VDD _06257_ sky130_fd_sc_hd__a21oi_1
X_18201_ _06971_ network.neuron_in202.counter\[3\] _00963_
+ _00962_ _06257_ VSS VSS VDD VDD _06258_ sky130_fd_sc_hd__a41o_1
X_18202_ net339 _06970_ network.in_period\[202\]\[3\] VSS
+ VSS VDD VDD _06259_ sky130_fd_sc_hd__a21oi_1
X_18203_ net339 _06258_ _06259_ VSS VSS VDD VDD _02874_ sky130_fd_sc_hd__a21oi_1
X_18204_ network.neuron_in203.counter\[0\] network.neuron_in203.counter\[1\]
+ _00233_ VSS VSS VDD VDD _06260_ sky130_fd_sc_hd__o21bai_1
X_18205_ _06947_ _06260_ network.neuron_in203.counter\[3\]
+ VSS VSS VDD VDD _06261_ sky130_fd_sc_hd__a21oi_1
X_18206_ _06947_ network.neuron_in203.counter\[3\] _00231_
+ _00232_ _06261_ VSS VSS VDD VDD _06262_ sky130_fd_sc_hd__a41o_1
X_18207_ net339 _06946_ network.in_period\[203\]\[3\] VSS
+ VSS VDD VDD _06263_ sky130_fd_sc_hd__a21oi_1
X_18208_ net339 _06262_ _06263_ VSS VSS VDD VDD _02878_ sky130_fd_sc_hd__a21oi_1
X_18209_ network.in_spk08_07 network.in_spk09_07 _09409_ VSS
+ VSS VDD VDD _06264_ sky130_fd_sc_hd__or3_1
X_18210_ network.in_spk10_07 _06264_ network.in_spk11_07 VSS
+ VSS VDD VDD _06265_ sky130_fd_sc_hd__o21ai_1
X_18211_ _04812_ _06265_ net419 VSS VSS VDD VDD _02037_ sky130_fd_sc_hd__a21oi_1
X_18212_ network.neuron_in204.counter\[0\] network.neuron_in204.counter\[1\]
+ VSS VSS VDD VDD _06266_ sky130_fd_sc_hd__nor2_1
X_18213_ _00825_ _06266_ VSS VSS VDD VDD _06267_ sky130_fd_sc_hd__nor2_1
X_18214_ network.neuron_in204.counter\[2\] _06267_ VSS VSS
+ VDD VDD _06268_ sky130_fd_sc_hd__nor2_1
X_18215_ network.neuron_in204.counter\[2\] network.neuron_in204.counter\[3\]
+ _06266_ VSS VSS VDD VDD _06269_ sky130_fd_sc_hd__nand3b_1
X_18216_ network.neuron_in204.counter\[3\] _06268_ _06269_
+ VSS VSS VDD VDD _06270_ sky130_fd_sc_hd__o21ai_0
X_18217_ net339 _07028_ network.in_period\[204\]\[3\] VSS
+ VSS VDD VDD _06271_ sky130_fd_sc_hd__a21oi_1
X_18218_ net339 _06270_ _06271_ VSS VSS VDD VDD _02882_ sky130_fd_sc_hd__a21oi_1
X_18219_ network.neuron_in110.counter\[3\] network.in_period\[110\]\[2\]
+ net411 _00160_ VSS VSS VDD VDD _06272_ sky130_fd_sc_hd__o22ai_1
Xoutput27 net26 VSS VSS VDD VDD done sky130_fd_sc_hd__buf_1
X_18221_ network.neuron_in110.counter\[2\] _00160_ net356
+ VSS VSS VDD VDD _06274_ sky130_fd_sc_hd__nand3_1
X_18222_ network.in_period\[110\]\[2\] net356 _06274_ VSS
+ VSS VDD VDD _06275_ sky130_fd_sc_hd__o21ai_0
X_18223_ _04847_ _06272_ _06275_ VSS VSS VDD VDD _02505_ sky130_fd_sc_hd__a21oi_1
X_18224_ network.neuron_in205.counter\[1\] network.neuron_in205.counter\[0\]
+ network.neuron_in205.counter\[2\] VSS VSS VDD VDD _06276_
+ sky130_fd_sc_hd__nor3_1
X_18225_ network.neuron_in205.counter\[3\] _06276_ VSS VSS
+ VDD VDD _06277_ sky130_fd_sc_hd__xnor2_1
X_18226_ network.in_period\[205\]\[3\] _07035_ VSS VSS VDD
+ VDD _06278_ sky130_fd_sc_hd__nand2_1
X_18227_ _07035_ _06277_ _06278_ VSS VSS VDD VDD _02886_ sky130_fd_sc_hd__o21ai_0
X_18228_ network.in_period\[110\]\[1\] _06167_ VSS VSS VDD
+ VDD _06279_ sky130_fd_sc_hd__nand2_1
X_18229_ _00161_ _06167_ _06279_ VSS VSS VDD VDD _02504_ sky130_fd_sc_hd__o21ai_0
X_18230_ network.in_spk10_07 _06264_ VSS VSS VDD VDD _06280_
+ sky130_fd_sc_hd__nand2_1
X_18231_ _04815_ _06280_ net419 VSS VSS VDD VDD _02038_ sky130_fd_sc_hd__a21oi_1
X_18232_ network.neuron_in206.counter\[1\] network.neuron_in206.counter\[2\]
+ network.neuron_in206.counter\[0\] VSS VSS VDD VDD _06281_
+ sky130_fd_sc_hd__nor3_1
X_18233_ network.neuron_in206.counter\[3\] _06281_ VSS VSS
+ VDD VDD _06282_ sky130_fd_sc_hd__xnor2_1
X_18234_ network.in_period\[206\]\[3\] _06954_ VSS VSS VDD
+ VDD _06283_ sky130_fd_sc_hd__nand2_1
X_18235_ _06954_ _06282_ _06283_ VSS VSS VDD VDD _02890_ sky130_fd_sc_hd__o21ai_0
X_18236_ network.neuron_in111.counter\[3\] network.in_period\[111\]\[2\]
+ net411 _00649_ VSS VSS VDD VDD _06284_ sky130_fd_sc_hd__o22ai_1
X_18237_ network.neuron_in111.counter\[2\] _00649_ net356
+ VSS VSS VDD VDD _06285_ sky130_fd_sc_hd__nand3_1
X_18238_ network.in_period\[111\]\[2\] net356 _06285_ VSS
+ VSS VDD VDD _06286_ sky130_fd_sc_hd__o21ai_0
X_18239_ _04844_ _06284_ _06286_ VSS VSS VDD VDD _02509_ sky130_fd_sc_hd__a21oi_1
X_18240_ network.neuron_in207.counter\[1\] network.neuron_in207.counter\[0\]
+ _00956_ VSS VSS VDD VDD _06287_ sky130_fd_sc_hd__o21bai_1
X_18241_ _06985_ _06287_ network.neuron_in207.counter\[3\]
+ VSS VSS VDD VDD _06288_ sky130_fd_sc_hd__a21oi_1
X_18242_ _06985_ network.neuron_in207.counter\[3\] _00955_
+ _00954_ _06288_ VSS VSS VDD VDD _06289_ sky130_fd_sc_hd__a41o_1
X_18243_ net339 _07055_ network.in_period\[207\]\[3\] VSS
+ VSS VDD VDD _06290_ sky130_fd_sc_hd__a21oi_1
X_18244_ net339 _06289_ _06290_ VSS VSS VDD VDD _02894_ sky130_fd_sc_hd__a21oi_1
X_18245_ network.in_period\[111\]\[1\] _06206_ VSS VSS VDD
+ VDD _06291_ sky130_fd_sc_hd__nand2_1
X_18246_ _00650_ _06206_ _06291_ VSS VSS VDD VDD _02508_ sky130_fd_sc_hd__o21ai_0
X_18247_ network.in_spk08_07 _09409_ network.in_spk09_07 VSS
+ VSS VDD VDD _06292_ sky130_fd_sc_hd__o21ai_0
X_18248_ _04817_ _06292_ net419 VSS VSS VDD VDD _02039_ sky130_fd_sc_hd__a21oi_1
X_18249_ network.neuron_in208.counter\[0\] network.neuron_in208.counter\[2\]
+ network.neuron_in208.counter\[1\] net425 VSS VSS VDD VDD _06293_
+ sky130_fd_sc_hd__nor4_1
X_18250_ network.in_period\[208\]\[3\] _06293_ _06937_ VSS
+ VSS VDD VDD _06294_ sky130_fd_sc_hd__mux2i_1
X_18251_ network.neuron_in208.counter\[0\] network.neuron_in208.counter\[2\]
+ network.neuron_in208.counter\[1\] net344 network.neuron_in208.counter\[3\]
+ VSS VSS VDD VDD _06295_ sky130_fd_sc_hd__o311a_1
X_18252_ network.in_period\[208\]\[3\] net425 _06295_ VSS
+ VSS VDD VDD _06296_ sky130_fd_sc_hd__a21oi_1
X_18253_ network.neuron_in208.counter\[3\] _06294_ _06296_
+ VSS VSS VDD VDD _02898_ sky130_fd_sc_hd__o21ai_0
X_18254_ network.neuron_in112.counter\[3\] network.in_period\[112\]\[2\]
+ net419 _00771_ VSS VSS VDD VDD _06297_ sky130_fd_sc_hd__o22ai_1
X_18255_ network.neuron_in112.counter\[2\] _00771_ net353
+ VSS VSS VDD VDD _06298_ sky130_fd_sc_hd__nand3_1
X_18256_ network.in_period\[112\]\[2\] net353 _06298_ VSS
+ VSS VDD VDD _06299_ sky130_fd_sc_hd__o21ai_0
X_18257_ _04840_ _06297_ _06299_ VSS VSS VDD VDD _02513_ sky130_fd_sc_hd__a21oi_1
X_18258_ network.neuron_in209.counter\[1\] network.neuron_in209.counter\[2\]
+ network.neuron_in209.counter\[0\] net425 VSS VSS VDD VDD _06300_
+ sky130_fd_sc_hd__nor4_1
X_18259_ network.in_period\[209\]\[3\] _06300_ _07129_ VSS
+ VSS VDD VDD _06301_ sky130_fd_sc_hd__mux2i_1
X_18260_ network.neuron_in209.counter\[1\] network.neuron_in209.counter\[2\]
+ network.neuron_in209.counter\[0\] net343 network.neuron_in209.counter\[3\]
+ VSS VSS VDD VDD _06302_ sky130_fd_sc_hd__o311a_1
X_18261_ network.in_period\[209\]\[3\] net425 _06302_ VSS
+ VSS VDD VDD _06303_ sky130_fd_sc_hd__a21oi_1
X_18262_ network.neuron_in209.counter\[3\] _06301_ _06303_
+ VSS VSS VDD VDD _02902_ sky130_fd_sc_hd__o21ai_0
X_18263_ network.in_period\[112\]\[1\] _06175_ VSS VSS VDD
+ VDD _06304_ sky130_fd_sc_hd__nand2_1
X_18264_ _00772_ _06175_ _06304_ VSS VSS VDD VDD _02512_ sky130_fd_sc_hd__o21ai_0
X_18265_ network.in_spk08_07 _09409_ VSS VSS VDD VDD _06305_
+ sky130_fd_sc_hd__nand2_1
X_18266_ _04820_ _06305_ net419 VSS VSS VDD VDD _02040_ sky130_fd_sc_hd__a21oi_1
X_18267_ network.neuron_in210.counter\[1\] network.neuron_in210.counter\[2\]
+ network.neuron_in210.counter\[0\] VSS VSS VDD VDD _06306_
+ sky130_fd_sc_hd__nor3_1
X_18268_ network.neuron_in210.counter\[3\] _06306_ VSS VSS
+ VDD VDD _06307_ sky130_fd_sc_hd__xnor2_1
X_18269_ network.in_period\[210\]\[3\] _07136_ VSS VSS VDD
+ VDD _06308_ sky130_fd_sc_hd__nand2_1
X_18270_ _07136_ _06307_ _06308_ VSS VSS VDD VDD _02906_ sky130_fd_sc_hd__o21ai_0
X_18271_ network.neuron_in238.counter\[1\] VSS VSS VDD VDD
+ _00806_ sky130_fd_sc_hd__inv_1
Xoutput26 net25 VSS VSS VDD VDD busy sky130_fd_sc_hd__buf_1
X_18273_ network.neuron_in211.counter\[1\] network.neuron_in211.counter\[0\]
+ _01038_ VSS VSS VDD VDD _06310_ sky130_fd_sc_hd__o21bai_1
X_18274_ _07075_ _06310_ network.neuron_in211.counter\[3\]
+ VSS VSS VDD VDD _06311_ sky130_fd_sc_hd__a21oi_1
X_18275_ _07075_ network.neuron_in211.counter\[3\] _01037_
+ _01036_ _06311_ VSS VSS VDD VDD _06312_ sky130_fd_sc_hd__a41o_1
X_18276_ net340 _07074_ network.in_period\[211\]\[3\] VSS
+ VSS VDD VDD _06313_ sky130_fd_sc_hd__a21oi_1
X_18277_ net343 _06312_ _06313_ VSS VSS VDD VDD _02910_ sky130_fd_sc_hd__a21oi_1
X_18278_ network.neuron_in113.counter\[3\] network.in_period\[113\]\[2\]
+ net411 _01004_ VSS VSS VDD VDD _06314_ sky130_fd_sc_hd__o22ai_1
Xinput25 net486 VSS VSS VDD VDD net24 sky130_fd_sc_hd__buf_1
X_18280_ network.neuron_in113.counter\[2\] _01004_ net355
+ VSS VSS VDD VDD _06316_ sky130_fd_sc_hd__nand3_1
X_18281_ network.in_period\[113\]\[2\] net355 _06316_ VSS
+ VSS VDD VDD _06317_ sky130_fd_sc_hd__o21ai_0
X_18282_ _04838_ _06314_ _06317_ VSS VSS VDD VDD _02517_ sky130_fd_sc_hd__a21oi_1
X_18283_ net324 _09327_ _09722_ VSS VSS VDD VDD _06318_ sky130_fd_sc_hd__nand3_1
X_18284_ network.in_spk07_07 _06318_ VSS VSS VDD VDD _06319_
+ sky130_fd_sc_hd__nand2_1
X_18285_ _04823_ _06319_ net411 VSS VSS VDD VDD _02041_ sky130_fd_sc_hd__a21oi_1
X_18286_ network.neuron_in212.counter\[1\] network.neuron_in212.counter\[0\]
+ VSS VSS VDD VDD _06320_ sky130_fd_sc_hd__nor2_1
X_18287_ _00343_ _06320_ VSS VSS VDD VDD _06321_ sky130_fd_sc_hd__nor2_1
X_18288_ network.neuron_in212.counter\[2\] _06321_ VSS VSS
+ VDD VDD _06322_ sky130_fd_sc_hd__nor2_1
X_18289_ network.neuron_in212.counter\[2\] network.neuron_in212.counter\[3\]
+ _06320_ VSS VSS VDD VDD _06323_ sky130_fd_sc_hd__nand3b_1
X_18290_ network.neuron_in212.counter\[3\] _06322_ _06323_
+ VSS VSS VDD VDD _06324_ sky130_fd_sc_hd__o21ai_0
X_18291_ net344 _07102_ network.in_period\[212\]\[3\] VSS
+ VSS VDD VDD _06325_ sky130_fd_sc_hd__a21oi_1
X_18292_ net344 _06324_ _06325_ VSS VSS VDD VDD _02914_ sky130_fd_sc_hd__a21oi_1
X_18293_ network.in_period\[113\]\[0\] _06224_ VSS VSS VDD
+ VDD _06326_ sky130_fd_sc_hd__nand2_1
X_18294_ network.neuron_in113.counter\[0\] _06224_ _06326_
+ VSS VSS VDD VDD _02515_ sky130_fd_sc_hd__o21ai_0
X_18295_ network.neuron_in114.counter\[2\] net356 VSS VSS
+ VDD VDD _06327_ sky130_fd_sc_hd__nand2_1
X_18296_ network.neuron_in114.counter\[3\] network.in_period\[114\]\[2\]
+ _06327_ VSS VSS VDD VDD _06328_ sky130_fd_sc_hd__o21ai_0
X_18297_ _01247_ network.neuron_in114.counter\[2\] net411
+ VSS VSS VDD VDD _06329_ sky130_fd_sc_hd__or3_1
X_18298_ network.in_period\[114\]\[2\] net356 _06329_ VSS
+ VSS VDD VDD _06330_ sky130_fd_sc_hd__o21ai_0
X_18299_ _01247_ _06328_ _06330_ VSS VSS VDD VDD _02521_ sky130_fd_sc_hd__a21oi_1
X_18300_ network.neuron_in213.counter\[0\] network.neuron_in213.counter\[1\]
+ _01008_ VSS VSS VDD VDD _06331_ sky130_fd_sc_hd__o21bai_1
X_18301_ _07080_ _06331_ network.neuron_in213.counter\[3\]
+ VSS VSS VDD VDD _06332_ sky130_fd_sc_hd__a21oi_1
X_18302_ _07080_ network.neuron_in213.counter\[3\] _01006_
+ _01007_ _06332_ VSS VSS VDD VDD _06333_ sky130_fd_sc_hd__a41o_1
X_18303_ net339 _07079_ network.in_period\[213\]\[3\] VSS
+ VSS VDD VDD _06334_ sky130_fd_sc_hd__a21oi_1
X_18304_ net339 _06333_ _06334_ VSS VSS VDD VDD _02918_ sky130_fd_sc_hd__a21oi_1
X_18305_ network.in_spk04_07 network.in_spk05_07 _09407_ _09408_
+ network.in_spk06_07 VSS VSS VDD VDD _06335_ sky130_fd_sc_hd__o41ai_1
X_18306_ _04826_ _06335_ net419 VSS VSS VDD VDD _02042_ sky130_fd_sc_hd__a21oi_1
X_18307_ network.neuron_in214.counter\[1\] network.neuron_in214.counter\[2\]
+ network.neuron_in214.counter\[0\] VSS VSS VDD VDD _06336_
+ sky130_fd_sc_hd__nor3_1
X_18308_ network.neuron_in214.counter\[3\] _06336_ VSS VSS
+ VDD VDD _06337_ sky130_fd_sc_hd__xnor2_1
X_18309_ network.in_period\[214\]\[3\] _07150_ VSS VSS VDD
+ VDD _06338_ sky130_fd_sc_hd__nand2_1
X_18310_ _07150_ _06337_ _06338_ VSS VSS VDD VDD _02922_ sky130_fd_sc_hd__o21ai_0
X_18311_ network.neuron_in215.counter\[1\] network.neuron_in215.counter\[0\]
+ _01184_ VSS VSS VDD VDD _06339_ sky130_fd_sc_hd__o21bai_1
X_18312_ _07107_ _06339_ network.neuron_in215.counter\[3\]
+ VSS VSS VDD VDD _06340_ sky130_fd_sc_hd__a21oi_1
X_18313_ _07107_ network.neuron_in215.counter\[3\] _01183_
+ _01182_ _06340_ VSS VSS VDD VDD _06341_ sky130_fd_sc_hd__a41o_1
Xinput24 net482 VSS VSS VDD VDD net23 sky130_fd_sc_hd__clkbuf_2
X_18315_ net343 _07116_ network.in_period\[215\]\[3\] VSS
+ VSS VDD VDD _06343_ sky130_fd_sc_hd__a21oi_1
X_18316_ net343 _06341_ _06343_ VSS VSS VDD VDD _02926_ sky130_fd_sc_hd__a21oi_1
X_18317_ network.in_spk04_07 _09407_ _09408_ network.in_spk05_07
+ VSS VSS VDD VDD _06344_ sky130_fd_sc_hd__o31ai_1
Xinput23 net485 VSS VSS VDD VDD net22 sky130_fd_sc_hd__buf_1
X_18319_ _04828_ _06344_ net411 VSS VSS VDD VDD _02043_ sky130_fd_sc_hd__a21oi_1
X_18320_ network.neuron_in216.counter\[1\] network.neuron_in216.counter\[0\]
+ network.neuron_in216.counter\[2\] net424 VSS VSS VDD VDD _06346_
+ sky130_fd_sc_hd__nor4_1
X_18321_ network.in_period\[216\]\[3\] _06346_ _07160_ VSS
+ VSS VDD VDD _06347_ sky130_fd_sc_hd__mux2i_1
X_18322_ network.neuron_in216.counter\[1\] network.neuron_in216.counter\[0\]
+ network.neuron_in216.counter\[2\] network.neuron_in216.counter\[3\]
+ net352 VSS VSS VDD VDD _06348_ sky130_fd_sc_hd__o311a_1
X_18323_ network.in_period\[216\]\[3\] net424 _06348_ VSS
+ VSS VDD VDD _06349_ sky130_fd_sc_hd__a21oi_1
X_18324_ network.neuron_in216.counter\[3\] _06347_ _06349_
+ VSS VSS VDD VDD _02930_ sky130_fd_sc_hd__o21ai_0
X_18325_ network.neuron_in217.counter\[1\] network.neuron_in217.counter\[0\]
+ _01016_ VSS VSS VDD VDD _06350_ sky130_fd_sc_hd__o21bai_1
X_18326_ _07120_ _06350_ network.neuron_in217.counter\[3\]
+ VSS VSS VDD VDD _06351_ sky130_fd_sc_hd__a21oi_1
X_18327_ _07120_ network.neuron_in217.counter\[3\] _01015_
+ _01014_ _06351_ VSS VSS VDD VDD _06352_ sky130_fd_sc_hd__a41o_1
X_18328_ net343 _07165_ network.in_period\[217\]\[3\] VSS
+ VSS VDD VDD _06353_ sky130_fd_sc_hd__a21oi_1
X_18329_ net343 _06352_ _06353_ VSS VSS VDD VDD _02934_ sky130_fd_sc_hd__a21oi_1
X_18330_ _09407_ _09408_ network.in_spk04_07 VSS VSS VDD VDD
+ _06354_ sky130_fd_sc_hd__o21ai_0
X_18331_ _04830_ _06354_ net411 VSS VSS VDD VDD _02044_ sky130_fd_sc_hd__a21oi_1
X_18332_ network.neuron_in218.counter\[0\] network.neuron_in218.counter\[2\]
+ network.neuron_in218.counter\[1\] VSS VSS VDD VDD _06355_
+ sky130_fd_sc_hd__nor3_1
X_18333_ network.neuron_in218.counter\[3\] _06355_ VSS VSS
+ VDD VDD _06356_ sky130_fd_sc_hd__xnor2_1
X_18334_ network.in_period\[218\]\[3\] _07070_ VSS VSS VDD
+ VDD _06357_ sky130_fd_sc_hd__nand2_1
X_18335_ _07070_ _06356_ _06357_ VSS VSS VDD VDD _02938_ sky130_fd_sc_hd__o21ai_0
X_18336_ network.neuron_in219.counter\[1\] network.neuron_in219.counter\[0\]
+ network.neuron_in219.counter\[2\] VSS VSS VDD VDD _06358_
+ sky130_fd_sc_hd__nor3_1
X_18337_ network.neuron_in219.counter\[3\] _06358_ VSS VSS
+ VDD VDD _06359_ sky130_fd_sc_hd__xnor2_1
X_18338_ network.in_period\[219\]\[3\] _07232_ VSS VSS VDD
+ VDD _06360_ sky130_fd_sc_hd__nand2_1
X_18339_ _07232_ _06359_ _06360_ VSS VSS VDD VDD _02942_ sky130_fd_sc_hd__o21ai_0
X_18340_ _09406_ _09329_ VSS VSS VDD VDD _06361_ sky130_fd_sc_hd__nand2_1
X_18341_ network.in_spk02_07 _06361_ network.in_spk03_07 VSS
+ VSS VDD VDD _06362_ sky130_fd_sc_hd__o21ai_0
X_18342_ _04833_ _06362_ net411 VSS VSS VDD VDD _02045_ sky130_fd_sc_hd__a21oi_1
X_18343_ network.neuron_in220.counter\[1\] network.neuron_in220.counter\[0\]
+ _00924_ VSS VSS VDD VDD _06363_ sky130_fd_sc_hd__o21bai_1
X_18344_ _07196_ _06363_ network.neuron_in220.counter\[3\]
+ VSS VSS VDD VDD _06364_ sky130_fd_sc_hd__a21oi_1
X_18345_ _07196_ network.neuron_in220.counter\[3\] _00923_
+ _00922_ _06364_ VSS VSS VDD VDD _06365_ sky130_fd_sc_hd__a41o_1
X_18346_ net344 _07235_ network.in_period\[220\]\[3\] VSS
+ VSS VDD VDD _06366_ sky130_fd_sc_hd__a21oi_1
X_18347_ net344 _06365_ _06366_ VSS VSS VDD VDD _02946_ sky130_fd_sc_hd__a21oi_1
X_18348_ network.neuron_in221.counter\[1\] network.neuron_in221.counter\[0\]
+ network.neuron_in221.counter\[2\] VSS VSS VDD VDD _06367_
+ sky130_fd_sc_hd__nor3_1
X_18349_ network.neuron_in221.counter\[3\] _06367_ VSS VSS
+ VDD VDD _06368_ sky130_fd_sc_hd__xnor2_1
X_18350_ network.in_period\[221\]\[3\] _07184_ VSS VSS VDD
+ VDD _06369_ sky130_fd_sc_hd__nand2_1
X_18351_ _07184_ _06368_ _06369_ VSS VSS VDD VDD _02950_ sky130_fd_sc_hd__o21ai_0
X_18352_ network.neuron_in116.counter\[2\] net353 VSS VSS
+ VDD VDD _06370_ sky130_fd_sc_hd__nand2_1
X_18353_ network.neuron_in116.counter\[3\] network.in_period\[116\]\[2\]
+ _06370_ VSS VSS VDD VDD _06371_ sky130_fd_sc_hd__o21ai_0
X_18354_ _00072_ network.neuron_in116.counter\[2\] net419
+ VSS VSS VDD VDD _06372_ sky130_fd_sc_hd__or3_1
X_18355_ network.in_period\[116\]\[2\] net353 _06372_ VSS
+ VSS VDD VDD _06373_ sky130_fd_sc_hd__o21ai_0
X_18356_ _00072_ _06371_ _06373_ VSS VSS VDD VDD _02529_ sky130_fd_sc_hd__a21oi_1
X_18357_ network.in_spk02_07 _06361_ VSS VSS VDD VDD _06374_
+ sky130_fd_sc_hd__nand2_1
X_18358_ _04835_ _06374_ net411 VSS VSS VDD VDD _02046_ sky130_fd_sc_hd__a21oi_1
X_18359_ network.neuron_in222.counter\[1\] network.neuron_in222.counter\[0\]
+ _00821_ VSS VSS VDD VDD _06375_ sky130_fd_sc_hd__o21bai_1
X_18360_ _07205_ _06375_ network.neuron_in222.counter\[3\]
+ VSS VSS VDD VDD _06376_ sky130_fd_sc_hd__a21oi_1
X_18361_ _07205_ network.neuron_in222.counter\[3\] _00820_
+ _00819_ _06376_ VSS VSS VDD VDD _06377_ sky130_fd_sc_hd__a41o_1
X_18362_ net344 _07204_ network.in_period\[222\]\[3\] VSS
+ VSS VDD VDD _06378_ sky130_fd_sc_hd__a21oi_1
X_18363_ net344 _06377_ _06378_ VSS VSS VDD VDD _02954_ sky130_fd_sc_hd__a21oi_1
X_18364_ network.neuron_in117.counter\[2\] net355 VSS VSS
+ VDD VDD _06379_ sky130_fd_sc_hd__nand2_1
X_18365_ network.neuron_in117.counter\[3\] network.in_period\[117\]\[2\]
+ _06379_ VSS VSS VDD VDD _06380_ sky130_fd_sc_hd__o21ai_0
X_18366_ _00064_ network.neuron_in117.counter\[2\] net419
+ VSS VSS VDD VDD _06381_ sky130_fd_sc_hd__or3_1
X_18367_ network.in_period\[117\]\[2\] net355 _06381_ VSS
+ VSS VDD VDD _06382_ sky130_fd_sc_hd__o21ai_0
X_18368_ _00064_ _06380_ _06382_ VSS VSS VDD VDD _02533_ sky130_fd_sc_hd__a21oi_1
X_18369_ network.neuron_in223.counter\[1\] network.neuron_in223.counter\[0\]
+ _00866_ VSS VSS VDD VDD _06383_ sky130_fd_sc_hd__o21bai_1
X_18370_ _07187_ _06383_ network.neuron_in223.counter\[3\]
+ VSS VSS VDD VDD _06384_ sky130_fd_sc_hd__a21oi_1
X_18371_ _07187_ network.neuron_in223.counter\[3\] _00865_
+ _00864_ _06384_ VSS VSS VDD VDD _06385_ sky130_fd_sc_hd__a41o_1
X_18372_ net339 _07186_ network.in_period\[223\]\[3\] VSS
+ VSS VDD VDD _06386_ sky130_fd_sc_hd__a21oi_1
X_18373_ net339 _06385_ _06386_ VSS VSS VDD VDD _02958_ sky130_fd_sc_hd__a21oi_1
X_18374_ net354 _04826_ VSS VSS VDD VDD _06387_ sky130_fd_sc_hd__nand2_1
X_18375_ network.in_period\[118\]\[0\] _06387_ VSS VSS VDD
+ VDD _06388_ sky130_fd_sc_hd__nand2_1
X_18376_ network.neuron_in118.counter\[0\] _06387_ _06388_
+ VSS VSS VDD VDD _02535_ sky130_fd_sc_hd__o21ai_0
Xinput22 net488 VSS VSS VDD VDD net21 sky130_fd_sc_hd__buf_1
X_18378_ network.neuron_in119.counter\[3\] network.in_period\[119\]\[2\]
+ net411 _00653_ VSS VSS VDD VDD _06390_ sky130_fd_sc_hd__o22ai_1
X_18379_ network.neuron_in119.counter\[2\] _00653_ net355
+ VSS VSS VDD VDD _06391_ sky130_fd_sc_hd__nand3_1
X_18380_ network.in_period\[119\]\[2\] net355 _06391_ VSS
+ VSS VDD VDD _06392_ sky130_fd_sc_hd__o21ai_0
X_18381_ _04822_ _06390_ _06392_ VSS VSS VDD VDD _02541_ sky130_fd_sc_hd__a21oi_1
X_18382_ network.in_spk00_07 _09328_ network.in_spk01_07 VSS
+ VSS VDD VDD _06393_ sky130_fd_sc_hd__o21ai_0
X_18383_ _04839_ _06393_ net411 VSS VSS VDD VDD _02047_ sky130_fd_sc_hd__a21oi_1
X_18384_ network.neuron_in224.counter\[1\] network.neuron_in224.counter\[0\]
+ _00813_ VSS VSS VDD VDD _06394_ sky130_fd_sc_hd__o21bai_1
X_18385_ _07174_ _06394_ network.neuron_in224.counter\[3\]
+ VSS VSS VDD VDD _06395_ sky130_fd_sc_hd__a21oi_1
X_18386_ _07174_ network.neuron_in224.counter\[3\] _00812_
+ _00811_ _06395_ VSS VSS VDD VDD _06396_ sky130_fd_sc_hd__a41o_1
X_18387_ net347 _07253_ network.in_period\[224\]\[3\] VSS
+ VSS VDD VDD _06397_ sky130_fd_sc_hd__a21oi_1
X_18388_ net347 _06396_ _06397_ VSS VSS VDD VDD _02962_ sky130_fd_sc_hd__a21oi_1
X_18389_ network.neuron_in115.counter\[3\] network.in_period\[115\]\[2\]
+ net411 _01210_ VSS VSS VDD VDD _06398_ sky130_fd_sc_hd__o22ai_1
X_18390_ network.neuron_in115.counter\[2\] _01210_ net355
+ VSS VSS VDD VDD _06399_ sky130_fd_sc_hd__nand3_1
X_18391_ network.in_period\[115\]\[2\] net355 _06399_ VSS
+ VSS VDD VDD _06400_ sky130_fd_sc_hd__o21ai_0
X_18392_ _04832_ _06398_ _06400_ VSS VSS VDD VDD _02525_ sky130_fd_sc_hd__a21oi_1
X_18393_ network.in_period\[114\]\[0\] _06181_ VSS VSS VDD
+ VDD _06401_ sky130_fd_sc_hd__nand2_1
X_18394_ network.neuron_in114.counter\[0\] _06181_ _06401_
+ VSS VSS VDD VDD _02519_ sky130_fd_sc_hd__o21ai_0
X_18395_ network.neuron_in225.counter\[0\] network.neuron_in225.counter\[1\]
+ _00359_ VSS VSS VDD VDD _06402_ sky130_fd_sc_hd__o21bai_1
X_18396_ _07210_ _06402_ network.neuron_in225.counter\[3\]
+ VSS VSS VDD VDD _06403_ sky130_fd_sc_hd__a21oi_1
X_18397_ _07210_ network.neuron_in225.counter\[3\] _00357_
+ _00358_ _06403_ VSS VSS VDD VDD _06404_ sky130_fd_sc_hd__a41o_1
X_18398_ net348 _07216_ network.in_period\[225\]\[3\] VSS
+ VSS VDD VDD _06405_ sky130_fd_sc_hd__a21oi_1
X_18399_ net348 _06404_ _06405_ VSS VSS VDD VDD _02966_ sky130_fd_sc_hd__a21oi_1
X_18400_ net355 _04833_ VSS VSS VDD VDD _06406_ sky130_fd_sc_hd__nand2_1
X_18401_ network.in_period\[115\]\[1\] _06406_ VSS VSS VDD
+ VDD _06407_ sky130_fd_sc_hd__nand2_1
X_18402_ _01211_ _06406_ _06407_ VSS VSS VDD VDD _02524_ sky130_fd_sc_hd__o21ai_0
X_18403_ network.in_period\[115\]\[0\] _06406_ VSS VSS VDD
+ VDD _06408_ sky130_fd_sc_hd__nand2_1
X_18404_ network.neuron_in115.counter\[0\] _06406_ _06408_
+ VSS VSS VDD VDD _02523_ sky130_fd_sc_hd__o21ai_0
X_18405_ network.in_spk00_07 _09408_ VSS VSS VDD VDD _06409_
+ sky130_fd_sc_hd__nand2_1
X_18406_ _04842_ _06409_ net411 VSS VSS VDD VDD _02048_ sky130_fd_sc_hd__a21oi_1
X_18407_ net353 _04830_ VSS VSS VDD VDD _06410_ sky130_fd_sc_hd__nand2_1
X_18408_ network.in_period\[116\]\[1\] _06410_ VSS VSS VDD
+ VDD _06411_ sky130_fd_sc_hd__nand2_1
X_18409_ _00073_ _06410_ _06411_ VSS VSS VDD VDD _02528_ sky130_fd_sc_hd__o21ai_0
Xinput21 net489 VSS VSS VDD VDD net20 sky130_fd_sc_hd__buf_1
X_18411_ network.neuron_in226.counter\[1\] network.neuron_in226.counter\[0\]
+ _00817_ VSS VSS VDD VDD _06413_ sky130_fd_sc_hd__o21bai_1
X_18412_ _07191_ _06413_ network.neuron_in226.counter\[3\]
+ VSS VSS VDD VDD _06414_ sky130_fd_sc_hd__a21oi_1
X_18413_ _07191_ network.neuron_in226.counter\[3\] _00816_
+ _00815_ _06414_ VSS VSS VDD VDD _06415_ sky130_fd_sc_hd__a41o_1
X_18414_ net347 _07267_ network.in_period\[226\]\[3\] VSS
+ VSS VDD VDD _06416_ sky130_fd_sc_hd__a21oi_1
X_18415_ net347 _06415_ _06416_ VSS VSS VDD VDD _02970_ sky130_fd_sc_hd__a21oi_1
X_18416_ network.in_period\[116\]\[0\] _06410_ VSS VSS VDD
+ VDD _06417_ sky130_fd_sc_hd__nand2_1
X_18417_ network.neuron_in116.counter\[0\] _06410_ _06417_
+ VSS VSS VDD VDD _02527_ sky130_fd_sc_hd__o21ai_0
X_18418_ network.in_period\[117\]\[1\] _05697_ VSS VSS VDD
+ VDD _06418_ sky130_fd_sc_hd__nand2_1
X_18419_ _00065_ _05697_ _06418_ VSS VSS VDD VDD _02532_ sky130_fd_sc_hd__o21ai_0
X_18420_ network.in_period\[117\]\[0\] _05697_ VSS VSS VDD
+ VDD _06419_ sky130_fd_sc_hd__nand2_1
X_18421_ network.neuron_in117.counter\[0\] _05697_ _06419_
+ VSS VSS VDD VDD _02531_ sky130_fd_sc_hd__o21ai_0
X_18422_ network.neuron_in227.counter\[0\] network.neuron_in227.counter\[1\]
+ _00625_ VSS VSS VDD VDD _06420_ sky130_fd_sc_hd__o21bai_1
X_18423_ _07220_ _06420_ network.neuron_in227.counter\[3\]
+ VSS VSS VDD VDD _06421_ sky130_fd_sc_hd__a21oi_1
X_18424_ _07220_ network.neuron_in227.counter\[3\] _00623_
+ _00624_ _06421_ VSS VSS VDD VDD _06422_ sky130_fd_sc_hd__a41o_1
X_18425_ net348 _07283_ network.in_period\[227\]\[3\] VSS
+ VSS VDD VDD _06423_ sky130_fd_sc_hd__a21oi_1
X_18426_ net348 _06422_ _06423_ VSS VSS VDD VDD _02974_ sky130_fd_sc_hd__a21oi_1
X_18427_ network.neuron_in118.counter\[3\] network.in_period\[118\]\[2\]
+ net419 _00120_ VSS VSS VDD VDD _06424_ sky130_fd_sc_hd__o22ai_1
X_18428_ network.neuron_in118.counter\[2\] _00120_ net354
+ VSS VSS VDD VDD _06425_ sky130_fd_sc_hd__nand3_1
X_18429_ network.in_period\[118\]\[2\] net354 _06425_ VSS
+ VSS VDD VDD _06426_ sky130_fd_sc_hd__o21ai_0
X_18430_ _04824_ _06424_ _06426_ VSS VSS VDD VDD _02537_ sky130_fd_sc_hd__a21oi_1
X_18431_ network.in_period\[118\]\[1\] _06387_ VSS VSS VDD
+ VDD _06427_ sky130_fd_sc_hd__nand2_1
X_18432_ _00121_ _06387_ _06427_ VSS VSS VDD VDD _02536_ sky130_fd_sc_hd__o21ai_0
X_18433_ _09484_ _09483_ VSS VSS VDD VDD _06428_ sky130_fd_sc_hd__or2_1
X_18434_ network.in_spk10_06 network.in_spk11_06 _06428_ VSS
+ VSS VDD VDD _06429_ sky130_fd_sc_hd__or3_1
X_18435_ network.in_spk12_06 network.in_spk13_06 network.in_spk14_06
+ _06429_ network.in_spk15_06 VSS VSS VDD VDD _06430_ sky130_fd_sc_hd__o41ai_1
X_18436_ _04845_ _06430_ net411 VSS VSS VDD VDD _02049_ sky130_fd_sc_hd__a21oi_1
X_18437_ network.neuron_in228.counter\[0\] network.neuron_in228.counter\[1\]
+ VSS VSS VDD VDD _06431_ sky130_fd_sc_hd__nor2_1
X_18438_ _01094_ _06431_ VSS VSS VDD VDD _06432_ sky130_fd_sc_hd__nor2_1
X_18439_ network.neuron_in228.counter\[2\] _06432_ VSS VSS
+ VDD VDD _06433_ sky130_fd_sc_hd__nor2_1
X_18440_ network.neuron_in228.counter\[2\] network.neuron_in228.counter\[3\]
+ _06431_ VSS VSS VDD VDD _06434_ sky130_fd_sc_hd__nand3b_1
X_18441_ network.neuron_in228.counter\[3\] _06433_ _06434_
+ VSS VSS VDD VDD _06435_ sky130_fd_sc_hd__o21ai_0
X_18442_ net347 _07178_ network.in_period\[228\]\[3\] VSS
+ VSS VDD VDD _06436_ sky130_fd_sc_hd__a21oi_1
X_18443_ net347 _06435_ _06436_ VSS VSS VDD VDD _02978_ sky130_fd_sc_hd__a21oi_1
X_18444_ net355 _04823_ VSS VSS VDD VDD _06437_ sky130_fd_sc_hd__nand2_1
X_18445_ network.in_period\[119\]\[1\] _06437_ VSS VSS VDD
+ VDD _06438_ sky130_fd_sc_hd__nand2_1
X_18446_ _00654_ _06437_ _06438_ VSS VSS VDD VDD _02540_ sky130_fd_sc_hd__o21ai_0
X_18447_ network.in_period\[119\]\[0\] _06437_ VSS VSS VDD
+ VDD _06439_ sky130_fd_sc_hd__nand2_1
X_18448_ network.neuron_in119.counter\[0\] _06437_ _06439_
+ VSS VSS VDD VDD _02539_ sky130_fd_sc_hd__o21ai_0
X_18449_ network.neuron_in229.counter\[0\] network.neuron_in229.counter\[1\]
+ _00932_ VSS VSS VDD VDD _06440_ sky130_fd_sc_hd__o21bai_1
X_18450_ _07170_ _06440_ network.neuron_in229.counter\[3\]
+ VSS VSS VDD VDD _06441_ sky130_fd_sc_hd__a21oi_1
X_18451_ _07170_ network.neuron_in229.counter\[3\] _00930_
+ _00931_ _06441_ VSS VSS VDD VDD _06442_ sky130_fd_sc_hd__a41o_1
Xinput20 net490 VSS VSS VDD VDD net19 sky130_fd_sc_hd__buf_1
X_18453_ net358 _07568_ network.in_period\[229\]\[3\] VSS
+ VSS VDD VDD _06444_ sky130_fd_sc_hd__a21oi_1
X_18454_ net358 _06442_ _06444_ VSS VSS VDD VDD _02982_ sky130_fd_sc_hd__a21oi_1
X_18455_ network.in_spk12_06 network.in_spk13_06 _06429_ network.in_spk14_06
+ VSS VSS VDD VDD _06445_ sky130_fd_sc_hd__o31ai_1
X_18456_ _04848_ _06445_ net411 VSS VSS VDD VDD _02050_ sky130_fd_sc_hd__a21oi_1
X_18457_ network.neuron_in230.counter\[1\] network.neuron_in230.counter\[0\]
+ _00702_ VSS VSS VDD VDD _06446_ sky130_fd_sc_hd__o21bai_1
X_18458_ _07449_ _06446_ network.neuron_in230.counter\[3\]
+ VSS VSS VDD VDD _06447_ sky130_fd_sc_hd__a21oi_1
X_18459_ _07449_ network.neuron_in230.counter\[3\] _00701_
+ _00700_ _06447_ VSS VSS VDD VDD _06448_ sky130_fd_sc_hd__a41o_1
X_18460_ net347 _07573_ network.in_period\[230\]\[3\] VSS
+ VSS VDD VDD _06449_ sky130_fd_sc_hd__a21oi_1
X_18461_ net347 _06448_ _06449_ VSS VSS VDD VDD _02986_ sky130_fd_sc_hd__a21oi_1
X_18462_ network.neuron_in231.counter\[0\] network.neuron_in231.counter\[2\]
+ network.neuron_in231.counter\[1\] net412 VSS VSS VDD VDD _06450_
+ sky130_fd_sc_hd__nor4_1
X_18463_ network.in_period\[231\]\[3\] _06450_ _07293_ VSS
+ VSS VDD VDD _06451_ sky130_fd_sc_hd__mux2i_1
X_18464_ network.neuron_in231.counter\[0\] network.neuron_in231.counter\[2\]
+ network.neuron_in231.counter\[1\] net358 network.neuron_in231.counter\[3\]
+ VSS VSS VDD VDD _06452_ sky130_fd_sc_hd__o311a_1
X_18465_ network.in_period\[231\]\[3\] net412 _06452_ VSS
+ VSS VDD VDD _06453_ sky130_fd_sc_hd__a21oi_1
X_18466_ network.neuron_in231.counter\[3\] _06451_ _06453_
+ VSS VSS VDD VDD _02990_ sky130_fd_sc_hd__o21ai_0
X_18467_ network.in_spk12_06 _06429_ network.in_spk13_06 VSS
+ VSS VDD VDD _06454_ sky130_fd_sc_hd__o21ai_1
X_18468_ _04850_ _06454_ net411 VSS VSS VDD VDD _02051_ sky130_fd_sc_hd__a21oi_1
X_18469_ network.neuron_in232.counter\[0\] network.neuron_in232.counter\[1\]
+ _00527_ VSS VSS VDD VDD _06455_ sky130_fd_sc_hd__o21bai_1
X_18470_ _07458_ _06455_ network.neuron_in232.counter\[3\]
+ VSS VSS VDD VDD _06456_ sky130_fd_sc_hd__a21oi_1
X_18471_ _07458_ network.neuron_in232.counter\[3\] _00525_
+ _00526_ _06456_ VSS VSS VDD VDD _06457_ sky130_fd_sc_hd__a41o_1
X_18472_ net347 _07457_ network.in_period\[232\]\[3\] VSS
+ VSS VDD VDD _06458_ sky130_fd_sc_hd__a21oi_1
X_18473_ net347 _06457_ _06458_ VSS VSS VDD VDD _02994_ sky130_fd_sc_hd__a21oi_1
X_18474_ network.neuron_in233.counter\[1\] network.neuron_in233.counter\[0\]
+ _00996_ VSS VSS VDD VDD _06459_ sky130_fd_sc_hd__o21bai_1
X_18475_ _07298_ _06459_ network.neuron_in233.counter\[3\]
+ VSS VSS VDD VDD _06460_ sky130_fd_sc_hd__a21oi_1
X_18476_ _07298_ network.neuron_in233.counter\[3\] _00995_
+ _00994_ _06460_ VSS VSS VDD VDD _06461_ sky130_fd_sc_hd__a41o_1
X_18477_ net347 _07297_ network.in_period\[233\]\[3\] VSS
+ VSS VDD VDD _06462_ sky130_fd_sc_hd__a21oi_1
X_18478_ net347 _06461_ _06462_ VSS VSS VDD VDD _02998_ sky130_fd_sc_hd__a21oi_1
X_18479_ network.in_spk12_06 _06429_ VSS VSS VDD VDD _06463_
+ sky130_fd_sc_hd__nand2_1
X_18480_ _04853_ _06463_ net411 VSS VSS VDD VDD _02052_ sky130_fd_sc_hd__a21oi_1
X_18481_ network.neuron_in234.counter\[1\] network.neuron_in234.counter\[0\]
+ _00928_ VSS VSS VDD VDD _06464_ sky130_fd_sc_hd__o21bai_1
X_18482_ _07288_ _06464_ network.neuron_in234.counter\[3\]
+ VSS VSS VDD VDD _06465_ sky130_fd_sc_hd__a21oi_1
X_18483_ _07288_ network.neuron_in234.counter\[3\] _00927_
+ _00926_ _06465_ VSS VSS VDD VDD _06466_ sky130_fd_sc_hd__a41o_1
X_18484_ net348 _07463_ network.in_period\[234\]\[3\] VSS
+ VSS VDD VDD _06467_ sky130_fd_sc_hd__a21oi_1
X_18485_ net348 _06466_ _06467_ VSS VSS VDD VDD _03002_ sky130_fd_sc_hd__a21oi_1
X_18486_ network.neuron_in120.counter\[3\] network.in_period\[120\]\[2\]
+ net419 _00968_ VSS VSS VDD VDD _06468_ sky130_fd_sc_hd__o22ai_1
Xinput19 net487 VSS VSS VDD VDD net18 sky130_fd_sc_hd__buf_1
X_18488_ network.neuron_in120.counter\[2\] _00968_ net353
+ VSS VSS VDD VDD _06470_ sky130_fd_sc_hd__nand3_1
X_18489_ network.in_period\[120\]\[2\] net353 _06470_ VSS
+ VSS VDD VDD _06471_ sky130_fd_sc_hd__o21ai_0
X_18490_ _04819_ _06468_ _06471_ VSS VSS VDD VDD _02545_ sky130_fd_sc_hd__a21oi_1
X_18491_ network.neuron_in235.counter\[1\] network.neuron_in235.counter\[0\]
+ _00421_ VSS VSS VDD VDD _06472_ sky130_fd_sc_hd__o21bai_1
X_18492_ _07468_ _06472_ network.neuron_in235.counter\[3\]
+ VSS VSS VDD VDD _06473_ sky130_fd_sc_hd__a21oi_1
X_18493_ _07468_ network.neuron_in235.counter\[3\] _00420_
+ _00419_ _06473_ VSS VSS VDD VDD _06474_ sky130_fd_sc_hd__a41o_1
X_18494_ net359 _07467_ network.in_period\[235\]\[3\] VSS
+ VSS VDD VDD _06475_ sky130_fd_sc_hd__a21oi_1
X_18495_ net359 _06474_ _06475_ VSS VSS VDD VDD _03006_ sky130_fd_sc_hd__a21oi_1
X_18496_ network.in_spk10_06 _06428_ network.in_spk11_06 VSS
+ VSS VDD VDD _06476_ sky130_fd_sc_hd__o21ai_0
X_18497_ _04856_ _06476_ net411 VSS VSS VDD VDD _02053_ sky130_fd_sc_hd__a21oi_1
X_18498_ network.neuron_in236.counter\[0\] network.neuron_in236.counter\[1\]
+ network.neuron_in236.counter\[2\] net421 VSS VSS VDD VDD _06477_
+ sky130_fd_sc_hd__nor4_1
X_18499_ network.in_period\[236\]\[3\] _06477_ _07564_ VSS
+ VSS VDD VDD _06478_ sky130_fd_sc_hd__mux2i_1
X_18500_ network.neuron_in236.counter\[0\] network.neuron_in236.counter\[1\]
+ network.neuron_in236.counter\[2\] network.neuron_in236.counter\[3\]
+ net359 VSS VSS VDD VDD _06479_ sky130_fd_sc_hd__o311a_1
X_18501_ network.in_period\[236\]\[3\] net421 _06479_ VSS
+ VSS VDD VDD _06480_ sky130_fd_sc_hd__a21oi_1
X_18502_ network.neuron_in236.counter\[3\] _06478_ _06480_
+ VSS VSS VDD VDD _03010_ sky130_fd_sc_hd__o21ai_0
X_18503_ net353 _04820_ VSS VSS VDD VDD _06481_ sky130_fd_sc_hd__nand2_1
X_18504_ network.in_period\[120\]\[1\] _06481_ VSS VSS VDD
+ VDD _06482_ sky130_fd_sc_hd__nand2_1
X_18505_ _00969_ _06481_ _06482_ VSS VSS VDD VDD _02544_ sky130_fd_sc_hd__o21ai_0
X_18506_ network.in_period\[120\]\[0\] _06481_ VSS VSS VDD
+ VDD _06483_ sky130_fd_sc_hd__nand2_1
X_18507_ network.neuron_in120.counter\[0\] _06481_ _06483_
+ VSS VSS VDD VDD _02543_ sky130_fd_sc_hd__o21ai_0
X_18508_ network.neuron_in237.counter\[1\] network.neuron_in237.counter\[2\]
+ network.neuron_in237.counter\[0\] VSS VSS VDD VDD _06484_
+ sky130_fd_sc_hd__nor3_1
X_18509_ network.neuron_in237.counter\[3\] _06484_ VSS VSS
+ VDD VDD _06485_ sky130_fd_sc_hd__xnor2_1
X_18510_ network.in_period\[237\]\[3\] _07718_ VSS VSS VDD
+ VDD _06486_ sky130_fd_sc_hd__nand2_1
X_18511_ _07718_ _06485_ _06486_ VSS VSS VDD VDD _03014_ sky130_fd_sc_hd__o21ai_0
X_18512_ network.in_spk10_06 _06428_ VSS VSS VDD VDD _06487_
+ sky130_fd_sc_hd__nand2_1
X_18513_ _04859_ _06487_ net411 VSS VSS VDD VDD _02054_ sky130_fd_sc_hd__a21oi_1
X_18514_ network.neuron_in238.counter\[0\] network.neuron_in238.counter\[1\]
+ _00807_ VSS VSS VDD VDD _06488_ sky130_fd_sc_hd__o21bai_1
X_18515_ _07721_ _06488_ network.neuron_in238.counter\[3\]
+ VSS VSS VDD VDD _06489_ sky130_fd_sc_hd__a21oi_1
X_18516_ _07721_ network.neuron_in238.counter\[3\] _00805_
+ _00806_ _06489_ VSS VSS VDD VDD _06490_ sky130_fd_sc_hd__a41o_1
X_18517_ net359 _07720_ network.in_period\[238\]\[3\] VSS
+ VSS VDD VDD _06491_ sky130_fd_sc_hd__a21oi_1
X_18518_ net359 _06490_ _06491_ VSS VSS VDD VDD _03018_ sky130_fd_sc_hd__a21oi_1
X_18519_ network.neuron_in239.counter\[0\] network.neuron_in239.counter\[1\]
+ network.neuron_in239.counter\[2\] net413 VSS VSS VDD VDD _06492_
+ sky130_fd_sc_hd__nor4_1
X_18520_ network.in_period\[239\]\[3\] _06492_ _07725_ VSS
+ VSS VDD VDD _06493_ sky130_fd_sc_hd__mux2i_1
X_18521_ network.neuron_in239.counter\[0\] network.neuron_in239.counter\[1\]
+ network.neuron_in239.counter\[2\] network.neuron_in239.counter\[3\]
+ net359 VSS VSS VDD VDD _06494_ sky130_fd_sc_hd__o311a_1
X_18522_ network.in_period\[239\]\[3\] net413 _06494_ VSS
+ VSS VDD VDD _06495_ sky130_fd_sc_hd__a21oi_1
X_18523_ network.neuron_in239.counter\[3\] _06493_ _06495_
+ VSS VSS VDD VDD _03022_ sky130_fd_sc_hd__o21ai_0
X_18524_ network.neuron_in121.counter\[2\] VSS VSS VDD VDD
+ _06496_ sky130_fd_sc_hd__inv_1
X_18525_ network.neuron_in121.counter\[3\] network.in_period\[121\]\[2\]
+ net419 _00641_ VSS VSS VDD VDD _06497_ sky130_fd_sc_hd__o22ai_1
X_18526_ network.neuron_in121.counter\[2\] _00641_ net353
+ VSS VSS VDD VDD _06498_ sky130_fd_sc_hd__nand3_1
X_18527_ network.in_period\[121\]\[2\] net353 _06498_ VSS
+ VSS VDD VDD _06499_ sky130_fd_sc_hd__o21ai_0
X_18528_ _06496_ _06497_ _06499_ VSS VSS VDD VDD _02549_ sky130_fd_sc_hd__a21oi_1
X_18529_ network.in_period\[121\]\[1\] _05716_ VSS VSS VDD
+ VDD _06500_ sky130_fd_sc_hd__nand2_1
X_18530_ _00642_ _05716_ _06500_ VSS VSS VDD VDD _02548_ sky130_fd_sc_hd__o21ai_0
X_18531_ _09391_ _09393_ _09354_ VSS VSS VDD VDD _06501_ sky130_fd_sc_hd__or3_1
X_18532_ network.in_spk08_06 _06501_ network.in_spk09_06 VSS
+ VSS VDD VDD _06502_ sky130_fd_sc_hd__o21ai_0
X_18533_ _04862_ _06502_ net412 VSS VSS VDD VDD _02055_ sky130_fd_sc_hd__a21oi_1
X_18534_ network.in_period\[121\]\[0\] _05716_ VSS VSS VDD
+ VDD _06503_ sky130_fd_sc_hd__nand2_1
X_18535_ network.neuron_in121.counter\[0\] _05716_ _06503_
+ VSS VSS VDD VDD _02547_ sky130_fd_sc_hd__o21ai_0
X_18536_ network.neuron_in240.counter\[1\] network.neuron_in240.counter\[0\]
+ _00429_ VSS VSS VDD VDD _06504_ sky130_fd_sc_hd__o21bai_1
X_18537_ _07730_ _06504_ network.neuron_in240.counter\[3\]
+ VSS VSS VDD VDD _06505_ sky130_fd_sc_hd__a21oi_1
X_18538_ _07730_ network.neuron_in240.counter\[3\] _00428_
+ _00427_ _06505_ VSS VSS VDD VDD _06506_ sky130_fd_sc_hd__a41o_1
X_18539_ net364 _07729_ network.in_period\[240\]\[3\] VSS
+ VSS VDD VDD _06507_ sky130_fd_sc_hd__a21oi_1
X_18540_ net364 _06506_ _06507_ VSS VSS VDD VDD _03026_ sky130_fd_sc_hd__a21oi_1
X_18541_ network.neuron_in241.counter\[2\] VSS VSS VDD VDD
+ _06508_ sky130_fd_sc_hd__inv_1
X_18542_ _00909_ _06508_ _00908_ net365 VSS VSS VDD VDD _06509_
+ sky130_fd_sc_hd__nand4_1
X_18543_ _06508_ _00910_ _06509_ VSS VSS VDD VDD _06510_ sky130_fd_sc_hd__a21oi_1
X_18544_ _06508_ _00910_ network.in_period\[241\]\[3\] _06510_
+ VSS VSS VDD VDD _06511_ sky130_fd_sc_hd__a31oi_1
X_18545_ network.neuron_in241.counter\[1\] network.neuron_in241.counter\[2\]
+ network.neuron_in241.counter\[0\] net365 network.neuron_in241.counter\[3\]
+ VSS VSS VDD VDD _06512_ sky130_fd_sc_hd__o311a_1
X_18546_ network.in_period\[241\]\[3\] net417 _06512_ VSS
+ VSS VDD VDD _06513_ sky130_fd_sc_hd__a21oi_1
X_18547_ network.neuron_in241.counter\[3\] _06511_ _06513_
+ VSS VSS VDD VDD _03030_ sky130_fd_sc_hd__o21ai_0
X_18548_ network.in_spk08_06 _06501_ _04865_ VSS VSS VDD VDD
+ _06514_ sky130_fd_sc_hd__a21boi_0
X_18549_ net412 _06514_ VSS VSS VDD VDD _02056_ sky130_fd_sc_hd__nor2_1
X_18550_ network.neuron_in242.counter\[0\] network.neuron_in242.counter\[1\]
+ _01188_ VSS VSS VDD VDD _06515_ sky130_fd_sc_hd__o21bai_1
X_18551_ _07758_ _06515_ network.neuron_in242.counter\[3\]
+ VSS VSS VDD VDD _06516_ sky130_fd_sc_hd__a21oi_1
X_18552_ _07758_ _01186_ network.neuron_in242.counter\[3\]
+ _01187_ _06516_ VSS VSS VDD VDD _06517_ sky130_fd_sc_hd__a41o_1
X_18553_ net365 _07785_ network.in_period\[242\]\[3\] VSS
+ VSS VDD VDD _06518_ sky130_fd_sc_hd__a21oi_1
X_18554_ net365 _06517_ _06518_ VSS VSS VDD VDD _03034_ sky130_fd_sc_hd__a21oi_1
X_18555_ net353 _04812_ VSS VSS VDD VDD _06519_ sky130_fd_sc_hd__nand2_1
X_18556_ network.in_period\[123\]\[1\] _06519_ VSS VSS VDD
+ VDD _06520_ sky130_fd_sc_hd__nand2_1
X_18557_ _00242_ _06519_ _06520_ VSS VSS VDD VDD _02556_ sky130_fd_sc_hd__o21ai_0
X_18558_ network.neuron_in122.counter\[3\] network.in_period\[122\]\[2\]
+ net420 _01052_ VSS VSS VDD VDD _06521_ sky130_fd_sc_hd__o22ai_1
X_18559_ network.neuron_in122.counter\[2\] _01052_ net353
+ VSS VSS VDD VDD _06522_ sky130_fd_sc_hd__nand3_1
X_18560_ network.in_period\[122\]\[2\] net353 _06522_ VSS
+ VSS VDD VDD _06523_ sky130_fd_sc_hd__o21ai_0
X_18561_ _04814_ _06521_ _06523_ VSS VSS VDD VDD _02553_ sky130_fd_sc_hd__a21oi_1
X_18562_ network.neuron_in243.counter\[0\] network.neuron_in243.counter\[1\]
+ network.neuron_in243.counter\[2\] net415 VSS VSS VDD VDD _06524_
+ sky130_fd_sc_hd__nor4_1
X_18563_ network.in_period\[243\]\[3\] _06524_ _07767_ VSS
+ VSS VDD VDD _06525_ sky130_fd_sc_hd__mux2i_1
X_18564_ network.neuron_in243.counter\[0\] network.neuron_in243.counter\[1\]
+ network.neuron_in243.counter\[2\] network.neuron_in243.counter\[3\]
+ net364 VSS VSS VDD VDD _06526_ sky130_fd_sc_hd__o311a_1
X_18565_ network.in_period\[243\]\[3\] net415 _06526_ VSS
+ VSS VDD VDD _06527_ sky130_fd_sc_hd__a21oi_1
X_18566_ network.neuron_in243.counter\[3\] _06525_ _06527_
+ VSS VSS VDD VDD _03038_ sky130_fd_sc_hd__o21ai_0
X_18567_ net353 _04815_ VSS VSS VDD VDD _06528_ sky130_fd_sc_hd__nand2_1
X_18568_ network.in_period\[122\]\[1\] _06528_ VSS VSS VDD
+ VDD _06529_ sky130_fd_sc_hd__nand2_1
X_18569_ _01053_ _06528_ _06529_ VSS VSS VDD VDD _02552_ sky130_fd_sc_hd__o21ai_0
X_18570_ network.in_period\[122\]\[0\] _06528_ VSS VSS VDD
+ VDD _06530_ sky130_fd_sc_hd__nand2_1
X_18571_ network.neuron_in122.counter\[0\] _06528_ _06530_
+ VSS VSS VDD VDD _02551_ sky130_fd_sc_hd__o21ai_0
X_18572_ _09391_ _09483_ VSS VSS VDD VDD _06531_ sky130_fd_sc_hd__nor2_1
X_18573_ _09392_ _06531_ VSS VSS VDD VDD _06532_ sky130_fd_sc_hd__nand2_1
X_18574_ network.in_spk07_06 _06532_ _04869_ VSS VSS VDD VDD
+ _06533_ sky130_fd_sc_hd__a21boi_0
X_18575_ net412 _06533_ VSS VSS VDD VDD _02057_ sky130_fd_sc_hd__nor2_1
X_18576_ network.neuron_in123.counter\[3\] network.in_period\[123\]\[2\]
+ net419 _00241_ VSS VSS VDD VDD _06534_ sky130_fd_sc_hd__o22ai_1
X_18577_ network.neuron_in123.counter\[2\] _00241_ net353
+ VSS VSS VDD VDD _06535_ sky130_fd_sc_hd__nand3_1
X_18578_ network.in_period\[123\]\[2\] net353 _06535_ VSS
+ VSS VDD VDD _06536_ sky130_fd_sc_hd__o21ai_0
X_18579_ _04810_ _06534_ _06536_ VSS VSS VDD VDD _02557_ sky130_fd_sc_hd__a21oi_1
X_18580_ network.neuron_in244.counter\[1\] network.neuron_in244.counter\[0\]
+ VSS VSS VDD VDD _06537_ sky130_fd_sc_hd__nor2_1
X_18581_ _00670_ _06537_ VSS VSS VDD VDD _06538_ sky130_fd_sc_hd__nor2_1
X_18582_ network.neuron_in244.counter\[2\] _06538_ VSS VSS
+ VDD VDD _06539_ sky130_fd_sc_hd__nor2_1
X_18583_ network.neuron_in244.counter\[2\] network.neuron_in244.counter\[3\]
+ _06537_ VSS VSS VDD VDD _06540_ sky130_fd_sc_hd__nand3b_1
X_18584_ network.neuron_in244.counter\[3\] _06539_ _06540_
+ VSS VSS VDD VDD _06541_ sky130_fd_sc_hd__o21ai_0
X_18585_ net348 _07917_ network.in_period\[244\]\[3\] VSS
+ VSS VDD VDD _06542_ sky130_fd_sc_hd__a21oi_1
X_18586_ net348 _06541_ _06542_ VSS VSS VDD VDD _03042_ sky130_fd_sc_hd__a21oi_1
X_18587_ network.neuron_in245.counter\[1\] network.neuron_in245.counter\[0\]
+ _00906_ VSS VSS VDD VDD _06543_ sky130_fd_sc_hd__o21bai_1
X_18588_ _07775_ _06543_ network.neuron_in245.counter\[3\]
+ VSS VSS VDD VDD _06544_ sky130_fd_sc_hd__a21oi_1
X_18589_ _07775_ _00905_ network.neuron_in245.counter\[3\]
+ _00904_ _06544_ VSS VSS VDD VDD _06545_ sky130_fd_sc_hd__a41o_1
X_18590_ net348 _08193_ network.in_period\[245\]\[3\] VSS
+ VSS VDD VDD _06546_ sky130_fd_sc_hd__a21oi_1
X_18591_ net348 _06545_ _06546_ VSS VSS VDD VDD _03046_ sky130_fd_sc_hd__a21oi_1
X_18592_ _09391_ _09483_ VSS VSS VDD VDD _06547_ sky130_fd_sc_hd__or2_2
X_18593_ network.in_spk04_06 network.in_spk05_06 _06547_ network.in_spk06_06
+ VSS VSS VDD VDD _06548_ sky130_fd_sc_hd__o31ai_1
X_18594_ _04872_ _06548_ net412 VSS VSS VDD VDD _02058_ sky130_fd_sc_hd__a21oi_1
X_18595_ network.neuron_in246.counter\[2\] VSS VSS VDD VDD
+ _06549_ sky130_fd_sc_hd__inv_1
X_18596_ network.neuron_in246.counter\[0\] network.neuron_in246.counter\[1\]
+ VSS VSS VDD VDD _06550_ sky130_fd_sc_hd__nor2_1
X_18597_ network.neuron_in246.counter\[2\] _00453_ net415
+ _06550_ VSS VSS VDD VDD _06551_ sky130_fd_sc_hd__nor4b_1
X_18598_ _06549_ _00453_ network.in_period\[246\]\[3\] _06551_
+ VSS VSS VDD VDD _06552_ sky130_fd_sc_hd__a31oi_1
X_18599_ network.neuron_in246.counter\[0\] network.neuron_in246.counter\[1\]
+ network.neuron_in246.counter\[2\] network.neuron_in246.counter\[3\]
+ net364 VSS VSS VDD VDD _06553_ sky130_fd_sc_hd__o311a_1
X_18600_ network.in_period\[246\]\[3\] net415 _06553_ VSS
+ VSS VDD VDD _06554_ sky130_fd_sc_hd__a21oi_1
X_18601_ network.neuron_in246.counter\[3\] _06552_ _06554_
+ VSS VSS VDD VDD _03050_ sky130_fd_sc_hd__o21ai_0
X_18602_ network.in_period\[123\]\[0\] _06519_ VSS VSS VDD
+ VDD _06555_ sky130_fd_sc_hd__nand2_1
X_18603_ network.neuron_in123.counter\[0\] _06519_ _06555_
+ VSS VSS VDD VDD _02555_ sky130_fd_sc_hd__o21ai_0
X_18604_ network.neuron_in124.counter\[3\] network.in_period\[124\]\[2\]
+ net420 _00405_ VSS VSS VDD VDD _06556_ sky130_fd_sc_hd__o22ai_1
X_18605_ network.neuron_in124.counter\[2\] _00405_ net354
+ VSS VSS VDD VDD _06557_ sky130_fd_sc_hd__nand3_1
X_18606_ network.in_period\[124\]\[2\] net354 _06557_ VSS
+ VSS VDD VDD _06558_ sky130_fd_sc_hd__o21ai_0
X_18607_ _04807_ _06556_ _06558_ VSS VSS VDD VDD _02561_ sky130_fd_sc_hd__a21oi_1
X_18608_ network.neuron_in247.counter\[0\] network.neuron_in247.counter\[1\]
+ _00613_ VSS VSS VDD VDD _06559_ sky130_fd_sc_hd__o21bai_1
X_18609_ _08212_ _06559_ network.neuron_in247.counter\[3\]
+ VSS VSS VDD VDD _06560_ sky130_fd_sc_hd__a21oi_1
X_18610_ _08212_ _00611_ _00612_ network.neuron_in247.counter\[3\]
+ _06560_ VSS VSS VDD VDD _06561_ sky130_fd_sc_hd__a41o_1
X_18611_ net365 _08211_ network.in_period\[247\]\[3\] VSS
+ VSS VDD VDD _06562_ sky130_fd_sc_hd__a21oi_1
X_18612_ net365 _06561_ _06562_ VSS VSS VDD VDD _03054_ sky130_fd_sc_hd__a21oi_1
X_18613_ net354 _04808_ VSS VSS VDD VDD _06563_ sky130_fd_sc_hd__nand2_1
X_18614_ network.in_period\[124\]\[1\] _06563_ VSS VSS VDD
+ VDD _06564_ sky130_fd_sc_hd__nand2_1
X_18615_ _00406_ _06563_ _06564_ VSS VSS VDD VDD _02560_ sky130_fd_sc_hd__o21ai_0
X_18616_ network.in_period\[124\]\[0\] _06563_ VSS VSS VDD
+ VDD _06565_ sky130_fd_sc_hd__nand2_1
X_18617_ network.neuron_in124.counter\[0\] _06563_ _06565_
+ VSS VSS VDD VDD _02559_ sky130_fd_sc_hd__o21ai_0
X_18618_ network.in_spk04_06 _06547_ network.in_spk05_06 VSS
+ VSS VDD VDD _06566_ sky130_fd_sc_hd__o21ai_0
X_18619_ _04874_ _06566_ net412 VSS VSS VDD VDD _02059_ sky130_fd_sc_hd__a21oi_1
X_18620_ network.neuron_in125.counter\[2\] net353 VSS VSS
+ VDD VDD _06567_ sky130_fd_sc_hd__nand2_1
X_18621_ network.neuron_in125.counter\[3\] network.in_period\[125\]\[2\]
+ _06567_ VSS VSS VDD VDD _06568_ sky130_fd_sc_hd__o21ai_0
X_18622_ _00597_ network.neuron_in125.counter\[2\] net420
+ VSS VSS VDD VDD _06569_ sky130_fd_sc_hd__or3_1
X_18623_ network.in_period\[125\]\[2\] net353 _06569_ VSS
+ VSS VDD VDD _06570_ sky130_fd_sc_hd__o21ai_0
X_18624_ _00597_ _06568_ _06570_ VSS VSS VDD VDD _02565_ sky130_fd_sc_hd__a21oi_1
X_18625_ network.neuron_in248.counter\[0\] network.neuron_in248.counter\[1\]
+ _00463_ VSS VSS VDD VDD _06571_ sky130_fd_sc_hd__o21bai_1
X_18626_ _08217_ _06571_ network.neuron_in248.counter\[3\]
+ VSS VSS VDD VDD _06572_ sky130_fd_sc_hd__a21oi_1
X_18627_ _08217_ network.neuron_in248.counter\[3\] _00461_
+ _00462_ _06572_ VSS VSS VDD VDD _06573_ sky130_fd_sc_hd__a41o_1
X_18628_ net364 _08216_ network.in_period\[248\]\[3\] VSS
+ VSS VDD VDD _06574_ sky130_fd_sc_hd__a21oi_1
X_18629_ net364 _06573_ _06574_ VSS VSS VDD VDD _03058_ sky130_fd_sc_hd__a21oi_1
X_18630_ net353 _04805_ VSS VSS VDD VDD _06575_ sky130_fd_sc_hd__nand2_1
X_18631_ network.in_period\[125\]\[1\] _06575_ VSS VSS VDD
+ VDD _06576_ sky130_fd_sc_hd__nand2_1
X_18632_ _00598_ _06575_ _06576_ VSS VSS VDD VDD _02564_ sky130_fd_sc_hd__o21ai_0
X_18633_ network.neuron_in249.counter\[1\] network.neuron_in249.counter\[0\]
+ _01146_ VSS VSS VDD VDD _06577_ sky130_fd_sc_hd__o21bai_1
X_18634_ _08222_ _06577_ network.neuron_in249.counter\[3\]
+ VSS VSS VDD VDD _06578_ sky130_fd_sc_hd__a21oi_1
X_18635_ _08222_ network.neuron_in249.counter\[3\] _01145_
+ _01144_ _06578_ VSS VSS VDD VDD _06579_ sky130_fd_sc_hd__a41o_1
X_18636_ net364 _08221_ network.in_period\[249\]\[3\] VSS
+ VSS VDD VDD _06580_ sky130_fd_sc_hd__a21oi_1
X_18637_ net364 _06579_ _06580_ VSS VSS VDD VDD _03062_ sky130_fd_sc_hd__a21oi_1
X_18638_ network.in_spk04_06 _06547_ VSS VSS VDD VDD _06581_
+ sky130_fd_sc_hd__nand2_1
X_18639_ _04877_ _06581_ net412 VSS VSS VDD VDD _02060_ sky130_fd_sc_hd__a21oi_1
X_18640_ network.neuron_in250.counter\[1\] network.neuron_in250.counter\[0\]
+ network.neuron_in250.counter\[2\] net416 VSS VSS VDD VDD _06582_
+ sky130_fd_sc_hd__nor4_1
X_18641_ network.in_period\[250\]\[3\] _06582_ _08384_ VSS
+ VSS VDD VDD _06583_ sky130_fd_sc_hd__mux2i_1
X_18642_ network.neuron_in250.counter\[1\] network.neuron_in250.counter\[0\]
+ network.neuron_in250.counter\[2\] network.neuron_in250.counter\[3\]
+ net348 VSS VSS VDD VDD _06584_ sky130_fd_sc_hd__o311a_1
X_18643_ network.in_period\[250\]\[3\] net416 _06584_ VSS
+ VSS VDD VDD _06585_ sky130_fd_sc_hd__a21oi_1
X_18644_ network.neuron_in250.counter\[3\] _06583_ _06585_
+ VSS VSS VDD VDD _03066_ sky130_fd_sc_hd__o21ai_0
X_18645_ network.neuron_in251.counter\[0\] network.neuron_in251.counter\[1\]
+ _00475_ VSS VSS VDD VDD _06586_ sky130_fd_sc_hd__o21bai_1
X_18646_ _08226_ _06586_ network.neuron_in251.counter\[3\]
+ VSS VSS VDD VDD _06587_ sky130_fd_sc_hd__a21oi_1
X_18647_ _08226_ network.neuron_in251.counter\[3\] _00473_
+ _00474_ _06587_ VSS VSS VDD VDD _06588_ sky130_fd_sc_hd__a41o_1
X_18648_ net365 _08389_ network.in_period\[251\]\[3\] VSS
+ VSS VDD VDD _06589_ sky130_fd_sc_hd__a21oi_1
X_18649_ net365 _06588_ _06589_ VSS VSS VDD VDD _03070_ sky130_fd_sc_hd__a21oi_1
X_18650_ network.in_period\[125\]\[0\] _06575_ VSS VSS VDD
+ VDD _06590_ sky130_fd_sc_hd__nand2_1
X_18651_ network.neuron_in125.counter\[0\] _06575_ _06590_
+ VSS VSS VDD VDD _02563_ sky130_fd_sc_hd__o21ai_0
X_18652_ network.neuron_in126.counter\[3\] network.in_period\[126\]\[2\]
+ net420 _00767_ VSS VSS VDD VDD _06591_ sky130_fd_sc_hd__o22ai_1
X_18653_ network.neuron_in126.counter\[2\] _00767_ net353
+ VSS VSS VDD VDD _06592_ sky130_fd_sc_hd__nand3_1
X_18654_ network.in_period\[126\]\[2\] net353 _06592_ VSS
+ VSS VDD VDD _06593_ sky130_fd_sc_hd__o21ai_0
X_18655_ _04802_ _06591_ _06593_ VSS VSS VDD VDD _02569_ sky130_fd_sc_hd__a21oi_1
X_18656_ network.in_spk02_06 network.in_spk00_06 network.in_spk01_06
+ _09483_ network.in_spk03_06 VSS VSS VDD VDD _06594_ sky130_fd_sc_hd__o41ai_1
X_18657_ _04880_ _06594_ net412 VSS VSS VDD VDD _02061_ sky130_fd_sc_hd__a21oi_1
X_18658_ net353 _04803_ VSS VSS VDD VDD _06595_ sky130_fd_sc_hd__nand2_1
X_18659_ network.in_period\[126\]\[1\] _06595_ VSS VSS VDD
+ VDD _06596_ sky130_fd_sc_hd__nand2_1
X_18660_ _00768_ _06595_ _06596_ VSS VSS VDD VDD _02568_ sky130_fd_sc_hd__o21ai_0
X_18661_ network.neuron_in252.counter\[0\] network.neuron_in252.counter\[1\]
+ _00487_ VSS VSS VDD VDD _06597_ sky130_fd_sc_hd__o21bai_1
X_18662_ _08395_ _06597_ network.neuron_in252.counter\[3\]
+ VSS VSS VDD VDD _06598_ sky130_fd_sc_hd__a21oi_1
X_18663_ _08395_ _00485_ network.neuron_in252.counter\[3\]
+ _00486_ _06598_ VSS VSS VDD VDD _06599_ sky130_fd_sc_hd__a41o_1
X_18664_ net360 _08394_ network.in_period\[252\]\[3\] VSS
+ VSS VDD VDD _06600_ sky130_fd_sc_hd__a21oi_1
X_18665_ net360 _06599_ _06600_ VSS VSS VDD VDD _03074_ sky130_fd_sc_hd__a21oi_1
X_18666_ network.in_period\[126\]\[0\] _06595_ VSS VSS VDD
+ VDD _06601_ sky130_fd_sc_hd__nand2_1
X_18667_ network.neuron_in126.counter\[0\] _06595_ _06601_
+ VSS VSS VDD VDD _02567_ sky130_fd_sc_hd__o21ai_0
X_18668_ network.neuron_in127.counter\[2\] net353 VSS VSS
+ VDD VDD _06602_ sky130_fd_sc_hd__nand2_1
X_18669_ network.neuron_in127.counter\[3\] network.in_period\[127\]\[2\]
+ _06602_ VSS VSS VDD VDD _06603_ sky130_fd_sc_hd__o21ai_0
X_18670_ _01114_ network.neuron_in127.counter\[2\] net420
+ VSS VSS VDD VDD _06604_ sky130_fd_sc_hd__or3_1
X_18671_ network.in_period\[127\]\[2\] net353 _06604_ VSS
+ VSS VDD VDD _06605_ sky130_fd_sc_hd__o21ai_0
X_18672_ _01114_ _06603_ _06605_ VSS VSS VDD VDD _02573_ sky130_fd_sc_hd__a21oi_1
X_18673_ network.in_period\[127\]\[1\] _05745_ VSS VSS VDD
+ VDD _06606_ sky130_fd_sc_hd__nand2_1
X_18674_ _01115_ _05745_ _06606_ VSS VSS VDD VDD _02572_ sky130_fd_sc_hd__o21ai_0
X_18675_ network.neuron_in253.counter\[0\] network.neuron_in253.counter\[2\]
+ network.neuron_in253.counter\[1\] VSS VSS VDD VDD _06607_
+ sky130_fd_sc_hd__nor3_1
X_18676_ network.neuron_in253.counter\[3\] _06607_ VSS VSS
+ VDD VDD _06608_ sky130_fd_sc_hd__xnor2_1
X_18677_ network.in_period\[253\]\[3\] _08401_ VSS VSS VDD
+ VDD _06609_ sky130_fd_sc_hd__nand2_1
X_18678_ _08401_ _06608_ _06609_ VSS VSS VDD VDD _03078_ sky130_fd_sc_hd__o21ai_0
X_18679_ network.in_period\[127\]\[0\] _05745_ VSS VSS VDD
+ VDD _06610_ sky130_fd_sc_hd__nand2_1
X_18680_ network.neuron_in127.counter\[0\] _05745_ _06610_
+ VSS VSS VDD VDD _02571_ sky130_fd_sc_hd__o21ai_0
X_18681_ network.in_spk00_06 network.in_spk01_06 _09483_ network.in_spk02_06
+ VSS VSS VDD VDD _06611_ sky130_fd_sc_hd__o31ai_1
X_18682_ _04883_ _06611_ net412 VSS VSS VDD VDD _02062_ sky130_fd_sc_hd__a21oi_1
X_18683_ network.neuron_in254.counter\[0\] network.neuron_in254.counter\[2\]
+ network.neuron_in254.counter\[1\] net417 VSS VSS VDD VDD _06612_
+ sky130_fd_sc_hd__nor4_1
X_18684_ network.in_period\[254\]\[3\] _06612_ _08404_ VSS
+ VSS VDD VDD _06613_ sky130_fd_sc_hd__mux2i_1
X_18685_ network.neuron_in254.counter\[0\] network.neuron_in254.counter\[2\]
+ network.neuron_in254.counter\[1\] net365 network.neuron_in254.counter\[3\]
+ VSS VSS VDD VDD _06614_ sky130_fd_sc_hd__o311a_1
X_18686_ network.in_period\[254\]\[3\] net417 _06614_ VSS
+ VSS VDD VDD _06615_ sky130_fd_sc_hd__a21oi_1
X_18687_ network.neuron_in254.counter\[3\] _06613_ _06615_
+ VSS VSS VDD VDD _03082_ sky130_fd_sc_hd__o21ai_0
X_18688_ network.neuron_in255.counter\[1\] network.neuron_in255.counter\[0\]
+ network.neuron_in255.counter\[2\] net417 VSS VSS VDD VDD _06616_
+ sky130_fd_sc_hd__nor4_1
X_18689_ network.in_period\[255\]\[3\] _06616_ _08408_ VSS
+ VSS VDD VDD _06617_ sky130_fd_sc_hd__mux2i_1
X_18690_ network.neuron_in255.counter\[1\] network.neuron_in255.counter\[0\]
+ network.neuron_in255.counter\[2\] network.neuron_in255.counter\[3\]
+ net364 VSS VSS VDD VDD _06618_ sky130_fd_sc_hd__o311a_1
X_18691_ network.in_period\[255\]\[3\] net417 _06618_ VSS
+ VSS VDD VDD _06619_ sky130_fd_sc_hd__a21oi_1
X_18692_ network.neuron_in255.counter\[3\] _06617_ _06619_
+ VSS VSS VDD VDD _03086_ sky130_fd_sc_hd__o21ai_0
X_18693_ _04125_ _04217_ VSS VSS VDD VDD _03299_ sky130_fd_sc_hd__nor2_1
X_18694_ net356 _04794_ VSS VSS VDD VDD _06620_ sky130_fd_sc_hd__nand2_1
X_18695_ network.in_period\[152\]\[0\] _06620_ VSS VSS VDD
+ VDD _06621_ sky130_fd_sc_hd__nand2_1
X_18696_ network.neuron_in152.counter\[0\] _06620_ _06621_
+ VSS VSS VDD VDD _02671_ sky130_fd_sc_hd__o21ai_0
X_18697_ network.in_period\[152\]\[1\] _06620_ VSS VSS VDD
+ VDD _06622_ sky130_fd_sc_hd__nand2_1
X_18698_ _00566_ _06620_ _06622_ VSS VSS VDD VDD _02672_ sky130_fd_sc_hd__o21ai_0
X_18699_ network.in_period\[151\]\[0\] _05894_ VSS VSS VDD
+ VDD _06623_ sky130_fd_sc_hd__nand2_1
X_18700_ network.neuron_in151.counter\[0\] _05894_ _06623_
+ VSS VSS VDD VDD _02667_ sky130_fd_sc_hd__o21ai_0
X_18701_ network.neuron_in152.counter\[2\] net356 VSS VSS
+ VDD VDD _06624_ sky130_fd_sc_hd__nand2_1
X_18702_ network.neuron_in152.counter\[3\] network.in_period\[152\]\[2\]
+ _06624_ VSS VSS VDD VDD _06625_ sky130_fd_sc_hd__o21ai_0
X_18703_ _00565_ network.neuron_in152.counter\[2\] net412
+ VSS VSS VDD VDD _06626_ sky130_fd_sc_hd__or3_1
X_18704_ network.in_period\[152\]\[2\] net356 _06626_ VSS
+ VSS VDD VDD _06627_ sky130_fd_sc_hd__o21ai_0
X_18705_ _00565_ _06625_ _06627_ VSS VSS VDD VDD _02673_ sky130_fd_sc_hd__a21oi_1
X_18706_ network.in_period\[151\]\[1\] _05894_ VSS VSS VDD
+ VDD _06628_ sky130_fd_sc_hd__nand2_1
X_18707_ _00574_ _05894_ _06628_ VSS VSS VDD VDD _02668_ sky130_fd_sc_hd__o21ai_0
X_18708_ network.neuron_in158.counter\[3\] network.in_period\[158\]\[2\]
+ net411 _00712_ VSS VSS VDD VDD _06629_ sky130_fd_sc_hd__o22ai_1
X_18709_ network.neuron_in158.counter\[2\] _00712_ net355
+ VSS VSS VDD VDD _06630_ sky130_fd_sc_hd__nand3_1
X_18710_ network.in_period\[158\]\[2\] net355 _06630_ VSS
+ VSS VDD VDD _06631_ sky130_fd_sc_hd__o21ai_0
X_18711_ _04789_ _06629_ _06631_ VSS VSS VDD VDD _02697_ sky130_fd_sc_hd__a21oi_1
X_18712_ network.neuron_in157.counter\[3\] network.in_period\[157\]\[2\]
+ net412 _00736_ VSS VSS VDD VDD _06632_ sky130_fd_sc_hd__o22ai_1
X_18713_ network.neuron_in157.counter\[2\] _00736_ net354
+ VSS VSS VDD VDD _06633_ sky130_fd_sc_hd__nand3_1
X_18714_ network.in_period\[157\]\[2\] net354 _06633_ VSS
+ VSS VDD VDD _06634_ sky130_fd_sc_hd__o21ai_0
X_18715_ _07241_ _06632_ _06634_ VSS VSS VDD VDD _02693_ sky130_fd_sc_hd__a21oi_1
X_18716_ network.in_period\[155\]\[0\] _06836_ VSS VSS VDD
+ VDD _06635_ sky130_fd_sc_hd__nand2_1
X_18717_ network.neuron_in155.counter\[0\] _06836_ _06635_
+ VSS VSS VDD VDD _02683_ sky130_fd_sc_hd__o21ai_0
X_18718_ network.in_period\[154\]\[0\] _07052_ VSS VSS VDD
+ VDD _06636_ sky130_fd_sc_hd__nand2_1
X_18719_ network.neuron_in154.counter\[0\] _07052_ _06636_
+ VSS VSS VDD VDD _02679_ sky130_fd_sc_hd__o21ai_0
X_18720_ net362 _04786_ VSS VSS VDD VDD _06637_ sky130_fd_sc_hd__nand2_1
X_18721_ network.in_period\[178\]\[1\] _06637_ VSS VSS VDD
+ VDD _06638_ sky130_fd_sc_hd__nand2_1
X_18722_ _01153_ _06637_ _06638_ VSS VSS VDD VDD _02776_ sky130_fd_sc_hd__o21ai_0
X_18723_ network.neuron_in161.counter\[3\] network.in_period\[161\]\[2\]
+ net416 _00799_ VSS VSS VDD VDD _06639_ sky130_fd_sc_hd__o22ai_1
X_18724_ network.neuron_in161.counter\[2\] _00799_ net346
+ VSS VSS VDD VDD _06640_ sky130_fd_sc_hd__nand3_1
X_18725_ network.in_period\[161\]\[2\] net346 _06640_ VSS
+ VSS VDD VDD _06641_ sky130_fd_sc_hd__o21ai_0
X_18726_ _06685_ _06639_ _06641_ VSS VSS VDD VDD _02709_ sky130_fd_sc_hd__a21oi_1
X_18727_ net355 _04790_ VSS VSS VDD VDD _06642_ sky130_fd_sc_hd__nand2_1
X_18728_ network.in_period\[158\]\[1\] _06642_ VSS VSS VDD
+ VDD _06643_ sky130_fd_sc_hd__nand2_1
X_18729_ _00713_ _06642_ _06643_ VSS VSS VDD VDD _02696_ sky130_fd_sc_hd__o21ai_0
X_18730_ network.neuron_in156.counter\[2\] net354 VSS VSS
+ VDD VDD _06644_ sky130_fd_sc_hd__nand2_1
X_18731_ network.neuron_in156.counter\[3\] network.in_period\[156\]\[2\]
+ _06644_ VSS VSS VDD VDD _06645_ sky130_fd_sc_hd__o21ai_0
X_18732_ _01082_ network.neuron_in156.counter\[2\] net420
+ VSS VSS VDD VDD _06646_ sky130_fd_sc_hd__or3_1
X_18733_ network.in_period\[156\]\[2\] net354 _06646_ VSS
+ VSS VDD VDD _06647_ sky130_fd_sc_hd__o21ai_0
X_18734_ _01082_ _06645_ _06647_ VSS VSS VDD VDD _02689_ sky130_fd_sc_hd__a21oi_1
X_18735_ network.in_period\[178\]\[0\] _06637_ VSS VSS VDD
+ VDD _06648_ sky130_fd_sc_hd__nand2_1
X_18736_ network.neuron_in178.counter\[0\] _06637_ _06648_
+ VSS VSS VDD VDD _02775_ sky130_fd_sc_hd__o21ai_0
X_18737_ network.in_period\[158\]\[0\] _06642_ VSS VSS VDD
+ VDD _06649_ sky130_fd_sc_hd__nand2_1
X_18738_ network.neuron_in158.counter\[0\] _06642_ _06649_
+ VSS VSS VDD VDD _02695_ sky130_fd_sc_hd__o21ai_0
X_18739_ network.neuron_in179.counter\[3\] network.in_period\[179\]\[2\]
+ net415 _00219_ VSS VSS VDD VDD _06650_ sky130_fd_sc_hd__o22ai_1
X_18740_ network.neuron_in179.counter\[2\] _00219_ net363
+ VSS VSS VDD VDD _06651_ sky130_fd_sc_hd__nand3_1
X_18741_ network.in_period\[179\]\[2\] net363 _06651_ VSS
+ VSS VDD VDD _06652_ sky130_fd_sc_hd__o21ai_0
X_18742_ _06770_ _06650_ _06652_ VSS VSS VDD VDD _02781_ sky130_fd_sc_hd__a21oi_1
X_18743_ network.in_period\[153\]\[1\] _07041_ VSS VSS VDD
+ VDD _06653_ sky130_fd_sc_hd__nand2_1
X_18744_ _00554_ _07041_ _06653_ VSS VSS VDD VDD _02676_ sky130_fd_sc_hd__o21ai_0
X_18745_ network.neuron_in153.counter\[3\] network.in_period\[153\]\[2\]
+ net412 _00553_ VSS VSS VDD VDD _06654_ sky130_fd_sc_hd__o22ai_1
X_18746_ network.neuron_in153.counter\[2\] _00553_ net358
+ VSS VSS VDD VDD _06655_ sky130_fd_sc_hd__nand3_1
X_18747_ network.in_period\[153\]\[2\] net358 _06655_ VSS
+ VSS VDD VDD _06656_ sky130_fd_sc_hd__o21ai_0
X_18748_ _07039_ _06654_ _06656_ VSS VSS VDD VDD _02677_ sky130_fd_sc_hd__a21oi_1
X_18749_ network.neuron_hid3.IF0.membrane_potential\[1\] network.neuron_hid3.IF0.input_current\[1\]
+ _00000_ VSS VSS VDD VDD _00001_ network.neuron_hid3.IF0.add_out\[1\]
+ sky130_fd_sc_hd__fa_1
X_18750_ network.neuron_hid6.IF0.membrane_potential\[1\] network.neuron_hid6.IF0.input_current\[1\]
+ _00002_ VSS VSS VDD VDD _00003_ network.neuron_hid6.IF0.add_out\[1\]
+ sky130_fd_sc_hd__fa_1
X_18751_ network.neuron_out2.IF0.membrane_potential\[1\] network.neuron_out2.IF0.input_current\[1\]
+ _00004_ VSS VSS VDD VDD _00005_ _00006_ sky130_fd_sc_hd__fa_1
X_18752_ network.neuron_out3.IF0.membrane_potential\[1\] network.neuron_out3.IF0.input_current\[1\]
+ _00007_ VSS VSS VDD VDD _00008_ _00009_ sky130_fd_sc_hd__fa_1
X_18753_ network.neuron_out1.IF0.membrane_potential\[1\] network.neuron_out1.IF0.input_current\[1\]
+ _00010_ VSS VSS VDD VDD _00011_ _00012_ sky130_fd_sc_hd__fa_1
X_18754_ network.neuron_hid7.IF0.membrane_potential\[1\] network.neuron_hid7.IF0.input_current\[1\]
+ _00013_ VSS VSS VDD VDD _00014_ network.neuron_hid7.IF0.add_out\[1\]
+ sky130_fd_sc_hd__fa_1
X_18755_ network.neuron_out5.IF0.membrane_potential\[1\] network.neuron_out5.IF0.input_current\[1\]
+ _00015_ VSS VSS VDD VDD _00016_ _00017_ sky130_fd_sc_hd__fa_1
X_18756_ network.neuron_hid5.IF0.membrane_potential\[1\] network.neuron_hid5.IF0.input_current\[1\]
+ _00018_ VSS VSS VDD VDD _00019_ network.neuron_hid5.IF0.add_out\[1\]
+ sky130_fd_sc_hd__fa_1
X_18757_ network.neuron_hid0.IF0.membrane_potential\[1\] network.neuron_hid0.IF0.input_current\[1\]
+ _00020_ VSS VSS VDD VDD _00021_ network.neuron_hid0.IF0.add_out\[1\]
+ sky130_fd_sc_hd__fa_1
X_18758_ network.neuron_hid2.IF0.membrane_potential\[1\] network.neuron_hid2.IF0.input_current\[1\]
+ _00022_ VSS VSS VDD VDD _00023_ network.neuron_hid2.IF0.add_out\[1\]
+ sky130_fd_sc_hd__fa_1
X_18759_ network.neuron_hid1.IF0.membrane_potential\[1\] network.neuron_hid1.IF0.input_current\[1\]
+ _00024_ VSS VSS VDD VDD _00025_ network.neuron_hid1.IF0.add_out\[1\]
+ sky130_fd_sc_hd__fa_1
X_18760_ network.neuron_hid4.IF0.membrane_potential\[1\] network.neuron_hid4.IF0.input_current\[1\]
+ _00026_ VSS VSS VDD VDD _00027_ network.neuron_hid4.IF0.add_out\[1\]
+ sky130_fd_sc_hd__fa_1
X_18761_ network.neuron_out0.IF0.membrane_potential\[1\] network.neuron_out0.IF0.input_current\[1\]
+ _00028_ VSS VSS VDD VDD _00029_ _00030_ sky130_fd_sc_hd__fa_1
X_18762_ network.neuron_out4.IF0.membrane_potential\[1\] network.neuron_out4.IF0.input_current\[1\]
+ _00031_ VSS VSS VDD VDD _00032_ _00033_ sky130_fd_sc_hd__fa_1
X_18763_ _00034_ _00035_ VSS VSS VDD VDD _00036_ _00037_ sky130_fd_sc_hd__ha_1
X_18764_ _00038_ _00039_ VSS VSS VDD VDD _00040_ _00041_ sky130_fd_sc_hd__ha_1
X_18765_ _00042_ _00043_ VSS VSS VDD VDD _00044_ _00045_ sky130_fd_sc_hd__ha_1
X_18766_ _00046_ _00047_ VSS VSS VDD VDD _00048_ _00049_ sky130_fd_sc_hd__ha_1
X_18767_ _00050_ _00051_ VSS VSS VDD VDD _00052_ _00053_ sky130_fd_sc_hd__ha_1
X_18768_ _00054_ _00055_ VSS VSS VDD VDD _00056_ _00057_ sky130_fd_sc_hd__ha_1
X_18769_ _00058_ _00059_ VSS VSS VDD VDD _00060_ _00061_ sky130_fd_sc_hd__ha_1
X_18770_ _00062_ _00063_ VSS VSS VDD VDD _00064_ _00065_ sky130_fd_sc_hd__ha_1
X_18771_ _00066_ _00067_ VSS VSS VDD VDD _00068_ _00069_ sky130_fd_sc_hd__ha_1
X_18772_ _00070_ _00071_ VSS VSS VDD VDD _00072_ _00073_ sky130_fd_sc_hd__ha_1
X_18773_ network.neuron_hid4.IF0.membrane_potential\[0\] network.neuron_hid4.IF0.input_current\[0\]
+ VSS VSS VDD VDD _00026_ network.neuron_hid4.IF0.add_out\[0\]
+ sky130_fd_sc_hd__ha_1
X_18774_ network.neuron_hid4.IF0.membrane_potential\[1\] network.neuron_hid4.IF0.input_current\[1\]
+ VSS VSS VDD VDD _00074_ _00075_ sky130_fd_sc_hd__ha_1
X_18775_ _00076_ _00077_ VSS VSS VDD VDD _00078_ _00079_ sky130_fd_sc_hd__ha_1
X_18776_ _00080_ _00081_ VSS VSS VDD VDD _00082_ _00083_ sky130_fd_sc_hd__ha_1
X_18777_ _00084_ _00085_ VSS VSS VDD VDD _00086_ _00087_ sky130_fd_sc_hd__ha_1
X_18778_ _00089_ _00090_ VSS VSS VDD VDD _00091_ _00092_ sky130_fd_sc_hd__ha_1
X_18779_ _00094_ _00095_ VSS VSS VDD VDD _00096_ _00097_ sky130_fd_sc_hd__ha_1
X_18780_ _00098_ _00099_ VSS VSS VDD VDD _00100_ _00101_ sky130_fd_sc_hd__ha_1
X_18781_ _00102_ _00103_ VSS VSS VDD VDD _00104_ _00105_ sky130_fd_sc_hd__ha_1
X_18782_ network.neuron_out4.IF0.membrane_potential\[3\] network.neuron_out4.IF0.input_current\[0\]
+ VSS VSS VDD VDD _00106_ _00107_ sky130_fd_sc_hd__ha_1
X_18783_ _00108_ _00109_ VSS VSS VDD VDD _00110_ _00111_ sky130_fd_sc_hd__ha_1
X_18784_ _00112_ _00113_ VSS VSS VDD VDD _00114_ _00115_ sky130_fd_sc_hd__ha_1
X_18785_ network.neuron_hid5.IF0.membrane_potential\[2\] network.neuron_hid5.IF0.input_current\[2\]
+ VSS VSS VDD VDD _00116_ _00117_ sky130_fd_sc_hd__ha_1
X_18786_ _00118_ _00119_ VSS VSS VDD VDD _00120_ _00121_ sky130_fd_sc_hd__ha_1
X_18787_ _00122_ _00123_ VSS VSS VDD VDD _00124_ _00125_ sky130_fd_sc_hd__ha_1
X_18788_ _00126_ _00127_ VSS VSS VDD VDD _00128_ _00129_ sky130_fd_sc_hd__ha_1
X_18789_ _00130_ _00131_ VSS VSS VDD VDD _00132_ _00133_ sky130_fd_sc_hd__ha_1
X_18790_ network.neuron_hid6.IF0.membrane_potential\[1\] network.neuron_hid6.IF0.input_current\[1\]
+ VSS VSS VDD VDD _00134_ _00093_ sky130_fd_sc_hd__ha_1
X_18791_ network.neuron_hid7.IF0.membrane_potential\[3\] network.neuron_hid7.IF0.input_current\[3\]
+ VSS VSS VDD VDD _00135_ _00136_ sky130_fd_sc_hd__ha_1
X_18792_ _00137_ _00138_ VSS VSS VDD VDD _00139_ _00140_ sky130_fd_sc_hd__ha_1
X_18793_ network.neuron_out0.IF0.membrane_potential\[5\] network.neuron_out0.IF0.input_current\[5\]
+ VSS VSS VDD VDD _00141_ _00142_ sky130_fd_sc_hd__ha_1
X_18794_ _00143_ _00144_ VSS VSS VDD VDD _00145_ _00146_ sky130_fd_sc_hd__ha_1
X_18795_ _00147_ _00148_ VSS VSS VDD VDD _00149_ _00150_ sky130_fd_sc_hd__ha_1
X_18796_ network.neuron_hid5.IF0.membrane_potential\[0\] network.neuron_hid5.IF0.input_current\[0\]
+ VSS VSS VDD VDD _00018_ network.neuron_hid5.IF0.add_out\[0\]
+ sky130_fd_sc_hd__ha_1
X_18797_ network.neuron_out2.IF0.membrane_potential\[0\] network.neuron_out2.IF0.input_current\[0\]
+ VSS VSS VDD VDD _00004_ _00151_ sky130_fd_sc_hd__ha_1
X_18798_ network.neuron_hid5.IF0.membrane_potential\[4\] network.neuron_hid5.IF0.input_current\[4\]
+ VSS VSS VDD VDD _00152_ _00153_ sky130_fd_sc_hd__ha_1
X_18799_ _00154_ _00155_ VSS VSS VDD VDD _00156_ _00157_ sky130_fd_sc_hd__ha_1
X_18800_ _00158_ _00159_ VSS VSS VDD VDD _00160_ _00161_ sky130_fd_sc_hd__ha_1
X_18801_ network.neuron_hid1.IF0.membrane_potential\[0\] network.neuron_hid1.IF0.input_current\[0\]
+ VSS VSS VDD VDD _00024_ network.neuron_hid1.IF0.add_out\[0\]
+ sky130_fd_sc_hd__ha_1
X_18802_ _00162_ _00163_ VSS VSS VDD VDD _00164_ _00165_ sky130_fd_sc_hd__ha_1
X_18803_ network.neuron_out3.IF0.membrane_potential\[1\] network.neuron_out3.IF0.input_current\[1\]
+ VSS VSS VDD VDD _00166_ _00167_ sky130_fd_sc_hd__ha_1
X_18804_ _00168_ _00169_ VSS VSS VDD VDD _00170_ _00171_ sky130_fd_sc_hd__ha_1
X_18805_ _00172_ _00173_ VSS VSS VDD VDD _00174_ _00175_ sky130_fd_sc_hd__ha_1
X_18806_ network.neuron_out4.IF0.membrane_potential\[0\] network.neuron_out4.IF0.input_current\[0\]
+ VSS VSS VDD VDD _00031_ _00176_ sky130_fd_sc_hd__ha_1
X_18807_ network.neuron_out1.IF0.membrane_potential\[3\] network.neuron_out1.IF0.input_current\[3\]
+ VSS VSS VDD VDD _00177_ _00178_ sky130_fd_sc_hd__ha_1
X_18808_ network.neuron_hid7.IF0.membrane_potential\[5\] network.neuron_hid2.IF0.input_current\[5\]
+ VSS VSS VDD VDD _00179_ _00180_ sky130_fd_sc_hd__ha_1
X_18809_ network.neuron_hid7.IF0.membrane_potential\[4\] network.neuron_hid2.IF0.input_current\[4\]
+ VSS VSS VDD VDD _00181_ _00182_ sky130_fd_sc_hd__ha_1
X_18810_ net27 net34 VSS VSS VDD VDD _00183_ _00184_ sky130_fd_sc_hd__ha_1
X_18811_ _00185_ _00186_ VSS VSS VDD VDD _00187_ _00188_ sky130_fd_sc_hd__ha_1
X_18812_ network.neuron_hid7.IF0.membrane_potential\[0\] network.neuron_hid7.IF0.input_current\[0\]
+ VSS VSS VDD VDD _00013_ network.neuron_hid7.IF0.add_out\[0\]
+ sky130_fd_sc_hd__ha_1
X_18813_ _00189_ _00190_ VSS VSS VDD VDD _00191_ _00192_ sky130_fd_sc_hd__ha_1
X_18814_ network.neuron_hid0.IF0.membrane_potential\[1\] network.neuron_hid0.IF0.input_current\[1\]
+ VSS VSS VDD VDD _00193_ _00194_ sky130_fd_sc_hd__ha_1
X_18815_ _00195_ _00196_ VSS VSS VDD VDD _00197_ _00198_ sky130_fd_sc_hd__ha_1
X_18816_ network.neuron_out4.IF0.membrane_potential\[1\] network.neuron_out4.IF0.input_current\[1\]
+ VSS VSS VDD VDD _00199_ _00200_ sky130_fd_sc_hd__ha_1
X_18817_ _00201_ _00202_ VSS VSS VDD VDD _00203_ _00204_ sky130_fd_sc_hd__ha_1
X_18818_ _00205_ _00206_ VSS VSS VDD VDD _00207_ _00208_ sky130_fd_sc_hd__ha_1
X_18819_ _00209_ _00210_ VSS VSS VDD VDD _00211_ _00212_ sky130_fd_sc_hd__ha_1
X_18820_ _00213_ _00214_ VSS VSS VDD VDD _00215_ _00216_ sky130_fd_sc_hd__ha_1
X_18821_ _00217_ _00218_ VSS VSS VDD VDD _00219_ _00220_ sky130_fd_sc_hd__ha_1
X_18822_ _00221_ _00222_ VSS VSS VDD VDD _00223_ _00224_ sky130_fd_sc_hd__ha_1
X_18823_ network.neuron_out5.IF0.membrane_potential\[1\] network.neuron_out5.IF0.input_current\[1\]
+ VSS VSS VDD VDD _00225_ _00226_ sky130_fd_sc_hd__ha_1
X_18824_ _00227_ _00228_ VSS VSS VDD VDD _00229_ _00230_ sky130_fd_sc_hd__ha_1
X_18825_ _00231_ _00232_ VSS VSS VDD VDD _00233_ _00234_ sky130_fd_sc_hd__ha_1
X_18826_ _00235_ _00236_ VSS VSS VDD VDD _00237_ _00238_ sky130_fd_sc_hd__ha_1
X_18827_ _00239_ _00240_ VSS VSS VDD VDD _00241_ _00242_ sky130_fd_sc_hd__ha_1
X_18828_ _00243_ _00244_ VSS VSS VDD VDD _00245_ _00246_ sky130_fd_sc_hd__ha_1
X_18829_ _00247_ _00248_ VSS VSS VDD VDD _00249_ _00250_ sky130_fd_sc_hd__ha_1
X_18830_ _00251_ _00252_ VSS VSS VDD VDD _00253_ _00254_ sky130_fd_sc_hd__ha_1
X_18831_ _00255_ _00256_ VSS VSS VDD VDD _00257_ _00258_ sky130_fd_sc_hd__ha_1
X_18832_ _00259_ _00260_ VSS VSS VDD VDD _00261_ _00262_ sky130_fd_sc_hd__ha_1
X_18833_ _00263_ _00264_ VSS VSS VDD VDD _00265_ _00266_ sky130_fd_sc_hd__ha_1
X_18834_ _00267_ _00268_ VSS VSS VDD VDD _00269_ _00270_ sky130_fd_sc_hd__ha_1
X_18835_ _00271_ _00272_ VSS VSS VDD VDD _00273_ _00274_ sky130_fd_sc_hd__ha_1
X_18836_ _00275_ _00276_ VSS VSS VDD VDD _00277_ _00278_ sky130_fd_sc_hd__ha_1
X_18837_ _00279_ _00280_ VSS VSS VDD VDD _00281_ _00282_ sky130_fd_sc_hd__ha_1
X_18838_ _00283_ _00284_ VSS VSS VDD VDD _00285_ _00286_ sky130_fd_sc_hd__ha_1
X_18839_ _00287_ _00288_ VSS VSS VDD VDD _00289_ _00290_ sky130_fd_sc_hd__ha_1
X_18840_ _00291_ _00292_ VSS VSS VDD VDD _00293_ _00294_ sky130_fd_sc_hd__ha_1
X_18841_ _00295_ _00296_ VSS VSS VDD VDD _00297_ _00298_ sky130_fd_sc_hd__ha_1
X_18842_ _00299_ _00300_ VSS VSS VDD VDD _00301_ _00302_ sky130_fd_sc_hd__ha_1
X_18843_ _00303_ _00304_ VSS VSS VDD VDD _00305_ _00306_ sky130_fd_sc_hd__ha_1
X_18844_ _00307_ _00308_ VSS VSS VDD VDD _00309_ _00310_ sky130_fd_sc_hd__ha_1
X_18845_ _00311_ _00312_ VSS VSS VDD VDD _00313_ _00314_ sky130_fd_sc_hd__ha_1
X_18846_ _00315_ _00316_ VSS VSS VDD VDD _00317_ _00318_ sky130_fd_sc_hd__ha_1
X_18847_ _00319_ _00320_ VSS VSS VDD VDD _00321_ _00322_ sky130_fd_sc_hd__ha_1
X_18848_ _00323_ _00324_ VSS VSS VDD VDD _00325_ _00326_ sky130_fd_sc_hd__ha_1
X_18849_ _00327_ _00328_ VSS VSS VDD VDD _00329_ _00330_ sky130_fd_sc_hd__ha_1
X_18850_ _00331_ _00332_ VSS VSS VDD VDD _00333_ _00334_ sky130_fd_sc_hd__ha_1
X_18851_ _00335_ _00336_ VSS VSS VDD VDD _00337_ _00338_ sky130_fd_sc_hd__ha_1
X_18852_ network.neuron_hid5.IF0.membrane_potential\[1\] network.neuron_hid5.IF0.input_current\[1\]
+ VSS VSS VDD VDD _00339_ _00340_ sky130_fd_sc_hd__ha_1
X_18853_ _00341_ _00342_ VSS VSS VDD VDD _00343_ _00344_ sky130_fd_sc_hd__ha_1
X_18854_ _00345_ _00346_ VSS VSS VDD VDD _00347_ _00348_ sky130_fd_sc_hd__ha_1
X_18855_ _00349_ _00350_ VSS VSS VDD VDD _00351_ _00352_ sky130_fd_sc_hd__ha_1
X_18856_ _00353_ _00354_ VSS VSS VDD VDD _00355_ _00356_ sky130_fd_sc_hd__ha_1
X_18857_ _00357_ _00358_ VSS VSS VDD VDD _00359_ _00360_ sky130_fd_sc_hd__ha_1
X_18858_ _00361_ _00362_ VSS VSS VDD VDD _00363_ _00364_ sky130_fd_sc_hd__ha_1
X_18859_ network.neuron_out0.IF0.membrane_potential\[3\] network.neuron_out0.IF0.input_current\[3\]
+ VSS VSS VDD VDD _00365_ _00366_ sky130_fd_sc_hd__ha_1
X_18860_ _00367_ _00368_ VSS VSS VDD VDD _00369_ _00370_ sky130_fd_sc_hd__ha_1
X_18861_ _00371_ _00372_ VSS VSS VDD VDD _00373_ _00374_ sky130_fd_sc_hd__ha_1
X_18862_ _00375_ _00376_ VSS VSS VDD VDD _00377_ _00378_ sky130_fd_sc_hd__ha_1
X_18863_ _00379_ _00380_ VSS VSS VDD VDD _00381_ _00382_ sky130_fd_sc_hd__ha_1
X_18864_ _00383_ _00384_ VSS VSS VDD VDD _00385_ _00386_ sky130_fd_sc_hd__ha_1
X_18865_ _00387_ _00388_ VSS VSS VDD VDD _00389_ _00390_ sky130_fd_sc_hd__ha_1
X_18866_ _00391_ _00392_ VSS VSS VDD VDD _00393_ _00394_ sky130_fd_sc_hd__ha_1
X_18867_ _00395_ _00396_ VSS VSS VDD VDD _00397_ _00398_ sky130_fd_sc_hd__ha_1
X_18868_ _00399_ _00400_ VSS VSS VDD VDD _00401_ _00402_ sky130_fd_sc_hd__ha_1
X_18869_ _00403_ _00404_ VSS VSS VDD VDD _00405_ _00406_ sky130_fd_sc_hd__ha_1
X_18870_ _00407_ _00408_ VSS VSS VDD VDD _00409_ _00410_ sky130_fd_sc_hd__ha_1
X_18871_ _00411_ _00412_ VSS VSS VDD VDD _00413_ _00414_ sky130_fd_sc_hd__ha_1
X_18872_ _00415_ _00416_ VSS VSS VDD VDD _00417_ _00418_ sky130_fd_sc_hd__ha_1
X_18873_ _00419_ _00420_ VSS VSS VDD VDD _00421_ _00422_ sky130_fd_sc_hd__ha_1
X_18874_ _00423_ _00424_ VSS VSS VDD VDD _00425_ _00426_ sky130_fd_sc_hd__ha_1
X_18875_ _00427_ _00428_ VSS VSS VDD VDD _00429_ _00430_ sky130_fd_sc_hd__ha_1
X_18876_ _00431_ _00432_ VSS VSS VDD VDD _00433_ _00434_ sky130_fd_sc_hd__ha_1
X_18877_ _00435_ _00436_ VSS VSS VDD VDD _00437_ _00438_ sky130_fd_sc_hd__ha_1
X_18878_ _00439_ _00440_ VSS VSS VDD VDD _00441_ _00442_ sky130_fd_sc_hd__ha_1
X_18879_ _00443_ _00444_ VSS VSS VDD VDD _00445_ _00446_ sky130_fd_sc_hd__ha_1
X_18880_ _00447_ _00448_ VSS VSS VDD VDD _00449_ _00450_ sky130_fd_sc_hd__ha_1
X_18881_ _00451_ _00452_ VSS VSS VDD VDD _00453_ _00454_ sky130_fd_sc_hd__ha_1
X_18882_ network.neuron_hid3.IF0.membrane_potential\[2\] network.neuron_hid3.IF0.input_current\[2\]
+ VSS VSS VDD VDD _00455_ _00456_ sky130_fd_sc_hd__ha_1
X_18883_ _00457_ _00458_ VSS VSS VDD VDD _00459_ _00460_ sky130_fd_sc_hd__ha_1
X_18884_ _00461_ _00462_ VSS VSS VDD VDD _00463_ _00464_ sky130_fd_sc_hd__ha_1
X_18885_ _00465_ _00466_ VSS VSS VDD VDD _00467_ _00468_ sky130_fd_sc_hd__ha_1
X_18886_ _00469_ _00470_ VSS VSS VDD VDD _00471_ _00472_ sky130_fd_sc_hd__ha_1
X_18887_ _00473_ _00474_ VSS VSS VDD VDD _00475_ _00476_ sky130_fd_sc_hd__ha_1
X_18888_ _00477_ _00478_ VSS VSS VDD VDD _00479_ _00480_ sky130_fd_sc_hd__ha_1
X_18889_ _00481_ _00482_ VSS VSS VDD VDD _00483_ _00484_ sky130_fd_sc_hd__ha_1
X_18890_ _00485_ _00486_ VSS VSS VDD VDD _00487_ _00488_ sky130_fd_sc_hd__ha_1
X_18891_ _00489_ _00490_ VSS VSS VDD VDD _00491_ _00492_ sky130_fd_sc_hd__ha_1
X_18892_ _00493_ _00494_ VSS VSS VDD VDD _00495_ _00496_ sky130_fd_sc_hd__ha_1
X_18893_ _00497_ _00498_ VSS VSS VDD VDD _00499_ _00500_ sky130_fd_sc_hd__ha_1
X_18894_ _00501_ _00502_ VSS VSS VDD VDD _00503_ _00504_ sky130_fd_sc_hd__ha_1
X_18895_ _00505_ _00506_ VSS VSS VDD VDD _00507_ _00508_ sky130_fd_sc_hd__ha_1
X_18896_ _00509_ _00510_ VSS VSS VDD VDD _00511_ _00512_ sky130_fd_sc_hd__ha_1
X_18897_ _00513_ _00514_ VSS VSS VDD VDD _00515_ _00516_ sky130_fd_sc_hd__ha_1
X_18898_ _00517_ _00518_ VSS VSS VDD VDD _00519_ _00520_ sky130_fd_sc_hd__ha_1
X_18899_ _00521_ _00522_ VSS VSS VDD VDD _00523_ _00524_ sky130_fd_sc_hd__ha_1
X_18900_ _00525_ _00526_ VSS VSS VDD VDD _00527_ _00528_ sky130_fd_sc_hd__ha_1
X_18901_ _00529_ _00530_ VSS VSS VDD VDD _00531_ _00532_ sky130_fd_sc_hd__ha_1
X_18902_ _00533_ _00534_ VSS VSS VDD VDD _00535_ _00536_ sky130_fd_sc_hd__ha_1
X_18903_ _00537_ _00538_ VSS VSS VDD VDD _00539_ _00540_ sky130_fd_sc_hd__ha_1
X_18904_ network.neuron_out4.IF0.membrane_potential\[4\] network.neuron_out4.IF0.input_current\[4\]
+ VSS VSS VDD VDD _00541_ _00542_ sky130_fd_sc_hd__ha_1
X_18905_ _00543_ _00544_ VSS VSS VDD VDD _00545_ _00546_ sky130_fd_sc_hd__ha_1
X_18906_ _00547_ _00548_ VSS VSS VDD VDD _00549_ _00550_ sky130_fd_sc_hd__ha_1
X_18907_ _00551_ _00552_ VSS VSS VDD VDD _00553_ _00554_ sky130_fd_sc_hd__ha_1
X_18908_ _00555_ _00556_ VSS VSS VDD VDD _00557_ _00558_ sky130_fd_sc_hd__ha_1
X_18909_ _00559_ _00560_ VSS VSS VDD VDD _00561_ _00562_ sky130_fd_sc_hd__ha_1
X_18910_ _00563_ _00564_ VSS VSS VDD VDD _00565_ _00566_ sky130_fd_sc_hd__ha_1
X_18911_ _00567_ _00568_ VSS VSS VDD VDD _00569_ _00570_ sky130_fd_sc_hd__ha_1
X_18912_ _00571_ _00572_ VSS VSS VDD VDD _00573_ _00574_ sky130_fd_sc_hd__ha_1
X_18913_ network.neuron_hid0.IF0.membrane_potential\[0\] network.neuron_hid0.IF0.input_current\[0\]
+ VSS VSS VDD VDD _00020_ network.neuron_hid0.IF0.add_out\[0\]
+ sky130_fd_sc_hd__ha_1
X_18914_ _00575_ _00576_ VSS VSS VDD VDD _00577_ _00578_ sky130_fd_sc_hd__ha_1
X_18915_ _00579_ _00580_ VSS VSS VDD VDD _00581_ _00582_ sky130_fd_sc_hd__ha_1
X_18916_ _00583_ _00584_ VSS VSS VDD VDD _00585_ _00586_ sky130_fd_sc_hd__ha_1
X_18917_ _00587_ _00588_ VSS VSS VDD VDD _00589_ _00590_ sky130_fd_sc_hd__ha_1
X_18918_ _00591_ _00592_ VSS VSS VDD VDD _00593_ _00594_ sky130_fd_sc_hd__ha_1
X_18919_ _00595_ _00596_ VSS VSS VDD VDD _00597_ _00598_ sky130_fd_sc_hd__ha_1
X_18920_ _00599_ _00600_ VSS VSS VDD VDD _00601_ _00602_ sky130_fd_sc_hd__ha_1
X_18921_ _00603_ _00604_ VSS VSS VDD VDD _00605_ _00606_ sky130_fd_sc_hd__ha_1
X_18922_ _00607_ _00608_ VSS VSS VDD VDD _00609_ _00610_ sky130_fd_sc_hd__ha_1
X_18923_ _00611_ _00612_ VSS VSS VDD VDD _00613_ _00614_ sky130_fd_sc_hd__ha_1
X_18924_ _00615_ _00616_ VSS VSS VDD VDD _00617_ _00618_ sky130_fd_sc_hd__ha_1
X_18925_ _00619_ _00620_ VSS VSS VDD VDD _00621_ _00622_ sky130_fd_sc_hd__ha_1
X_18926_ _00623_ _00624_ VSS VSS VDD VDD _00625_ _00626_ sky130_fd_sc_hd__ha_1
X_18927_ _00627_ _00628_ VSS VSS VDD VDD _00629_ _00630_ sky130_fd_sc_hd__ha_1
X_18928_ _00631_ _00632_ VSS VSS VDD VDD _00633_ _00634_ sky130_fd_sc_hd__ha_1
X_18929_ _00635_ _00636_ VSS VSS VDD VDD _00637_ _00638_ sky130_fd_sc_hd__ha_1
X_18930_ _00639_ _00640_ VSS VSS VDD VDD _00641_ _00642_ sky130_fd_sc_hd__ha_1
X_18931_ _00643_ _00644_ VSS VSS VDD VDD _00645_ _00646_ sky130_fd_sc_hd__ha_1
X_18932_ _00647_ _00648_ VSS VSS VDD VDD _00649_ _00650_ sky130_fd_sc_hd__ha_1
X_18933_ _00651_ _00652_ VSS VSS VDD VDD _00653_ _00654_ sky130_fd_sc_hd__ha_1
X_18934_ _00655_ _00656_ VSS VSS VDD VDD _00657_ _00658_ sky130_fd_sc_hd__ha_1
X_18935_ network.neuron_out1.IF0.membrane_potential\[0\] network.neuron_out1.IF0.input_current\[0\]
+ VSS VSS VDD VDD _00010_ _00659_ sky130_fd_sc_hd__ha_1
X_18936_ _00660_ _00661_ VSS VSS VDD VDD _00662_ _00663_ sky130_fd_sc_hd__ha_1
X_18937_ _00664_ _00665_ VSS VSS VDD VDD _00666_ _00667_ sky130_fd_sc_hd__ha_1
X_18938_ _00668_ _00669_ VSS VSS VDD VDD _00670_ _00671_ sky130_fd_sc_hd__ha_1
X_18939_ _00672_ _00673_ VSS VSS VDD VDD _00674_ _00675_ sky130_fd_sc_hd__ha_1
X_18940_ _00676_ _00677_ VSS VSS VDD VDD _00678_ _00679_ sky130_fd_sc_hd__ha_1
X_18941_ _00680_ _00681_ VSS VSS VDD VDD _00682_ _00683_ sky130_fd_sc_hd__ha_1
X_18942_ _00684_ _00685_ VSS VSS VDD VDD _00686_ _00687_ sky130_fd_sc_hd__ha_1
X_18943_ _00688_ _00689_ VSS VSS VDD VDD _00690_ _00691_ sky130_fd_sc_hd__ha_1
X_18944_ _00692_ _00693_ VSS VSS VDD VDD _00694_ _00695_ sky130_fd_sc_hd__ha_1
X_18945_ _00696_ _00697_ VSS VSS VDD VDD _00698_ _00699_ sky130_fd_sc_hd__ha_1
X_18946_ _00700_ _00701_ VSS VSS VDD VDD _00702_ _00703_ sky130_fd_sc_hd__ha_1
X_18947_ network.neuron_hid7.IF0.membrane_potential\[6\] network.neuron_hid2.IF0.input_current\[6\]
+ VSS VSS VDD VDD _00704_ _00705_ sky130_fd_sc_hd__ha_1
X_18948_ _00706_ _00707_ VSS VSS VDD VDD _00708_ _00709_ sky130_fd_sc_hd__ha_1
X_18949_ _00710_ _00711_ VSS VSS VDD VDD _00712_ _00713_ sky130_fd_sc_hd__ha_1
X_18950_ _00714_ _00715_ VSS VSS VDD VDD _00716_ _00717_ sky130_fd_sc_hd__ha_1
X_18951_ network.neuron_out1.IF0.membrane_potential\[1\] network.neuron_out1.IF0.input_current\[1\]
+ VSS VSS VDD VDD _00718_ _00719_ sky130_fd_sc_hd__ha_1
X_18952_ network.neuron_out0.IF0.membrane_potential\[4\] network.neuron_out0.IF0.input_current\[4\]
+ VSS VSS VDD VDD _00720_ _00721_ sky130_fd_sc_hd__ha_1
X_18953_ _00722_ _00723_ VSS VSS VDD VDD _00724_ _00725_ sky130_fd_sc_hd__ha_1
X_18954_ _00726_ _00727_ VSS VSS VDD VDD _00728_ _00729_ sky130_fd_sc_hd__ha_1
X_18955_ _00730_ _00731_ VSS VSS VDD VDD _00732_ _00733_ sky130_fd_sc_hd__ha_1
X_18956_ _00734_ _00735_ VSS VSS VDD VDD _00736_ _00737_ sky130_fd_sc_hd__ha_1
X_18957_ _00738_ _00739_ VSS VSS VDD VDD _00740_ _00741_ sky130_fd_sc_hd__ha_1
X_18958_ network.neuron_hid3.IF0.membrane_potential\[1\] network.neuron_hid3.IF0.input_current\[1\]
+ VSS VSS VDD VDD _00743_ _00088_ sky130_fd_sc_hd__ha_1
X_18959_ network.neuron_hid7.IF0.membrane_potential\[1\] network.neuron_hid7.IF0.input_current\[1\]
+ VSS VSS VDD VDD _00744_ _00745_ sky130_fd_sc_hd__ha_1
X_18960_ _00746_ _00747_ VSS VSS VDD VDD _00748_ _00749_ sky130_fd_sc_hd__ha_1
X_18961_ network.neuron_hid1.IF0.membrane_potential\[3\] network.neuron_hid1.IF0.input_current\[3\]
+ VSS VSS VDD VDD _00750_ _00751_ sky130_fd_sc_hd__ha_1
X_18962_ network.neuron_hid2.IF0.membrane_potential\[2\] network.neuron_hid2.IF0.input_current\[2\]
+ VSS VSS VDD VDD _00752_ _00753_ sky130_fd_sc_hd__ha_1
X_18963_ network.neuron_out0.IF0.membrane_potential\[1\] network.neuron_out0.IF0.input_current\[1\]
+ VSS VSS VDD VDD _00754_ _00755_ sky130_fd_sc_hd__ha_1
X_18964_ _00756_ _00757_ VSS VSS VDD VDD _00758_ _00759_ sky130_fd_sc_hd__ha_1
X_18965_ _00760_ _00761_ VSS VSS VDD VDD _00762_ _00763_ sky130_fd_sc_hd__ha_1
X_18966_ network.neuron_out2.IF0.membrane_potential\[1\] network.neuron_out2.IF0.input_current\[1\]
+ VSS VSS VDD VDD _00764_ _00742_ sky130_fd_sc_hd__ha_1
X_18967_ _00765_ _00766_ VSS VSS VDD VDD _00767_ _00768_ sky130_fd_sc_hd__ha_1
X_18968_ _00769_ _00770_ VSS VSS VDD VDD _00771_ _00772_ sky130_fd_sc_hd__ha_1
X_18969_ network.neuron_out2.IF0.membrane_potential\[3\] network.neuron_out2.IF0.input_current\[3\]
+ VSS VSS VDD VDD _00773_ _00774_ sky130_fd_sc_hd__ha_1
X_18970_ network.neuron_hid4.IF0.membrane_potential\[3\] network.neuron_hid4.IF0.input_current\[3\]
+ VSS VSS VDD VDD _00775_ _00776_ sky130_fd_sc_hd__ha_1
X_18971_ network.neuron_hid1.IF0.membrane_potential\[2\] network.neuron_hid1.IF0.input_current\[2\]
+ VSS VSS VDD VDD _00777_ _00778_ sky130_fd_sc_hd__ha_1
X_18972_ _00779_ _00780_ VSS VSS VDD VDD _00781_ _00782_ sky130_fd_sc_hd__ha_1
X_18973_ _00783_ _00784_ VSS VSS VDD VDD _00785_ _00786_ sky130_fd_sc_hd__ha_1
X_18974_ network.neuron_hid1.IF0.membrane_potential\[1\] network.neuron_hid1.IF0.input_current\[1\]
+ VSS VSS VDD VDD _00787_ _00788_ sky130_fd_sc_hd__ha_1
X_18975_ network.neuron_out5.IF0.membrane_potential\[6\] network.neuron_out5.IF0.input_current\[6\]
+ VSS VSS VDD VDD _00789_ _00790_ sky130_fd_sc_hd__ha_1
X_18976_ network.neuron_hid6.IF0.membrane_potential\[4\] network.neuron_hid6.IF0.input_current\[4\]
+ VSS VSS VDD VDD _00791_ _00792_ sky130_fd_sc_hd__ha_1
X_18977_ network.neuron_out2.IF0.membrane_potential\[4\] network.neuron_out2.IF0.input_current\[4\]
+ VSS VSS VDD VDD _00793_ _00794_ sky130_fd_sc_hd__ha_1
X_18978_ network.neuron_out5.IF0.membrane_potential\[5\] network.neuron_out5.IF0.input_current\[5\]
+ VSS VSS VDD VDD _00795_ _00796_ sky130_fd_sc_hd__ha_1
X_18979_ _00797_ _00798_ VSS VSS VDD VDD _00799_ _00800_ sky130_fd_sc_hd__ha_1
X_18980_ network.neuron_hid2.IF0.membrane_potential\[0\] network.neuron_hid2.IF0.input_current\[0\]
+ VSS VSS VDD VDD _00022_ network.neuron_hid2.IF0.add_out\[0\]
+ sky130_fd_sc_hd__ha_1
X_18981_ _00801_ _00802_ VSS VSS VDD VDD _00803_ _00804_ sky130_fd_sc_hd__ha_1
X_18982_ _00805_ _00806_ VSS VSS VDD VDD _00807_ _00808_ sky130_fd_sc_hd__ha_1
X_18983_ network.neuron_hid0.IF0.membrane_potential\[2\] network.neuron_hid0.IF0.input_current\[2\]
+ VSS VSS VDD VDD _00809_ _00810_ sky130_fd_sc_hd__ha_1
X_18984_ _00811_ _00812_ VSS VSS VDD VDD _00813_ _00814_ sky130_fd_sc_hd__ha_1
X_18985_ _00815_ _00816_ VSS VSS VDD VDD _00817_ _00818_ sky130_fd_sc_hd__ha_1
X_18986_ _00819_ _00820_ VSS VSS VDD VDD _00821_ _00822_ sky130_fd_sc_hd__ha_1
X_18987_ _00823_ _00824_ VSS VSS VDD VDD _00825_ _00826_ sky130_fd_sc_hd__ha_1
X_18988_ _00827_ _00828_ VSS VSS VDD VDD _00829_ _00830_ sky130_fd_sc_hd__ha_1
X_18989_ _00831_ _00832_ VSS VSS VDD VDD _00833_ _00834_ sky130_fd_sc_hd__ha_1
X_18990_ _00835_ _00836_ VSS VSS VDD VDD _00837_ _00838_ sky130_fd_sc_hd__ha_1
X_18991_ _00839_ _00840_ VSS VSS VDD VDD _00841_ _00842_ sky130_fd_sc_hd__ha_1
X_18992_ _00843_ _00844_ VSS VSS VDD VDD _00845_ _00846_ sky130_fd_sc_hd__ha_1
X_18993_ _00843_ loaded\[1\] VSS VSS VDD VDD _00847_ _09728_
+ sky130_fd_sc_hd__ha_1
X_18994_ loaded\[0\] _00844_ VSS VSS VDD VDD _00848_ _09729_
+ sky130_fd_sc_hd__ha_1
X_18995_ loaded\[0\] loaded\[1\] VSS VSS VDD VDD _00849_ _09730_
+ sky130_fd_sc_hd__ha_1
X_18996_ network.neuron_out0.IF0.membrane_potential\[0\] network.neuron_out0.IF0.input_current\[0\]
+ VSS VSS VDD VDD _00028_ _00850_ sky130_fd_sc_hd__ha_1
X_18997_ network.neuron_hid6.IF0.membrane_potential\[0\] network.neuron_hid6.IF0.input_current\[0\]
+ VSS VSS VDD VDD _00002_ network.neuron_hid6.IF0.add_out\[0\]
+ sky130_fd_sc_hd__ha_1
X_18998_ network.neuron_out2.IF0.membrane_potential\[2\] network.neuron_out2.IF0.input_current\[2\]
+ VSS VSS VDD VDD _00851_ _00852_ sky130_fd_sc_hd__ha_1
X_18999_ network.neuron_out5.IF0.membrane_potential\[2\] network.neuron_out0.IF0.input_current\[2\]
+ VSS VSS VDD VDD _00853_ _00854_ sky130_fd_sc_hd__ha_1
X_19000_ network.neuron_hid6.IF0.membrane_potential\[3\] network.neuron_hid6.IF0.input_current\[3\]
+ VSS VSS VDD VDD _00855_ _00856_ sky130_fd_sc_hd__ha_1
X_19001_ network.neuron_out3.IF0.membrane_potential\[0\] network.neuron_out3.IF0.input_current\[0\]
+ VSS VSS VDD VDD _00007_ _00857_ sky130_fd_sc_hd__ha_1
X_19002_ network.neuron_hid5.IF0.membrane_potential\[3\] network.neuron_hid5.IF0.input_current\[3\]
+ VSS VSS VDD VDD _00858_ _00859_ sky130_fd_sc_hd__ha_1
X_19003_ _00860_ _00861_ VSS VSS VDD VDD _00862_ _00863_ sky130_fd_sc_hd__ha_1
X_19004_ _00864_ _00865_ VSS VSS VDD VDD _00866_ _00867_ sky130_fd_sc_hd__ha_1
X_19005_ network.neuron_hid4.IF0.membrane_potential\[4\] network.neuron_hid4.IF0.input_current\[4\]
+ VSS VSS VDD VDD _00868_ _00869_ sky130_fd_sc_hd__ha_1
X_19006_ network.neuron_hid4.IF0.membrane_potential\[2\] network.neuron_hid4.IF0.input_current\[2\]
+ VSS VSS VDD VDD _00870_ _00871_ sky130_fd_sc_hd__ha_1
X_19007_ _00872_ _00873_ VSS VSS VDD VDD _00874_ _00875_ sky130_fd_sc_hd__ha_1
X_19008_ network.neuron_hid3.IF0.membrane_potential\[5\] network.neuron_hid2.IF0.input_current\[5\]
+ VSS VSS VDD VDD _00876_ _00877_ sky130_fd_sc_hd__ha_1
X_19009_ network.neuron_hid2.IF0.membrane_potential\[3\] network.neuron_hid2.IF0.input_current\[3\]
+ VSS VSS VDD VDD _00878_ _00879_ sky130_fd_sc_hd__ha_1
X_19010_ network.neuron_hid2.IF0.membrane_potential\[6\] network.neuron_hid2.IF0.input_current\[6\]
+ VSS VSS VDD VDD _00880_ _00881_ sky130_fd_sc_hd__ha_1
X_19011_ _00882_ _00883_ VSS VSS VDD VDD _00884_ _00885_ sky130_fd_sc_hd__ha_1
X_19012_ network.neuron_hid0.IF0.membrane_potential\[3\] network.neuron_hid0.IF0.input_current\[3\]
+ VSS VSS VDD VDD _00886_ _00887_ sky130_fd_sc_hd__ha_1
X_19013_ network.neuron_out5.IF0.membrane_potential\[0\] network.neuron_out5.IF0.input_current\[0\]
+ VSS VSS VDD VDD _00015_ _00888_ sky130_fd_sc_hd__ha_1
X_19014_ network.neuron_hid3.IF0.membrane_potential\[6\] network.neuron_hid2.IF0.input_current\[6\]
+ VSS VSS VDD VDD _00889_ _00890_ sky130_fd_sc_hd__ha_1
X_19015_ _00891_ _00892_ VSS VSS VDD VDD _00893_ _00894_ sky130_fd_sc_hd__ha_1
X_19016_ _00896_ _00897_ VSS VSS VDD VDD _00898_ _00899_ sky130_fd_sc_hd__ha_1
X_19017_ _00900_ _00901_ VSS VSS VDD VDD _00902_ _00903_ sky130_fd_sc_hd__ha_1
X_19018_ _00904_ _00905_ VSS VSS VDD VDD _00906_ _00907_ sky130_fd_sc_hd__ha_1
X_19019_ _00908_ _00909_ VSS VSS VDD VDD _00910_ _00911_ sky130_fd_sc_hd__ha_1
X_19020_ _00912_ _00913_ VSS VSS VDD VDD _00914_ _00915_ sky130_fd_sc_hd__ha_1
X_19021_ network.neuron_hid0.IF0.membrane_potential\[4\] network.neuron_hid0.IF0.input_current\[4\]
+ VSS VSS VDD VDD _00916_ _00917_ sky130_fd_sc_hd__ha_1
X_19022_ _00918_ _00919_ VSS VSS VDD VDD _00920_ _00921_ sky130_fd_sc_hd__ha_1
X_19023_ _00922_ _00923_ VSS VSS VDD VDD _00924_ _00925_ sky130_fd_sc_hd__ha_1
X_19024_ _00926_ _00927_ VSS VSS VDD VDD _00928_ _00929_ sky130_fd_sc_hd__ha_1
X_19025_ _00930_ _00931_ VSS VSS VDD VDD _00932_ _00933_ sky130_fd_sc_hd__ha_1
X_19026_ _00934_ _00935_ VSS VSS VDD VDD _00936_ _00937_ sky130_fd_sc_hd__ha_1
X_19027_ _00938_ _00939_ VSS VSS VDD VDD _00940_ _00941_ sky130_fd_sc_hd__ha_1
X_19028_ _00942_ _00943_ VSS VSS VDD VDD _00944_ _00945_ sky130_fd_sc_hd__ha_1
X_19029_ _00946_ _00947_ VSS VSS VDD VDD _00948_ _00949_ sky130_fd_sc_hd__ha_1
X_19030_ _00950_ _00951_ VSS VSS VDD VDD _00952_ _00953_ sky130_fd_sc_hd__ha_1
X_19031_ _00954_ _00955_ VSS VSS VDD VDD _00956_ _00957_ sky130_fd_sc_hd__ha_1
X_19032_ _00958_ _00959_ VSS VSS VDD VDD _00960_ _00961_ sky130_fd_sc_hd__ha_1
X_19033_ _00962_ _00963_ VSS VSS VDD VDD _00964_ _00965_ sky130_fd_sc_hd__ha_1
X_19034_ _00966_ _00967_ VSS VSS VDD VDD _00968_ _00969_ sky130_fd_sc_hd__ha_1
X_19035_ _00970_ _00971_ VSS VSS VDD VDD _00972_ _00973_ sky130_fd_sc_hd__ha_1
X_19036_ _00974_ _00975_ VSS VSS VDD VDD _00976_ _00977_ sky130_fd_sc_hd__ha_1
X_19037_ _00978_ _00979_ VSS VSS VDD VDD _00980_ _00981_ sky130_fd_sc_hd__ha_1
X_19038_ _00982_ _00983_ VSS VSS VDD VDD _00984_ _00985_ sky130_fd_sc_hd__ha_1
X_19039_ _00986_ _00987_ VSS VSS VDD VDD _00988_ _00989_ sky130_fd_sc_hd__ha_1
X_19040_ _00990_ _00991_ VSS VSS VDD VDD _00992_ _00993_ sky130_fd_sc_hd__ha_1
X_19041_ _00994_ _00995_ VSS VSS VDD VDD _00996_ _00997_ sky130_fd_sc_hd__ha_1
X_19042_ _00998_ _00999_ VSS VSS VDD VDD _01000_ _01001_ sky130_fd_sc_hd__ha_1
X_19043_ _01002_ _01003_ VSS VSS VDD VDD _01004_ _01005_ sky130_fd_sc_hd__ha_1
X_19044_ _01006_ _01007_ VSS VSS VDD VDD _01008_ _01009_ sky130_fd_sc_hd__ha_1
X_19045_ _01010_ _01011_ VSS VSS VDD VDD _01012_ _01013_ sky130_fd_sc_hd__ha_1
X_19046_ _01014_ _01015_ VSS VSS VDD VDD _01016_ _01017_ sky130_fd_sc_hd__ha_1
X_19047_ network.neuron_hid1.IF0.membrane_potential\[4\] network.neuron_hid1.IF0.input_current\[4\]
+ VSS VSS VDD VDD _01018_ _01019_ sky130_fd_sc_hd__ha_1
X_19048_ _01020_ _01021_ VSS VSS VDD VDD _01022_ _01023_ sky130_fd_sc_hd__ha_1
X_19049_ _01024_ _01025_ VSS VSS VDD VDD _01026_ _01027_ sky130_fd_sc_hd__ha_1
X_19050_ _01028_ _01029_ VSS VSS VDD VDD _01030_ _01031_ sky130_fd_sc_hd__ha_1
X_19051_ _01032_ _01033_ VSS VSS VDD VDD _01034_ _01035_ sky130_fd_sc_hd__ha_1
X_19052_ _01036_ _01037_ VSS VSS VDD VDD _01038_ _01039_ sky130_fd_sc_hd__ha_1
X_19053_ _01040_ _01041_ VSS VSS VDD VDD _01042_ _01043_ sky130_fd_sc_hd__ha_1
X_19054_ _01044_ _01045_ VSS VSS VDD VDD _01046_ _01047_ sky130_fd_sc_hd__ha_1
X_19055_ network.neuron_out4.IF0.membrane_potential\[2\] network.neuron_out1.IF0.input_current\[2\]
+ VSS VSS VDD VDD _01048_ _01049_ sky130_fd_sc_hd__ha_1
X_19056_ _01050_ _01051_ VSS VSS VDD VDD _01052_ _01053_ sky130_fd_sc_hd__ha_1
X_19057_ _01054_ _01055_ VSS VSS VDD VDD _01056_ _01057_ sky130_fd_sc_hd__ha_1
X_19058_ _01058_ _01059_ VSS VSS VDD VDD _01060_ _01061_ sky130_fd_sc_hd__ha_1
X_19059_ network.neuron_hid3.IF0.membrane_potential\[3\] network.neuron_hid2.IF0.input_current\[3\]
+ VSS VSS VDD VDD _01062_ _01063_ sky130_fd_sc_hd__ha_1
X_19060_ network.neuron_out1.IF0.membrane_potential\[2\] network.neuron_out1.IF0.input_current\[2\]
+ VSS VSS VDD VDD _01064_ _01065_ sky130_fd_sc_hd__ha_1
X_19061_ network.neuron_out3.IF0.membrane_potential\[4\] network.neuron_out3.IF0.input_current\[4\]
+ VSS VSS VDD VDD _01066_ _01067_ sky130_fd_sc_hd__ha_1
X_19062_ _01068_ _01069_ VSS VSS VDD VDD _01070_ _01071_ sky130_fd_sc_hd__ha_1
X_19063_ network.neuron_hid3.IF0.membrane_potential\[4\] network.neuron_hid2.IF0.input_current\[4\]
+ VSS VSS VDD VDD _01072_ _01073_ sky130_fd_sc_hd__ha_1
X_19064_ network.neuron_hid3.IF0.membrane_potential\[0\] network.neuron_hid3.IF0.input_current\[0\]
+ VSS VSS VDD VDD _00000_ network.neuron_hid3.IF0.add_out\[0\]
+ sky130_fd_sc_hd__ha_1
X_19065_ network.neuron_out0.IF0.membrane_potential\[2\] network.neuron_out0.IF0.input_current\[2\]
+ VSS VSS VDD VDD _01074_ _01075_ sky130_fd_sc_hd__ha_1
X_19066_ network.neuron_out5.IF0.membrane_potential\[4\] network.neuron_out5.IF0.input_current\[4\]
+ VSS VSS VDD VDD _01076_ _01077_ sky130_fd_sc_hd__ha_1
X_19067_ network.neuron_hid6.IF0.membrane_potential\[2\] network.neuron_hid6.IF0.input_current\[2\]
+ VSS VSS VDD VDD _01078_ _01079_ sky130_fd_sc_hd__ha_1
X_19068_ _01080_ _01081_ VSS VSS VDD VDD _01082_ _01083_ sky130_fd_sc_hd__ha_1
X_19069_ _01084_ _01085_ VSS VSS VDD VDD _01086_ _01087_ sky130_fd_sc_hd__ha_1
X_19070_ _01088_ _01089_ VSS VSS VDD VDD _01090_ _01091_ sky130_fd_sc_hd__ha_1
X_19071_ _01092_ _01093_ VSS VSS VDD VDD _01094_ _01095_ sky130_fd_sc_hd__ha_1
X_19072_ _01096_ _01097_ VSS VSS VDD VDD _01098_ _01099_ sky130_fd_sc_hd__ha_1
X_19073_ _01100_ _01101_ VSS VSS VDD VDD _01102_ _01103_ sky130_fd_sc_hd__ha_1
X_19074_ _01104_ _01105_ VSS VSS VDD VDD _01106_ _01107_ sky130_fd_sc_hd__ha_1
X_19075_ _01108_ _01109_ VSS VSS VDD VDD _01110_ _01111_ sky130_fd_sc_hd__ha_1
X_19076_ _01112_ _01113_ VSS VSS VDD VDD _01114_ _01115_ sky130_fd_sc_hd__ha_1
X_19077_ _01116_ _01117_ VSS VSS VDD VDD _01118_ _01119_ sky130_fd_sc_hd__ha_1
X_19078_ _01120_ _01121_ VSS VSS VDD VDD _01122_ _01123_ sky130_fd_sc_hd__ha_1
X_19079_ _01124_ _01125_ VSS VSS VDD VDD _01126_ _01127_ sky130_fd_sc_hd__ha_1
X_19080_ _01128_ _01129_ VSS VSS VDD VDD _01130_ _01131_ sky130_fd_sc_hd__ha_1
X_19081_ network.neuron_hid7.IF0.membrane_potential\[2\] network.neuron_hid7.IF0.input_current\[2\]
+ VSS VSS VDD VDD _01132_ _01133_ sky130_fd_sc_hd__ha_1
X_19082_ _01134_ _01135_ VSS VSS VDD VDD _01136_ _01137_ sky130_fd_sc_hd__ha_1
X_19083_ network.neuron_out5.IF0.membrane_potential\[3\] network.neuron_out5.IF0.input_current\[3\]
+ VSS VSS VDD VDD _01138_ _01139_ sky130_fd_sc_hd__ha_1
X_19084_ network.neuron_out3.IF0.membrane_potential\[3\] network.neuron_out3.IF0.input_current\[3\]
+ VSS VSS VDD VDD _01140_ _01141_ sky130_fd_sc_hd__ha_1
X_19085_ network.neuron_out3.IF0.membrane_potential\[2\] network.neuron_out3.IF0.input_current\[2\]
+ VSS VSS VDD VDD _01142_ _01143_ sky130_fd_sc_hd__ha_1
X_19086_ _01144_ _01145_ VSS VSS VDD VDD _01146_ _01147_ sky130_fd_sc_hd__ha_1
X_19087_ network.neuron_hid2.IF0.membrane_potential\[7\] network.neuron_hid2.IF0.input_current\[7\]
+ VSS VSS VDD VDD _01148_ _01149_ sky130_fd_sc_hd__ha_1
X_19088_ _01150_ _01151_ VSS VSS VDD VDD _01152_ _01153_ sky130_fd_sc_hd__ha_1
X_19089_ _01154_ _01155_ VSS VSS VDD VDD _01156_ _01157_ sky130_fd_sc_hd__ha_1
X_19090_ _01158_ _01159_ VSS VSS VDD VDD _01160_ _01161_ sky130_fd_sc_hd__ha_1
X_19091_ network.neuron_hid7.IF0.membrane_potential\[7\] network.neuron_hid2.IF0.input_current\[7\]
+ VSS VSS VDD VDD _01162_ _01163_ sky130_fd_sc_hd__ha_1
X_19092_ network.neuron_out1.IF0.membrane_potential\[4\] network.neuron_out1.IF0.input_current\[4\]
+ VSS VSS VDD VDD _01164_ _01165_ sky130_fd_sc_hd__ha_1
X_19093_ _01166_ _01167_ VSS VSS VDD VDD _01168_ _01169_ sky130_fd_sc_hd__ha_1
X_19094_ _01170_ _01171_ VSS VSS VDD VDD _01172_ _01173_ sky130_fd_sc_hd__ha_1
X_19095_ _01174_ _01175_ VSS VSS VDD VDD _01176_ _01177_ sky130_fd_sc_hd__ha_1
X_19096_ _01178_ _01179_ VSS VSS VDD VDD _01180_ _01181_ sky130_fd_sc_hd__ha_1
X_19097_ _01182_ _01183_ VSS VSS VDD VDD _01184_ _01185_ sky130_fd_sc_hd__ha_1
X_19098_ _01186_ _01187_ VSS VSS VDD VDD _01188_ _01189_ sky130_fd_sc_hd__ha_1
X_19099_ _01190_ _01191_ VSS VSS VDD VDD _01192_ _01193_ sky130_fd_sc_hd__ha_1
X_19100_ _01194_ _01195_ VSS VSS VDD VDD _01196_ _01197_ sky130_fd_sc_hd__ha_1
X_19101_ _01198_ _01199_ VSS VSS VDD VDD _01200_ _01201_ sky130_fd_sc_hd__ha_1
X_19102_ network.neuron_hid3.IF0.membrane_potential\[7\] network.neuron_hid2.IF0.input_current\[7\]
+ VSS VSS VDD VDD _01202_ _01203_ sky130_fd_sc_hd__ha_1
X_19103_ _01204_ _01205_ VSS VSS VDD VDD _01206_ _01207_ sky130_fd_sc_hd__ha_1
X_19104_ _01208_ _01209_ VSS VSS VDD VDD _01210_ _01211_ sky130_fd_sc_hd__ha_1
X_19105_ _01212_ _01213_ VSS VSS VDD VDD _01214_ _01215_ sky130_fd_sc_hd__ha_1
X_19106_ _01216_ _01217_ VSS VSS VDD VDD _01218_ _01219_ sky130_fd_sc_hd__ha_1
X_19107_ _01220_ _01221_ VSS VSS VDD VDD _01222_ _01223_ sky130_fd_sc_hd__ha_1
X_19108_ _01224_ _01225_ VSS VSS VDD VDD _01226_ _01227_ sky130_fd_sc_hd__ha_1
X_19109_ _01228_ _01229_ VSS VSS VDD VDD _01230_ _01231_ sky130_fd_sc_hd__ha_1
X_19110_ _01232_ _01233_ VSS VSS VDD VDD _01234_ _01235_ sky130_fd_sc_hd__ha_1
X_19111_ network.neuron_hid2.IF0.membrane_potential\[4\] network.neuron_hid2.IF0.input_current\[4\]
+ VSS VSS VDD VDD _01236_ _01237_ sky130_fd_sc_hd__ha_1
X_19112_ network.neuron_hid2.IF0.membrane_potential\[1\] network.neuron_hid2.IF0.input_current\[1\]
+ VSS VSS VDD VDD _01238_ _00895_ sky130_fd_sc_hd__ha_1
X_19113_ network.neuron_hid2.IF0.membrane_potential\[5\] network.neuron_hid2.IF0.input_current\[5\]
+ VSS VSS VDD VDD _01239_ _01240_ sky130_fd_sc_hd__ha_1
X_19114_ _01241_ _01242_ VSS VSS VDD VDD _01243_ _01244_ sky130_fd_sc_hd__ha_1
X_19115_ _01245_ _01246_ VSS VSS VDD VDD _01247_ _01248_ sky130_fd_sc_hd__ha_1
XTAP_TAPCELL_ROW_0_0 VSS VDD sky130_fd_sc_hd__tapvpwrvgnd_1
Xbusy$_SDFFE_PP0P_ clknet_2_0__leaf_clk_regs _01958_ VSS VSS
+ VDD VDD net25 sky130_fd_sc_hd__dfxtp_1
Xdone$_SDFF_PP0_ clknet_2_3__leaf_clk_regs _01955_ VSS VSS
+ VDD VDD net26 sky130_fd_sc_hd__dfxtp_1
Xicg_load.icg clknet_1_0__leaf_clk icg_load.en VSS VSS VDD
+ VDD clk_load sky130_fd_sc_hd__dlclkp_1
Xicg_net.icg clknet_1_1__leaf_clk icg_net.en VSS VSS VDD VDD
+ clk_net sky130_fd_sc_hd__dlclkp_1
Xinference_cycles\[0\]$_SDFFE_PP0P_ clknet_2_3__leaf_clk_regs
+ _01564_ VSS VSS VDD VDD net27 sky130_fd_sc_hd__dfxtp_1
Xinference_cycles\[10\]$_SDFFE_PP0P_ clknet_2_2__leaf_clk_regs
+ _01554_ VSS VSS VDD VDD net28 sky130_fd_sc_hd__dfxtp_1
Xinference_cycles\[11\]$_SDFFE_PP0P_ clknet_2_2__leaf_clk_regs
+ _01553_ VSS VSS VDD VDD net29 sky130_fd_sc_hd__dfxtp_1
Xinference_cycles\[12\]$_SDFFE_PP0P_ clknet_2_3__leaf_clk_regs
+ _01552_ VSS VSS VDD VDD net30 sky130_fd_sc_hd__dfxtp_1
Xinference_cycles\[13\]$_SDFFE_PP0P_ clknet_2_2__leaf_clk_regs
+ _01551_ VSS VSS VDD VDD net31 sky130_fd_sc_hd__dfxtp_1
Xinference_cycles\[14\]$_SDFFE_PP0P_ clknet_2_2__leaf_clk_regs
+ _01550_ VSS VSS VDD VDD net32 sky130_fd_sc_hd__dfxtp_1
Xinference_cycles\[15\]$_SDFFE_PP0P_ clknet_2_0__leaf_clk_regs
+ _01954_ VSS VSS VDD VDD net33 sky130_fd_sc_hd__dfxtp_1
Xinference_cycles\[1\]$_SDFFE_PP0P_ clknet_2_3__leaf_clk_regs
+ _01563_ VSS VSS VDD VDD net34 sky130_fd_sc_hd__dfxtp_1
Xinference_cycles\[2\]$_SDFFE_PP0P_ clknet_2_3__leaf_clk_regs
+ _01562_ VSS VSS VDD VDD net35 sky130_fd_sc_hd__dfxtp_1
Xinference_cycles\[3\]$_SDFFE_PP0P_ clknet_2_3__leaf_clk_regs
+ _01561_ VSS VSS VDD VDD net36 sky130_fd_sc_hd__dfxtp_1
Xinference_cycles\[4\]$_SDFFE_PP0P_ clknet_2_3__leaf_clk_regs
+ _01560_ VSS VSS VDD VDD net37 sky130_fd_sc_hd__dfxtp_1
Xinference_cycles\[5\]$_SDFFE_PP0P_ clknet_2_3__leaf_clk_regs
+ _01559_ VSS VSS VDD VDD net38 sky130_fd_sc_hd__dfxtp_1
Xinference_cycles\[6\]$_SDFFE_PP0P_ clknet_2_3__leaf_clk_regs
+ _01558_ VSS VSS VDD VDD net39 sky130_fd_sc_hd__dfxtp_1
Xinference_cycles\[7\]$_SDFFE_PP0P_ clknet_2_3__leaf_clk_regs
+ _01557_ VSS VSS VDD VDD net40 sky130_fd_sc_hd__dfxtp_1
Xinference_cycles\[8\]$_SDFFE_PP0P_ clknet_2_2__leaf_clk_regs
+ _01556_ VSS VSS VDD VDD net41 sky130_fd_sc_hd__dfxtp_1
Xinference_cycles\[9\]$_SDFFE_PP0P_ clknet_2_2__leaf_clk_regs
+ _01555_ VSS VSS VDD VDD net42 sky130_fd_sc_hd__dfxtp_1
Xloaded\[0\]$_SDFFE_PP0P_ clknet_2_1__leaf_clk_regs _01572_
+ VSS VSS VDD VDD loaded\[0\] sky130_fd_sc_hd__dfxtp_1
Xloaded\[1\]$_SDFFE_PP0P_ clknet_2_1__leaf_clk_regs net484
+ VSS VSS VDD VDD loaded\[1\] sky130_fd_sc_hd__dfxtp_1
Xloaded\[2\]$_SDFFE_PP0P_ clknet_2_1__leaf_clk_regs _01570_
+ VSS VSS VDD VDD loaded\[2\] sky130_fd_sc_hd__dfxtp_1
Xloaded\[3\]$_SDFFE_PP0P_ clknet_2_0__leaf_clk_regs _01569_
+ VSS VSS VDD VDD loaded\[3\] sky130_fd_sc_hd__dfxtp_1
Xloaded\[4\]$_SDFFE_PP0P_ clknet_2_1__leaf_clk_regs _01568_
+ VSS VSS VDD VDD loaded\[4\] sky130_fd_sc_hd__dfxtp_1
Xloaded\[5\]$_SDFFE_PP0P_ clknet_2_0__leaf_clk_regs _01567_
+ VSS VSS VDD VDD loaded\[5\] sky130_fd_sc_hd__dfxtp_1
Xloaded\[6\]$_SDFFE_PP0P_ clknet_2_1__leaf_clk_regs _01566_
+ VSS VSS VDD VDD loaded\[6\] sky130_fd_sc_hd__dfxtp_1
Xloaded\[7\]$_SDFFE_PP0P_ clknet_2_1__leaf_clk_regs _01565_
+ VSS VSS VDD VDD loaded\[7\] sky130_fd_sc_hd__dfxtp_1
Xloaded\[8\]$_SDFFE_PP0P_ clknet_2_1__leaf_clk_regs _01950_
+ VSS VSS VDD VDD loaded\[8\] sky130_fd_sc_hd__dfxtp_1
Xnetwork.arbit.counter\[0\]$_SDFFE_PP0N_ clknet_leaf_125_clk_net
+ _01576_ VSS VSS VDD VDD network.arbit.counter\[0\] sky130_fd_sc_hd__dfxtp_1
Xnetwork.arbit.counter\[1\]$_SDFFE_PP0N_ clknet_leaf_125_clk_net
+ _01575_ VSS VSS VDD VDD network.arbit.counter\[1\] sky130_fd_sc_hd__dfxtp_1
Xnetwork.arbit.counter\[2\]$_SDFFE_PP1N_ clknet_leaf_124_clk_net
+ _01574_ VSS VSS VDD VDD network.arbit.counter\[2\] sky130_fd_sc_hd__dfxtp_1
Xnetwork.arbit.counter\[3\]$_SDFFE_PP1N_ clknet_leaf_124_clk_net
+ _01948_ VSS VSS VDD VDD network.arbit.counter\[3\] sky130_fd_sc_hd__dfxtp_1
Xnetwork.cnt_main.counter\[0\]$_SDFF_PP0_ clknet_leaf_121_clk_net
+ _01741_ VSS VSS VDD VDD network.cnt_main.counter\[0\] sky130_fd_sc_hd__dfxtp_1
Xnetwork.cnt_main.counter\[10\]$_SDFF_PP0_ clknet_leaf_122_clk_net
+ _01731_ VSS VSS VDD VDD network.cnt_main.counter\[10\] sky130_fd_sc_hd__dfxtp_1
Xnetwork.cnt_main.counter\[11\]$_SDFF_PP1_ clknet_leaf_122_clk_net
+ _01730_ VSS VSS VDD VDD network.cnt_main.counter\[11\] sky130_fd_sc_hd__dfxtp_1
Xnetwork.cnt_main.counter\[12\]$_SDFF_PP0_ clknet_leaf_122_clk_net
+ _01729_ VSS VSS VDD VDD network.cnt_main.counter\[12\] sky130_fd_sc_hd__dfxtp_1
Xnetwork.cnt_main.counter\[13\]$_SDFF_PP0_ clknet_leaf_122_clk_net
+ _01866_ VSS VSS VDD VDD network.cnt_main.counter\[13\] sky130_fd_sc_hd__dfxtp_1
Xnetwork.cnt_main.counter\[1\]$_SDFF_PP0_ clknet_leaf_121_clk_net
+ _01740_ VSS VSS VDD VDD network.cnt_main.counter\[1\] sky130_fd_sc_hd__dfxtp_1
Xnetwork.cnt_main.counter\[2\]$_SDFF_PP1_ clknet_leaf_122_clk_net
+ _01739_ VSS VSS VDD VDD network.cnt_main.counter\[2\] sky130_fd_sc_hd__dfxtp_1
Xnetwork.cnt_main.counter\[3\]$_SDFF_PP0_ clknet_leaf_121_clk_net
+ _01738_ VSS VSS VDD VDD network.cnt_main.counter\[3\] sky130_fd_sc_hd__dfxtp_1
Xnetwork.cnt_main.counter\[4\]$_SDFF_PP0_ clknet_leaf_121_clk_net
+ _01737_ VSS VSS VDD VDD network.cnt_main.counter\[4\] sky130_fd_sc_hd__dfxtp_1
Xnetwork.cnt_main.counter\[5\]$_SDFF_PP0_ clknet_leaf_121_clk_net
+ _01736_ VSS VSS VDD VDD network.cnt_main.counter\[5\] sky130_fd_sc_hd__dfxtp_1
Xnetwork.cnt_main.counter\[6\]$_SDFF_PP1_ clknet_leaf_121_clk_net
+ _01735_ VSS VSS VDD VDD network.cnt_main.counter\[6\] sky130_fd_sc_hd__dfxtp_1
Xnetwork.cnt_main.counter\[7\]$_SDFF_PP1_ clknet_leaf_122_clk_net
+ _01734_ VSS VSS VDD VDD network.cnt_main.counter\[7\] sky130_fd_sc_hd__dfxtp_1
Xnetwork.cnt_main.counter\[8\]$_SDFF_PP1_ clknet_leaf_122_clk_net
+ _01733_ VSS VSS VDD VDD network.cnt_main.counter\[8\] sky130_fd_sc_hd__dfxtp_1
Xnetwork.cnt_main.counter\[9\]$_SDFF_PP0_ clknet_leaf_123_clk_net
+ _01732_ VSS VSS VDD VDD network.cnt_main.counter\[9\] sky130_fd_sc_hd__dfxtp_1
Xnetwork.hid_controler.addr_out\[0\]$_SDFF_PP0_ clknet_leaf_70_clk_net
+ _01728_ VSS VSS VDD VDD network.ctrl_addr\[0\] sky130_fd_sc_hd__dfxtp_1
Xnetwork.hid_controler.addr_out\[1\]$_SDFF_PP0_ clknet_leaf_72_clk_net
+ _01727_ VSS VSS VDD VDD network.ctrl_addr\[1\] sky130_fd_sc_hd__dfxtp_1
Xnetwork.hid_controler.addr_out\[2\]$_SDFF_PP0_ clknet_leaf_72_clk_net
+ _01726_ VSS VSS VDD VDD network.ctrl_addr\[2\] sky130_fd_sc_hd__dfxtp_1
Xnetwork.hid_controler.addr_out\[3\]$_SDFF_PP0_ clknet_leaf_105_clk_net
+ _01725_ VSS VSS VDD VDD network.ctrl_addr\[3\] sky130_fd_sc_hd__dfxtp_1
Xnetwork.hid_controler.addr_out\[4\]$_SDFF_PP0_ clknet_leaf_107_clk_net
+ _01724_ VSS VSS VDD VDD network.ctrl_addr\[4\] sky130_fd_sc_hd__dfxtp_1
Xnetwork.hid_controler.addr_out\[5\]$_SDFF_PP0_ clknet_leaf_69_clk_net
+ _01723_ VSS VSS VDD VDD network.ctrl_addr\[5\] sky130_fd_sc_hd__dfxtp_1
Xnetwork.hid_controler.addr_out\[6\]$_SDFF_PP0_ clknet_leaf_104_clk_net
+ _01722_ VSS VSS VDD VDD network.ctrl_addr\[6\] sky130_fd_sc_hd__dfxtp_1
Xnetwork.hid_controler.addr_out\[7\]$_SDFF_PP0_ clknet_leaf_105_clk_net
+ _01903_ VSS VSS VDD VDD network.ctrl_addr\[7\] sky130_fd_sc_hd__dfxtp_1
Xnetwork.hid_controler.spike_out$_SDFF_PP0_ clknet_leaf_70_clk_net
+ _01902_ VSS VSS VDD VDD network.ctrl_spk sky130_fd_sc_hd__dfxtp_1
Xnetwork.in_period\[0\]\[0\]$_DFFE_PP_ clknet_leaf_114_clk_load
+ net478 _03087_ VSS VSS VDD VDD network.in_period\[0\]\[0\]
+ sky130_fd_sc_hd__edfxtp_1
Xnetwork.in_period\[0\]\[1\]$_DFFE_PP_ clknet_leaf_113_clk_load
+ net472 _03087_ VSS VSS VDD VDD network.in_period\[0\]\[1\]
+ sky130_fd_sc_hd__edfxtp_1
Xnetwork.in_period\[0\]\[2\]$_DFFE_PP_ clknet_leaf_113_clk_load
+ net465 _03087_ VSS VSS VDD VDD network.in_period\[0\]\[2\]
+ sky130_fd_sc_hd__edfxtp_1
Xnetwork.in_period\[0\]\[3\]$_DFFE_PP_ clknet_leaf_113_clk_load
+ net457 _03087_ VSS VSS VDD VDD network.in_period\[0\]\[3\]
+ sky130_fd_sc_hd__edfxtp_1
Xnetwork.in_period\[100\]\[0\]$_DFFE_PP_ clknet_leaf_34_clk_load
+ net481 _03088_ VSS VSS VDD VDD network.in_period\[100\]\[0\]
+ sky130_fd_sc_hd__edfxtp_1
Xnetwork.in_period\[100\]\[1\]$_DFFE_PP_ clknet_leaf_34_clk_load
+ net470 _03088_ VSS VSS VDD VDD network.in_period\[100\]\[1\]
+ sky130_fd_sc_hd__edfxtp_1
Xnetwork.in_period\[100\]\[2\]$_DFFE_PP_ clknet_leaf_34_clk_load
+ net464 _03088_ VSS VSS VDD VDD network.in_period\[100\]\[2\]
+ sky130_fd_sc_hd__edfxtp_1
Xnetwork.in_period\[100\]\[3\]$_DFFE_PP_ clknet_leaf_34_clk_load
+ net462 _03088_ VSS VSS VDD VDD network.in_period\[100\]\[3\]
+ sky130_fd_sc_hd__edfxtp_1
Xnetwork.in_period\[101\]\[0\]$_DFFE_PP_ clknet_leaf_37_clk_load
+ net476 _03089_ VSS VSS VDD VDD network.in_period\[101\]\[0\]
+ sky130_fd_sc_hd__edfxtp_1
Xnetwork.in_period\[101\]\[1\]$_DFFE_PP_ clknet_leaf_37_clk_load
+ net474 _03089_ VSS VSS VDD VDD network.in_period\[101\]\[1\]
+ sky130_fd_sc_hd__edfxtp_1
Xnetwork.in_period\[101\]\[2\]$_DFFE_PP_ clknet_leaf_36_clk_load
+ net468 _03089_ VSS VSS VDD VDD network.in_period\[101\]\[2\]
+ sky130_fd_sc_hd__edfxtp_1
Xnetwork.in_period\[101\]\[3\]$_DFFE_PP_ clknet_leaf_36_clk_load
+ net461 _03089_ VSS VSS VDD VDD network.in_period\[101\]\[3\]
+ sky130_fd_sc_hd__edfxtp_1
Xnetwork.in_period\[102\]\[0\]$_DFFE_PP_ clknet_leaf_36_clk_load
+ net476 _03090_ VSS VSS VDD VDD network.in_period\[102\]\[0\]
+ sky130_fd_sc_hd__edfxtp_1
Xnetwork.in_period\[102\]\[1\]$_DFFE_PP_ clknet_leaf_36_clk_load
+ net474 _03090_ VSS VSS VDD VDD network.in_period\[102\]\[1\]
+ sky130_fd_sc_hd__edfxtp_1
Xnetwork.in_period\[102\]\[2\]$_DFFE_PP_ clknet_leaf_36_clk_load
+ net468 _03090_ VSS VSS VDD VDD network.in_period\[102\]\[2\]
+ sky130_fd_sc_hd__edfxtp_1
Xnetwork.in_period\[102\]\[3\]$_DFFE_PP_ clknet_leaf_36_clk_load
+ net461 _03090_ VSS VSS VDD VDD network.in_period\[102\]\[3\]
+ sky130_fd_sc_hd__edfxtp_1
Xnetwork.in_period\[103\]\[0\]$_DFFE_PP_ clknet_leaf_22_clk_load
+ net480 _03091_ VSS VSS VDD VDD network.in_period\[103\]\[0\]
+ sky130_fd_sc_hd__edfxtp_1
Xnetwork.in_period\[103\]\[1\]$_DFFE_PP_ clknet_leaf_22_clk_load
+ net473 _03091_ VSS VSS VDD VDD network.in_period\[103\]\[1\]
+ sky130_fd_sc_hd__edfxtp_1
Xnetwork.in_period\[103\]\[2\]$_DFFE_PP_ clknet_leaf_22_clk_load
+ net468 _03091_ VSS VSS VDD VDD network.in_period\[103\]\[2\]
+ sky130_fd_sc_hd__edfxtp_1
Xnetwork.in_period\[103\]\[3\]$_DFFE_PP_ clknet_leaf_22_clk_load
+ net459 _03091_ VSS VSS VDD VDD network.in_period\[103\]\[3\]
+ sky130_fd_sc_hd__edfxtp_1
Xnetwork.in_period\[104\]\[0\]$_DFFE_PP_ clknet_leaf_22_clk_load
+ net480 _03092_ VSS VSS VDD VDD network.in_period\[104\]\[0\]
+ sky130_fd_sc_hd__edfxtp_1
Xnetwork.in_period\[104\]\[1\]$_DFFE_PP_ clknet_leaf_21_clk_load
+ net473 _03092_ VSS VSS VDD VDD network.in_period\[104\]\[1\]
+ sky130_fd_sc_hd__edfxtp_1
Xnetwork.in_period\[104\]\[2\]$_DFFE_PP_ clknet_leaf_21_clk_load
+ net467 _03092_ VSS VSS VDD VDD network.in_period\[104\]\[2\]
+ sky130_fd_sc_hd__edfxtp_1
Xnetwork.in_period\[104\]\[3\]$_DFFE_PP_ clknet_leaf_21_clk_load
+ net459 _03092_ VSS VSS VDD VDD network.in_period\[104\]\[3\]
+ sky130_fd_sc_hd__edfxtp_1
Xnetwork.in_period\[105\]\[0\]$_DFFE_PP_ clknet_leaf_36_clk_load
+ net481 _03093_ VSS VSS VDD VDD network.in_period\[105\]\[0\]
+ sky130_fd_sc_hd__edfxtp_1
Xnetwork.in_period\[105\]\[1\]$_DFFE_PP_ clknet_leaf_35_clk_load
+ net474 _03093_ VSS VSS VDD VDD network.in_period\[105\]\[1\]
+ sky130_fd_sc_hd__edfxtp_1
Xnetwork.in_period\[105\]\[2\]$_DFFE_PP_ clknet_leaf_35_clk_load
+ net468 _03093_ VSS VSS VDD VDD network.in_period\[105\]\[2\]
+ sky130_fd_sc_hd__edfxtp_1
Xnetwork.in_period\[105\]\[3\]$_DFFE_PP_ clknet_leaf_35_clk_load
+ net460 _03093_ VSS VSS VDD VDD network.in_period\[105\]\[3\]
+ sky130_fd_sc_hd__edfxtp_1
Xnetwork.in_period\[106\]\[0\]$_DFFE_PP_ clknet_leaf_32_clk_load
+ net481 _03094_ VSS VSS VDD VDD network.in_period\[106\]\[0\]
+ sky130_fd_sc_hd__edfxtp_1
Xnetwork.in_period\[106\]\[1\]$_DFFE_PP_ clknet_leaf_32_clk_load
+ net470 _03094_ VSS VSS VDD VDD network.in_period\[106\]\[1\]
+ sky130_fd_sc_hd__edfxtp_1
Xnetwork.in_period\[106\]\[2\]$_DFFE_PP_ clknet_leaf_32_clk_load
+ net464 _03094_ VSS VSS VDD VDD network.in_period\[106\]\[2\]
+ sky130_fd_sc_hd__edfxtp_1
Xnetwork.in_period\[106\]\[3\]$_DFFE_PP_ clknet_leaf_32_clk_load
+ net456 _03094_ VSS VSS VDD VDD network.in_period\[106\]\[3\]
+ sky130_fd_sc_hd__edfxtp_1
Xnetwork.in_period\[107\]\[0\]$_DFFE_PP_ clknet_leaf_31_clk_load
+ net481 _03095_ VSS VSS VDD VDD network.in_period\[107\]\[0\]
+ sky130_fd_sc_hd__edfxtp_1
Xnetwork.in_period\[107\]\[1\]$_DFFE_PP_ clknet_leaf_31_clk_load
+ net470 _03095_ VSS VSS VDD VDD network.in_period\[107\]\[1\]
+ sky130_fd_sc_hd__edfxtp_1
Xnetwork.in_period\[107\]\[2\]$_DFFE_PP_ clknet_leaf_31_clk_load
+ net464 _03095_ VSS VSS VDD VDD network.in_period\[107\]\[2\]
+ sky130_fd_sc_hd__edfxtp_1
Xnetwork.in_period\[107\]\[3\]$_DFFE_PP_ clknet_leaf_31_clk_load
+ net462 _03095_ VSS VSS VDD VDD network.in_period\[107\]\[3\]
+ sky130_fd_sc_hd__edfxtp_1
Xnetwork.in_period\[108\]\[0\]$_DFFE_PP_ clknet_leaf_29_clk_load
+ net480 _03096_ VSS VSS VDD VDD network.in_period\[108\]\[0\]
+ sky130_fd_sc_hd__edfxtp_1
Xnetwork.in_period\[108\]\[1\]$_DFFE_PP_ clknet_leaf_29_clk_load
+ net474 _03096_ VSS VSS VDD VDD network.in_period\[108\]\[1\]
+ sky130_fd_sc_hd__edfxtp_1
Xnetwork.in_period\[108\]\[2\]$_DFFE_PP_ clknet_leaf_29_clk_load
+ net468 _03096_ VSS VSS VDD VDD network.in_period\[108\]\[2\]
+ sky130_fd_sc_hd__edfxtp_1
Xnetwork.in_period\[108\]\[3\]$_DFFE_PP_ clknet_leaf_29_clk_load
+ net456 _03096_ VSS VSS VDD VDD network.in_period\[108\]\[3\]
+ sky130_fd_sc_hd__edfxtp_1
Xnetwork.in_period\[109\]\[0\]$_DFFE_PP_ clknet_leaf_30_clk_load
+ net480 _03097_ VSS VSS VDD VDD network.in_period\[109\]\[0\]
+ sky130_fd_sc_hd__edfxtp_1
Xnetwork.in_period\[109\]\[1\]$_DFFE_PP_ clknet_leaf_30_clk_load
+ net474 _03097_ VSS VSS VDD VDD network.in_period\[109\]\[1\]
+ sky130_fd_sc_hd__edfxtp_1
Xnetwork.in_period\[109\]\[2\]$_DFFE_PP_ clknet_leaf_29_clk_load
+ net468 _03097_ VSS VSS VDD VDD network.in_period\[109\]\[2\]
+ sky130_fd_sc_hd__edfxtp_1
Xnetwork.in_period\[109\]\[3\]$_DFFE_PP_ clknet_leaf_29_clk_load
+ net459 _03097_ VSS VSS VDD VDD network.in_period\[109\]\[3\]
+ sky130_fd_sc_hd__edfxtp_1
Xnetwork.in_period\[10\]\[0\]$_DFFE_PP_ clknet_leaf_114_clk_load
+ net478 _03098_ VSS VSS VDD VDD network.in_period\[10\]\[0\]
+ sky130_fd_sc_hd__edfxtp_1
Xnetwork.in_period\[10\]\[1\]$_DFFE_PP_ clknet_leaf_114_clk_load
+ net472 _03098_ VSS VSS VDD VDD network.in_period\[10\]\[1\]
+ sky130_fd_sc_hd__edfxtp_1
Xnetwork.in_period\[10\]\[2\]$_DFFE_PP_ clknet_leaf_114_clk_load
+ net465 _03098_ VSS VSS VDD VDD network.in_period\[10\]\[2\]
+ sky130_fd_sc_hd__edfxtp_1
Xnetwork.in_period\[10\]\[3\]$_DFFE_PP_ clknet_leaf_114_clk_load
+ net457 _03098_ VSS VSS VDD VDD network.in_period\[10\]\[3\]
+ sky130_fd_sc_hd__edfxtp_1
Xnetwork.in_period\[110\]\[0\]$_DFFE_PP_ clknet_leaf_29_clk_load
+ net481 _03099_ VSS VSS VDD VDD network.in_period\[110\]\[0\]
+ sky130_fd_sc_hd__edfxtp_1
Xnetwork.in_period\[110\]\[1\]$_DFFE_PP_ clknet_leaf_29_clk_load
+ net470 _03099_ VSS VSS VDD VDD network.in_period\[110\]\[1\]
+ sky130_fd_sc_hd__edfxtp_1
Xnetwork.in_period\[110\]\[2\]$_DFFE_PP_ clknet_leaf_29_clk_load
+ net464 _03099_ VSS VSS VDD VDD network.in_period\[110\]\[2\]
+ sky130_fd_sc_hd__edfxtp_1
Xnetwork.in_period\[110\]\[3\]$_DFFE_PP_ clknet_leaf_29_clk_load
+ net456 _03099_ VSS VSS VDD VDD network.in_period\[110\]\[3\]
+ sky130_fd_sc_hd__edfxtp_1
Xnetwork.in_period\[111\]\[0\]$_DFFE_PP_ clknet_leaf_30_clk_load
+ net480 _03100_ VSS VSS VDD VDD network.in_period\[111\]\[0\]
+ sky130_fd_sc_hd__edfxtp_1
Xnetwork.in_period\[111\]\[1\]$_DFFE_PP_ clknet_leaf_30_clk_load
+ net474 _03100_ VSS VSS VDD VDD network.in_period\[111\]\[1\]
+ sky130_fd_sc_hd__edfxtp_1
Xnetwork.in_period\[111\]\[2\]$_DFFE_PP_ clknet_leaf_31_clk_load
+ net468 _03100_ VSS VSS VDD VDD network.in_period\[111\]\[2\]
+ sky130_fd_sc_hd__edfxtp_1
Xnetwork.in_period\[111\]\[3\]$_DFFE_PP_ clknet_leaf_31_clk_load
+ net459 _03100_ VSS VSS VDD VDD network.in_period\[111\]\[3\]
+ sky130_fd_sc_hd__edfxtp_1
Xnetwork.in_period\[112\]\[0\]$_DFFE_PP_ clknet_leaf_25_clk_load
+ net477 _03101_ VSS VSS VDD VDD network.in_period\[112\]\[0\]
+ sky130_fd_sc_hd__edfxtp_1
Xnetwork.in_period\[112\]\[1\]$_DFFE_PP_ clknet_leaf_27_clk_load
+ net470 _03101_ VSS VSS VDD VDD network.in_period\[112\]\[1\]
+ sky130_fd_sc_hd__edfxtp_1
Xnetwork.in_period\[112\]\[2\]$_DFFE_PP_ clknet_leaf_25_clk_load
+ net464 _03101_ VSS VSS VDD VDD network.in_period\[112\]\[2\]
+ sky130_fd_sc_hd__edfxtp_1
Xnetwork.in_period\[112\]\[3\]$_DFFE_PP_ clknet_leaf_25_clk_load
+ net456 _03101_ VSS VSS VDD VDD network.in_period\[112\]\[3\]
+ sky130_fd_sc_hd__edfxtp_1
Xnetwork.in_period\[113\]\[0\]$_DFFE_PP_ clknet_leaf_27_clk_load
+ net481 _03102_ VSS VSS VDD VDD network.in_period\[113\]\[0\]
+ sky130_fd_sc_hd__edfxtp_1
Xnetwork.in_period\[113\]\[1\]$_DFFE_PP_ clknet_leaf_27_clk_load
+ net470 _03102_ VSS VSS VDD VDD network.in_period\[113\]\[1\]
+ sky130_fd_sc_hd__edfxtp_1
Xnetwork.in_period\[113\]\[2\]$_DFFE_PP_ clknet_leaf_27_clk_load
+ net464 _03102_ VSS VSS VDD VDD network.in_period\[113\]\[2\]
+ sky130_fd_sc_hd__edfxtp_1
Xnetwork.in_period\[113\]\[3\]$_DFFE_PP_ clknet_leaf_27_clk_load
+ net456 _03102_ VSS VSS VDD VDD network.in_period\[113\]\[3\]
+ sky130_fd_sc_hd__edfxtp_1
Xnetwork.in_period\[114\]\[0\]$_DFFE_PP_ clknet_leaf_28_clk_load
+ net481 _03103_ VSS VSS VDD VDD network.in_period\[114\]\[0\]
+ sky130_fd_sc_hd__edfxtp_1
Xnetwork.in_period\[114\]\[1\]$_DFFE_PP_ clknet_leaf_28_clk_load
+ net470 _03103_ VSS VSS VDD VDD network.in_period\[114\]\[1\]
+ sky130_fd_sc_hd__edfxtp_1
Xnetwork.in_period\[114\]\[2\]$_DFFE_PP_ clknet_leaf_28_clk_load
+ net464 _03103_ VSS VSS VDD VDD network.in_period\[114\]\[2\]
+ sky130_fd_sc_hd__edfxtp_1
Xnetwork.in_period\[114\]\[3\]$_DFFE_PP_ clknet_leaf_27_clk_load
+ net456 _03103_ VSS VSS VDD VDD network.in_period\[114\]\[3\]
+ sky130_fd_sc_hd__edfxtp_1
Xnetwork.in_period\[115\]\[0\]$_DFFE_PP_ clknet_leaf_23_clk_load
+ net480 _03104_ VSS VSS VDD VDD network.in_period\[115\]\[0\]
+ sky130_fd_sc_hd__edfxtp_1
Xnetwork.in_period\[115\]\[1\]$_DFFE_PP_ clknet_leaf_23_clk_load
+ net474 _03104_ VSS VSS VDD VDD network.in_period\[115\]\[1\]
+ sky130_fd_sc_hd__edfxtp_1
Xnetwork.in_period\[115\]\[2\]$_DFFE_PP_ clknet_leaf_23_clk_load
+ net468 _03104_ VSS VSS VDD VDD network.in_period\[115\]\[2\]
+ sky130_fd_sc_hd__edfxtp_1
Xnetwork.in_period\[115\]\[3\]$_DFFE_PP_ clknet_leaf_23_clk_load
+ net456 _03104_ VSS VSS VDD VDD network.in_period\[115\]\[3\]
+ sky130_fd_sc_hd__edfxtp_1
Xnetwork.in_period\[116\]\[0\]$_DFFE_PP_ clknet_leaf_26_clk_load
+ net481 _03105_ VSS VSS VDD VDD network.in_period\[116\]\[0\]
+ sky130_fd_sc_hd__edfxtp_1
Xnetwork.in_period\[116\]\[1\]$_DFFE_PP_ clknet_leaf_26_clk_load
+ net470 _03105_ VSS VSS VDD VDD network.in_period\[116\]\[1\]
+ sky130_fd_sc_hd__edfxtp_1
Xnetwork.in_period\[116\]\[2\]$_DFFE_PP_ clknet_leaf_26_clk_load
+ net464 _03105_ VSS VSS VDD VDD network.in_period\[116\]\[2\]
+ sky130_fd_sc_hd__edfxtp_1
Xnetwork.in_period\[116\]\[3\]$_DFFE_PP_ clknet_leaf_26_clk_load
+ net456 _03105_ VSS VSS VDD VDD network.in_period\[116\]\[3\]
+ sky130_fd_sc_hd__edfxtp_1
Xnetwork.in_period\[117\]\[0\]$_DFFE_PP_ clknet_leaf_28_clk_load
+ net481 _03106_ VSS VSS VDD VDD network.in_period\[117\]\[0\]
+ sky130_fd_sc_hd__edfxtp_1
Xnetwork.in_period\[117\]\[1\]$_DFFE_PP_ clknet_leaf_28_clk_load
+ net470 _03106_ VSS VSS VDD VDD network.in_period\[117\]\[1\]
+ sky130_fd_sc_hd__edfxtp_1
Xnetwork.in_period\[117\]\[2\]$_DFFE_PP_ clknet_leaf_28_clk_load
+ net464 _03106_ VSS VSS VDD VDD network.in_period\[117\]\[2\]
+ sky130_fd_sc_hd__edfxtp_1
Xnetwork.in_period\[117\]\[3\]$_DFFE_PP_ clknet_leaf_28_clk_load
+ net456 _03106_ VSS VSS VDD VDD network.in_period\[117\]\[3\]
+ sky130_fd_sc_hd__edfxtp_1
Xnetwork.in_period\[118\]\[0\]$_DFFE_PP_ clknet_leaf_24_clk_load
+ net480 _03107_ VSS VSS VDD VDD network.in_period\[118\]\[0\]
+ sky130_fd_sc_hd__edfxtp_1
Xnetwork.in_period\[118\]\[1\]$_DFFE_PP_ clknet_leaf_24_clk_load
+ net474 _03107_ VSS VSS VDD VDD network.in_period\[118\]\[1\]
+ sky130_fd_sc_hd__edfxtp_1
Xnetwork.in_period\[118\]\[2\]$_DFFE_PP_ clknet_leaf_10_clk_load
+ net467 _03107_ VSS VSS VDD VDD network.in_period\[118\]\[2\]
+ sky130_fd_sc_hd__edfxtp_1
Xnetwork.in_period\[118\]\[3\]$_DFFE_PP_ clknet_leaf_10_clk_load
+ net459 _03107_ VSS VSS VDD VDD network.in_period\[118\]\[3\]
+ sky130_fd_sc_hd__edfxtp_1
Xnetwork.in_period\[119\]\[0\]$_DFFE_PP_ clknet_leaf_25_clk_load
+ net481 _03108_ VSS VSS VDD VDD network.in_period\[119\]\[0\]
+ sky130_fd_sc_hd__edfxtp_1
Xnetwork.in_period\[119\]\[1\]$_DFFE_PP_ clknet_leaf_27_clk_load
+ net470 _03108_ VSS VSS VDD VDD network.in_period\[119\]\[1\]
+ sky130_fd_sc_hd__edfxtp_1
Xnetwork.in_period\[119\]\[2\]$_DFFE_PP_ clknet_leaf_27_clk_load
+ net464 _03108_ VSS VSS VDD VDD network.in_period\[119\]\[2\]
+ sky130_fd_sc_hd__edfxtp_1
Xnetwork.in_period\[119\]\[3\]$_DFFE_PP_ clknet_leaf_27_clk_load
+ net456 _03108_ VSS VSS VDD VDD network.in_period\[119\]\[3\]
+ sky130_fd_sc_hd__edfxtp_1
Xnetwork.in_period\[11\]\[0\]$_DFFE_PP_ clknet_leaf_114_clk_load
+ net478 _03109_ VSS VSS VDD VDD network.in_period\[11\]\[0\]
+ sky130_fd_sc_hd__edfxtp_1
Xnetwork.in_period\[11\]\[1\]$_DFFE_PP_ clknet_leaf_114_clk_load
+ net472 _03109_ VSS VSS VDD VDD network.in_period\[11\]\[1\]
+ sky130_fd_sc_hd__edfxtp_1
Xnetwork.in_period\[11\]\[2\]$_DFFE_PP_ clknet_leaf_114_clk_load
+ net465 _03109_ VSS VSS VDD VDD network.in_period\[11\]\[2\]
+ sky130_fd_sc_hd__edfxtp_1
Xnetwork.in_period\[11\]\[3\]$_DFFE_PP_ clknet_leaf_114_clk_load
+ net457 _03109_ VSS VSS VDD VDD network.in_period\[11\]\[3\]
+ sky130_fd_sc_hd__edfxtp_1
Xnetwork.in_period\[120\]\[0\]$_DFFE_PP_ clknet_leaf_26_clk_load
+ net481 _03110_ VSS VSS VDD VDD network.in_period\[120\]\[0\]
+ sky130_fd_sc_hd__edfxtp_1
Xnetwork.in_period\[120\]\[1\]$_DFFE_PP_ clknet_leaf_26_clk_load
+ net470 _03110_ VSS VSS VDD VDD network.in_period\[120\]\[1\]
+ sky130_fd_sc_hd__edfxtp_1
Xnetwork.in_period\[120\]\[2\]$_DFFE_PP_ clknet_leaf_26_clk_load
+ net464 _03110_ VSS VSS VDD VDD network.in_period\[120\]\[2\]
+ sky130_fd_sc_hd__edfxtp_1
Xnetwork.in_period\[120\]\[3\]$_DFFE_PP_ clknet_leaf_26_clk_load
+ net456 _03110_ VSS VSS VDD VDD network.in_period\[120\]\[3\]
+ sky130_fd_sc_hd__edfxtp_1
Xnetwork.in_period\[121\]\[0\]$_DFFE_PP_ clknet_leaf_25_clk_load
+ net481 _03111_ VSS VSS VDD VDD network.in_period\[121\]\[0\]
+ sky130_fd_sc_hd__edfxtp_1
Xnetwork.in_period\[121\]\[1\]$_DFFE_PP_ clknet_leaf_25_clk_load
+ net470 _03111_ VSS VSS VDD VDD network.in_period\[121\]\[1\]
+ sky130_fd_sc_hd__edfxtp_1
Xnetwork.in_period\[121\]\[2\]$_DFFE_PP_ clknet_leaf_25_clk_load
+ net464 _03111_ VSS VSS VDD VDD network.in_period\[121\]\[2\]
+ sky130_fd_sc_hd__edfxtp_1
Xnetwork.in_period\[121\]\[3\]$_DFFE_PP_ clknet_leaf_25_clk_load
+ net456 _03111_ VSS VSS VDD VDD network.in_period\[121\]\[3\]
+ sky130_fd_sc_hd__edfxtp_1
Xnetwork.in_period\[122\]\[0\]$_DFFE_PP_ clknet_leaf_8_clk_load
+ net481 _03112_ VSS VSS VDD VDD network.in_period\[122\]\[0\]
+ sky130_fd_sc_hd__edfxtp_1
Xnetwork.in_period\[122\]\[1\]$_DFFE_PP_ clknet_leaf_8_clk_load
+ net470 _03112_ VSS VSS VDD VDD network.in_period\[122\]\[1\]
+ sky130_fd_sc_hd__edfxtp_1
Xnetwork.in_period\[122\]\[2\]$_DFFE_PP_ clknet_leaf_8_clk_load
+ net464 _03112_ VSS VSS VDD VDD network.in_period\[122\]\[2\]
+ sky130_fd_sc_hd__edfxtp_1
Xnetwork.in_period\[122\]\[3\]$_DFFE_PP_ clknet_leaf_8_clk_load
+ net456 _03112_ VSS VSS VDD VDD network.in_period\[122\]\[3\]
+ sky130_fd_sc_hd__edfxtp_1
Xnetwork.in_period\[123\]\[0\]$_DFFE_PP_ clknet_leaf_8_clk_load
+ net477 _03113_ VSS VSS VDD VDD network.in_period\[123\]\[0\]
+ sky130_fd_sc_hd__edfxtp_1
Xnetwork.in_period\[123\]\[1\]$_DFFE_PP_ clknet_leaf_25_clk_load
+ net470 _03113_ VSS VSS VDD VDD network.in_period\[123\]\[1\]
+ sky130_fd_sc_hd__edfxtp_1
Xnetwork.in_period\[123\]\[2\]$_DFFE_PP_ clknet_leaf_8_clk_load
+ net464 _03113_ VSS VSS VDD VDD network.in_period\[123\]\[2\]
+ sky130_fd_sc_hd__edfxtp_1
Xnetwork.in_period\[123\]\[3\]$_DFFE_PP_ clknet_leaf_8_clk_load
+ net456 _03113_ VSS VSS VDD VDD network.in_period\[123\]\[3\]
+ sky130_fd_sc_hd__edfxtp_1
Xnetwork.in_period\[124\]\[0\]$_DFFE_PP_ clknet_leaf_10_clk_load
+ net477 _03114_ VSS VSS VDD VDD network.in_period\[124\]\[0\]
+ sky130_fd_sc_hd__edfxtp_1
Xnetwork.in_period\[124\]\[1\]$_DFFE_PP_ clknet_leaf_9_clk_load
+ net470 _03114_ VSS VSS VDD VDD network.in_period\[124\]\[1\]
+ sky130_fd_sc_hd__edfxtp_1
Xnetwork.in_period\[124\]\[2\]$_DFFE_PP_ clknet_leaf_9_clk_load
+ net464 _03114_ VSS VSS VDD VDD network.in_period\[124\]\[2\]
+ sky130_fd_sc_hd__edfxtp_1
Xnetwork.in_period\[124\]\[3\]$_DFFE_PP_ clknet_leaf_9_clk_load
+ net456 _03114_ VSS VSS VDD VDD network.in_period\[124\]\[3\]
+ sky130_fd_sc_hd__edfxtp_1
Xnetwork.in_period\[125\]\[0\]$_DFFE_PP_ clknet_leaf_9_clk_load
+ net477 _03115_ VSS VSS VDD VDD network.in_period\[125\]\[0\]
+ sky130_fd_sc_hd__edfxtp_1
Xnetwork.in_period\[125\]\[1\]$_DFFE_PP_ clknet_leaf_9_clk_load
+ net470 _03115_ VSS VSS VDD VDD network.in_period\[125\]\[1\]
+ sky130_fd_sc_hd__edfxtp_1
Xnetwork.in_period\[125\]\[2\]$_DFFE_PP_ clknet_leaf_9_clk_load
+ net464 _03115_ VSS VSS VDD VDD network.in_period\[125\]\[2\]
+ sky130_fd_sc_hd__edfxtp_1
Xnetwork.in_period\[125\]\[3\]$_DFFE_PP_ clknet_leaf_9_clk_load
+ net456 _03115_ VSS VSS VDD VDD network.in_period\[125\]\[3\]
+ sky130_fd_sc_hd__edfxtp_1
Xnetwork.in_period\[126\]\[0\]$_DFFE_PP_ clknet_leaf_9_clk_load
+ net477 _03116_ VSS VSS VDD VDD network.in_period\[126\]\[0\]
+ sky130_fd_sc_hd__edfxtp_1
Xnetwork.in_period\[126\]\[1\]$_DFFE_PP_ clknet_leaf_8_clk_load
+ net470 _03116_ VSS VSS VDD VDD network.in_period\[126\]\[1\]
+ sky130_fd_sc_hd__edfxtp_1
Xnetwork.in_period\[126\]\[2\]$_DFFE_PP_ clknet_leaf_8_clk_load
+ net464 _03116_ VSS VSS VDD VDD network.in_period\[126\]\[2\]
+ sky130_fd_sc_hd__edfxtp_1
Xnetwork.in_period\[126\]\[3\]$_DFFE_PP_ clknet_leaf_8_clk_load
+ net456 _03116_ VSS VSS VDD VDD network.in_period\[126\]\[3\]
+ sky130_fd_sc_hd__edfxtp_1
Xnetwork.in_period\[127\]\[0\]$_DFFE_PP_ clknet_leaf_7_clk_load
+ net481 _03117_ VSS VSS VDD VDD network.in_period\[127\]\[0\]
+ sky130_fd_sc_hd__edfxtp_1
Xnetwork.in_period\[127\]\[1\]$_DFFE_PP_ clknet_leaf_7_clk_load
+ net470 _03117_ VSS VSS VDD VDD network.in_period\[127\]\[1\]
+ sky130_fd_sc_hd__edfxtp_1
Xnetwork.in_period\[127\]\[2\]$_DFFE_PP_ clknet_leaf_7_clk_load
+ net464 _03117_ VSS VSS VDD VDD network.in_period\[127\]\[2\]
+ sky130_fd_sc_hd__edfxtp_1
Xnetwork.in_period\[127\]\[3\]$_DFFE_PP_ clknet_leaf_7_clk_load
+ net456 _03117_ VSS VSS VDD VDD network.in_period\[127\]\[3\]
+ sky130_fd_sc_hd__edfxtp_1
Xnetwork.in_period\[128\]\[0\]$_DFFE_PP_ clknet_leaf_106_clk_load
+ net478 _03118_ VSS VSS VDD VDD network.in_period\[128\]\[0\]
+ sky130_fd_sc_hd__edfxtp_1
Xnetwork.in_period\[128\]\[1\]$_DFFE_PP_ clknet_leaf_106_clk_load
+ net473 _03118_ VSS VSS VDD VDD network.in_period\[128\]\[1\]
+ sky130_fd_sc_hd__edfxtp_1
Xnetwork.in_period\[128\]\[2\]$_DFFE_PP_ clknet_leaf_106_clk_load
+ net465 _03118_ VSS VSS VDD VDD network.in_period\[128\]\[2\]
+ sky130_fd_sc_hd__edfxtp_1
Xnetwork.in_period\[128\]\[3\]$_DFFE_PP_ clknet_leaf_106_clk_load
+ net457 _03118_ VSS VSS VDD VDD network.in_period\[128\]\[3\]
+ sky130_fd_sc_hd__edfxtp_1
Xnetwork.in_period\[129\]\[0\]$_DFFE_PP_ clknet_leaf_99_clk_load
+ net478 _03119_ VSS VSS VDD VDD network.in_period\[129\]\[0\]
+ sky130_fd_sc_hd__edfxtp_1
Xnetwork.in_period\[129\]\[1\]$_DFFE_PP_ clknet_leaf_99_clk_load
+ net472 _03119_ VSS VSS VDD VDD network.in_period\[129\]\[1\]
+ sky130_fd_sc_hd__edfxtp_1
Xnetwork.in_period\[129\]\[2\]$_DFFE_PP_ clknet_leaf_103_clk_load
+ net465 _03119_ VSS VSS VDD VDD network.in_period\[129\]\[2\]
+ sky130_fd_sc_hd__edfxtp_1
Xnetwork.in_period\[129\]\[3\]$_DFFE_PP_ clknet_leaf_103_clk_load
+ net457 _03119_ VSS VSS VDD VDD network.in_period\[129\]\[3\]
+ sky130_fd_sc_hd__edfxtp_1
Xnetwork.in_period\[12\]\[0\]$_DFFE_PP_ clknet_leaf_117_clk_load
+ net480 _03120_ VSS VSS VDD VDD network.in_period\[12\]\[0\]
+ sky130_fd_sc_hd__edfxtp_1
Xnetwork.in_period\[12\]\[1\]$_DFFE_PP_ clknet_leaf_117_clk_load
+ net473 _03120_ VSS VSS VDD VDD network.in_period\[12\]\[1\]
+ sky130_fd_sc_hd__edfxtp_1
Xnetwork.in_period\[12\]\[2\]$_DFFE_PP_ clknet_leaf_115_clk_load
+ net467 _03120_ VSS VSS VDD VDD network.in_period\[12\]\[2\]
+ sky130_fd_sc_hd__edfxtp_1
Xnetwork.in_period\[12\]\[3\]$_DFFE_PP_ clknet_leaf_115_clk_load
+ net459 _03120_ VSS VSS VDD VDD network.in_period\[12\]\[3\]
+ sky130_fd_sc_hd__edfxtp_1
Xnetwork.in_period\[130\]\[0\]$_DFFE_PP_ clknet_leaf_74_clk_load
+ net479 _03121_ VSS VSS VDD VDD network.in_period\[130\]\[0\]
+ sky130_fd_sc_hd__edfxtp_1
Xnetwork.in_period\[130\]\[1\]$_DFFE_PP_ clknet_leaf_74_clk_load
+ net471 _03121_ VSS VSS VDD VDD network.in_period\[130\]\[1\]
+ sky130_fd_sc_hd__edfxtp_1
Xnetwork.in_period\[130\]\[2\]$_DFFE_PP_ clknet_leaf_74_clk_load
+ net466 _03121_ VSS VSS VDD VDD network.in_period\[130\]\[2\]
+ sky130_fd_sc_hd__edfxtp_1
Xnetwork.in_period\[130\]\[3\]$_DFFE_PP_ clknet_leaf_74_clk_load
+ net458 _03121_ VSS VSS VDD VDD network.in_period\[130\]\[3\]
+ sky130_fd_sc_hd__edfxtp_1
Xnetwork.in_period\[131\]\[0\]$_DFFE_PP_ clknet_leaf_75_clk_load
+ net479 _03122_ VSS VSS VDD VDD network.in_period\[131\]\[0\]
+ sky130_fd_sc_hd__edfxtp_1
Xnetwork.in_period\[131\]\[1\]$_DFFE_PP_ clknet_leaf_75_clk_load
+ net471 _03122_ VSS VSS VDD VDD network.in_period\[131\]\[1\]
+ sky130_fd_sc_hd__edfxtp_1
Xnetwork.in_period\[131\]\[2\]$_DFFE_PP_ clknet_leaf_75_clk_load
+ net466 _03122_ VSS VSS VDD VDD network.in_period\[131\]\[2\]
+ sky130_fd_sc_hd__edfxtp_1
Xnetwork.in_period\[131\]\[3\]$_DFFE_PP_ clknet_leaf_75_clk_load
+ net458 _03122_ VSS VSS VDD VDD network.in_period\[131\]\[3\]
+ sky130_fd_sc_hd__edfxtp_1
Xnetwork.in_period\[132\]\[0\]$_DFFE_PP_ clknet_leaf_105_clk_load
+ net479 _03123_ VSS VSS VDD VDD network.in_period\[132\]\[0\]
+ sky130_fd_sc_hd__edfxtp_1
Xnetwork.in_period\[132\]\[1\]$_DFFE_PP_ clknet_leaf_106_clk_load
+ net471 _03123_ VSS VSS VDD VDD network.in_period\[132\]\[1\]
+ sky130_fd_sc_hd__edfxtp_1
Xnetwork.in_period\[132\]\[2\]$_DFFE_PP_ clknet_leaf_106_clk_load
+ net466 _03123_ VSS VSS VDD VDD network.in_period\[132\]\[2\]
+ sky130_fd_sc_hd__edfxtp_1
Xnetwork.in_period\[132\]\[3\]$_DFFE_PP_ clknet_leaf_105_clk_load
+ net458 _03123_ VSS VSS VDD VDD network.in_period\[132\]\[3\]
+ sky130_fd_sc_hd__edfxtp_1
Xnetwork.in_period\[133\]\[0\]$_DFFE_PP_ clknet_leaf_103_clk_load
+ net478 _03124_ VSS VSS VDD VDD network.in_period\[133\]\[0\]
+ sky130_fd_sc_hd__edfxtp_1
Xnetwork.in_period\[133\]\[1\]$_DFFE_PP_ clknet_leaf_103_clk_load
+ net472 _03124_ VSS VSS VDD VDD network.in_period\[133\]\[1\]
+ sky130_fd_sc_hd__edfxtp_1
Xnetwork.in_period\[133\]\[2\]$_DFFE_PP_ clknet_leaf_104_clk_load
+ net465 _03124_ VSS VSS VDD VDD network.in_period\[133\]\[2\]
+ sky130_fd_sc_hd__edfxtp_1
Xnetwork.in_period\[133\]\[3\]$_DFFE_PP_ clknet_leaf_103_clk_load
+ net457 _03124_ VSS VSS VDD VDD network.in_period\[133\]\[3\]
+ sky130_fd_sc_hd__edfxtp_1
Xnetwork.in_period\[134\]\[0\]$_DFFE_PP_ clknet_leaf_106_clk_load
+ net478 _03125_ VSS VSS VDD VDD network.in_period\[134\]\[0\]
+ sky130_fd_sc_hd__edfxtp_1
Xnetwork.in_period\[134\]\[1\]$_DFFE_PP_ clknet_leaf_106_clk_load
+ net472 _03125_ VSS VSS VDD VDD network.in_period\[134\]\[1\]
+ sky130_fd_sc_hd__edfxtp_1
Xnetwork.in_period\[134\]\[2\]$_DFFE_PP_ clknet_leaf_106_clk_load
+ net465 _03125_ VSS VSS VDD VDD network.in_period\[134\]\[2\]
+ sky130_fd_sc_hd__edfxtp_1
Xnetwork.in_period\[134\]\[3\]$_DFFE_PP_ clknet_leaf_106_clk_load
+ net457 _03125_ VSS VSS VDD VDD network.in_period\[134\]\[3\]
+ sky130_fd_sc_hd__edfxtp_1
Xnetwork.in_period\[135\]\[0\]$_DFFE_PP_ clknet_leaf_103_clk_load
+ net478 _03126_ VSS VSS VDD VDD network.in_period\[135\]\[0\]
+ sky130_fd_sc_hd__edfxtp_1
Xnetwork.in_period\[135\]\[1\]$_DFFE_PP_ clknet_leaf_103_clk_load
+ net472 _03126_ VSS VSS VDD VDD network.in_period\[135\]\[1\]
+ sky130_fd_sc_hd__edfxtp_1
Xnetwork.in_period\[135\]\[2\]$_DFFE_PP_ clknet_leaf_103_clk_load
+ net465 _03126_ VSS VSS VDD VDD network.in_period\[135\]\[2\]
+ sky130_fd_sc_hd__edfxtp_1
Xnetwork.in_period\[135\]\[3\]$_DFFE_PP_ clknet_leaf_103_clk_load
+ net457 _03126_ VSS VSS VDD VDD network.in_period\[135\]\[3\]
+ sky130_fd_sc_hd__edfxtp_1
Xnetwork.in_period\[136\]\[0\]$_DFFE_PP_ clknet_leaf_74_clk_load
+ net479 _03127_ VSS VSS VDD VDD network.in_period\[136\]\[0\]
+ sky130_fd_sc_hd__edfxtp_1
Xnetwork.in_period\[136\]\[1\]$_DFFE_PP_ clknet_leaf_75_clk_load
+ net471 _03127_ VSS VSS VDD VDD network.in_period\[136\]\[1\]
+ sky130_fd_sc_hd__edfxtp_1
Xnetwork.in_period\[136\]\[2\]$_DFFE_PP_ clknet_leaf_74_clk_load
+ net466 _03127_ VSS VSS VDD VDD network.in_period\[136\]\[2\]
+ sky130_fd_sc_hd__edfxtp_1
Xnetwork.in_period\[136\]\[3\]$_DFFE_PP_ clknet_leaf_75_clk_load
+ net458 _03127_ VSS VSS VDD VDD network.in_period\[136\]\[3\]
+ sky130_fd_sc_hd__edfxtp_1
Xnetwork.in_period\[137\]\[0\]$_DFFE_PP_ clknet_leaf_104_clk_load
+ net478 _03128_ VSS VSS VDD VDD network.in_period\[137\]\[0\]
+ sky130_fd_sc_hd__edfxtp_1
Xnetwork.in_period\[137\]\[1\]$_DFFE_PP_ clknet_leaf_104_clk_load
+ net472 _03128_ VSS VSS VDD VDD network.in_period\[137\]\[1\]
+ sky130_fd_sc_hd__edfxtp_1
Xnetwork.in_period\[137\]\[2\]$_DFFE_PP_ clknet_leaf_104_clk_load
+ net465 _03128_ VSS VSS VDD VDD network.in_period\[137\]\[2\]
+ sky130_fd_sc_hd__edfxtp_1
Xnetwork.in_period\[137\]\[3\]$_DFFE_PP_ clknet_leaf_104_clk_load
+ net457 _03128_ VSS VSS VDD VDD network.in_period\[137\]\[3\]
+ sky130_fd_sc_hd__edfxtp_1
Xnetwork.in_period\[138\]\[0\]$_DFFE_PP_ clknet_leaf_102_clk_load
+ net478 _03129_ VSS VSS VDD VDD network.in_period\[138\]\[0\]
+ sky130_fd_sc_hd__edfxtp_1
Xnetwork.in_period\[138\]\[1\]$_DFFE_PP_ clknet_leaf_102_clk_load
+ net472 _03129_ VSS VSS VDD VDD network.in_period\[138\]\[1\]
+ sky130_fd_sc_hd__edfxtp_1
Xnetwork.in_period\[138\]\[2\]$_DFFE_PP_ clknet_leaf_101_clk_load
+ net465 _03129_ VSS VSS VDD VDD network.in_period\[138\]\[2\]
+ sky130_fd_sc_hd__edfxtp_1
Xnetwork.in_period\[138\]\[3\]$_DFFE_PP_ clknet_leaf_102_clk_load
+ net457 _03129_ VSS VSS VDD VDD network.in_period\[138\]\[3\]
+ sky130_fd_sc_hd__edfxtp_1
Xnetwork.in_period\[139\]\[0\]$_DFFE_PP_ clknet_leaf_102_clk_load
+ net478 _03130_ VSS VSS VDD VDD network.in_period\[139\]\[0\]
+ sky130_fd_sc_hd__edfxtp_1
Xnetwork.in_period\[139\]\[1\]$_DFFE_PP_ clknet_leaf_102_clk_load
+ net472 _03130_ VSS VSS VDD VDD network.in_period\[139\]\[1\]
+ sky130_fd_sc_hd__edfxtp_1
Xnetwork.in_period\[139\]\[2\]$_DFFE_PP_ clknet_leaf_102_clk_load
+ net465 _03130_ VSS VSS VDD VDD network.in_period\[139\]\[2\]
+ sky130_fd_sc_hd__edfxtp_1
Xnetwork.in_period\[139\]\[3\]$_DFFE_PP_ clknet_leaf_102_clk_load
+ net457 _03130_ VSS VSS VDD VDD network.in_period\[139\]\[3\]
+ sky130_fd_sc_hd__edfxtp_1
Xnetwork.in_period\[13\]\[0\]$_DFFE_PP_ clknet_leaf_113_clk_load
+ net478 _03131_ VSS VSS VDD VDD network.in_period\[13\]\[0\]
+ sky130_fd_sc_hd__edfxtp_1
Xnetwork.in_period\[13\]\[1\]$_DFFE_PP_ clknet_leaf_113_clk_load
+ net472 _03131_ VSS VSS VDD VDD network.in_period\[13\]\[1\]
+ sky130_fd_sc_hd__edfxtp_1
Xnetwork.in_period\[13\]\[2\]$_DFFE_PP_ clknet_leaf_112_clk_load
+ net465 _03131_ VSS VSS VDD VDD network.in_period\[13\]\[2\]
+ sky130_fd_sc_hd__edfxtp_1
Xnetwork.in_period\[13\]\[3\]$_DFFE_PP_ clknet_leaf_112_clk_load
+ net457 _03131_ VSS VSS VDD VDD network.in_period\[13\]\[3\]
+ sky130_fd_sc_hd__edfxtp_1
Xnetwork.in_period\[140\]\[0\]$_DFFE_PP_ clknet_leaf_102_clk_load
+ net478 _03132_ VSS VSS VDD VDD network.in_period\[140\]\[0\]
+ sky130_fd_sc_hd__edfxtp_1
Xnetwork.in_period\[140\]\[1\]$_DFFE_PP_ clknet_leaf_102_clk_load
+ net472 _03132_ VSS VSS VDD VDD network.in_period\[140\]\[1\]
+ sky130_fd_sc_hd__edfxtp_1
Xnetwork.in_period\[140\]\[2\]$_DFFE_PP_ clknet_leaf_101_clk_load
+ net465 _03132_ VSS VSS VDD VDD network.in_period\[140\]\[2\]
+ sky130_fd_sc_hd__edfxtp_1
Xnetwork.in_period\[140\]\[3\]$_DFFE_PP_ clknet_leaf_101_clk_load
+ net457 _03132_ VSS VSS VDD VDD network.in_period\[140\]\[3\]
+ sky130_fd_sc_hd__edfxtp_1
Xnetwork.in_period\[141\]\[0\]$_DFFE_PP_ clknet_leaf_101_clk_load
+ net478 _03133_ VSS VSS VDD VDD network.in_period\[141\]\[0\]
+ sky130_fd_sc_hd__edfxtp_1
Xnetwork.in_period\[141\]\[1\]$_DFFE_PP_ clknet_leaf_101_clk_load
+ net472 _03133_ VSS VSS VDD VDD network.in_period\[141\]\[1\]
+ sky130_fd_sc_hd__edfxtp_1
Xnetwork.in_period\[141\]\[2\]$_DFFE_PP_ clknet_leaf_101_clk_load
+ net465 _03133_ VSS VSS VDD VDD network.in_period\[141\]\[2\]
+ sky130_fd_sc_hd__edfxtp_1
Xnetwork.in_period\[141\]\[3\]$_DFFE_PP_ clknet_leaf_101_clk_load
+ net457 _03133_ VSS VSS VDD VDD network.in_period\[141\]\[3\]
+ sky130_fd_sc_hd__edfxtp_1
Xnetwork.in_period\[142\]\[0\]$_DFFE_PP_ clknet_leaf_76_clk_load
+ net479 _03134_ VSS VSS VDD VDD network.in_period\[142\]\[0\]
+ sky130_fd_sc_hd__edfxtp_1
Xnetwork.in_period\[142\]\[1\]$_DFFE_PP_ clknet_leaf_76_clk_load
+ net471 _03134_ VSS VSS VDD VDD network.in_period\[142\]\[1\]
+ sky130_fd_sc_hd__edfxtp_1
Xnetwork.in_period\[142\]\[2\]$_DFFE_PP_ clknet_leaf_76_clk_load
+ net466 _03134_ VSS VSS VDD VDD network.in_period\[142\]\[2\]
+ sky130_fd_sc_hd__edfxtp_1
Xnetwork.in_period\[142\]\[3\]$_DFFE_PP_ clknet_leaf_76_clk_load
+ net458 _03134_ VSS VSS VDD VDD network.in_period\[142\]\[3\]
+ sky130_fd_sc_hd__edfxtp_1
Xnetwork.in_period\[143\]\[0\]$_DFFE_PP_ clknet_leaf_75_clk_load
+ net479 _03135_ VSS VSS VDD VDD network.in_period\[143\]\[0\]
+ sky130_fd_sc_hd__edfxtp_1
Xnetwork.in_period\[143\]\[1\]$_DFFE_PP_ clknet_leaf_75_clk_load
+ net471 _03135_ VSS VSS VDD VDD network.in_period\[143\]\[1\]
+ sky130_fd_sc_hd__edfxtp_1
Xnetwork.in_period\[143\]\[2\]$_DFFE_PP_ clknet_leaf_75_clk_load
+ net466 _03135_ VSS VSS VDD VDD network.in_period\[143\]\[2\]
+ sky130_fd_sc_hd__edfxtp_1
Xnetwork.in_period\[143\]\[3\]$_DFFE_PP_ clknet_leaf_75_clk_load
+ net458 _03135_ VSS VSS VDD VDD network.in_period\[143\]\[3\]
+ sky130_fd_sc_hd__edfxtp_1
Xnetwork.in_period\[144\]\[0\]$_DFFE_PP_ clknet_leaf_45_clk_load
+ net476 _03136_ VSS VSS VDD VDD network.in_period\[144\]\[0\]
+ sky130_fd_sc_hd__edfxtp_1
Xnetwork.in_period\[144\]\[1\]$_DFFE_PP_ clknet_leaf_45_clk_load
+ net474 _03136_ VSS VSS VDD VDD network.in_period\[144\]\[1\]
+ sky130_fd_sc_hd__edfxtp_1
Xnetwork.in_period\[144\]\[2\]$_DFFE_PP_ clknet_leaf_45_clk_load
+ net468 _03136_ VSS VSS VDD VDD network.in_period\[144\]\[2\]
+ sky130_fd_sc_hd__edfxtp_1
Xnetwork.in_period\[144\]\[3\]$_DFFE_PP_ clknet_leaf_45_clk_load
+ net460 _03136_ VSS VSS VDD VDD network.in_period\[144\]\[3\]
+ sky130_fd_sc_hd__edfxtp_1
Xnetwork.in_period\[145\]\[0\]$_DFFE_PP_ clknet_leaf_46_clk_load
+ net476 _03137_ VSS VSS VDD VDD network.in_period\[145\]\[0\]
+ sky130_fd_sc_hd__edfxtp_1
Xnetwork.in_period\[145\]\[1\]$_DFFE_PP_ clknet_leaf_46_clk_load
+ net469 _03137_ VSS VSS VDD VDD network.in_period\[145\]\[1\]
+ sky130_fd_sc_hd__edfxtp_1
Xnetwork.in_period\[145\]\[2\]$_DFFE_PP_ clknet_leaf_46_clk_load
+ net463 _03137_ VSS VSS VDD VDD network.in_period\[145\]\[2\]
+ sky130_fd_sc_hd__edfxtp_1
Xnetwork.in_period\[145\]\[3\]$_DFFE_PP_ clknet_leaf_46_clk_load
+ net460 _03137_ VSS VSS VDD VDD network.in_period\[145\]\[3\]
+ sky130_fd_sc_hd__edfxtp_1
Xnetwork.in_period\[146\]\[0\]$_DFFE_PP_ clknet_leaf_41_clk_load
+ net475 _03138_ VSS VSS VDD VDD network.in_period\[146\]\[0\]
+ sky130_fd_sc_hd__edfxtp_1
Xnetwork.in_period\[146\]\[1\]$_DFFE_PP_ clknet_leaf_54_clk_load
+ net469 _03138_ VSS VSS VDD VDD network.in_period\[146\]\[1\]
+ sky130_fd_sc_hd__edfxtp_1
Xnetwork.in_period\[146\]\[2\]$_DFFE_PP_ clknet_leaf_40_clk_load
+ net468 _03138_ VSS VSS VDD VDD network.in_period\[146\]\[2\]
+ sky130_fd_sc_hd__edfxtp_1
Xnetwork.in_period\[146\]\[3\]$_DFFE_PP_ clknet_leaf_55_clk_load
+ net462 _03138_ VSS VSS VDD VDD network.in_period\[146\]\[3\]
+ sky130_fd_sc_hd__edfxtp_1
Xnetwork.in_period\[147\]\[0\]$_DFFE_PP_ clknet_leaf_42_clk_load
+ net475 _03139_ VSS VSS VDD VDD network.in_period\[147\]\[0\]
+ sky130_fd_sc_hd__edfxtp_1
Xnetwork.in_period\[147\]\[1\]$_DFFE_PP_ clknet_leaf_42_clk_load
+ net469 _03139_ VSS VSS VDD VDD network.in_period\[147\]\[1\]
+ sky130_fd_sc_hd__edfxtp_1
Xnetwork.in_period\[147\]\[2\]$_DFFE_PP_ clknet_leaf_42_clk_load
+ net463 _03139_ VSS VSS VDD VDD network.in_period\[147\]\[2\]
+ sky130_fd_sc_hd__edfxtp_1
Xnetwork.in_period\[147\]\[3\]$_DFFE_PP_ clknet_leaf_41_clk_load
+ net461 _03139_ VSS VSS VDD VDD network.in_period\[147\]\[3\]
+ sky130_fd_sc_hd__edfxtp_1
Xnetwork.in_period\[148\]\[0\]$_DFFE_PP_ clknet_leaf_42_clk_load
+ net475 _03140_ VSS VSS VDD VDD network.in_period\[148\]\[0\]
+ sky130_fd_sc_hd__edfxtp_1
Xnetwork.in_period\[148\]\[1\]$_DFFE_PP_ clknet_leaf_42_clk_load
+ net469 _03140_ VSS VSS VDD VDD network.in_period\[148\]\[1\]
+ sky130_fd_sc_hd__edfxtp_1
Xnetwork.in_period\[148\]\[2\]$_DFFE_PP_ clknet_leaf_42_clk_load
+ net463 _03140_ VSS VSS VDD VDD network.in_period\[148\]\[2\]
+ sky130_fd_sc_hd__edfxtp_1
Xnetwork.in_period\[148\]\[3\]$_DFFE_PP_ clknet_leaf_42_clk_load
+ net460 _03140_ VSS VSS VDD VDD network.in_period\[148\]\[3\]
+ sky130_fd_sc_hd__edfxtp_1
Xnetwork.in_period\[149\]\[0\]$_DFFE_PP_ clknet_leaf_53_clk_load
+ net475 _03141_ VSS VSS VDD VDD network.in_period\[149\]\[0\]
+ sky130_fd_sc_hd__edfxtp_1
Xnetwork.in_period\[149\]\[1\]$_DFFE_PP_ clknet_leaf_53_clk_load
+ net469 _03141_ VSS VSS VDD VDD network.in_period\[149\]\[1\]
+ sky130_fd_sc_hd__edfxtp_1
Xnetwork.in_period\[149\]\[2\]$_DFFE_PP_ clknet_leaf_53_clk_load
+ net463 _03141_ VSS VSS VDD VDD network.in_period\[149\]\[2\]
+ sky130_fd_sc_hd__edfxtp_1
Xnetwork.in_period\[149\]\[3\]$_DFFE_PP_ clknet_leaf_53_clk_load
+ net460 _03141_ VSS VSS VDD VDD network.in_period\[149\]\[3\]
+ sky130_fd_sc_hd__edfxtp_1
Xnetwork.in_period\[14\]\[0\]$_DFFE_PP_ clknet_leaf_110_clk_load
+ net478 _03142_ VSS VSS VDD VDD network.in_period\[14\]\[0\]
+ sky130_fd_sc_hd__edfxtp_1
Xnetwork.in_period\[14\]\[1\]$_DFFE_PP_ clknet_leaf_110_clk_load
+ net472 _03142_ VSS VSS VDD VDD network.in_period\[14\]\[1\]
+ sky130_fd_sc_hd__edfxtp_1
Xnetwork.in_period\[14\]\[2\]$_DFFE_PP_ clknet_leaf_110_clk_load
+ net465 _03142_ VSS VSS VDD VDD network.in_period\[14\]\[2\]
+ sky130_fd_sc_hd__edfxtp_1
Xnetwork.in_period\[14\]\[3\]$_DFFE_PP_ clknet_leaf_110_clk_load
+ net457 _03142_ VSS VSS VDD VDD network.in_period\[14\]\[3\]
+ sky130_fd_sc_hd__edfxtp_1
Xnetwork.in_period\[150\]\[0\]$_DFFE_PP_ clknet_leaf_43_clk_load
+ net476 _03143_ VSS VSS VDD VDD network.in_period\[150\]\[0\]
+ sky130_fd_sc_hd__edfxtp_1
Xnetwork.in_period\[150\]\[1\]$_DFFE_PP_ clknet_leaf_43_clk_load
+ net474 _03143_ VSS VSS VDD VDD network.in_period\[150\]\[1\]
+ sky130_fd_sc_hd__edfxtp_1
Xnetwork.in_period\[150\]\[2\]$_DFFE_PP_ clknet_leaf_43_clk_load
+ net468 _03143_ VSS VSS VDD VDD network.in_period\[150\]\[2\]
+ sky130_fd_sc_hd__edfxtp_1
Xnetwork.in_period\[150\]\[3\]$_DFFE_PP_ clknet_leaf_43_clk_load
+ net460 _03143_ VSS VSS VDD VDD network.in_period\[150\]\[3\]
+ sky130_fd_sc_hd__edfxtp_1
Xnetwork.in_period\[151\]\[0\]$_DFFE_PP_ clknet_leaf_45_clk_load
+ net476 _03144_ VSS VSS VDD VDD network.in_period\[151\]\[0\]
+ sky130_fd_sc_hd__edfxtp_1
Xnetwork.in_period\[151\]\[1\]$_DFFE_PP_ clknet_leaf_45_clk_load
+ net474 _03144_ VSS VSS VDD VDD network.in_period\[151\]\[1\]
+ sky130_fd_sc_hd__edfxtp_1
Xnetwork.in_period\[151\]\[2\]$_DFFE_PP_ clknet_leaf_45_clk_load
+ net468 _03144_ VSS VSS VDD VDD network.in_period\[151\]\[2\]
+ sky130_fd_sc_hd__edfxtp_1
Xnetwork.in_period\[151\]\[3\]$_DFFE_PP_ clknet_leaf_45_clk_load
+ net460 _03144_ VSS VSS VDD VDD network.in_period\[151\]\[3\]
+ sky130_fd_sc_hd__edfxtp_1
Xnetwork.in_period\[152\]\[0\]$_DFFE_PP_ clknet_leaf_44_clk_load
+ net480 _03145_ VSS VSS VDD VDD network.in_period\[152\]\[0\]
+ sky130_fd_sc_hd__edfxtp_1
Xnetwork.in_period\[152\]\[1\]$_DFFE_PP_ clknet_leaf_44_clk_load
+ net473 _03145_ VSS VSS VDD VDD network.in_period\[152\]\[1\]
+ sky130_fd_sc_hd__edfxtp_1
Xnetwork.in_period\[152\]\[2\]$_DFFE_PP_ clknet_leaf_45_clk_load
+ net467 _03145_ VSS VSS VDD VDD network.in_period\[152\]\[2\]
+ sky130_fd_sc_hd__edfxtp_1
Xnetwork.in_period\[152\]\[3\]$_DFFE_PP_ clknet_leaf_44_clk_load
+ net459 _03145_ VSS VSS VDD VDD network.in_period\[152\]\[3\]
+ sky130_fd_sc_hd__edfxtp_1
Xnetwork.in_period\[153\]\[0\]$_DFFE_PP_ clknet_leaf_19_clk_load
+ net480 _03146_ VSS VSS VDD VDD network.in_period\[153\]\[0\]
+ sky130_fd_sc_hd__edfxtp_1
Xnetwork.in_period\[153\]\[1\]$_DFFE_PP_ clknet_leaf_21_clk_load
+ net473 _03146_ VSS VSS VDD VDD network.in_period\[153\]\[1\]
+ sky130_fd_sc_hd__edfxtp_1
Xnetwork.in_period\[153\]\[2\]$_DFFE_PP_ clknet_leaf_21_clk_load
+ net467 _03146_ VSS VSS VDD VDD network.in_period\[153\]\[2\]
+ sky130_fd_sc_hd__edfxtp_1
Xnetwork.in_period\[153\]\[3\]$_DFFE_PP_ clknet_leaf_21_clk_load
+ net459 _03146_ VSS VSS VDD VDD network.in_period\[153\]\[3\]
+ sky130_fd_sc_hd__edfxtp_1
Xnetwork.in_period\[154\]\[0\]$_DFFE_PP_ clknet_leaf_72_clk_load
+ net479 _03147_ VSS VSS VDD VDD network.in_period\[154\]\[0\]
+ sky130_fd_sc_hd__edfxtp_1
Xnetwork.in_period\[154\]\[1\]$_DFFE_PP_ clknet_leaf_72_clk_load
+ net471 _03147_ VSS VSS VDD VDD network.in_period\[154\]\[1\]
+ sky130_fd_sc_hd__edfxtp_1
Xnetwork.in_period\[154\]\[2\]$_DFFE_PP_ clknet_leaf_47_clk_load
+ net466 _03147_ VSS VSS VDD VDD network.in_period\[154\]\[2\]
+ sky130_fd_sc_hd__edfxtp_1
Xnetwork.in_period\[154\]\[3\]$_DFFE_PP_ clknet_leaf_47_clk_load
+ net458 _03147_ VSS VSS VDD VDD network.in_period\[154\]\[3\]
+ sky130_fd_sc_hd__edfxtp_1
Xnetwork.in_period\[155\]\[0\]$_DFFE_PP_ clknet_leaf_17_clk_load
+ net479 _03148_ VSS VSS VDD VDD network.in_period\[155\]\[0\]
+ sky130_fd_sc_hd__edfxtp_1
Xnetwork.in_period\[155\]\[1\]$_DFFE_PP_ clknet_leaf_17_clk_load
+ net471 _03148_ VSS VSS VDD VDD network.in_period\[155\]\[1\]
+ sky130_fd_sc_hd__edfxtp_1
Xnetwork.in_period\[155\]\[2\]$_DFFE_PP_ clknet_leaf_17_clk_load
+ net466 _03148_ VSS VSS VDD VDD network.in_period\[155\]\[2\]
+ sky130_fd_sc_hd__edfxtp_1
Xnetwork.in_period\[155\]\[3\]$_DFFE_PP_ clknet_leaf_18_clk_load
+ net458 _03148_ VSS VSS VDD VDD network.in_period\[155\]\[3\]
+ sky130_fd_sc_hd__edfxtp_1
Xnetwork.in_period\[156\]\[0\]$_DFFE_PP_ clknet_leaf_17_clk_load
+ net479 _03149_ VSS VSS VDD VDD network.in_period\[156\]\[0\]
+ sky130_fd_sc_hd__edfxtp_1
Xnetwork.in_period\[156\]\[1\]$_DFFE_PP_ clknet_leaf_17_clk_load
+ net471 _03149_ VSS VSS VDD VDD network.in_period\[156\]\[1\]
+ sky130_fd_sc_hd__edfxtp_1
Xnetwork.in_period\[156\]\[2\]$_DFFE_PP_ clknet_leaf_16_clk_load
+ net466 _03149_ VSS VSS VDD VDD network.in_period\[156\]\[2\]
+ sky130_fd_sc_hd__edfxtp_1
Xnetwork.in_period\[156\]\[3\]$_DFFE_PP_ clknet_leaf_16_clk_load
+ net458 _03149_ VSS VSS VDD VDD network.in_period\[156\]\[3\]
+ sky130_fd_sc_hd__edfxtp_1
Xnetwork.in_period\[157\]\[0\]$_DFFE_PP_ clknet_leaf_18_clk_load
+ net479 _03150_ VSS VSS VDD VDD network.in_period\[157\]\[0\]
+ sky130_fd_sc_hd__edfxtp_1
Xnetwork.in_period\[157\]\[1\]$_DFFE_PP_ clknet_leaf_18_clk_load
+ net471 _03150_ VSS VSS VDD VDD network.in_period\[157\]\[1\]
+ sky130_fd_sc_hd__edfxtp_1
Xnetwork.in_period\[157\]\[2\]$_DFFE_PP_ clknet_leaf_17_clk_load
+ net466 _03150_ VSS VSS VDD VDD network.in_period\[157\]\[2\]
+ sky130_fd_sc_hd__edfxtp_1
Xnetwork.in_period\[157\]\[3\]$_DFFE_PP_ clknet_leaf_17_clk_load
+ net458 _03150_ VSS VSS VDD VDD network.in_period\[157\]\[3\]
+ sky130_fd_sc_hd__edfxtp_1
Xnetwork.in_period\[158\]\[0\]$_DFFE_PP_ clknet_leaf_18_clk_load
+ net479 _03151_ VSS VSS VDD VDD network.in_period\[158\]\[0\]
+ sky130_fd_sc_hd__edfxtp_1
Xnetwork.in_period\[158\]\[1\]$_DFFE_PP_ clknet_leaf_18_clk_load
+ net471 _03151_ VSS VSS VDD VDD network.in_period\[158\]\[1\]
+ sky130_fd_sc_hd__edfxtp_1
Xnetwork.in_period\[158\]\[2\]$_DFFE_PP_ clknet_leaf_18_clk_load
+ net467 _03151_ VSS VSS VDD VDD network.in_period\[158\]\[2\]
+ sky130_fd_sc_hd__edfxtp_1
Xnetwork.in_period\[158\]\[3\]$_DFFE_PP_ clknet_leaf_18_clk_load
+ net458 _03151_ VSS VSS VDD VDD network.in_period\[158\]\[3\]
+ sky130_fd_sc_hd__edfxtp_1
Xnetwork.in_period\[159\]\[0\]$_DFFE_PP_ clknet_leaf_72_clk_load
+ net479 _03152_ VSS VSS VDD VDD network.in_period\[159\]\[0\]
+ sky130_fd_sc_hd__edfxtp_1
Xnetwork.in_period\[159\]\[1\]$_DFFE_PP_ clknet_leaf_72_clk_load
+ net471 _03152_ VSS VSS VDD VDD network.in_period\[159\]\[1\]
+ sky130_fd_sc_hd__edfxtp_1
Xnetwork.in_period\[159\]\[2\]$_DFFE_PP_ clknet_leaf_17_clk_load
+ net466 _03152_ VSS VSS VDD VDD network.in_period\[159\]\[2\]
+ sky130_fd_sc_hd__edfxtp_1
Xnetwork.in_period\[159\]\[3\]$_DFFE_PP_ clknet_leaf_17_clk_load
+ net458 _03152_ VSS VSS VDD VDD network.in_period\[159\]\[3\]
+ sky130_fd_sc_hd__edfxtp_1
Xnetwork.in_period\[15\]\[0\]$_DFFE_PP_ clknet_leaf_112_clk_load
+ net478 _03153_ VSS VSS VDD VDD network.in_period\[15\]\[0\]
+ sky130_fd_sc_hd__edfxtp_1
Xnetwork.in_period\[15\]\[1\]$_DFFE_PP_ clknet_leaf_112_clk_load
+ net472 _03153_ VSS VSS VDD VDD network.in_period\[15\]\[1\]
+ sky130_fd_sc_hd__edfxtp_1
Xnetwork.in_period\[15\]\[2\]$_DFFE_PP_ clknet_leaf_112_clk_load
+ net465 _03153_ VSS VSS VDD VDD network.in_period\[15\]\[2\]
+ sky130_fd_sc_hd__edfxtp_1
Xnetwork.in_period\[15\]\[3\]$_DFFE_PP_ clknet_leaf_112_clk_load
+ net457 _03153_ VSS VSS VDD VDD network.in_period\[15\]\[3\]
+ sky130_fd_sc_hd__edfxtp_1
Xnetwork.in_period\[160\]\[0\]$_DFFE_PP_ clknet_leaf_51_clk_load
+ net475 _03154_ VSS VSS VDD VDD network.in_period\[160\]\[0\]
+ sky130_fd_sc_hd__edfxtp_1
Xnetwork.in_period\[160\]\[1\]$_DFFE_PP_ clknet_leaf_51_clk_load
+ net469 _03154_ VSS VSS VDD VDD network.in_period\[160\]\[1\]
+ sky130_fd_sc_hd__edfxtp_1
Xnetwork.in_period\[160\]\[2\]$_DFFE_PP_ clknet_leaf_51_clk_load
+ net463 _03154_ VSS VSS VDD VDD network.in_period\[160\]\[2\]
+ sky130_fd_sc_hd__edfxtp_1
Xnetwork.in_period\[160\]\[3\]$_DFFE_PP_ clknet_leaf_51_clk_load
+ net461 _03154_ VSS VSS VDD VDD network.in_period\[160\]\[3\]
+ sky130_fd_sc_hd__edfxtp_1
Xnetwork.in_period\[161\]\[0\]$_DFFE_PP_ clknet_leaf_50_clk_load
+ net476 _03155_ VSS VSS VDD VDD network.in_period\[161\]\[0\]
+ sky130_fd_sc_hd__edfxtp_1
Xnetwork.in_period\[161\]\[1\]$_DFFE_PP_ clknet_leaf_50_clk_load
+ net469 _03155_ VSS VSS VDD VDD network.in_period\[161\]\[1\]
+ sky130_fd_sc_hd__edfxtp_1
Xnetwork.in_period\[161\]\[2\]$_DFFE_PP_ clknet_leaf_53_clk_load
+ net463 _03155_ VSS VSS VDD VDD network.in_period\[161\]\[2\]
+ sky130_fd_sc_hd__edfxtp_1
Xnetwork.in_period\[161\]\[3\]$_DFFE_PP_ clknet_leaf_50_clk_load
+ net460 _03155_ VSS VSS VDD VDD network.in_period\[161\]\[3\]
+ sky130_fd_sc_hd__edfxtp_1
Xnetwork.in_period\[162\]\[0\]$_DFFE_PP_ clknet_leaf_52_clk_load
+ net475 _03156_ VSS VSS VDD VDD network.in_period\[162\]\[0\]
+ sky130_fd_sc_hd__edfxtp_1
Xnetwork.in_period\[162\]\[1\]$_DFFE_PP_ clknet_leaf_52_clk_load
+ net469 _03156_ VSS VSS VDD VDD network.in_period\[162\]\[1\]
+ sky130_fd_sc_hd__edfxtp_1
Xnetwork.in_period\[162\]\[2\]$_DFFE_PP_ clknet_leaf_52_clk_load
+ net463 _03156_ VSS VSS VDD VDD network.in_period\[162\]\[2\]
+ sky130_fd_sc_hd__edfxtp_1
Xnetwork.in_period\[162\]\[3\]$_DFFE_PP_ clknet_leaf_52_clk_load
+ net461 _03156_ VSS VSS VDD VDD network.in_period\[162\]\[3\]
+ sky130_fd_sc_hd__edfxtp_1
Xnetwork.in_period\[163\]\[0\]$_DFFE_PP_ clknet_leaf_59_clk_load
+ net475 _03157_ VSS VSS VDD VDD network.in_period\[163\]\[0\]
+ sky130_fd_sc_hd__edfxtp_1
Xnetwork.in_period\[163\]\[1\]$_DFFE_PP_ clknet_leaf_59_clk_load
+ net469 _03157_ VSS VSS VDD VDD network.in_period\[163\]\[1\]
+ sky130_fd_sc_hd__edfxtp_1
Xnetwork.in_period\[163\]\[2\]$_DFFE_PP_ clknet_leaf_59_clk_load
+ net463 _03157_ VSS VSS VDD VDD network.in_period\[163\]\[2\]
+ sky130_fd_sc_hd__edfxtp_1
Xnetwork.in_period\[163\]\[3\]$_DFFE_PP_ clknet_leaf_59_clk_load
+ net462 _03157_ VSS VSS VDD VDD network.in_period\[163\]\[3\]
+ sky130_fd_sc_hd__edfxtp_1
Xnetwork.in_period\[164\]\[0\]$_DFFE_PP_ clknet_leaf_55_clk_load
+ net475 _03158_ VSS VSS VDD VDD network.in_period\[164\]\[0\]
+ sky130_fd_sc_hd__edfxtp_1
Xnetwork.in_period\[164\]\[1\]$_DFFE_PP_ clknet_leaf_55_clk_load
+ net469 _03158_ VSS VSS VDD VDD network.in_period\[164\]\[1\]
+ sky130_fd_sc_hd__edfxtp_1
Xnetwork.in_period\[164\]\[2\]$_DFFE_PP_ clknet_leaf_54_clk_load
+ net463 _03158_ VSS VSS VDD VDD network.in_period\[164\]\[2\]
+ sky130_fd_sc_hd__edfxtp_1
Xnetwork.in_period\[164\]\[3\]$_DFFE_PP_ clknet_leaf_54_clk_load
+ net461 _03158_ VSS VSS VDD VDD network.in_period\[164\]\[3\]
+ sky130_fd_sc_hd__edfxtp_1
Xnetwork.in_period\[165\]\[0\]$_DFFE_PP_ clknet_leaf_54_clk_load
+ net475 _03159_ VSS VSS VDD VDD network.in_period\[165\]\[0\]
+ sky130_fd_sc_hd__edfxtp_1
Xnetwork.in_period\[165\]\[1\]$_DFFE_PP_ clknet_leaf_52_clk_load
+ net469 _03159_ VSS VSS VDD VDD network.in_period\[165\]\[1\]
+ sky130_fd_sc_hd__edfxtp_1
Xnetwork.in_period\[165\]\[2\]$_DFFE_PP_ clknet_leaf_52_clk_load
+ net463 _03159_ VSS VSS VDD VDD network.in_period\[165\]\[2\]
+ sky130_fd_sc_hd__edfxtp_1
Xnetwork.in_period\[165\]\[3\]$_DFFE_PP_ clknet_leaf_52_clk_load
+ net461 _03159_ VSS VSS VDD VDD network.in_period\[165\]\[3\]
+ sky130_fd_sc_hd__edfxtp_1
Xnetwork.in_period\[166\]\[0\]$_DFFE_PP_ clknet_leaf_52_clk_load
+ net475 _03160_ VSS VSS VDD VDD network.in_period\[166\]\[0\]
+ sky130_fd_sc_hd__edfxtp_1
Xnetwork.in_period\[166\]\[1\]$_DFFE_PP_ clknet_leaf_52_clk_load
+ net469 _03160_ VSS VSS VDD VDD network.in_period\[166\]\[1\]
+ sky130_fd_sc_hd__edfxtp_1
Xnetwork.in_period\[166\]\[2\]$_DFFE_PP_ clknet_leaf_52_clk_load
+ net463 _03160_ VSS VSS VDD VDD network.in_period\[166\]\[2\]
+ sky130_fd_sc_hd__edfxtp_1
Xnetwork.in_period\[166\]\[3\]$_DFFE_PP_ clknet_leaf_52_clk_load
+ net461 _03160_ VSS VSS VDD VDD network.in_period\[166\]\[3\]
+ sky130_fd_sc_hd__edfxtp_1
Xnetwork.in_period\[167\]\[0\]$_DFFE_PP_ clknet_leaf_50_clk_load
+ net476 _03161_ VSS VSS VDD VDD network.in_period\[167\]\[0\]
+ sky130_fd_sc_hd__edfxtp_1
Xnetwork.in_period\[167\]\[1\]$_DFFE_PP_ clknet_leaf_50_clk_load
+ net469 _03161_ VSS VSS VDD VDD network.in_period\[167\]\[1\]
+ sky130_fd_sc_hd__edfxtp_1
Xnetwork.in_period\[167\]\[2\]$_DFFE_PP_ clknet_leaf_50_clk_load
+ net463 _03161_ VSS VSS VDD VDD network.in_period\[167\]\[2\]
+ sky130_fd_sc_hd__edfxtp_1
Xnetwork.in_period\[167\]\[3\]$_DFFE_PP_ clknet_leaf_50_clk_load
+ net460 _03161_ VSS VSS VDD VDD network.in_period\[167\]\[3\]
+ sky130_fd_sc_hd__edfxtp_1
Xnetwork.in_period\[168\]\[0\]$_DFFE_PP_ clknet_leaf_54_clk_load
+ net475 _03162_ VSS VSS VDD VDD network.in_period\[168\]\[0\]
+ sky130_fd_sc_hd__edfxtp_1
Xnetwork.in_period\[168\]\[1\]$_DFFE_PP_ clknet_leaf_54_clk_load
+ net469 _03162_ VSS VSS VDD VDD network.in_period\[168\]\[1\]
+ sky130_fd_sc_hd__edfxtp_1
Xnetwork.in_period\[168\]\[2\]$_DFFE_PP_ clknet_leaf_54_clk_load
+ net463 _03162_ VSS VSS VDD VDD network.in_period\[168\]\[2\]
+ sky130_fd_sc_hd__edfxtp_1
Xnetwork.in_period\[168\]\[3\]$_DFFE_PP_ clknet_leaf_54_clk_load
+ net461 _03162_ VSS VSS VDD VDD network.in_period\[168\]\[3\]
+ sky130_fd_sc_hd__edfxtp_1
Xnetwork.in_period\[169\]\[0\]$_DFFE_PP_ clknet_leaf_53_clk_load
+ net475 _03163_ VSS VSS VDD VDD network.in_period\[169\]\[0\]
+ sky130_fd_sc_hd__edfxtp_1
Xnetwork.in_period\[169\]\[1\]$_DFFE_PP_ clknet_leaf_53_clk_load
+ net469 _03163_ VSS VSS VDD VDD network.in_period\[169\]\[1\]
+ sky130_fd_sc_hd__edfxtp_1
Xnetwork.in_period\[169\]\[2\]$_DFFE_PP_ clknet_leaf_53_clk_load
+ net463 _03163_ VSS VSS VDD VDD network.in_period\[169\]\[2\]
+ sky130_fd_sc_hd__edfxtp_1
Xnetwork.in_period\[169\]\[3\]$_DFFE_PP_ clknet_leaf_53_clk_load
+ net461 _03163_ VSS VSS VDD VDD network.in_period\[169\]\[3\]
+ sky130_fd_sc_hd__edfxtp_1
Xnetwork.in_period\[16\]\[0\]$_DFFE_PP_ clknet_leaf_109_clk_load
+ net480 _03164_ VSS VSS VDD VDD network.in_period\[16\]\[0\]
+ sky130_fd_sc_hd__edfxtp_1
Xnetwork.in_period\[16\]\[1\]$_DFFE_PP_ clknet_leaf_109_clk_load
+ net473 _03164_ VSS VSS VDD VDD network.in_period\[16\]\[1\]
+ sky130_fd_sc_hd__edfxtp_1
Xnetwork.in_period\[16\]\[2\]$_DFFE_PP_ clknet_leaf_109_clk_load
+ net466 _03164_ VSS VSS VDD VDD network.in_period\[16\]\[2\]
+ sky130_fd_sc_hd__edfxtp_1
Xnetwork.in_period\[16\]\[3\]$_DFFE_PP_ clknet_leaf_109_clk_load
+ net458 _03164_ VSS VSS VDD VDD network.in_period\[16\]\[3\]
+ sky130_fd_sc_hd__edfxtp_1
Xnetwork.in_period\[170\]\[0\]$_DFFE_PP_ clknet_leaf_51_clk_load
+ net475 _03165_ VSS VSS VDD VDD network.in_period\[170\]\[0\]
+ sky130_fd_sc_hd__edfxtp_1
Xnetwork.in_period\[170\]\[1\]$_DFFE_PP_ clknet_leaf_51_clk_load
+ net469 _03165_ VSS VSS VDD VDD network.in_period\[170\]\[1\]
+ sky130_fd_sc_hd__edfxtp_1
Xnetwork.in_period\[170\]\[2\]$_DFFE_PP_ clknet_leaf_51_clk_load
+ net463 _03165_ VSS VSS VDD VDD network.in_period\[170\]\[2\]
+ sky130_fd_sc_hd__edfxtp_1
Xnetwork.in_period\[170\]\[3\]$_DFFE_PP_ clknet_leaf_51_clk_load
+ net461 _03165_ VSS VSS VDD VDD network.in_period\[170\]\[3\]
+ sky130_fd_sc_hd__edfxtp_1
Xnetwork.in_period\[171\]\[0\]$_DFFE_PP_ clknet_leaf_68_clk_load
+ net475 _03166_ VSS VSS VDD VDD network.in_period\[171\]\[0\]
+ sky130_fd_sc_hd__edfxtp_1
Xnetwork.in_period\[171\]\[1\]$_DFFE_PP_ clknet_leaf_68_clk_load
+ net469 _03166_ VSS VSS VDD VDD network.in_period\[171\]\[1\]
+ sky130_fd_sc_hd__edfxtp_1
Xnetwork.in_period\[171\]\[2\]$_DFFE_PP_ clknet_leaf_68_clk_load
+ net463 _03166_ VSS VSS VDD VDD network.in_period\[171\]\[2\]
+ sky130_fd_sc_hd__edfxtp_1
Xnetwork.in_period\[171\]\[3\]$_DFFE_PP_ clknet_leaf_68_clk_load
+ net461 _03166_ VSS VSS VDD VDD network.in_period\[171\]\[3\]
+ sky130_fd_sc_hd__edfxtp_1
Xnetwork.in_period\[172\]\[0\]$_DFFE_PP_ clknet_leaf_67_clk_load
+ net475 _03167_ VSS VSS VDD VDD network.in_period\[172\]\[0\]
+ sky130_fd_sc_hd__edfxtp_1
Xnetwork.in_period\[172\]\[1\]$_DFFE_PP_ clknet_leaf_67_clk_load
+ net469 _03167_ VSS VSS VDD VDD network.in_period\[172\]\[1\]
+ sky130_fd_sc_hd__edfxtp_1
Xnetwork.in_period\[172\]\[2\]$_DFFE_PP_ clknet_leaf_67_clk_load
+ net463 _03167_ VSS VSS VDD VDD network.in_period\[172\]\[2\]
+ sky130_fd_sc_hd__edfxtp_1
Xnetwork.in_period\[172\]\[3\]$_DFFE_PP_ clknet_leaf_67_clk_load
+ net461 _03167_ VSS VSS VDD VDD network.in_period\[172\]\[3\]
+ sky130_fd_sc_hd__edfxtp_1
Xnetwork.in_period\[173\]\[0\]$_DFFE_PP_ clknet_leaf_68_clk_load
+ net475 _03168_ VSS VSS VDD VDD network.in_period\[173\]\[0\]
+ sky130_fd_sc_hd__edfxtp_1
Xnetwork.in_period\[173\]\[1\]$_DFFE_PP_ clknet_leaf_68_clk_load
+ net469 _03168_ VSS VSS VDD VDD network.in_period\[173\]\[1\]
+ sky130_fd_sc_hd__edfxtp_1
Xnetwork.in_period\[173\]\[2\]$_DFFE_PP_ clknet_leaf_68_clk_load
+ net463 _03168_ VSS VSS VDD VDD network.in_period\[173\]\[2\]
+ sky130_fd_sc_hd__edfxtp_1
Xnetwork.in_period\[173\]\[3\]$_DFFE_PP_ clknet_leaf_68_clk_load
+ net461 _03168_ VSS VSS VDD VDD network.in_period\[173\]\[3\]
+ sky130_fd_sc_hd__edfxtp_1
Xnetwork.in_period\[174\]\[0\]$_DFFE_PP_ clknet_leaf_67_clk_load
+ net475 _03169_ VSS VSS VDD VDD network.in_period\[174\]\[0\]
+ sky130_fd_sc_hd__edfxtp_1
Xnetwork.in_period\[174\]\[1\]$_DFFE_PP_ clknet_leaf_67_clk_load
+ net469 _03169_ VSS VSS VDD VDD network.in_period\[174\]\[1\]
+ sky130_fd_sc_hd__edfxtp_1
Xnetwork.in_period\[174\]\[2\]$_DFFE_PP_ clknet_leaf_67_clk_load
+ net463 _03169_ VSS VSS VDD VDD network.in_period\[174\]\[2\]
+ sky130_fd_sc_hd__edfxtp_1
Xnetwork.in_period\[174\]\[3\]$_DFFE_PP_ clknet_leaf_67_clk_load
+ net461 _03169_ VSS VSS VDD VDD network.in_period\[174\]\[3\]
+ sky130_fd_sc_hd__edfxtp_1
Xnetwork.in_period\[175\]\[0\]$_DFFE_PP_ clknet_leaf_68_clk_load
+ net475 _03170_ VSS VSS VDD VDD network.in_period\[175\]\[0\]
+ sky130_fd_sc_hd__edfxtp_1
Xnetwork.in_period\[175\]\[1\]$_DFFE_PP_ clknet_leaf_69_clk_load
+ net469 _03170_ VSS VSS VDD VDD network.in_period\[175\]\[1\]
+ sky130_fd_sc_hd__edfxtp_1
Xnetwork.in_period\[175\]\[2\]$_DFFE_PP_ clknet_leaf_67_clk_load
+ net463 _03170_ VSS VSS VDD VDD network.in_period\[175\]\[2\]
+ sky130_fd_sc_hd__edfxtp_1
Xnetwork.in_period\[175\]\[3\]$_DFFE_PP_ clknet_leaf_67_clk_load
+ net461 _03170_ VSS VSS VDD VDD network.in_period\[175\]\[3\]
+ sky130_fd_sc_hd__edfxtp_1
Xnetwork.in_period\[176\]\[0\]$_DFFE_PP_ clknet_leaf_61_clk_load
+ net475 _03171_ VSS VSS VDD VDD network.in_period\[176\]\[0\]
+ sky130_fd_sc_hd__edfxtp_1
Xnetwork.in_period\[176\]\[1\]$_DFFE_PP_ clknet_leaf_61_clk_load
+ net474 _03171_ VSS VSS VDD VDD network.in_period\[176\]\[1\]
+ sky130_fd_sc_hd__edfxtp_1
Xnetwork.in_period\[176\]\[2\]$_DFFE_PP_ clknet_leaf_61_clk_load
+ net468 _03171_ VSS VSS VDD VDD network.in_period\[176\]\[2\]
+ sky130_fd_sc_hd__edfxtp_1
Xnetwork.in_period\[176\]\[3\]$_DFFE_PP_ clknet_leaf_61_clk_load
+ net462 _03171_ VSS VSS VDD VDD network.in_period\[176\]\[3\]
+ sky130_fd_sc_hd__edfxtp_1
Xnetwork.in_period\[177\]\[0\]$_DFFE_PP_ clknet_leaf_56_clk_load
+ net475 _03172_ VSS VSS VDD VDD network.in_period\[177\]\[0\]
+ sky130_fd_sc_hd__edfxtp_1
Xnetwork.in_period\[177\]\[1\]$_DFFE_PP_ clknet_leaf_56_clk_load
+ net474 _03172_ VSS VSS VDD VDD network.in_period\[177\]\[1\]
+ sky130_fd_sc_hd__edfxtp_1
Xnetwork.in_period\[177\]\[2\]$_DFFE_PP_ clknet_leaf_56_clk_load
+ net468 _03172_ VSS VSS VDD VDD network.in_period\[177\]\[2\]
+ sky130_fd_sc_hd__edfxtp_1
Xnetwork.in_period\[177\]\[3\]$_DFFE_PP_ clknet_leaf_56_clk_load
+ net462 _03172_ VSS VSS VDD VDD network.in_period\[177\]\[3\]
+ sky130_fd_sc_hd__edfxtp_1
Xnetwork.in_period\[178\]\[0\]$_DFFE_PP_ clknet_leaf_62_clk_load
+ net475 _03173_ VSS VSS VDD VDD network.in_period\[178\]\[0\]
+ sky130_fd_sc_hd__edfxtp_1
Xnetwork.in_period\[178\]\[1\]$_DFFE_PP_ clknet_leaf_62_clk_load
+ net474 _03173_ VSS VSS VDD VDD network.in_period\[178\]\[1\]
+ sky130_fd_sc_hd__edfxtp_1
Xnetwork.in_period\[178\]\[2\]$_DFFE_PP_ clknet_leaf_62_clk_load
+ net468 _03173_ VSS VSS VDD VDD network.in_period\[178\]\[2\]
+ sky130_fd_sc_hd__edfxtp_1
Xnetwork.in_period\[178\]\[3\]$_DFFE_PP_ clknet_leaf_62_clk_load
+ net462 _03173_ VSS VSS VDD VDD network.in_period\[178\]\[3\]
+ sky130_fd_sc_hd__edfxtp_1
Xnetwork.in_period\[179\]\[0\]$_DFFE_PP_ clknet_leaf_58_clk_load
+ net475 _03174_ VSS VSS VDD VDD network.in_period\[179\]\[0\]
+ sky130_fd_sc_hd__edfxtp_1
Xnetwork.in_period\[179\]\[1\]$_DFFE_PP_ clknet_leaf_57_clk_load
+ net474 _03174_ VSS VSS VDD VDD network.in_period\[179\]\[1\]
+ sky130_fd_sc_hd__edfxtp_1
Xnetwork.in_period\[179\]\[2\]$_DFFE_PP_ clknet_leaf_57_clk_load
+ net468 _03174_ VSS VSS VDD VDD network.in_period\[179\]\[2\]
+ sky130_fd_sc_hd__edfxtp_1
Xnetwork.in_period\[179\]\[3\]$_DFFE_PP_ clknet_leaf_57_clk_load
+ net462 _03174_ VSS VSS VDD VDD network.in_period\[179\]\[3\]
+ sky130_fd_sc_hd__edfxtp_1
Xnetwork.in_period\[17\]\[0\]$_DFFE_PP_ clknet_leaf_118_clk_load
+ net477 _03175_ VSS VSS VDD VDD network.in_period\[17\]\[0\]
+ sky130_fd_sc_hd__edfxtp_1
Xnetwork.in_period\[17\]\[1\]$_DFFE_PP_ clknet_leaf_118_clk_load
+ net470 _03175_ VSS VSS VDD VDD network.in_period\[17\]\[1\]
+ sky130_fd_sc_hd__edfxtp_1
Xnetwork.in_period\[17\]\[2\]$_DFFE_PP_ clknet_leaf_118_clk_load
+ net464 _03175_ VSS VSS VDD VDD network.in_period\[17\]\[2\]
+ sky130_fd_sc_hd__edfxtp_1
Xnetwork.in_period\[17\]\[3\]$_DFFE_PP_ clknet_leaf_118_clk_load
+ net456 _03175_ VSS VSS VDD VDD network.in_period\[17\]\[3\]
+ sky130_fd_sc_hd__edfxtp_1
Xnetwork.in_period\[180\]\[0\]$_DFFE_PP_ clknet_leaf_55_clk_load
+ net475 _03176_ VSS VSS VDD VDD network.in_period\[180\]\[0\]
+ sky130_fd_sc_hd__edfxtp_1
Xnetwork.in_period\[180\]\[1\]$_DFFE_PP_ clknet_leaf_55_clk_load
+ net474 _03176_ VSS VSS VDD VDD network.in_period\[180\]\[1\]
+ sky130_fd_sc_hd__edfxtp_1
Xnetwork.in_period\[180\]\[2\]$_DFFE_PP_ clknet_leaf_55_clk_load
+ net468 _03176_ VSS VSS VDD VDD network.in_period\[180\]\[2\]
+ sky130_fd_sc_hd__edfxtp_1
Xnetwork.in_period\[180\]\[3\]$_DFFE_PP_ clknet_leaf_55_clk_load
+ net462 _03176_ VSS VSS VDD VDD network.in_period\[180\]\[3\]
+ sky130_fd_sc_hd__edfxtp_1
Xnetwork.in_period\[181\]\[0\]$_DFFE_PP_ clknet_leaf_56_clk_load
+ net475 _03177_ VSS VSS VDD VDD network.in_period\[181\]\[0\]
+ sky130_fd_sc_hd__edfxtp_1
Xnetwork.in_period\[181\]\[1\]$_DFFE_PP_ clknet_leaf_56_clk_load
+ net474 _03177_ VSS VSS VDD VDD network.in_period\[181\]\[1\]
+ sky130_fd_sc_hd__edfxtp_1
Xnetwork.in_period\[181\]\[2\]$_DFFE_PP_ clknet_leaf_56_clk_load
+ net468 _03177_ VSS VSS VDD VDD network.in_period\[181\]\[2\]
+ sky130_fd_sc_hd__edfxtp_1
Xnetwork.in_period\[181\]\[3\]$_DFFE_PP_ clknet_leaf_56_clk_load
+ net462 _03177_ VSS VSS VDD VDD network.in_period\[181\]\[3\]
+ sky130_fd_sc_hd__edfxtp_1
Xnetwork.in_period\[182\]\[0\]$_DFFE_PP_ clknet_leaf_62_clk_load
+ net475 _03178_ VSS VSS VDD VDD network.in_period\[182\]\[0\]
+ sky130_fd_sc_hd__edfxtp_1
Xnetwork.in_period\[182\]\[1\]$_DFFE_PP_ clknet_leaf_62_clk_load
+ net474 _03178_ VSS VSS VDD VDD network.in_period\[182\]\[1\]
+ sky130_fd_sc_hd__edfxtp_1
Xnetwork.in_period\[182\]\[2\]$_DFFE_PP_ clknet_leaf_62_clk_load
+ net468 _03178_ VSS VSS VDD VDD network.in_period\[182\]\[2\]
+ sky130_fd_sc_hd__edfxtp_1
Xnetwork.in_period\[182\]\[3\]$_DFFE_PP_ clknet_leaf_62_clk_load
+ net462 _03178_ VSS VSS VDD VDD network.in_period\[182\]\[3\]
+ sky130_fd_sc_hd__edfxtp_1
Xnetwork.in_period\[183\]\[0\]$_DFFE_PP_ clknet_leaf_57_clk_load
+ net475 _03179_ VSS VSS VDD VDD network.in_period\[183\]\[0\]
+ sky130_fd_sc_hd__edfxtp_1
Xnetwork.in_period\[183\]\[1\]$_DFFE_PP_ clknet_leaf_57_clk_load
+ net474 _03179_ VSS VSS VDD VDD network.in_period\[183\]\[1\]
+ sky130_fd_sc_hd__edfxtp_1
Xnetwork.in_period\[183\]\[2\]$_DFFE_PP_ clknet_leaf_56_clk_load
+ net468 _03179_ VSS VSS VDD VDD network.in_period\[183\]\[2\]
+ sky130_fd_sc_hd__edfxtp_1
Xnetwork.in_period\[183\]\[3\]$_DFFE_PP_ clknet_leaf_56_clk_load
+ net462 _03179_ VSS VSS VDD VDD network.in_period\[183\]\[3\]
+ sky130_fd_sc_hd__edfxtp_1
Xnetwork.in_period\[184\]\[0\]$_DFFE_PP_ clknet_leaf_58_clk_load
+ net475 _03180_ VSS VSS VDD VDD network.in_period\[184\]\[0\]
+ sky130_fd_sc_hd__edfxtp_1
Xnetwork.in_period\[184\]\[1\]$_DFFE_PP_ clknet_leaf_58_clk_load
+ net474 _03180_ VSS VSS VDD VDD network.in_period\[184\]\[1\]
+ sky130_fd_sc_hd__edfxtp_1
Xnetwork.in_period\[184\]\[2\]$_DFFE_PP_ clknet_leaf_58_clk_load
+ net468 _03180_ VSS VSS VDD VDD network.in_period\[184\]\[2\]
+ sky130_fd_sc_hd__edfxtp_1
Xnetwork.in_period\[184\]\[3\]$_DFFE_PP_ clknet_leaf_58_clk_load
+ net462 _03180_ VSS VSS VDD VDD network.in_period\[184\]\[3\]
+ sky130_fd_sc_hd__edfxtp_1
Xnetwork.in_period\[185\]\[0\]$_DFFE_PP_ clknet_leaf_57_clk_load
+ net475 _03181_ VSS VSS VDD VDD network.in_period\[185\]\[0\]
+ sky130_fd_sc_hd__edfxtp_1
Xnetwork.in_period\[185\]\[1\]$_DFFE_PP_ clknet_leaf_57_clk_load
+ net474 _03181_ VSS VSS VDD VDD network.in_period\[185\]\[1\]
+ sky130_fd_sc_hd__edfxtp_1
Xnetwork.in_period\[185\]\[2\]$_DFFE_PP_ clknet_leaf_57_clk_load
+ net468 _03181_ VSS VSS VDD VDD network.in_period\[185\]\[2\]
+ sky130_fd_sc_hd__edfxtp_1
Xnetwork.in_period\[185\]\[3\]$_DFFE_PP_ clknet_leaf_57_clk_load
+ net462 _03181_ VSS VSS VDD VDD network.in_period\[185\]\[3\]
+ sky130_fd_sc_hd__edfxtp_1
Xnetwork.in_period\[186\]\[0\]$_DFFE_PP_ clknet_leaf_61_clk_load
+ net475 _03182_ VSS VSS VDD VDD network.in_period\[186\]\[0\]
+ sky130_fd_sc_hd__edfxtp_1
Xnetwork.in_period\[186\]\[1\]$_DFFE_PP_ clknet_leaf_61_clk_load
+ net469 _03182_ VSS VSS VDD VDD network.in_period\[186\]\[1\]
+ sky130_fd_sc_hd__edfxtp_1
Xnetwork.in_period\[186\]\[2\]$_DFFE_PP_ clknet_leaf_61_clk_load
+ net468 _03182_ VSS VSS VDD VDD network.in_period\[186\]\[2\]
+ sky130_fd_sc_hd__edfxtp_1
Xnetwork.in_period\[186\]\[3\]$_DFFE_PP_ clknet_leaf_61_clk_load
+ net462 _03182_ VSS VSS VDD VDD network.in_period\[186\]\[3\]
+ sky130_fd_sc_hd__edfxtp_1
Xnetwork.in_period\[187\]\[0\]$_DFFE_PP_ clknet_leaf_58_clk_load
+ net475 _03183_ VSS VSS VDD VDD network.in_period\[187\]\[0\]
+ sky130_fd_sc_hd__edfxtp_1
Xnetwork.in_period\[187\]\[1\]$_DFFE_PP_ clknet_leaf_58_clk_load
+ net469 _03183_ VSS VSS VDD VDD network.in_period\[187\]\[1\]
+ sky130_fd_sc_hd__edfxtp_1
Xnetwork.in_period\[187\]\[2\]$_DFFE_PP_ clknet_leaf_58_clk_load
+ net468 _03183_ VSS VSS VDD VDD network.in_period\[187\]\[2\]
+ sky130_fd_sc_hd__edfxtp_1
Xnetwork.in_period\[187\]\[3\]$_DFFE_PP_ clknet_leaf_58_clk_load
+ net462 _03183_ VSS VSS VDD VDD network.in_period\[187\]\[3\]
+ sky130_fd_sc_hd__edfxtp_1
Xnetwork.in_period\[188\]\[0\]$_DFFE_PP_ clknet_leaf_59_clk_load
+ net475 _03184_ VSS VSS VDD VDD network.in_period\[188\]\[0\]
+ sky130_fd_sc_hd__edfxtp_1
Xnetwork.in_period\[188\]\[1\]$_DFFE_PP_ clknet_leaf_59_clk_load
+ net469 _03184_ VSS VSS VDD VDD network.in_period\[188\]\[1\]
+ sky130_fd_sc_hd__edfxtp_1
Xnetwork.in_period\[188\]\[2\]$_DFFE_PP_ clknet_leaf_59_clk_load
+ net463 _03184_ VSS VSS VDD VDD network.in_period\[188\]\[2\]
+ sky130_fd_sc_hd__edfxtp_1
Xnetwork.in_period\[188\]\[3\]$_DFFE_PP_ clknet_leaf_59_clk_load
+ net462 _03184_ VSS VSS VDD VDD network.in_period\[188\]\[3\]
+ sky130_fd_sc_hd__edfxtp_1
Xnetwork.in_period\[189\]\[0\]$_DFFE_PP_ clknet_leaf_63_clk_load
+ net475 _03185_ VSS VSS VDD VDD network.in_period\[189\]\[0\]
+ sky130_fd_sc_hd__edfxtp_1
Xnetwork.in_period\[189\]\[1\]$_DFFE_PP_ clknet_leaf_63_clk_load
+ net469 _03185_ VSS VSS VDD VDD network.in_period\[189\]\[1\]
+ sky130_fd_sc_hd__edfxtp_1
Xnetwork.in_period\[189\]\[2\]$_DFFE_PP_ clknet_leaf_60_clk_load
+ net463 _03185_ VSS VSS VDD VDD network.in_period\[189\]\[2\]
+ sky130_fd_sc_hd__edfxtp_1
Xnetwork.in_period\[189\]\[3\]$_DFFE_PP_ clknet_leaf_63_clk_load
+ net462 _03185_ VSS VSS VDD VDD network.in_period\[189\]\[3\]
+ sky130_fd_sc_hd__edfxtp_1
Xnetwork.in_period\[18\]\[0\]$_DFFE_PP_ clknet_leaf_109_clk_load
+ net480 _03186_ VSS VSS VDD VDD network.in_period\[18\]\[0\]
+ sky130_fd_sc_hd__edfxtp_1
Xnetwork.in_period\[18\]\[1\]$_DFFE_PP_ clknet_leaf_109_clk_load
+ net473 _03186_ VSS VSS VDD VDD network.in_period\[18\]\[1\]
+ sky130_fd_sc_hd__edfxtp_1
Xnetwork.in_period\[18\]\[2\]$_DFFE_PP_ clknet_leaf_109_clk_load
+ net467 _03186_ VSS VSS VDD VDD network.in_period\[18\]\[2\]
+ sky130_fd_sc_hd__edfxtp_1
Xnetwork.in_period\[18\]\[3\]$_DFFE_PP_ clknet_leaf_109_clk_load
+ net459 _03186_ VSS VSS VDD VDD network.in_period\[18\]\[3\]
+ sky130_fd_sc_hd__edfxtp_1
Xnetwork.in_period\[190\]\[0\]$_DFFE_PP_ clknet_leaf_60_clk_load
+ net475 _03187_ VSS VSS VDD VDD network.in_period\[190\]\[0\]
+ sky130_fd_sc_hd__edfxtp_1
Xnetwork.in_period\[190\]\[1\]$_DFFE_PP_ clknet_leaf_60_clk_load
+ net469 _03187_ VSS VSS VDD VDD network.in_period\[190\]\[1\]
+ sky130_fd_sc_hd__edfxtp_1
Xnetwork.in_period\[190\]\[2\]$_DFFE_PP_ clknet_leaf_60_clk_load
+ net463 _03187_ VSS VSS VDD VDD network.in_period\[190\]\[2\]
+ sky130_fd_sc_hd__edfxtp_1
Xnetwork.in_period\[190\]\[3\]$_DFFE_PP_ clknet_leaf_60_clk_load
+ net462 _03187_ VSS VSS VDD VDD network.in_period\[190\]\[3\]
+ sky130_fd_sc_hd__edfxtp_1
Xnetwork.in_period\[191\]\[0\]$_DFFE_PP_ clknet_leaf_60_clk_load
+ net475 _03188_ VSS VSS VDD VDD network.in_period\[191\]\[0\]
+ sky130_fd_sc_hd__edfxtp_1
Xnetwork.in_period\[191\]\[1\]$_DFFE_PP_ clknet_leaf_60_clk_load
+ net469 _03188_ VSS VSS VDD VDD network.in_period\[191\]\[1\]
+ sky130_fd_sc_hd__edfxtp_1
Xnetwork.in_period\[191\]\[2\]$_DFFE_PP_ clknet_leaf_60_clk_load
+ net463 _03188_ VSS VSS VDD VDD network.in_period\[191\]\[2\]
+ sky130_fd_sc_hd__edfxtp_1
Xnetwork.in_period\[191\]\[3\]$_DFFE_PP_ clknet_leaf_60_clk_load
+ net462 _03188_ VSS VSS VDD VDD network.in_period\[191\]\[3\]
+ sky130_fd_sc_hd__edfxtp_1
Xnetwork.in_period\[192\]\[0\]$_DFFE_PP_ clknet_leaf_83_clk_load
+ net479 _03189_ VSS VSS VDD VDD network.in_period\[192\]\[0\]
+ sky130_fd_sc_hd__edfxtp_1
Xnetwork.in_period\[192\]\[1\]$_DFFE_PP_ clknet_leaf_83_clk_load
+ net471 _03189_ VSS VSS VDD VDD network.in_period\[192\]\[1\]
+ sky130_fd_sc_hd__edfxtp_1
Xnetwork.in_period\[192\]\[2\]$_DFFE_PP_ clknet_leaf_83_clk_load
+ net466 _03189_ VSS VSS VDD VDD network.in_period\[192\]\[2\]
+ sky130_fd_sc_hd__edfxtp_1
Xnetwork.in_period\[192\]\[3\]$_DFFE_PP_ clknet_leaf_83_clk_load
+ net458 _03189_ VSS VSS VDD VDD network.in_period\[192\]\[3\]
+ sky130_fd_sc_hd__edfxtp_1
Xnetwork.in_period\[193\]\[0\]$_DFFE_PP_ clknet_leaf_84_clk_load
+ net479 _03190_ VSS VSS VDD VDD network.in_period\[193\]\[0\]
+ sky130_fd_sc_hd__edfxtp_1
Xnetwork.in_period\[193\]\[1\]$_DFFE_PP_ clknet_leaf_84_clk_load
+ net471 _03190_ VSS VSS VDD VDD network.in_period\[193\]\[1\]
+ sky130_fd_sc_hd__edfxtp_1
Xnetwork.in_period\[193\]\[2\]$_DFFE_PP_ clknet_leaf_84_clk_load
+ net466 _03190_ VSS VSS VDD VDD network.in_period\[193\]\[2\]
+ sky130_fd_sc_hd__edfxtp_1
Xnetwork.in_period\[193\]\[3\]$_DFFE_PP_ clknet_leaf_84_clk_load
+ net458 _03190_ VSS VSS VDD VDD network.in_period\[193\]\[3\]
+ sky130_fd_sc_hd__edfxtp_1
Xnetwork.in_period\[194\]\[0\]$_DFFE_PP_ clknet_leaf_81_clk_load
+ net479 _03191_ VSS VSS VDD VDD network.in_period\[194\]\[0\]
+ sky130_fd_sc_hd__edfxtp_1
Xnetwork.in_period\[194\]\[1\]$_DFFE_PP_ clknet_leaf_81_clk_load
+ net471 _03191_ VSS VSS VDD VDD network.in_period\[194\]\[1\]
+ sky130_fd_sc_hd__edfxtp_1
Xnetwork.in_period\[194\]\[2\]$_DFFE_PP_ clknet_leaf_80_clk_load
+ net466 _03191_ VSS VSS VDD VDD network.in_period\[194\]\[2\]
+ sky130_fd_sc_hd__edfxtp_1
Xnetwork.in_period\[194\]\[3\]$_DFFE_PP_ clknet_leaf_81_clk_load
+ net458 _03191_ VSS VSS VDD VDD network.in_period\[194\]\[3\]
+ sky130_fd_sc_hd__edfxtp_1
Xnetwork.in_period\[195\]\[0\]$_DFFE_PP_ clknet_leaf_81_clk_load
+ net479 _03192_ VSS VSS VDD VDD network.in_period\[195\]\[0\]
+ sky130_fd_sc_hd__edfxtp_1
Xnetwork.in_period\[195\]\[1\]$_DFFE_PP_ clknet_leaf_81_clk_load
+ net471 _03192_ VSS VSS VDD VDD network.in_period\[195\]\[1\]
+ sky130_fd_sc_hd__edfxtp_1
Xnetwork.in_period\[195\]\[2\]$_DFFE_PP_ clknet_leaf_82_clk_load
+ net466 _03192_ VSS VSS VDD VDD network.in_period\[195\]\[2\]
+ sky130_fd_sc_hd__edfxtp_1
Xnetwork.in_period\[195\]\[3\]$_DFFE_PP_ clknet_leaf_82_clk_load
+ net458 _03192_ VSS VSS VDD VDD network.in_period\[195\]\[3\]
+ sky130_fd_sc_hd__edfxtp_1
Xnetwork.in_period\[196\]\[0\]$_DFFE_PP_ clknet_leaf_80_clk_load
+ net479 _03193_ VSS VSS VDD VDD network.in_period\[196\]\[0\]
+ sky130_fd_sc_hd__edfxtp_1
Xnetwork.in_period\[196\]\[1\]$_DFFE_PP_ clknet_leaf_81_clk_load
+ net471 _03193_ VSS VSS VDD VDD network.in_period\[196\]\[1\]
+ sky130_fd_sc_hd__edfxtp_1
Xnetwork.in_period\[196\]\[2\]$_DFFE_PP_ clknet_leaf_80_clk_load
+ net466 _03193_ VSS VSS VDD VDD network.in_period\[196\]\[2\]
+ sky130_fd_sc_hd__edfxtp_1
Xnetwork.in_period\[196\]\[3\]$_DFFE_PP_ clknet_leaf_80_clk_load
+ net458 _03193_ VSS VSS VDD VDD network.in_period\[196\]\[3\]
+ sky130_fd_sc_hd__edfxtp_1
Xnetwork.in_period\[197\]\[0\]$_DFFE_PP_ clknet_leaf_81_clk_load
+ net479 _03194_ VSS VSS VDD VDD network.in_period\[197\]\[0\]
+ sky130_fd_sc_hd__edfxtp_1
Xnetwork.in_period\[197\]\[1\]$_DFFE_PP_ clknet_leaf_81_clk_load
+ net471 _03194_ VSS VSS VDD VDD network.in_period\[197\]\[1\]
+ sky130_fd_sc_hd__edfxtp_1
Xnetwork.in_period\[197\]\[2\]$_DFFE_PP_ clknet_leaf_81_clk_load
+ net466 _03194_ VSS VSS VDD VDD network.in_period\[197\]\[2\]
+ sky130_fd_sc_hd__edfxtp_1
Xnetwork.in_period\[197\]\[3\]$_DFFE_PP_ clknet_leaf_81_clk_load
+ net458 _03194_ VSS VSS VDD VDD network.in_period\[197\]\[3\]
+ sky130_fd_sc_hd__edfxtp_1
Xnetwork.in_period\[198\]\[0\]$_DFFE_PP_ clknet_leaf_82_clk_load
+ net479 _03195_ VSS VSS VDD VDD network.in_period\[198\]\[0\]
+ sky130_fd_sc_hd__edfxtp_1
Xnetwork.in_period\[198\]\[1\]$_DFFE_PP_ clknet_leaf_82_clk_load
+ net471 _03195_ VSS VSS VDD VDD network.in_period\[198\]\[1\]
+ sky130_fd_sc_hd__edfxtp_1
Xnetwork.in_period\[198\]\[2\]$_DFFE_PP_ clknet_leaf_82_clk_load
+ net466 _03195_ VSS VSS VDD VDD network.in_period\[198\]\[2\]
+ sky130_fd_sc_hd__edfxtp_1
Xnetwork.in_period\[198\]\[3\]$_DFFE_PP_ clknet_leaf_82_clk_load
+ net458 _03195_ VSS VSS VDD VDD network.in_period\[198\]\[3\]
+ sky130_fd_sc_hd__edfxtp_1
Xnetwork.in_period\[199\]\[0\]$_DFFE_PP_ clknet_leaf_83_clk_load
+ net479 _03196_ VSS VSS VDD VDD network.in_period\[199\]\[0\]
+ sky130_fd_sc_hd__edfxtp_1
Xnetwork.in_period\[199\]\[1\]$_DFFE_PP_ clknet_leaf_82_clk_load
+ net471 _03196_ VSS VSS VDD VDD network.in_period\[199\]\[1\]
+ sky130_fd_sc_hd__edfxtp_1
Xnetwork.in_period\[199\]\[2\]$_DFFE_PP_ clknet_leaf_82_clk_load
+ net466 _03196_ VSS VSS VDD VDD network.in_period\[199\]\[2\]
+ sky130_fd_sc_hd__edfxtp_1
Xnetwork.in_period\[199\]\[3\]$_DFFE_PP_ clknet_leaf_83_clk_load
+ net458 _03196_ VSS VSS VDD VDD network.in_period\[199\]\[3\]
+ sky130_fd_sc_hd__edfxtp_1
Xnetwork.in_period\[19\]\[0\]$_DFFE_PP_ clknet_leaf_108_clk_load
+ net480 _03197_ VSS VSS VDD VDD network.in_period\[19\]\[0\]
+ sky130_fd_sc_hd__edfxtp_1
Xnetwork.in_period\[19\]\[1\]$_DFFE_PP_ clknet_leaf_108_clk_load
+ net473 _03197_ VSS VSS VDD VDD network.in_period\[19\]\[1\]
+ sky130_fd_sc_hd__edfxtp_1
Xnetwork.in_period\[19\]\[2\]$_DFFE_PP_ clknet_leaf_108_clk_load
+ net466 _03197_ VSS VSS VDD VDD network.in_period\[19\]\[2\]
+ sky130_fd_sc_hd__edfxtp_1
Xnetwork.in_period\[19\]\[3\]$_DFFE_PP_ clknet_leaf_108_clk_load
+ net458 _03197_ VSS VSS VDD VDD network.in_period\[19\]\[3\]
+ sky130_fd_sc_hd__edfxtp_1
Xnetwork.in_period\[1\]\[0\]$_DFFE_PP_ clknet_leaf_117_clk_load
+ net477 _03198_ VSS VSS VDD VDD network.in_period\[1\]\[0\]
+ sky130_fd_sc_hd__edfxtp_1
Xnetwork.in_period\[1\]\[1\]$_DFFE_PP_ clknet_leaf_117_clk_load
+ net470 _03198_ VSS VSS VDD VDD network.in_period\[1\]\[1\]
+ sky130_fd_sc_hd__edfxtp_1
Xnetwork.in_period\[1\]\[2\]$_DFFE_PP_ clknet_leaf_116_clk_load
+ net464 _03198_ VSS VSS VDD VDD network.in_period\[1\]\[2\]
+ sky130_fd_sc_hd__edfxtp_1
Xnetwork.in_period\[1\]\[3\]$_DFFE_PP_ clknet_leaf_116_clk_load
+ net456 _03198_ VSS VSS VDD VDD network.in_period\[1\]\[3\]
+ sky130_fd_sc_hd__edfxtp_1
Xnetwork.in_period\[200\]\[0\]$_DFFE_PP_ clknet_leaf_85_clk_load
+ net479 _03199_ VSS VSS VDD VDD network.in_period\[200\]\[0\]
+ sky130_fd_sc_hd__edfxtp_1
Xnetwork.in_period\[200\]\[1\]$_DFFE_PP_ clknet_leaf_85_clk_load
+ net471 _03199_ VSS VSS VDD VDD network.in_period\[200\]\[1\]
+ sky130_fd_sc_hd__edfxtp_1
Xnetwork.in_period\[200\]\[2\]$_DFFE_PP_ clknet_leaf_85_clk_load
+ net466 _03199_ VSS VSS VDD VDD network.in_period\[200\]\[2\]
+ sky130_fd_sc_hd__edfxtp_1
Xnetwork.in_period\[200\]\[3\]$_DFFE_PP_ clknet_leaf_85_clk_load
+ net458 _03199_ VSS VSS VDD VDD network.in_period\[200\]\[3\]
+ sky130_fd_sc_hd__edfxtp_1
Xnetwork.in_period\[201\]\[0\]$_DFFE_PP_ clknet_leaf_84_clk_load
+ net479 _03200_ VSS VSS VDD VDD network.in_period\[201\]\[0\]
+ sky130_fd_sc_hd__edfxtp_1
Xnetwork.in_period\[201\]\[1\]$_DFFE_PP_ clknet_leaf_84_clk_load
+ net471 _03200_ VSS VSS VDD VDD network.in_period\[201\]\[1\]
+ sky130_fd_sc_hd__edfxtp_1
Xnetwork.in_period\[201\]\[2\]$_DFFE_PP_ clknet_leaf_84_clk_load
+ net466 _03200_ VSS VSS VDD VDD network.in_period\[201\]\[2\]
+ sky130_fd_sc_hd__edfxtp_1
Xnetwork.in_period\[201\]\[3\]$_DFFE_PP_ clknet_leaf_84_clk_load
+ net458 _03200_ VSS VSS VDD VDD network.in_period\[201\]\[3\]
+ sky130_fd_sc_hd__edfxtp_1
Xnetwork.in_period\[202\]\[0\]$_DFFE_PP_ clknet_leaf_86_clk_load
+ net479 _03201_ VSS VSS VDD VDD network.in_period\[202\]\[0\]
+ sky130_fd_sc_hd__edfxtp_1
Xnetwork.in_period\[202\]\[1\]$_DFFE_PP_ clknet_leaf_86_clk_load
+ net471 _03201_ VSS VSS VDD VDD network.in_period\[202\]\[1\]
+ sky130_fd_sc_hd__edfxtp_1
Xnetwork.in_period\[202\]\[2\]$_DFFE_PP_ clknet_leaf_86_clk_load
+ net466 _03201_ VSS VSS VDD VDD network.in_period\[202\]\[2\]
+ sky130_fd_sc_hd__edfxtp_1
Xnetwork.in_period\[202\]\[3\]$_DFFE_PP_ clknet_leaf_86_clk_load
+ net458 _03201_ VSS VSS VDD VDD network.in_period\[202\]\[3\]
+ sky130_fd_sc_hd__edfxtp_1
Xnetwork.in_period\[203\]\[0\]$_DFFE_PP_ clknet_leaf_86_clk_load
+ net479 _03202_ VSS VSS VDD VDD network.in_period\[203\]\[0\]
+ sky130_fd_sc_hd__edfxtp_1
Xnetwork.in_period\[203\]\[1\]$_DFFE_PP_ clknet_leaf_86_clk_load
+ net471 _03202_ VSS VSS VDD VDD network.in_period\[203\]\[1\]
+ sky130_fd_sc_hd__edfxtp_1
Xnetwork.in_period\[203\]\[2\]$_DFFE_PP_ clknet_leaf_86_clk_load
+ net466 _03202_ VSS VSS VDD VDD network.in_period\[203\]\[2\]
+ sky130_fd_sc_hd__edfxtp_1
Xnetwork.in_period\[203\]\[3\]$_DFFE_PP_ clknet_leaf_86_clk_load
+ net458 _03202_ VSS VSS VDD VDD network.in_period\[203\]\[3\]
+ sky130_fd_sc_hd__edfxtp_1
Xnetwork.in_period\[204\]\[0\]$_DFFE_PP_ clknet_leaf_88_clk_load
+ net479 _03203_ VSS VSS VDD VDD network.in_period\[204\]\[0\]
+ sky130_fd_sc_hd__edfxtp_1
Xnetwork.in_period\[204\]\[1\]$_DFFE_PP_ clknet_leaf_88_clk_load
+ net471 _03203_ VSS VSS VDD VDD network.in_period\[204\]\[1\]
+ sky130_fd_sc_hd__edfxtp_1
Xnetwork.in_period\[204\]\[2\]$_DFFE_PP_ clknet_leaf_88_clk_load
+ net466 _03203_ VSS VSS VDD VDD network.in_period\[204\]\[2\]
+ sky130_fd_sc_hd__edfxtp_1
Xnetwork.in_period\[204\]\[3\]$_DFFE_PP_ clknet_leaf_88_clk_load
+ net458 _03203_ VSS VSS VDD VDD network.in_period\[204\]\[3\]
+ sky130_fd_sc_hd__edfxtp_1
Xnetwork.in_period\[205\]\[0\]$_DFFE_PP_ clknet_leaf_87_clk_load
+ net479 _03204_ VSS VSS VDD VDD network.in_period\[205\]\[0\]
+ sky130_fd_sc_hd__edfxtp_1
Xnetwork.in_period\[205\]\[1\]$_DFFE_PP_ clknet_leaf_87_clk_load
+ net471 _03204_ VSS VSS VDD VDD network.in_period\[205\]\[1\]
+ sky130_fd_sc_hd__edfxtp_1
Xnetwork.in_period\[205\]\[2\]$_DFFE_PP_ clknet_leaf_87_clk_load
+ net466 _03204_ VSS VSS VDD VDD network.in_period\[205\]\[2\]
+ sky130_fd_sc_hd__edfxtp_1
Xnetwork.in_period\[205\]\[3\]$_DFFE_PP_ clknet_leaf_87_clk_load
+ net458 _03204_ VSS VSS VDD VDD network.in_period\[205\]\[3\]
+ sky130_fd_sc_hd__edfxtp_1
Xnetwork.in_period\[206\]\[0\]$_DFFE_PP_ clknet_leaf_88_clk_load
+ net479 _03205_ VSS VSS VDD VDD network.in_period\[206\]\[0\]
+ sky130_fd_sc_hd__edfxtp_1
Xnetwork.in_period\[206\]\[1\]$_DFFE_PP_ clknet_leaf_88_clk_load
+ net471 _03205_ VSS VSS VDD VDD network.in_period\[206\]\[1\]
+ sky130_fd_sc_hd__edfxtp_1
Xnetwork.in_period\[206\]\[2\]$_DFFE_PP_ clknet_leaf_88_clk_load
+ net466 _03205_ VSS VSS VDD VDD network.in_period\[206\]\[2\]
+ sky130_fd_sc_hd__edfxtp_1
Xnetwork.in_period\[206\]\[3\]$_DFFE_PP_ clknet_leaf_88_clk_load
+ net458 _03205_ VSS VSS VDD VDD network.in_period\[206\]\[3\]
+ sky130_fd_sc_hd__edfxtp_1
Xnetwork.in_period\[207\]\[0\]$_DFFE_PP_ clknet_leaf_87_clk_load
+ net479 _03206_ VSS VSS VDD VDD network.in_period\[207\]\[0\]
+ sky130_fd_sc_hd__edfxtp_1
Xnetwork.in_period\[207\]\[1\]$_DFFE_PP_ clknet_leaf_87_clk_load
+ net471 _03206_ VSS VSS VDD VDD network.in_period\[207\]\[1\]
+ sky130_fd_sc_hd__edfxtp_1
Xnetwork.in_period\[207\]\[2\]$_DFFE_PP_ clknet_leaf_86_clk_load
+ net466 _03206_ VSS VSS VDD VDD network.in_period\[207\]\[2\]
+ sky130_fd_sc_hd__edfxtp_1
Xnetwork.in_period\[207\]\[3\]$_DFFE_PP_ clknet_leaf_86_clk_load
+ net458 _03206_ VSS VSS VDD VDD network.in_period\[207\]\[3\]
+ sky130_fd_sc_hd__edfxtp_1
Xnetwork.in_period\[208\]\[0\]$_DFFE_PP_ clknet_leaf_92_clk_load
+ net478 _03207_ VSS VSS VDD VDD network.in_period\[208\]\[0\]
+ sky130_fd_sc_hd__edfxtp_1
Xnetwork.in_period\[208\]\[1\]$_DFFE_PP_ clknet_leaf_91_clk_load
+ net472 _03207_ VSS VSS VDD VDD network.in_period\[208\]\[1\]
+ sky130_fd_sc_hd__edfxtp_1
Xnetwork.in_period\[208\]\[2\]$_DFFE_PP_ clknet_leaf_91_clk_load
+ net465 _03207_ VSS VSS VDD VDD network.in_period\[208\]\[2\]
+ sky130_fd_sc_hd__edfxtp_1
Xnetwork.in_period\[208\]\[3\]$_DFFE_PP_ clknet_leaf_91_clk_load
+ net457 _03207_ VSS VSS VDD VDD network.in_period\[208\]\[3\]
+ sky130_fd_sc_hd__edfxtp_1
Xnetwork.in_period\[209\]\[0\]$_DFFE_PP_ clknet_leaf_94_clk_load
+ net478 _03208_ VSS VSS VDD VDD network.in_period\[209\]\[0\]
+ sky130_fd_sc_hd__edfxtp_1
Xnetwork.in_period\[209\]\[1\]$_DFFE_PP_ clknet_leaf_94_clk_load
+ net472 _03208_ VSS VSS VDD VDD network.in_period\[209\]\[1\]
+ sky130_fd_sc_hd__edfxtp_1
Xnetwork.in_period\[209\]\[2\]$_DFFE_PP_ clknet_leaf_94_clk_load
+ net465 _03208_ VSS VSS VDD VDD network.in_period\[209\]\[2\]
+ sky130_fd_sc_hd__edfxtp_1
Xnetwork.in_period\[209\]\[3\]$_DFFE_PP_ clknet_leaf_94_clk_load
+ net457 _03208_ VSS VSS VDD VDD network.in_period\[209\]\[3\]
+ sky130_fd_sc_hd__edfxtp_1
Xnetwork.in_period\[20\]\[0\]$_DFFE_PP_ clknet_leaf_2_clk_load
+ net477 _03209_ VSS VSS VDD VDD network.in_period\[20\]\[0\]
+ sky130_fd_sc_hd__edfxtp_1
Xnetwork.in_period\[20\]\[1\]$_DFFE_PP_ clknet_leaf_2_clk_load
+ net470 _03209_ VSS VSS VDD VDD network.in_period\[20\]\[1\]
+ sky130_fd_sc_hd__edfxtp_1
Xnetwork.in_period\[20\]\[2\]$_DFFE_PP_ clknet_leaf_2_clk_load
+ net464 _03209_ VSS VSS VDD VDD network.in_period\[20\]\[2\]
+ sky130_fd_sc_hd__edfxtp_1
Xnetwork.in_period\[20\]\[3\]$_DFFE_PP_ clknet_leaf_2_clk_load
+ net456 _03209_ VSS VSS VDD VDD network.in_period\[20\]\[3\]
+ sky130_fd_sc_hd__edfxtp_1
Xnetwork.in_period\[210\]\[0\]$_DFFE_PP_ clknet_leaf_85_clk_load
+ net479 _03210_ VSS VSS VDD VDD network.in_period\[210\]\[0\]
+ sky130_fd_sc_hd__edfxtp_1
Xnetwork.in_period\[210\]\[1\]$_DFFE_PP_ clknet_leaf_85_clk_load
+ net471 _03210_ VSS VSS VDD VDD network.in_period\[210\]\[1\]
+ sky130_fd_sc_hd__edfxtp_1
Xnetwork.in_period\[210\]\[2\]$_DFFE_PP_ clknet_leaf_85_clk_load
+ net466 _03210_ VSS VSS VDD VDD network.in_period\[210\]\[2\]
+ sky130_fd_sc_hd__edfxtp_1
Xnetwork.in_period\[210\]\[3\]$_DFFE_PP_ clknet_leaf_85_clk_load
+ net458 _03210_ VSS VSS VDD VDD network.in_period\[210\]\[3\]
+ sky130_fd_sc_hd__edfxtp_1
Xnetwork.in_period\[211\]\[0\]$_DFFE_PP_ clknet_leaf_93_clk_load
+ net478 _03211_ VSS VSS VDD VDD network.in_period\[211\]\[0\]
+ sky130_fd_sc_hd__edfxtp_1
Xnetwork.in_period\[211\]\[1\]$_DFFE_PP_ clknet_leaf_93_clk_load
+ net472 _03211_ VSS VSS VDD VDD network.in_period\[211\]\[1\]
+ sky130_fd_sc_hd__edfxtp_1
Xnetwork.in_period\[211\]\[2\]$_DFFE_PP_ clknet_leaf_93_clk_load
+ net465 _03211_ VSS VSS VDD VDD network.in_period\[211\]\[2\]
+ sky130_fd_sc_hd__edfxtp_1
Xnetwork.in_period\[211\]\[3\]$_DFFE_PP_ clknet_leaf_93_clk_load
+ net457 _03211_ VSS VSS VDD VDD network.in_period\[211\]\[3\]
+ sky130_fd_sc_hd__edfxtp_1
Xnetwork.in_period\[212\]\[0\]$_DFFE_PP_ clknet_leaf_90_clk_load
+ net478 _03212_ VSS VSS VDD VDD network.in_period\[212\]\[0\]
+ sky130_fd_sc_hd__edfxtp_1
Xnetwork.in_period\[212\]\[1\]$_DFFE_PP_ clknet_leaf_90_clk_load
+ net472 _03212_ VSS VSS VDD VDD network.in_period\[212\]\[1\]
+ sky130_fd_sc_hd__edfxtp_1
Xnetwork.in_period\[212\]\[2\]$_DFFE_PP_ clknet_leaf_90_clk_load
+ net465 _03212_ VSS VSS VDD VDD network.in_period\[212\]\[2\]
+ sky130_fd_sc_hd__edfxtp_1
Xnetwork.in_period\[212\]\[3\]$_DFFE_PP_ clknet_leaf_90_clk_load
+ net457 _03212_ VSS VSS VDD VDD network.in_period\[212\]\[3\]
+ sky130_fd_sc_hd__edfxtp_1
Xnetwork.in_period\[213\]\[0\]$_DFFE_PP_ clknet_leaf_87_clk_load
+ net479 _03213_ VSS VSS VDD VDD network.in_period\[213\]\[0\]
+ sky130_fd_sc_hd__edfxtp_1
Xnetwork.in_period\[213\]\[1\]$_DFFE_PP_ clknet_leaf_87_clk_load
+ net471 _03213_ VSS VSS VDD VDD network.in_period\[213\]\[1\]
+ sky130_fd_sc_hd__edfxtp_1
Xnetwork.in_period\[213\]\[2\]$_DFFE_PP_ clknet_leaf_89_clk_load
+ net466 _03213_ VSS VSS VDD VDD network.in_period\[213\]\[2\]
+ sky130_fd_sc_hd__edfxtp_1
Xnetwork.in_period\[213\]\[3\]$_DFFE_PP_ clknet_leaf_89_clk_load
+ net458 _03213_ VSS VSS VDD VDD network.in_period\[213\]\[3\]
+ sky130_fd_sc_hd__edfxtp_1
Xnetwork.in_period\[214\]\[0\]$_DFFE_PP_ clknet_leaf_90_clk_load
+ net478 _03214_ VSS VSS VDD VDD network.in_period\[214\]\[0\]
+ sky130_fd_sc_hd__edfxtp_1
Xnetwork.in_period\[214\]\[1\]$_DFFE_PP_ clknet_leaf_90_clk_load
+ net472 _03214_ VSS VSS VDD VDD network.in_period\[214\]\[1\]
+ sky130_fd_sc_hd__edfxtp_1
Xnetwork.in_period\[214\]\[2\]$_DFFE_PP_ clknet_leaf_92_clk_load
+ net466 _03214_ VSS VSS VDD VDD network.in_period\[214\]\[2\]
+ sky130_fd_sc_hd__edfxtp_1
Xnetwork.in_period\[214\]\[3\]$_DFFE_PP_ clknet_leaf_90_clk_load
+ net458 _03214_ VSS VSS VDD VDD network.in_period\[214\]\[3\]
+ sky130_fd_sc_hd__edfxtp_1
Xnetwork.in_period\[215\]\[0\]$_DFFE_PP_ clknet_leaf_92_clk_load
+ net478 _03215_ VSS VSS VDD VDD network.in_period\[215\]\[0\]
+ sky130_fd_sc_hd__edfxtp_1
Xnetwork.in_period\[215\]\[1\]$_DFFE_PP_ clknet_leaf_92_clk_load
+ net472 _03215_ VSS VSS VDD VDD network.in_period\[215\]\[1\]
+ sky130_fd_sc_hd__edfxtp_1
Xnetwork.in_period\[215\]\[2\]$_DFFE_PP_ clknet_leaf_92_clk_load
+ net465 _03215_ VSS VSS VDD VDD network.in_period\[215\]\[2\]
+ sky130_fd_sc_hd__edfxtp_1
Xnetwork.in_period\[215\]\[3\]$_DFFE_PP_ clknet_leaf_92_clk_load
+ net457 _03215_ VSS VSS VDD VDD network.in_period\[215\]\[3\]
+ sky130_fd_sc_hd__edfxtp_1
Xnetwork.in_period\[216\]\[0\]$_DFFE_PP_ clknet_leaf_101_clk_load
+ net478 _03216_ VSS VSS VDD VDD network.in_period\[216\]\[0\]
+ sky130_fd_sc_hd__edfxtp_1
Xnetwork.in_period\[216\]\[1\]$_DFFE_PP_ clknet_leaf_101_clk_load
+ net472 _03216_ VSS VSS VDD VDD network.in_period\[216\]\[1\]
+ sky130_fd_sc_hd__edfxtp_1
Xnetwork.in_period\[216\]\[2\]$_DFFE_PP_ clknet_leaf_92_clk_load
+ net465 _03216_ VSS VSS VDD VDD network.in_period\[216\]\[2\]
+ sky130_fd_sc_hd__edfxtp_1
Xnetwork.in_period\[216\]\[3\]$_DFFE_PP_ clknet_leaf_92_clk_load
+ net457 _03216_ VSS VSS VDD VDD network.in_period\[216\]\[3\]
+ sky130_fd_sc_hd__edfxtp_1
Xnetwork.in_period\[217\]\[0\]$_DFFE_PP_ clknet_leaf_93_clk_load
+ net478 _03217_ VSS VSS VDD VDD network.in_period\[217\]\[0\]
+ sky130_fd_sc_hd__edfxtp_1
Xnetwork.in_period\[217\]\[1\]$_DFFE_PP_ clknet_leaf_93_clk_load
+ net472 _03217_ VSS VSS VDD VDD network.in_period\[217\]\[1\]
+ sky130_fd_sc_hd__edfxtp_1
Xnetwork.in_period\[217\]\[2\]$_DFFE_PP_ clknet_leaf_93_clk_load
+ net465 _03217_ VSS VSS VDD VDD network.in_period\[217\]\[2\]
+ sky130_fd_sc_hd__edfxtp_1
Xnetwork.in_period\[217\]\[3\]$_DFFE_PP_ clknet_leaf_93_clk_load
+ net457 _03217_ VSS VSS VDD VDD network.in_period\[217\]\[3\]
+ sky130_fd_sc_hd__edfxtp_1
Xnetwork.in_period\[218\]\[0\]$_DFFE_PP_ clknet_leaf_94_clk_load
+ net478 _03218_ VSS VSS VDD VDD network.in_period\[218\]\[0\]
+ sky130_fd_sc_hd__edfxtp_1
Xnetwork.in_period\[218\]\[1\]$_DFFE_PP_ clknet_leaf_94_clk_load
+ net472 _03218_ VSS VSS VDD VDD network.in_period\[218\]\[1\]
+ sky130_fd_sc_hd__edfxtp_1
Xnetwork.in_period\[218\]\[2\]$_DFFE_PP_ clknet_leaf_94_clk_load
+ net465 _03218_ VSS VSS VDD VDD network.in_period\[218\]\[2\]
+ sky130_fd_sc_hd__edfxtp_1
Xnetwork.in_period\[218\]\[3\]$_DFFE_PP_ clknet_leaf_94_clk_load
+ net457 _03218_ VSS VSS VDD VDD network.in_period\[218\]\[3\]
+ sky130_fd_sc_hd__edfxtp_1
Xnetwork.in_period\[219\]\[0\]$_DFFE_PP_ clknet_leaf_95_clk_load
+ net478 _03219_ VSS VSS VDD VDD network.in_period\[219\]\[0\]
+ sky130_fd_sc_hd__edfxtp_1
Xnetwork.in_period\[219\]\[1\]$_DFFE_PP_ clknet_leaf_94_clk_load
+ net472 _03219_ VSS VSS VDD VDD network.in_period\[219\]\[1\]
+ sky130_fd_sc_hd__edfxtp_1
Xnetwork.in_period\[219\]\[2\]$_DFFE_PP_ clknet_leaf_94_clk_load
+ net465 _03219_ VSS VSS VDD VDD network.in_period\[219\]\[2\]
+ sky130_fd_sc_hd__edfxtp_1
Xnetwork.in_period\[219\]\[3\]$_DFFE_PP_ clknet_leaf_93_clk_load
+ net457 _03219_ VSS VSS VDD VDD network.in_period\[219\]\[3\]
+ sky130_fd_sc_hd__edfxtp_1
Xnetwork.in_period\[21\]\[0\]$_DFFE_PP_ clknet_leaf_3_clk_load
+ net477 _03220_ VSS VSS VDD VDD network.in_period\[21\]\[0\]
+ sky130_fd_sc_hd__edfxtp_1
Xnetwork.in_period\[21\]\[1\]$_DFFE_PP_ clknet_leaf_3_clk_load
+ net470 _03220_ VSS VSS VDD VDD network.in_period\[21\]\[1\]
+ sky130_fd_sc_hd__edfxtp_1
Xnetwork.in_period\[21\]\[2\]$_DFFE_PP_ clknet_leaf_3_clk_load
+ net464 _03220_ VSS VSS VDD VDD network.in_period\[21\]\[2\]
+ sky130_fd_sc_hd__edfxtp_1
Xnetwork.in_period\[21\]\[3\]$_DFFE_PP_ clknet_leaf_3_clk_load
+ net456 _03220_ VSS VSS VDD VDD network.in_period\[21\]\[3\]
+ sky130_fd_sc_hd__edfxtp_1
Xnetwork.in_period\[220\]\[0\]$_DFFE_PP_ clknet_leaf_89_clk_load
+ net478 _03221_ VSS VSS VDD VDD network.in_period\[220\]\[0\]
+ sky130_fd_sc_hd__edfxtp_1
Xnetwork.in_period\[220\]\[1\]$_DFFE_PP_ clknet_leaf_89_clk_load
+ net472 _03221_ VSS VSS VDD VDD network.in_period\[220\]\[1\]
+ sky130_fd_sc_hd__edfxtp_1
Xnetwork.in_period\[220\]\[2\]$_DFFE_PP_ clknet_leaf_89_clk_load
+ net465 _03221_ VSS VSS VDD VDD network.in_period\[220\]\[2\]
+ sky130_fd_sc_hd__edfxtp_1
Xnetwork.in_period\[220\]\[3\]$_DFFE_PP_ clknet_leaf_89_clk_load
+ net457 _03221_ VSS VSS VDD VDD network.in_period\[220\]\[3\]
+ sky130_fd_sc_hd__edfxtp_1
Xnetwork.in_period\[221\]\[0\]$_DFFE_PP_ clknet_leaf_91_clk_load
+ net478 _03222_ VSS VSS VDD VDD network.in_period\[221\]\[0\]
+ sky130_fd_sc_hd__edfxtp_1
Xnetwork.in_period\[221\]\[1\]$_DFFE_PP_ clknet_leaf_91_clk_load
+ net472 _03222_ VSS VSS VDD VDD network.in_period\[221\]\[1\]
+ sky130_fd_sc_hd__edfxtp_1
Xnetwork.in_period\[221\]\[2\]$_DFFE_PP_ clknet_leaf_91_clk_load
+ net465 _03222_ VSS VSS VDD VDD network.in_period\[221\]\[2\]
+ sky130_fd_sc_hd__edfxtp_1
Xnetwork.in_period\[221\]\[3\]$_DFFE_PP_ clknet_leaf_91_clk_load
+ net457 _03222_ VSS VSS VDD VDD network.in_period\[221\]\[3\]
+ sky130_fd_sc_hd__edfxtp_1
Xnetwork.in_period\[222\]\[0\]$_DFFE_PP_ clknet_leaf_91_clk_load
+ net478 _03223_ VSS VSS VDD VDD network.in_period\[222\]\[0\]
+ sky130_fd_sc_hd__edfxtp_1
Xnetwork.in_period\[222\]\[1\]$_DFFE_PP_ clknet_leaf_91_clk_load
+ net472 _03223_ VSS VSS VDD VDD network.in_period\[222\]\[1\]
+ sky130_fd_sc_hd__edfxtp_1
Xnetwork.in_period\[222\]\[2\]$_DFFE_PP_ clknet_leaf_91_clk_load
+ net465 _03223_ VSS VSS VDD VDD network.in_period\[222\]\[2\]
+ sky130_fd_sc_hd__edfxtp_1
Xnetwork.in_period\[222\]\[3\]$_DFFE_PP_ clknet_leaf_91_clk_load
+ net457 _03223_ VSS VSS VDD VDD network.in_period\[222\]\[3\]
+ sky130_fd_sc_hd__edfxtp_1
Xnetwork.in_period\[223\]\[0\]$_DFFE_PP_ clknet_leaf_88_clk_load
+ net479 _03224_ VSS VSS VDD VDD network.in_period\[223\]\[0\]
+ sky130_fd_sc_hd__edfxtp_1
Xnetwork.in_period\[223\]\[1\]$_DFFE_PP_ clknet_leaf_88_clk_load
+ net471 _03224_ VSS VSS VDD VDD network.in_period\[223\]\[1\]
+ sky130_fd_sc_hd__edfxtp_1
Xnetwork.in_period\[223\]\[2\]$_DFFE_PP_ clknet_leaf_89_clk_load
+ net466 _03224_ VSS VSS VDD VDD network.in_period\[223\]\[2\]
+ sky130_fd_sc_hd__edfxtp_1
Xnetwork.in_period\[223\]\[3\]$_DFFE_PP_ clknet_leaf_89_clk_load
+ net458 _03224_ VSS VSS VDD VDD network.in_period\[223\]\[3\]
+ sky130_fd_sc_hd__edfxtp_1
Xnetwork.in_period\[224\]\[0\]$_DFFE_PP_ clknet_leaf_70_clk_load
+ net476 _03225_ VSS VSS VDD VDD network.in_period\[224\]\[0\]
+ sky130_fd_sc_hd__edfxtp_1
Xnetwork.in_period\[224\]\[1\]$_DFFE_PP_ clknet_leaf_70_clk_load
+ net469 _03225_ VSS VSS VDD VDD network.in_period\[224\]\[1\]
+ sky130_fd_sc_hd__edfxtp_1
Xnetwork.in_period\[224\]\[2\]$_DFFE_PP_ clknet_leaf_70_clk_load
+ net467 _03225_ VSS VSS VDD VDD network.in_period\[224\]\[2\]
+ sky130_fd_sc_hd__edfxtp_1
Xnetwork.in_period\[224\]\[3\]$_DFFE_PP_ clknet_leaf_70_clk_load
+ net460 _03225_ VSS VSS VDD VDD network.in_period\[224\]\[3\]
+ sky130_fd_sc_hd__edfxtp_1
Xnetwork.in_period\[225\]\[0\]$_DFFE_PP_ clknet_leaf_73_clk_load
+ net476 _03226_ VSS VSS VDD VDD network.in_period\[225\]\[0\]
+ sky130_fd_sc_hd__edfxtp_1
Xnetwork.in_period\[225\]\[1\]$_DFFE_PP_ clknet_leaf_73_clk_load
+ net469 _03226_ VSS VSS VDD VDD network.in_period\[225\]\[1\]
+ sky130_fd_sc_hd__edfxtp_1
Xnetwork.in_period\[225\]\[2\]$_DFFE_PP_ clknet_leaf_70_clk_load
+ net467 _03226_ VSS VSS VDD VDD network.in_period\[225\]\[2\]
+ sky130_fd_sc_hd__edfxtp_1
Xnetwork.in_period\[225\]\[3\]$_DFFE_PP_ clknet_leaf_71_clk_load
+ net460 _03226_ VSS VSS VDD VDD network.in_period\[225\]\[3\]
+ sky130_fd_sc_hd__edfxtp_1
Xnetwork.in_period\[226\]\[0\]$_DFFE_PP_ clknet_leaf_71_clk_load
+ net476 _03227_ VSS VSS VDD VDD network.in_period\[226\]\[0\]
+ sky130_fd_sc_hd__edfxtp_1
Xnetwork.in_period\[226\]\[1\]$_DFFE_PP_ clknet_leaf_71_clk_load
+ net469 _03227_ VSS VSS VDD VDD network.in_period\[226\]\[1\]
+ sky130_fd_sc_hd__edfxtp_1
Xnetwork.in_period\[226\]\[2\]$_DFFE_PP_ clknet_leaf_71_clk_load
+ net467 _03227_ VSS VSS VDD VDD network.in_period\[226\]\[2\]
+ sky130_fd_sc_hd__edfxtp_1
Xnetwork.in_period\[226\]\[3\]$_DFFE_PP_ clknet_leaf_71_clk_load
+ net460 _03227_ VSS VSS VDD VDD network.in_period\[226\]\[3\]
+ sky130_fd_sc_hd__edfxtp_1
Xnetwork.in_period\[227\]\[0\]$_DFFE_PP_ clknet_leaf_69_clk_load
+ net476 _03228_ VSS VSS VDD VDD network.in_period\[227\]\[0\]
+ sky130_fd_sc_hd__edfxtp_1
Xnetwork.in_period\[227\]\[1\]$_DFFE_PP_ clknet_leaf_69_clk_load
+ net469 _03228_ VSS VSS VDD VDD network.in_period\[227\]\[1\]
+ sky130_fd_sc_hd__edfxtp_1
Xnetwork.in_period\[227\]\[2\]$_DFFE_PP_ clknet_leaf_69_clk_load
+ net467 _03228_ VSS VSS VDD VDD network.in_period\[227\]\[2\]
+ sky130_fd_sc_hd__edfxtp_1
Xnetwork.in_period\[227\]\[3\]$_DFFE_PP_ clknet_leaf_69_clk_load
+ net460 _03228_ VSS VSS VDD VDD network.in_period\[227\]\[3\]
+ sky130_fd_sc_hd__edfxtp_1
Xnetwork.in_period\[228\]\[0\]$_DFFE_PP_ clknet_leaf_49_clk_load
+ net476 _03229_ VSS VSS VDD VDD network.in_period\[228\]\[0\]
+ sky130_fd_sc_hd__edfxtp_1
Xnetwork.in_period\[228\]\[1\]$_DFFE_PP_ clknet_leaf_49_clk_load
+ net469 _03229_ VSS VSS VDD VDD network.in_period\[228\]\[1\]
+ sky130_fd_sc_hd__edfxtp_1
Xnetwork.in_period\[228\]\[2\]$_DFFE_PP_ clknet_leaf_49_clk_load
+ net467 _03229_ VSS VSS VDD VDD network.in_period\[228\]\[2\]
+ sky130_fd_sc_hd__edfxtp_1
Xnetwork.in_period\[228\]\[3\]$_DFFE_PP_ clknet_leaf_49_clk_load
+ net460 _03229_ VSS VSS VDD VDD network.in_period\[228\]\[3\]
+ sky130_fd_sc_hd__edfxtp_1
Xnetwork.in_period\[229\]\[0\]$_DFFE_PP_ clknet_leaf_49_clk_load
+ net476 _03230_ VSS VSS VDD VDD network.in_period\[229\]\[0\]
+ sky130_fd_sc_hd__edfxtp_1
Xnetwork.in_period\[229\]\[1\]$_DFFE_PP_ clknet_leaf_49_clk_load
+ net469 _03230_ VSS VSS VDD VDD network.in_period\[229\]\[1\]
+ sky130_fd_sc_hd__edfxtp_1
Xnetwork.in_period\[229\]\[2\]$_DFFE_PP_ clknet_leaf_46_clk_load
+ net467 _03230_ VSS VSS VDD VDD network.in_period\[229\]\[2\]
+ sky130_fd_sc_hd__edfxtp_1
Xnetwork.in_period\[229\]\[3\]$_DFFE_PP_ clknet_leaf_46_clk_load
+ net460 _03230_ VSS VSS VDD VDD network.in_period\[229\]\[3\]
+ sky130_fd_sc_hd__edfxtp_1
Xnetwork.in_period\[22\]\[0\]$_DFFE_PP_ clknet_leaf_3_clk_load
+ net477 _03231_ VSS VSS VDD VDD network.in_period\[22\]\[0\]
+ sky130_fd_sc_hd__edfxtp_1
Xnetwork.in_period\[22\]\[1\]$_DFFE_PP_ clknet_leaf_3_clk_load
+ net470 _03231_ VSS VSS VDD VDD network.in_period\[22\]\[1\]
+ sky130_fd_sc_hd__edfxtp_1
Xnetwork.in_period\[22\]\[2\]$_DFFE_PP_ clknet_leaf_118_clk_load
+ net464 _03231_ VSS VSS VDD VDD network.in_period\[22\]\[2\]
+ sky130_fd_sc_hd__edfxtp_1
Xnetwork.in_period\[22\]\[3\]$_DFFE_PP_ clknet_leaf_118_clk_load
+ net456 _03231_ VSS VSS VDD VDD network.in_period\[22\]\[3\]
+ sky130_fd_sc_hd__edfxtp_1
Xnetwork.in_period\[230\]\[0\]$_DFFE_PP_ clknet_leaf_47_clk_load
+ net476 _03232_ VSS VSS VDD VDD network.in_period\[230\]\[0\]
+ sky130_fd_sc_hd__edfxtp_1
Xnetwork.in_period\[230\]\[1\]$_DFFE_PP_ clknet_leaf_47_clk_load
+ net469 _03232_ VSS VSS VDD VDD network.in_period\[230\]\[1\]
+ sky130_fd_sc_hd__edfxtp_1
Xnetwork.in_period\[230\]\[2\]$_DFFE_PP_ clknet_leaf_48_clk_load
+ net467 _03232_ VSS VSS VDD VDD network.in_period\[230\]\[2\]
+ sky130_fd_sc_hd__edfxtp_1
Xnetwork.in_period\[230\]\[3\]$_DFFE_PP_ clknet_leaf_48_clk_load
+ net460 _03232_ VSS VSS VDD VDD network.in_period\[230\]\[3\]
+ sky130_fd_sc_hd__edfxtp_1
Xnetwork.in_period\[231\]\[0\]$_DFFE_PP_ clknet_leaf_47_clk_load
+ net476 _03233_ VSS VSS VDD VDD network.in_period\[231\]\[0\]
+ sky130_fd_sc_hd__edfxtp_1
Xnetwork.in_period\[231\]\[1\]$_DFFE_PP_ clknet_leaf_47_clk_load
+ net473 _03233_ VSS VSS VDD VDD network.in_period\[231\]\[1\]
+ sky130_fd_sc_hd__edfxtp_1
Xnetwork.in_period\[231\]\[2\]$_DFFE_PP_ clknet_leaf_47_clk_load
+ net467 _03233_ VSS VSS VDD VDD network.in_period\[231\]\[2\]
+ sky130_fd_sc_hd__edfxtp_1
Xnetwork.in_period\[231\]\[3\]$_DFFE_PP_ clknet_leaf_47_clk_load
+ net460 _03233_ VSS VSS VDD VDD network.in_period\[231\]\[3\]
+ sky130_fd_sc_hd__edfxtp_1
Xnetwork.in_period\[232\]\[0\]$_DFFE_PP_ clknet_leaf_48_clk_load
+ net476 _03234_ VSS VSS VDD VDD network.in_period\[232\]\[0\]
+ sky130_fd_sc_hd__edfxtp_1
Xnetwork.in_period\[232\]\[1\]$_DFFE_PP_ clknet_leaf_48_clk_load
+ net469 _03234_ VSS VSS VDD VDD network.in_period\[232\]\[1\]
+ sky130_fd_sc_hd__edfxtp_1
Xnetwork.in_period\[232\]\[2\]$_DFFE_PP_ clknet_leaf_48_clk_load
+ net467 _03234_ VSS VSS VDD VDD network.in_period\[232\]\[2\]
+ sky130_fd_sc_hd__edfxtp_1
Xnetwork.in_period\[232\]\[3\]$_DFFE_PP_ clknet_leaf_48_clk_load
+ net460 _03234_ VSS VSS VDD VDD network.in_period\[232\]\[3\]
+ sky130_fd_sc_hd__edfxtp_1
Xnetwork.in_period\[233\]\[0\]$_DFFE_PP_ clknet_leaf_48_clk_load
+ net476 _03235_ VSS VSS VDD VDD network.in_period\[233\]\[0\]
+ sky130_fd_sc_hd__edfxtp_1
Xnetwork.in_period\[233\]\[1\]$_DFFE_PP_ clknet_leaf_48_clk_load
+ net469 _03235_ VSS VSS VDD VDD network.in_period\[233\]\[1\]
+ sky130_fd_sc_hd__edfxtp_1
Xnetwork.in_period\[233\]\[2\]$_DFFE_PP_ clknet_leaf_50_clk_load
+ net467 _03235_ VSS VSS VDD VDD network.in_period\[233\]\[2\]
+ sky130_fd_sc_hd__edfxtp_1
Xnetwork.in_period\[233\]\[3\]$_DFFE_PP_ clknet_leaf_48_clk_load
+ net460 _03235_ VSS VSS VDD VDD network.in_period\[233\]\[3\]
+ sky130_fd_sc_hd__edfxtp_1
Xnetwork.in_period\[234\]\[0\]$_DFFE_PP_ clknet_leaf_69_clk_load
+ net476 _03236_ VSS VSS VDD VDD network.in_period\[234\]\[0\]
+ sky130_fd_sc_hd__edfxtp_1
Xnetwork.in_period\[234\]\[1\]$_DFFE_PP_ clknet_leaf_69_clk_load
+ net469 _03236_ VSS VSS VDD VDD network.in_period\[234\]\[1\]
+ sky130_fd_sc_hd__edfxtp_1
Xnetwork.in_period\[234\]\[2\]$_DFFE_PP_ clknet_leaf_69_clk_load
+ net467 _03236_ VSS VSS VDD VDD network.in_period\[234\]\[2\]
+ sky130_fd_sc_hd__edfxtp_1
Xnetwork.in_period\[234\]\[3\]$_DFFE_PP_ clknet_leaf_69_clk_load
+ net460 _03236_ VSS VSS VDD VDD network.in_period\[234\]\[3\]
+ sky130_fd_sc_hd__edfxtp_1
Xnetwork.in_period\[235\]\[0\]$_DFFE_PP_ clknet_leaf_72_clk_load
+ net479 _03237_ VSS VSS VDD VDD network.in_period\[235\]\[0\]
+ sky130_fd_sc_hd__edfxtp_1
Xnetwork.in_period\[235\]\[1\]$_DFFE_PP_ clknet_leaf_72_clk_load
+ net471 _03237_ VSS VSS VDD VDD network.in_period\[235\]\[1\]
+ sky130_fd_sc_hd__edfxtp_1
Xnetwork.in_period\[235\]\[2\]$_DFFE_PP_ clknet_leaf_72_clk_load
+ net466 _03237_ VSS VSS VDD VDD network.in_period\[235\]\[2\]
+ sky130_fd_sc_hd__edfxtp_1
Xnetwork.in_period\[235\]\[3\]$_DFFE_PP_ clknet_leaf_72_clk_load
+ net458 _03237_ VSS VSS VDD VDD network.in_period\[235\]\[3\]
+ sky130_fd_sc_hd__edfxtp_1
Xnetwork.in_period\[236\]\[0\]$_DFFE_PP_ clknet_leaf_105_clk_load
+ net479 _03238_ VSS VSS VDD VDD network.in_period\[236\]\[0\]
+ sky130_fd_sc_hd__edfxtp_1
Xnetwork.in_period\[236\]\[1\]$_DFFE_PP_ clknet_leaf_105_clk_load
+ net471 _03238_ VSS VSS VDD VDD network.in_period\[236\]\[1\]
+ sky130_fd_sc_hd__edfxtp_1
Xnetwork.in_period\[236\]\[2\]$_DFFE_PP_ clknet_leaf_105_clk_load
+ net466 _03238_ VSS VSS VDD VDD network.in_period\[236\]\[2\]
+ sky130_fd_sc_hd__edfxtp_1
Xnetwork.in_period\[236\]\[3\]$_DFFE_PP_ clknet_leaf_105_clk_load
+ net458 _03238_ VSS VSS VDD VDD network.in_period\[236\]\[3\]
+ sky130_fd_sc_hd__edfxtp_1
Xnetwork.in_period\[237\]\[0\]$_DFFE_PP_ clknet_leaf_105_clk_load
+ net479 _03239_ VSS VSS VDD VDD network.in_period\[237\]\[0\]
+ sky130_fd_sc_hd__edfxtp_1
Xnetwork.in_period\[237\]\[1\]$_DFFE_PP_ clknet_leaf_105_clk_load
+ net471 _03239_ VSS VSS VDD VDD network.in_period\[237\]\[1\]
+ sky130_fd_sc_hd__edfxtp_1
Xnetwork.in_period\[237\]\[2\]$_DFFE_PP_ clknet_leaf_105_clk_load
+ net466 _03239_ VSS VSS VDD VDD network.in_period\[237\]\[2\]
+ sky130_fd_sc_hd__edfxtp_1
Xnetwork.in_period\[237\]\[3\]$_DFFE_PP_ clknet_leaf_105_clk_load
+ net458 _03239_ VSS VSS VDD VDD network.in_period\[237\]\[3\]
+ sky130_fd_sc_hd__edfxtp_1
Xnetwork.in_period\[238\]\[0\]$_DFFE_PP_ clknet_leaf_72_clk_load
+ net479 _03240_ VSS VSS VDD VDD network.in_period\[238\]\[0\]
+ sky130_fd_sc_hd__edfxtp_1
Xnetwork.in_period\[238\]\[1\]$_DFFE_PP_ clknet_leaf_104_clk_load
+ net471 _03240_ VSS VSS VDD VDD network.in_period\[238\]\[1\]
+ sky130_fd_sc_hd__edfxtp_1
Xnetwork.in_period\[238\]\[2\]$_DFFE_PP_ clknet_leaf_73_clk_load
+ net466 _03240_ VSS VSS VDD VDD network.in_period\[238\]\[2\]
+ sky130_fd_sc_hd__edfxtp_1
Xnetwork.in_period\[238\]\[3\]$_DFFE_PP_ clknet_leaf_73_clk_load
+ net458 _03240_ VSS VSS VDD VDD network.in_period\[238\]\[3\]
+ sky130_fd_sc_hd__edfxtp_1
Xnetwork.in_period\[239\]\[0\]$_DFFE_PP_ clknet_leaf_73_clk_load
+ net479 _03241_ VSS VSS VDD VDD network.in_period\[239\]\[0\]
+ sky130_fd_sc_hd__edfxtp_1
Xnetwork.in_period\[239\]\[1\]$_DFFE_PP_ clknet_leaf_73_clk_load
+ net471 _03241_ VSS VSS VDD VDD network.in_period\[239\]\[1\]
+ sky130_fd_sc_hd__edfxtp_1
Xnetwork.in_period\[239\]\[2\]$_DFFE_PP_ clknet_leaf_73_clk_load
+ net466 _03241_ VSS VSS VDD VDD network.in_period\[239\]\[2\]
+ sky130_fd_sc_hd__edfxtp_1
Xnetwork.in_period\[239\]\[3\]$_DFFE_PP_ clknet_leaf_73_clk_load
+ net458 _03241_ VSS VSS VDD VDD network.in_period\[239\]\[3\]
+ sky130_fd_sc_hd__edfxtp_1
Xnetwork.in_period\[23\]\[0\]$_DFFE_PP_ clknet_leaf_107_clk_load
+ net478 _03242_ VSS VSS VDD VDD network.in_period\[23\]\[0\]
+ sky130_fd_sc_hd__edfxtp_1
Xnetwork.in_period\[23\]\[1\]$_DFFE_PP_ clknet_leaf_107_clk_load
+ net472 _03242_ VSS VSS VDD VDD network.in_period\[23\]\[1\]
+ sky130_fd_sc_hd__edfxtp_1
Xnetwork.in_period\[23\]\[2\]$_DFFE_PP_ clknet_leaf_107_clk_load
+ net465 _03242_ VSS VSS VDD VDD network.in_period\[23\]\[2\]
+ sky130_fd_sc_hd__edfxtp_1
Xnetwork.in_period\[23\]\[3\]$_DFFE_PP_ clknet_leaf_107_clk_load
+ net457 _03242_ VSS VSS VDD VDD network.in_period\[23\]\[3\]
+ sky130_fd_sc_hd__edfxtp_1
Xnetwork.in_period\[240\]\[0\]$_DFFE_PP_ clknet_leaf_64_clk_load
+ net475 _03243_ VSS VSS VDD VDD network.in_period\[240\]\[0\]
+ sky130_fd_sc_hd__edfxtp_1
Xnetwork.in_period\[240\]\[1\]$_DFFE_PP_ clknet_leaf_64_clk_load
+ net469 _03243_ VSS VSS VDD VDD network.in_period\[240\]\[1\]
+ sky130_fd_sc_hd__edfxtp_1
Xnetwork.in_period\[240\]\[2\]$_DFFE_PP_ clknet_leaf_64_clk_load
+ net463 _03243_ VSS VSS VDD VDD network.in_period\[240\]\[2\]
+ sky130_fd_sc_hd__edfxtp_1
Xnetwork.in_period\[240\]\[3\]$_DFFE_PP_ clknet_leaf_64_clk_load
+ net461 _03243_ VSS VSS VDD VDD network.in_period\[240\]\[3\]
+ sky130_fd_sc_hd__edfxtp_1
Xnetwork.in_period\[241\]\[0\]$_DFFE_PP_ clknet_leaf_79_clk_load
+ net475 _03244_ VSS VSS VDD VDD network.in_period\[241\]\[0\]
+ sky130_fd_sc_hd__edfxtp_1
Xnetwork.in_period\[241\]\[1\]$_DFFE_PP_ clknet_leaf_79_clk_load
+ net469 _03244_ VSS VSS VDD VDD network.in_period\[241\]\[1\]
+ sky130_fd_sc_hd__edfxtp_1
Xnetwork.in_period\[241\]\[2\]$_DFFE_PP_ clknet_leaf_64_clk_load
+ net463 _03244_ VSS VSS VDD VDD network.in_period\[241\]\[2\]
+ sky130_fd_sc_hd__edfxtp_1
Xnetwork.in_period\[241\]\[3\]$_DFFE_PP_ clknet_leaf_79_clk_load
+ net461 _03244_ VSS VSS VDD VDD network.in_period\[241\]\[3\]
+ sky130_fd_sc_hd__edfxtp_1
Xnetwork.in_period\[242\]\[0\]$_DFFE_PP_ clknet_leaf_79_clk_load
+ net475 _03245_ VSS VSS VDD VDD network.in_period\[242\]\[0\]
+ sky130_fd_sc_hd__edfxtp_1
Xnetwork.in_period\[242\]\[1\]$_DFFE_PP_ clknet_leaf_79_clk_load
+ net469 _03245_ VSS VSS VDD VDD network.in_period\[242\]\[1\]
+ sky130_fd_sc_hd__edfxtp_1
Xnetwork.in_period\[242\]\[2\]$_DFFE_PP_ clknet_leaf_79_clk_load
+ net463 _03245_ VSS VSS VDD VDD network.in_period\[242\]\[2\]
+ sky130_fd_sc_hd__edfxtp_1
Xnetwork.in_period\[242\]\[3\]$_DFFE_PP_ clknet_leaf_79_clk_load
+ net461 _03245_ VSS VSS VDD VDD network.in_period\[242\]\[3\]
+ sky130_fd_sc_hd__edfxtp_1
Xnetwork.in_period\[243\]\[0\]$_DFFE_PP_ clknet_leaf_64_clk_load
+ net475 _03246_ VSS VSS VDD VDD network.in_period\[243\]\[0\]
+ sky130_fd_sc_hd__edfxtp_1
Xnetwork.in_period\[243\]\[1\]$_DFFE_PP_ clknet_leaf_64_clk_load
+ net469 _03246_ VSS VSS VDD VDD network.in_period\[243\]\[1\]
+ sky130_fd_sc_hd__edfxtp_1
Xnetwork.in_period\[243\]\[2\]$_DFFE_PP_ clknet_leaf_64_clk_load
+ net463 _03246_ VSS VSS VDD VDD network.in_period\[243\]\[2\]
+ sky130_fd_sc_hd__edfxtp_1
Xnetwork.in_period\[243\]\[3\]$_DFFE_PP_ clknet_leaf_64_clk_load
+ net461 _03246_ VSS VSS VDD VDD network.in_period\[243\]\[3\]
+ sky130_fd_sc_hd__edfxtp_1
Xnetwork.in_period\[244\]\[0\]$_DFFE_PP_ clknet_leaf_74_clk_load
+ net476 _03247_ VSS VSS VDD VDD network.in_period\[244\]\[0\]
+ sky130_fd_sc_hd__edfxtp_1
Xnetwork.in_period\[244\]\[1\]$_DFFE_PP_ clknet_leaf_74_clk_load
+ net469 _03247_ VSS VSS VDD VDD network.in_period\[244\]\[1\]
+ sky130_fd_sc_hd__edfxtp_1
Xnetwork.in_period\[244\]\[2\]$_DFFE_PP_ clknet_leaf_70_clk_load
+ net467 _03247_ VSS VSS VDD VDD network.in_period\[244\]\[2\]
+ sky130_fd_sc_hd__edfxtp_1
Xnetwork.in_period\[244\]\[3\]$_DFFE_PP_ clknet_leaf_70_clk_load
+ net460 _03247_ VSS VSS VDD VDD network.in_period\[244\]\[3\]
+ sky130_fd_sc_hd__edfxtp_1
Xnetwork.in_period\[245\]\[0\]$_DFFE_PP_ clknet_leaf_70_clk_load
+ net475 _03248_ VSS VSS VDD VDD network.in_period\[245\]\[0\]
+ sky130_fd_sc_hd__edfxtp_1
Xnetwork.in_period\[245\]\[1\]$_DFFE_PP_ clknet_leaf_66_clk_load
+ net469 _03248_ VSS VSS VDD VDD network.in_period\[245\]\[1\]
+ sky130_fd_sc_hd__edfxtp_1
Xnetwork.in_period\[245\]\[2\]$_DFFE_PP_ clknet_leaf_66_clk_load
+ net463 _03248_ VSS VSS VDD VDD network.in_period\[245\]\[2\]
+ sky130_fd_sc_hd__edfxtp_1
Xnetwork.in_period\[245\]\[3\]$_DFFE_PP_ clknet_leaf_70_clk_load
+ net460 _03248_ VSS VSS VDD VDD network.in_period\[245\]\[3\]
+ sky130_fd_sc_hd__edfxtp_1
Xnetwork.in_period\[246\]\[0\]$_DFFE_PP_ clknet_leaf_65_clk_load
+ net475 _03249_ VSS VSS VDD VDD network.in_period\[246\]\[0\]
+ sky130_fd_sc_hd__edfxtp_1
Xnetwork.in_period\[246\]\[1\]$_DFFE_PP_ clknet_leaf_65_clk_load
+ net469 _03249_ VSS VSS VDD VDD network.in_period\[246\]\[1\]
+ sky130_fd_sc_hd__edfxtp_1
Xnetwork.in_period\[246\]\[2\]$_DFFE_PP_ clknet_leaf_65_clk_load
+ net463 _03249_ VSS VSS VDD VDD network.in_period\[246\]\[2\]
+ sky130_fd_sc_hd__edfxtp_1
Xnetwork.in_period\[246\]\[3\]$_DFFE_PP_ clknet_leaf_65_clk_load
+ net461 _03249_ VSS VSS VDD VDD network.in_period\[246\]\[3\]
+ sky130_fd_sc_hd__edfxtp_1
Xnetwork.in_period\[247\]\[0\]$_DFFE_PP_ clknet_leaf_77_clk_load
+ net479 _03250_ VSS VSS VDD VDD network.in_period\[247\]\[0\]
+ sky130_fd_sc_hd__edfxtp_1
Xnetwork.in_period\[247\]\[1\]$_DFFE_PP_ clknet_leaf_77_clk_load
+ net471 _03250_ VSS VSS VDD VDD network.in_period\[247\]\[1\]
+ sky130_fd_sc_hd__edfxtp_1
Xnetwork.in_period\[247\]\[2\]$_DFFE_PP_ clknet_leaf_78_clk_load
+ net466 _03250_ VSS VSS VDD VDD network.in_period\[247\]\[2\]
+ sky130_fd_sc_hd__edfxtp_1
Xnetwork.in_period\[247\]\[3\]$_DFFE_PP_ clknet_leaf_78_clk_load
+ net458 _03250_ VSS VSS VDD VDD network.in_period\[247\]\[3\]
+ sky130_fd_sc_hd__edfxtp_1
Xnetwork.in_period\[248\]\[0\]$_DFFE_PP_ clknet_leaf_66_clk_load
+ net475 _03251_ VSS VSS VDD VDD network.in_period\[248\]\[0\]
+ sky130_fd_sc_hd__edfxtp_1
Xnetwork.in_period\[248\]\[1\]$_DFFE_PP_ clknet_leaf_66_clk_load
+ net469 _03251_ VSS VSS VDD VDD network.in_period\[248\]\[1\]
+ sky130_fd_sc_hd__edfxtp_1
Xnetwork.in_period\[248\]\[2\]$_DFFE_PP_ clknet_leaf_66_clk_load
+ net463 _03251_ VSS VSS VDD VDD network.in_period\[248\]\[2\]
+ sky130_fd_sc_hd__edfxtp_1
Xnetwork.in_period\[248\]\[3\]$_DFFE_PP_ clknet_leaf_66_clk_load
+ net461 _03251_ VSS VSS VDD VDD network.in_period\[248\]\[3\]
+ sky130_fd_sc_hd__edfxtp_1
Xnetwork.in_period\[249\]\[0\]$_DFFE_PP_ clknet_leaf_65_clk_load
+ net475 _03252_ VSS VSS VDD VDD network.in_period\[249\]\[0\]
+ sky130_fd_sc_hd__edfxtp_1
Xnetwork.in_period\[249\]\[1\]$_DFFE_PP_ clknet_leaf_65_clk_load
+ net469 _03252_ VSS VSS VDD VDD network.in_period\[249\]\[1\]
+ sky130_fd_sc_hd__edfxtp_1
Xnetwork.in_period\[249\]\[2\]$_DFFE_PP_ clknet_leaf_65_clk_load
+ net463 _03252_ VSS VSS VDD VDD network.in_period\[249\]\[2\]
+ sky130_fd_sc_hd__edfxtp_1
Xnetwork.in_period\[249\]\[3\]$_DFFE_PP_ clknet_leaf_65_clk_load
+ net461 _03252_ VSS VSS VDD VDD network.in_period\[249\]\[3\]
+ sky130_fd_sc_hd__edfxtp_1
Xnetwork.in_period\[24\]\[0\]$_DFFE_PP_ clknet_leaf_121_clk_load
+ net477 _03253_ VSS VSS VDD VDD network.in_period\[24\]\[0\]
+ sky130_fd_sc_hd__edfxtp_1
Xnetwork.in_period\[24\]\[1\]$_DFFE_PP_ clknet_leaf_122_clk_load
+ net470 _03253_ VSS VSS VDD VDD network.in_period\[24\]\[1\]
+ sky130_fd_sc_hd__edfxtp_1
Xnetwork.in_period\[24\]\[2\]$_DFFE_PP_ clknet_leaf_122_clk_load
+ net464 _03253_ VSS VSS VDD VDD network.in_period\[24\]\[2\]
+ sky130_fd_sc_hd__edfxtp_1
Xnetwork.in_period\[24\]\[3\]$_DFFE_PP_ clknet_leaf_121_clk_load
+ net456 _03253_ VSS VSS VDD VDD network.in_period\[24\]\[3\]
+ sky130_fd_sc_hd__edfxtp_1
Xnetwork.in_period\[250\]\[0\]$_DFFE_PP_ clknet_leaf_78_clk_load
+ net479 _03254_ VSS VSS VDD VDD network.in_period\[250\]\[0\]
+ sky130_fd_sc_hd__edfxtp_1
Xnetwork.in_period\[250\]\[1\]$_DFFE_PP_ clknet_leaf_77_clk_load
+ net471 _03254_ VSS VSS VDD VDD network.in_period\[250\]\[1\]
+ sky130_fd_sc_hd__edfxtp_1
Xnetwork.in_period\[250\]\[2\]$_DFFE_PP_ clknet_leaf_77_clk_load
+ net466 _03254_ VSS VSS VDD VDD network.in_period\[250\]\[2\]
+ sky130_fd_sc_hd__edfxtp_1
Xnetwork.in_period\[250\]\[3\]$_DFFE_PP_ clknet_leaf_77_clk_load
+ net458 _03254_ VSS VSS VDD VDD network.in_period\[250\]\[3\]
+ sky130_fd_sc_hd__edfxtp_1
Xnetwork.in_period\[251\]\[0\]$_DFFE_PP_ clknet_leaf_79_clk_load
+ net479 _03255_ VSS VSS VDD VDD network.in_period\[251\]\[0\]
+ sky130_fd_sc_hd__edfxtp_1
Xnetwork.in_period\[251\]\[1\]$_DFFE_PP_ clknet_leaf_79_clk_load
+ net471 _03255_ VSS VSS VDD VDD network.in_period\[251\]\[1\]
+ sky130_fd_sc_hd__edfxtp_1
Xnetwork.in_period\[251\]\[2\]$_DFFE_PP_ clknet_leaf_79_clk_load
+ net466 _03255_ VSS VSS VDD VDD network.in_period\[251\]\[2\]
+ sky130_fd_sc_hd__edfxtp_1
Xnetwork.in_period\[251\]\[3\]$_DFFE_PP_ clknet_leaf_79_clk_load
+ net458 _03255_ VSS VSS VDD VDD network.in_period\[251\]\[3\]
+ sky130_fd_sc_hd__edfxtp_1
Xnetwork.in_period\[252\]\[0\]$_DFFE_PP_ clknet_leaf_76_clk_load
+ net479 _03256_ VSS VSS VDD VDD network.in_period\[252\]\[0\]
+ sky130_fd_sc_hd__edfxtp_1
Xnetwork.in_period\[252\]\[1\]$_DFFE_PP_ clknet_leaf_76_clk_load
+ net471 _03256_ VSS VSS VDD VDD network.in_period\[252\]\[1\]
+ sky130_fd_sc_hd__edfxtp_1
Xnetwork.in_period\[252\]\[2\]$_DFFE_PP_ clknet_leaf_76_clk_load
+ net466 _03256_ VSS VSS VDD VDD network.in_period\[252\]\[2\]
+ sky130_fd_sc_hd__edfxtp_1
Xnetwork.in_period\[252\]\[3\]$_DFFE_PP_ clknet_leaf_76_clk_load
+ net458 _03256_ VSS VSS VDD VDD network.in_period\[252\]\[3\]
+ sky130_fd_sc_hd__edfxtp_1
Xnetwork.in_period\[253\]\[0\]$_DFFE_PP_ clknet_leaf_77_clk_load
+ net479 _03257_ VSS VSS VDD VDD network.in_period\[253\]\[0\]
+ sky130_fd_sc_hd__edfxtp_1
Xnetwork.in_period\[253\]\[1\]$_DFFE_PP_ clknet_leaf_77_clk_load
+ net471 _03257_ VSS VSS VDD VDD network.in_period\[253\]\[1\]
+ sky130_fd_sc_hd__edfxtp_1
Xnetwork.in_period\[253\]\[2\]$_DFFE_PP_ clknet_leaf_77_clk_load
+ net466 _03257_ VSS VSS VDD VDD network.in_period\[253\]\[2\]
+ sky130_fd_sc_hd__edfxtp_1
Xnetwork.in_period\[253\]\[3\]$_DFFE_PP_ clknet_leaf_77_clk_load
+ net458 _03257_ VSS VSS VDD VDD network.in_period\[253\]\[3\]
+ sky130_fd_sc_hd__edfxtp_1
Xnetwork.in_period\[254\]\[0\]$_DFFE_PP_ clknet_leaf_80_clk_load
+ net479 _03258_ VSS VSS VDD VDD network.in_period\[254\]\[0\]
+ sky130_fd_sc_hd__edfxtp_1
Xnetwork.in_period\[254\]\[1\]$_DFFE_PP_ clknet_leaf_80_clk_load
+ net471 _03258_ VSS VSS VDD VDD network.in_period\[254\]\[1\]
+ sky130_fd_sc_hd__edfxtp_1
Xnetwork.in_period\[254\]\[2\]$_DFFE_PP_ clknet_leaf_80_clk_load
+ net466 _03258_ VSS VSS VDD VDD network.in_period\[254\]\[2\]
+ sky130_fd_sc_hd__edfxtp_1
Xnetwork.in_period\[254\]\[3\]$_DFFE_PP_ clknet_leaf_80_clk_load
+ net458 _03258_ VSS VSS VDD VDD network.in_period\[254\]\[3\]
+ sky130_fd_sc_hd__edfxtp_1
Xnetwork.in_period\[255\]\[0\]$_DFFE_PP_ clknet_leaf_78_clk_load
+ net475 _03259_ VSS VSS VDD VDD network.in_period\[255\]\[0\]
+ sky130_fd_sc_hd__edfxtp_1
Xnetwork.in_period\[255\]\[1\]$_DFFE_PP_ clknet_leaf_78_clk_load
+ net469 _03259_ VSS VSS VDD VDD network.in_period\[255\]\[1\]
+ sky130_fd_sc_hd__edfxtp_1
Xnetwork.in_period\[255\]\[2\]$_DFFE_PP_ clknet_leaf_65_clk_load
+ net463 _03259_ VSS VSS VDD VDD network.in_period\[255\]\[2\]
+ sky130_fd_sc_hd__edfxtp_1
Xnetwork.in_period\[255\]\[3\]$_DFFE_PP_ clknet_leaf_78_clk_load
+ net461 _03259_ VSS VSS VDD VDD network.in_period\[255\]\[3\]
+ sky130_fd_sc_hd__edfxtp_1
Xnetwork.in_period\[25\]\[0\]$_DFFE_PP_ clknet_leaf_119_clk_load
+ net477 _03260_ VSS VSS VDD VDD network.in_period\[25\]\[0\]
+ sky130_fd_sc_hd__edfxtp_1
Xnetwork.in_period\[25\]\[1\]$_DFFE_PP_ clknet_leaf_119_clk_load
+ net470 _03260_ VSS VSS VDD VDD network.in_period\[25\]\[1\]
+ sky130_fd_sc_hd__edfxtp_1
Xnetwork.in_period\[25\]\[2\]$_DFFE_PP_ clknet_leaf_119_clk_load
+ net464 _03260_ VSS VSS VDD VDD network.in_period\[25\]\[2\]
+ sky130_fd_sc_hd__edfxtp_1
Xnetwork.in_period\[25\]\[3\]$_DFFE_PP_ clknet_leaf_119_clk_load
+ net456 _03260_ VSS VSS VDD VDD network.in_period\[25\]\[3\]
+ sky130_fd_sc_hd__edfxtp_1
Xnetwork.in_period\[26\]\[0\]$_DFFE_PP_ clknet_leaf_119_clk_load
+ net477 _03261_ VSS VSS VDD VDD network.in_period\[26\]\[0\]
+ sky130_fd_sc_hd__edfxtp_1
Xnetwork.in_period\[26\]\[1\]$_DFFE_PP_ clknet_leaf_119_clk_load
+ net470 _03261_ VSS VSS VDD VDD network.in_period\[26\]\[1\]
+ sky130_fd_sc_hd__edfxtp_1
Xnetwork.in_period\[26\]\[2\]$_DFFE_PP_ clknet_leaf_119_clk_load
+ net464 _03261_ VSS VSS VDD VDD network.in_period\[26\]\[2\]
+ sky130_fd_sc_hd__edfxtp_1
Xnetwork.in_period\[26\]\[3\]$_DFFE_PP_ clknet_leaf_119_clk_load
+ net456 _03261_ VSS VSS VDD VDD network.in_period\[26\]\[3\]
+ sky130_fd_sc_hd__edfxtp_1
Xnetwork.in_period\[27\]\[0\]$_DFFE_PP_ clknet_leaf_122_clk_load
+ net477 _03262_ VSS VSS VDD VDD network.in_period\[27\]\[0\]
+ sky130_fd_sc_hd__edfxtp_1
Xnetwork.in_period\[27\]\[1\]$_DFFE_PP_ clknet_leaf_122_clk_load
+ net470 _03262_ VSS VSS VDD VDD network.in_period\[27\]\[1\]
+ sky130_fd_sc_hd__edfxtp_1
Xnetwork.in_period\[27\]\[2\]$_DFFE_PP_ clknet_leaf_122_clk_load
+ net464 _03262_ VSS VSS VDD VDD network.in_period\[27\]\[2\]
+ sky130_fd_sc_hd__edfxtp_1
Xnetwork.in_period\[27\]\[3\]$_DFFE_PP_ clknet_leaf_122_clk_load
+ net456 _03262_ VSS VSS VDD VDD network.in_period\[27\]\[3\]
+ sky130_fd_sc_hd__edfxtp_1
Xnetwork.in_period\[28\]\[0\]$_DFFE_PP_ clknet_leaf_120_clk_load
+ net477 _03263_ VSS VSS VDD VDD network.in_period\[28\]\[0\]
+ sky130_fd_sc_hd__edfxtp_1
Xnetwork.in_period\[28\]\[1\]$_DFFE_PP_ clknet_leaf_121_clk_load
+ net470 _03263_ VSS VSS VDD VDD network.in_period\[28\]\[1\]
+ sky130_fd_sc_hd__edfxtp_1
Xnetwork.in_period\[28\]\[2\]$_DFFE_PP_ clknet_leaf_120_clk_load
+ net464 _03263_ VSS VSS VDD VDD network.in_period\[28\]\[2\]
+ sky130_fd_sc_hd__edfxtp_1
Xnetwork.in_period\[28\]\[3\]$_DFFE_PP_ clknet_leaf_120_clk_load
+ net456 _03263_ VSS VSS VDD VDD network.in_period\[28\]\[3\]
+ sky130_fd_sc_hd__edfxtp_1
Xnetwork.in_period\[29\]\[0\]$_DFFE_PP_ clknet_leaf_0_clk_load
+ net477 _03264_ VSS VSS VDD VDD network.in_period\[29\]\[0\]
+ sky130_fd_sc_hd__edfxtp_1
Xnetwork.in_period\[29\]\[1\]$_DFFE_PP_ clknet_leaf_0_clk_load
+ net470 _03264_ VSS VSS VDD VDD network.in_period\[29\]\[1\]
+ sky130_fd_sc_hd__edfxtp_1
Xnetwork.in_period\[29\]\[2\]$_DFFE_PP_ clknet_leaf_0_clk_load
+ net464 _03264_ VSS VSS VDD VDD network.in_period\[29\]\[2\]
+ sky130_fd_sc_hd__edfxtp_1
Xnetwork.in_period\[29\]\[3\]$_DFFE_PP_ clknet_leaf_0_clk_load
+ net456 _03264_ VSS VSS VDD VDD network.in_period\[29\]\[3\]
+ sky130_fd_sc_hd__edfxtp_1
Xnetwork.in_period\[2\]\[0\]$_DFFE_PP_ clknet_leaf_110_clk_load
+ net478 _03265_ VSS VSS VDD VDD network.in_period\[2\]\[0\]
+ sky130_fd_sc_hd__edfxtp_1
Xnetwork.in_period\[2\]\[1\]$_DFFE_PP_ clknet_leaf_110_clk_load
+ net472 _03265_ VSS VSS VDD VDD network.in_period\[2\]\[1\]
+ sky130_fd_sc_hd__edfxtp_1
Xnetwork.in_period\[2\]\[2\]$_DFFE_PP_ clknet_leaf_110_clk_load
+ net465 _03265_ VSS VSS VDD VDD network.in_period\[2\]\[2\]
+ sky130_fd_sc_hd__edfxtp_1
Xnetwork.in_period\[2\]\[3\]$_DFFE_PP_ clknet_leaf_111_clk_load
+ net457 _03265_ VSS VSS VDD VDD network.in_period\[2\]\[3\]
+ sky130_fd_sc_hd__edfxtp_1
Xnetwork.in_period\[30\]\[0\]$_DFFE_PP_ clknet_leaf_121_clk_load
+ net477 _03266_ VSS VSS VDD VDD network.in_period\[30\]\[0\]
+ sky130_fd_sc_hd__edfxtp_1
Xnetwork.in_period\[30\]\[1\]$_DFFE_PP_ clknet_leaf_122_clk_load
+ net470 _03266_ VSS VSS VDD VDD network.in_period\[30\]\[1\]
+ sky130_fd_sc_hd__edfxtp_1
Xnetwork.in_period\[30\]\[2\]$_DFFE_PP_ clknet_leaf_121_clk_load
+ net464 _03266_ VSS VSS VDD VDD network.in_period\[30\]\[2\]
+ sky130_fd_sc_hd__edfxtp_1
Xnetwork.in_period\[30\]\[3\]$_DFFE_PP_ clknet_leaf_121_clk_load
+ net456 _03266_ VSS VSS VDD VDD network.in_period\[30\]\[3\]
+ sky130_fd_sc_hd__edfxtp_1
Xnetwork.in_period\[31\]\[0\]$_DFFE_PP_ clknet_leaf_121_clk_load
+ net477 _03267_ VSS VSS VDD VDD network.in_period\[31\]\[0\]
+ sky130_fd_sc_hd__edfxtp_1
Xnetwork.in_period\[31\]\[1\]$_DFFE_PP_ clknet_leaf_121_clk_load
+ net470 _03267_ VSS VSS VDD VDD network.in_period\[31\]\[1\]
+ sky130_fd_sc_hd__edfxtp_1
Xnetwork.in_period\[31\]\[2\]$_DFFE_PP_ clknet_leaf_121_clk_load
+ net464 _03267_ VSS VSS VDD VDD network.in_period\[31\]\[2\]
+ sky130_fd_sc_hd__edfxtp_1
Xnetwork.in_period\[31\]\[3\]$_DFFE_PP_ clknet_leaf_121_clk_load
+ net456 _03267_ VSS VSS VDD VDD network.in_period\[31\]\[3\]
+ sky130_fd_sc_hd__edfxtp_1
Xnetwork.in_period\[32\]\[0\]$_DFFE_PP_ clknet_leaf_99_clk_load
+ net478 _03268_ VSS VSS VDD VDD network.in_period\[32\]\[0\]
+ sky130_fd_sc_hd__edfxtp_1
Xnetwork.in_period\[32\]\[1\]$_DFFE_PP_ clknet_leaf_99_clk_load
+ net472 _03268_ VSS VSS VDD VDD network.in_period\[32\]\[1\]
+ sky130_fd_sc_hd__edfxtp_1
Xnetwork.in_period\[32\]\[2\]$_DFFE_PP_ clknet_leaf_111_clk_load
+ net465 _03268_ VSS VSS VDD VDD network.in_period\[32\]\[2\]
+ sky130_fd_sc_hd__edfxtp_1
Xnetwork.in_period\[32\]\[3\]$_DFFE_PP_ clknet_leaf_99_clk_load
+ net457 _03268_ VSS VSS VDD VDD network.in_period\[32\]\[3\]
+ sky130_fd_sc_hd__edfxtp_1
Xnetwork.in_period\[33\]\[0\]$_DFFE_PP_ clknet_leaf_107_clk_load
+ net478 _03269_ VSS VSS VDD VDD network.in_period\[33\]\[0\]
+ sky130_fd_sc_hd__edfxtp_1
Xnetwork.in_period\[33\]\[1\]$_DFFE_PP_ clknet_leaf_107_clk_load
+ net472 _03269_ VSS VSS VDD VDD network.in_period\[33\]\[1\]
+ sky130_fd_sc_hd__edfxtp_1
Xnetwork.in_period\[33\]\[2\]$_DFFE_PP_ clknet_leaf_107_clk_load
+ net465 _03269_ VSS VSS VDD VDD network.in_period\[33\]\[2\]
+ sky130_fd_sc_hd__edfxtp_1
Xnetwork.in_period\[33\]\[3\]$_DFFE_PP_ clknet_leaf_107_clk_load
+ net457 _03269_ VSS VSS VDD VDD network.in_period\[33\]\[3\]
+ sky130_fd_sc_hd__edfxtp_1
Xnetwork.in_period\[34\]\[0\]$_DFFE_PP_ clknet_leaf_100_clk_load
+ net478 _03270_ VSS VSS VDD VDD network.in_period\[34\]\[0\]
+ sky130_fd_sc_hd__edfxtp_1
Xnetwork.in_period\[34\]\[1\]$_DFFE_PP_ clknet_leaf_100_clk_load
+ net472 _03270_ VSS VSS VDD VDD network.in_period\[34\]\[1\]
+ sky130_fd_sc_hd__edfxtp_1
Xnetwork.in_period\[34\]\[2\]$_DFFE_PP_ clknet_leaf_100_clk_load
+ net465 _03270_ VSS VSS VDD VDD network.in_period\[34\]\[2\]
+ sky130_fd_sc_hd__edfxtp_1
Xnetwork.in_period\[34\]\[3\]$_DFFE_PP_ clknet_leaf_100_clk_load
+ net457 _03270_ VSS VSS VDD VDD network.in_period\[34\]\[3\]
+ sky130_fd_sc_hd__edfxtp_1
Xnetwork.in_period\[35\]\[0\]$_DFFE_PP_ clknet_leaf_100_clk_load
+ net478 _03271_ VSS VSS VDD VDD network.in_period\[35\]\[0\]
+ sky130_fd_sc_hd__edfxtp_1
Xnetwork.in_period\[35\]\[1\]$_DFFE_PP_ clknet_leaf_100_clk_load
+ net472 _03271_ VSS VSS VDD VDD network.in_period\[35\]\[1\]
+ sky130_fd_sc_hd__edfxtp_1
Xnetwork.in_period\[35\]\[2\]$_DFFE_PP_ clknet_leaf_100_clk_load
+ net465 _03271_ VSS VSS VDD VDD network.in_period\[35\]\[2\]
+ sky130_fd_sc_hd__edfxtp_1
Xnetwork.in_period\[35\]\[3\]$_DFFE_PP_ clknet_leaf_100_clk_load
+ net457 _03271_ VSS VSS VDD VDD network.in_period\[35\]\[3\]
+ sky130_fd_sc_hd__edfxtp_1
Xnetwork.in_period\[36\]\[0\]$_DFFE_PP_ clknet_leaf_99_clk_load
+ net478 _03272_ VSS VSS VDD VDD network.in_period\[36\]\[0\]
+ sky130_fd_sc_hd__edfxtp_1
Xnetwork.in_period\[36\]\[1\]$_DFFE_PP_ clknet_leaf_99_clk_load
+ net472 _03272_ VSS VSS VDD VDD network.in_period\[36\]\[1\]
+ sky130_fd_sc_hd__edfxtp_1
Xnetwork.in_period\[36\]\[2\]$_DFFE_PP_ clknet_leaf_99_clk_load
+ net465 _03272_ VSS VSS VDD VDD network.in_period\[36\]\[2\]
+ sky130_fd_sc_hd__edfxtp_1
Xnetwork.in_period\[36\]\[3\]$_DFFE_PP_ clknet_leaf_99_clk_load
+ net457 _03272_ VSS VSS VDD VDD network.in_period\[36\]\[3\]
+ sky130_fd_sc_hd__edfxtp_1
Xnetwork.in_period\[37\]\[0\]$_DFFE_PP_ clknet_leaf_95_clk_load
+ net478 _03273_ VSS VSS VDD VDD network.in_period\[37\]\[0\]
+ sky130_fd_sc_hd__edfxtp_1
Xnetwork.in_period\[37\]\[1\]$_DFFE_PP_ clknet_leaf_95_clk_load
+ net472 _03273_ VSS VSS VDD VDD network.in_period\[37\]\[1\]
+ sky130_fd_sc_hd__edfxtp_1
Xnetwork.in_period\[37\]\[2\]$_DFFE_PP_ clknet_leaf_95_clk_load
+ net465 _03273_ VSS VSS VDD VDD network.in_period\[37\]\[2\]
+ sky130_fd_sc_hd__edfxtp_1
Xnetwork.in_period\[37\]\[3\]$_DFFE_PP_ clknet_leaf_95_clk_load
+ net457 _03273_ VSS VSS VDD VDD network.in_period\[37\]\[3\]
+ sky130_fd_sc_hd__edfxtp_1
Xnetwork.in_period\[38\]\[0\]$_DFFE_PP_ clknet_leaf_96_clk_load
+ net478 _03274_ VSS VSS VDD VDD network.in_period\[38\]\[0\]
+ sky130_fd_sc_hd__edfxtp_1
Xnetwork.in_period\[38\]\[1\]$_DFFE_PP_ clknet_leaf_95_clk_load
+ net472 _03274_ VSS VSS VDD VDD network.in_period\[38\]\[1\]
+ sky130_fd_sc_hd__edfxtp_1
Xnetwork.in_period\[38\]\[2\]$_DFFE_PP_ clknet_leaf_96_clk_load
+ net465 _03274_ VSS VSS VDD VDD network.in_period\[38\]\[2\]
+ sky130_fd_sc_hd__edfxtp_1
Xnetwork.in_period\[38\]\[3\]$_DFFE_PP_ clknet_leaf_96_clk_load
+ net457 _03274_ VSS VSS VDD VDD network.in_period\[38\]\[3\]
+ sky130_fd_sc_hd__edfxtp_1
Xnetwork.in_period\[39\]\[0\]$_DFFE_PP_ clknet_leaf_98_clk_load
+ net478 _03275_ VSS VSS VDD VDD network.in_period\[39\]\[0\]
+ sky130_fd_sc_hd__edfxtp_1
Xnetwork.in_period\[39\]\[1\]$_DFFE_PP_ clknet_leaf_98_clk_load
+ net472 _03275_ VSS VSS VDD VDD network.in_period\[39\]\[1\]
+ sky130_fd_sc_hd__edfxtp_1
Xnetwork.in_period\[39\]\[2\]$_DFFE_PP_ clknet_leaf_96_clk_load
+ net465 _03275_ VSS VSS VDD VDD network.in_period\[39\]\[2\]
+ sky130_fd_sc_hd__edfxtp_1
Xnetwork.in_period\[39\]\[3\]$_DFFE_PP_ clknet_leaf_96_clk_load
+ net457 _03275_ VSS VSS VDD VDD network.in_period\[39\]\[3\]
+ sky130_fd_sc_hd__edfxtp_1
Xnetwork.in_period\[3\]\[0\]$_DFFE_PP_ clknet_leaf_111_clk_load
+ net478 _03276_ VSS VSS VDD VDD network.in_period\[3\]\[0\]
+ sky130_fd_sc_hd__edfxtp_1
Xnetwork.in_period\[3\]\[1\]$_DFFE_PP_ clknet_leaf_111_clk_load
+ net472 _03276_ VSS VSS VDD VDD network.in_period\[3\]\[1\]
+ sky130_fd_sc_hd__edfxtp_1
Xnetwork.in_period\[3\]\[2\]$_DFFE_PP_ clknet_leaf_111_clk_load
+ net465 _03276_ VSS VSS VDD VDD network.in_period\[3\]\[2\]
+ sky130_fd_sc_hd__edfxtp_1
Xnetwork.in_period\[3\]\[3\]$_DFFE_PP_ clknet_leaf_111_clk_load
+ net457 _03276_ VSS VSS VDD VDD network.in_period\[3\]\[3\]
+ sky130_fd_sc_hd__edfxtp_1
Xnetwork.in_period\[40\]\[0\]$_DFFE_PP_ clknet_leaf_96_clk_load
+ net478 _03277_ VSS VSS VDD VDD network.in_period\[40\]\[0\]
+ sky130_fd_sc_hd__edfxtp_1
Xnetwork.in_period\[40\]\[1\]$_DFFE_PP_ clknet_leaf_96_clk_load
+ net472 _03277_ VSS VSS VDD VDD network.in_period\[40\]\[1\]
+ sky130_fd_sc_hd__edfxtp_1
Xnetwork.in_period\[40\]\[2\]$_DFFE_PP_ clknet_leaf_96_clk_load
+ net465 _03277_ VSS VSS VDD VDD network.in_period\[40\]\[2\]
+ sky130_fd_sc_hd__edfxtp_1
Xnetwork.in_period\[40\]\[3\]$_DFFE_PP_ clknet_leaf_96_clk_load
+ net457 _03277_ VSS VSS VDD VDD network.in_period\[40\]\[3\]
+ sky130_fd_sc_hd__edfxtp_1
Xnetwork.in_period\[41\]\[0\]$_DFFE_PP_ clknet_leaf_98_clk_load
+ net478 _03278_ VSS VSS VDD VDD network.in_period\[41\]\[0\]
+ sky130_fd_sc_hd__edfxtp_1
Xnetwork.in_period\[41\]\[1\]$_DFFE_PP_ clknet_leaf_98_clk_load
+ net472 _03278_ VSS VSS VDD VDD network.in_period\[41\]\[1\]
+ sky130_fd_sc_hd__edfxtp_1
Xnetwork.in_period\[41\]\[2\]$_DFFE_PP_ clknet_leaf_98_clk_load
+ net465 _03278_ VSS VSS VDD VDD network.in_period\[41\]\[2\]
+ sky130_fd_sc_hd__edfxtp_1
Xnetwork.in_period\[41\]\[3\]$_DFFE_PP_ clknet_leaf_98_clk_load
+ net457 _03278_ VSS VSS VDD VDD network.in_period\[41\]\[3\]
+ sky130_fd_sc_hd__edfxtp_1
Xnetwork.in_period\[42\]\[0\]$_DFFE_PP_ clknet_leaf_97_clk_load
+ net478 _03279_ VSS VSS VDD VDD network.in_period\[42\]\[0\]
+ sky130_fd_sc_hd__edfxtp_1
Xnetwork.in_period\[42\]\[1\]$_DFFE_PP_ clknet_leaf_97_clk_load
+ net472 _03279_ VSS VSS VDD VDD network.in_period\[42\]\[1\]
+ sky130_fd_sc_hd__edfxtp_1
Xnetwork.in_period\[42\]\[2\]$_DFFE_PP_ clknet_leaf_98_clk_load
+ net465 _03279_ VSS VSS VDD VDD network.in_period\[42\]\[2\]
+ sky130_fd_sc_hd__edfxtp_1
Xnetwork.in_period\[42\]\[3\]$_DFFE_PP_ clknet_leaf_97_clk_load
+ net457 _03279_ VSS VSS VDD VDD network.in_period\[42\]\[3\]
+ sky130_fd_sc_hd__edfxtp_1
Xnetwork.in_period\[43\]\[0\]$_DFFE_PP_ clknet_leaf_112_clk_load
+ net478 _03280_ VSS VSS VDD VDD network.in_period\[43\]\[0\]
+ sky130_fd_sc_hd__edfxtp_1
Xnetwork.in_period\[43\]\[1\]$_DFFE_PP_ clknet_leaf_112_clk_load
+ net472 _03280_ VSS VSS VDD VDD network.in_period\[43\]\[1\]
+ sky130_fd_sc_hd__edfxtp_1
Xnetwork.in_period\[43\]\[2\]$_DFFE_PP_ clknet_leaf_98_clk_load
+ net465 _03280_ VSS VSS VDD VDD network.in_period\[43\]\[2\]
+ sky130_fd_sc_hd__edfxtp_1
Xnetwork.in_period\[43\]\[3\]$_DFFE_PP_ clknet_leaf_98_clk_load
+ net457 _03280_ VSS VSS VDD VDD network.in_period\[43\]\[3\]
+ sky130_fd_sc_hd__edfxtp_1
Xnetwork.in_period\[44\]\[0\]$_DFFE_PP_ clknet_leaf_97_clk_load
+ net478 _03281_ VSS VSS VDD VDD network.in_period\[44\]\[0\]
+ sky130_fd_sc_hd__edfxtp_1
Xnetwork.in_period\[44\]\[1\]$_DFFE_PP_ clknet_leaf_97_clk_load
+ net472 _03281_ VSS VSS VDD VDD network.in_period\[44\]\[1\]
+ sky130_fd_sc_hd__edfxtp_1
Xnetwork.in_period\[44\]\[2\]$_DFFE_PP_ clknet_leaf_97_clk_load
+ net465 _03281_ VSS VSS VDD VDD network.in_period\[44\]\[2\]
+ sky130_fd_sc_hd__edfxtp_1
Xnetwork.in_period\[44\]\[3\]$_DFFE_PP_ clknet_leaf_97_clk_load
+ net457 _03281_ VSS VSS VDD VDD network.in_period\[44\]\[3\]
+ sky130_fd_sc_hd__edfxtp_1
Xnetwork.in_period\[45\]\[0\]$_DFFE_PP_ clknet_leaf_113_clk_load
+ net478 _03282_ VSS VSS VDD VDD network.in_period\[45\]\[0\]
+ sky130_fd_sc_hd__edfxtp_1
Xnetwork.in_period\[45\]\[1\]$_DFFE_PP_ clknet_leaf_113_clk_load
+ net472 _03282_ VSS VSS VDD VDD network.in_period\[45\]\[1\]
+ sky130_fd_sc_hd__edfxtp_1
Xnetwork.in_period\[45\]\[2\]$_DFFE_PP_ clknet_leaf_113_clk_load
+ net465 _03282_ VSS VSS VDD VDD network.in_period\[45\]\[2\]
+ sky130_fd_sc_hd__edfxtp_1
Xnetwork.in_period\[45\]\[3\]$_DFFE_PP_ clknet_leaf_113_clk_load
+ net457 _03282_ VSS VSS VDD VDD network.in_period\[45\]\[3\]
+ sky130_fd_sc_hd__edfxtp_1
Xnetwork.in_period\[46\]\[0\]$_DFFE_PP_ clknet_leaf_95_clk_load
+ net478 _03283_ VSS VSS VDD VDD network.in_period\[46\]\[0\]
+ sky130_fd_sc_hd__edfxtp_1
Xnetwork.in_period\[46\]\[1\]$_DFFE_PP_ clknet_leaf_95_clk_load
+ net472 _03283_ VSS VSS VDD VDD network.in_period\[46\]\[1\]
+ sky130_fd_sc_hd__edfxtp_1
Xnetwork.in_period\[46\]\[2\]$_DFFE_PP_ clknet_leaf_95_clk_load
+ net465 _03283_ VSS VSS VDD VDD network.in_period\[46\]\[2\]
+ sky130_fd_sc_hd__edfxtp_1
Xnetwork.in_period\[46\]\[3\]$_DFFE_PP_ clknet_leaf_95_clk_load
+ net457 _03283_ VSS VSS VDD VDD network.in_period\[46\]\[3\]
+ sky130_fd_sc_hd__edfxtp_1
Xnetwork.in_period\[47\]\[0\]$_DFFE_PP_ clknet_leaf_97_clk_load
+ net478 _03284_ VSS VSS VDD VDD network.in_period\[47\]\[0\]
+ sky130_fd_sc_hd__edfxtp_1
Xnetwork.in_period\[47\]\[1\]$_DFFE_PP_ clknet_leaf_97_clk_load
+ net472 _03284_ VSS VSS VDD VDD network.in_period\[47\]\[1\]
+ sky130_fd_sc_hd__edfxtp_1
Xnetwork.in_period\[47\]\[2\]$_DFFE_PP_ clknet_leaf_97_clk_load
+ net465 _03284_ VSS VSS VDD VDD network.in_period\[47\]\[2\]
+ sky130_fd_sc_hd__edfxtp_1
Xnetwork.in_period\[47\]\[3\]$_DFFE_PP_ clknet_leaf_97_clk_load
+ net457 _03284_ VSS VSS VDD VDD network.in_period\[47\]\[3\]
+ sky130_fd_sc_hd__edfxtp_1
Xnetwork.in_period\[48\]\[0\]$_DFFE_PP_ clknet_leaf_13_clk_load
+ net480 _03285_ VSS VSS VDD VDD network.in_period\[48\]\[0\]
+ sky130_fd_sc_hd__edfxtp_1
Xnetwork.in_period\[48\]\[1\]$_DFFE_PP_ clknet_leaf_13_clk_load
+ net473 _03285_ VSS VSS VDD VDD network.in_period\[48\]\[1\]
+ sky130_fd_sc_hd__edfxtp_1
Xnetwork.in_period\[48\]\[2\]$_DFFE_PP_ clknet_leaf_13_clk_load
+ net467 _03285_ VSS VSS VDD VDD network.in_period\[48\]\[2\]
+ sky130_fd_sc_hd__edfxtp_1
Xnetwork.in_period\[48\]\[3\]$_DFFE_PP_ clknet_leaf_13_clk_load
+ net459 _03285_ VSS VSS VDD VDD network.in_period\[48\]\[3\]
+ sky130_fd_sc_hd__edfxtp_1
Xnetwork.in_period\[49\]\[0\]$_DFFE_PP_ clknet_leaf_13_clk_load
+ net480 _03286_ VSS VSS VDD VDD network.in_period\[49\]\[0\]
+ sky130_fd_sc_hd__edfxtp_1
Xnetwork.in_period\[49\]\[1\]$_DFFE_PP_ clknet_leaf_13_clk_load
+ net473 _03286_ VSS VSS VDD VDD network.in_period\[49\]\[1\]
+ sky130_fd_sc_hd__edfxtp_1
Xnetwork.in_period\[49\]\[2\]$_DFFE_PP_ clknet_leaf_109_clk_load
+ net467 _03286_ VSS VSS VDD VDD network.in_period\[49\]\[2\]
+ sky130_fd_sc_hd__edfxtp_1
Xnetwork.in_period\[49\]\[3\]$_DFFE_PP_ clknet_leaf_13_clk_load
+ net459 _03286_ VSS VSS VDD VDD network.in_period\[49\]\[3\]
+ sky130_fd_sc_hd__edfxtp_1
Xnetwork.in_period\[4\]\[0\]$_DFFE_PP_ clknet_leaf_120_clk_load
+ net477 _03287_ VSS VSS VDD VDD network.in_period\[4\]\[0\]
+ sky130_fd_sc_hd__edfxtp_1
Xnetwork.in_period\[4\]\[1\]$_DFFE_PP_ clknet_leaf_120_clk_load
+ net470 _03287_ VSS VSS VDD VDD network.in_period\[4\]\[1\]
+ sky130_fd_sc_hd__edfxtp_1
Xnetwork.in_period\[4\]\[2\]$_DFFE_PP_ clknet_leaf_120_clk_load
+ net464 _03287_ VSS VSS VDD VDD network.in_period\[4\]\[2\]
+ sky130_fd_sc_hd__edfxtp_1
Xnetwork.in_period\[4\]\[3\]$_DFFE_PP_ clknet_leaf_117_clk_load
+ net456 _03287_ VSS VSS VDD VDD network.in_period\[4\]\[3\]
+ sky130_fd_sc_hd__edfxtp_1
Xnetwork.in_period\[50\]\[0\]$_DFFE_PP_ clknet_leaf_108_clk_load
+ net480 _03288_ VSS VSS VDD VDD network.in_period\[50\]\[0\]
+ sky130_fd_sc_hd__edfxtp_1
Xnetwork.in_period\[50\]\[1\]$_DFFE_PP_ clknet_leaf_108_clk_load
+ net473 _03288_ VSS VSS VDD VDD network.in_period\[50\]\[1\]
+ sky130_fd_sc_hd__edfxtp_1
Xnetwork.in_period\[50\]\[2\]$_DFFE_PP_ clknet_leaf_108_clk_load
+ net466 _03288_ VSS VSS VDD VDD network.in_period\[50\]\[2\]
+ sky130_fd_sc_hd__edfxtp_1
Xnetwork.in_period\[50\]\[3\]$_DFFE_PP_ clknet_leaf_108_clk_load
+ net458 _03288_ VSS VSS VDD VDD network.in_period\[50\]\[3\]
+ sky130_fd_sc_hd__edfxtp_1
Xnetwork.in_period\[51\]\[0\]$_DFFE_PP_ clknet_leaf_4_clk_load
+ net477 _03289_ VSS VSS VDD VDD network.in_period\[51\]\[0\]
+ sky130_fd_sc_hd__edfxtp_1
Xnetwork.in_period\[51\]\[1\]$_DFFE_PP_ clknet_leaf_4_clk_load
+ net470 _03289_ VSS VSS VDD VDD network.in_period\[51\]\[1\]
+ sky130_fd_sc_hd__edfxtp_1
Xnetwork.in_period\[51\]\[2\]$_DFFE_PP_ clknet_leaf_4_clk_load
+ net467 _03289_ VSS VSS VDD VDD network.in_period\[51\]\[2\]
+ sky130_fd_sc_hd__edfxtp_1
Xnetwork.in_period\[51\]\[3\]$_DFFE_PP_ clknet_leaf_4_clk_load
+ net456 _03289_ VSS VSS VDD VDD network.in_period\[51\]\[3\]
+ sky130_fd_sc_hd__edfxtp_1
Xnetwork.in_period\[52\]\[0\]$_DFFE_PP_ clknet_leaf_7_clk_load
+ net477 _03290_ VSS VSS VDD VDD network.in_period\[52\]\[0\]
+ sky130_fd_sc_hd__edfxtp_1
Xnetwork.in_period\[52\]\[1\]$_DFFE_PP_ clknet_leaf_7_clk_load
+ net470 _03290_ VSS VSS VDD VDD network.in_period\[52\]\[1\]
+ sky130_fd_sc_hd__edfxtp_1
Xnetwork.in_period\[52\]\[2\]$_DFFE_PP_ clknet_leaf_6_clk_load
+ net464 _03290_ VSS VSS VDD VDD network.in_period\[52\]\[2\]
+ sky130_fd_sc_hd__edfxtp_1
Xnetwork.in_period\[52\]\[3\]$_DFFE_PP_ clknet_leaf_7_clk_load
+ net456 _03290_ VSS VSS VDD VDD network.in_period\[52\]\[3\]
+ sky130_fd_sc_hd__edfxtp_1
Xnetwork.in_period\[53\]\[0\]$_DFFE_PP_ clknet_leaf_4_clk_load
+ net477 _03291_ VSS VSS VDD VDD network.in_period\[53\]\[0\]
+ sky130_fd_sc_hd__edfxtp_1
Xnetwork.in_period\[53\]\[1\]$_DFFE_PP_ clknet_leaf_4_clk_load
+ net470 _03291_ VSS VSS VDD VDD network.in_period\[53\]\[1\]
+ sky130_fd_sc_hd__edfxtp_1
Xnetwork.in_period\[53\]\[2\]$_DFFE_PP_ clknet_leaf_4_clk_load
+ net467 _03291_ VSS VSS VDD VDD network.in_period\[53\]\[2\]
+ sky130_fd_sc_hd__edfxtp_1
Xnetwork.in_period\[53\]\[3\]$_DFFE_PP_ clknet_leaf_4_clk_load
+ net456 _03291_ VSS VSS VDD VDD network.in_period\[53\]\[3\]
+ sky130_fd_sc_hd__edfxtp_1
Xnetwork.in_period\[54\]\[0\]$_DFFE_PP_ clknet_leaf_12_clk_load
+ net477 _03292_ VSS VSS VDD VDD network.in_period\[54\]\[0\]
+ sky130_fd_sc_hd__edfxtp_1
Xnetwork.in_period\[54\]\[1\]$_DFFE_PP_ clknet_leaf_12_clk_load
+ net470 _03292_ VSS VSS VDD VDD network.in_period\[54\]\[1\]
+ sky130_fd_sc_hd__edfxtp_1
Xnetwork.in_period\[54\]\[2\]$_DFFE_PP_ clknet_leaf_12_clk_load
+ net467 _03292_ VSS VSS VDD VDD network.in_period\[54\]\[2\]
+ sky130_fd_sc_hd__edfxtp_1
Xnetwork.in_period\[54\]\[3\]$_DFFE_PP_ clknet_leaf_12_clk_load
+ net456 _03292_ VSS VSS VDD VDD network.in_period\[54\]\[3\]
+ sky130_fd_sc_hd__edfxtp_1
Xnetwork.in_period\[55\]\[0\]$_DFFE_PP_ clknet_leaf_12_clk_load
+ net477 _03293_ VSS VSS VDD VDD network.in_period\[55\]\[0\]
+ sky130_fd_sc_hd__edfxtp_1
Xnetwork.in_period\[55\]\[1\]$_DFFE_PP_ clknet_leaf_12_clk_load
+ net470 _03293_ VSS VSS VDD VDD network.in_period\[55\]\[1\]
+ sky130_fd_sc_hd__edfxtp_1
Xnetwork.in_period\[55\]\[2\]$_DFFE_PP_ clknet_leaf_12_clk_load
+ net467 _03293_ VSS VSS VDD VDD network.in_period\[55\]\[2\]
+ sky130_fd_sc_hd__edfxtp_1
Xnetwork.in_period\[55\]\[3\]$_DFFE_PP_ clknet_leaf_12_clk_load
+ net456 _03293_ VSS VSS VDD VDD network.in_period\[55\]\[3\]
+ sky130_fd_sc_hd__edfxtp_1
Xnetwork.in_period\[56\]\[0\]$_DFFE_PP_ clknet_leaf_5_clk_load
+ net477 _03294_ VSS VSS VDD VDD network.in_period\[56\]\[0\]
+ sky130_fd_sc_hd__edfxtp_1
Xnetwork.in_period\[56\]\[1\]$_DFFE_PP_ clknet_leaf_5_clk_load
+ net470 _03294_ VSS VSS VDD VDD network.in_period\[56\]\[1\]
+ sky130_fd_sc_hd__edfxtp_1
Xnetwork.in_period\[56\]\[2\]$_DFFE_PP_ clknet_leaf_5_clk_load
+ net464 _03294_ VSS VSS VDD VDD network.in_period\[56\]\[2\]
+ sky130_fd_sc_hd__edfxtp_1
Xnetwork.in_period\[56\]\[3\]$_DFFE_PP_ clknet_leaf_5_clk_load
+ net456 _03294_ VSS VSS VDD VDD network.in_period\[56\]\[3\]
+ sky130_fd_sc_hd__edfxtp_1
Xnetwork.in_period\[57\]\[0\]$_DFFE_PP_ clknet_leaf_1_clk_load
+ net477 _03295_ VSS VSS VDD VDD network.in_period\[57\]\[0\]
+ sky130_fd_sc_hd__edfxtp_1
Xnetwork.in_period\[57\]\[1\]$_DFFE_PP_ clknet_leaf_1_clk_load
+ net470 _03295_ VSS VSS VDD VDD network.in_period\[57\]\[1\]
+ sky130_fd_sc_hd__edfxtp_1
Xnetwork.in_period\[57\]\[2\]$_DFFE_PP_ clknet_leaf_3_clk_load
+ net464 _03295_ VSS VSS VDD VDD network.in_period\[57\]\[2\]
+ sky130_fd_sc_hd__edfxtp_1
Xnetwork.in_period\[57\]\[3\]$_DFFE_PP_ clknet_leaf_1_clk_load
+ net456 _03295_ VSS VSS VDD VDD network.in_period\[57\]\[3\]
+ sky130_fd_sc_hd__edfxtp_1
Xnetwork.in_period\[58\]\[0\]$_DFFE_PP_ clknet_leaf_6_clk_load
+ net477 _03296_ VSS VSS VDD VDD network.in_period\[58\]\[0\]
+ sky130_fd_sc_hd__edfxtp_1
Xnetwork.in_period\[58\]\[1\]$_DFFE_PP_ clknet_leaf_6_clk_load
+ net470 _03296_ VSS VSS VDD VDD network.in_period\[58\]\[1\]
+ sky130_fd_sc_hd__edfxtp_1
Xnetwork.in_period\[58\]\[2\]$_DFFE_PP_ clknet_leaf_6_clk_load
+ net464 _03296_ VSS VSS VDD VDD network.in_period\[58\]\[2\]
+ sky130_fd_sc_hd__edfxtp_1
Xnetwork.in_period\[58\]\[3\]$_DFFE_PP_ clknet_leaf_6_clk_load
+ net456 _03296_ VSS VSS VDD VDD network.in_period\[58\]\[3\]
+ sky130_fd_sc_hd__edfxtp_1
Xnetwork.in_period\[59\]\[0\]$_DFFE_PP_ clknet_leaf_6_clk_load
+ net477 _03297_ VSS VSS VDD VDD network.in_period\[59\]\[0\]
+ sky130_fd_sc_hd__edfxtp_1
Xnetwork.in_period\[59\]\[1\]$_DFFE_PP_ clknet_leaf_6_clk_load
+ net470 _03297_ VSS VSS VDD VDD network.in_period\[59\]\[1\]
+ sky130_fd_sc_hd__edfxtp_1
Xnetwork.in_period\[59\]\[2\]$_DFFE_PP_ clknet_leaf_6_clk_load
+ net464 _03297_ VSS VSS VDD VDD network.in_period\[59\]\[2\]
+ sky130_fd_sc_hd__edfxtp_1
Xnetwork.in_period\[59\]\[3\]$_DFFE_PP_ clknet_leaf_6_clk_load
+ net456 _03297_ VSS VSS VDD VDD network.in_period\[59\]\[3\]
+ sky130_fd_sc_hd__edfxtp_1
Xnetwork.in_period\[5\]\[0\]$_DFFE_PP_ clknet_leaf_116_clk_load
+ net480 _03298_ VSS VSS VDD VDD network.in_period\[5\]\[0\]
+ sky130_fd_sc_hd__edfxtp_1
Xnetwork.in_period\[5\]\[1\]$_DFFE_PP_ clknet_leaf_116_clk_load
+ net473 _03298_ VSS VSS VDD VDD network.in_period\[5\]\[1\]
+ sky130_fd_sc_hd__edfxtp_1
Xnetwork.in_period\[5\]\[2\]$_DFFE_PP_ clknet_leaf_115_clk_load
+ net467 _03298_ VSS VSS VDD VDD network.in_period\[5\]\[2\]
+ sky130_fd_sc_hd__edfxtp_1
Xnetwork.in_period\[5\]\[3\]$_DFFE_PP_ clknet_leaf_115_clk_load
+ net459 _03298_ VSS VSS VDD VDD network.in_period\[5\]\[3\]
+ sky130_fd_sc_hd__edfxtp_1
Xnetwork.in_period\[60\]\[0\]$_DFFE_PP_ clknet_leaf_0_clk_load
+ net477 _03299_ VSS VSS VDD VDD network.in_period\[60\]\[0\]
+ sky130_fd_sc_hd__edfxtp_1
Xnetwork.in_period\[60\]\[1\]$_DFFE_PP_ clknet_leaf_0_clk_load
+ net470 _03299_ VSS VSS VDD VDD network.in_period\[60\]\[1\]
+ sky130_fd_sc_hd__edfxtp_1
Xnetwork.in_period\[60\]\[2\]$_DFFE_PP_ clknet_leaf_0_clk_load
+ net464 _03299_ VSS VSS VDD VDD network.in_period\[60\]\[2\]
+ sky130_fd_sc_hd__edfxtp_1
Xnetwork.in_period\[60\]\[3\]$_DFFE_PP_ clknet_leaf_0_clk_load
+ net456 _03299_ VSS VSS VDD VDD network.in_period\[60\]\[3\]
+ sky130_fd_sc_hd__edfxtp_1
Xnetwork.in_period\[61\]\[0\]$_DFFE_PP_ clknet_leaf_5_clk_load
+ net477 _03300_ VSS VSS VDD VDD network.in_period\[61\]\[0\]
+ sky130_fd_sc_hd__edfxtp_1
Xnetwork.in_period\[61\]\[1\]$_DFFE_PP_ clknet_leaf_5_clk_load
+ net470 _03300_ VSS VSS VDD VDD network.in_period\[61\]\[1\]
+ sky130_fd_sc_hd__edfxtp_1
Xnetwork.in_period\[61\]\[2\]$_DFFE_PP_ clknet_leaf_5_clk_load
+ net464 _03300_ VSS VSS VDD VDD network.in_period\[61\]\[2\]
+ sky130_fd_sc_hd__edfxtp_1
Xnetwork.in_period\[61\]\[3\]$_DFFE_PP_ clknet_leaf_5_clk_load
+ net456 _03300_ VSS VSS VDD VDD network.in_period\[61\]\[3\]
+ sky130_fd_sc_hd__edfxtp_1
Xnetwork.in_period\[62\]\[0\]$_DFFE_PP_ clknet_leaf_2_clk_load
+ net477 _03301_ VSS VSS VDD VDD network.in_period\[62\]\[0\]
+ sky130_fd_sc_hd__edfxtp_1
Xnetwork.in_period\[62\]\[1\]$_DFFE_PP_ clknet_leaf_2_clk_load
+ net470 _03301_ VSS VSS VDD VDD network.in_period\[62\]\[1\]
+ sky130_fd_sc_hd__edfxtp_1
Xnetwork.in_period\[62\]\[2\]$_DFFE_PP_ clknet_leaf_1_clk_load
+ net464 _03301_ VSS VSS VDD VDD network.in_period\[62\]\[2\]
+ sky130_fd_sc_hd__edfxtp_1
Xnetwork.in_period\[62\]\[3\]$_DFFE_PP_ clknet_leaf_2_clk_load
+ net456 _03301_ VSS VSS VDD VDD network.in_period\[62\]\[3\]
+ sky130_fd_sc_hd__edfxtp_1
Xnetwork.in_period\[63\]\[0\]$_DFFE_PP_ clknet_leaf_1_clk_load
+ net477 _03302_ VSS VSS VDD VDD network.in_period\[63\]\[0\]
+ sky130_fd_sc_hd__edfxtp_1
Xnetwork.in_period\[63\]\[1\]$_DFFE_PP_ clknet_leaf_1_clk_load
+ net470 _03302_ VSS VSS VDD VDD network.in_period\[63\]\[1\]
+ sky130_fd_sc_hd__edfxtp_1
Xnetwork.in_period\[63\]\[2\]$_DFFE_PP_ clknet_leaf_1_clk_load
+ net464 _03302_ VSS VSS VDD VDD network.in_period\[63\]\[2\]
+ sky130_fd_sc_hd__edfxtp_1
Xnetwork.in_period\[63\]\[3\]$_DFFE_PP_ clknet_leaf_1_clk_load
+ net456 _03302_ VSS VSS VDD VDD network.in_period\[63\]\[3\]
+ sky130_fd_sc_hd__edfxtp_1
Xnetwork.in_period\[64\]\[0\]$_DFFE_PP_ clknet_leaf_16_clk_load
+ net480 _03303_ VSS VSS VDD VDD network.in_period\[64\]\[0\]
+ sky130_fd_sc_hd__edfxtp_1
Xnetwork.in_period\[64\]\[1\]$_DFFE_PP_ clknet_leaf_16_clk_load
+ net473 _03303_ VSS VSS VDD VDD network.in_period\[64\]\[1\]
+ sky130_fd_sc_hd__edfxtp_1
Xnetwork.in_period\[64\]\[2\]$_DFFE_PP_ clknet_leaf_16_clk_load
+ net466 _03303_ VSS VSS VDD VDD network.in_period\[64\]\[2\]
+ sky130_fd_sc_hd__edfxtp_1
Xnetwork.in_period\[64\]\[3\]$_DFFE_PP_ clknet_leaf_16_clk_load
+ net458 _03303_ VSS VSS VDD VDD network.in_period\[64\]\[3\]
+ sky130_fd_sc_hd__edfxtp_1
Xnetwork.in_period\[65\]\[0\]$_DFFE_PP_ clknet_leaf_10_clk_load
+ net480 _03304_ VSS VSS VDD VDD network.in_period\[65\]\[0\]
+ sky130_fd_sc_hd__edfxtp_1
Xnetwork.in_period\[65\]\[1\]$_DFFE_PP_ clknet_leaf_10_clk_load
+ net474 _03304_ VSS VSS VDD VDD network.in_period\[65\]\[1\]
+ sky130_fd_sc_hd__edfxtp_1
Xnetwork.in_period\[65\]\[2\]$_DFFE_PP_ clknet_leaf_11_clk_load
+ net467 _03304_ VSS VSS VDD VDD network.in_period\[65\]\[2\]
+ sky130_fd_sc_hd__edfxtp_1
Xnetwork.in_period\[65\]\[3\]$_DFFE_PP_ clknet_leaf_11_clk_load
+ net459 _03304_ VSS VSS VDD VDD network.in_period\[65\]\[3\]
+ sky130_fd_sc_hd__edfxtp_1
Xnetwork.in_period\[66\]\[0\]$_DFFE_PP_ clknet_leaf_15_clk_load
+ net480 _03305_ VSS VSS VDD VDD network.in_period\[66\]\[0\]
+ sky130_fd_sc_hd__edfxtp_1
Xnetwork.in_period\[66\]\[1\]$_DFFE_PP_ clknet_leaf_15_clk_load
+ net473 _03305_ VSS VSS VDD VDD network.in_period\[66\]\[1\]
+ sky130_fd_sc_hd__edfxtp_1
Xnetwork.in_period\[66\]\[2\]$_DFFE_PP_ clknet_leaf_16_clk_load
+ net466 _03305_ VSS VSS VDD VDD network.in_period\[66\]\[2\]
+ sky130_fd_sc_hd__edfxtp_1
Xnetwork.in_period\[66\]\[3\]$_DFFE_PP_ clknet_leaf_15_clk_load
+ net458 _03305_ VSS VSS VDD VDD network.in_period\[66\]\[3\]
+ sky130_fd_sc_hd__edfxtp_1
Xnetwork.in_period\[67\]\[0\]$_DFFE_PP_ clknet_leaf_14_clk_load
+ net480 _03306_ VSS VSS VDD VDD network.in_period\[67\]\[0\]
+ sky130_fd_sc_hd__edfxtp_1
Xnetwork.in_period\[67\]\[1\]$_DFFE_PP_ clknet_leaf_14_clk_load
+ net473 _03306_ VSS VSS VDD VDD network.in_period\[67\]\[1\]
+ sky130_fd_sc_hd__edfxtp_1
Xnetwork.in_period\[67\]\[2\]$_DFFE_PP_ clknet_leaf_14_clk_load
+ net467 _03306_ VSS VSS VDD VDD network.in_period\[67\]\[2\]
+ sky130_fd_sc_hd__edfxtp_1
Xnetwork.in_period\[67\]\[3\]$_DFFE_PP_ clknet_leaf_14_clk_load
+ net459 _03306_ VSS VSS VDD VDD network.in_period\[67\]\[3\]
+ sky130_fd_sc_hd__edfxtp_1
Xnetwork.in_period\[68\]\[0\]$_DFFE_PP_ clknet_leaf_23_clk_load
+ net480 _03307_ VSS VSS VDD VDD network.in_period\[68\]\[0\]
+ sky130_fd_sc_hd__edfxtp_1
Xnetwork.in_period\[68\]\[1\]$_DFFE_PP_ clknet_leaf_23_clk_load
+ net474 _03307_ VSS VSS VDD VDD network.in_period\[68\]\[1\]
+ sky130_fd_sc_hd__edfxtp_1
Xnetwork.in_period\[68\]\[2\]$_DFFE_PP_ clknet_leaf_23_clk_load
+ net467 _03307_ VSS VSS VDD VDD network.in_period\[68\]\[2\]
+ sky130_fd_sc_hd__edfxtp_1
Xnetwork.in_period\[68\]\[3\]$_DFFE_PP_ clknet_leaf_23_clk_load
+ net459 _03307_ VSS VSS VDD VDD network.in_period\[68\]\[3\]
+ sky130_fd_sc_hd__edfxtp_1
Xnetwork.in_period\[69\]\[0\]$_DFFE_PP_ clknet_leaf_24_clk_load
+ net480 _03308_ VSS VSS VDD VDD network.in_period\[69\]\[0\]
+ sky130_fd_sc_hd__edfxtp_1
Xnetwork.in_period\[69\]\[1\]$_DFFE_PP_ clknet_leaf_24_clk_load
+ net474 _03308_ VSS VSS VDD VDD network.in_period\[69\]\[1\]
+ sky130_fd_sc_hd__edfxtp_1
Xnetwork.in_period\[69\]\[2\]$_DFFE_PP_ clknet_leaf_24_clk_load
+ net467 _03308_ VSS VSS VDD VDD network.in_period\[69\]\[2\]
+ sky130_fd_sc_hd__edfxtp_1
Xnetwork.in_period\[69\]\[3\]$_DFFE_PP_ clknet_leaf_24_clk_load
+ net459 _03308_ VSS VSS VDD VDD network.in_period\[69\]\[3\]
+ sky130_fd_sc_hd__edfxtp_1
Xnetwork.in_period\[6\]\[0\]$_DFFE_PP_ clknet_leaf_115_clk_load
+ net478 _03309_ VSS VSS VDD VDD network.in_period\[6\]\[0\]
+ sky130_fd_sc_hd__edfxtp_1
Xnetwork.in_period\[6\]\[1\]$_DFFE_PP_ clknet_leaf_115_clk_load
+ net472 _03309_ VSS VSS VDD VDD network.in_period\[6\]\[1\]
+ sky130_fd_sc_hd__edfxtp_1
Xnetwork.in_period\[6\]\[2\]$_DFFE_PP_ clknet_leaf_115_clk_load
+ net465 _03309_ VSS VSS VDD VDD network.in_period\[6\]\[2\]
+ sky130_fd_sc_hd__edfxtp_1
Xnetwork.in_period\[6\]\[3\]$_DFFE_PP_ clknet_leaf_115_clk_load
+ net457 _03309_ VSS VSS VDD VDD network.in_period\[6\]\[3\]
+ sky130_fd_sc_hd__edfxtp_1
Xnetwork.in_period\[70\]\[0\]$_DFFE_PP_ clknet_leaf_20_clk_load
+ net480 _03310_ VSS VSS VDD VDD network.in_period\[70\]\[0\]
+ sky130_fd_sc_hd__edfxtp_1
Xnetwork.in_period\[70\]\[1\]$_DFFE_PP_ clknet_leaf_19_clk_load
+ net471 _03310_ VSS VSS VDD VDD network.in_period\[70\]\[1\]
+ sky130_fd_sc_hd__edfxtp_1
Xnetwork.in_period\[70\]\[2\]$_DFFE_PP_ clknet_leaf_20_clk_load
+ net467 _03310_ VSS VSS VDD VDD network.in_period\[70\]\[2\]
+ sky130_fd_sc_hd__edfxtp_1
Xnetwork.in_period\[70\]\[3\]$_DFFE_PP_ clknet_leaf_20_clk_load
+ net459 _03310_ VSS VSS VDD VDD network.in_period\[70\]\[3\]
+ sky130_fd_sc_hd__edfxtp_1
Xnetwork.in_period\[71\]\[0\]$_DFFE_PP_ clknet_leaf_15_clk_load
+ net480 _03311_ VSS VSS VDD VDD network.in_period\[71\]\[0\]
+ sky130_fd_sc_hd__edfxtp_1
Xnetwork.in_period\[71\]\[1\]$_DFFE_PP_ clknet_leaf_15_clk_load
+ net474 _03311_ VSS VSS VDD VDD network.in_period\[71\]\[1\]
+ sky130_fd_sc_hd__edfxtp_1
Xnetwork.in_period\[71\]\[2\]$_DFFE_PP_ clknet_leaf_15_clk_load
+ net467 _03311_ VSS VSS VDD VDD network.in_period\[71\]\[2\]
+ sky130_fd_sc_hd__edfxtp_1
Xnetwork.in_period\[71\]\[3\]$_DFFE_PP_ clknet_leaf_15_clk_load
+ net459 _03311_ VSS VSS VDD VDD network.in_period\[71\]\[3\]
+ sky130_fd_sc_hd__edfxtp_1
Xnetwork.in_period\[72\]\[0\]$_DFFE_PP_ clknet_leaf_19_clk_load
+ net480 _03312_ VSS VSS VDD VDD network.in_period\[72\]\[0\]
+ sky130_fd_sc_hd__edfxtp_1
Xnetwork.in_period\[72\]\[1\]$_DFFE_PP_ clknet_leaf_19_clk_load
+ net471 _03312_ VSS VSS VDD VDD network.in_period\[72\]\[1\]
+ sky130_fd_sc_hd__edfxtp_1
Xnetwork.in_period\[72\]\[2\]$_DFFE_PP_ clknet_leaf_19_clk_load
+ net467 _03312_ VSS VSS VDD VDD network.in_period\[72\]\[2\]
+ sky130_fd_sc_hd__edfxtp_1
Xnetwork.in_period\[72\]\[3\]$_DFFE_PP_ clknet_leaf_19_clk_load
+ net459 _03312_ VSS VSS VDD VDD network.in_period\[72\]\[3\]
+ sky130_fd_sc_hd__edfxtp_1
Xnetwork.in_period\[73\]\[0\]$_DFFE_PP_ clknet_leaf_24_clk_load
+ net480 _03313_ VSS VSS VDD VDD network.in_period\[73\]\[0\]
+ sky130_fd_sc_hd__edfxtp_1
Xnetwork.in_period\[73\]\[1\]$_DFFE_PP_ clknet_leaf_24_clk_load
+ net474 _03313_ VSS VSS VDD VDD network.in_period\[73\]\[1\]
+ sky130_fd_sc_hd__edfxtp_1
Xnetwork.in_period\[73\]\[2\]$_DFFE_PP_ clknet_leaf_24_clk_load
+ net467 _03313_ VSS VSS VDD VDD network.in_period\[73\]\[2\]
+ sky130_fd_sc_hd__edfxtp_1
Xnetwork.in_period\[73\]\[3\]$_DFFE_PP_ clknet_leaf_19_clk_load
+ net459 _03313_ VSS VSS VDD VDD network.in_period\[73\]\[3\]
+ sky130_fd_sc_hd__edfxtp_1
Xnetwork.in_period\[74\]\[0\]$_DFFE_PP_ clknet_leaf_20_clk_load
+ net480 _03314_ VSS VSS VDD VDD network.in_period\[74\]\[0\]
+ sky130_fd_sc_hd__edfxtp_1
Xnetwork.in_period\[74\]\[1\]$_DFFE_PP_ clknet_leaf_20_clk_load
+ net471 _03314_ VSS VSS VDD VDD network.in_period\[74\]\[1\]
+ sky130_fd_sc_hd__edfxtp_1
Xnetwork.in_period\[74\]\[2\]$_DFFE_PP_ clknet_leaf_20_clk_load
+ net467 _03314_ VSS VSS VDD VDD network.in_period\[74\]\[2\]
+ sky130_fd_sc_hd__edfxtp_1
Xnetwork.in_period\[74\]\[3\]$_DFFE_PP_ clknet_leaf_20_clk_load
+ net459 _03314_ VSS VSS VDD VDD network.in_period\[74\]\[3\]
+ sky130_fd_sc_hd__edfxtp_1
Xnetwork.in_period\[75\]\[0\]$_DFFE_PP_ clknet_leaf_10_clk_load
+ net480 _03315_ VSS VSS VDD VDD network.in_period\[75\]\[0\]
+ sky130_fd_sc_hd__edfxtp_1
Xnetwork.in_period\[75\]\[1\]$_DFFE_PP_ clknet_leaf_10_clk_load
+ net474 _03315_ VSS VSS VDD VDD network.in_period\[75\]\[1\]
+ sky130_fd_sc_hd__edfxtp_1
Xnetwork.in_period\[75\]\[2\]$_DFFE_PP_ clknet_leaf_10_clk_load
+ net467 _03315_ VSS VSS VDD VDD network.in_period\[75\]\[2\]
+ sky130_fd_sc_hd__edfxtp_1
Xnetwork.in_period\[75\]\[3\]$_DFFE_PP_ clknet_leaf_10_clk_load
+ net459 _03315_ VSS VSS VDD VDD network.in_period\[75\]\[3\]
+ sky130_fd_sc_hd__edfxtp_1
Xnetwork.in_period\[76\]\[0\]$_DFFE_PP_ clknet_leaf_14_clk_load
+ net480 _03316_ VSS VSS VDD VDD network.in_period\[76\]\[0\]
+ sky130_fd_sc_hd__edfxtp_1
Xnetwork.in_period\[76\]\[1\]$_DFFE_PP_ clknet_leaf_108_clk_load
+ net473 _03316_ VSS VSS VDD VDD network.in_period\[76\]\[1\]
+ sky130_fd_sc_hd__edfxtp_1
Xnetwork.in_period\[76\]\[2\]$_DFFE_PP_ clknet_leaf_108_clk_load
+ net466 _03316_ VSS VSS VDD VDD network.in_period\[76\]\[2\]
+ sky130_fd_sc_hd__edfxtp_1
Xnetwork.in_period\[76\]\[3\]$_DFFE_PP_ clknet_leaf_108_clk_load
+ net458 _03316_ VSS VSS VDD VDD network.in_period\[76\]\[3\]
+ sky130_fd_sc_hd__edfxtp_1
Xnetwork.in_period\[77\]\[0\]$_DFFE_PP_ clknet_leaf_11_clk_load
+ net477 _03317_ VSS VSS VDD VDD network.in_period\[77\]\[0\]
+ sky130_fd_sc_hd__edfxtp_1
Xnetwork.in_period\[77\]\[1\]$_DFFE_PP_ clknet_leaf_11_clk_load
+ net470 _03317_ VSS VSS VDD VDD network.in_period\[77\]\[1\]
+ sky130_fd_sc_hd__edfxtp_1
Xnetwork.in_period\[77\]\[2\]$_DFFE_PP_ clknet_leaf_11_clk_load
+ net467 _03317_ VSS VSS VDD VDD network.in_period\[77\]\[2\]
+ sky130_fd_sc_hd__edfxtp_1
Xnetwork.in_period\[77\]\[3\]$_DFFE_PP_ clknet_leaf_11_clk_load
+ net456 _03317_ VSS VSS VDD VDD network.in_period\[77\]\[3\]
+ sky130_fd_sc_hd__edfxtp_1
Xnetwork.in_period\[78\]\[0\]$_DFFE_PP_ clknet_leaf_14_clk_load
+ net480 _03318_ VSS VSS VDD VDD network.in_period\[78\]\[0\]
+ sky130_fd_sc_hd__edfxtp_1
Xnetwork.in_period\[78\]\[1\]$_DFFE_PP_ clknet_leaf_14_clk_load
+ net473 _03318_ VSS VSS VDD VDD network.in_period\[78\]\[1\]
+ sky130_fd_sc_hd__edfxtp_1
Xnetwork.in_period\[78\]\[2\]$_DFFE_PP_ clknet_leaf_14_clk_load
+ net467 _03318_ VSS VSS VDD VDD network.in_period\[78\]\[2\]
+ sky130_fd_sc_hd__edfxtp_1
Xnetwork.in_period\[78\]\[3\]$_DFFE_PP_ clknet_leaf_14_clk_load
+ net459 _03318_ VSS VSS VDD VDD network.in_period\[78\]\[3\]
+ sky130_fd_sc_hd__edfxtp_1
Xnetwork.in_period\[79\]\[0\]$_DFFE_PP_ clknet_leaf_11_clk_load
+ net477 _03319_ VSS VSS VDD VDD network.in_period\[79\]\[0\]
+ sky130_fd_sc_hd__edfxtp_1
Xnetwork.in_period\[79\]\[1\]$_DFFE_PP_ clknet_leaf_11_clk_load
+ net470 _03319_ VSS VSS VDD VDD network.in_period\[79\]\[1\]
+ sky130_fd_sc_hd__edfxtp_1
Xnetwork.in_period\[79\]\[2\]$_DFFE_PP_ clknet_leaf_11_clk_load
+ net467 _03319_ VSS VSS VDD VDD network.in_period\[79\]\[2\]
+ sky130_fd_sc_hd__edfxtp_1
Xnetwork.in_period\[79\]\[3\]$_DFFE_PP_ clknet_leaf_11_clk_load
+ net456 _03319_ VSS VSS VDD VDD network.in_period\[79\]\[3\]
+ sky130_fd_sc_hd__edfxtp_1
Xnetwork.in_period\[7\]\[0\]$_DFFE_PP_ clknet_leaf_120_clk_load
+ net477 _03320_ VSS VSS VDD VDD network.in_period\[7\]\[0\]
+ sky130_fd_sc_hd__edfxtp_1
Xnetwork.in_period\[7\]\[1\]$_DFFE_PP_ clknet_leaf_120_clk_load
+ net470 _03320_ VSS VSS VDD VDD network.in_period\[7\]\[1\]
+ sky130_fd_sc_hd__edfxtp_1
Xnetwork.in_period\[7\]\[2\]$_DFFE_PP_ clknet_leaf_116_clk_load
+ net464 _03320_ VSS VSS VDD VDD network.in_period\[7\]\[2\]
+ sky130_fd_sc_hd__edfxtp_1
Xnetwork.in_period\[7\]\[3\]$_DFFE_PP_ clknet_leaf_116_clk_load
+ net456 _03320_ VSS VSS VDD VDD network.in_period\[7\]\[3\]
+ sky130_fd_sc_hd__edfxtp_1
Xnetwork.in_period\[80\]\[0\]$_DFFE_PP_ clknet_leaf_34_clk_load
+ net476 _03321_ VSS VSS VDD VDD network.in_period\[80\]\[0\]
+ sky130_fd_sc_hd__edfxtp_1
Xnetwork.in_period\[80\]\[1\]$_DFFE_PP_ clknet_leaf_34_clk_load
+ net474 _03321_ VSS VSS VDD VDD network.in_period\[80\]\[1\]
+ sky130_fd_sc_hd__edfxtp_1
Xnetwork.in_period\[80\]\[2\]$_DFFE_PP_ clknet_leaf_33_clk_load
+ net468 _03321_ VSS VSS VDD VDD network.in_period\[80\]\[2\]
+ sky130_fd_sc_hd__edfxtp_1
Xnetwork.in_period\[80\]\[3\]$_DFFE_PP_ clknet_leaf_33_clk_load
+ net460 _03321_ VSS VSS VDD VDD network.in_period\[80\]\[3\]
+ sky130_fd_sc_hd__edfxtp_1
Xnetwork.in_period\[81\]\[0\]$_DFFE_PP_ clknet_leaf_43_clk_load
+ net476 _03322_ VSS VSS VDD VDD network.in_period\[81\]\[0\]
+ sky130_fd_sc_hd__edfxtp_1
Xnetwork.in_period\[81\]\[1\]$_DFFE_PP_ clknet_leaf_43_clk_load
+ net474 _03322_ VSS VSS VDD VDD network.in_period\[81\]\[1\]
+ sky130_fd_sc_hd__edfxtp_1
Xnetwork.in_period\[81\]\[2\]$_DFFE_PP_ clknet_leaf_41_clk_load
+ net463 _03322_ VSS VSS VDD VDD network.in_period\[81\]\[2\]
+ sky130_fd_sc_hd__edfxtp_1
Xnetwork.in_period\[81\]\[3\]$_DFFE_PP_ clknet_leaf_41_clk_load
+ net461 _03322_ VSS VSS VDD VDD network.in_period\[81\]\[3\]
+ sky130_fd_sc_hd__edfxtp_1
Xnetwork.in_period\[82\]\[0\]$_DFFE_PP_ clknet_leaf_40_clk_load
+ net475 _03323_ VSS VSS VDD VDD network.in_period\[82\]\[0\]
+ sky130_fd_sc_hd__edfxtp_1
Xnetwork.in_period\[82\]\[1\]$_DFFE_PP_ clknet_leaf_40_clk_load
+ net474 _03323_ VSS VSS VDD VDD network.in_period\[82\]\[1\]
+ sky130_fd_sc_hd__edfxtp_1
Xnetwork.in_period\[82\]\[2\]$_DFFE_PP_ clknet_leaf_40_clk_load
+ net468 _03323_ VSS VSS VDD VDD network.in_period\[82\]\[2\]
+ sky130_fd_sc_hd__edfxtp_1
Xnetwork.in_period\[82\]\[3\]$_DFFE_PP_ clknet_leaf_40_clk_load
+ net462 _03323_ VSS VSS VDD VDD network.in_period\[82\]\[3\]
+ sky130_fd_sc_hd__edfxtp_1
Xnetwork.in_period\[83\]\[0\]$_DFFE_PP_ clknet_leaf_41_clk_load
+ net475 _03324_ VSS VSS VDD VDD network.in_period\[83\]\[0\]
+ sky130_fd_sc_hd__edfxtp_1
Xnetwork.in_period\[83\]\[1\]$_DFFE_PP_ clknet_leaf_41_clk_load
+ net469 _03324_ VSS VSS VDD VDD network.in_period\[83\]\[1\]
+ sky130_fd_sc_hd__edfxtp_1
Xnetwork.in_period\[83\]\[2\]$_DFFE_PP_ clknet_leaf_41_clk_load
+ net463 _03324_ VSS VSS VDD VDD network.in_period\[83\]\[2\]
+ sky130_fd_sc_hd__edfxtp_1
Xnetwork.in_period\[83\]\[3\]$_DFFE_PP_ clknet_leaf_41_clk_load
+ net461 _03324_ VSS VSS VDD VDD network.in_period\[83\]\[3\]
+ sky130_fd_sc_hd__edfxtp_1
Xnetwork.in_period\[84\]\[0\]$_DFFE_PP_ clknet_leaf_39_clk_load
+ net476 _03325_ VSS VSS VDD VDD network.in_period\[84\]\[0\]
+ sky130_fd_sc_hd__edfxtp_1
Xnetwork.in_period\[84\]\[1\]$_DFFE_PP_ clknet_leaf_39_clk_load
+ net474 _03325_ VSS VSS VDD VDD network.in_period\[84\]\[1\]
+ sky130_fd_sc_hd__edfxtp_1
Xnetwork.in_period\[84\]\[2\]$_DFFE_PP_ clknet_leaf_39_clk_load
+ net468 _03325_ VSS VSS VDD VDD network.in_period\[84\]\[2\]
+ sky130_fd_sc_hd__edfxtp_1
Xnetwork.in_period\[84\]\[3\]$_DFFE_PP_ clknet_leaf_39_clk_load
+ net462 _03325_ VSS VSS VDD VDD network.in_period\[84\]\[3\]
+ sky130_fd_sc_hd__edfxtp_1
Xnetwork.in_period\[85\]\[0\]$_DFFE_PP_ clknet_leaf_39_clk_load
+ net475 _03326_ VSS VSS VDD VDD network.in_period\[85\]\[0\]
+ sky130_fd_sc_hd__edfxtp_1
Xnetwork.in_period\[85\]\[1\]$_DFFE_PP_ clknet_leaf_40_clk_load
+ net474 _03326_ VSS VSS VDD VDD network.in_period\[85\]\[1\]
+ sky130_fd_sc_hd__edfxtp_1
Xnetwork.in_period\[85\]\[2\]$_DFFE_PP_ clknet_leaf_40_clk_load
+ net468 _03326_ VSS VSS VDD VDD network.in_period\[85\]\[2\]
+ sky130_fd_sc_hd__edfxtp_1
Xnetwork.in_period\[85\]\[3\]$_DFFE_PP_ clknet_leaf_40_clk_load
+ net462 _03326_ VSS VSS VDD VDD network.in_period\[85\]\[3\]
+ sky130_fd_sc_hd__edfxtp_1
Xnetwork.in_period\[86\]\[0\]$_DFFE_PP_ clknet_leaf_39_clk_load
+ net475 _03327_ VSS VSS VDD VDD network.in_period\[86\]\[0\]
+ sky130_fd_sc_hd__edfxtp_1
Xnetwork.in_period\[86\]\[1\]$_DFFE_PP_ clknet_leaf_39_clk_load
+ net474 _03327_ VSS VSS VDD VDD network.in_period\[86\]\[1\]
+ sky130_fd_sc_hd__edfxtp_1
Xnetwork.in_period\[86\]\[2\]$_DFFE_PP_ clknet_leaf_41_clk_load
+ net468 _03327_ VSS VSS VDD VDD network.in_period\[86\]\[2\]
+ sky130_fd_sc_hd__edfxtp_1
Xnetwork.in_period\[86\]\[3\]$_DFFE_PP_ clknet_leaf_39_clk_load
+ net462 _03327_ VSS VSS VDD VDD network.in_period\[86\]\[3\]
+ sky130_fd_sc_hd__edfxtp_1
Xnetwork.in_period\[87\]\[0\]$_DFFE_PP_ clknet_leaf_38_clk_load
+ net476 _03328_ VSS VSS VDD VDD network.in_period\[87\]\[0\]
+ sky130_fd_sc_hd__edfxtp_1
Xnetwork.in_period\[87\]\[1\]$_DFFE_PP_ clknet_leaf_38_clk_load
+ net474 _03328_ VSS VSS VDD VDD network.in_period\[87\]\[1\]
+ sky130_fd_sc_hd__edfxtp_1
Xnetwork.in_period\[87\]\[2\]$_DFFE_PP_ clknet_leaf_38_clk_load
+ net468 _03328_ VSS VSS VDD VDD network.in_period\[87\]\[2\]
+ sky130_fd_sc_hd__edfxtp_1
Xnetwork.in_period\[87\]\[3\]$_DFFE_PP_ clknet_leaf_37_clk_load
+ net462 _03328_ VSS VSS VDD VDD network.in_period\[87\]\[3\]
+ sky130_fd_sc_hd__edfxtp_1
Xnetwork.in_period\[88\]\[0\]$_DFFE_PP_ clknet_leaf_33_clk_load
+ net481 _03329_ VSS VSS VDD VDD network.in_period\[88\]\[0\]
+ sky130_fd_sc_hd__edfxtp_1
Xnetwork.in_period\[88\]\[1\]$_DFFE_PP_ clknet_leaf_33_clk_load
+ net474 _03329_ VSS VSS VDD VDD network.in_period\[88\]\[1\]
+ sky130_fd_sc_hd__edfxtp_1
Xnetwork.in_period\[88\]\[2\]$_DFFE_PP_ clknet_leaf_34_clk_load
+ net468 _03329_ VSS VSS VDD VDD network.in_period\[88\]\[2\]
+ sky130_fd_sc_hd__edfxtp_1
Xnetwork.in_period\[88\]\[3\]$_DFFE_PP_ clknet_leaf_34_clk_load
+ net462 _03329_ VSS VSS VDD VDD network.in_period\[88\]\[3\]
+ sky130_fd_sc_hd__edfxtp_1
Xnetwork.in_period\[89\]\[0\]$_DFFE_PP_ clknet_leaf_38_clk_load
+ net476 _03330_ VSS VSS VDD VDD network.in_period\[89\]\[0\]
+ sky130_fd_sc_hd__edfxtp_1
Xnetwork.in_period\[89\]\[1\]$_DFFE_PP_ clknet_leaf_38_clk_load
+ net474 _03330_ VSS VSS VDD VDD network.in_period\[89\]\[1\]
+ sky130_fd_sc_hd__edfxtp_1
Xnetwork.in_period\[89\]\[2\]$_DFFE_PP_ clknet_leaf_38_clk_load
+ net468 _03330_ VSS VSS VDD VDD network.in_period\[89\]\[2\]
+ sky130_fd_sc_hd__edfxtp_1
Xnetwork.in_period\[89\]\[3\]$_DFFE_PP_ clknet_leaf_38_clk_load
+ net462 _03330_ VSS VSS VDD VDD network.in_period\[89\]\[3\]
+ sky130_fd_sc_hd__edfxtp_1
Xnetwork.in_period\[8\]\[0\]$_DFFE_PP_ clknet_leaf_116_clk_load
+ net480 _03331_ VSS VSS VDD VDD network.in_period\[8\]\[0\]
+ sky130_fd_sc_hd__edfxtp_1
Xnetwork.in_period\[8\]\[1\]$_DFFE_PP_ clknet_leaf_116_clk_load
+ net473 _03331_ VSS VSS VDD VDD network.in_period\[8\]\[1\]
+ sky130_fd_sc_hd__edfxtp_1
Xnetwork.in_period\[8\]\[2\]$_DFFE_PP_ clknet_leaf_116_clk_load
+ net467 _03331_ VSS VSS VDD VDD network.in_period\[8\]\[2\]
+ sky130_fd_sc_hd__edfxtp_1
Xnetwork.in_period\[8\]\[3\]$_DFFE_PP_ clknet_leaf_116_clk_load
+ net459 _03331_ VSS VSS VDD VDD network.in_period\[8\]\[3\]
+ sky130_fd_sc_hd__edfxtp_1
Xnetwork.in_period\[90\]\[0\]$_DFFE_PP_ clknet_leaf_33_clk_load
+ net476 _03332_ VSS VSS VDD VDD network.in_period\[90\]\[0\]
+ sky130_fd_sc_hd__edfxtp_1
Xnetwork.in_period\[90\]\[1\]$_DFFE_PP_ clknet_leaf_33_clk_load
+ net474 _03332_ VSS VSS VDD VDD network.in_period\[90\]\[1\]
+ sky130_fd_sc_hd__edfxtp_1
Xnetwork.in_period\[90\]\[2\]$_DFFE_PP_ clknet_leaf_33_clk_load
+ net468 _03332_ VSS VSS VDD VDD network.in_period\[90\]\[2\]
+ sky130_fd_sc_hd__edfxtp_1
Xnetwork.in_period\[90\]\[3\]$_DFFE_PP_ clknet_leaf_33_clk_load
+ net462 _03332_ VSS VSS VDD VDD network.in_period\[90\]\[3\]
+ sky130_fd_sc_hd__edfxtp_1
Xnetwork.in_period\[91\]\[0\]$_DFFE_PP_ clknet_leaf_37_clk_load
+ net476 _03333_ VSS VSS VDD VDD network.in_period\[91\]\[0\]
+ sky130_fd_sc_hd__edfxtp_1
Xnetwork.in_period\[91\]\[1\]$_DFFE_PP_ clknet_leaf_37_clk_load
+ net474 _03333_ VSS VSS VDD VDD network.in_period\[91\]\[1\]
+ sky130_fd_sc_hd__edfxtp_1
Xnetwork.in_period\[91\]\[2\]$_DFFE_PP_ clknet_leaf_37_clk_load
+ net468 _03333_ VSS VSS VDD VDD network.in_period\[91\]\[2\]
+ sky130_fd_sc_hd__edfxtp_1
Xnetwork.in_period\[91\]\[3\]$_DFFE_PP_ clknet_leaf_37_clk_load
+ net462 _03333_ VSS VSS VDD VDD network.in_period\[91\]\[3\]
+ sky130_fd_sc_hd__edfxtp_1
Xnetwork.in_period\[92\]\[0\]$_DFFE_PP_ clknet_leaf_22_clk_load
+ net480 _03334_ VSS VSS VDD VDD network.in_period\[92\]\[0\]
+ sky130_fd_sc_hd__edfxtp_1
Xnetwork.in_period\[92\]\[1\]$_DFFE_PP_ clknet_leaf_30_clk_load
+ net473 _03334_ VSS VSS VDD VDD network.in_period\[92\]\[1\]
+ sky130_fd_sc_hd__edfxtp_1
Xnetwork.in_period\[92\]\[2\]$_DFFE_PP_ clknet_leaf_35_clk_load
+ net468 _03334_ VSS VSS VDD VDD network.in_period\[92\]\[2\]
+ sky130_fd_sc_hd__edfxtp_1
Xnetwork.in_period\[92\]\[3\]$_DFFE_PP_ clknet_leaf_30_clk_load
+ net459 _03334_ VSS VSS VDD VDD network.in_period\[92\]\[3\]
+ sky130_fd_sc_hd__edfxtp_1
Xnetwork.in_period\[93\]\[0\]$_DFFE_PP_ clknet_leaf_21_clk_load
+ net480 _03335_ VSS VSS VDD VDD network.in_period\[93\]\[0\]
+ sky130_fd_sc_hd__edfxtp_1
Xnetwork.in_period\[93\]\[1\]$_DFFE_PP_ clknet_leaf_21_clk_load
+ net473 _03335_ VSS VSS VDD VDD network.in_period\[93\]\[1\]
+ sky130_fd_sc_hd__edfxtp_1
Xnetwork.in_period\[93\]\[2\]$_DFFE_PP_ clknet_leaf_21_clk_load
+ net467 _03335_ VSS VSS VDD VDD network.in_period\[93\]\[2\]
+ sky130_fd_sc_hd__edfxtp_1
Xnetwork.in_period\[93\]\[3\]$_DFFE_PP_ clknet_leaf_21_clk_load
+ net459 _03335_ VSS VSS VDD VDD network.in_period\[93\]\[3\]
+ sky130_fd_sc_hd__edfxtp_1
Xnetwork.in_period\[94\]\[0\]$_DFFE_PP_ clknet_leaf_36_clk_load
+ net476 _03336_ VSS VSS VDD VDD network.in_period\[94\]\[0\]
+ sky130_fd_sc_hd__edfxtp_1
Xnetwork.in_period\[94\]\[1\]$_DFFE_PP_ clknet_leaf_36_clk_load
+ net474 _03336_ VSS VSS VDD VDD network.in_period\[94\]\[1\]
+ sky130_fd_sc_hd__edfxtp_1
Xnetwork.in_period\[94\]\[2\]$_DFFE_PP_ clknet_leaf_44_clk_load
+ net468 _03336_ VSS VSS VDD VDD network.in_period\[94\]\[2\]
+ sky130_fd_sc_hd__edfxtp_1
Xnetwork.in_period\[94\]\[3\]$_DFFE_PP_ clknet_leaf_44_clk_load
+ net460 _03336_ VSS VSS VDD VDD network.in_period\[94\]\[3\]
+ sky130_fd_sc_hd__edfxtp_1
Xnetwork.in_period\[95\]\[0\]$_DFFE_PP_ clknet_leaf_35_clk_load
+ net481 _03337_ VSS VSS VDD VDD network.in_period\[95\]\[0\]
+ sky130_fd_sc_hd__edfxtp_1
Xnetwork.in_period\[95\]\[1\]$_DFFE_PP_ clknet_leaf_35_clk_load
+ net474 _03337_ VSS VSS VDD VDD network.in_period\[95\]\[1\]
+ sky130_fd_sc_hd__edfxtp_1
Xnetwork.in_period\[95\]\[2\]$_DFFE_PP_ clknet_leaf_35_clk_load
+ net468 _03337_ VSS VSS VDD VDD network.in_period\[95\]\[2\]
+ sky130_fd_sc_hd__edfxtp_1
Xnetwork.in_period\[95\]\[3\]$_DFFE_PP_ clknet_leaf_35_clk_load
+ net460 _03337_ VSS VSS VDD VDD network.in_period\[95\]\[3\]
+ sky130_fd_sc_hd__edfxtp_1
Xnetwork.in_period\[96\]\[0\]$_DFFE_PP_ clknet_leaf_30_clk_load
+ net481 _03338_ VSS VSS VDD VDD network.in_period\[96\]\[0\]
+ sky130_fd_sc_hd__edfxtp_1
Xnetwork.in_period\[96\]\[1\]$_DFFE_PP_ clknet_leaf_30_clk_load
+ net474 _03338_ VSS VSS VDD VDD network.in_period\[96\]\[1\]
+ sky130_fd_sc_hd__edfxtp_1
Xnetwork.in_period\[96\]\[2\]$_DFFE_PP_ clknet_leaf_31_clk_load
+ net468 _03338_ VSS VSS VDD VDD network.in_period\[96\]\[2\]
+ sky130_fd_sc_hd__edfxtp_1
Xnetwork.in_period\[96\]\[3\]$_DFFE_PP_ clknet_leaf_30_clk_load
+ net459 _03338_ VSS VSS VDD VDD network.in_period\[96\]\[3\]
+ sky130_fd_sc_hd__edfxtp_1
Xnetwork.in_period\[97\]\[0\]$_DFFE_PP_ clknet_leaf_44_clk_load
+ net480 _03339_ VSS VSS VDD VDD network.in_period\[97\]\[0\]
+ sky130_fd_sc_hd__edfxtp_1
Xnetwork.in_period\[97\]\[1\]$_DFFE_PP_ clknet_leaf_22_clk_load
+ net473 _03339_ VSS VSS VDD VDD network.in_period\[97\]\[1\]
+ sky130_fd_sc_hd__edfxtp_1
Xnetwork.in_period\[97\]\[2\]$_DFFE_PP_ clknet_leaf_22_clk_load
+ net468 _03339_ VSS VSS VDD VDD network.in_period\[97\]\[2\]
+ sky130_fd_sc_hd__edfxtp_1
Xnetwork.in_period\[97\]\[3\]$_DFFE_PP_ clknet_leaf_22_clk_load
+ net459 _03339_ VSS VSS VDD VDD network.in_period\[97\]\[3\]
+ sky130_fd_sc_hd__edfxtp_1
Xnetwork.in_period\[98\]\[0\]$_DFFE_PP_ clknet_leaf_35_clk_load
+ net481 _03340_ VSS VSS VDD VDD network.in_period\[98\]\[0\]
+ sky130_fd_sc_hd__edfxtp_1
Xnetwork.in_period\[98\]\[1\]$_DFFE_PP_ clknet_leaf_35_clk_load
+ net474 _03340_ VSS VSS VDD VDD network.in_period\[98\]\[1\]
+ sky130_fd_sc_hd__edfxtp_1
Xnetwork.in_period\[98\]\[2\]$_DFFE_PP_ clknet_leaf_35_clk_load
+ net468 _03340_ VSS VSS VDD VDD network.in_period\[98\]\[2\]
+ sky130_fd_sc_hd__edfxtp_1
Xnetwork.in_period\[98\]\[3\]$_DFFE_PP_ clknet_leaf_34_clk_load
+ net459 _03340_ VSS VSS VDD VDD network.in_period\[98\]\[3\]
+ sky130_fd_sc_hd__edfxtp_1
Xnetwork.in_period\[99\]\[0\]$_DFFE_PP_ clknet_leaf_31_clk_load
+ net481 _03341_ VSS VSS VDD VDD network.in_period\[99\]\[0\]
+ sky130_fd_sc_hd__edfxtp_1
Xnetwork.in_period\[99\]\[1\]$_DFFE_PP_ clknet_leaf_31_clk_load
+ net470 _03341_ VSS VSS VDD VDD network.in_period\[99\]\[1\]
+ sky130_fd_sc_hd__edfxtp_1
Xnetwork.in_period\[99\]\[2\]$_DFFE_PP_ clknet_leaf_34_clk_load
+ net464 _03341_ VSS VSS VDD VDD network.in_period\[99\]\[2\]
+ sky130_fd_sc_hd__edfxtp_1
Xnetwork.in_period\[99\]\[3\]$_DFFE_PP_ clknet_leaf_31_clk_load
+ net462 _03341_ VSS VSS VDD VDD network.in_period\[99\]\[3\]
+ sky130_fd_sc_hd__edfxtp_1
Xnetwork.in_period\[9\]\[0\]$_DFFE_PP_ clknet_leaf_117_clk_load
+ net480 _03342_ VSS VSS VDD VDD network.in_period\[9\]\[0\]
+ sky130_fd_sc_hd__edfxtp_1
Xnetwork.in_period\[9\]\[1\]$_DFFE_PP_ clknet_leaf_117_clk_load
+ net473 _03342_ VSS VSS VDD VDD network.in_period\[9\]\[1\]
+ sky130_fd_sc_hd__edfxtp_1
Xnetwork.in_period\[9\]\[2\]$_DFFE_PP_ clknet_leaf_117_clk_load
+ net467 _03342_ VSS VSS VDD VDD network.in_period\[9\]\[2\]
+ sky130_fd_sc_hd__edfxtp_1
Xnetwork.in_period\[9\]\[3\]$_DFFE_PP_ clknet_leaf_117_clk_load
+ net459 _03342_ VSS VSS VDD VDD network.in_period\[9\]\[3\]
+ sky130_fd_sc_hd__edfxtp_1
Xnetwork.neuron_hid0.IF0.membrane_potential\[0\]$_SDFF_PP0_
+ clknet_leaf_89_clk_net _01721_ VSS VSS VDD VDD network.neuron_hid0.IF0.membrane_potential\[0\]
+ sky130_fd_sc_hd__dfxtp_1
Xnetwork.neuron_hid0.IF0.membrane_potential\[10\]$_SDFF_PP0_
+ clknet_leaf_88_clk_net _01906_ VSS VSS VDD VDD network.neuron_hid0.IF0.membrane_potential\[10\]
+ sky130_fd_sc_hd__dfxtp_1
Xnetwork.neuron_hid0.IF0.membrane_potential\[1\]$_SDFF_PP0_
+ clknet_leaf_89_clk_net _01720_ VSS VSS VDD VDD network.neuron_hid0.IF0.membrane_potential\[1\]
+ sky130_fd_sc_hd__dfxtp_1
Xnetwork.neuron_hid0.IF0.membrane_potential\[2\]$_SDFF_PP0_
+ clknet_leaf_88_clk_net _01719_ VSS VSS VDD VDD network.neuron_hid0.IF0.membrane_potential\[2\]
+ sky130_fd_sc_hd__dfxtp_1
Xnetwork.neuron_hid0.IF0.membrane_potential\[3\]$_SDFF_PP0_
+ clknet_leaf_89_clk_net _01718_ VSS VSS VDD VDD network.neuron_hid0.IF0.membrane_potential\[3\]
+ sky130_fd_sc_hd__dfxtp_1
Xnetwork.neuron_hid0.IF0.membrane_potential\[4\]$_SDFF_PP0_
+ clknet_leaf_88_clk_net _01717_ VSS VSS VDD VDD network.neuron_hid0.IF0.membrane_potential\[4\]
+ sky130_fd_sc_hd__dfxtp_1
Xnetwork.neuron_hid0.IF0.membrane_potential\[5\]$_SDFF_PP0_
+ clknet_leaf_88_clk_net _01716_ VSS VSS VDD VDD network.neuron_hid0.IF0.membrane_potential\[5\]
+ sky130_fd_sc_hd__dfxtp_1
Xnetwork.neuron_hid0.IF0.membrane_potential\[6\]$_SDFF_PP0_
+ clknet_leaf_88_clk_net _01715_ VSS VSS VDD VDD network.neuron_hid0.IF0.membrane_potential\[6\]
+ sky130_fd_sc_hd__dfxtp_1
Xnetwork.neuron_hid0.IF0.membrane_potential\[7\]$_SDFF_PP0_
+ clknet_leaf_88_clk_net _01714_ VSS VSS VDD VDD network.neuron_hid0.IF0.membrane_potential\[7\]
+ sky130_fd_sc_hd__dfxtp_1
Xnetwork.neuron_hid0.IF0.membrane_potential\[8\]$_SDFF_PP0_
+ clknet_leaf_88_clk_net _01713_ VSS VSS VDD VDD network.neuron_hid0.IF0.membrane_potential\[8\]
+ sky130_fd_sc_hd__dfxtp_1
Xnetwork.neuron_hid0.IF0.membrane_potential\[9\]$_SDFF_PP0_
+ clknet_leaf_88_clk_net _01712_ VSS VSS VDD VDD network.neuron_hid0.IF0.membrane_potential\[9\]
+ sky130_fd_sc_hd__dfxtp_1
Xnetwork.neuron_hid0.IF0.ref_counter\[0\]$_SDFFE_PP0P_ clknet_leaf_90_clk_net
+ _01711_ VSS VSS VDD VDD network.neuron_hid0.IF0.ref_counter\[0\]
+ sky130_fd_sc_hd__dfxtp_1
Xnetwork.neuron_hid0.IF0.ref_counter\[1\]$_SDFFE_PP0P_ clknet_leaf_90_clk_net
+ _01904_ VSS VSS VDD VDD network.neuron_hid0.IF0.ref_counter\[1\]
+ sky130_fd_sc_hd__dfxtp_1
Xnetwork.neuron_hid0.IF_in\[0\]$_SDFF_PP0_ clknet_leaf_89_clk_net
+ _01548_ VSS VSS VDD VDD network.neuron_hid0.IF0.input_current\[0\]
+ sky130_fd_sc_hd__dfxtp_1
Xnetwork.neuron_hid0.IF_in\[1\]$_SDFF_PP0_ clknet_leaf_89_clk_net
+ _01547_ VSS VSS VDD VDD network.neuron_hid0.IF0.input_current\[1\]
+ sky130_fd_sc_hd__dfxtp_1
Xnetwork.neuron_hid0.IF_in\[2\]$_SDFF_PP0_ clknet_leaf_89_clk_net
+ _01546_ VSS VSS VDD VDD network.neuron_hid0.IF0.input_current\[2\]
+ sky130_fd_sc_hd__dfxtp_1
Xnetwork.neuron_hid0.IF_in\[3\]$_SDFF_PP0_ clknet_leaf_90_clk_net
+ _01540_ VSS VSS VDD VDD network.neuron_hid0.IF0.input_current\[3\]
+ sky130_fd_sc_hd__dfxtp_1
Xnetwork.neuron_hid0.IF_in\[4\]$_SDFF_PP0_ clknet_leaf_88_clk_net
+ _01767_ VSS VSS VDD VDD network.neuron_hid0.IF0.input_current\[4\]
+ sky130_fd_sc_hd__dfxtp_1
Xnetwork.neuron_hid0.ROM_address\[0\]$_SDFF_PP0_ clknet_leaf_100_clk_net
+ _01710_ VSS VSS VDD VDD network.neuron_hid0.ROM0.address\[0\]
+ sky130_fd_sc_hd__dfxtp_1
Xnetwork.neuron_hid0.ROM_address\[1\]$_SDFF_PP0_ clknet_leaf_75_clk_net
+ _01709_ VSS VSS VDD VDD network.neuron_hid0.ROM0.address\[1\]
+ sky130_fd_sc_hd__dfxtp_2
Xnetwork.neuron_hid0.ROM_address\[2\]$_SDFF_PP0_ clknet_leaf_75_clk_net
+ _01708_ VSS VSS VDD VDD network.neuron_hid0.ROM0.address\[2\]
+ sky130_fd_sc_hd__dfxtp_1
Xnetwork.neuron_hid0.ROM_address\[3\]$_SDFF_PP0_ clknet_leaf_101_clk_net
+ _01707_ VSS VSS VDD VDD network.neuron_hid0.ROM0.address\[3\]
+ sky130_fd_sc_hd__dfxtp_1
Xnetwork.neuron_hid0.ROM_address\[4\]$_SDFF_PP0_ clknet_leaf_101_clk_net
+ _01706_ VSS VSS VDD VDD network.neuron_hid0.ROM0.address\[4\]
+ sky130_fd_sc_hd__dfxtp_1
Xnetwork.neuron_hid0.ROM_address\[5\]$_SDFF_PP0_ clknet_leaf_70_clk_net
+ _01705_ VSS VSS VDD VDD network.neuron_hid0.ROM0.address\[5\]
+ sky130_fd_sc_hd__dfxtp_1
Xnetwork.neuron_hid0.ROM_address\[6\]$_SDFF_PP0_ clknet_leaf_104_clk_net
+ _01704_ VSS VSS VDD VDD network.neuron_hid0.ROM0.address\[6\]
+ sky130_fd_sc_hd__dfxtp_1
Xnetwork.neuron_hid0.ROM_address\[7\]$_SDFF_PP0_ clknet_leaf_102_clk_net
+ _01909_ VSS VSS VDD VDD network.neuron_hid0.ROM0.address\[7\]
+ sky130_fd_sc_hd__dfxtp_1
Xnetwork.neuron_hid0.enable$_SDFF_PP0_ clknet_leaf_101_clk_net
+ _01911_ VSS VSS VDD VDD network.neuron_hid0.ROM0.read_en sky130_fd_sc_hd__dfxtp_1
Xnetwork.neuron_hid0.spike_out$_SDFFE_PP0P_ clknet_leaf_117_clk_net
+ _01908_ VSS VSS VDD VDD network.hid_spk0 sky130_fd_sc_hd__dfxtp_1
Xnetwork.neuron_hid1.IF0.membrane_potential\[0\]$_SDFF_PP0_
+ clknet_leaf_91_clk_net _01703_ VSS VSS VDD VDD network.neuron_hid1.IF0.membrane_potential\[0\]
+ sky130_fd_sc_hd__dfxtp_1
Xnetwork.neuron_hid1.IF0.membrane_potential\[10\]$_SDFF_PP0_
+ clknet_leaf_91_clk_net _01913_ VSS VSS VDD VDD network.neuron_hid1.IF0.membrane_potential\[10\]
+ sky130_fd_sc_hd__dfxtp_1
Xnetwork.neuron_hid1.IF0.membrane_potential\[1\]$_SDFF_PP0_
+ clknet_leaf_91_clk_net _01702_ VSS VSS VDD VDD network.neuron_hid1.IF0.membrane_potential\[1\]
+ sky130_fd_sc_hd__dfxtp_1
Xnetwork.neuron_hid1.IF0.membrane_potential\[2\]$_SDFF_PP0_
+ clknet_leaf_90_clk_net _01701_ VSS VSS VDD VDD network.neuron_hid1.IF0.membrane_potential\[2\]
+ sky130_fd_sc_hd__dfxtp_1
Xnetwork.neuron_hid1.IF0.membrane_potential\[3\]$_SDFF_PP0_
+ clknet_leaf_90_clk_net _01700_ VSS VSS VDD VDD network.neuron_hid1.IF0.membrane_potential\[3\]
+ sky130_fd_sc_hd__dfxtp_1
Xnetwork.neuron_hid1.IF0.membrane_potential\[4\]$_SDFF_PP0_
+ clknet_leaf_90_clk_net _01699_ VSS VSS VDD VDD network.neuron_hid1.IF0.membrane_potential\[4\]
+ sky130_fd_sc_hd__dfxtp_1
Xnetwork.neuron_hid1.IF0.membrane_potential\[5\]$_SDFF_PP0_
+ clknet_leaf_90_clk_net _01698_ VSS VSS VDD VDD network.neuron_hid1.IF0.membrane_potential\[5\]
+ sky130_fd_sc_hd__dfxtp_1
Xnetwork.neuron_hid1.IF0.membrane_potential\[6\]$_SDFF_PP0_
+ clknet_leaf_90_clk_net _01697_ VSS VSS VDD VDD network.neuron_hid1.IF0.membrane_potential\[6\]
+ sky130_fd_sc_hd__dfxtp_1
Xnetwork.neuron_hid1.IF0.membrane_potential\[7\]$_SDFF_PP0_
+ clknet_leaf_91_clk_net _01696_ VSS VSS VDD VDD network.neuron_hid1.IF0.membrane_potential\[7\]
+ sky130_fd_sc_hd__dfxtp_1
Xnetwork.neuron_hid1.IF0.membrane_potential\[8\]$_SDFF_PP0_
+ clknet_leaf_91_clk_net _01695_ VSS VSS VDD VDD network.neuron_hid1.IF0.membrane_potential\[8\]
+ sky130_fd_sc_hd__dfxtp_1
Xnetwork.neuron_hid1.IF0.membrane_potential\[9\]$_SDFF_PP0_
+ clknet_leaf_91_clk_net _01694_ VSS VSS VDD VDD network.neuron_hid1.IF0.membrane_potential\[9\]
+ sky130_fd_sc_hd__dfxtp_1
Xnetwork.neuron_hid1.IF0.ref_counter\[0\]$_SDFFE_PP0P_ clknet_leaf_91_clk_net
+ _01693_ VSS VSS VDD VDD network.neuron_hid1.IF0.ref_counter\[0\]
+ sky130_fd_sc_hd__dfxtp_1
Xnetwork.neuron_hid1.IF0.ref_counter\[1\]$_SDFFE_PP0P_ clknet_leaf_91_clk_net
+ _01912_ VSS VSS VDD VDD network.neuron_hid1.IF0.ref_counter\[1\]
+ sky130_fd_sc_hd__dfxtp_1
Xnetwork.neuron_hid1.IF_in\[0\]$_SDFF_PP0_ clknet_leaf_91_clk_net
+ _01506_ VSS VSS VDD VDD network.neuron_hid1.IF0.input_current\[0\]
+ sky130_fd_sc_hd__dfxtp_1
Xnetwork.neuron_hid1.IF_in\[1\]$_SDFF_PP0_ clknet_leaf_90_clk_net
+ _01508_ VSS VSS VDD VDD network.neuron_hid1.IF0.input_current\[1\]
+ sky130_fd_sc_hd__dfxtp_1
Xnetwork.neuron_hid1.IF_in\[2\]$_SDFF_PP0_ clknet_leaf_90_clk_net
+ _01507_ VSS VSS VDD VDD network.neuron_hid1.IF0.input_current\[2\]
+ sky130_fd_sc_hd__dfxtp_1
Xnetwork.neuron_hid1.IF_in\[3\]$_SDFF_PP0_ clknet_leaf_89_clk_net
+ _01505_ VSS VSS VDD VDD network.neuron_hid1.IF0.input_current\[3\]
+ sky130_fd_sc_hd__dfxtp_1
Xnetwork.neuron_hid1.IF_in\[4\]$_SDFF_PP0_ clknet_leaf_90_clk_net
+ _01764_ VSS VSS VDD VDD network.neuron_hid1.IF0.input_current\[4\]
+ sky130_fd_sc_hd__dfxtp_1
Xnetwork.neuron_hid1.spike_out$_SDFFE_PP0P_ clknet_leaf_117_clk_net
+ _01915_ VSS VSS VDD VDD network.hid_spk1 sky130_fd_sc_hd__dfxtp_1
Xnetwork.neuron_hid2.IF0.membrane_potential\[0\]$_SDFF_PP0_
+ clknet_leaf_116_clk_net _01692_ VSS VSS VDD VDD network.neuron_hid2.IF0.membrane_potential\[0\]
+ sky130_fd_sc_hd__dfxtp_1
Xnetwork.neuron_hid2.IF0.membrane_potential\[10\]$_SDFF_PP0_
+ clknet_leaf_117_clk_net _01917_ VSS VSS VDD VDD network.neuron_hid2.IF0.membrane_potential\[10\]
+ sky130_fd_sc_hd__dfxtp_1
Xnetwork.neuron_hid2.IF0.membrane_potential\[1\]$_SDFF_PP0_
+ clknet_leaf_118_clk_net _01691_ VSS VSS VDD VDD network.neuron_hid2.IF0.membrane_potential\[1\]
+ sky130_fd_sc_hd__dfxtp_1
Xnetwork.neuron_hid2.IF0.membrane_potential\[2\]$_SDFF_PP0_
+ clknet_leaf_116_clk_net _01690_ VSS VSS VDD VDD network.neuron_hid2.IF0.membrane_potential\[2\]
+ sky130_fd_sc_hd__dfxtp_1
Xnetwork.neuron_hid2.IF0.membrane_potential\[3\]$_SDFF_PP0_
+ clknet_leaf_116_clk_net _01689_ VSS VSS VDD VDD network.neuron_hid2.IF0.membrane_potential\[3\]
+ sky130_fd_sc_hd__dfxtp_1
Xnetwork.neuron_hid2.IF0.membrane_potential\[4\]$_SDFF_PP0_
+ clknet_leaf_116_clk_net _01688_ VSS VSS VDD VDD network.neuron_hid2.IF0.membrane_potential\[4\]
+ sky130_fd_sc_hd__dfxtp_1
Xnetwork.neuron_hid2.IF0.membrane_potential\[5\]$_SDFF_PP0_
+ clknet_leaf_116_clk_net _01687_ VSS VSS VDD VDD network.neuron_hid2.IF0.membrane_potential\[5\]
+ sky130_fd_sc_hd__dfxtp_1
Xnetwork.neuron_hid2.IF0.membrane_potential\[6\]$_SDFF_PP0_
+ clknet_leaf_118_clk_net _01686_ VSS VSS VDD VDD network.neuron_hid2.IF0.membrane_potential\[6\]
+ sky130_fd_sc_hd__dfxtp_1
Xnetwork.neuron_hid2.IF0.membrane_potential\[7\]$_SDFF_PP0_
+ clknet_leaf_118_clk_net _01685_ VSS VSS VDD VDD network.neuron_hid2.IF0.membrane_potential\[7\]
+ sky130_fd_sc_hd__dfxtp_1
Xnetwork.neuron_hid2.IF0.membrane_potential\[8\]$_SDFF_PP0_
+ clknet_leaf_116_clk_net _01684_ VSS VSS VDD VDD network.neuron_hid2.IF0.membrane_potential\[8\]
+ sky130_fd_sc_hd__dfxtp_1
Xnetwork.neuron_hid2.IF0.membrane_potential\[9\]$_SDFF_PP0_
+ clknet_leaf_116_clk_net _01683_ VSS VSS VDD VDD network.neuron_hid2.IF0.membrane_potential\[9\]
+ sky130_fd_sc_hd__dfxtp_1
Xnetwork.neuron_hid2.IF0.ref_counter\[0\]$_SDFFE_PP0P_ clknet_leaf_117_clk_net
+ _01682_ VSS VSS VDD VDD network.neuron_hid2.IF0.ref_counter\[0\]
+ sky130_fd_sc_hd__dfxtp_1
Xnetwork.neuron_hid2.IF0.ref_counter\[1\]$_SDFFE_PP0P_ clknet_leaf_117_clk_net
+ _01916_ VSS VSS VDD VDD network.neuron_hid2.IF0.ref_counter\[1\]
+ sky130_fd_sc_hd__dfxtp_1
Xnetwork.neuron_hid2.IF_in\[0\]$_SDFF_PP0_ clknet_leaf_95_clk_net
+ _01749_ VSS VSS VDD VDD network.neuron_hid2.IF0.input_current\[0\]
+ sky130_fd_sc_hd__dfxtp_1
Xnetwork.neuron_hid2.IF_in\[1\]$_SDFF_PP0_ clknet_leaf_97_clk_net
+ _01748_ VSS VSS VDD VDD network.neuron_hid2.IF0.input_current\[1\]
+ sky130_fd_sc_hd__dfxtp_1
Xnetwork.neuron_hid2.IF_in\[2\]$_SDFF_PP0_ clknet_leaf_97_clk_net
+ _01747_ VSS VSS VDD VDD network.neuron_hid2.IF0.input_current\[2\]
+ sky130_fd_sc_hd__dfxtp_1
Xnetwork.neuron_hid2.IF_in\[3\]$_SDFF_PP0_ clknet_leaf_100_clk_net
+ _01746_ VSS VSS VDD VDD network.neuron_hid2.IF0.input_current\[3\]
+ sky130_fd_sc_hd__dfxtp_1
Xnetwork.neuron_hid2.IF_in\[4\]$_SDFF_PP0_ clknet_leaf_100_clk_net
+ _01759_ VSS VSS VDD VDD network.neuron_hid2.IF0.input_current\[4\]
+ sky130_fd_sc_hd__dfxtp_1
Xnetwork.neuron_hid2.spike_out$_SDFFE_PP0P_ clknet_leaf_117_clk_net
+ _01920_ VSS VSS VDD VDD network.hid_spk2 sky130_fd_sc_hd__dfxtp_1
Xnetwork.neuron_hid3.IF0.membrane_potential\[0\]$_SDFF_PP0_
+ clknet_leaf_94_clk_net _01681_ VSS VSS VDD VDD network.neuron_hid3.IF0.membrane_potential\[0\]
+ sky130_fd_sc_hd__dfxtp_1
Xnetwork.neuron_hid3.IF0.membrane_potential\[10\]$_SDFF_PP0_
+ clknet_leaf_119_clk_net _01918_ VSS VSS VDD VDD network.neuron_hid3.IF0.membrane_potential\[10\]
+ sky130_fd_sc_hd__dfxtp_1
Xnetwork.neuron_hid3.IF0.membrane_potential\[1\]$_SDFF_PP0_
+ clknet_leaf_94_clk_net _01680_ VSS VSS VDD VDD network.neuron_hid3.IF0.membrane_potential\[1\]
+ sky130_fd_sc_hd__dfxtp_1
Xnetwork.neuron_hid3.IF0.membrane_potential\[2\]$_SDFF_PP0_
+ clknet_leaf_95_clk_net _01679_ VSS VSS VDD VDD network.neuron_hid3.IF0.membrane_potential\[2\]
+ sky130_fd_sc_hd__dfxtp_1
Xnetwork.neuron_hid3.IF0.membrane_potential\[3\]$_SDFF_PP0_
+ clknet_leaf_95_clk_net _01678_ VSS VSS VDD VDD network.neuron_hid3.IF0.membrane_potential\[3\]
+ sky130_fd_sc_hd__dfxtp_1
Xnetwork.neuron_hid3.IF0.membrane_potential\[4\]$_SDFF_PP0_
+ clknet_leaf_118_clk_net _01677_ VSS VSS VDD VDD network.neuron_hid3.IF0.membrane_potential\[4\]
+ sky130_fd_sc_hd__dfxtp_1
Xnetwork.neuron_hid3.IF0.membrane_potential\[5\]$_SDFF_PP0_
+ clknet_leaf_95_clk_net _01676_ VSS VSS VDD VDD network.neuron_hid3.IF0.membrane_potential\[5\]
+ sky130_fd_sc_hd__dfxtp_1
Xnetwork.neuron_hid3.IF0.membrane_potential\[6\]$_SDFF_PP0_
+ clknet_leaf_118_clk_net _01675_ VSS VSS VDD VDD network.neuron_hid3.IF0.membrane_potential\[6\]
+ sky130_fd_sc_hd__dfxtp_1
Xnetwork.neuron_hid3.IF0.membrane_potential\[7\]$_SDFF_PP0_
+ clknet_leaf_118_clk_net _01674_ VSS VSS VDD VDD network.neuron_hid3.IF0.membrane_potential\[7\]
+ sky130_fd_sc_hd__dfxtp_1
Xnetwork.neuron_hid3.IF0.membrane_potential\[8\]$_SDFF_PP0_
+ clknet_leaf_119_clk_net _01673_ VSS VSS VDD VDD network.neuron_hid3.IF0.membrane_potential\[8\]
+ sky130_fd_sc_hd__dfxtp_1
Xnetwork.neuron_hid3.IF0.membrane_potential\[9\]$_SDFF_PP0_
+ clknet_leaf_118_clk_net _01672_ VSS VSS VDD VDD network.neuron_hid3.IF0.membrane_potential\[9\]
+ sky130_fd_sc_hd__dfxtp_1
Xnetwork.neuron_hid3.IF0.ref_counter\[0\]$_SDFFE_PP0P_ clknet_leaf_119_clk_net
+ _01671_ VSS VSS VDD VDD network.neuron_hid3.IF0.ref_counter\[0\]
+ sky130_fd_sc_hd__dfxtp_1
Xnetwork.neuron_hid3.IF0.ref_counter\[1\]$_SDFFE_PP0P_ clknet_leaf_120_clk_net
+ _01922_ VSS VSS VDD VDD network.neuron_hid3.IF0.ref_counter\[1\]
+ sky130_fd_sc_hd__dfxtp_1
Xnetwork.neuron_hid3.IF_in\[0\]$_SDFF_PP0_ clknet_leaf_95_clk_net
+ _01752_ VSS VSS VDD VDD network.neuron_hid3.IF0.input_current\[0\]
+ sky130_fd_sc_hd__dfxtp_1
Xnetwork.neuron_hid3.IF_in\[1\]$_SDFF_PP0_ clknet_leaf_95_clk_net
+ _01751_ VSS VSS VDD VDD network.neuron_hid3.IF0.input_current\[1\]
+ sky130_fd_sc_hd__dfxtp_1
Xnetwork.neuron_hid3.IF_in\[2\]$_SDFF_PP0_ clknet_leaf_95_clk_net
+ _01750_ VSS VSS VDD VDD network.neuron_hid3.IF0.input_current\[2\]
+ sky130_fd_sc_hd__dfxtp_1
Xnetwork.neuron_hid3.IF_in\[5\]$_SDFF_PP0_ clknet_leaf_96_clk_net
+ _01757_ VSS VSS VDD VDD network.neuron_hid2.IF0.input_current\[5\]
+ sky130_fd_sc_hd__dfxtp_1
Xnetwork.neuron_hid3.spike_out$_SDFFE_PP0P_ clknet_leaf_117_clk_net
+ _01921_ VSS VSS VDD VDD network.hid_spk3 sky130_fd_sc_hd__dfxtp_1
Xnetwork.neuron_hid4.IF0.membrane_potential\[0\]$_SDFF_PP0_
+ clknet_leaf_92_clk_net _01670_ VSS VSS VDD VDD network.neuron_hid4.IF0.membrane_potential\[0\]
+ sky130_fd_sc_hd__dfxtp_1
Xnetwork.neuron_hid4.IF0.membrane_potential\[10\]$_SDFF_PP0_
+ clknet_leaf_95_clk_net _01925_ VSS VSS VDD VDD network.neuron_hid4.IF0.membrane_potential\[10\]
+ sky130_fd_sc_hd__dfxtp_1
Xnetwork.neuron_hid4.IF0.membrane_potential\[1\]$_SDFF_PP0_
+ clknet_leaf_93_clk_net _01669_ VSS VSS VDD VDD network.neuron_hid4.IF0.membrane_potential\[1\]
+ sky130_fd_sc_hd__dfxtp_1
Xnetwork.neuron_hid4.IF0.membrane_potential\[2\]$_SDFF_PP0_
+ clknet_leaf_96_clk_net _01668_ VSS VSS VDD VDD network.neuron_hid4.IF0.membrane_potential\[2\]
+ sky130_fd_sc_hd__dfxtp_1
Xnetwork.neuron_hid4.IF0.membrane_potential\[3\]$_SDFF_PP0_
+ clknet_leaf_95_clk_net _01667_ VSS VSS VDD VDD network.neuron_hid4.IF0.membrane_potential\[3\]
+ sky130_fd_sc_hd__dfxtp_1
Xnetwork.neuron_hid4.IF0.membrane_potential\[4\]$_SDFF_PP0_
+ clknet_leaf_95_clk_net _01666_ VSS VSS VDD VDD network.neuron_hid4.IF0.membrane_potential\[4\]
+ sky130_fd_sc_hd__dfxtp_1
Xnetwork.neuron_hid4.IF0.membrane_potential\[5\]$_SDFF_PP0_
+ clknet_leaf_93_clk_net _01665_ VSS VSS VDD VDD network.neuron_hid4.IF0.membrane_potential\[5\]
+ sky130_fd_sc_hd__dfxtp_1
Xnetwork.neuron_hid4.IF0.membrane_potential\[6\]$_SDFF_PP0_
+ clknet_leaf_94_clk_net _01664_ VSS VSS VDD VDD network.neuron_hid4.IF0.membrane_potential\[6\]
+ sky130_fd_sc_hd__dfxtp_1
Xnetwork.neuron_hid4.IF0.membrane_potential\[7\]$_SDFF_PP0_
+ clknet_leaf_93_clk_net _01663_ VSS VSS VDD VDD network.neuron_hid4.IF0.membrane_potential\[7\]
+ sky130_fd_sc_hd__dfxtp_1
Xnetwork.neuron_hid4.IF0.membrane_potential\[8\]$_SDFF_PP0_
+ clknet_leaf_94_clk_net _01662_ VSS VSS VDD VDD network.neuron_hid4.IF0.membrane_potential\[8\]
+ sky130_fd_sc_hd__dfxtp_1
Xnetwork.neuron_hid4.IF0.membrane_potential\[9\]$_SDFF_PP0_
+ clknet_leaf_94_clk_net _01661_ VSS VSS VDD VDD network.neuron_hid4.IF0.membrane_potential\[9\]
+ sky130_fd_sc_hd__dfxtp_1
Xnetwork.neuron_hid4.IF0.ref_counter\[0\]$_SDFFE_PP0P_ clknet_leaf_94_clk_net
+ _01660_ VSS VSS VDD VDD network.neuron_hid4.IF0.ref_counter\[0\]
+ sky130_fd_sc_hd__dfxtp_1
Xnetwork.neuron_hid4.IF0.ref_counter\[1\]$_SDFFE_PP0P_ clknet_leaf_94_clk_net
+ _01923_ VSS VSS VDD VDD network.neuron_hid4.IF0.ref_counter\[1\]
+ sky130_fd_sc_hd__dfxtp_1
Xnetwork.neuron_hid4.IF_in\[0\]$_SDFF_PP0_ clknet_leaf_92_clk_net
+ _01516_ VSS VSS VDD VDD network.neuron_hid4.IF0.input_current\[0\]
+ sky130_fd_sc_hd__dfxtp_1
Xnetwork.neuron_hid4.IF_in\[1\]$_SDFF_PP0_ clknet_leaf_92_clk_net
+ _01515_ VSS VSS VDD VDD network.neuron_hid4.IF0.input_current\[1\]
+ sky130_fd_sc_hd__dfxtp_1
Xnetwork.neuron_hid4.IF_in\[2\]$_SDFF_PP0_ clknet_leaf_96_clk_net
+ _01514_ VSS VSS VDD VDD network.neuron_hid4.IF0.input_current\[2\]
+ sky130_fd_sc_hd__dfxtp_1
Xnetwork.neuron_hid4.IF_in\[3\]$_SDFF_PP0_ clknet_leaf_96_clk_net
+ _01513_ VSS VSS VDD VDD network.neuron_hid4.IF0.input_current\[3\]
+ sky130_fd_sc_hd__dfxtp_1
Xnetwork.neuron_hid4.IF_in\[4\]$_SDFF_PP0_ clknet_leaf_96_clk_net
+ _01756_ VSS VSS VDD VDD network.neuron_hid4.IF0.input_current\[4\]
+ sky130_fd_sc_hd__dfxtp_1
Xnetwork.neuron_hid4.spike_out$_SDFFE_PP0P_ clknet_leaf_121_clk_net
+ _01927_ VSS VSS VDD VDD network.hid_spk4 sky130_fd_sc_hd__dfxtp_1
Xnetwork.neuron_hid5.IF0.membrane_potential\[0\]$_SDFF_PP0_
+ clknet_leaf_119_clk_net _01659_ VSS VSS VDD VDD network.neuron_hid5.IF0.membrane_potential\[0\]
+ sky130_fd_sc_hd__dfxtp_1
Xnetwork.neuron_hid5.IF0.membrane_potential\[10\]$_SDFF_PP0_
+ clknet_leaf_120_clk_net _01930_ VSS VSS VDD VDD network.neuron_hid5.IF0.membrane_potential\[10\]
+ sky130_fd_sc_hd__dfxtp_1
Xnetwork.neuron_hid5.IF0.membrane_potential\[1\]$_SDFF_PP0_
+ clknet_leaf_119_clk_net _01658_ VSS VSS VDD VDD network.neuron_hid5.IF0.membrane_potential\[1\]
+ sky130_fd_sc_hd__dfxtp_1
Xnetwork.neuron_hid5.IF0.membrane_potential\[2\]$_SDFF_PP0_
+ clknet_leaf_119_clk_net _01657_ VSS VSS VDD VDD network.neuron_hid5.IF0.membrane_potential\[2\]
+ sky130_fd_sc_hd__dfxtp_1
Xnetwork.neuron_hid5.IF0.membrane_potential\[3\]$_SDFF_PP0_
+ clknet_leaf_120_clk_net _01656_ VSS VSS VDD VDD network.neuron_hid5.IF0.membrane_potential\[3\]
+ sky130_fd_sc_hd__dfxtp_1
Xnetwork.neuron_hid5.IF0.membrane_potential\[4\]$_SDFF_PP0_
+ clknet_leaf_120_clk_net _01655_ VSS VSS VDD VDD network.neuron_hid5.IF0.membrane_potential\[4\]
+ sky130_fd_sc_hd__dfxtp_1
Xnetwork.neuron_hid5.IF0.membrane_potential\[5\]$_SDFF_PP0_
+ clknet_leaf_120_clk_net _01654_ VSS VSS VDD VDD network.neuron_hid5.IF0.membrane_potential\[5\]
+ sky130_fd_sc_hd__dfxtp_1
Xnetwork.neuron_hid5.IF0.membrane_potential\[6\]$_SDFF_PP0_
+ clknet_leaf_120_clk_net _01653_ VSS VSS VDD VDD network.neuron_hid5.IF0.membrane_potential\[6\]
+ sky130_fd_sc_hd__dfxtp_1
Xnetwork.neuron_hid5.IF0.membrane_potential\[7\]$_SDFF_PP0_
+ clknet_leaf_120_clk_net _01652_ VSS VSS VDD VDD network.neuron_hid5.IF0.membrane_potential\[7\]
+ sky130_fd_sc_hd__dfxtp_1
Xnetwork.neuron_hid5.IF0.membrane_potential\[8\]$_SDFF_PP0_
+ clknet_leaf_120_clk_net _01651_ VSS VSS VDD VDD network.neuron_hid5.IF0.membrane_potential\[8\]
+ sky130_fd_sc_hd__dfxtp_1
Xnetwork.neuron_hid5.IF0.membrane_potential\[9\]$_SDFF_PP0_
+ clknet_leaf_120_clk_net _01650_ VSS VSS VDD VDD network.neuron_hid5.IF0.membrane_potential\[9\]
+ sky130_fd_sc_hd__dfxtp_1
Xnetwork.neuron_hid5.IF0.ref_counter\[0\]$_SDFFE_PP0P_ clknet_leaf_121_clk_net
+ _01649_ VSS VSS VDD VDD network.neuron_hid5.IF0.ref_counter\[0\]
+ sky130_fd_sc_hd__dfxtp_1
Xnetwork.neuron_hid5.IF0.ref_counter\[1\]$_SDFFE_PP0P_ clknet_leaf_120_clk_net
+ _01928_ VSS VSS VDD VDD network.neuron_hid5.IF0.ref_counter\[1\]
+ sky130_fd_sc_hd__dfxtp_1
Xnetwork.neuron_hid5.IF_in\[0\]$_SDFF_PP0_ clknet_leaf_118_clk_net
+ _01512_ VSS VSS VDD VDD network.neuron_hid5.IF0.input_current\[0\]
+ sky130_fd_sc_hd__dfxtp_1
Xnetwork.neuron_hid5.IF_in\[1\]$_SDFF_PP0_ clknet_leaf_119_clk_net
+ _01511_ VSS VSS VDD VDD network.neuron_hid5.IF0.input_current\[1\]
+ sky130_fd_sc_hd__dfxtp_1
Xnetwork.neuron_hid5.IF_in\[2\]$_SDFF_PP0_ clknet_leaf_118_clk_net
+ _01510_ VSS VSS VDD VDD network.neuron_hid5.IF0.input_current\[2\]
+ sky130_fd_sc_hd__dfxtp_1
Xnetwork.neuron_hid5.IF_in\[3\]$_SDFF_PP0_ clknet_leaf_119_clk_net
+ _01509_ VSS VSS VDD VDD network.neuron_hid5.IF0.input_current\[3\]
+ sky130_fd_sc_hd__dfxtp_1
Xnetwork.neuron_hid5.IF_in\[4\]$_SDFF_PP0_ clknet_leaf_119_clk_net
+ _01753_ VSS VSS VDD VDD network.neuron_hid5.IF0.input_current\[4\]
+ sky130_fd_sc_hd__dfxtp_1
Xnetwork.neuron_hid5.spike_out$_SDFFE_PP0P_ clknet_leaf_121_clk_net
+ _01931_ VSS VSS VDD VDD network.hid_spk5 sky130_fd_sc_hd__dfxtp_1
Xnetwork.neuron_hid6.IF0.membrane_potential\[0\]$_SDFF_PP0_
+ clknet_leaf_93_clk_net _01648_ VSS VSS VDD VDD network.neuron_hid6.IF0.membrane_potential\[0\]
+ sky130_fd_sc_hd__dfxtp_1
Xnetwork.neuron_hid6.IF0.membrane_potential\[10\]$_SDFF_PP0_
+ clknet_leaf_94_clk_net _01934_ VSS VSS VDD VDD network.neuron_hid6.IF0.membrane_potential\[10\]
+ sky130_fd_sc_hd__dfxtp_1
Xnetwork.neuron_hid6.IF0.membrane_potential\[1\]$_SDFF_PP0_
+ clknet_leaf_93_clk_net _01647_ VSS VSS VDD VDD network.neuron_hid6.IF0.membrane_potential\[1\]
+ sky130_fd_sc_hd__dfxtp_1
Xnetwork.neuron_hid6.IF0.membrane_potential\[2\]$_SDFF_PP0_
+ clknet_leaf_93_clk_net _01646_ VSS VSS VDD VDD network.neuron_hid6.IF0.membrane_potential\[2\]
+ sky130_fd_sc_hd__dfxtp_1
Xnetwork.neuron_hid6.IF0.membrane_potential\[3\]$_SDFF_PP0_
+ clknet_leaf_92_clk_net _01645_ VSS VSS VDD VDD network.neuron_hid6.IF0.membrane_potential\[3\]
+ sky130_fd_sc_hd__dfxtp_1
Xnetwork.neuron_hid6.IF0.membrane_potential\[4\]$_SDFF_PP0_
+ clknet_leaf_92_clk_net _01644_ VSS VSS VDD VDD network.neuron_hid6.IF0.membrane_potential\[4\]
+ sky130_fd_sc_hd__dfxtp_1
Xnetwork.neuron_hid6.IF0.membrane_potential\[5\]$_SDFF_PP0_
+ clknet_leaf_93_clk_net _01643_ VSS VSS VDD VDD network.neuron_hid6.IF0.membrane_potential\[5\]
+ sky130_fd_sc_hd__dfxtp_1
Xnetwork.neuron_hid6.IF0.membrane_potential\[6\]$_SDFF_PP0_
+ clknet_leaf_93_clk_net _01642_ VSS VSS VDD VDD network.neuron_hid6.IF0.membrane_potential\[6\]
+ sky130_fd_sc_hd__dfxtp_1
Xnetwork.neuron_hid6.IF0.membrane_potential\[7\]$_SDFF_PP0_
+ clknet_leaf_93_clk_net _01641_ VSS VSS VDD VDD network.neuron_hid6.IF0.membrane_potential\[7\]
+ sky130_fd_sc_hd__dfxtp_1
Xnetwork.neuron_hid6.IF0.membrane_potential\[8\]$_SDFF_PP0_
+ clknet_leaf_93_clk_net _01640_ VSS VSS VDD VDD network.neuron_hid6.IF0.membrane_potential\[8\]
+ sky130_fd_sc_hd__dfxtp_1
Xnetwork.neuron_hid6.IF0.membrane_potential\[9\]$_SDFF_PP0_
+ clknet_leaf_94_clk_net _01639_ VSS VSS VDD VDD network.neuron_hid6.IF0.membrane_potential\[9\]
+ sky130_fd_sc_hd__dfxtp_1
Xnetwork.neuron_hid6.IF0.ref_counter\[0\]$_SDFFE_PP0P_ clknet_leaf_94_clk_net
+ _01638_ VSS VSS VDD VDD network.neuron_hid6.IF0.ref_counter\[0\]
+ sky130_fd_sc_hd__dfxtp_1
Xnetwork.neuron_hid6.IF0.ref_counter\[1\]$_SDFFE_PP0P_ clknet_leaf_94_clk_net
+ _01932_ VSS VSS VDD VDD network.neuron_hid6.IF0.ref_counter\[1\]
+ sky130_fd_sc_hd__dfxtp_1
Xnetwork.neuron_hid6.IF_in\[0\]$_SDFF_PP0_ clknet_leaf_92_clk_net
+ _01520_ VSS VSS VDD VDD network.neuron_hid6.IF0.input_current\[0\]
+ sky130_fd_sc_hd__dfxtp_1
Xnetwork.neuron_hid6.IF_in\[1\]$_SDFF_PP0_ clknet_leaf_92_clk_net
+ _01519_ VSS VSS VDD VDD network.neuron_hid6.IF0.input_current\[1\]
+ sky130_fd_sc_hd__dfxtp_1
Xnetwork.neuron_hid6.IF_in\[2\]$_SDFF_PP0_ clknet_leaf_92_clk_net
+ _01518_ VSS VSS VDD VDD network.neuron_hid6.IF0.input_current\[2\]
+ sky130_fd_sc_hd__dfxtp_1
Xnetwork.neuron_hid6.IF_in\[3\]$_SDFF_PP0_ clknet_leaf_92_clk_net
+ _01517_ VSS VSS VDD VDD network.neuron_hid6.IF0.input_current\[3\]
+ sky130_fd_sc_hd__dfxtp_1
Xnetwork.neuron_hid6.IF_in\[4\]$_SDFF_PP0_ clknet_leaf_92_clk_net
+ _01758_ VSS VSS VDD VDD network.neuron_hid6.IF0.input_current\[4\]
+ sky130_fd_sc_hd__dfxtp_1
Xnetwork.neuron_hid6.spike_out$_SDFFE_PP0P_ clknet_leaf_121_clk_net
+ _01936_ VSS VSS VDD VDD network.hid_spk6 sky130_fd_sc_hd__dfxtp_1
Xnetwork.neuron_hid7.IF0.membrane_potential\[0\]$_SDFF_PP0_
+ clknet_leaf_96_clk_net _01637_ VSS VSS VDD VDD network.neuron_hid7.IF0.membrane_potential\[0\]
+ sky130_fd_sc_hd__dfxtp_1
Xnetwork.neuron_hid7.IF0.membrane_potential\[10\]$_SDFF_PP0_
+ clknet_leaf_98_clk_net _01939_ VSS VSS VDD VDD network.neuron_hid7.IF0.membrane_potential\[10\]
+ sky130_fd_sc_hd__dfxtp_1
Xnetwork.neuron_hid7.IF0.membrane_potential\[1\]$_SDFF_PP0_
+ clknet_leaf_96_clk_net _01636_ VSS VSS VDD VDD network.neuron_hid7.IF0.membrane_potential\[1\]
+ sky130_fd_sc_hd__dfxtp_1
Xnetwork.neuron_hid7.IF0.membrane_potential\[2\]$_SDFF_PP0_
+ clknet_leaf_97_clk_net _01635_ VSS VSS VDD VDD network.neuron_hid7.IF0.membrane_potential\[2\]
+ sky130_fd_sc_hd__dfxtp_1
Xnetwork.neuron_hid7.IF0.membrane_potential\[3\]$_SDFF_PP0_
+ clknet_leaf_97_clk_net _01634_ VSS VSS VDD VDD network.neuron_hid7.IF0.membrane_potential\[3\]
+ sky130_fd_sc_hd__dfxtp_1
Xnetwork.neuron_hid7.IF0.membrane_potential\[4\]$_SDFF_PP0_
+ clknet_leaf_97_clk_net _01633_ VSS VSS VDD VDD network.neuron_hid7.IF0.membrane_potential\[4\]
+ sky130_fd_sc_hd__dfxtp_1
Xnetwork.neuron_hid7.IF0.membrane_potential\[5\]$_SDFF_PP0_
+ clknet_leaf_97_clk_net _01632_ VSS VSS VDD VDD network.neuron_hid7.IF0.membrane_potential\[5\]
+ sky130_fd_sc_hd__dfxtp_1
Xnetwork.neuron_hid7.IF0.membrane_potential\[6\]$_SDFF_PP0_
+ clknet_leaf_97_clk_net _01631_ VSS VSS VDD VDD network.neuron_hid7.IF0.membrane_potential\[6\]
+ sky130_fd_sc_hd__dfxtp_1
Xnetwork.neuron_hid7.IF0.membrane_potential\[7\]$_SDFF_PP0_
+ clknet_leaf_98_clk_net _01630_ VSS VSS VDD VDD network.neuron_hid7.IF0.membrane_potential\[7\]
+ sky130_fd_sc_hd__dfxtp_1
Xnetwork.neuron_hid7.IF0.membrane_potential\[8\]$_SDFF_PP0_
+ clknet_leaf_97_clk_net _01629_ VSS VSS VDD VDD network.neuron_hid7.IF0.membrane_potential\[8\]
+ sky130_fd_sc_hd__dfxtp_1
Xnetwork.neuron_hid7.IF0.membrane_potential\[9\]$_SDFF_PP0_
+ clknet_leaf_98_clk_net _01628_ VSS VSS VDD VDD network.neuron_hid7.IF0.membrane_potential\[9\]
+ sky130_fd_sc_hd__dfxtp_1
Xnetwork.neuron_hid7.IF0.ref_counter\[0\]$_SDFFE_PP0P_ clknet_leaf_98_clk_net
+ _01627_ VSS VSS VDD VDD network.neuron_hid7.IF0.ref_counter\[0\]
+ sky130_fd_sc_hd__dfxtp_1
Xnetwork.neuron_hid7.IF0.ref_counter\[1\]$_SDFFE_PP0P_ clknet_leaf_98_clk_net
+ _01937_ VSS VSS VDD VDD network.neuron_hid7.IF0.ref_counter\[1\]
+ sky130_fd_sc_hd__dfxtp_1
Xnetwork.neuron_hid7.IF_in\[0\]$_SDFF_PP0_ clknet_leaf_96_clk_net
+ _01745_ VSS VSS VDD VDD network.neuron_hid7.IF0.input_current\[0\]
+ sky130_fd_sc_hd__dfxtp_1
Xnetwork.neuron_hid7.IF_in\[1\]$_SDFF_PP0_ clknet_leaf_97_clk_net
+ _01744_ VSS VSS VDD VDD network.neuron_hid7.IF0.input_current\[1\]
+ sky130_fd_sc_hd__dfxtp_1
Xnetwork.neuron_hid7.IF_in\[2\]$_SDFF_PP0_ clknet_leaf_96_clk_net
+ _01743_ VSS VSS VDD VDD network.neuron_hid7.IF0.input_current\[2\]
+ sky130_fd_sc_hd__dfxtp_1
Xnetwork.neuron_hid7.IF_in\[3\]$_SDFF_PP0_ clknet_leaf_99_clk_net
+ _01742_ VSS VSS VDD VDD network.neuron_hid7.IF0.input_current\[3\]
+ sky130_fd_sc_hd__dfxtp_1
Xnetwork.neuron_hid7.IF_in\[6\]$_SDFF_PP0_ clknet_leaf_97_clk_net
+ _01763_ VSS VSS VDD VDD network.neuron_hid2.IF0.input_current\[6\]
+ sky130_fd_sc_hd__dfxtp_1
Xnetwork.neuron_hid7.IF_in\[7\]$_SDFF_PP0_ clknet_leaf_97_clk_net
+ _01754_ VSS VSS VDD VDD network.neuron_hid2.IF0.input_current\[7\]
+ sky130_fd_sc_hd__dfxtp_1
Xnetwork.neuron_hid7.spike_out$_SDFFE_PP0P_ clknet_leaf_117_clk_net
+ _01941_ VSS VSS VDD VDD network.hid_spk7 sky130_fd_sc_hd__dfxtp_1
Xnetwork.neuron_in000.counter\[0\]$_DFFE_PP_ clknet_leaf_176_clk_net
+ _02063_ _01504_ VSS VSS VDD VDD network.neuron_in000.counter\[0\]
+ sky130_fd_sc_hd__edfxtp_1
Xnetwork.neuron_in000.counter\[1\]$_DFFE_PP_ clknet_leaf_176_clk_net
+ _02064_ _01504_ VSS VSS VDD VDD network.neuron_in000.counter\[1\]
+ sky130_fd_sc_hd__edfxtp_1
Xnetwork.neuron_in000.counter\[2\]$_DFFE_PP_ clknet_leaf_175_clk_net
+ _02065_ _01504_ VSS VSS VDD VDD network.neuron_in000.counter\[2\]
+ sky130_fd_sc_hd__edfxtp_1
Xnetwork.neuron_in000.counter\[3\]$_DFFE_PP_ clknet_leaf_175_clk_net
+ _02066_ _01504_ VSS VSS VDD VDD network.neuron_in000.counter\[3\]
+ sky130_fd_sc_hd__edfxtp_1
Xnetwork.neuron_in000.spike$_SDFFE_PP0P_ clknet_leaf_168_clk_net
+ _01865_ VSS VSS VDD VDD network.in_spk00_00 sky130_fd_sc_hd__dfxtp_1
Xnetwork.neuron_in001.counter\[0\]$_DFFE_PP_ clknet_leaf_184_clk_net
+ _02067_ _01503_ VSS VSS VDD VDD network.neuron_in001.counter\[0\]
+ sky130_fd_sc_hd__edfxtp_1
Xnetwork.neuron_in001.counter\[1\]$_DFFE_PP_ clknet_leaf_184_clk_net
+ _02068_ _01503_ VSS VSS VDD VDD network.neuron_in001.counter\[1\]
+ sky130_fd_sc_hd__edfxtp_1
Xnetwork.neuron_in001.counter\[2\]$_DFFE_PP_ clknet_leaf_184_clk_net
+ _02069_ _01503_ VSS VSS VDD VDD network.neuron_in001.counter\[2\]
+ sky130_fd_sc_hd__edfxtp_1
Xnetwork.neuron_in001.counter\[3\]$_DFFE_PP_ clknet_leaf_184_clk_net
+ _02070_ _01503_ VSS VSS VDD VDD network.neuron_in001.counter\[3\]
+ sky130_fd_sc_hd__edfxtp_1
Xnetwork.neuron_in001.spike$_SDFFE_PP0P_ clknet_leaf_179_clk_net
+ _01864_ VSS VSS VDD VDD network.in_spk01_00 sky130_fd_sc_hd__dfxtp_1
Xnetwork.neuron_in002.counter\[0\]$_DFFE_PP_ clknet_leaf_169_clk_net
+ _02071_ _01502_ VSS VSS VDD VDD network.neuron_in002.counter\[0\]
+ sky130_fd_sc_hd__edfxtp_1
Xnetwork.neuron_in002.counter\[1\]$_DFFE_PP_ clknet_leaf_169_clk_net
+ _02072_ _01502_ VSS VSS VDD VDD network.neuron_in002.counter\[1\]
+ sky130_fd_sc_hd__edfxtp_1
Xnetwork.neuron_in002.counter\[2\]$_DFFE_PP_ clknet_leaf_169_clk_net
+ _02073_ _01502_ VSS VSS VDD VDD network.neuron_in002.counter\[2\]
+ sky130_fd_sc_hd__edfxtp_1
Xnetwork.neuron_in002.counter\[3\]$_DFFE_PP_ clknet_leaf_169_clk_net
+ _02074_ _01502_ VSS VSS VDD VDD network.neuron_in002.counter\[3\]
+ sky130_fd_sc_hd__edfxtp_1
Xnetwork.neuron_in002.spike$_SDFFE_PP0P_ clknet_leaf_168_clk_net
+ _01863_ VSS VSS VDD VDD network.in_spk02_00 sky130_fd_sc_hd__dfxtp_1
Xnetwork.neuron_in003.counter\[0\]$_DFFE_PP_ clknet_leaf_168_clk_net
+ _02075_ _01501_ VSS VSS VDD VDD network.neuron_in003.counter\[0\]
+ sky130_fd_sc_hd__edfxtp_1
Xnetwork.neuron_in003.counter\[1\]$_DFFE_PP_ clknet_leaf_168_clk_net
+ _02076_ _01501_ VSS VSS VDD VDD network.neuron_in003.counter\[1\]
+ sky130_fd_sc_hd__edfxtp_1
Xnetwork.neuron_in003.counter\[2\]$_DFFE_PP_ clknet_leaf_172_clk_net
+ _02077_ _01501_ VSS VSS VDD VDD network.neuron_in003.counter\[2\]
+ sky130_fd_sc_hd__edfxtp_1
Xnetwork.neuron_in003.counter\[3\]$_DFFE_PP_ clknet_leaf_168_clk_net
+ _02078_ _01501_ VSS VSS VDD VDD network.neuron_in003.counter\[3\]
+ sky130_fd_sc_hd__edfxtp_1
Xnetwork.neuron_in003.spike$_SDFFE_PP0P_ clknet_leaf_168_clk_net
+ _01862_ VSS VSS VDD VDD network.in_spk03_00 sky130_fd_sc_hd__dfxtp_1
Xnetwork.neuron_in004.counter\[0\]$_DFFE_PP_ clknet_leaf_184_clk_net
+ _02079_ _01500_ VSS VSS VDD VDD network.neuron_in004.counter\[0\]
+ sky130_fd_sc_hd__edfxtp_1
Xnetwork.neuron_in004.counter\[1\]$_DFFE_PP_ clknet_leaf_184_clk_net
+ _02080_ _01500_ VSS VSS VDD VDD network.neuron_in004.counter\[1\]
+ sky130_fd_sc_hd__edfxtp_1
Xnetwork.neuron_in004.counter\[2\]$_DFFE_PP_ clknet_leaf_184_clk_net
+ _02081_ _01500_ VSS VSS VDD VDD network.neuron_in004.counter\[2\]
+ sky130_fd_sc_hd__edfxtp_1
Xnetwork.neuron_in004.counter\[3\]$_DFFE_PP_ clknet_leaf_184_clk_net
+ _02082_ _01500_ VSS VSS VDD VDD network.neuron_in004.counter\[3\]
+ sky130_fd_sc_hd__edfxtp_1
Xnetwork.neuron_in004.spike$_SDFFE_PP0P_ clknet_leaf_180_clk_net
+ _01861_ VSS VSS VDD VDD network.in_spk04_00 sky130_fd_sc_hd__dfxtp_1
Xnetwork.neuron_in005.counter\[0\]$_DFFE_PP_ clknet_leaf_178_clk_net
+ _02083_ _01499_ VSS VSS VDD VDD network.neuron_in005.counter\[0\]
+ sky130_fd_sc_hd__edfxtp_1
Xnetwork.neuron_in005.counter\[1\]$_DFFE_PP_ clknet_leaf_178_clk_net
+ _02084_ _01499_ VSS VSS VDD VDD network.neuron_in005.counter\[1\]
+ sky130_fd_sc_hd__edfxtp_1
Xnetwork.neuron_in005.counter\[2\]$_DFFE_PP_ clknet_leaf_178_clk_net
+ _02085_ _01499_ VSS VSS VDD VDD network.neuron_in005.counter\[2\]
+ sky130_fd_sc_hd__edfxtp_1
Xnetwork.neuron_in005.counter\[3\]$_DFFE_PP_ clknet_leaf_178_clk_net
+ _02086_ _01499_ VSS VSS VDD VDD network.neuron_in005.counter\[3\]
+ sky130_fd_sc_hd__edfxtp_1
Xnetwork.neuron_in005.spike$_SDFFE_PP0P_ clknet_leaf_180_clk_net
+ _01860_ VSS VSS VDD VDD network.in_spk05_00 sky130_fd_sc_hd__dfxtp_1
Xnetwork.neuron_in006.counter\[0\]$_DFFE_PP_ clknet_leaf_179_clk_net
+ _02087_ _01498_ VSS VSS VDD VDD network.neuron_in006.counter\[0\]
+ sky130_fd_sc_hd__edfxtp_1
Xnetwork.neuron_in006.counter\[1\]$_DFFE_PP_ clknet_leaf_179_clk_net
+ _02088_ _01498_ VSS VSS VDD VDD network.neuron_in006.counter\[1\]
+ sky130_fd_sc_hd__edfxtp_1
Xnetwork.neuron_in006.counter\[2\]$_DFFE_PP_ clknet_leaf_179_clk_net
+ _02089_ _01498_ VSS VSS VDD VDD network.neuron_in006.counter\[2\]
+ sky130_fd_sc_hd__edfxtp_1
Xnetwork.neuron_in006.counter\[3\]$_DFFE_PP_ clknet_leaf_179_clk_net
+ _02090_ _01498_ VSS VSS VDD VDD network.neuron_in006.counter\[3\]
+ sky130_fd_sc_hd__edfxtp_1
Xnetwork.neuron_in006.spike$_SDFFE_PP0P_ clknet_leaf_179_clk_net
+ _01859_ VSS VSS VDD VDD network.in_spk06_00 sky130_fd_sc_hd__dfxtp_1
Xnetwork.neuron_in007.counter\[0\]$_DFFE_PP_ clknet_leaf_185_clk_net
+ _02091_ _01497_ VSS VSS VDD VDD network.neuron_in007.counter\[0\]
+ sky130_fd_sc_hd__edfxtp_1
Xnetwork.neuron_in007.counter\[1\]$_DFFE_PP_ clknet_leaf_185_clk_net
+ _02092_ _01497_ VSS VSS VDD VDD network.neuron_in007.counter\[1\]
+ sky130_fd_sc_hd__edfxtp_1
Xnetwork.neuron_in007.counter\[2\]$_DFFE_PP_ clknet_leaf_185_clk_net
+ _02093_ _01497_ VSS VSS VDD VDD network.neuron_in007.counter\[2\]
+ sky130_fd_sc_hd__edfxtp_1
Xnetwork.neuron_in007.counter\[3\]$_DFFE_PP_ clknet_leaf_185_clk_net
+ _02094_ _01497_ VSS VSS VDD VDD network.neuron_in007.counter\[3\]
+ sky130_fd_sc_hd__edfxtp_1
Xnetwork.neuron_in007.spike$_SDFFE_PP0P_ clknet_leaf_180_clk_net
+ _01858_ VSS VSS VDD VDD network.in_spk07_00 sky130_fd_sc_hd__dfxtp_1
Xnetwork.neuron_in008.counter\[0\]$_DFFE_PP_ clknet_leaf_177_clk_net
+ _02095_ _01496_ VSS VSS VDD VDD network.neuron_in008.counter\[0\]
+ sky130_fd_sc_hd__edfxtp_1
Xnetwork.neuron_in008.counter\[1\]$_DFFE_PP_ clknet_leaf_177_clk_net
+ _02096_ _01496_ VSS VSS VDD VDD network.neuron_in008.counter\[1\]
+ sky130_fd_sc_hd__edfxtp_1
Xnetwork.neuron_in008.counter\[2\]$_DFFE_PP_ clknet_leaf_177_clk_net
+ _02097_ _01496_ VSS VSS VDD VDD network.neuron_in008.counter\[2\]
+ sky130_fd_sc_hd__edfxtp_1
Xnetwork.neuron_in008.counter\[3\]$_DFFE_PP_ clknet_leaf_177_clk_net
+ _02098_ _01496_ VSS VSS VDD VDD network.neuron_in008.counter\[3\]
+ sky130_fd_sc_hd__edfxtp_1
Xnetwork.neuron_in008.spike$_SDFFE_PP0P_ clknet_leaf_180_clk_net
+ _01857_ VSS VSS VDD VDD network.in_spk08_00 sky130_fd_sc_hd__dfxtp_1
Xnetwork.neuron_in009.counter\[0\]$_DFFE_PP_ clknet_leaf_182_clk_net
+ _02099_ _01495_ VSS VSS VDD VDD network.neuron_in009.counter\[0\]
+ sky130_fd_sc_hd__edfxtp_1
Xnetwork.neuron_in009.counter\[1\]$_DFFE_PP_ clknet_leaf_182_clk_net
+ _02100_ _01495_ VSS VSS VDD VDD network.neuron_in009.counter\[1\]
+ sky130_fd_sc_hd__edfxtp_1
Xnetwork.neuron_in009.counter\[2\]$_DFFE_PP_ clknet_leaf_180_clk_net
+ _02101_ _01495_ VSS VSS VDD VDD network.neuron_in009.counter\[2\]
+ sky130_fd_sc_hd__edfxtp_1
Xnetwork.neuron_in009.counter\[3\]$_DFFE_PP_ clknet_leaf_180_clk_net
+ _02102_ _01495_ VSS VSS VDD VDD network.neuron_in009.counter\[3\]
+ sky130_fd_sc_hd__edfxtp_1
Xnetwork.neuron_in009.spike$_SDFFE_PP0P_ clknet_leaf_180_clk_net
+ _01856_ VSS VSS VDD VDD network.in_spk09_00 sky130_fd_sc_hd__dfxtp_1
Xnetwork.neuron_in010.counter\[0\]$_DFFE_PP_ clknet_leaf_177_clk_net
+ _02103_ _01494_ VSS VSS VDD VDD network.neuron_in010.counter\[0\]
+ sky130_fd_sc_hd__edfxtp_1
Xnetwork.neuron_in010.counter\[1\]$_DFFE_PP_ clknet_leaf_177_clk_net
+ _02104_ _01494_ VSS VSS VDD VDD network.neuron_in010.counter\[1\]
+ sky130_fd_sc_hd__edfxtp_1
Xnetwork.neuron_in010.counter\[2\]$_DFFE_PP_ clknet_leaf_177_clk_net
+ _02105_ _01494_ VSS VSS VDD VDD network.neuron_in010.counter\[2\]
+ sky130_fd_sc_hd__edfxtp_1
Xnetwork.neuron_in010.counter\[3\]$_DFFE_PP_ clknet_leaf_177_clk_net
+ _02106_ _01494_ VSS VSS VDD VDD network.neuron_in010.counter\[3\]
+ sky130_fd_sc_hd__edfxtp_1
Xnetwork.neuron_in010.spike$_SDFFE_PP0P_ clknet_leaf_179_clk_net
+ _01855_ VSS VSS VDD VDD network.in_spk10_00 sky130_fd_sc_hd__dfxtp_1
Xnetwork.neuron_in011.counter\[0\]$_DFFE_PP_ clknet_leaf_176_clk_net
+ _02107_ _01493_ VSS VSS VDD VDD network.neuron_in011.counter\[0\]
+ sky130_fd_sc_hd__edfxtp_1
Xnetwork.neuron_in011.counter\[1\]$_DFFE_PP_ clknet_leaf_176_clk_net
+ _02108_ _01493_ VSS VSS VDD VDD network.neuron_in011.counter\[1\]
+ sky130_fd_sc_hd__edfxtp_1
Xnetwork.neuron_in011.counter\[2\]$_DFFE_PP_ clknet_leaf_179_clk_net
+ _02109_ _01493_ VSS VSS VDD VDD network.neuron_in011.counter\[2\]
+ sky130_fd_sc_hd__edfxtp_1
Xnetwork.neuron_in011.counter\[3\]$_DFFE_PP_ clknet_leaf_179_clk_net
+ _02110_ _01493_ VSS VSS VDD VDD network.neuron_in011.counter\[3\]
+ sky130_fd_sc_hd__edfxtp_1
Xnetwork.neuron_in011.spike$_SDFFE_PP0P_ clknet_leaf_180_clk_net
+ _01854_ VSS VSS VDD VDD network.in_spk11_00 sky130_fd_sc_hd__dfxtp_1
Xnetwork.neuron_in012.counter\[0\]$_DFFE_PP_ clknet_leaf_180_clk_net
+ _02111_ _01492_ VSS VSS VDD VDD network.neuron_in012.counter\[0\]
+ sky130_fd_sc_hd__edfxtp_1
Xnetwork.neuron_in012.counter\[1\]$_DFFE_PP_ clknet_leaf_178_clk_net
+ _02112_ _01492_ VSS VSS VDD VDD network.neuron_in012.counter\[1\]
+ sky130_fd_sc_hd__edfxtp_1
Xnetwork.neuron_in012.counter\[2\]$_DFFE_PP_ clknet_leaf_178_clk_net
+ _02113_ _01492_ VSS VSS VDD VDD network.neuron_in012.counter\[2\]
+ sky130_fd_sc_hd__edfxtp_1
Xnetwork.neuron_in012.counter\[3\]$_DFFE_PP_ clknet_leaf_178_clk_net
+ _02114_ _01492_ VSS VSS VDD VDD network.neuron_in012.counter\[3\]
+ sky130_fd_sc_hd__edfxtp_1
Xnetwork.neuron_in012.spike$_SDFFE_PP0P_ clknet_leaf_181_clk_net
+ _01853_ VSS VSS VDD VDD network.in_spk12_00 sky130_fd_sc_hd__dfxtp_1
Xnetwork.neuron_in013.counter\[0\]$_DFFE_PP_ clknet_leaf_175_clk_net
+ _02115_ _01491_ VSS VSS VDD VDD network.neuron_in013.counter\[0\]
+ sky130_fd_sc_hd__edfxtp_1
Xnetwork.neuron_in013.counter\[1\]$_DFFE_PP_ clknet_leaf_175_clk_net
+ _02116_ _01491_ VSS VSS VDD VDD network.neuron_in013.counter\[1\]
+ sky130_fd_sc_hd__edfxtp_1
Xnetwork.neuron_in013.counter\[2\]$_DFFE_PP_ clknet_leaf_176_clk_net
+ _02117_ _01491_ VSS VSS VDD VDD network.neuron_in013.counter\[2\]
+ sky130_fd_sc_hd__edfxtp_1
Xnetwork.neuron_in013.counter\[3\]$_DFFE_PP_ clknet_leaf_176_clk_net
+ _02118_ _01491_ VSS VSS VDD VDD network.neuron_in013.counter\[3\]
+ sky130_fd_sc_hd__edfxtp_1
Xnetwork.neuron_in013.spike$_SDFFE_PP0P_ clknet_leaf_168_clk_net
+ _01852_ VSS VSS VDD VDD network.in_spk13_00 sky130_fd_sc_hd__dfxtp_1
Xnetwork.neuron_in014.counter\[0\]$_DFFE_PP_ clknet_leaf_167_clk_net
+ _02119_ _01490_ VSS VSS VDD VDD network.neuron_in014.counter\[0\]
+ sky130_fd_sc_hd__edfxtp_1
Xnetwork.neuron_in014.counter\[1\]$_DFFE_PP_ clknet_leaf_167_clk_net
+ _02120_ _01490_ VSS VSS VDD VDD network.neuron_in014.counter\[1\]
+ sky130_fd_sc_hd__edfxtp_1
Xnetwork.neuron_in014.counter\[2\]$_DFFE_PP_ clknet_leaf_169_clk_net
+ _02121_ _01490_ VSS VSS VDD VDD network.neuron_in014.counter\[2\]
+ sky130_fd_sc_hd__edfxtp_1
Xnetwork.neuron_in014.counter\[3\]$_DFFE_PP_ clknet_leaf_164_clk_net
+ _02122_ _01490_ VSS VSS VDD VDD network.neuron_in014.counter\[3\]
+ sky130_fd_sc_hd__edfxtp_1
Xnetwork.neuron_in014.spike$_SDFFE_PP0P_ clknet_leaf_167_clk_net
+ _01851_ VSS VSS VDD VDD network.in_spk14_00 sky130_fd_sc_hd__dfxtp_1
Xnetwork.neuron_in015.counter\[0\]$_DFFE_PP_ clknet_leaf_172_clk_net
+ _02123_ _01489_ VSS VSS VDD VDD network.neuron_in015.counter\[0\]
+ sky130_fd_sc_hd__edfxtp_1
Xnetwork.neuron_in015.counter\[1\]$_DFFE_PP_ clknet_leaf_172_clk_net
+ _02124_ _01489_ VSS VSS VDD VDD network.neuron_in015.counter\[1\]
+ sky130_fd_sc_hd__edfxtp_1
Xnetwork.neuron_in015.counter\[2\]$_DFFE_PP_ clknet_leaf_172_clk_net
+ _02125_ _01489_ VSS VSS VDD VDD network.neuron_in015.counter\[2\]
+ sky130_fd_sc_hd__edfxtp_1
Xnetwork.neuron_in015.counter\[3\]$_DFFE_PP_ clknet_leaf_176_clk_net
+ _02126_ _01489_ VSS VSS VDD VDD network.neuron_in015.counter\[3\]
+ sky130_fd_sc_hd__edfxtp_1
Xnetwork.neuron_in015.spike$_SDFFE_PP0P_ clknet_leaf_168_clk_net
+ _01850_ VSS VSS VDD VDD network.in_spk15_00 sky130_fd_sc_hd__dfxtp_1
Xnetwork.neuron_in016.counter\[0\]$_DFFE_PP_ clknet_leaf_167_clk_net
+ _02127_ _01488_ VSS VSS VDD VDD network.neuron_in016.counter\[0\]
+ sky130_fd_sc_hd__edfxtp_1
Xnetwork.neuron_in016.counter\[1\]$_DFFE_PP_ clknet_leaf_167_clk_net
+ _02128_ _01488_ VSS VSS VDD VDD network.neuron_in016.counter\[1\]
+ sky130_fd_sc_hd__edfxtp_1
Xnetwork.neuron_in016.counter\[2\]$_DFFE_PP_ clknet_leaf_167_clk_net
+ _02129_ _01488_ VSS VSS VDD VDD network.neuron_in016.counter\[2\]
+ sky130_fd_sc_hd__edfxtp_1
Xnetwork.neuron_in016.counter\[3\]$_DFFE_PP_ clknet_leaf_167_clk_net
+ _02130_ _01488_ VSS VSS VDD VDD network.neuron_in016.counter\[3\]
+ sky130_fd_sc_hd__edfxtp_1
Xnetwork.neuron_in016.spike$_SDFFE_PP0P_ clknet_leaf_167_clk_net
+ _01849_ VSS VSS VDD VDD network.in_spk00_01 sky130_fd_sc_hd__dfxtp_1
Xnetwork.neuron_in017.counter\[0\]$_DFFE_PP_ clknet_leaf_182_clk_net
+ _02131_ _01487_ VSS VSS VDD VDD network.neuron_in017.counter\[0\]
+ sky130_fd_sc_hd__edfxtp_1
Xnetwork.neuron_in017.counter\[1\]$_DFFE_PP_ clknet_leaf_182_clk_net
+ _02132_ _01487_ VSS VSS VDD VDD network.neuron_in017.counter\[1\]
+ sky130_fd_sc_hd__edfxtp_1
Xnetwork.neuron_in017.counter\[2\]$_DFFE_PP_ clknet_leaf_181_clk_net
+ _02133_ _01487_ VSS VSS VDD VDD network.neuron_in017.counter\[2\]
+ sky130_fd_sc_hd__edfxtp_1
Xnetwork.neuron_in017.counter\[3\]$_DFFE_PP_ clknet_leaf_4_clk_net
+ _02134_ _01487_ VSS VSS VDD VDD network.neuron_in017.counter\[3\]
+ sky130_fd_sc_hd__edfxtp_1
Xnetwork.neuron_in017.spike$_SDFFE_PP0P_ clknet_leaf_181_clk_net
+ _01848_ VSS VSS VDD VDD network.in_spk01_01 sky130_fd_sc_hd__dfxtp_1
Xnetwork.neuron_in018.counter\[0\]$_DFFE_PP_ clknet_leaf_181_clk_net
+ _02135_ _01486_ VSS VSS VDD VDD network.neuron_in018.counter\[0\]
+ sky130_fd_sc_hd__edfxtp_1
Xnetwork.neuron_in018.counter\[1\]$_DFFE_PP_ clknet_leaf_166_clk_net
+ _02136_ _01486_ VSS VSS VDD VDD network.neuron_in018.counter\[1\]
+ sky130_fd_sc_hd__edfxtp_1
Xnetwork.neuron_in018.counter\[2\]$_DFFE_PP_ clknet_leaf_17_clk_net
+ _02137_ _01486_ VSS VSS VDD VDD network.neuron_in018.counter\[2\]
+ sky130_fd_sc_hd__edfxtp_1
Xnetwork.neuron_in018.counter\[3\]$_DFFE_PP_ clknet_leaf_17_clk_net
+ _02138_ _01486_ VSS VSS VDD VDD network.neuron_in018.counter\[3\]
+ sky130_fd_sc_hd__edfxtp_1
Xnetwork.neuron_in018.spike$_SDFFE_PP0P_ clknet_leaf_181_clk_net
+ _01847_ VSS VSS VDD VDD network.in_spk02_01 sky130_fd_sc_hd__dfxtp_1
Xnetwork.neuron_in019.counter\[0\]$_DFFE_PP_ clknet_leaf_166_clk_net
+ _02139_ _01485_ VSS VSS VDD VDD network.neuron_in019.counter\[0\]
+ sky130_fd_sc_hd__edfxtp_1
Xnetwork.neuron_in019.counter\[1\]$_DFFE_PP_ clknet_leaf_166_clk_net
+ _02140_ _01485_ VSS VSS VDD VDD network.neuron_in019.counter\[1\]
+ sky130_fd_sc_hd__edfxtp_1
Xnetwork.neuron_in019.counter\[2\]$_DFFE_PP_ clknet_leaf_166_clk_net
+ _02141_ _01485_ VSS VSS VDD VDD network.neuron_in019.counter\[2\]
+ sky130_fd_sc_hd__edfxtp_1
Xnetwork.neuron_in019.counter\[3\]$_DFFE_PP_ clknet_leaf_166_clk_net
+ _02142_ _01485_ VSS VSS VDD VDD network.neuron_in019.counter\[3\]
+ sky130_fd_sc_hd__edfxtp_1
Xnetwork.neuron_in019.spike$_SDFFE_PP0P_ clknet_leaf_167_clk_net
+ _01846_ VSS VSS VDD VDD network.in_spk03_01 sky130_fd_sc_hd__dfxtp_1
Xnetwork.neuron_in020.counter\[0\]$_DFFE_PP_ clknet_leaf_2_clk_net
+ _02143_ _01484_ VSS VSS VDD VDD network.neuron_in020.counter\[0\]
+ sky130_fd_sc_hd__edfxtp_1
Xnetwork.neuron_in020.counter\[1\]$_DFFE_PP_ clknet_leaf_2_clk_net
+ _02144_ _01484_ VSS VSS VDD VDD network.neuron_in020.counter\[1\]
+ sky130_fd_sc_hd__edfxtp_1
Xnetwork.neuron_in020.counter\[2\]$_DFFE_PP_ clknet_leaf_3_clk_net
+ _02145_ _01484_ VSS VSS VDD VDD network.neuron_in020.counter\[2\]
+ sky130_fd_sc_hd__edfxtp_1
Xnetwork.neuron_in020.counter\[3\]$_DFFE_PP_ clknet_leaf_2_clk_net
+ _02146_ _01484_ VSS VSS VDD VDD network.neuron_in020.counter\[3\]
+ sky130_fd_sc_hd__edfxtp_1
Xnetwork.neuron_in020.spike$_SDFFE_PP0P_ clknet_leaf_182_clk_net
+ _01845_ VSS VSS VDD VDD network.in_spk04_01 sky130_fd_sc_hd__dfxtp_1
Xnetwork.neuron_in021.counter\[0\]$_DFFE_PP_ clknet_leaf_3_clk_net
+ _02147_ _01483_ VSS VSS VDD VDD network.neuron_in021.counter\[0\]
+ sky130_fd_sc_hd__edfxtp_1
Xnetwork.neuron_in021.counter\[1\]$_DFFE_PP_ clknet_leaf_3_clk_net
+ _02148_ _01483_ VSS VSS VDD VDD network.neuron_in021.counter\[1\]
+ sky130_fd_sc_hd__edfxtp_1
Xnetwork.neuron_in021.counter\[2\]$_DFFE_PP_ clknet_leaf_3_clk_net
+ _02149_ _01483_ VSS VSS VDD VDD network.neuron_in021.counter\[2\]
+ sky130_fd_sc_hd__edfxtp_1
Xnetwork.neuron_in021.counter\[3\]$_DFFE_PP_ clknet_leaf_3_clk_net
+ _02150_ _01483_ VSS VSS VDD VDD network.neuron_in021.counter\[3\]
+ sky130_fd_sc_hd__edfxtp_1
Xnetwork.neuron_in021.spike$_SDFFE_PP0P_ clknet_leaf_181_clk_net
+ _01844_ VSS VSS VDD VDD network.in_spk05_01 sky130_fd_sc_hd__dfxtp_1
Xnetwork.neuron_in022.counter\[0\]$_DFFE_PP_ clknet_leaf_4_clk_net
+ _02151_ _01482_ VSS VSS VDD VDD network.neuron_in022.counter\[0\]
+ sky130_fd_sc_hd__edfxtp_1
Xnetwork.neuron_in022.counter\[1\]$_DFFE_PP_ clknet_leaf_4_clk_net
+ _02152_ _01482_ VSS VSS VDD VDD network.neuron_in022.counter\[1\]
+ sky130_fd_sc_hd__edfxtp_1
Xnetwork.neuron_in022.counter\[2\]$_DFFE_PP_ clknet_leaf_4_clk_net
+ _02153_ _01482_ VSS VSS VDD VDD network.neuron_in022.counter\[2\]
+ sky130_fd_sc_hd__edfxtp_1
Xnetwork.neuron_in022.counter\[3\]$_DFFE_PP_ clknet_leaf_4_clk_net
+ _02154_ _01482_ VSS VSS VDD VDD network.neuron_in022.counter\[3\]
+ sky130_fd_sc_hd__edfxtp_1
Xnetwork.neuron_in022.spike$_SDFFE_PP0P_ clknet_leaf_181_clk_net
+ _01843_ VSS VSS VDD VDD network.in_spk06_01 sky130_fd_sc_hd__dfxtp_1
Xnetwork.neuron_in023.counter\[0\]$_DFFE_PP_ clknet_leaf_165_clk_net
+ _02155_ _01481_ VSS VSS VDD VDD network.neuron_in023.counter\[0\]
+ sky130_fd_sc_hd__edfxtp_1
Xnetwork.neuron_in023.counter\[1\]$_DFFE_PP_ clknet_leaf_165_clk_net
+ _02156_ _01481_ VSS VSS VDD VDD network.neuron_in023.counter\[1\]
+ sky130_fd_sc_hd__edfxtp_1
Xnetwork.neuron_in023.counter\[2\]$_DFFE_PP_ clknet_leaf_164_clk_net
+ _02157_ _01481_ VSS VSS VDD VDD network.neuron_in023.counter\[2\]
+ sky130_fd_sc_hd__edfxtp_1
Xnetwork.neuron_in023.counter\[3\]$_DFFE_PP_ clknet_leaf_165_clk_net
+ _02158_ _01481_ VSS VSS VDD VDD network.neuron_in023.counter\[3\]
+ sky130_fd_sc_hd__edfxtp_1
Xnetwork.neuron_in023.spike$_SDFFE_PP0P_ clknet_leaf_181_clk_net
+ _01842_ VSS VSS VDD VDD network.in_spk07_01 sky130_fd_sc_hd__dfxtp_1
Xnetwork.neuron_in024.counter\[0\]$_DFFE_PP_ clknet_leaf_187_clk_net
+ _02159_ _01480_ VSS VSS VDD VDD network.neuron_in024.counter\[0\]
+ sky130_fd_sc_hd__edfxtp_1
Xnetwork.neuron_in024.counter\[1\]$_DFFE_PP_ clknet_leaf_187_clk_net
+ _02160_ _01480_ VSS VSS VDD VDD network.neuron_in024.counter\[1\]
+ sky130_fd_sc_hd__edfxtp_1
Xnetwork.neuron_in024.counter\[2\]$_DFFE_PP_ clknet_leaf_3_clk_net
+ _02161_ _01480_ VSS VSS VDD VDD network.neuron_in024.counter\[2\]
+ sky130_fd_sc_hd__edfxtp_1
Xnetwork.neuron_in024.counter\[3\]$_DFFE_PP_ clknet_leaf_0_clk_net
+ _02162_ _01480_ VSS VSS VDD VDD network.neuron_in024.counter\[3\]
+ sky130_fd_sc_hd__edfxtp_1
Xnetwork.neuron_in024.spike$_SDFFE_PP0P_ clknet_leaf_182_clk_net
+ _01841_ VSS VSS VDD VDD network.in_spk08_01 sky130_fd_sc_hd__dfxtp_1
Xnetwork.neuron_in025.counter\[0\]$_DFFE_PP_ clknet_leaf_183_clk_net
+ _02163_ _01479_ VSS VSS VDD VDD network.neuron_in025.counter\[0\]
+ sky130_fd_sc_hd__edfxtp_1
Xnetwork.neuron_in025.counter\[1\]$_DFFE_PP_ clknet_leaf_183_clk_net
+ _02164_ _01479_ VSS VSS VDD VDD network.neuron_in025.counter\[1\]
+ sky130_fd_sc_hd__edfxtp_1
Xnetwork.neuron_in025.counter\[2\]$_DFFE_PP_ clknet_leaf_183_clk_net
+ _02165_ _01479_ VSS VSS VDD VDD network.neuron_in025.counter\[2\]
+ sky130_fd_sc_hd__edfxtp_1
Xnetwork.neuron_in025.counter\[3\]$_DFFE_PP_ clknet_leaf_186_clk_net
+ _02166_ _01479_ VSS VSS VDD VDD network.neuron_in025.counter\[3\]
+ sky130_fd_sc_hd__edfxtp_1
Xnetwork.neuron_in025.spike$_SDFFE_PP0P_ clknet_leaf_182_clk_net
+ _01840_ VSS VSS VDD VDD network.in_spk09_01 sky130_fd_sc_hd__dfxtp_1
Xnetwork.neuron_in026.counter\[0\]$_DFFE_PP_ clknet_leaf_3_clk_net
+ _02167_ _01478_ VSS VSS VDD VDD network.neuron_in026.counter\[0\]
+ sky130_fd_sc_hd__edfxtp_1
Xnetwork.neuron_in026.counter\[1\]$_DFFE_PP_ clknet_leaf_3_clk_net
+ _02168_ _01478_ VSS VSS VDD VDD network.neuron_in026.counter\[1\]
+ sky130_fd_sc_hd__edfxtp_1
Xnetwork.neuron_in026.counter\[2\]$_DFFE_PP_ clknet_leaf_183_clk_net
+ _02169_ _01478_ VSS VSS VDD VDD network.neuron_in026.counter\[2\]
+ sky130_fd_sc_hd__edfxtp_1
Xnetwork.neuron_in026.counter\[3\]$_DFFE_PP_ clknet_leaf_183_clk_net
+ _02170_ _01478_ VSS VSS VDD VDD network.neuron_in026.counter\[3\]
+ sky130_fd_sc_hd__edfxtp_1
Xnetwork.neuron_in026.spike$_SDFFE_PP0P_ clknet_leaf_182_clk_net
+ _01839_ VSS VSS VDD VDD network.in_spk10_01 sky130_fd_sc_hd__dfxtp_1
Xnetwork.neuron_in027.counter\[0\]$_DFFE_PP_ clknet_leaf_187_clk_net
+ _02171_ _01477_ VSS VSS VDD VDD network.neuron_in027.counter\[0\]
+ sky130_fd_sc_hd__edfxtp_1
Xnetwork.neuron_in027.counter\[1\]$_DFFE_PP_ clknet_leaf_187_clk_net
+ _02172_ _01477_ VSS VSS VDD VDD network.neuron_in027.counter\[1\]
+ sky130_fd_sc_hd__edfxtp_1
Xnetwork.neuron_in027.counter\[2\]$_DFFE_PP_ clknet_leaf_187_clk_net
+ _02173_ _01477_ VSS VSS VDD VDD network.neuron_in027.counter\[2\]
+ sky130_fd_sc_hd__edfxtp_1
Xnetwork.neuron_in027.counter\[3\]$_DFFE_PP_ clknet_leaf_0_clk_net
+ _02174_ _01477_ VSS VSS VDD VDD network.neuron_in027.counter\[3\]
+ sky130_fd_sc_hd__edfxtp_1
Xnetwork.neuron_in027.spike$_SDFFE_PP0P_ clknet_leaf_182_clk_net
+ _01838_ VSS VSS VDD VDD network.in_spk11_01 sky130_fd_sc_hd__dfxtp_1
Xnetwork.neuron_in028.counter\[0\]$_DFFE_PP_ clknet_leaf_185_clk_net
+ _02175_ _01476_ VSS VSS VDD VDD network.neuron_in028.counter\[0\]
+ sky130_fd_sc_hd__edfxtp_1
Xnetwork.neuron_in028.counter\[1\]$_DFFE_PP_ clknet_leaf_185_clk_net
+ _02176_ _01476_ VSS VSS VDD VDD network.neuron_in028.counter\[1\]
+ sky130_fd_sc_hd__edfxtp_1
Xnetwork.neuron_in028.counter\[2\]$_DFFE_PP_ clknet_leaf_186_clk_net
+ _02177_ _01476_ VSS VSS VDD VDD network.neuron_in028.counter\[2\]
+ sky130_fd_sc_hd__edfxtp_1
Xnetwork.neuron_in028.counter\[3\]$_DFFE_PP_ clknet_leaf_185_clk_net
+ _02178_ _01476_ VSS VSS VDD VDD network.neuron_in028.counter\[3\]
+ sky130_fd_sc_hd__edfxtp_1
Xnetwork.neuron_in028.spike$_SDFFE_PP0P_ clknet_leaf_183_clk_net
+ _01837_ VSS VSS VDD VDD network.in_spk12_01 sky130_fd_sc_hd__dfxtp_1
Xnetwork.neuron_in029.counter\[0\]$_DFFE_PP_ clknet_leaf_0_clk_net
+ _02179_ _01475_ VSS VSS VDD VDD network.neuron_in029.counter\[0\]
+ sky130_fd_sc_hd__edfxtp_1
Xnetwork.neuron_in029.counter\[1\]$_DFFE_PP_ clknet_leaf_0_clk_net
+ _02180_ _01475_ VSS VSS VDD VDD network.neuron_in029.counter\[1\]
+ sky130_fd_sc_hd__edfxtp_1
Xnetwork.neuron_in029.counter\[2\]$_DFFE_PP_ clknet_leaf_0_clk_net
+ _02181_ _01475_ VSS VSS VDD VDD network.neuron_in029.counter\[2\]
+ sky130_fd_sc_hd__edfxtp_1
Xnetwork.neuron_in029.counter\[3\]$_DFFE_PP_ clknet_leaf_0_clk_net
+ _02182_ _01475_ VSS VSS VDD VDD network.neuron_in029.counter\[3\]
+ sky130_fd_sc_hd__edfxtp_1
Xnetwork.neuron_in029.spike$_SDFFE_PP0P_ clknet_leaf_182_clk_net
+ _01836_ VSS VSS VDD VDD network.in_spk13_01 sky130_fd_sc_hd__dfxtp_1
Xnetwork.neuron_in030.counter\[0\]$_DFFE_PP_ clknet_leaf_186_clk_net
+ _02183_ _01474_ VSS VSS VDD VDD network.neuron_in030.counter\[0\]
+ sky130_fd_sc_hd__edfxtp_1
Xnetwork.neuron_in030.counter\[1\]$_DFFE_PP_ clknet_leaf_187_clk_net
+ _02184_ _01474_ VSS VSS VDD VDD network.neuron_in030.counter\[1\]
+ sky130_fd_sc_hd__edfxtp_1
Xnetwork.neuron_in030.counter\[2\]$_DFFE_PP_ clknet_leaf_186_clk_net
+ _02185_ _01474_ VSS VSS VDD VDD network.neuron_in030.counter\[2\]
+ sky130_fd_sc_hd__edfxtp_1
Xnetwork.neuron_in030.counter\[3\]$_DFFE_PP_ clknet_leaf_186_clk_net
+ _02186_ _01474_ VSS VSS VDD VDD network.neuron_in030.counter\[3\]
+ sky130_fd_sc_hd__edfxtp_1
Xnetwork.neuron_in030.spike$_SDFFE_PP0P_ clknet_leaf_183_clk_net
+ _01835_ VSS VSS VDD VDD network.in_spk14_01 sky130_fd_sc_hd__dfxtp_1
Xnetwork.neuron_in031.counter\[0\]$_DFFE_PP_ clknet_leaf_187_clk_net
+ _02187_ _01473_ VSS VSS VDD VDD network.neuron_in031.counter\[0\]
+ sky130_fd_sc_hd__edfxtp_1
Xnetwork.neuron_in031.counter\[1\]$_DFFE_PP_ clknet_leaf_186_clk_net
+ _02188_ _01473_ VSS VSS VDD VDD network.neuron_in031.counter\[1\]
+ sky130_fd_sc_hd__edfxtp_1
Xnetwork.neuron_in031.counter\[2\]$_DFFE_PP_ clknet_leaf_186_clk_net
+ _02189_ _01473_ VSS VSS VDD VDD network.neuron_in031.counter\[2\]
+ sky130_fd_sc_hd__edfxtp_1
Xnetwork.neuron_in031.counter\[3\]$_DFFE_PP_ clknet_leaf_186_clk_net
+ _02190_ _01473_ VSS VSS VDD VDD network.neuron_in031.counter\[3\]
+ sky130_fd_sc_hd__edfxtp_1
Xnetwork.neuron_in031.spike$_SDFFE_PP0P_ clknet_leaf_183_clk_net
+ _01834_ VSS VSS VDD VDD network.in_spk15_01 sky130_fd_sc_hd__dfxtp_1
Xnetwork.neuron_in032.counter\[0\]$_DFFE_PP_ clknet_leaf_170_clk_net
+ _02191_ _01472_ VSS VSS VDD VDD network.neuron_in032.counter\[0\]
+ sky130_fd_sc_hd__edfxtp_1
Xnetwork.neuron_in032.counter\[1\]$_DFFE_PP_ clknet_leaf_164_clk_net
+ _02192_ _01472_ VSS VSS VDD VDD network.neuron_in032.counter\[1\]
+ sky130_fd_sc_hd__edfxtp_1
Xnetwork.neuron_in032.counter\[2\]$_DFFE_PP_ clknet_leaf_164_clk_net
+ _02193_ _01472_ VSS VSS VDD VDD network.neuron_in032.counter\[2\]
+ sky130_fd_sc_hd__edfxtp_1
Xnetwork.neuron_in032.counter\[3\]$_DFFE_PP_ clknet_leaf_170_clk_net
+ _02194_ _01472_ VSS VSS VDD VDD network.neuron_in032.counter\[3\]
+ sky130_fd_sc_hd__edfxtp_1
Xnetwork.neuron_in032.spike$_SDFFE_PP0P_ clknet_leaf_169_clk_net
+ _01833_ VSS VSS VDD VDD network.in_spk00_02 sky130_fd_sc_hd__dfxtp_1
Xnetwork.neuron_in033.counter\[0\]$_DFFE_PP_ clknet_leaf_164_clk_net
+ _02195_ _01471_ VSS VSS VDD VDD network.neuron_in033.counter\[0\]
+ sky130_fd_sc_hd__edfxtp_1
Xnetwork.neuron_in033.counter\[1\]$_DFFE_PP_ clknet_leaf_164_clk_net
+ _02196_ _01471_ VSS VSS VDD VDD network.neuron_in033.counter\[1\]
+ sky130_fd_sc_hd__edfxtp_1
Xnetwork.neuron_in033.counter\[2\]$_DFFE_PP_ clknet_leaf_164_clk_net
+ _02197_ _01471_ VSS VSS VDD VDD network.neuron_in033.counter\[2\]
+ sky130_fd_sc_hd__edfxtp_1
Xnetwork.neuron_in033.counter\[3\]$_DFFE_PP_ clknet_leaf_164_clk_net
+ _02198_ _01471_ VSS VSS VDD VDD network.neuron_in033.counter\[3\]
+ sky130_fd_sc_hd__edfxtp_1
Xnetwork.neuron_in033.spike$_SDFFE_PP0P_ clknet_leaf_169_clk_net
+ _01832_ VSS VSS VDD VDD network.in_spk01_02 sky130_fd_sc_hd__dfxtp_1
Xnetwork.neuron_in034.counter\[0\]$_DFFE_PP_ clknet_leaf_151_clk_net
+ _02199_ _01470_ VSS VSS VDD VDD network.neuron_in034.counter\[0\]
+ sky130_fd_sc_hd__edfxtp_1
Xnetwork.neuron_in034.counter\[1\]$_DFFE_PP_ clknet_leaf_151_clk_net
+ _02200_ _01470_ VSS VSS VDD VDD network.neuron_in034.counter\[1\]
+ sky130_fd_sc_hd__edfxtp_1
Xnetwork.neuron_in034.counter\[2\]$_DFFE_PP_ clknet_leaf_151_clk_net
+ _02201_ _01470_ VSS VSS VDD VDD network.neuron_in034.counter\[2\]
+ sky130_fd_sc_hd__edfxtp_1
Xnetwork.neuron_in034.counter\[3\]$_DFFE_PP_ clknet_leaf_151_clk_net
+ _02202_ _01470_ VSS VSS VDD VDD network.neuron_in034.counter\[3\]
+ sky130_fd_sc_hd__edfxtp_1
Xnetwork.neuron_in034.spike$_SDFFE_PP0P_ clknet_leaf_170_clk_net
+ _01831_ VSS VSS VDD VDD network.in_spk02_02 sky130_fd_sc_hd__dfxtp_1
Xnetwork.neuron_in035.counter\[0\]$_DFFE_PP_ clknet_leaf_150_clk_net
+ _02203_ _01469_ VSS VSS VDD VDD network.neuron_in035.counter\[0\]
+ sky130_fd_sc_hd__edfxtp_1
Xnetwork.neuron_in035.counter\[1\]$_DFFE_PP_ clknet_leaf_150_clk_net
+ _02204_ _01469_ VSS VSS VDD VDD network.neuron_in035.counter\[1\]
+ sky130_fd_sc_hd__edfxtp_1
Xnetwork.neuron_in035.counter\[2\]$_DFFE_PP_ clknet_leaf_150_clk_net
+ _02205_ _01469_ VSS VSS VDD VDD network.neuron_in035.counter\[2\]
+ sky130_fd_sc_hd__edfxtp_1
Xnetwork.neuron_in035.counter\[3\]$_DFFE_PP_ clknet_leaf_150_clk_net
+ _02206_ _01469_ VSS VSS VDD VDD network.neuron_in035.counter\[3\]
+ sky130_fd_sc_hd__edfxtp_1
Xnetwork.neuron_in035.spike$_SDFFE_PP0P_ clknet_leaf_169_clk_net
+ _01830_ VSS VSS VDD VDD network.in_spk03_02 sky130_fd_sc_hd__dfxtp_1
Xnetwork.neuron_in036.counter\[0\]$_DFFE_PP_ clknet_leaf_170_clk_net
+ _02207_ _01468_ VSS VSS VDD VDD network.neuron_in036.counter\[0\]
+ sky130_fd_sc_hd__edfxtp_1
Xnetwork.neuron_in036.counter\[1\]$_DFFE_PP_ clknet_leaf_170_clk_net
+ _02208_ _01468_ VSS VSS VDD VDD network.neuron_in036.counter\[1\]
+ sky130_fd_sc_hd__edfxtp_1
Xnetwork.neuron_in036.counter\[2\]$_DFFE_PP_ clknet_leaf_170_clk_net
+ _02209_ _01468_ VSS VSS VDD VDD network.neuron_in036.counter\[2\]
+ sky130_fd_sc_hd__edfxtp_1
Xnetwork.neuron_in036.counter\[3\]$_DFFE_PP_ clknet_leaf_150_clk_net
+ _02210_ _01468_ VSS VSS VDD VDD network.neuron_in036.counter\[3\]
+ sky130_fd_sc_hd__edfxtp_1
Xnetwork.neuron_in036.spike$_SDFFE_PP0P_ clknet_leaf_170_clk_net
+ _01829_ VSS VSS VDD VDD network.in_spk04_02 sky130_fd_sc_hd__dfxtp_1
Xnetwork.neuron_in037.counter\[0\]$_DFFE_PP_ clknet_leaf_147_clk_net
+ _02211_ _01467_ VSS VSS VDD VDD network.neuron_in037.counter\[0\]
+ sky130_fd_sc_hd__edfxtp_1
Xnetwork.neuron_in037.counter\[1\]$_DFFE_PP_ clknet_leaf_147_clk_net
+ _02212_ _01467_ VSS VSS VDD VDD network.neuron_in037.counter\[1\]
+ sky130_fd_sc_hd__edfxtp_1
Xnetwork.neuron_in037.counter\[2\]$_DFFE_PP_ clknet_leaf_147_clk_net
+ _02213_ _01467_ VSS VSS VDD VDD network.neuron_in037.counter\[2\]
+ sky130_fd_sc_hd__edfxtp_1
Xnetwork.neuron_in037.counter\[3\]$_DFFE_PP_ clknet_leaf_147_clk_net
+ _02214_ _01467_ VSS VSS VDD VDD network.neuron_in037.counter\[3\]
+ sky130_fd_sc_hd__edfxtp_1
Xnetwork.neuron_in037.spike$_SDFFE_PP0P_ clknet_leaf_170_clk_net
+ _01828_ VSS VSS VDD VDD network.in_spk05_02 sky130_fd_sc_hd__dfxtp_1
Xnetwork.neuron_in038.counter\[0\]$_DFFE_PP_ clknet_leaf_149_clk_net
+ _02215_ _01466_ VSS VSS VDD VDD network.neuron_in038.counter\[0\]
+ sky130_fd_sc_hd__edfxtp_1
Xnetwork.neuron_in038.counter\[1\]$_DFFE_PP_ clknet_leaf_149_clk_net
+ _02216_ _01466_ VSS VSS VDD VDD network.neuron_in038.counter\[1\]
+ sky130_fd_sc_hd__edfxtp_1
Xnetwork.neuron_in038.counter\[2\]$_DFFE_PP_ clknet_leaf_149_clk_net
+ _02217_ _01466_ VSS VSS VDD VDD network.neuron_in038.counter\[2\]
+ sky130_fd_sc_hd__edfxtp_1
Xnetwork.neuron_in038.counter\[3\]$_DFFE_PP_ clknet_leaf_149_clk_net
+ _02218_ _01466_ VSS VSS VDD VDD network.neuron_in038.counter\[3\]
+ sky130_fd_sc_hd__edfxtp_1
Xnetwork.neuron_in038.spike$_SDFFE_PP0P_ clknet_leaf_171_clk_net
+ _01827_ VSS VSS VDD VDD network.in_spk06_02 sky130_fd_sc_hd__dfxtp_1
Xnetwork.neuron_in039.counter\[0\]$_DFFE_PP_ clknet_leaf_150_clk_net
+ _02219_ _01465_ VSS VSS VDD VDD network.neuron_in039.counter\[0\]
+ sky130_fd_sc_hd__edfxtp_1
Xnetwork.neuron_in039.counter\[1\]$_DFFE_PP_ clknet_leaf_150_clk_net
+ _02220_ _01465_ VSS VSS VDD VDD network.neuron_in039.counter\[1\]
+ sky130_fd_sc_hd__edfxtp_1
Xnetwork.neuron_in039.counter\[2\]$_DFFE_PP_ clknet_leaf_149_clk_net
+ _02221_ _01465_ VSS VSS VDD VDD network.neuron_in039.counter\[2\]
+ sky130_fd_sc_hd__edfxtp_1
Xnetwork.neuron_in039.counter\[3\]$_DFFE_PP_ clknet_leaf_150_clk_net
+ _02222_ _01465_ VSS VSS VDD VDD network.neuron_in039.counter\[3\]
+ sky130_fd_sc_hd__edfxtp_1
Xnetwork.neuron_in039.spike$_SDFFE_PP0P_ clknet_leaf_171_clk_net
+ _01826_ VSS VSS VDD VDD network.in_spk07_02 sky130_fd_sc_hd__dfxtp_1
Xnetwork.neuron_in040.counter\[0\]$_DFFE_PP_ clknet_leaf_173_clk_net
+ _02223_ _01464_ VSS VSS VDD VDD network.neuron_in040.counter\[0\]
+ sky130_fd_sc_hd__edfxtp_1
Xnetwork.neuron_in040.counter\[1\]$_DFFE_PP_ clknet_leaf_148_clk_net
+ _02224_ _01464_ VSS VSS VDD VDD network.neuron_in040.counter\[1\]
+ sky130_fd_sc_hd__edfxtp_1
Xnetwork.neuron_in040.counter\[2\]$_DFFE_PP_ clknet_leaf_148_clk_net
+ _02225_ _01464_ VSS VSS VDD VDD network.neuron_in040.counter\[2\]
+ sky130_fd_sc_hd__edfxtp_1
Xnetwork.neuron_in040.counter\[3\]$_DFFE_PP_ clknet_leaf_148_clk_net
+ _02226_ _01464_ VSS VSS VDD VDD network.neuron_in040.counter\[3\]
+ sky130_fd_sc_hd__edfxtp_1
Xnetwork.neuron_in040.spike$_SDFFE_PP0P_ clknet_leaf_171_clk_net
+ _01825_ VSS VSS VDD VDD network.in_spk08_02 sky130_fd_sc_hd__dfxtp_1
Xnetwork.neuron_in041.counter\[0\]$_DFFE_PP_ clknet_leaf_173_clk_net
+ _02227_ _01463_ VSS VSS VDD VDD network.neuron_in041.counter\[0\]
+ sky130_fd_sc_hd__edfxtp_1
Xnetwork.neuron_in041.counter\[1\]$_DFFE_PP_ clknet_leaf_171_clk_net
+ _02228_ _01463_ VSS VSS VDD VDD network.neuron_in041.counter\[1\]
+ sky130_fd_sc_hd__edfxtp_1
Xnetwork.neuron_in041.counter\[2\]$_DFFE_PP_ clknet_leaf_171_clk_net
+ _02229_ _01463_ VSS VSS VDD VDD network.neuron_in041.counter\[2\]
+ sky130_fd_sc_hd__edfxtp_1
Xnetwork.neuron_in041.counter\[3\]$_DFFE_PP_ clknet_leaf_171_clk_net
+ _02230_ _01463_ VSS VSS VDD VDD network.neuron_in041.counter\[3\]
+ sky130_fd_sc_hd__edfxtp_1
Xnetwork.neuron_in041.spike$_SDFFE_PP0P_ clknet_leaf_171_clk_net
+ _01824_ VSS VSS VDD VDD network.in_spk09_02 sky130_fd_sc_hd__dfxtp_1
Xnetwork.neuron_in042.counter\[0\]$_DFFE_PP_ clknet_leaf_174_clk_net
+ _02231_ _01462_ VSS VSS VDD VDD network.neuron_in042.counter\[0\]
+ sky130_fd_sc_hd__edfxtp_1
Xnetwork.neuron_in042.counter\[1\]$_DFFE_PP_ clknet_leaf_174_clk_net
+ _02232_ _01462_ VSS VSS VDD VDD network.neuron_in042.counter\[1\]
+ sky130_fd_sc_hd__edfxtp_1
Xnetwork.neuron_in042.counter\[2\]$_DFFE_PP_ clknet_leaf_173_clk_net
+ _02233_ _01462_ VSS VSS VDD VDD network.neuron_in042.counter\[2\]
+ sky130_fd_sc_hd__edfxtp_1
Xnetwork.neuron_in042.counter\[3\]$_DFFE_PP_ clknet_leaf_173_clk_net
+ _02234_ _01462_ VSS VSS VDD VDD network.neuron_in042.counter\[3\]
+ sky130_fd_sc_hd__edfxtp_1
Xnetwork.neuron_in042.spike$_SDFFE_PP0P_ clknet_leaf_171_clk_net
+ _01823_ VSS VSS VDD VDD network.in_spk10_02 sky130_fd_sc_hd__dfxtp_1
Xnetwork.neuron_in043.counter\[0\]$_DFFE_PP_ clknet_leaf_172_clk_net
+ _02235_ _01461_ VSS VSS VDD VDD network.neuron_in043.counter\[0\]
+ sky130_fd_sc_hd__edfxtp_1
Xnetwork.neuron_in043.counter\[1\]$_DFFE_PP_ clknet_leaf_172_clk_net
+ _02236_ _01461_ VSS VSS VDD VDD network.neuron_in043.counter\[1\]
+ sky130_fd_sc_hd__edfxtp_1
Xnetwork.neuron_in043.counter\[2\]$_DFFE_PP_ clknet_leaf_173_clk_net
+ _02237_ _01461_ VSS VSS VDD VDD network.neuron_in043.counter\[2\]
+ sky130_fd_sc_hd__edfxtp_1
Xnetwork.neuron_in043.counter\[3\]$_DFFE_PP_ clknet_leaf_173_clk_net
+ _02238_ _01461_ VSS VSS VDD VDD network.neuron_in043.counter\[3\]
+ sky130_fd_sc_hd__edfxtp_1
Xnetwork.neuron_in043.spike$_SDFFE_PP0P_ clknet_leaf_171_clk_net
+ _01822_ VSS VSS VDD VDD network.in_spk11_02 sky130_fd_sc_hd__dfxtp_1
Xnetwork.neuron_in044.counter\[0\]$_DFFE_PP_ clknet_leaf_175_clk_net
+ _02239_ _01460_ VSS VSS VDD VDD network.neuron_in044.counter\[0\]
+ sky130_fd_sc_hd__edfxtp_1
Xnetwork.neuron_in044.counter\[1\]$_DFFE_PP_ clknet_leaf_174_clk_net
+ _02240_ _01460_ VSS VSS VDD VDD network.neuron_in044.counter\[1\]
+ sky130_fd_sc_hd__edfxtp_1
Xnetwork.neuron_in044.counter\[2\]$_DFFE_PP_ clknet_leaf_174_clk_net
+ _02241_ _01460_ VSS VSS VDD VDD network.neuron_in044.counter\[2\]
+ sky130_fd_sc_hd__edfxtp_1
Xnetwork.neuron_in044.counter\[3\]$_DFFE_PP_ clknet_leaf_174_clk_net
+ _02242_ _01460_ VSS VSS VDD VDD network.neuron_in044.counter\[3\]
+ sky130_fd_sc_hd__edfxtp_1
Xnetwork.neuron_in044.spike$_SDFFE_PP0P_ clknet_leaf_172_clk_net
+ _01821_ VSS VSS VDD VDD network.in_spk12_02 sky130_fd_sc_hd__dfxtp_1
Xnetwork.neuron_in045.counter\[0\]$_DFFE_PP_ clknet_leaf_175_clk_net
+ _02243_ _01459_ VSS VSS VDD VDD network.neuron_in045.counter\[0\]
+ sky130_fd_sc_hd__edfxtp_1
Xnetwork.neuron_in045.counter\[1\]$_DFFE_PP_ clknet_leaf_175_clk_net
+ _02244_ _01459_ VSS VSS VDD VDD network.neuron_in045.counter\[1\]
+ sky130_fd_sc_hd__edfxtp_1
Xnetwork.neuron_in045.counter\[2\]$_DFFE_PP_ clknet_leaf_175_clk_net
+ _02245_ _01459_ VSS VSS VDD VDD network.neuron_in045.counter\[2\]
+ sky130_fd_sc_hd__edfxtp_1
Xnetwork.neuron_in045.counter\[3\]$_DFFE_PP_ clknet_leaf_175_clk_net
+ _02246_ _01459_ VSS VSS VDD VDD network.neuron_in045.counter\[3\]
+ sky130_fd_sc_hd__edfxtp_1
Xnetwork.neuron_in045.spike$_SDFFE_PP0P_ clknet_leaf_172_clk_net
+ _01820_ VSS VSS VDD VDD network.in_spk13_02 sky130_fd_sc_hd__dfxtp_1
Xnetwork.neuron_in046.counter\[0\]$_DFFE_PP_ clknet_leaf_148_clk_net
+ _02247_ _01458_ VSS VSS VDD VDD network.neuron_in046.counter\[0\]
+ sky130_fd_sc_hd__edfxtp_1
Xnetwork.neuron_in046.counter\[1\]$_DFFE_PP_ clknet_leaf_148_clk_net
+ _02248_ _01458_ VSS VSS VDD VDD network.neuron_in046.counter\[1\]
+ sky130_fd_sc_hd__edfxtp_1
Xnetwork.neuron_in046.counter\[2\]$_DFFE_PP_ clknet_leaf_147_clk_net
+ _02249_ _01458_ VSS VSS VDD VDD network.neuron_in046.counter\[2\]
+ sky130_fd_sc_hd__edfxtp_1
Xnetwork.neuron_in046.counter\[3\]$_DFFE_PP_ clknet_leaf_147_clk_net
+ _02250_ _01458_ VSS VSS VDD VDD network.neuron_in046.counter\[3\]
+ sky130_fd_sc_hd__edfxtp_1
Xnetwork.neuron_in046.spike$_SDFFE_PP0P_ clknet_leaf_173_clk_net
+ _01819_ VSS VSS VDD VDD network.in_spk14_02 sky130_fd_sc_hd__dfxtp_1
Xnetwork.neuron_in047.counter\[0\]$_DFFE_PP_ clknet_leaf_174_clk_net
+ _02251_ _01457_ VSS VSS VDD VDD network.neuron_in047.counter\[0\]
+ sky130_fd_sc_hd__edfxtp_1
Xnetwork.neuron_in047.counter\[1\]$_DFFE_PP_ clknet_leaf_174_clk_net
+ _02252_ _01457_ VSS VSS VDD VDD network.neuron_in047.counter\[1\]
+ sky130_fd_sc_hd__edfxtp_1
Xnetwork.neuron_in047.counter\[2\]$_DFFE_PP_ clknet_leaf_174_clk_net
+ _02253_ _01457_ VSS VSS VDD VDD network.neuron_in047.counter\[2\]
+ sky130_fd_sc_hd__edfxtp_1
Xnetwork.neuron_in047.counter\[3\]$_DFFE_PP_ clknet_leaf_148_clk_net
+ _02254_ _01457_ VSS VSS VDD VDD network.neuron_in047.counter\[3\]
+ sky130_fd_sc_hd__edfxtp_1
Xnetwork.neuron_in047.spike$_SDFFE_PP0P_ clknet_leaf_173_clk_net
+ _01818_ VSS VSS VDD VDD network.in_spk15_02 sky130_fd_sc_hd__dfxtp_1
Xnetwork.neuron_in048.counter\[0\]$_DFFE_PP_ clknet_leaf_18_clk_net
+ _02255_ _01456_ VSS VSS VDD VDD network.neuron_in048.counter\[0\]
+ sky130_fd_sc_hd__edfxtp_1
Xnetwork.neuron_in048.counter\[1\]$_DFFE_PP_ clknet_leaf_18_clk_net
+ _02256_ _01456_ VSS VSS VDD VDD network.neuron_in048.counter\[1\]
+ sky130_fd_sc_hd__edfxtp_1
Xnetwork.neuron_in048.counter\[2\]$_DFFE_PP_ clknet_leaf_18_clk_net
+ _02257_ _01456_ VSS VSS VDD VDD network.neuron_in048.counter\[2\]
+ sky130_fd_sc_hd__edfxtp_1
Xnetwork.neuron_in048.counter\[3\]$_DFFE_PP_ clknet_leaf_18_clk_net
+ _02258_ _01456_ VSS VSS VDD VDD network.neuron_in048.counter\[3\]
+ sky130_fd_sc_hd__edfxtp_1
Xnetwork.neuron_in048.spike$_SDFFE_PP0P_ clknet_leaf_17_clk_net
+ _01817_ VSS VSS VDD VDD network.in_spk00_03 sky130_fd_sc_hd__dfxtp_1
Xnetwork.neuron_in049.counter\[0\]$_DFFE_PP_ clknet_leaf_17_clk_net
+ _02259_ _01455_ VSS VSS VDD VDD network.neuron_in049.counter\[0\]
+ sky130_fd_sc_hd__edfxtp_1
Xnetwork.neuron_in049.counter\[1\]$_DFFE_PP_ clknet_leaf_17_clk_net
+ _02260_ _01455_ VSS VSS VDD VDD network.neuron_in049.counter\[1\]
+ sky130_fd_sc_hd__edfxtp_1
Xnetwork.neuron_in049.counter\[2\]$_DFFE_PP_ clknet_leaf_17_clk_net
+ _02261_ _01455_ VSS VSS VDD VDD network.neuron_in049.counter\[2\]
+ sky130_fd_sc_hd__edfxtp_1
Xnetwork.neuron_in049.counter\[3\]$_DFFE_PP_ clknet_leaf_17_clk_net
+ _02262_ _01455_ VSS VSS VDD VDD network.neuron_in049.counter\[3\]
+ sky130_fd_sc_hd__edfxtp_1
Xnetwork.neuron_in049.spike$_SDFFE_PP0P_ clknet_leaf_17_clk_net
+ _01816_ VSS VSS VDD VDD network.in_spk01_03 sky130_fd_sc_hd__dfxtp_1
Xnetwork.neuron_in050.counter\[0\]$_DFFE_PP_ clknet_leaf_166_clk_net
+ _02263_ _01454_ VSS VSS VDD VDD network.neuron_in050.counter\[0\]
+ sky130_fd_sc_hd__edfxtp_1
Xnetwork.neuron_in050.counter\[1\]$_DFFE_PP_ clknet_leaf_18_clk_net
+ _02264_ _01454_ VSS VSS VDD VDD network.neuron_in050.counter\[1\]
+ sky130_fd_sc_hd__edfxtp_1
Xnetwork.neuron_in050.counter\[2\]$_DFFE_PP_ clknet_leaf_165_clk_net
+ _02265_ _01454_ VSS VSS VDD VDD network.neuron_in050.counter\[2\]
+ sky130_fd_sc_hd__edfxtp_1
Xnetwork.neuron_in050.counter\[3\]$_DFFE_PP_ clknet_leaf_165_clk_net
+ _02266_ _01454_ VSS VSS VDD VDD network.neuron_in050.counter\[3\]
+ sky130_fd_sc_hd__edfxtp_1
Xnetwork.neuron_in050.spike$_SDFFE_PP0P_ clknet_leaf_17_clk_net
+ _01815_ VSS VSS VDD VDD network.in_spk02_03 sky130_fd_sc_hd__dfxtp_1
Xnetwork.neuron_in051.counter\[0\]$_DFFE_PP_ clknet_leaf_6_clk_net
+ _02267_ _01453_ VSS VSS VDD VDD network.neuron_in051.counter\[0\]
+ sky130_fd_sc_hd__edfxtp_1
Xnetwork.neuron_in051.counter\[1\]$_DFFE_PP_ clknet_leaf_5_clk_net
+ _02268_ _01453_ VSS VSS VDD VDD network.neuron_in051.counter\[1\]
+ sky130_fd_sc_hd__edfxtp_1
Xnetwork.neuron_in051.counter\[2\]$_DFFE_PP_ clknet_leaf_5_clk_net
+ _02269_ _01453_ VSS VSS VDD VDD network.neuron_in051.counter\[2\]
+ sky130_fd_sc_hd__edfxtp_1
Xnetwork.neuron_in051.counter\[3\]$_DFFE_PP_ clknet_leaf_5_clk_net
+ _02270_ _01453_ VSS VSS VDD VDD network.neuron_in051.counter\[3\]
+ sky130_fd_sc_hd__edfxtp_1
Xnetwork.neuron_in051.spike$_SDFFE_PP0P_ clknet_leaf_4_clk_net
+ _01814_ VSS VSS VDD VDD network.in_spk03_03 sky130_fd_sc_hd__dfxtp_1
Xnetwork.neuron_in052.counter\[0\]$_DFFE_PP_ clknet_leaf_9_clk_net
+ _02271_ _01452_ VSS VSS VDD VDD network.neuron_in052.counter\[0\]
+ sky130_fd_sc_hd__edfxtp_1
Xnetwork.neuron_in052.counter\[1\]$_DFFE_PP_ clknet_leaf_9_clk_net
+ _02272_ _01452_ VSS VSS VDD VDD network.neuron_in052.counter\[1\]
+ sky130_fd_sc_hd__edfxtp_1
Xnetwork.neuron_in052.counter\[2\]$_DFFE_PP_ clknet_leaf_9_clk_net
+ _02273_ _01452_ VSS VSS VDD VDD network.neuron_in052.counter\[2\]
+ sky130_fd_sc_hd__edfxtp_1
Xnetwork.neuron_in052.counter\[3\]$_DFFE_PP_ clknet_leaf_9_clk_net
+ _02274_ _01452_ VSS VSS VDD VDD network.neuron_in052.counter\[3\]
+ sky130_fd_sc_hd__edfxtp_1
Xnetwork.neuron_in052.spike$_SDFFE_PP0P_ clknet_leaf_16_clk_net
+ _01813_ VSS VSS VDD VDD network.in_spk04_03 sky130_fd_sc_hd__dfxtp_1
Xnetwork.neuron_in053.counter\[0\]$_DFFE_PP_ clknet_leaf_6_clk_net
+ _02275_ _01451_ VSS VSS VDD VDD network.neuron_in053.counter\[0\]
+ sky130_fd_sc_hd__edfxtp_1
Xnetwork.neuron_in053.counter\[1\]$_DFFE_PP_ clknet_leaf_6_clk_net
+ _02276_ _01451_ VSS VSS VDD VDD network.neuron_in053.counter\[1\]
+ sky130_fd_sc_hd__edfxtp_1
Xnetwork.neuron_in053.counter\[2\]$_DFFE_PP_ clknet_leaf_6_clk_net
+ _02277_ _01451_ VSS VSS VDD VDD network.neuron_in053.counter\[2\]
+ sky130_fd_sc_hd__edfxtp_1
Xnetwork.neuron_in053.counter\[3\]$_DFFE_PP_ clknet_leaf_6_clk_net
+ _02278_ _01451_ VSS VSS VDD VDD network.neuron_in053.counter\[3\]
+ sky130_fd_sc_hd__edfxtp_1
Xnetwork.neuron_in053.spike$_SDFFE_PP0P_ clknet_leaf_5_clk_net
+ _01812_ VSS VSS VDD VDD network.in_spk05_03 sky130_fd_sc_hd__dfxtp_1
Xnetwork.neuron_in054.counter\[0\]$_DFFE_PP_ clknet_leaf_16_clk_net
+ _02279_ _01450_ VSS VSS VDD VDD network.neuron_in054.counter\[0\]
+ sky130_fd_sc_hd__edfxtp_1
Xnetwork.neuron_in054.counter\[1\]$_DFFE_PP_ clknet_leaf_16_clk_net
+ _02280_ _01450_ VSS VSS VDD VDD network.neuron_in054.counter\[1\]
+ sky130_fd_sc_hd__edfxtp_1
Xnetwork.neuron_in054.counter\[2\]$_DFFE_PP_ clknet_leaf_16_clk_net
+ _02281_ _01450_ VSS VSS VDD VDD network.neuron_in054.counter\[2\]
+ sky130_fd_sc_hd__edfxtp_1
Xnetwork.neuron_in054.counter\[3\]$_DFFE_PP_ clknet_leaf_16_clk_net
+ _02282_ _01450_ VSS VSS VDD VDD network.neuron_in054.counter\[3\]
+ sky130_fd_sc_hd__edfxtp_1
Xnetwork.neuron_in054.spike$_SDFFE_PP0P_ clknet_leaf_17_clk_net
+ _01811_ VSS VSS VDD VDD network.in_spk06_03 sky130_fd_sc_hd__dfxtp_1
Xnetwork.neuron_in055.counter\[0\]$_DFFE_PP_ clknet_leaf_16_clk_net
+ _02283_ _01449_ VSS VSS VDD VDD network.neuron_in055.counter\[0\]
+ sky130_fd_sc_hd__edfxtp_1
Xnetwork.neuron_in055.counter\[1\]$_DFFE_PP_ clknet_leaf_6_clk_net
+ _02284_ _01449_ VSS VSS VDD VDD network.neuron_in055.counter\[1\]
+ sky130_fd_sc_hd__edfxtp_1
Xnetwork.neuron_in055.counter\[2\]$_DFFE_PP_ clknet_leaf_16_clk_net
+ _02285_ _01449_ VSS VSS VDD VDD network.neuron_in055.counter\[2\]
+ sky130_fd_sc_hd__edfxtp_1
Xnetwork.neuron_in055.counter\[3\]$_DFFE_PP_ clknet_leaf_16_clk_net
+ _02286_ _01449_ VSS VSS VDD VDD network.neuron_in055.counter\[3\]
+ sky130_fd_sc_hd__edfxtp_1
Xnetwork.neuron_in055.spike$_SDFFE_PP0P_ clknet_leaf_6_clk_net
+ _01810_ VSS VSS VDD VDD network.in_spk07_03 sky130_fd_sc_hd__dfxtp_1
Xnetwork.neuron_in056.counter\[0\]$_DFFE_PP_ clknet_leaf_7_clk_net
+ _02287_ _01448_ VSS VSS VDD VDD network.neuron_in056.counter\[0\]
+ sky130_fd_sc_hd__edfxtp_1
Xnetwork.neuron_in056.counter\[1\]$_DFFE_PP_ clknet_leaf_7_clk_net
+ _02288_ _01448_ VSS VSS VDD VDD network.neuron_in056.counter\[1\]
+ sky130_fd_sc_hd__edfxtp_1
Xnetwork.neuron_in056.counter\[2\]$_DFFE_PP_ clknet_leaf_7_clk_net
+ _02289_ _01448_ VSS VSS VDD VDD network.neuron_in056.counter\[2\]
+ sky130_fd_sc_hd__edfxtp_1
Xnetwork.neuron_in056.counter\[3\]$_DFFE_PP_ clknet_leaf_7_clk_net
+ _02290_ _01448_ VSS VSS VDD VDD network.neuron_in056.counter\[3\]
+ sky130_fd_sc_hd__edfxtp_1
Xnetwork.neuron_in056.spike$_SDFFE_PP0P_ clknet_leaf_7_clk_net
+ _01809_ VSS VSS VDD VDD network.in_spk08_03 sky130_fd_sc_hd__dfxtp_1
Xnetwork.neuron_in057.counter\[0\]$_DFFE_PP_ clknet_leaf_7_clk_net
+ _02291_ _01447_ VSS VSS VDD VDD network.neuron_in057.counter\[0\]
+ sky130_fd_sc_hd__edfxtp_1
Xnetwork.neuron_in057.counter\[1\]$_DFFE_PP_ clknet_leaf_2_clk_net
+ _02292_ _01447_ VSS VSS VDD VDD network.neuron_in057.counter\[1\]
+ sky130_fd_sc_hd__edfxtp_1
Xnetwork.neuron_in057.counter\[2\]$_DFFE_PP_ clknet_leaf_2_clk_net
+ _02293_ _01447_ VSS VSS VDD VDD network.neuron_in057.counter\[2\]
+ sky130_fd_sc_hd__edfxtp_1
Xnetwork.neuron_in057.counter\[3\]$_DFFE_PP_ clknet_leaf_2_clk_net
+ _02294_ _01447_ VSS VSS VDD VDD network.neuron_in057.counter\[3\]
+ sky130_fd_sc_hd__edfxtp_1
Xnetwork.neuron_in057.spike$_SDFFE_PP0P_ clknet_leaf_5_clk_net
+ _01808_ VSS VSS VDD VDD network.in_spk09_03 sky130_fd_sc_hd__dfxtp_1
Xnetwork.neuron_in058.counter\[0\]$_DFFE_PP_ clknet_leaf_8_clk_net
+ _02295_ _01446_ VSS VSS VDD VDD network.neuron_in058.counter\[0\]
+ sky130_fd_sc_hd__edfxtp_1
Xnetwork.neuron_in058.counter\[1\]$_DFFE_PP_ clknet_leaf_8_clk_net
+ _02296_ _01446_ VSS VSS VDD VDD network.neuron_in058.counter\[1\]
+ sky130_fd_sc_hd__edfxtp_1
Xnetwork.neuron_in058.counter\[2\]$_DFFE_PP_ clknet_leaf_8_clk_net
+ _02297_ _01446_ VSS VSS VDD VDD network.neuron_in058.counter\[2\]
+ sky130_fd_sc_hd__edfxtp_1
Xnetwork.neuron_in058.counter\[3\]$_DFFE_PP_ clknet_leaf_8_clk_net
+ _02298_ _01446_ VSS VSS VDD VDD network.neuron_in058.counter\[3\]
+ sky130_fd_sc_hd__edfxtp_1
Xnetwork.neuron_in058.spike$_SDFFE_PP0P_ clknet_leaf_5_clk_net
+ _01807_ VSS VSS VDD VDD network.in_spk10_03 sky130_fd_sc_hd__dfxtp_1
Xnetwork.neuron_in059.counter\[0\]$_DFFE_PP_ clknet_leaf_9_clk_net
+ _02299_ _01445_ VSS VSS VDD VDD network.neuron_in059.counter\[0\]
+ sky130_fd_sc_hd__edfxtp_1
Xnetwork.neuron_in059.counter\[1\]$_DFFE_PP_ clknet_leaf_9_clk_net
+ _02300_ _01445_ VSS VSS VDD VDD network.neuron_in059.counter\[1\]
+ sky130_fd_sc_hd__edfxtp_1
Xnetwork.neuron_in059.counter\[2\]$_DFFE_PP_ clknet_leaf_6_clk_net
+ _02301_ _01445_ VSS VSS VDD VDD network.neuron_in059.counter\[2\]
+ sky130_fd_sc_hd__edfxtp_1
Xnetwork.neuron_in059.counter\[3\]$_DFFE_PP_ clknet_leaf_6_clk_net
+ _02302_ _01445_ VSS VSS VDD VDD network.neuron_in059.counter\[3\]
+ sky130_fd_sc_hd__edfxtp_1
Xnetwork.neuron_in059.spike$_SDFFE_PP0P_ clknet_leaf_7_clk_net
+ _01806_ VSS VSS VDD VDD network.in_spk11_03 sky130_fd_sc_hd__dfxtp_1
Xnetwork.neuron_in060.counter\[0\]$_DFFE_PP_ clknet_leaf_1_clk_net
+ _02303_ _01444_ VSS VSS VDD VDD network.neuron_in060.counter\[0\]
+ sky130_fd_sc_hd__edfxtp_1
Xnetwork.neuron_in060.counter\[1\]$_DFFE_PP_ clknet_leaf_1_clk_net
+ _02304_ _01444_ VSS VSS VDD VDD network.neuron_in060.counter\[1\]
+ sky130_fd_sc_hd__edfxtp_1
Xnetwork.neuron_in060.counter\[2\]$_DFFE_PP_ clknet_leaf_0_clk_net
+ _02305_ _01444_ VSS VSS VDD VDD network.neuron_in060.counter\[2\]
+ sky130_fd_sc_hd__edfxtp_1
Xnetwork.neuron_in060.counter\[3\]$_DFFE_PP_ clknet_leaf_1_clk_net
+ _02306_ _01444_ VSS VSS VDD VDD network.neuron_in060.counter\[3\]
+ sky130_fd_sc_hd__edfxtp_1
Xnetwork.neuron_in060.spike$_SDFFE_PP0P_ clknet_leaf_4_clk_net
+ _01805_ VSS VSS VDD VDD network.in_spk12_03 sky130_fd_sc_hd__dfxtp_1
Xnetwork.neuron_in061.counter\[0\]$_DFFE_PP_ clknet_leaf_8_clk_net
+ _02307_ _01443_ VSS VSS VDD VDD network.neuron_in061.counter\[0\]
+ sky130_fd_sc_hd__edfxtp_1
Xnetwork.neuron_in061.counter\[1\]$_DFFE_PP_ clknet_leaf_8_clk_net
+ _02308_ _01443_ VSS VSS VDD VDD network.neuron_in061.counter\[1\]
+ sky130_fd_sc_hd__edfxtp_1
Xnetwork.neuron_in061.counter\[2\]$_DFFE_PP_ clknet_leaf_8_clk_net
+ _02309_ _01443_ VSS VSS VDD VDD network.neuron_in061.counter\[2\]
+ sky130_fd_sc_hd__edfxtp_1
Xnetwork.neuron_in061.counter\[3\]$_DFFE_PP_ clknet_leaf_8_clk_net
+ _02310_ _01443_ VSS VSS VDD VDD network.neuron_in061.counter\[3\]
+ sky130_fd_sc_hd__edfxtp_1
Xnetwork.neuron_in061.spike$_SDFFE_PP0P_ clknet_leaf_5_clk_net
+ _01804_ VSS VSS VDD VDD network.in_spk13_03 sky130_fd_sc_hd__dfxtp_1
Xnetwork.neuron_in062.counter\[0\]$_DFFE_PP_ clknet_leaf_2_clk_net
+ _02311_ _01442_ VSS VSS VDD VDD network.neuron_in062.counter\[0\]
+ sky130_fd_sc_hd__edfxtp_1
Xnetwork.neuron_in062.counter\[1\]$_DFFE_PP_ clknet_leaf_2_clk_net
+ _02312_ _01442_ VSS VSS VDD VDD network.neuron_in062.counter\[1\]
+ sky130_fd_sc_hd__edfxtp_1
Xnetwork.neuron_in062.counter\[2\]$_DFFE_PP_ clknet_leaf_2_clk_net
+ _02313_ _01442_ VSS VSS VDD VDD network.neuron_in062.counter\[2\]
+ sky130_fd_sc_hd__edfxtp_1
Xnetwork.neuron_in062.counter\[3\]$_DFFE_PP_ clknet_leaf_1_clk_net
+ _02314_ _01442_ VSS VSS VDD VDD network.neuron_in062.counter\[3\]
+ sky130_fd_sc_hd__edfxtp_1
Xnetwork.neuron_in062.spike$_SDFFE_PP0P_ clknet_leaf_4_clk_net
+ _01803_ VSS VSS VDD VDD network.in_spk14_03 sky130_fd_sc_hd__dfxtp_1
Xnetwork.neuron_in063.counter\[0\]$_DFFE_PP_ clknet_leaf_1_clk_net
+ _02315_ _01441_ VSS VSS VDD VDD network.neuron_in063.counter\[0\]
+ sky130_fd_sc_hd__edfxtp_1
Xnetwork.neuron_in063.counter\[1\]$_DFFE_PP_ clknet_leaf_1_clk_net
+ _02316_ _01441_ VSS VSS VDD VDD network.neuron_in063.counter\[1\]
+ sky130_fd_sc_hd__edfxtp_1
Xnetwork.neuron_in063.counter\[2\]$_DFFE_PP_ clknet_leaf_8_clk_net
+ _02317_ _01441_ VSS VSS VDD VDD network.neuron_in063.counter\[2\]
+ sky130_fd_sc_hd__edfxtp_1
Xnetwork.neuron_in063.counter\[3\]$_DFFE_PP_ clknet_leaf_1_clk_net
+ _02318_ _01441_ VSS VSS VDD VDD network.neuron_in063.counter\[3\]
+ sky130_fd_sc_hd__edfxtp_1
Xnetwork.neuron_in063.spike$_SDFFE_PP0P_ clknet_leaf_5_clk_net
+ _01802_ VSS VSS VDD VDD network.in_spk15_03 sky130_fd_sc_hd__dfxtp_1
Xnetwork.neuron_in064.counter\[0\]$_DFFE_PP_ clknet_leaf_19_clk_net
+ _02319_ _01440_ VSS VSS VDD VDD network.neuron_in064.counter\[0\]
+ sky130_fd_sc_hd__edfxtp_1
Xnetwork.neuron_in064.counter\[1\]$_DFFE_PP_ clknet_leaf_19_clk_net
+ _02320_ _01440_ VSS VSS VDD VDD network.neuron_in064.counter\[1\]
+ sky130_fd_sc_hd__edfxtp_1
Xnetwork.neuron_in064.counter\[2\]$_DFFE_PP_ clknet_leaf_21_clk_net
+ _02321_ _01440_ VSS VSS VDD VDD network.neuron_in064.counter\[2\]
+ sky130_fd_sc_hd__edfxtp_1
Xnetwork.neuron_in064.counter\[3\]$_DFFE_PP_ clknet_leaf_19_clk_net
+ _02322_ _01440_ VSS VSS VDD VDD network.neuron_in064.counter\[3\]
+ sky130_fd_sc_hd__edfxtp_1
Xnetwork.neuron_in064.spike$_SDFFE_PP0P_ clknet_leaf_21_clk_net
+ _01801_ VSS VSS VDD VDD network.in_spk00_04 sky130_fd_sc_hd__dfxtp_1
Xnetwork.neuron_in065.counter\[0\]$_DFFE_PP_ clknet_leaf_13_clk_net
+ _02323_ _01439_ VSS VSS VDD VDD network.neuron_in065.counter\[0\]
+ sky130_fd_sc_hd__edfxtp_1
Xnetwork.neuron_in065.counter\[1\]$_DFFE_PP_ clknet_leaf_13_clk_net
+ _02324_ _01439_ VSS VSS VDD VDD network.neuron_in065.counter\[1\]
+ sky130_fd_sc_hd__edfxtp_1
Xnetwork.neuron_in065.counter\[2\]$_DFFE_PP_ clknet_leaf_15_clk_net
+ _02325_ _01439_ VSS VSS VDD VDD network.neuron_in065.counter\[2\]
+ sky130_fd_sc_hd__edfxtp_1
Xnetwork.neuron_in065.counter\[3\]$_DFFE_PP_ clknet_leaf_14_clk_net
+ _02326_ _01439_ VSS VSS VDD VDD network.neuron_in065.counter\[3\]
+ sky130_fd_sc_hd__edfxtp_1
Xnetwork.neuron_in065.spike$_SDFFE_PP0P_ clknet_leaf_20_clk_net
+ _01800_ VSS VSS VDD VDD network.in_spk01_04 sky130_fd_sc_hd__dfxtp_1
Xnetwork.neuron_in066.counter\[0\]$_DFFE_PP_ clknet_leaf_20_clk_net
+ _02327_ _01438_ VSS VSS VDD VDD network.neuron_in066.counter\[0\]
+ sky130_fd_sc_hd__edfxtp_1
Xnetwork.neuron_in066.counter\[1\]$_DFFE_PP_ clknet_leaf_20_clk_net
+ _02328_ _01438_ VSS VSS VDD VDD network.neuron_in066.counter\[1\]
+ sky130_fd_sc_hd__edfxtp_1
Xnetwork.neuron_in066.counter\[2\]$_DFFE_PP_ clknet_leaf_21_clk_net
+ _02329_ _01438_ VSS VSS VDD VDD network.neuron_in066.counter\[2\]
+ sky130_fd_sc_hd__edfxtp_1
Xnetwork.neuron_in066.counter\[3\]$_DFFE_PP_ clknet_leaf_20_clk_net
+ _02330_ _01438_ VSS VSS VDD VDD network.neuron_in066.counter\[3\]
+ sky130_fd_sc_hd__edfxtp_1
Xnetwork.neuron_in066.spike$_SDFFE_PP0P_ clknet_leaf_21_clk_net
+ _01799_ VSS VSS VDD VDD network.in_spk02_04 sky130_fd_sc_hd__dfxtp_1
Xnetwork.neuron_in067.counter\[0\]$_DFFE_PP_ clknet_leaf_19_clk_net
+ _02331_ _01437_ VSS VSS VDD VDD network.neuron_in067.counter\[0\]
+ sky130_fd_sc_hd__edfxtp_1
Xnetwork.neuron_in067.counter\[1\]$_DFFE_PP_ clknet_leaf_19_clk_net
+ _02332_ _01437_ VSS VSS VDD VDD network.neuron_in067.counter\[1\]
+ sky130_fd_sc_hd__edfxtp_1
Xnetwork.neuron_in067.counter\[2\]$_DFFE_PP_ clknet_leaf_19_clk_net
+ _02333_ _01437_ VSS VSS VDD VDD network.neuron_in067.counter\[2\]
+ sky130_fd_sc_hd__edfxtp_1
Xnetwork.neuron_in067.counter\[3\]$_DFFE_PP_ clknet_leaf_19_clk_net
+ _02334_ _01437_ VSS VSS VDD VDD network.neuron_in067.counter\[3\]
+ sky130_fd_sc_hd__edfxtp_1
Xnetwork.neuron_in067.spike$_SDFFE_PP0P_ clknet_leaf_20_clk_net
+ _01798_ VSS VSS VDD VDD network.in_spk03_04 sky130_fd_sc_hd__dfxtp_1
Xnetwork.neuron_in068.counter\[0\]$_DFFE_PP_ clknet_leaf_32_clk_net
+ _02335_ _01436_ VSS VSS VDD VDD network.neuron_in068.counter\[0\]
+ sky130_fd_sc_hd__edfxtp_1
Xnetwork.neuron_in068.counter\[1\]$_DFFE_PP_ clknet_leaf_32_clk_net
+ _02336_ _01436_ VSS VSS VDD VDD network.neuron_in068.counter\[1\]
+ sky130_fd_sc_hd__edfxtp_1
Xnetwork.neuron_in068.counter\[2\]$_DFFE_PP_ clknet_leaf_32_clk_net
+ _02337_ _01436_ VSS VSS VDD VDD network.neuron_in068.counter\[2\]
+ sky130_fd_sc_hd__edfxtp_1
Xnetwork.neuron_in068.counter\[3\]$_DFFE_PP_ clknet_leaf_32_clk_net
+ _02338_ _01436_ VSS VSS VDD VDD network.neuron_in068.counter\[3\]
+ sky130_fd_sc_hd__edfxtp_1
Xnetwork.neuron_in068.spike$_SDFFE_PP0P_ clknet_leaf_27_clk_net
+ _01797_ VSS VSS VDD VDD network.in_spk04_04 sky130_fd_sc_hd__dfxtp_1
Xnetwork.neuron_in069.counter\[0\]$_DFFE_PP_ clknet_leaf_35_clk_net
+ _02339_ _01435_ VSS VSS VDD VDD network.neuron_in069.counter\[0\]
+ sky130_fd_sc_hd__edfxtp_1
Xnetwork.neuron_in069.counter\[1\]$_DFFE_PP_ clknet_leaf_33_clk_net
+ _02340_ _01435_ VSS VSS VDD VDD network.neuron_in069.counter\[1\]
+ sky130_fd_sc_hd__edfxtp_1
Xnetwork.neuron_in069.counter\[2\]$_DFFE_PP_ clknet_leaf_33_clk_net
+ _02341_ _01435_ VSS VSS VDD VDD network.neuron_in069.counter\[2\]
+ sky130_fd_sc_hd__edfxtp_1
Xnetwork.neuron_in069.counter\[3\]$_DFFE_PP_ clknet_leaf_35_clk_net
+ _02342_ _01435_ VSS VSS VDD VDD network.neuron_in069.counter\[3\]
+ sky130_fd_sc_hd__edfxtp_1
Xnetwork.neuron_in069.spike$_SDFFE_PP0P_ clknet_leaf_27_clk_net
+ _01796_ VSS VSS VDD VDD network.in_spk05_04 sky130_fd_sc_hd__dfxtp_1
Xnetwork.neuron_in070.counter\[0\]$_DFFE_PP_ clknet_leaf_28_clk_net
+ _02343_ _01434_ VSS VSS VDD VDD network.neuron_in070.counter\[0\]
+ sky130_fd_sc_hd__edfxtp_1
Xnetwork.neuron_in070.counter\[1\]$_DFFE_PP_ clknet_leaf_27_clk_net
+ _02344_ _01434_ VSS VSS VDD VDD network.neuron_in070.counter\[1\]
+ sky130_fd_sc_hd__edfxtp_1
Xnetwork.neuron_in070.counter\[2\]$_DFFE_PP_ clknet_leaf_28_clk_net
+ _02345_ _01434_ VSS VSS VDD VDD network.neuron_in070.counter\[2\]
+ sky130_fd_sc_hd__edfxtp_1
Xnetwork.neuron_in070.counter\[3\]$_DFFE_PP_ clknet_leaf_28_clk_net
+ _02346_ _01434_ VSS VSS VDD VDD network.neuron_in070.counter\[3\]
+ sky130_fd_sc_hd__edfxtp_1
Xnetwork.neuron_in070.spike$_SDFFE_PP0P_ clknet_leaf_27_clk_net
+ _01795_ VSS VSS VDD VDD network.in_spk06_04 sky130_fd_sc_hd__dfxtp_1
Xnetwork.neuron_in071.counter\[0\]$_DFFE_PP_ clknet_leaf_14_clk_net
+ _02347_ _01433_ VSS VSS VDD VDD network.neuron_in071.counter\[0\]
+ sky130_fd_sc_hd__edfxtp_1
Xnetwork.neuron_in071.counter\[1\]$_DFFE_PP_ clknet_leaf_14_clk_net
+ _02348_ _01433_ VSS VSS VDD VDD network.neuron_in071.counter\[1\]
+ sky130_fd_sc_hd__edfxtp_1
Xnetwork.neuron_in071.counter\[2\]$_DFFE_PP_ clknet_leaf_14_clk_net
+ _02349_ _01433_ VSS VSS VDD VDD network.neuron_in071.counter\[2\]
+ sky130_fd_sc_hd__edfxtp_1
Xnetwork.neuron_in071.counter\[3\]$_DFFE_PP_ clknet_leaf_14_clk_net
+ _02350_ _01433_ VSS VSS VDD VDD network.neuron_in071.counter\[3\]
+ sky130_fd_sc_hd__edfxtp_1
Xnetwork.neuron_in071.spike$_SDFFE_PP0P_ clknet_leaf_20_clk_net
+ _01794_ VSS VSS VDD VDD network.in_spk07_04 sky130_fd_sc_hd__dfxtp_1
Xnetwork.neuron_in072.counter\[0\]$_DFFE_PP_ clknet_leaf_27_clk_net
+ _02351_ _01432_ VSS VSS VDD VDD network.neuron_in072.counter\[0\]
+ sky130_fd_sc_hd__edfxtp_1
Xnetwork.neuron_in072.counter\[1\]$_DFFE_PP_ clknet_leaf_27_clk_net
+ _02352_ _01432_ VSS VSS VDD VDD network.neuron_in072.counter\[1\]
+ sky130_fd_sc_hd__edfxtp_1
Xnetwork.neuron_in072.counter\[2\]$_DFFE_PP_ clknet_leaf_27_clk_net
+ _02353_ _01432_ VSS VSS VDD VDD network.neuron_in072.counter\[2\]
+ sky130_fd_sc_hd__edfxtp_1
Xnetwork.neuron_in072.counter\[3\]$_DFFE_PP_ clknet_leaf_26_clk_net
+ _02354_ _01432_ VSS VSS VDD VDD network.neuron_in072.counter\[3\]
+ sky130_fd_sc_hd__edfxtp_1
Xnetwork.neuron_in072.spike$_SDFFE_PP0P_ clknet_leaf_27_clk_net
+ _01793_ VSS VSS VDD VDD network.in_spk08_04 sky130_fd_sc_hd__dfxtp_1
Xnetwork.neuron_in073.counter\[0\]$_DFFE_PP_ clknet_leaf_34_clk_net
+ _02355_ _01431_ VSS VSS VDD VDD network.neuron_in073.counter\[0\]
+ sky130_fd_sc_hd__edfxtp_1
Xnetwork.neuron_in073.counter\[1\]$_DFFE_PP_ clknet_leaf_34_clk_net
+ _02356_ _01431_ VSS VSS VDD VDD network.neuron_in073.counter\[1\]
+ sky130_fd_sc_hd__edfxtp_1
Xnetwork.neuron_in073.counter\[2\]$_DFFE_PP_ clknet_leaf_34_clk_net
+ _02357_ _01431_ VSS VSS VDD VDD network.neuron_in073.counter\[2\]
+ sky130_fd_sc_hd__edfxtp_1
Xnetwork.neuron_in073.counter\[3\]$_DFFE_PP_ clknet_leaf_34_clk_net
+ _02358_ _01431_ VSS VSS VDD VDD network.neuron_in073.counter\[3\]
+ sky130_fd_sc_hd__edfxtp_1
Xnetwork.neuron_in073.spike$_SDFFE_PP0P_ clknet_leaf_34_clk_net
+ _01792_ VSS VSS VDD VDD network.in_spk09_04 sky130_fd_sc_hd__dfxtp_1
Xnetwork.neuron_in074.counter\[0\]$_DFFE_PP_ clknet_leaf_33_clk_net
+ _02359_ _01430_ VSS VSS VDD VDD network.neuron_in074.counter\[0\]
+ sky130_fd_sc_hd__edfxtp_1
Xnetwork.neuron_in074.counter\[1\]$_DFFE_PP_ clknet_leaf_33_clk_net
+ _02360_ _01430_ VSS VSS VDD VDD network.neuron_in074.counter\[1\]
+ sky130_fd_sc_hd__edfxtp_1
Xnetwork.neuron_in074.counter\[2\]$_DFFE_PP_ clknet_leaf_33_clk_net
+ _02361_ _01430_ VSS VSS VDD VDD network.neuron_in074.counter\[2\]
+ sky130_fd_sc_hd__edfxtp_1
Xnetwork.neuron_in074.counter\[3\]$_DFFE_PP_ clknet_leaf_33_clk_net
+ _02362_ _01430_ VSS VSS VDD VDD network.neuron_in074.counter\[3\]
+ sky130_fd_sc_hd__edfxtp_1
Xnetwork.neuron_in074.spike$_SDFFE_PP0P_ clknet_leaf_34_clk_net
+ _01791_ VSS VSS VDD VDD network.in_spk10_04 sky130_fd_sc_hd__dfxtp_1
Xnetwork.neuron_in075.counter\[0\]$_DFFE_PP_ clknet_leaf_35_clk_net
+ _02363_ _01429_ VSS VSS VDD VDD network.neuron_in075.counter\[0\]
+ sky130_fd_sc_hd__edfxtp_1
Xnetwork.neuron_in075.counter\[1\]$_DFFE_PP_ clknet_leaf_13_clk_net
+ _02364_ _01429_ VSS VSS VDD VDD network.neuron_in075.counter\[1\]
+ sky130_fd_sc_hd__edfxtp_1
Xnetwork.neuron_in075.counter\[2\]$_DFFE_PP_ clknet_leaf_14_clk_net
+ _02365_ _01429_ VSS VSS VDD VDD network.neuron_in075.counter\[2\]
+ sky130_fd_sc_hd__edfxtp_1
Xnetwork.neuron_in075.counter\[3\]$_DFFE_PP_ clknet_leaf_34_clk_net
+ _02366_ _01429_ VSS VSS VDD VDD network.neuron_in075.counter\[3\]
+ sky130_fd_sc_hd__edfxtp_1
Xnetwork.neuron_in075.spike$_SDFFE_PP0P_ clknet_leaf_34_clk_net
+ _01790_ VSS VSS VDD VDD network.in_spk11_04 sky130_fd_sc_hd__dfxtp_1
Xnetwork.neuron_in076.counter\[0\]$_DFFE_PP_ clknet_leaf_18_clk_net
+ _02367_ _01428_ VSS VSS VDD VDD network.neuron_in076.counter\[0\]
+ sky130_fd_sc_hd__edfxtp_1
Xnetwork.neuron_in076.counter\[1\]$_DFFE_PP_ clknet_leaf_18_clk_net
+ _02368_ _01428_ VSS VSS VDD VDD network.neuron_in076.counter\[1\]
+ sky130_fd_sc_hd__edfxtp_1
Xnetwork.neuron_in076.counter\[2\]$_DFFE_PP_ clknet_leaf_18_clk_net
+ _02369_ _01428_ VSS VSS VDD VDD network.neuron_in076.counter\[2\]
+ sky130_fd_sc_hd__edfxtp_1
Xnetwork.neuron_in076.counter\[3\]$_DFFE_PP_ clknet_leaf_18_clk_net
+ _02370_ _01428_ VSS VSS VDD VDD network.neuron_in076.counter\[3\]
+ sky130_fd_sc_hd__edfxtp_1
Xnetwork.neuron_in076.spike$_SDFFE_PP0P_ clknet_leaf_20_clk_net
+ _01789_ VSS VSS VDD VDD network.in_spk12_04 sky130_fd_sc_hd__dfxtp_1
Xnetwork.neuron_in077.counter\[0\]$_DFFE_PP_ clknet_leaf_12_clk_net
+ _02371_ _01427_ VSS VSS VDD VDD network.neuron_in077.counter\[0\]
+ sky130_fd_sc_hd__edfxtp_1
Xnetwork.neuron_in077.counter\[1\]$_DFFE_PP_ clknet_leaf_13_clk_net
+ _02372_ _01427_ VSS VSS VDD VDD network.neuron_in077.counter\[1\]
+ sky130_fd_sc_hd__edfxtp_1
Xnetwork.neuron_in077.counter\[2\]$_DFFE_PP_ clknet_leaf_13_clk_net
+ _02373_ _01427_ VSS VSS VDD VDD network.neuron_in077.counter\[2\]
+ sky130_fd_sc_hd__edfxtp_1
Xnetwork.neuron_in077.counter\[3\]$_DFFE_PP_ clknet_leaf_13_clk_net
+ _02374_ _01427_ VSS VSS VDD VDD network.neuron_in077.counter\[3\]
+ sky130_fd_sc_hd__edfxtp_1
Xnetwork.neuron_in077.spike$_SDFFE_PP0P_ clknet_leaf_20_clk_net
+ _01788_ VSS VSS VDD VDD network.in_spk13_04 sky130_fd_sc_hd__dfxtp_1
Xnetwork.neuron_in078.counter\[0\]$_DFFE_PP_ clknet_leaf_15_clk_net
+ _02375_ _01426_ VSS VSS VDD VDD network.neuron_in078.counter\[0\]
+ sky130_fd_sc_hd__edfxtp_1
Xnetwork.neuron_in078.counter\[1\]$_DFFE_PP_ clknet_leaf_15_clk_net
+ _02376_ _01426_ VSS VSS VDD VDD network.neuron_in078.counter\[1\]
+ sky130_fd_sc_hd__edfxtp_1
Xnetwork.neuron_in078.counter\[2\]$_DFFE_PP_ clknet_leaf_14_clk_net
+ _02377_ _01426_ VSS VSS VDD VDD network.neuron_in078.counter\[2\]
+ sky130_fd_sc_hd__edfxtp_1
Xnetwork.neuron_in078.counter\[3\]$_DFFE_PP_ clknet_leaf_14_clk_net
+ _02378_ _01426_ VSS VSS VDD VDD network.neuron_in078.counter\[3\]
+ sky130_fd_sc_hd__edfxtp_1
Xnetwork.neuron_in078.spike$_SDFFE_PP0P_ clknet_leaf_20_clk_net
+ _01787_ VSS VSS VDD VDD network.in_spk14_04 sky130_fd_sc_hd__dfxtp_1
Xnetwork.neuron_in079.counter\[0\]$_DFFE_PP_ clknet_leaf_15_clk_net
+ _02379_ _01425_ VSS VSS VDD VDD network.neuron_in079.counter\[0\]
+ sky130_fd_sc_hd__edfxtp_1
Xnetwork.neuron_in079.counter\[1\]$_DFFE_PP_ clknet_leaf_15_clk_net
+ _02380_ _01425_ VSS VSS VDD VDD network.neuron_in079.counter\[1\]
+ sky130_fd_sc_hd__edfxtp_1
Xnetwork.neuron_in079.counter\[2\]$_DFFE_PP_ clknet_leaf_15_clk_net
+ _02381_ _01425_ VSS VSS VDD VDD network.neuron_in079.counter\[2\]
+ sky130_fd_sc_hd__edfxtp_1
Xnetwork.neuron_in079.counter\[3\]$_DFFE_PP_ clknet_leaf_15_clk_net
+ _02382_ _01425_ VSS VSS VDD VDD network.neuron_in079.counter\[3\]
+ sky130_fd_sc_hd__edfxtp_1
Xnetwork.neuron_in079.spike$_SDFFE_PP0P_ clknet_leaf_20_clk_net
+ _01786_ VSS VSS VDD VDD network.in_spk15_04 sky130_fd_sc_hd__dfxtp_1
Xnetwork.neuron_in080.counter\[0\]$_DFFE_PP_ clknet_leaf_49_clk_net
+ _02383_ _01424_ VSS VSS VDD VDD network.neuron_in080.counter\[0\]
+ sky130_fd_sc_hd__edfxtp_1
Xnetwork.neuron_in080.counter\[1\]$_DFFE_PP_ clknet_leaf_48_clk_net
+ _02384_ _01424_ VSS VSS VDD VDD network.neuron_in080.counter\[1\]
+ sky130_fd_sc_hd__edfxtp_1
Xnetwork.neuron_in080.counter\[2\]$_DFFE_PP_ clknet_leaf_48_clk_net
+ _02385_ _01424_ VSS VSS VDD VDD network.neuron_in080.counter\[2\]
+ sky130_fd_sc_hd__edfxtp_1
Xnetwork.neuron_in080.counter\[3\]$_DFFE_PP_ clknet_leaf_49_clk_net
+ _02386_ _01424_ VSS VSS VDD VDD network.neuron_in080.counter\[3\]
+ sky130_fd_sc_hd__edfxtp_1
Xnetwork.neuron_in080.spike$_SDFFE_PP0P_ clknet_leaf_62_clk_net
+ _01785_ VSS VSS VDD VDD network.in_spk00_05 sky130_fd_sc_hd__dfxtp_1
Xnetwork.neuron_in081.counter\[0\]$_DFFE_PP_ clknet_leaf_61_clk_net
+ _02387_ _01423_ VSS VSS VDD VDD network.neuron_in081.counter\[0\]
+ sky130_fd_sc_hd__edfxtp_1
Xnetwork.neuron_in081.counter\[1\]$_DFFE_PP_ clknet_leaf_61_clk_net
+ _02388_ _01423_ VSS VSS VDD VDD network.neuron_in081.counter\[1\]
+ sky130_fd_sc_hd__edfxtp_1
Xnetwork.neuron_in081.counter\[2\]$_DFFE_PP_ clknet_leaf_61_clk_net
+ _02389_ _01423_ VSS VSS VDD VDD network.neuron_in081.counter\[2\]
+ sky130_fd_sc_hd__edfxtp_1
Xnetwork.neuron_in081.counter\[3\]$_DFFE_PP_ clknet_leaf_61_clk_net
+ _02390_ _01423_ VSS VSS VDD VDD network.neuron_in081.counter\[3\]
+ sky130_fd_sc_hd__edfxtp_1
Xnetwork.neuron_in081.spike$_SDFFE_PP0P_ clknet_leaf_61_clk_net
+ _01784_ VSS VSS VDD VDD network.in_spk01_05 sky130_fd_sc_hd__dfxtp_1
Xnetwork.neuron_in082.counter\[0\]$_DFFE_PP_ clknet_leaf_57_clk_net
+ _02391_ _01422_ VSS VSS VDD VDD network.neuron_in082.counter\[0\]
+ sky130_fd_sc_hd__edfxtp_1
Xnetwork.neuron_in082.counter\[1\]$_DFFE_PP_ clknet_leaf_55_clk_net
+ _02392_ _01422_ VSS VSS VDD VDD network.neuron_in082.counter\[1\]
+ sky130_fd_sc_hd__edfxtp_1
Xnetwork.neuron_in082.counter\[2\]$_DFFE_PP_ clknet_leaf_57_clk_net
+ _02393_ _01422_ VSS VSS VDD VDD network.neuron_in082.counter\[2\]
+ sky130_fd_sc_hd__edfxtp_1
Xnetwork.neuron_in082.counter\[3\]$_DFFE_PP_ clknet_leaf_57_clk_net
+ _02394_ _01422_ VSS VSS VDD VDD network.neuron_in082.counter\[3\]
+ sky130_fd_sc_hd__edfxtp_1
Xnetwork.neuron_in082.spike$_SDFFE_PP0P_ clknet_leaf_61_clk_net
+ _01783_ VSS VSS VDD VDD network.in_spk02_05 sky130_fd_sc_hd__dfxtp_1
Xnetwork.neuron_in083.counter\[0\]$_DFFE_PP_ clknet_leaf_58_clk_net
+ _02395_ _01421_ VSS VSS VDD VDD network.neuron_in083.counter\[0\]
+ sky130_fd_sc_hd__edfxtp_1
Xnetwork.neuron_in083.counter\[1\]$_DFFE_PP_ clknet_leaf_58_clk_net
+ _02396_ _01421_ VSS VSS VDD VDD network.neuron_in083.counter\[1\]
+ sky130_fd_sc_hd__edfxtp_1
Xnetwork.neuron_in083.counter\[2\]$_DFFE_PP_ clknet_leaf_60_clk_net
+ _02397_ _01421_ VSS VSS VDD VDD network.neuron_in083.counter\[2\]
+ sky130_fd_sc_hd__edfxtp_1
Xnetwork.neuron_in083.counter\[3\]$_DFFE_PP_ clknet_leaf_60_clk_net
+ _02398_ _01421_ VSS VSS VDD VDD network.neuron_in083.counter\[3\]
+ sky130_fd_sc_hd__edfxtp_1
Xnetwork.neuron_in083.spike$_SDFFE_PP0P_ clknet_leaf_61_clk_net
+ _01782_ VSS VSS VDD VDD network.in_spk03_05 sky130_fd_sc_hd__dfxtp_1
Xnetwork.neuron_in084.counter\[0\]$_DFFE_PP_ clknet_leaf_54_clk_net
+ _02399_ _01420_ VSS VSS VDD VDD network.neuron_in084.counter\[0\]
+ sky130_fd_sc_hd__edfxtp_1
Xnetwork.neuron_in084.counter\[1\]$_DFFE_PP_ clknet_leaf_54_clk_net
+ _02400_ _01420_ VSS VSS VDD VDD network.neuron_in084.counter\[1\]
+ sky130_fd_sc_hd__edfxtp_1
Xnetwork.neuron_in084.counter\[2\]$_DFFE_PP_ clknet_leaf_55_clk_net
+ _02401_ _01420_ VSS VSS VDD VDD network.neuron_in084.counter\[2\]
+ sky130_fd_sc_hd__edfxtp_1
Xnetwork.neuron_in084.counter\[3\]$_DFFE_PP_ clknet_leaf_54_clk_net
+ _02402_ _01420_ VSS VSS VDD VDD network.neuron_in084.counter\[3\]
+ sky130_fd_sc_hd__edfxtp_1
Xnetwork.neuron_in084.spike$_SDFFE_PP0P_ clknet_leaf_52_clk_net
+ _01781_ VSS VSS VDD VDD network.in_spk04_05 sky130_fd_sc_hd__dfxtp_1
Xnetwork.neuron_in085.counter\[0\]$_DFFE_PP_ clknet_leaf_55_clk_net
+ _02403_ _01419_ VSS VSS VDD VDD network.neuron_in085.counter\[0\]
+ sky130_fd_sc_hd__edfxtp_1
Xnetwork.neuron_in085.counter\[1\]$_DFFE_PP_ clknet_leaf_55_clk_net
+ _02404_ _01419_ VSS VSS VDD VDD network.neuron_in085.counter\[1\]
+ sky130_fd_sc_hd__edfxtp_1
Xnetwork.neuron_in085.counter\[2\]$_DFFE_PP_ clknet_leaf_55_clk_net
+ _02405_ _01419_ VSS VSS VDD VDD network.neuron_in085.counter\[2\]
+ sky130_fd_sc_hd__edfxtp_1
Xnetwork.neuron_in085.counter\[3\]$_DFFE_PP_ clknet_leaf_55_clk_net
+ _02406_ _01419_ VSS VSS VDD VDD network.neuron_in085.counter\[3\]
+ sky130_fd_sc_hd__edfxtp_1
Xnetwork.neuron_in085.spike$_SDFFE_PP0P_ clknet_leaf_52_clk_net
+ _01780_ VSS VSS VDD VDD network.in_spk05_05 sky130_fd_sc_hd__dfxtp_1
Xnetwork.neuron_in086.counter\[0\]$_DFFE_PP_ clknet_leaf_54_clk_net
+ _02407_ _01418_ VSS VSS VDD VDD network.neuron_in086.counter\[0\]
+ sky130_fd_sc_hd__edfxtp_1
Xnetwork.neuron_in086.counter\[1\]$_DFFE_PP_ clknet_leaf_54_clk_net
+ _02408_ _01418_ VSS VSS VDD VDD network.neuron_in086.counter\[1\]
+ sky130_fd_sc_hd__edfxtp_1
Xnetwork.neuron_in086.counter\[2\]$_DFFE_PP_ clknet_leaf_55_clk_net
+ _02409_ _01418_ VSS VSS VDD VDD network.neuron_in086.counter\[2\]
+ sky130_fd_sc_hd__edfxtp_1
Xnetwork.neuron_in086.counter\[3\]$_DFFE_PP_ clknet_leaf_54_clk_net
+ _02410_ _01418_ VSS VSS VDD VDD network.neuron_in086.counter\[3\]
+ sky130_fd_sc_hd__edfxtp_1
Xnetwork.neuron_in086.spike$_SDFFE_PP0P_ clknet_leaf_51_clk_net
+ _01779_ VSS VSS VDD VDD network.in_spk06_05 sky130_fd_sc_hd__dfxtp_1
Xnetwork.neuron_in087.counter\[0\]$_DFFE_PP_ clknet_leaf_53_clk_net
+ _02411_ _01417_ VSS VSS VDD VDD network.neuron_in087.counter\[0\]
+ sky130_fd_sc_hd__edfxtp_1
Xnetwork.neuron_in087.counter\[1\]$_DFFE_PP_ clknet_leaf_53_clk_net
+ _02412_ _01417_ VSS VSS VDD VDD network.neuron_in087.counter\[1\]
+ sky130_fd_sc_hd__edfxtp_1
Xnetwork.neuron_in087.counter\[2\]$_DFFE_PP_ clknet_leaf_54_clk_net
+ _02413_ _01417_ VSS VSS VDD VDD network.neuron_in087.counter\[2\]
+ sky130_fd_sc_hd__edfxtp_1
Xnetwork.neuron_in087.counter\[3\]$_DFFE_PP_ clknet_leaf_54_clk_net
+ _02414_ _01417_ VSS VSS VDD VDD network.neuron_in087.counter\[3\]
+ sky130_fd_sc_hd__edfxtp_1
Xnetwork.neuron_in087.spike$_SDFFE_PP0P_ clknet_leaf_52_clk_net
+ _01778_ VSS VSS VDD VDD network.in_spk07_05 sky130_fd_sc_hd__dfxtp_1
Xnetwork.neuron_in088.counter\[0\]$_DFFE_PP_ clknet_leaf_48_clk_net
+ _02415_ _01416_ VSS VSS VDD VDD network.neuron_in088.counter\[0\]
+ sky130_fd_sc_hd__edfxtp_1
Xnetwork.neuron_in088.counter\[1\]$_DFFE_PP_ clknet_leaf_48_clk_net
+ _02416_ _01416_ VSS VSS VDD VDD network.neuron_in088.counter\[1\]
+ sky130_fd_sc_hd__edfxtp_1
Xnetwork.neuron_in088.counter\[2\]$_DFFE_PP_ clknet_leaf_48_clk_net
+ _02417_ _01416_ VSS VSS VDD VDD network.neuron_in088.counter\[2\]
+ sky130_fd_sc_hd__edfxtp_1
Xnetwork.neuron_in088.counter\[3\]$_DFFE_PP_ clknet_leaf_49_clk_net
+ _02418_ _01416_ VSS VSS VDD VDD network.neuron_in088.counter\[3\]
+ sky130_fd_sc_hd__edfxtp_1
Xnetwork.neuron_in088.spike$_SDFFE_PP0P_ clknet_leaf_52_clk_net
+ _01777_ VSS VSS VDD VDD network.in_spk08_05 sky130_fd_sc_hd__dfxtp_1
Xnetwork.neuron_in089.counter\[0\]$_DFFE_PP_ clknet_leaf_52_clk_net
+ _02419_ _01415_ VSS VSS VDD VDD network.neuron_in089.counter\[0\]
+ sky130_fd_sc_hd__edfxtp_1
Xnetwork.neuron_in089.counter\[1\]$_DFFE_PP_ clknet_leaf_52_clk_net
+ _02420_ _01415_ VSS VSS VDD VDD network.neuron_in089.counter\[1\]
+ sky130_fd_sc_hd__edfxtp_1
Xnetwork.neuron_in089.counter\[2\]$_DFFE_PP_ clknet_leaf_52_clk_net
+ _02421_ _01415_ VSS VSS VDD VDD network.neuron_in089.counter\[2\]
+ sky130_fd_sc_hd__edfxtp_1
Xnetwork.neuron_in089.counter\[3\]$_DFFE_PP_ clknet_leaf_52_clk_net
+ _02422_ _01415_ VSS VSS VDD VDD network.neuron_in089.counter\[3\]
+ sky130_fd_sc_hd__edfxtp_1
Xnetwork.neuron_in089.spike$_SDFFE_PP0P_ clknet_leaf_52_clk_net
+ _01776_ VSS VSS VDD VDD network.in_spk09_05 sky130_fd_sc_hd__dfxtp_1
Xnetwork.neuron_in090.counter\[0\]$_DFFE_PP_ clknet_leaf_48_clk_net
+ _02423_ _01414_ VSS VSS VDD VDD network.neuron_in090.counter\[0\]
+ sky130_fd_sc_hd__edfxtp_1
Xnetwork.neuron_in090.counter\[1\]$_DFFE_PP_ clknet_leaf_48_clk_net
+ _02424_ _01414_ VSS VSS VDD VDD network.neuron_in090.counter\[1\]
+ sky130_fd_sc_hd__edfxtp_1
Xnetwork.neuron_in090.counter\[2\]$_DFFE_PP_ clknet_leaf_48_clk_net
+ _02425_ _01414_ VSS VSS VDD VDD network.neuron_in090.counter\[2\]
+ sky130_fd_sc_hd__edfxtp_1
Xnetwork.neuron_in090.counter\[3\]$_DFFE_PP_ clknet_leaf_48_clk_net
+ _02426_ _01414_ VSS VSS VDD VDD network.neuron_in090.counter\[3\]
+ sky130_fd_sc_hd__edfxtp_1
Xnetwork.neuron_in090.spike$_SDFFE_PP0P_ clknet_leaf_51_clk_net
+ _01775_ VSS VSS VDD VDD network.in_spk10_05 sky130_fd_sc_hd__dfxtp_1
Xnetwork.neuron_in091.counter\[0\]$_DFFE_PP_ clknet_leaf_53_clk_net
+ _02427_ _01413_ VSS VSS VDD VDD network.neuron_in091.counter\[0\]
+ sky130_fd_sc_hd__edfxtp_1
Xnetwork.neuron_in091.counter\[1\]$_DFFE_PP_ clknet_leaf_53_clk_net
+ _02428_ _01413_ VSS VSS VDD VDD network.neuron_in091.counter\[1\]
+ sky130_fd_sc_hd__edfxtp_1
Xnetwork.neuron_in091.counter\[2\]$_DFFE_PP_ clknet_leaf_53_clk_net
+ _02429_ _01413_ VSS VSS VDD VDD network.neuron_in091.counter\[2\]
+ sky130_fd_sc_hd__edfxtp_1
Xnetwork.neuron_in091.counter\[3\]$_DFFE_PP_ clknet_leaf_53_clk_net
+ _02430_ _01413_ VSS VSS VDD VDD network.neuron_in091.counter\[3\]
+ sky130_fd_sc_hd__edfxtp_1
Xnetwork.neuron_in091.spike$_SDFFE_PP0P_ clknet_leaf_51_clk_net
+ _01774_ VSS VSS VDD VDD network.in_spk11_05 sky130_fd_sc_hd__dfxtp_1
Xnetwork.neuron_in092.counter\[0\]$_DFFE_PP_ clknet_leaf_45_clk_net
+ _02431_ _01412_ VSS VSS VDD VDD network.neuron_in092.counter\[0\]
+ sky130_fd_sc_hd__edfxtp_1
Xnetwork.neuron_in092.counter\[1\]$_DFFE_PP_ clknet_leaf_44_clk_net
+ _02432_ _01412_ VSS VSS VDD VDD network.neuron_in092.counter\[1\]
+ sky130_fd_sc_hd__edfxtp_1
Xnetwork.neuron_in092.counter\[2\]$_DFFE_PP_ clknet_leaf_45_clk_net
+ _02433_ _01412_ VSS VSS VDD VDD network.neuron_in092.counter\[2\]
+ sky130_fd_sc_hd__edfxtp_1
Xnetwork.neuron_in092.counter\[3\]$_DFFE_PP_ clknet_leaf_44_clk_net
+ _02434_ _01412_ VSS VSS VDD VDD network.neuron_in092.counter\[3\]
+ sky130_fd_sc_hd__edfxtp_1
Xnetwork.neuron_in092.spike$_SDFFE_PP0P_ clknet_leaf_62_clk_net
+ _01773_ VSS VSS VDD VDD network.in_spk12_05 sky130_fd_sc_hd__dfxtp_1
Xnetwork.neuron_in093.counter\[0\]$_DFFE_PP_ clknet_leaf_33_clk_net
+ _02435_ _01411_ VSS VSS VDD VDD network.neuron_in093.counter\[0\]
+ sky130_fd_sc_hd__edfxtp_1
Xnetwork.neuron_in093.counter\[1\]$_DFFE_PP_ clknet_leaf_32_clk_net
+ _02436_ _01411_ VSS VSS VDD VDD network.neuron_in093.counter\[1\]
+ sky130_fd_sc_hd__edfxtp_1
Xnetwork.neuron_in093.counter\[2\]$_DFFE_PP_ clknet_leaf_28_clk_net
+ _02437_ _01411_ VSS VSS VDD VDD network.neuron_in093.counter\[2\]
+ sky130_fd_sc_hd__edfxtp_1
Xnetwork.neuron_in093.counter\[3\]$_DFFE_PP_ clknet_leaf_33_clk_net
+ _02438_ _01411_ VSS VSS VDD VDD network.neuron_in093.counter\[3\]
+ sky130_fd_sc_hd__edfxtp_1
Xnetwork.neuron_in093.spike$_SDFFE_PP0P_ clknet_leaf_62_clk_net
+ _01772_ VSS VSS VDD VDD network.in_spk13_05 sky130_fd_sc_hd__dfxtp_1
Xnetwork.neuron_in094.counter\[0\]$_DFFE_PP_ clknet_leaf_50_clk_net
+ _02439_ _01410_ VSS VSS VDD VDD network.neuron_in094.counter\[0\]
+ sky130_fd_sc_hd__edfxtp_1
Xnetwork.neuron_in094.counter\[1\]$_DFFE_PP_ clknet_leaf_50_clk_net
+ _02440_ _01410_ VSS VSS VDD VDD network.neuron_in094.counter\[1\]
+ sky130_fd_sc_hd__edfxtp_1
Xnetwork.neuron_in094.counter\[2\]$_DFFE_PP_ clknet_leaf_62_clk_net
+ _02441_ _01410_ VSS VSS VDD VDD network.neuron_in094.counter\[2\]
+ sky130_fd_sc_hd__edfxtp_1
Xnetwork.neuron_in094.counter\[3\]$_DFFE_PP_ clknet_leaf_62_clk_net
+ _02442_ _01410_ VSS VSS VDD VDD network.neuron_in094.counter\[3\]
+ sky130_fd_sc_hd__edfxtp_1
Xnetwork.neuron_in094.spike$_SDFFE_PP0P_ clknet_leaf_62_clk_net
+ _01771_ VSS VSS VDD VDD network.in_spk14_05 sky130_fd_sc_hd__dfxtp_1
Xnetwork.neuron_in095.counter\[0\]$_DFFE_PP_ clknet_leaf_50_clk_net
+ _02443_ _01409_ VSS VSS VDD VDD network.neuron_in095.counter\[0\]
+ sky130_fd_sc_hd__edfxtp_1
Xnetwork.neuron_in095.counter\[1\]$_DFFE_PP_ clknet_leaf_50_clk_net
+ _02444_ _01409_ VSS VSS VDD VDD network.neuron_in095.counter\[1\]
+ sky130_fd_sc_hd__edfxtp_1
Xnetwork.neuron_in095.counter\[2\]$_DFFE_PP_ clknet_leaf_45_clk_net
+ _02445_ _01409_ VSS VSS VDD VDD network.neuron_in095.counter\[2\]
+ sky130_fd_sc_hd__edfxtp_1
Xnetwork.neuron_in095.counter\[3\]$_DFFE_PP_ clknet_leaf_45_clk_net
+ _02446_ _01409_ VSS VSS VDD VDD network.neuron_in095.counter\[3\]
+ sky130_fd_sc_hd__edfxtp_1
Xnetwork.neuron_in095.spike$_SDFFE_PP0P_ clknet_leaf_62_clk_net
+ _01770_ VSS VSS VDD VDD network.in_spk15_05 sky130_fd_sc_hd__dfxtp_1
Xnetwork.neuron_in096.counter\[0\]$_DFFE_PP_ clknet_leaf_45_clk_net
+ _02447_ _01408_ VSS VSS VDD VDD network.neuron_in096.counter\[0\]
+ sky130_fd_sc_hd__edfxtp_1
Xnetwork.neuron_in096.counter\[1\]$_DFFE_PP_ clknet_leaf_45_clk_net
+ _02448_ _01408_ VSS VSS VDD VDD network.neuron_in096.counter\[1\]
+ sky130_fd_sc_hd__edfxtp_1
Xnetwork.neuron_in096.counter\[2\]$_DFFE_PP_ clknet_leaf_45_clk_net
+ _02449_ _01408_ VSS VSS VDD VDD network.neuron_in096.counter\[2\]
+ sky130_fd_sc_hd__edfxtp_1
Xnetwork.neuron_in096.counter\[3\]$_DFFE_PP_ clknet_leaf_45_clk_net
+ _02450_ _01408_ VSS VSS VDD VDD network.neuron_in096.counter\[3\]
+ sky130_fd_sc_hd__edfxtp_1
Xnetwork.neuron_in096.spike$_SDFFE_PP0P_ clknet_leaf_31_clk_net
+ _01769_ VSS VSS VDD VDD network.in_spk00_06 sky130_fd_sc_hd__dfxtp_1
Xnetwork.neuron_in097.counter\[0\]$_DFFE_PP_ clknet_leaf_31_clk_net
+ _02451_ _01407_ VSS VSS VDD VDD network.neuron_in097.counter\[0\]
+ sky130_fd_sc_hd__edfxtp_1
Xnetwork.neuron_in097.counter\[1\]$_DFFE_PP_ clknet_leaf_31_clk_net
+ _02452_ _01407_ VSS VSS VDD VDD network.neuron_in097.counter\[1\]
+ sky130_fd_sc_hd__edfxtp_1
Xnetwork.neuron_in097.counter\[2\]$_DFFE_PP_ clknet_leaf_31_clk_net
+ _02453_ _01407_ VSS VSS VDD VDD network.neuron_in097.counter\[2\]
+ sky130_fd_sc_hd__edfxtp_1
Xnetwork.neuron_in097.counter\[3\]$_DFFE_PP_ clknet_leaf_31_clk_net
+ _02454_ _01407_ VSS VSS VDD VDD network.neuron_in097.counter\[3\]
+ sky130_fd_sc_hd__edfxtp_1
Xnetwork.neuron_in097.spike$_SDFFE_PP0P_ clknet_leaf_30_clk_net
+ _01768_ VSS VSS VDD VDD network.in_spk01_06 sky130_fd_sc_hd__dfxtp_1
Xnetwork.neuron_in098.counter\[0\]$_DFFE_PP_ clknet_leaf_46_clk_net
+ _02455_ _01406_ VSS VSS VDD VDD network.neuron_in098.counter\[0\]
+ sky130_fd_sc_hd__edfxtp_1
Xnetwork.neuron_in098.counter\[1\]$_DFFE_PP_ clknet_leaf_46_clk_net
+ _02456_ _01406_ VSS VSS VDD VDD network.neuron_in098.counter\[1\]
+ sky130_fd_sc_hd__edfxtp_1
Xnetwork.neuron_in098.counter\[2\]$_DFFE_PP_ clknet_leaf_49_clk_net
+ _02457_ _01406_ VSS VSS VDD VDD network.neuron_in098.counter\[2\]
+ sky130_fd_sc_hd__edfxtp_1
Xnetwork.neuron_in098.counter\[3\]$_DFFE_PP_ clknet_leaf_49_clk_net
+ _02458_ _01406_ VSS VSS VDD VDD network.neuron_in098.counter\[3\]
+ sky130_fd_sc_hd__edfxtp_1
Xnetwork.neuron_in098.spike$_SDFFE_PP0P_ clknet_leaf_62_clk_net
+ _02062_ VSS VSS VDD VDD network.in_spk02_06 sky130_fd_sc_hd__dfxtp_1
Xnetwork.neuron_in099.counter\[0\]$_DFFE_PP_ clknet_leaf_46_clk_net
+ _02459_ _01405_ VSS VSS VDD VDD network.neuron_in099.counter\[0\]
+ sky130_fd_sc_hd__edfxtp_1
Xnetwork.neuron_in099.counter\[1\]$_DFFE_PP_ clknet_leaf_46_clk_net
+ _02460_ _01405_ VSS VSS VDD VDD network.neuron_in099.counter\[1\]
+ sky130_fd_sc_hd__edfxtp_1
Xnetwork.neuron_in099.counter\[2\]$_DFFE_PP_ clknet_leaf_46_clk_net
+ _02461_ _01405_ VSS VSS VDD VDD network.neuron_in099.counter\[2\]
+ sky130_fd_sc_hd__edfxtp_1
Xnetwork.neuron_in099.counter\[3\]$_DFFE_PP_ clknet_leaf_46_clk_net
+ _02462_ _01405_ VSS VSS VDD VDD network.neuron_in099.counter\[3\]
+ sky130_fd_sc_hd__edfxtp_1
Xnetwork.neuron_in099.spike$_SDFFE_PP0P_ clknet_leaf_62_clk_net
+ _02061_ VSS VSS VDD VDD network.in_spk03_06 sky130_fd_sc_hd__dfxtp_1
Xnetwork.neuron_in100.counter\[0\]$_DFFE_PP_ clknet_leaf_46_clk_net
+ _02463_ _01404_ VSS VSS VDD VDD network.neuron_in100.counter\[0\]
+ sky130_fd_sc_hd__edfxtp_1
Xnetwork.neuron_in100.counter\[1\]$_DFFE_PP_ clknet_leaf_47_clk_net
+ _02464_ _01404_ VSS VSS VDD VDD network.neuron_in100.counter\[1\]
+ sky130_fd_sc_hd__edfxtp_1
Xnetwork.neuron_in100.counter\[2\]$_DFFE_PP_ clknet_leaf_49_clk_net
+ _02465_ _01404_ VSS VSS VDD VDD network.neuron_in100.counter\[2\]
+ sky130_fd_sc_hd__edfxtp_1
Xnetwork.neuron_in100.counter\[3\]$_DFFE_PP_ clknet_leaf_49_clk_net
+ _02466_ _01404_ VSS VSS VDD VDD network.neuron_in100.counter\[3\]
+ sky130_fd_sc_hd__edfxtp_1
Xnetwork.neuron_in100.spike$_SDFFE_PP0P_ clknet_leaf_62_clk_net
+ _02060_ VSS VSS VDD VDD network.in_spk04_06 sky130_fd_sc_hd__dfxtp_1
Xnetwork.neuron_in101.counter\[0\]$_DFFE_PP_ clknet_leaf_53_clk_net
+ _02467_ _01403_ VSS VSS VDD VDD network.neuron_in101.counter\[0\]
+ sky130_fd_sc_hd__edfxtp_1
Xnetwork.neuron_in101.counter\[1\]$_DFFE_PP_ clknet_leaf_53_clk_net
+ _02468_ _01403_ VSS VSS VDD VDD network.neuron_in101.counter\[1\]
+ sky130_fd_sc_hd__edfxtp_1
Xnetwork.neuron_in101.counter\[2\]$_DFFE_PP_ clknet_leaf_51_clk_net
+ _02469_ _01403_ VSS VSS VDD VDD network.neuron_in101.counter\[2\]
+ sky130_fd_sc_hd__edfxtp_1
Xnetwork.neuron_in101.counter\[3\]$_DFFE_PP_ clknet_leaf_51_clk_net
+ _02470_ _01403_ VSS VSS VDD VDD network.neuron_in101.counter\[3\]
+ sky130_fd_sc_hd__edfxtp_1
Xnetwork.neuron_in101.spike$_SDFFE_PP0P_ clknet_leaf_62_clk_net
+ _02059_ VSS VSS VDD VDD network.in_spk05_06 sky130_fd_sc_hd__dfxtp_1
Xnetwork.neuron_in102.counter\[0\]$_DFFE_PP_ clknet_leaf_50_clk_net
+ _02471_ _01402_ VSS VSS VDD VDD network.neuron_in102.counter\[0\]
+ sky130_fd_sc_hd__edfxtp_1
Xnetwork.neuron_in102.counter\[1\]$_DFFE_PP_ clknet_leaf_50_clk_net
+ _02472_ _01402_ VSS VSS VDD VDD network.neuron_in102.counter\[1\]
+ sky130_fd_sc_hd__edfxtp_1
Xnetwork.neuron_in102.counter\[2\]$_DFFE_PP_ clknet_leaf_51_clk_net
+ _02473_ _01402_ VSS VSS VDD VDD network.neuron_in102.counter\[2\]
+ sky130_fd_sc_hd__edfxtp_1
Xnetwork.neuron_in102.counter\[3\]$_DFFE_PP_ clknet_leaf_51_clk_net
+ _02474_ _01402_ VSS VSS VDD VDD network.neuron_in102.counter\[3\]
+ sky130_fd_sc_hd__edfxtp_1
Xnetwork.neuron_in102.spike$_SDFFE_PP0P_ clknet_leaf_62_clk_net
+ _02058_ VSS VSS VDD VDD network.in_spk06_06 sky130_fd_sc_hd__dfxtp_1
Xnetwork.neuron_in103.counter\[0\]$_DFFE_PP_ clknet_leaf_32_clk_net
+ _02475_ _01401_ VSS VSS VDD VDD network.neuron_in103.counter\[0\]
+ sky130_fd_sc_hd__edfxtp_1
Xnetwork.neuron_in103.counter\[1\]$_DFFE_PP_ clknet_leaf_32_clk_net
+ _02476_ _01401_ VSS VSS VDD VDD network.neuron_in103.counter\[1\]
+ sky130_fd_sc_hd__edfxtp_1
Xnetwork.neuron_in103.counter\[2\]$_DFFE_PP_ clknet_leaf_32_clk_net
+ _02477_ _01401_ VSS VSS VDD VDD network.neuron_in103.counter\[2\]
+ sky130_fd_sc_hd__edfxtp_1
Xnetwork.neuron_in103.counter\[3\]$_DFFE_PP_ clknet_leaf_32_clk_net
+ _02478_ _01401_ VSS VSS VDD VDD network.neuron_in103.counter\[3\]
+ sky130_fd_sc_hd__edfxtp_1
Xnetwork.neuron_in103.spike$_SDFFE_PP0P_ clknet_leaf_30_clk_net
+ _02057_ VSS VSS VDD VDD network.in_spk07_06 sky130_fd_sc_hd__dfxtp_1
Xnetwork.neuron_in104.counter\[0\]$_DFFE_PP_ clknet_leaf_31_clk_net
+ _02479_ _01400_ VSS VSS VDD VDD network.neuron_in104.counter\[0\]
+ sky130_fd_sc_hd__edfxtp_1
Xnetwork.neuron_in104.counter\[1\]$_DFFE_PP_ clknet_leaf_30_clk_net
+ _02480_ _01400_ VSS VSS VDD VDD network.neuron_in104.counter\[1\]
+ sky130_fd_sc_hd__edfxtp_1
Xnetwork.neuron_in104.counter\[2\]$_DFFE_PP_ clknet_leaf_30_clk_net
+ _02481_ _01400_ VSS VSS VDD VDD network.neuron_in104.counter\[2\]
+ sky130_fd_sc_hd__edfxtp_1
Xnetwork.neuron_in104.counter\[3\]$_DFFE_PP_ clknet_leaf_30_clk_net
+ _02482_ _01400_ VSS VSS VDD VDD network.neuron_in104.counter\[3\]
+ sky130_fd_sc_hd__edfxtp_1
Xnetwork.neuron_in104.spike$_SDFFE_PP0P_ clknet_leaf_30_clk_net
+ _02056_ VSS VSS VDD VDD network.in_spk08_06 sky130_fd_sc_hd__dfxtp_1
Xnetwork.neuron_in105.counter\[0\]$_DFFE_PP_ clknet_leaf_49_clk_net
+ _02483_ _01399_ VSS VSS VDD VDD network.neuron_in105.counter\[0\]
+ sky130_fd_sc_hd__edfxtp_1
Xnetwork.neuron_in105.counter\[1\]$_DFFE_PP_ clknet_leaf_49_clk_net
+ _02484_ _01399_ VSS VSS VDD VDD network.neuron_in105.counter\[1\]
+ sky130_fd_sc_hd__edfxtp_1
Xnetwork.neuron_in105.counter\[2\]$_DFFE_PP_ clknet_leaf_50_clk_net
+ _02485_ _01399_ VSS VSS VDD VDD network.neuron_in105.counter\[2\]
+ sky130_fd_sc_hd__edfxtp_1
Xnetwork.neuron_in105.counter\[3\]$_DFFE_PP_ clknet_leaf_50_clk_net
+ _02486_ _01399_ VSS VSS VDD VDD network.neuron_in105.counter\[3\]
+ sky130_fd_sc_hd__edfxtp_1
Xnetwork.neuron_in105.spike$_SDFFE_PP0P_ clknet_leaf_30_clk_net
+ _02055_ VSS VSS VDD VDD network.in_spk09_06 sky130_fd_sc_hd__dfxtp_1
Xnetwork.neuron_in106.counter\[0\]$_DFFE_PP_ clknet_leaf_41_clk_net
+ _02487_ _01398_ VSS VSS VDD VDD network.neuron_in106.counter\[0\]
+ sky130_fd_sc_hd__edfxtp_1
Xnetwork.neuron_in106.counter\[1\]$_DFFE_PP_ clknet_leaf_41_clk_net
+ _02488_ _01398_ VSS VSS VDD VDD network.neuron_in106.counter\[1\]
+ sky130_fd_sc_hd__edfxtp_1
Xnetwork.neuron_in106.counter\[2\]$_DFFE_PP_ clknet_leaf_41_clk_net
+ _02489_ _01398_ VSS VSS VDD VDD network.neuron_in106.counter\[2\]
+ sky130_fd_sc_hd__edfxtp_1
Xnetwork.neuron_in106.counter\[3\]$_DFFE_PP_ clknet_leaf_41_clk_net
+ _02490_ _01398_ VSS VSS VDD VDD network.neuron_in106.counter\[3\]
+ sky130_fd_sc_hd__edfxtp_1
Xnetwork.neuron_in106.spike$_SDFFE_PP0P_ clknet_leaf_44_clk_net
+ _02054_ VSS VSS VDD VDD network.in_spk10_06 sky130_fd_sc_hd__dfxtp_1
Xnetwork.neuron_in107.counter\[0\]$_DFFE_PP_ clknet_leaf_47_clk_net
+ _02491_ _01397_ VSS VSS VDD VDD network.neuron_in107.counter\[0\]
+ sky130_fd_sc_hd__edfxtp_1
Xnetwork.neuron_in107.counter\[1\]$_DFFE_PP_ clknet_leaf_47_clk_net
+ _02492_ _01397_ VSS VSS VDD VDD network.neuron_in107.counter\[1\]
+ sky130_fd_sc_hd__edfxtp_1
Xnetwork.neuron_in107.counter\[2\]$_DFFE_PP_ clknet_leaf_42_clk_net
+ _02493_ _01397_ VSS VSS VDD VDD network.neuron_in107.counter\[2\]
+ sky130_fd_sc_hd__edfxtp_1
Xnetwork.neuron_in107.counter\[3\]$_DFFE_PP_ clknet_leaf_47_clk_net
+ _02494_ _01397_ VSS VSS VDD VDD network.neuron_in107.counter\[3\]
+ sky130_fd_sc_hd__edfxtp_1
Xnetwork.neuron_in107.spike$_SDFFE_PP0P_ clknet_leaf_44_clk_net
+ _02053_ VSS VSS VDD VDD network.in_spk11_06 sky130_fd_sc_hd__dfxtp_1
Xnetwork.neuron_in108.counter\[0\]$_DFFE_PP_ clknet_leaf_42_clk_net
+ _02495_ _01396_ VSS VSS VDD VDD network.neuron_in108.counter\[0\]
+ sky130_fd_sc_hd__edfxtp_1
Xnetwork.neuron_in108.counter\[1\]$_DFFE_PP_ clknet_leaf_43_clk_net
+ _02496_ _01396_ VSS VSS VDD VDD network.neuron_in108.counter\[1\]
+ sky130_fd_sc_hd__edfxtp_1
Xnetwork.neuron_in108.counter\[2\]$_DFFE_PP_ clknet_leaf_43_clk_net
+ _02497_ _01396_ VSS VSS VDD VDD network.neuron_in108.counter\[2\]
+ sky130_fd_sc_hd__edfxtp_1
Xnetwork.neuron_in108.counter\[3\]$_DFFE_PP_ clknet_leaf_42_clk_net
+ _02498_ _01396_ VSS VSS VDD VDD network.neuron_in108.counter\[3\]
+ sky130_fd_sc_hd__edfxtp_1
Xnetwork.neuron_in108.spike$_SDFFE_PP0P_ clknet_leaf_43_clk_net
+ _02052_ VSS VSS VDD VDD network.in_spk12_06 sky130_fd_sc_hd__dfxtp_1
Xnetwork.neuron_in109.counter\[0\]$_DFFE_PP_ clknet_leaf_43_clk_net
+ _02499_ _01395_ VSS VSS VDD VDD network.neuron_in109.counter\[0\]
+ sky130_fd_sc_hd__edfxtp_1
Xnetwork.neuron_in109.counter\[1\]$_DFFE_PP_ clknet_leaf_43_clk_net
+ _02500_ _01395_ VSS VSS VDD VDD network.neuron_in109.counter\[1\]
+ sky130_fd_sc_hd__edfxtp_1
Xnetwork.neuron_in109.counter\[2\]$_DFFE_PP_ clknet_leaf_43_clk_net
+ _02501_ _01395_ VSS VSS VDD VDD network.neuron_in109.counter\[2\]
+ sky130_fd_sc_hd__edfxtp_1
Xnetwork.neuron_in109.counter\[3\]$_DFFE_PP_ clknet_leaf_43_clk_net
+ _02502_ _01395_ VSS VSS VDD VDD network.neuron_in109.counter\[3\]
+ sky130_fd_sc_hd__edfxtp_1
Xnetwork.neuron_in109.spike$_SDFFE_PP0P_ clknet_leaf_44_clk_net
+ _02051_ VSS VSS VDD VDD network.in_spk13_06 sky130_fd_sc_hd__dfxtp_1
Xnetwork.neuron_in110.counter\[0\]$_DFFE_PP_ clknet_leaf_42_clk_net
+ _02503_ _01394_ VSS VSS VDD VDD network.neuron_in110.counter\[0\]
+ sky130_fd_sc_hd__edfxtp_1
Xnetwork.neuron_in110.counter\[1\]$_DFFE_PP_ clknet_leaf_42_clk_net
+ _02504_ _01394_ VSS VSS VDD VDD network.neuron_in110.counter\[1\]
+ sky130_fd_sc_hd__edfxtp_1
Xnetwork.neuron_in110.counter\[2\]$_DFFE_PP_ clknet_leaf_42_clk_net
+ _02505_ _01394_ VSS VSS VDD VDD network.neuron_in110.counter\[2\]
+ sky130_fd_sc_hd__edfxtp_1
Xnetwork.neuron_in110.counter\[3\]$_DFFE_PP_ clknet_leaf_42_clk_net
+ _02506_ _01394_ VSS VSS VDD VDD network.neuron_in110.counter\[3\]
+ sky130_fd_sc_hd__edfxtp_1
Xnetwork.neuron_in110.spike$_SDFFE_PP0P_ clknet_leaf_44_clk_net
+ _02050_ VSS VSS VDD VDD network.in_spk14_06 sky130_fd_sc_hd__dfxtp_1
Xnetwork.neuron_in111.counter\[0\]$_DFFE_PP_ clknet_leaf_43_clk_net
+ _02507_ _01393_ VSS VSS VDD VDD network.neuron_in111.counter\[0\]
+ sky130_fd_sc_hd__edfxtp_1
Xnetwork.neuron_in111.counter\[1\]$_DFFE_PP_ clknet_leaf_43_clk_net
+ _02508_ _01393_ VSS VSS VDD VDD network.neuron_in111.counter\[1\]
+ sky130_fd_sc_hd__edfxtp_1
Xnetwork.neuron_in111.counter\[2\]$_DFFE_PP_ clknet_leaf_44_clk_net
+ _02509_ _01393_ VSS VSS VDD VDD network.neuron_in111.counter\[2\]
+ sky130_fd_sc_hd__edfxtp_1
Xnetwork.neuron_in111.counter\[3\]$_DFFE_PP_ clknet_leaf_44_clk_net
+ _02510_ _01393_ VSS VSS VDD VDD network.neuron_in111.counter\[3\]
+ sky130_fd_sc_hd__edfxtp_1
Xnetwork.neuron_in111.spike$_SDFFE_PP0P_ clknet_leaf_44_clk_net
+ _02049_ VSS VSS VDD VDD network.in_spk15_06 sky130_fd_sc_hd__dfxtp_1
Xnetwork.neuron_in112.counter\[0\]$_DFFE_PP_ clknet_leaf_38_clk_net
+ _02511_ _01392_ VSS VSS VDD VDD network.neuron_in112.counter\[0\]
+ sky130_fd_sc_hd__edfxtp_1
Xnetwork.neuron_in112.counter\[1\]$_DFFE_PP_ clknet_leaf_37_clk_net
+ _02512_ _01392_ VSS VSS VDD VDD network.neuron_in112.counter\[1\]
+ sky130_fd_sc_hd__edfxtp_1
Xnetwork.neuron_in112.counter\[2\]$_DFFE_PP_ clknet_leaf_38_clk_net
+ _02513_ _01392_ VSS VSS VDD VDD network.neuron_in112.counter\[2\]
+ sky130_fd_sc_hd__edfxtp_1
Xnetwork.neuron_in112.counter\[3\]$_DFFE_PP_ clknet_leaf_37_clk_net
+ _02514_ _01392_ VSS VSS VDD VDD network.neuron_in112.counter\[3\]
+ sky130_fd_sc_hd__edfxtp_1
Xnetwork.neuron_in112.spike$_SDFFE_PP0P_ clknet_leaf_36_clk_net
+ _02048_ VSS VSS VDD VDD network.in_spk00_07 sky130_fd_sc_hd__dfxtp_1
Xnetwork.neuron_in113.counter\[0\]$_DFFE_PP_ clknet_leaf_40_clk_net
+ _02515_ _01391_ VSS VSS VDD VDD network.neuron_in113.counter\[0\]
+ sky130_fd_sc_hd__edfxtp_1
Xnetwork.neuron_in113.counter\[1\]$_DFFE_PP_ clknet_leaf_40_clk_net
+ _02516_ _01391_ VSS VSS VDD VDD network.neuron_in113.counter\[1\]
+ sky130_fd_sc_hd__edfxtp_1
Xnetwork.neuron_in113.counter\[2\]$_DFFE_PP_ clknet_leaf_40_clk_net
+ _02517_ _01391_ VSS VSS VDD VDD network.neuron_in113.counter\[2\]
+ sky130_fd_sc_hd__edfxtp_1
Xnetwork.neuron_in113.counter\[3\]$_DFFE_PP_ clknet_leaf_40_clk_net
+ _02518_ _01391_ VSS VSS VDD VDD network.neuron_in113.counter\[3\]
+ sky130_fd_sc_hd__edfxtp_1
Xnetwork.neuron_in113.spike$_SDFFE_PP0P_ clknet_leaf_36_clk_net
+ _02047_ VSS VSS VDD VDD network.in_spk01_07 sky130_fd_sc_hd__dfxtp_1
Xnetwork.neuron_in114.counter\[0\]$_DFFE_PP_ clknet_leaf_41_clk_net
+ _02519_ _01390_ VSS VSS VDD VDD network.neuron_in114.counter\[0\]
+ sky130_fd_sc_hd__edfxtp_1
Xnetwork.neuron_in114.counter\[1\]$_DFFE_PP_ clknet_leaf_41_clk_net
+ _02520_ _01390_ VSS VSS VDD VDD network.neuron_in114.counter\[1\]
+ sky130_fd_sc_hd__edfxtp_1
Xnetwork.neuron_in114.counter\[2\]$_DFFE_PP_ clknet_leaf_41_clk_net
+ _02521_ _01390_ VSS VSS VDD VDD network.neuron_in114.counter\[2\]
+ sky130_fd_sc_hd__edfxtp_1
Xnetwork.neuron_in114.counter\[3\]$_DFFE_PP_ clknet_leaf_41_clk_net
+ _02522_ _01390_ VSS VSS VDD VDD network.neuron_in114.counter\[3\]
+ sky130_fd_sc_hd__edfxtp_1
Xnetwork.neuron_in114.spike$_SDFFE_PP0P_ clknet_leaf_36_clk_net
+ _02046_ VSS VSS VDD VDD network.in_spk02_07 sky130_fd_sc_hd__dfxtp_1
Xnetwork.neuron_in115.counter\[0\]$_DFFE_PP_ clknet_leaf_36_clk_net
+ _02523_ _01389_ VSS VSS VDD VDD network.neuron_in115.counter\[0\]
+ sky130_fd_sc_hd__edfxtp_1
Xnetwork.neuron_in115.counter\[1\]$_DFFE_PP_ clknet_leaf_35_clk_net
+ _02524_ _01389_ VSS VSS VDD VDD network.neuron_in115.counter\[1\]
+ sky130_fd_sc_hd__edfxtp_1
Xnetwork.neuron_in115.counter\[2\]$_DFFE_PP_ clknet_leaf_36_clk_net
+ _02525_ _01389_ VSS VSS VDD VDD network.neuron_in115.counter\[2\]
+ sky130_fd_sc_hd__edfxtp_1
Xnetwork.neuron_in115.counter\[3\]$_DFFE_PP_ clknet_leaf_36_clk_net
+ _02526_ _01389_ VSS VSS VDD VDD network.neuron_in115.counter\[3\]
+ sky130_fd_sc_hd__edfxtp_1
Xnetwork.neuron_in115.spike$_SDFFE_PP0P_ clknet_leaf_35_clk_net
+ _02045_ VSS VSS VDD VDD network.in_spk03_07 sky130_fd_sc_hd__dfxtp_1
Xnetwork.neuron_in116.counter\[0\]$_DFFE_PP_ clknet_leaf_39_clk_net
+ _02527_ _01388_ VSS VSS VDD VDD network.neuron_in116.counter\[0\]
+ sky130_fd_sc_hd__edfxtp_1
Xnetwork.neuron_in116.counter\[1\]$_DFFE_PP_ clknet_leaf_39_clk_net
+ _02528_ _01388_ VSS VSS VDD VDD network.neuron_in116.counter\[1\]
+ sky130_fd_sc_hd__edfxtp_1
Xnetwork.neuron_in116.counter\[2\]$_DFFE_PP_ clknet_leaf_39_clk_net
+ _02529_ _01388_ VSS VSS VDD VDD network.neuron_in116.counter\[2\]
+ sky130_fd_sc_hd__edfxtp_1
Xnetwork.neuron_in116.counter\[3\]$_DFFE_PP_ clknet_leaf_39_clk_net
+ _02530_ _01388_ VSS VSS VDD VDD network.neuron_in116.counter\[3\]
+ sky130_fd_sc_hd__edfxtp_1
Xnetwork.neuron_in116.spike$_SDFFE_PP0P_ clknet_leaf_36_clk_net
+ _02044_ VSS VSS VDD VDD network.in_spk04_07 sky130_fd_sc_hd__dfxtp_1
Xnetwork.neuron_in117.counter\[0\]$_DFFE_PP_ clknet_leaf_40_clk_net
+ _02531_ _01387_ VSS VSS VDD VDD network.neuron_in117.counter\[0\]
+ sky130_fd_sc_hd__edfxtp_1
Xnetwork.neuron_in117.counter\[1\]$_DFFE_PP_ clknet_leaf_40_clk_net
+ _02532_ _01387_ VSS VSS VDD VDD network.neuron_in117.counter\[1\]
+ sky130_fd_sc_hd__edfxtp_1
Xnetwork.neuron_in117.counter\[2\]$_DFFE_PP_ clknet_leaf_40_clk_net
+ _02533_ _01387_ VSS VSS VDD VDD network.neuron_in117.counter\[2\]
+ sky130_fd_sc_hd__edfxtp_1
Xnetwork.neuron_in117.counter\[3\]$_DFFE_PP_ clknet_leaf_40_clk_net
+ _02534_ _01387_ VSS VSS VDD VDD network.neuron_in117.counter\[3\]
+ sky130_fd_sc_hd__edfxtp_1
Xnetwork.neuron_in117.spike$_SDFFE_PP0P_ clknet_leaf_36_clk_net
+ _02043_ VSS VSS VDD VDD network.in_spk05_07 sky130_fd_sc_hd__dfxtp_1
Xnetwork.neuron_in118.counter\[0\]$_DFFE_PP_ clknet_leaf_35_clk_net
+ _02535_ _01386_ VSS VSS VDD VDD network.neuron_in118.counter\[0\]
+ sky130_fd_sc_hd__edfxtp_1
Xnetwork.neuron_in118.counter\[1\]$_DFFE_PP_ clknet_leaf_35_clk_net
+ _02536_ _01386_ VSS VSS VDD VDD network.neuron_in118.counter\[1\]
+ sky130_fd_sc_hd__edfxtp_1
Xnetwork.neuron_in118.counter\[2\]$_DFFE_PP_ clknet_leaf_13_clk_net
+ _02537_ _01386_ VSS VSS VDD VDD network.neuron_in118.counter\[2\]
+ sky130_fd_sc_hd__edfxtp_1
Xnetwork.neuron_in118.counter\[3\]$_DFFE_PP_ clknet_leaf_13_clk_net
+ _02538_ _01386_ VSS VSS VDD VDD network.neuron_in118.counter\[3\]
+ sky130_fd_sc_hd__edfxtp_1
Xnetwork.neuron_in118.spike$_SDFFE_PP0P_ clknet_leaf_37_clk_net
+ _02042_ VSS VSS VDD VDD network.in_spk06_07 sky130_fd_sc_hd__dfxtp_1
Xnetwork.neuron_in119.counter\[0\]$_DFFE_PP_ clknet_leaf_39_clk_net
+ _02539_ _01385_ VSS VSS VDD VDD network.neuron_in119.counter\[0\]
+ sky130_fd_sc_hd__edfxtp_1
Xnetwork.neuron_in119.counter\[1\]$_DFFE_PP_ clknet_leaf_39_clk_net
+ _02540_ _01385_ VSS VSS VDD VDD network.neuron_in119.counter\[1\]
+ sky130_fd_sc_hd__edfxtp_1
Xnetwork.neuron_in119.counter\[2\]$_DFFE_PP_ clknet_leaf_40_clk_net
+ _02541_ _01385_ VSS VSS VDD VDD network.neuron_in119.counter\[2\]
+ sky130_fd_sc_hd__edfxtp_1
Xnetwork.neuron_in119.counter\[3\]$_DFFE_PP_ clknet_leaf_39_clk_net
+ _02542_ _01385_ VSS VSS VDD VDD network.neuron_in119.counter\[3\]
+ sky130_fd_sc_hd__edfxtp_1
Xnetwork.neuron_in119.spike$_SDFFE_PP0P_ clknet_leaf_36_clk_net
+ _02041_ VSS VSS VDD VDD network.in_spk07_07 sky130_fd_sc_hd__dfxtp_1
Xnetwork.neuron_in120.counter\[0\]$_DFFE_PP_ clknet_leaf_38_clk_net
+ _02543_ _01384_ VSS VSS VDD VDD network.neuron_in120.counter\[0\]
+ sky130_fd_sc_hd__edfxtp_1
Xnetwork.neuron_in120.counter\[1\]$_DFFE_PP_ clknet_leaf_38_clk_net
+ _02544_ _01384_ VSS VSS VDD VDD network.neuron_in120.counter\[1\]
+ sky130_fd_sc_hd__edfxtp_1
Xnetwork.neuron_in120.counter\[2\]$_DFFE_PP_ clknet_leaf_39_clk_net
+ _02545_ _01384_ VSS VSS VDD VDD network.neuron_in120.counter\[2\]
+ sky130_fd_sc_hd__edfxtp_1
Xnetwork.neuron_in120.counter\[3\]$_DFFE_PP_ clknet_leaf_39_clk_net
+ _02546_ _01384_ VSS VSS VDD VDD network.neuron_in120.counter\[3\]
+ sky130_fd_sc_hd__edfxtp_1
Xnetwork.neuron_in120.spike$_SDFFE_PP0P_ clknet_leaf_38_clk_net
+ _02040_ VSS VSS VDD VDD network.in_spk08_07 sky130_fd_sc_hd__dfxtp_1
Xnetwork.neuron_in121.counter\[0\]$_DFFE_PP_ clknet_leaf_11_clk_net
+ _02547_ _01383_ VSS VSS VDD VDD network.neuron_in121.counter\[0\]
+ sky130_fd_sc_hd__edfxtp_1
Xnetwork.neuron_in121.counter\[1\]$_DFFE_PP_ clknet_leaf_11_clk_net
+ _02548_ _01383_ VSS VSS VDD VDD network.neuron_in121.counter\[1\]
+ sky130_fd_sc_hd__edfxtp_1
Xnetwork.neuron_in121.counter\[2\]$_DFFE_PP_ clknet_leaf_38_clk_net
+ _02549_ _01383_ VSS VSS VDD VDD network.neuron_in121.counter\[2\]
+ sky130_fd_sc_hd__edfxtp_1
Xnetwork.neuron_in121.counter\[3\]$_DFFE_PP_ clknet_leaf_38_clk_net
+ _02550_ _01383_ VSS VSS VDD VDD network.neuron_in121.counter\[3\]
+ sky130_fd_sc_hd__edfxtp_1
Xnetwork.neuron_in121.spike$_SDFFE_PP0P_ clknet_leaf_38_clk_net
+ _02039_ VSS VSS VDD VDD network.in_spk09_07 sky130_fd_sc_hd__dfxtp_1
Xnetwork.neuron_in122.counter\[0\]$_DFFE_PP_ clknet_leaf_11_clk_net
+ _02551_ _01382_ VSS VSS VDD VDD network.neuron_in122.counter\[0\]
+ sky130_fd_sc_hd__edfxtp_1
Xnetwork.neuron_in122.counter\[1\]$_DFFE_PP_ clknet_leaf_10_clk_net
+ _02552_ _01382_ VSS VSS VDD VDD network.neuron_in122.counter\[1\]
+ sky130_fd_sc_hd__edfxtp_1
Xnetwork.neuron_in122.counter\[2\]$_DFFE_PP_ clknet_leaf_10_clk_net
+ _02553_ _01382_ VSS VSS VDD VDD network.neuron_in122.counter\[2\]
+ sky130_fd_sc_hd__edfxtp_1
Xnetwork.neuron_in122.counter\[3\]$_DFFE_PP_ clknet_leaf_10_clk_net
+ _02554_ _01382_ VSS VSS VDD VDD network.neuron_in122.counter\[3\]
+ sky130_fd_sc_hd__edfxtp_1
Xnetwork.neuron_in122.spike$_SDFFE_PP0P_ clknet_leaf_37_clk_net
+ _02038_ VSS VSS VDD VDD network.in_spk10_07 sky130_fd_sc_hd__dfxtp_1
Xnetwork.neuron_in123.counter\[0\]$_DFFE_PP_ clknet_leaf_38_clk_net
+ _02555_ _01381_ VSS VSS VDD VDD network.neuron_in123.counter\[0\]
+ sky130_fd_sc_hd__edfxtp_1
Xnetwork.neuron_in123.counter\[1\]$_DFFE_PP_ clknet_leaf_38_clk_net
+ _02556_ _01381_ VSS VSS VDD VDD network.neuron_in123.counter\[1\]
+ sky130_fd_sc_hd__edfxtp_1
Xnetwork.neuron_in123.counter\[2\]$_DFFE_PP_ clknet_leaf_11_clk_net
+ _02557_ _01381_ VSS VSS VDD VDD network.neuron_in123.counter\[2\]
+ sky130_fd_sc_hd__edfxtp_1
Xnetwork.neuron_in123.counter\[3\]$_DFFE_PP_ clknet_leaf_11_clk_net
+ _02558_ _01381_ VSS VSS VDD VDD network.neuron_in123.counter\[3\]
+ sky130_fd_sc_hd__edfxtp_1
Xnetwork.neuron_in123.spike$_SDFFE_PP0P_ clknet_leaf_37_clk_net
+ _02037_ VSS VSS VDD VDD network.in_spk11_07 sky130_fd_sc_hd__dfxtp_1
Xnetwork.neuron_in124.counter\[0\]$_DFFE_PP_ clknet_leaf_12_clk_net
+ _02559_ _01380_ VSS VSS VDD VDD network.neuron_in124.counter\[0\]
+ sky130_fd_sc_hd__edfxtp_1
Xnetwork.neuron_in124.counter\[1\]$_DFFE_PP_ clknet_leaf_12_clk_net
+ _02560_ _01380_ VSS VSS VDD VDD network.neuron_in124.counter\[1\]
+ sky130_fd_sc_hd__edfxtp_1
Xnetwork.neuron_in124.counter\[2\]$_DFFE_PP_ clknet_leaf_12_clk_net
+ _02561_ _01380_ VSS VSS VDD VDD network.neuron_in124.counter\[2\]
+ sky130_fd_sc_hd__edfxtp_1
Xnetwork.neuron_in124.counter\[3\]$_DFFE_PP_ clknet_leaf_12_clk_net
+ _02562_ _01380_ VSS VSS VDD VDD network.neuron_in124.counter\[3\]
+ sky130_fd_sc_hd__edfxtp_1
Xnetwork.neuron_in124.spike$_SDFFE_PP0P_ clknet_leaf_37_clk_net
+ _02036_ VSS VSS VDD VDD network.in_spk12_07 sky130_fd_sc_hd__dfxtp_1
Xnetwork.neuron_in125.counter\[0\]$_DFFE_PP_ clknet_leaf_9_clk_net
+ _02563_ _01379_ VSS VSS VDD VDD network.neuron_in125.counter\[0\]
+ sky130_fd_sc_hd__edfxtp_1
Xnetwork.neuron_in125.counter\[1\]$_DFFE_PP_ clknet_leaf_9_clk_net
+ _02564_ _01379_ VSS VSS VDD VDD network.neuron_in125.counter\[1\]
+ sky130_fd_sc_hd__edfxtp_1
Xnetwork.neuron_in125.counter\[2\]$_DFFE_PP_ clknet_leaf_12_clk_net
+ _02565_ _01379_ VSS VSS VDD VDD network.neuron_in125.counter\[2\]
+ sky130_fd_sc_hd__edfxtp_1
Xnetwork.neuron_in125.counter\[3\]$_DFFE_PP_ clknet_leaf_12_clk_net
+ _02566_ _01379_ VSS VSS VDD VDD network.neuron_in125.counter\[3\]
+ sky130_fd_sc_hd__edfxtp_1
Xnetwork.neuron_in125.spike$_SDFFE_PP0P_ clknet_leaf_37_clk_net
+ _02035_ VSS VSS VDD VDD network.in_spk13_07 sky130_fd_sc_hd__dfxtp_1
Xnetwork.neuron_in126.counter\[0\]$_DFFE_PP_ clknet_leaf_12_clk_net
+ _02567_ _01378_ VSS VSS VDD VDD network.neuron_in126.counter\[0\]
+ sky130_fd_sc_hd__edfxtp_1
Xnetwork.neuron_in126.counter\[1\]$_DFFE_PP_ clknet_leaf_10_clk_net
+ _02568_ _01378_ VSS VSS VDD VDD network.neuron_in126.counter\[1\]
+ sky130_fd_sc_hd__edfxtp_1
Xnetwork.neuron_in126.counter\[2\]$_DFFE_PP_ clknet_leaf_12_clk_net
+ _02569_ _01378_ VSS VSS VDD VDD network.neuron_in126.counter\[2\]
+ sky130_fd_sc_hd__edfxtp_1
Xnetwork.neuron_in126.counter\[3\]$_DFFE_PP_ clknet_leaf_11_clk_net
+ _02570_ _01378_ VSS VSS VDD VDD network.neuron_in126.counter\[3\]
+ sky130_fd_sc_hd__edfxtp_1
Xnetwork.neuron_in126.spike$_SDFFE_PP0P_ clknet_leaf_11_clk_net
+ _02034_ VSS VSS VDD VDD network.in_spk14_07 sky130_fd_sc_hd__dfxtp_1
Xnetwork.neuron_in127.counter\[0\]$_DFFE_PP_ clknet_leaf_10_clk_net
+ _02571_ _01377_ VSS VSS VDD VDD network.neuron_in127.counter\[0\]
+ sky130_fd_sc_hd__edfxtp_1
Xnetwork.neuron_in127.counter\[1\]$_DFFE_PP_ clknet_leaf_10_clk_net
+ _02572_ _01377_ VSS VSS VDD VDD network.neuron_in127.counter\[1\]
+ sky130_fd_sc_hd__edfxtp_1
Xnetwork.neuron_in127.counter\[2\]$_DFFE_PP_ clknet_leaf_10_clk_net
+ _02573_ _01377_ VSS VSS VDD VDD network.neuron_in127.counter\[2\]
+ sky130_fd_sc_hd__edfxtp_1
Xnetwork.neuron_in127.counter\[3\]$_DFFE_PP_ clknet_leaf_10_clk_net
+ _02574_ _01377_ VSS VSS VDD VDD network.neuron_in127.counter\[3\]
+ sky130_fd_sc_hd__edfxtp_1
Xnetwork.neuron_in127.spike$_SDFFE_PP0P_ clknet_leaf_37_clk_net
+ _02033_ VSS VSS VDD VDD network.in_spk15_07 sky130_fd_sc_hd__dfxtp_1
Xnetwork.neuron_in128.counter\[0\]$_DFFE_PP_ clknet_leaf_19_clk_net
+ _02575_ _01376_ VSS VSS VDD VDD network.neuron_in128.counter\[0\]
+ sky130_fd_sc_hd__edfxtp_1
Xnetwork.neuron_in128.counter\[1\]$_DFFE_PP_ clknet_leaf_22_clk_net
+ _02576_ _01376_ VSS VSS VDD VDD network.neuron_in128.counter\[1\]
+ sky130_fd_sc_hd__edfxtp_1
Xnetwork.neuron_in128.counter\[2\]$_DFFE_PP_ clknet_leaf_22_clk_net
+ _02577_ _01376_ VSS VSS VDD VDD network.neuron_in128.counter\[2\]
+ sky130_fd_sc_hd__edfxtp_1
Xnetwork.neuron_in128.counter\[3\]$_DFFE_PP_ clknet_leaf_22_clk_net
+ _02578_ _01376_ VSS VSS VDD VDD network.neuron_in128.counter\[3\]
+ sky130_fd_sc_hd__edfxtp_1
Xnetwork.neuron_in128.spike$_SDFFE_PP0P_ clknet_leaf_160_clk_net
+ _02032_ VSS VSS VDD VDD network.in_spk00_08 sky130_fd_sc_hd__dfxtp_1
Xnetwork.neuron_in129.counter\[0\]$_DFFE_PP_ clknet_leaf_151_clk_net
+ _02579_ _01375_ VSS VSS VDD VDD network.neuron_in129.counter\[0\]
+ sky130_fd_sc_hd__edfxtp_1
Xnetwork.neuron_in129.counter\[1\]$_DFFE_PP_ clknet_leaf_151_clk_net
+ _02580_ _01375_ VSS VSS VDD VDD network.neuron_in129.counter\[1\]
+ sky130_fd_sc_hd__edfxtp_1
Xnetwork.neuron_in129.counter\[2\]$_DFFE_PP_ clknet_leaf_157_clk_net
+ _02581_ _01375_ VSS VSS VDD VDD network.neuron_in129.counter\[2\]
+ sky130_fd_sc_hd__edfxtp_1
Xnetwork.neuron_in129.counter\[3\]$_DFFE_PP_ clknet_leaf_157_clk_net
+ _02582_ _01375_ VSS VSS VDD VDD network.neuron_in129.counter\[3\]
+ sky130_fd_sc_hd__edfxtp_1
Xnetwork.neuron_in129.spike$_SDFFE_PP0P_ clknet_leaf_160_clk_net
+ _02031_ VSS VSS VDD VDD network.in_spk01_08 sky130_fd_sc_hd__dfxtp_1
Xnetwork.neuron_in130.counter\[0\]$_DFFE_PP_ clknet_leaf_107_clk_net
+ _02583_ _01374_ VSS VSS VDD VDD network.neuron_in130.counter\[0\]
+ sky130_fd_sc_hd__edfxtp_1
Xnetwork.neuron_in130.counter\[1\]$_DFFE_PP_ clknet_leaf_107_clk_net
+ _02584_ _01374_ VSS VSS VDD VDD network.neuron_in130.counter\[1\]
+ sky130_fd_sc_hd__edfxtp_1
Xnetwork.neuron_in130.counter\[2\]$_DFFE_PP_ clknet_leaf_107_clk_net
+ _02585_ _01374_ VSS VSS VDD VDD network.neuron_in130.counter\[2\]
+ sky130_fd_sc_hd__edfxtp_1
Xnetwork.neuron_in130.counter\[3\]$_DFFE_PP_ clknet_leaf_107_clk_net
+ _02586_ _01374_ VSS VSS VDD VDD network.neuron_in130.counter\[3\]
+ sky130_fd_sc_hd__edfxtp_1
Xnetwork.neuron_in130.spike$_SDFFE_PP0P_ clknet_leaf_159_clk_net
+ _02030_ VSS VSS VDD VDD network.in_spk02_08 sky130_fd_sc_hd__dfxtp_1
Xnetwork.neuron_in131.counter\[0\]$_DFFE_PP_ clknet_leaf_155_clk_net
+ _02587_ _01373_ VSS VSS VDD VDD network.neuron_in131.counter\[0\]
+ sky130_fd_sc_hd__edfxtp_1
Xnetwork.neuron_in131.counter\[1\]$_DFFE_PP_ clknet_leaf_155_clk_net
+ _02588_ _01373_ VSS VSS VDD VDD network.neuron_in131.counter\[1\]
+ sky130_fd_sc_hd__edfxtp_1
Xnetwork.neuron_in131.counter\[2\]$_DFFE_PP_ clknet_leaf_108_clk_net
+ _02589_ _01373_ VSS VSS VDD VDD network.neuron_in131.counter\[2\]
+ sky130_fd_sc_hd__edfxtp_1
Xnetwork.neuron_in131.counter\[3\]$_DFFE_PP_ clknet_leaf_111_clk_net
+ _02590_ _01373_ VSS VSS VDD VDD network.neuron_in131.counter\[3\]
+ sky130_fd_sc_hd__edfxtp_1
Xnetwork.neuron_in131.spike$_SDFFE_PP0P_ clknet_leaf_159_clk_net
+ _02029_ VSS VSS VDD VDD network.in_spk03_08 sky130_fd_sc_hd__dfxtp_1
Xnetwork.neuron_in132.counter\[0\]$_DFFE_PP_ clknet_leaf_162_clk_net
+ _02591_ _01372_ VSS VSS VDD VDD network.neuron_in132.counter\[0\]
+ sky130_fd_sc_hd__edfxtp_1
Xnetwork.neuron_in132.counter\[1\]$_DFFE_PP_ clknet_leaf_162_clk_net
+ _02592_ _01372_ VSS VSS VDD VDD network.neuron_in132.counter\[1\]
+ sky130_fd_sc_hd__edfxtp_1
Xnetwork.neuron_in132.counter\[2\]$_DFFE_PP_ clknet_leaf_162_clk_net
+ _02593_ _01372_ VSS VSS VDD VDD network.neuron_in132.counter\[2\]
+ sky130_fd_sc_hd__edfxtp_1
Xnetwork.neuron_in132.counter\[3\]$_DFFE_PP_ clknet_leaf_161_clk_net
+ _02594_ _01372_ VSS VSS VDD VDD network.neuron_in132.counter\[3\]
+ sky130_fd_sc_hd__edfxtp_1
Xnetwork.neuron_in132.spike$_SDFFE_PP0P_ clknet_leaf_161_clk_net
+ _02028_ VSS VSS VDD VDD network.in_spk04_08 sky130_fd_sc_hd__dfxtp_1
Xnetwork.neuron_in133.counter\[0\]$_DFFE_PP_ clknet_leaf_163_clk_net
+ _02595_ _01371_ VSS VSS VDD VDD network.neuron_in133.counter\[0\]
+ sky130_fd_sc_hd__edfxtp_1
Xnetwork.neuron_in133.counter\[1\]$_DFFE_PP_ clknet_leaf_162_clk_net
+ _02596_ _01371_ VSS VSS VDD VDD network.neuron_in133.counter\[1\]
+ sky130_fd_sc_hd__edfxtp_1
Xnetwork.neuron_in133.counter\[2\]$_DFFE_PP_ clknet_leaf_162_clk_net
+ _02597_ _01371_ VSS VSS VDD VDD network.neuron_in133.counter\[2\]
+ sky130_fd_sc_hd__edfxtp_1
Xnetwork.neuron_in133.counter\[3\]$_DFFE_PP_ clknet_leaf_162_clk_net
+ _02598_ _01371_ VSS VSS VDD VDD network.neuron_in133.counter\[3\]
+ sky130_fd_sc_hd__edfxtp_1
Xnetwork.neuron_in133.spike$_SDFFE_PP0P_ clknet_leaf_162_clk_net
+ _02027_ VSS VSS VDD VDD network.in_spk05_08 sky130_fd_sc_hd__dfxtp_1
Xnetwork.neuron_in134.counter\[0\]$_DFFE_PP_ clknet_leaf_165_clk_net
+ _02599_ _01370_ VSS VSS VDD VDD network.neuron_in134.counter\[0\]
+ sky130_fd_sc_hd__edfxtp_1
Xnetwork.neuron_in134.counter\[1\]$_DFFE_PP_ clknet_leaf_165_clk_net
+ _02600_ _01370_ VSS VSS VDD VDD network.neuron_in134.counter\[1\]
+ sky130_fd_sc_hd__edfxtp_1
Xnetwork.neuron_in134.counter\[2\]$_DFFE_PP_ clknet_leaf_165_clk_net
+ _02601_ _01370_ VSS VSS VDD VDD network.neuron_in134.counter\[2\]
+ sky130_fd_sc_hd__edfxtp_1
Xnetwork.neuron_in134.counter\[3\]$_DFFE_PP_ clknet_leaf_162_clk_net
+ _02602_ _01370_ VSS VSS VDD VDD network.neuron_in134.counter\[3\]
+ sky130_fd_sc_hd__edfxtp_1
Xnetwork.neuron_in134.spike$_SDFFE_PP0P_ clknet_leaf_162_clk_net
+ _02026_ VSS VSS VDD VDD network.in_spk06_08 sky130_fd_sc_hd__dfxtp_1
Xnetwork.neuron_in135.counter\[0\]$_DFFE_PP_ clknet_leaf_163_clk_net
+ _02603_ _01369_ VSS VSS VDD VDD network.neuron_in135.counter\[0\]
+ sky130_fd_sc_hd__edfxtp_1
Xnetwork.neuron_in135.counter\[1\]$_DFFE_PP_ clknet_leaf_163_clk_net
+ _02604_ _01369_ VSS VSS VDD VDD network.neuron_in135.counter\[1\]
+ sky130_fd_sc_hd__edfxtp_1
Xnetwork.neuron_in135.counter\[2\]$_DFFE_PP_ clknet_leaf_163_clk_net
+ _02605_ _01369_ VSS VSS VDD VDD network.neuron_in135.counter\[2\]
+ sky130_fd_sc_hd__edfxtp_1
Xnetwork.neuron_in135.counter\[3\]$_DFFE_PP_ clknet_leaf_163_clk_net
+ _02606_ _01369_ VSS VSS VDD VDD network.neuron_in135.counter\[3\]
+ sky130_fd_sc_hd__edfxtp_1
Xnetwork.neuron_in135.spike$_SDFFE_PP0P_ clknet_leaf_163_clk_net
+ _02025_ VSS VSS VDD VDD network.in_spk07_08 sky130_fd_sc_hd__dfxtp_1
Xnetwork.neuron_in136.counter\[0\]$_DFFE_PP_ clknet_leaf_159_clk_net
+ _02607_ _01368_ VSS VSS VDD VDD network.neuron_in136.counter\[0\]
+ sky130_fd_sc_hd__edfxtp_1
Xnetwork.neuron_in136.counter\[1\]$_DFFE_PP_ clknet_leaf_159_clk_net
+ _02608_ _01368_ VSS VSS VDD VDD network.neuron_in136.counter\[1\]
+ sky130_fd_sc_hd__edfxtp_1
Xnetwork.neuron_in136.counter\[2\]$_DFFE_PP_ clknet_leaf_107_clk_net
+ _02609_ _01368_ VSS VSS VDD VDD network.neuron_in136.counter\[2\]
+ sky130_fd_sc_hd__edfxtp_1
Xnetwork.neuron_in136.counter\[3\]$_DFFE_PP_ clknet_leaf_108_clk_net
+ _02610_ _01368_ VSS VSS VDD VDD network.neuron_in136.counter\[3\]
+ sky130_fd_sc_hd__edfxtp_1
Xnetwork.neuron_in136.spike$_SDFFE_PP0P_ clknet_leaf_159_clk_net
+ _02024_ VSS VSS VDD VDD network.in_spk08_08 sky130_fd_sc_hd__dfxtp_1
Xnetwork.neuron_in137.counter\[0\]$_DFFE_PP_ clknet_leaf_157_clk_net
+ _02611_ _01367_ VSS VSS VDD VDD network.neuron_in137.counter\[0\]
+ sky130_fd_sc_hd__edfxtp_1
Xnetwork.neuron_in137.counter\[1\]$_DFFE_PP_ clknet_leaf_157_clk_net
+ _02612_ _01367_ VSS VSS VDD VDD network.neuron_in137.counter\[1\]
+ sky130_fd_sc_hd__edfxtp_1
Xnetwork.neuron_in137.counter\[2\]$_DFFE_PP_ clknet_leaf_157_clk_net
+ _02613_ _01367_ VSS VSS VDD VDD network.neuron_in137.counter\[2\]
+ sky130_fd_sc_hd__edfxtp_1
Xnetwork.neuron_in137.counter\[3\]$_DFFE_PP_ clknet_leaf_158_clk_net
+ _02614_ _01367_ VSS VSS VDD VDD network.neuron_in137.counter\[3\]
+ sky130_fd_sc_hd__edfxtp_1
Xnetwork.neuron_in137.spike$_SDFFE_PP0P_ clknet_leaf_158_clk_net
+ _02023_ VSS VSS VDD VDD network.in_spk09_08 sky130_fd_sc_hd__dfxtp_1
Xnetwork.neuron_in138.counter\[0\]$_DFFE_PP_ clknet_leaf_156_clk_net
+ _02615_ _01366_ VSS VSS VDD VDD network.neuron_in138.counter\[0\]
+ sky130_fd_sc_hd__edfxtp_1
Xnetwork.neuron_in138.counter\[1\]$_DFFE_PP_ clknet_leaf_156_clk_net
+ _02616_ _01366_ VSS VSS VDD VDD network.neuron_in138.counter\[1\]
+ sky130_fd_sc_hd__edfxtp_1
Xnetwork.neuron_in138.counter\[2\]$_DFFE_PP_ clknet_leaf_156_clk_net
+ _02617_ _01366_ VSS VSS VDD VDD network.neuron_in138.counter\[2\]
+ sky130_fd_sc_hd__edfxtp_1
Xnetwork.neuron_in138.counter\[3\]$_DFFE_PP_ clknet_leaf_156_clk_net
+ _02618_ _01366_ VSS VSS VDD VDD network.neuron_in138.counter\[3\]
+ sky130_fd_sc_hd__edfxtp_1
Xnetwork.neuron_in138.spike$_SDFFE_PP0P_ clknet_leaf_158_clk_net
+ _02022_ VSS VSS VDD VDD network.in_spk10_08 sky130_fd_sc_hd__dfxtp_1
Xnetwork.neuron_in139.counter\[0\]$_DFFE_PP_ clknet_leaf_157_clk_net
+ _02619_ _01365_ VSS VSS VDD VDD network.neuron_in139.counter\[0\]
+ sky130_fd_sc_hd__edfxtp_1
Xnetwork.neuron_in139.counter\[1\]$_DFFE_PP_ clknet_leaf_157_clk_net
+ _02620_ _01365_ VSS VSS VDD VDD network.neuron_in139.counter\[1\]
+ sky130_fd_sc_hd__edfxtp_1
Xnetwork.neuron_in139.counter\[2\]$_DFFE_PP_ clknet_leaf_158_clk_net
+ _02621_ _01365_ VSS VSS VDD VDD network.neuron_in139.counter\[2\]
+ sky130_fd_sc_hd__edfxtp_1
Xnetwork.neuron_in139.counter\[3\]$_DFFE_PP_ clknet_leaf_157_clk_net
+ _02622_ _01365_ VSS VSS VDD VDD network.neuron_in139.counter\[3\]
+ sky130_fd_sc_hd__edfxtp_1
Xnetwork.neuron_in139.spike$_SDFFE_PP0P_ clknet_leaf_158_clk_net
+ _02021_ VSS VSS VDD VDD network.in_spk11_08 sky130_fd_sc_hd__dfxtp_1
Xnetwork.neuron_in140.counter\[0\]$_DFFE_PP_ clknet_leaf_158_clk_net
+ _02623_ _01364_ VSS VSS VDD VDD network.neuron_in140.counter\[0\]
+ sky130_fd_sc_hd__edfxtp_1
Xnetwork.neuron_in140.counter\[1\]$_DFFE_PP_ clknet_leaf_155_clk_net
+ _02624_ _01364_ VSS VSS VDD VDD network.neuron_in140.counter\[1\]
+ sky130_fd_sc_hd__edfxtp_1
Xnetwork.neuron_in140.counter\[2\]$_DFFE_PP_ clknet_leaf_155_clk_net
+ _02625_ _01364_ VSS VSS VDD VDD network.neuron_in140.counter\[2\]
+ sky130_fd_sc_hd__edfxtp_1
Xnetwork.neuron_in140.counter\[3\]$_DFFE_PP_ clknet_leaf_155_clk_net
+ _02626_ _01364_ VSS VSS VDD VDD network.neuron_in140.counter\[3\]
+ sky130_fd_sc_hd__edfxtp_1
Xnetwork.neuron_in140.spike$_SDFFE_PP0P_ clknet_leaf_158_clk_net
+ _02020_ VSS VSS VDD VDD network.in_spk12_08 sky130_fd_sc_hd__dfxtp_1
Xnetwork.neuron_in141.counter\[0\]$_DFFE_PP_ clknet_leaf_156_clk_net
+ _02627_ _01363_ VSS VSS VDD VDD network.neuron_in141.counter\[0\]
+ sky130_fd_sc_hd__edfxtp_1
Xnetwork.neuron_in141.counter\[1\]$_DFFE_PP_ clknet_leaf_156_clk_net
+ _02628_ _01363_ VSS VSS VDD VDD network.neuron_in141.counter\[1\]
+ sky130_fd_sc_hd__edfxtp_1
Xnetwork.neuron_in141.counter\[2\]$_DFFE_PP_ clknet_leaf_156_clk_net
+ _02629_ _01363_ VSS VSS VDD VDD network.neuron_in141.counter\[2\]
+ sky130_fd_sc_hd__edfxtp_1
Xnetwork.neuron_in141.counter\[3\]$_DFFE_PP_ clknet_leaf_155_clk_net
+ _02630_ _01363_ VSS VSS VDD VDD network.neuron_in141.counter\[3\]
+ sky130_fd_sc_hd__edfxtp_1
Xnetwork.neuron_in141.spike$_SDFFE_PP0P_ clknet_leaf_158_clk_net
+ _02019_ VSS VSS VDD VDD network.in_spk13_08 sky130_fd_sc_hd__dfxtp_1
Xnetwork.neuron_in142.counter\[0\]$_DFFE_PP_ clknet_leaf_154_clk_net
+ _02631_ _01362_ VSS VSS VDD VDD network.neuron_in142.counter\[0\]
+ sky130_fd_sc_hd__edfxtp_1
Xnetwork.neuron_in142.counter\[1\]$_DFFE_PP_ clknet_leaf_154_clk_net
+ _02632_ _01362_ VSS VSS VDD VDD network.neuron_in142.counter\[1\]
+ sky130_fd_sc_hd__edfxtp_1
Xnetwork.neuron_in142.counter\[2\]$_DFFE_PP_ clknet_leaf_154_clk_net
+ _02633_ _01362_ VSS VSS VDD VDD network.neuron_in142.counter\[2\]
+ sky130_fd_sc_hd__edfxtp_1
Xnetwork.neuron_in142.counter\[3\]$_DFFE_PP_ clknet_leaf_154_clk_net
+ _02634_ _01362_ VSS VSS VDD VDD network.neuron_in142.counter\[3\]
+ sky130_fd_sc_hd__edfxtp_1
Xnetwork.neuron_in142.spike$_SDFFE_PP0P_ clknet_leaf_158_clk_net
+ _02018_ VSS VSS VDD VDD network.in_spk14_08 sky130_fd_sc_hd__dfxtp_1
Xnetwork.neuron_in143.counter\[0\]$_DFFE_PP_ clknet_leaf_155_clk_net
+ _02635_ _01361_ VSS VSS VDD VDD network.neuron_in143.counter\[0\]
+ sky130_fd_sc_hd__edfxtp_1
Xnetwork.neuron_in143.counter\[1\]$_DFFE_PP_ clknet_leaf_155_clk_net
+ _02636_ _01361_ VSS VSS VDD VDD network.neuron_in143.counter\[1\]
+ sky130_fd_sc_hd__edfxtp_1
Xnetwork.neuron_in143.counter\[2\]$_DFFE_PP_ clknet_leaf_111_clk_net
+ _02637_ _01361_ VSS VSS VDD VDD network.neuron_in143.counter\[2\]
+ sky130_fd_sc_hd__edfxtp_1
Xnetwork.neuron_in143.counter\[3\]$_DFFE_PP_ clknet_leaf_154_clk_net
+ _02638_ _01361_ VSS VSS VDD VDD network.neuron_in143.counter\[3\]
+ sky130_fd_sc_hd__edfxtp_1
Xnetwork.neuron_in143.spike$_SDFFE_PP0P_ clknet_leaf_159_clk_net
+ _02017_ VSS VSS VDD VDD network.in_spk15_08 sky130_fd_sc_hd__dfxtp_1
Xnetwork.neuron_in144.counter\[0\]$_DFFE_PP_ clknet_leaf_63_clk_net
+ _02639_ _01360_ VSS VSS VDD VDD network.neuron_in144.counter\[0\]
+ sky130_fd_sc_hd__edfxtp_1
Xnetwork.neuron_in144.counter\[1\]$_DFFE_PP_ clknet_leaf_63_clk_net
+ _02640_ _01360_ VSS VSS VDD VDD network.neuron_in144.counter\[1\]
+ sky130_fd_sc_hd__edfxtp_1
Xnetwork.neuron_in144.counter\[2\]$_DFFE_PP_ clknet_leaf_64_clk_net
+ _02641_ _01360_ VSS VSS VDD VDD network.neuron_in144.counter\[2\]
+ sky130_fd_sc_hd__edfxtp_1
Xnetwork.neuron_in144.counter\[3\]$_DFFE_PP_ clknet_leaf_63_clk_net
+ _02642_ _01360_ VSS VSS VDD VDD network.neuron_in144.counter\[3\]
+ sky130_fd_sc_hd__edfxtp_1
Xnetwork.neuron_in144.spike$_SDFFE_PP0P_ clknet_leaf_64_clk_net
+ _02016_ VSS VSS VDD VDD network.in_spk00_09 sky130_fd_sc_hd__dfxtp_1
Xnetwork.neuron_in145.counter\[0\]$_DFFE_PP_ clknet_leaf_65_clk_net
+ _02643_ _01359_ VSS VSS VDD VDD network.neuron_in145.counter\[0\]
+ sky130_fd_sc_hd__edfxtp_1
Xnetwork.neuron_in145.counter\[1\]$_DFFE_PP_ clknet_leaf_65_clk_net
+ _02644_ _01359_ VSS VSS VDD VDD network.neuron_in145.counter\[1\]
+ sky130_fd_sc_hd__edfxtp_1
Xnetwork.neuron_in145.counter\[2\]$_DFFE_PP_ clknet_leaf_65_clk_net
+ _02645_ _01359_ VSS VSS VDD VDD network.neuron_in145.counter\[2\]
+ sky130_fd_sc_hd__edfxtp_1
Xnetwork.neuron_in145.counter\[3\]$_DFFE_PP_ clknet_leaf_65_clk_net
+ _02646_ _01359_ VSS VSS VDD VDD network.neuron_in145.counter\[3\]
+ sky130_fd_sc_hd__edfxtp_1
Xnetwork.neuron_in145.spike$_SDFFE_PP0P_ clknet_leaf_64_clk_net
+ _02015_ VSS VSS VDD VDD network.in_spk01_09 sky130_fd_sc_hd__dfxtp_1
Xnetwork.neuron_in146.counter\[0\]$_DFFE_PP_ clknet_leaf_58_clk_net
+ _02647_ _01358_ VSS VSS VDD VDD network.neuron_in146.counter\[0\]
+ sky130_fd_sc_hd__edfxtp_1
Xnetwork.neuron_in146.counter\[1\]$_DFFE_PP_ clknet_leaf_58_clk_net
+ _02648_ _01358_ VSS VSS VDD VDD network.neuron_in146.counter\[1\]
+ sky130_fd_sc_hd__edfxtp_1
Xnetwork.neuron_in146.counter\[2\]$_DFFE_PP_ clknet_leaf_57_clk_net
+ _02649_ _01358_ VSS VSS VDD VDD network.neuron_in146.counter\[2\]
+ sky130_fd_sc_hd__edfxtp_1
Xnetwork.neuron_in146.counter\[3\]$_DFFE_PP_ clknet_leaf_57_clk_net
+ _02650_ _01358_ VSS VSS VDD VDD network.neuron_in146.counter\[3\]
+ sky130_fd_sc_hd__edfxtp_1
Xnetwork.neuron_in146.spike$_SDFFE_PP0P_ clknet_leaf_66_clk_net
+ _02014_ VSS VSS VDD VDD network.in_spk02_09 sky130_fd_sc_hd__dfxtp_1
Xnetwork.neuron_in147.counter\[0\]$_DFFE_PP_ clknet_leaf_60_clk_net
+ _02651_ _01357_ VSS VSS VDD VDD network.neuron_in147.counter\[0\]
+ sky130_fd_sc_hd__edfxtp_1
Xnetwork.neuron_in147.counter\[1\]$_DFFE_PP_ clknet_leaf_60_clk_net
+ _02652_ _01357_ VSS VSS VDD VDD network.neuron_in147.counter\[1\]
+ sky130_fd_sc_hd__edfxtp_1
Xnetwork.neuron_in147.counter\[2\]$_DFFE_PP_ clknet_leaf_58_clk_net
+ _02653_ _01357_ VSS VSS VDD VDD network.neuron_in147.counter\[2\]
+ sky130_fd_sc_hd__edfxtp_1
Xnetwork.neuron_in147.counter\[3\]$_DFFE_PP_ clknet_leaf_60_clk_net
+ _02654_ _01357_ VSS VSS VDD VDD network.neuron_in147.counter\[3\]
+ sky130_fd_sc_hd__edfxtp_1
Xnetwork.neuron_in147.spike$_SDFFE_PP0P_ clknet_leaf_64_clk_net
+ _02013_ VSS VSS VDD VDD network.in_spk03_09 sky130_fd_sc_hd__dfxtp_1
Xnetwork.neuron_in148.counter\[0\]$_DFFE_PP_ clknet_leaf_60_clk_net
+ _02655_ _01356_ VSS VSS VDD VDD network.neuron_in148.counter\[0\]
+ sky130_fd_sc_hd__edfxtp_1
Xnetwork.neuron_in148.counter\[1\]$_DFFE_PP_ clknet_leaf_60_clk_net
+ _02656_ _01356_ VSS VSS VDD VDD network.neuron_in148.counter\[1\]
+ sky130_fd_sc_hd__edfxtp_1
Xnetwork.neuron_in148.counter\[2\]$_DFFE_PP_ clknet_leaf_65_clk_net
+ _02657_ _01356_ VSS VSS VDD VDD network.neuron_in148.counter\[2\]
+ sky130_fd_sc_hd__edfxtp_1
Xnetwork.neuron_in148.counter\[3\]$_DFFE_PP_ clknet_leaf_60_clk_net
+ _02658_ _01356_ VSS VSS VDD VDD network.neuron_in148.counter\[3\]
+ sky130_fd_sc_hd__edfxtp_1
Xnetwork.neuron_in148.spike$_SDFFE_PP0P_ clknet_leaf_64_clk_net
+ _02012_ VSS VSS VDD VDD network.in_spk04_09 sky130_fd_sc_hd__dfxtp_1
Xnetwork.neuron_in149.counter\[0\]$_DFFE_PP_ clknet_leaf_59_clk_net
+ _02659_ _01355_ VSS VSS VDD VDD network.neuron_in149.counter\[0\]
+ sky130_fd_sc_hd__edfxtp_1
Xnetwork.neuron_in149.counter\[1\]$_DFFE_PP_ clknet_leaf_59_clk_net
+ _02660_ _01355_ VSS VSS VDD VDD network.neuron_in149.counter\[1\]
+ sky130_fd_sc_hd__edfxtp_1
Xnetwork.neuron_in149.counter\[2\]$_DFFE_PP_ clknet_leaf_59_clk_net
+ _02661_ _01355_ VSS VSS VDD VDD network.neuron_in149.counter\[2\]
+ sky130_fd_sc_hd__edfxtp_1
Xnetwork.neuron_in149.counter\[3\]$_DFFE_PP_ clknet_leaf_65_clk_net
+ _02662_ _01355_ VSS VSS VDD VDD network.neuron_in149.counter\[3\]
+ sky130_fd_sc_hd__edfxtp_1
Xnetwork.neuron_in149.spike$_SDFFE_PP0P_ clknet_leaf_64_clk_net
+ _02011_ VSS VSS VDD VDD network.in_spk05_09 sky130_fd_sc_hd__dfxtp_1
Xnetwork.neuron_in150.counter\[0\]$_DFFE_PP_ clknet_leaf_61_clk_net
+ _02663_ _01354_ VSS VSS VDD VDD network.neuron_in150.counter\[0\]
+ sky130_fd_sc_hd__edfxtp_1
Xnetwork.neuron_in150.counter\[1\]$_DFFE_PP_ clknet_leaf_63_clk_net
+ _02664_ _01354_ VSS VSS VDD VDD network.neuron_in150.counter\[1\]
+ sky130_fd_sc_hd__edfxtp_1
Xnetwork.neuron_in150.counter\[2\]$_DFFE_PP_ clknet_leaf_65_clk_net
+ _02665_ _01354_ VSS VSS VDD VDD network.neuron_in150.counter\[2\]
+ sky130_fd_sc_hd__edfxtp_1
Xnetwork.neuron_in150.counter\[3\]$_DFFE_PP_ clknet_leaf_61_clk_net
+ _02666_ _01354_ VSS VSS VDD VDD network.neuron_in150.counter\[3\]
+ sky130_fd_sc_hd__edfxtp_1
Xnetwork.neuron_in150.spike$_SDFFE_PP0P_ clknet_leaf_64_clk_net
+ _02010_ VSS VSS VDD VDD network.in_spk06_09 sky130_fd_sc_hd__dfxtp_1
Xnetwork.neuron_in151.counter\[0\]$_DFFE_PP_ clknet_leaf_63_clk_net
+ _02667_ _01353_ VSS VSS VDD VDD network.neuron_in151.counter\[0\]
+ sky130_fd_sc_hd__edfxtp_1
Xnetwork.neuron_in151.counter\[1\]$_DFFE_PP_ clknet_leaf_63_clk_net
+ _02668_ _01353_ VSS VSS VDD VDD network.neuron_in151.counter\[1\]
+ sky130_fd_sc_hd__edfxtp_1
Xnetwork.neuron_in151.counter\[2\]$_DFFE_PP_ clknet_leaf_63_clk_net
+ _02669_ _01353_ VSS VSS VDD VDD network.neuron_in151.counter\[2\]
+ sky130_fd_sc_hd__edfxtp_1
Xnetwork.neuron_in151.counter\[3\]$_DFFE_PP_ clknet_leaf_63_clk_net
+ _02670_ _01353_ VSS VSS VDD VDD network.neuron_in151.counter\[3\]
+ sky130_fd_sc_hd__edfxtp_1
Xnetwork.neuron_in151.spike$_SDFFE_PP0P_ clknet_leaf_64_clk_net
+ _02009_ VSS VSS VDD VDD network.in_spk07_09 sky130_fd_sc_hd__dfxtp_1
Xnetwork.neuron_in152.counter\[0\]$_DFFE_PP_ clknet_leaf_29_clk_net
+ _02671_ _01352_ VSS VSS VDD VDD network.neuron_in152.counter\[0\]
+ sky130_fd_sc_hd__edfxtp_1
Xnetwork.neuron_in152.counter\[1\]$_DFFE_PP_ clknet_leaf_29_clk_net
+ _02672_ _01352_ VSS VSS VDD VDD network.neuron_in152.counter\[1\]
+ sky130_fd_sc_hd__edfxtp_1
Xnetwork.neuron_in152.counter\[2\]$_DFFE_PP_ clknet_leaf_29_clk_net
+ _02673_ _01352_ VSS VSS VDD VDD network.neuron_in152.counter\[2\]
+ sky130_fd_sc_hd__edfxtp_1
Xnetwork.neuron_in152.counter\[3\]$_DFFE_PP_ clknet_leaf_29_clk_net
+ _02674_ _01352_ VSS VSS VDD VDD network.neuron_in152.counter\[3\]
+ sky130_fd_sc_hd__edfxtp_1
Xnetwork.neuron_in152.spike$_SDFFE_PP0P_ clknet_leaf_29_clk_net
+ _02008_ VSS VSS VDD VDD network.in_spk08_09 sky130_fd_sc_hd__dfxtp_1
Xnetwork.neuron_in153.counter\[0\]$_DFFE_PP_ clknet_leaf_28_clk_net
+ _02675_ _01351_ VSS VSS VDD VDD network.neuron_in153.counter\[0\]
+ sky130_fd_sc_hd__edfxtp_1
Xnetwork.neuron_in153.counter\[1\]$_DFFE_PP_ clknet_leaf_28_clk_net
+ _02676_ _01351_ VSS VSS VDD VDD network.neuron_in153.counter\[1\]
+ sky130_fd_sc_hd__edfxtp_1
Xnetwork.neuron_in153.counter\[2\]$_DFFE_PP_ clknet_leaf_28_clk_net
+ _02677_ _01351_ VSS VSS VDD VDD network.neuron_in153.counter\[2\]
+ sky130_fd_sc_hd__edfxtp_1
Xnetwork.neuron_in153.counter\[3\]$_DFFE_PP_ clknet_leaf_28_clk_net
+ _02678_ _01351_ VSS VSS VDD VDD network.neuron_in153.counter\[3\]
+ sky130_fd_sc_hd__edfxtp_1
Xnetwork.neuron_in153.spike$_SDFFE_PP0P_ clknet_leaf_67_clk_net
+ _02007_ VSS VSS VDD VDD network.in_spk09_09 sky130_fd_sc_hd__dfxtp_1
Xnetwork.neuron_in154.counter\[0\]$_DFFE_PP_ clknet_leaf_24_clk_net
+ _02679_ _01350_ VSS VSS VDD VDD network.neuron_in154.counter\[0\]
+ sky130_fd_sc_hd__edfxtp_1
Xnetwork.neuron_in154.counter\[1\]$_DFFE_PP_ clknet_leaf_24_clk_net
+ _02680_ _01350_ VSS VSS VDD VDD network.neuron_in154.counter\[1\]
+ sky130_fd_sc_hd__edfxtp_1
Xnetwork.neuron_in154.counter\[2\]$_DFFE_PP_ clknet_leaf_24_clk_net
+ _02681_ _01350_ VSS VSS VDD VDD network.neuron_in154.counter\[2\]
+ sky130_fd_sc_hd__edfxtp_1
Xnetwork.neuron_in154.counter\[3\]$_DFFE_PP_ clknet_leaf_24_clk_net
+ _02682_ _01350_ VSS VSS VDD VDD network.neuron_in154.counter\[3\]
+ sky130_fd_sc_hd__edfxtp_1
Xnetwork.neuron_in154.spike$_SDFFE_PP0P_ clknet_leaf_67_clk_net
+ _02006_ VSS VSS VDD VDD network.in_spk10_09 sky130_fd_sc_hd__dfxtp_1
Xnetwork.neuron_in155.counter\[0\]$_DFFE_PP_ clknet_leaf_24_clk_net
+ _02683_ _01349_ VSS VSS VDD VDD network.neuron_in155.counter\[0\]
+ sky130_fd_sc_hd__edfxtp_1
Xnetwork.neuron_in155.counter\[1\]$_DFFE_PP_ clknet_leaf_24_clk_net
+ _02684_ _01349_ VSS VSS VDD VDD network.neuron_in155.counter\[1\]
+ sky130_fd_sc_hd__edfxtp_1
Xnetwork.neuron_in155.counter\[2\]$_DFFE_PP_ clknet_leaf_24_clk_net
+ _02685_ _01349_ VSS VSS VDD VDD network.neuron_in155.counter\[2\]
+ sky130_fd_sc_hd__edfxtp_1
Xnetwork.neuron_in155.counter\[3\]$_DFFE_PP_ clknet_leaf_24_clk_net
+ _02686_ _01349_ VSS VSS VDD VDD network.neuron_in155.counter\[3\]
+ sky130_fd_sc_hd__edfxtp_1
Xnetwork.neuron_in155.spike$_SDFFE_PP0P_ clknet_leaf_67_clk_net
+ _02005_ VSS VSS VDD VDD network.in_spk11_09 sky130_fd_sc_hd__dfxtp_1
Xnetwork.neuron_in156.counter\[0\]$_DFFE_PP_ clknet_leaf_21_clk_net
+ _02687_ _01348_ VSS VSS VDD VDD network.neuron_in156.counter\[0\]
+ sky130_fd_sc_hd__edfxtp_1
Xnetwork.neuron_in156.counter\[1\]$_DFFE_PP_ clknet_leaf_21_clk_net
+ _02688_ _01348_ VSS VSS VDD VDD network.neuron_in156.counter\[1\]
+ sky130_fd_sc_hd__edfxtp_1
Xnetwork.neuron_in156.counter\[2\]$_DFFE_PP_ clknet_leaf_21_clk_net
+ _02689_ _01348_ VSS VSS VDD VDD network.neuron_in156.counter\[2\]
+ sky130_fd_sc_hd__edfxtp_1
Xnetwork.neuron_in156.counter\[3\]$_DFFE_PP_ clknet_leaf_21_clk_net
+ _02690_ _01348_ VSS VSS VDD VDD network.neuron_in156.counter\[3\]
+ sky130_fd_sc_hd__edfxtp_1
Xnetwork.neuron_in156.spike$_SDFFE_PP0P_ clknet_leaf_25_clk_net
+ _02004_ VSS VSS VDD VDD network.in_spk12_09 sky130_fd_sc_hd__dfxtp_1
Xnetwork.neuron_in157.counter\[0\]$_DFFE_PP_ clknet_leaf_26_clk_net
+ _02691_ _01347_ VSS VSS VDD VDD network.neuron_in157.counter\[0\]
+ sky130_fd_sc_hd__edfxtp_1
Xnetwork.neuron_in157.counter\[1\]$_DFFE_PP_ clknet_leaf_26_clk_net
+ _02692_ _01347_ VSS VSS VDD VDD network.neuron_in157.counter\[1\]
+ sky130_fd_sc_hd__edfxtp_1
Xnetwork.neuron_in157.counter\[2\]$_DFFE_PP_ clknet_leaf_26_clk_net
+ _02693_ _01347_ VSS VSS VDD VDD network.neuron_in157.counter\[2\]
+ sky130_fd_sc_hd__edfxtp_1
Xnetwork.neuron_in157.counter\[3\]$_DFFE_PP_ clknet_leaf_26_clk_net
+ _02694_ _01347_ VSS VSS VDD VDD network.neuron_in157.counter\[3\]
+ sky130_fd_sc_hd__edfxtp_1
Xnetwork.neuron_in157.spike$_SDFFE_PP0P_ clknet_leaf_25_clk_net
+ _02003_ VSS VSS VDD VDD network.in_spk13_09 sky130_fd_sc_hd__dfxtp_1
Xnetwork.neuron_in158.counter\[0\]$_DFFE_PP_ clknet_leaf_26_clk_net
+ _02695_ _01346_ VSS VSS VDD VDD network.neuron_in158.counter\[0\]
+ sky130_fd_sc_hd__edfxtp_1
Xnetwork.neuron_in158.counter\[1\]$_DFFE_PP_ clknet_leaf_26_clk_net
+ _02696_ _01346_ VSS VSS VDD VDD network.neuron_in158.counter\[1\]
+ sky130_fd_sc_hd__edfxtp_1
Xnetwork.neuron_in158.counter\[2\]$_DFFE_PP_ clknet_leaf_26_clk_net
+ _02697_ _01346_ VSS VSS VDD VDD network.neuron_in158.counter\[2\]
+ sky130_fd_sc_hd__edfxtp_1
Xnetwork.neuron_in158.counter\[3\]$_DFFE_PP_ clknet_leaf_26_clk_net
+ _02698_ _01346_ VSS VSS VDD VDD network.neuron_in158.counter\[3\]
+ sky130_fd_sc_hd__edfxtp_1
Xnetwork.neuron_in158.spike$_SDFFE_PP0P_ clknet_leaf_25_clk_net
+ _02002_ VSS VSS VDD VDD network.in_spk14_09 sky130_fd_sc_hd__dfxtp_1
Xnetwork.neuron_in159.counter\[0\]$_DFFE_PP_ clknet_leaf_23_clk_net
+ _02699_ _01345_ VSS VSS VDD VDD network.neuron_in159.counter\[0\]
+ sky130_fd_sc_hd__edfxtp_1
Xnetwork.neuron_in159.counter\[1\]$_DFFE_PP_ clknet_leaf_23_clk_net
+ _02700_ _01345_ VSS VSS VDD VDD network.neuron_in159.counter\[1\]
+ sky130_fd_sc_hd__edfxtp_1
Xnetwork.neuron_in159.counter\[2\]$_DFFE_PP_ clknet_leaf_23_clk_net
+ _02701_ _01345_ VSS VSS VDD VDD network.neuron_in159.counter\[2\]
+ sky130_fd_sc_hd__edfxtp_1
Xnetwork.neuron_in159.counter\[3\]$_DFFE_PP_ clknet_leaf_23_clk_net
+ _02702_ _01345_ VSS VSS VDD VDD network.neuron_in159.counter\[3\]
+ sky130_fd_sc_hd__edfxtp_1
Xnetwork.neuron_in159.spike$_SDFFE_PP0P_ clknet_leaf_25_clk_net
+ _02001_ VSS VSS VDD VDD network.in_spk15_09 sky130_fd_sc_hd__dfxtp_1
Xnetwork.neuron_in160.counter\[0\]$_DFFE_PP_ clknet_leaf_74_clk_net
+ _02703_ _01344_ VSS VSS VDD VDD network.neuron_in160.counter\[0\]
+ sky130_fd_sc_hd__edfxtp_1
Xnetwork.neuron_in160.counter\[1\]$_DFFE_PP_ clknet_leaf_74_clk_net
+ _02704_ _01344_ VSS VSS VDD VDD network.neuron_in160.counter\[1\]
+ sky130_fd_sc_hd__edfxtp_1
Xnetwork.neuron_in160.counter\[2\]$_DFFE_PP_ clknet_leaf_76_clk_net
+ _02705_ _01344_ VSS VSS VDD VDD network.neuron_in160.counter\[2\]
+ sky130_fd_sc_hd__edfxtp_1
Xnetwork.neuron_in160.counter\[3\]$_DFFE_PP_ clknet_leaf_78_clk_net
+ _02706_ _01344_ VSS VSS VDD VDD network.neuron_in160.counter\[3\]
+ sky130_fd_sc_hd__edfxtp_1
Xnetwork.neuron_in160.spike$_SDFFE_PP0P_ clknet_leaf_72_clk_net
+ _02000_ VSS VSS VDD VDD network.in_spk00_10 sky130_fd_sc_hd__dfxtp_1
Xnetwork.neuron_in161.counter\[0\]$_DFFE_PP_ clknet_leaf_66_clk_net
+ _02707_ _01343_ VSS VSS VDD VDD network.neuron_in161.counter\[0\]
+ sky130_fd_sc_hd__edfxtp_1
Xnetwork.neuron_in161.counter\[1\]$_DFFE_PP_ clknet_leaf_66_clk_net
+ _02708_ _01343_ VSS VSS VDD VDD network.neuron_in161.counter\[1\]
+ sky130_fd_sc_hd__edfxtp_1
Xnetwork.neuron_in161.counter\[2\]$_DFFE_PP_ clknet_leaf_71_clk_net
+ _02709_ _01343_ VSS VSS VDD VDD network.neuron_in161.counter\[2\]
+ sky130_fd_sc_hd__edfxtp_1
Xnetwork.neuron_in161.counter\[3\]$_DFFE_PP_ clknet_leaf_66_clk_net
+ _02710_ _01343_ VSS VSS VDD VDD network.neuron_in161.counter\[3\]
+ sky130_fd_sc_hd__edfxtp_1
Xnetwork.neuron_in161.spike$_SDFFE_PP0P_ clknet_leaf_71_clk_net
+ _01999_ VSS VSS VDD VDD network.in_spk01_10 sky130_fd_sc_hd__dfxtp_1
Xnetwork.neuron_in162.counter\[0\]$_DFFE_PP_ clknet_leaf_79_clk_net
+ _02711_ _01342_ VSS VSS VDD VDD network.neuron_in162.counter\[0\]
+ sky130_fd_sc_hd__edfxtp_1
Xnetwork.neuron_in162.counter\[1\]$_DFFE_PP_ clknet_leaf_79_clk_net
+ _02712_ _01342_ VSS VSS VDD VDD network.neuron_in162.counter\[1\]
+ sky130_fd_sc_hd__edfxtp_1
Xnetwork.neuron_in162.counter\[2\]$_DFFE_PP_ clknet_leaf_79_clk_net
+ _02713_ _01342_ VSS VSS VDD VDD network.neuron_in162.counter\[2\]
+ sky130_fd_sc_hd__edfxtp_1
Xnetwork.neuron_in162.counter\[3\]$_DFFE_PP_ clknet_leaf_79_clk_net
+ _02714_ _01342_ VSS VSS VDD VDD network.neuron_in162.counter\[3\]
+ sky130_fd_sc_hd__edfxtp_1
Xnetwork.neuron_in162.spike$_SDFFE_PP0P_ clknet_leaf_72_clk_net
+ _01998_ VSS VSS VDD VDD network.in_spk02_10 sky130_fd_sc_hd__dfxtp_1
Xnetwork.neuron_in163.counter\[0\]$_DFFE_PP_ clknet_leaf_77_clk_net
+ _02715_ _01341_ VSS VSS VDD VDD network.neuron_in163.counter\[0\]
+ sky130_fd_sc_hd__edfxtp_1
Xnetwork.neuron_in163.counter\[1\]$_DFFE_PP_ clknet_leaf_77_clk_net
+ _02716_ _01341_ VSS VSS VDD VDD network.neuron_in163.counter\[1\]
+ sky130_fd_sc_hd__edfxtp_1
Xnetwork.neuron_in163.counter\[2\]$_DFFE_PP_ clknet_leaf_77_clk_net
+ _02717_ _01341_ VSS VSS VDD VDD network.neuron_in163.counter\[2\]
+ sky130_fd_sc_hd__edfxtp_1
Xnetwork.neuron_in163.counter\[3\]$_DFFE_PP_ clknet_leaf_76_clk_net
+ _02718_ _01341_ VSS VSS VDD VDD network.neuron_in163.counter\[3\]
+ sky130_fd_sc_hd__edfxtp_1
Xnetwork.neuron_in163.spike$_SDFFE_PP0P_ clknet_leaf_72_clk_net
+ _01997_ VSS VSS VDD VDD network.in_spk03_10 sky130_fd_sc_hd__dfxtp_1
Xnetwork.neuron_in164.counter\[0\]$_DFFE_PP_ clknet_leaf_57_clk_net
+ _02719_ _01340_ VSS VSS VDD VDD network.neuron_in164.counter\[0\]
+ sky130_fd_sc_hd__edfxtp_1
Xnetwork.neuron_in164.counter\[1\]$_DFFE_PP_ clknet_leaf_57_clk_net
+ _02720_ _01340_ VSS VSS VDD VDD network.neuron_in164.counter\[1\]
+ sky130_fd_sc_hd__edfxtp_1
Xnetwork.neuron_in164.counter\[2\]$_DFFE_PP_ clknet_leaf_58_clk_net
+ _02721_ _01340_ VSS VSS VDD VDD network.neuron_in164.counter\[2\]
+ sky130_fd_sc_hd__edfxtp_1
Xnetwork.neuron_in164.counter\[3\]$_DFFE_PP_ clknet_leaf_58_clk_net
+ _02722_ _01340_ VSS VSS VDD VDD network.neuron_in164.counter\[3\]
+ sky130_fd_sc_hd__edfxtp_1
Xnetwork.neuron_in164.spike$_SDFFE_PP0P_ clknet_leaf_71_clk_net
+ _01996_ VSS VSS VDD VDD network.in_spk04_10 sky130_fd_sc_hd__dfxtp_1
Xnetwork.neuron_in165.counter\[0\]$_DFFE_PP_ clknet_leaf_80_clk_net
+ _02723_ _01339_ VSS VSS VDD VDD network.neuron_in165.counter\[0\]
+ sky130_fd_sc_hd__edfxtp_1
Xnetwork.neuron_in165.counter\[1\]$_DFFE_PP_ clknet_leaf_80_clk_net
+ _02724_ _01339_ VSS VSS VDD VDD network.neuron_in165.counter\[1\]
+ sky130_fd_sc_hd__edfxtp_1
Xnetwork.neuron_in165.counter\[2\]$_DFFE_PP_ clknet_leaf_79_clk_net
+ _02725_ _01339_ VSS VSS VDD VDD network.neuron_in165.counter\[2\]
+ sky130_fd_sc_hd__edfxtp_1
Xnetwork.neuron_in165.counter\[3\]$_DFFE_PP_ clknet_leaf_80_clk_net
+ _02726_ _01339_ VSS VSS VDD VDD network.neuron_in165.counter\[3\]
+ sky130_fd_sc_hd__edfxtp_1
Xnetwork.neuron_in165.spike$_SDFFE_PP0P_ clknet_leaf_72_clk_net
+ _01995_ VSS VSS VDD VDD network.in_spk05_10 sky130_fd_sc_hd__dfxtp_1
Xnetwork.neuron_in166.counter\[0\]$_DFFE_PP_ clknet_leaf_72_clk_net
+ _02727_ _01338_ VSS VSS VDD VDD network.neuron_in166.counter\[0\]
+ sky130_fd_sc_hd__edfxtp_1
Xnetwork.neuron_in166.counter\[1\]$_DFFE_PP_ clknet_leaf_78_clk_net
+ _02728_ _01338_ VSS VSS VDD VDD network.neuron_in166.counter\[1\]
+ sky130_fd_sc_hd__edfxtp_1
Xnetwork.neuron_in166.counter\[2\]$_DFFE_PP_ clknet_leaf_78_clk_net
+ _02729_ _01338_ VSS VSS VDD VDD network.neuron_in166.counter\[2\]
+ sky130_fd_sc_hd__edfxtp_1
Xnetwork.neuron_in166.counter\[3\]$_DFFE_PP_ clknet_leaf_78_clk_net
+ _02730_ _01338_ VSS VSS VDD VDD network.neuron_in166.counter\[3\]
+ sky130_fd_sc_hd__edfxtp_1
Xnetwork.neuron_in166.spike$_SDFFE_PP0P_ clknet_leaf_72_clk_net
+ _01994_ VSS VSS VDD VDD network.in_spk06_10 sky130_fd_sc_hd__dfxtp_1
Xnetwork.neuron_in167.counter\[0\]$_DFFE_PP_ clknet_leaf_66_clk_net
+ _02731_ _01337_ VSS VSS VDD VDD network.neuron_in167.counter\[0\]
+ sky130_fd_sc_hd__edfxtp_1
Xnetwork.neuron_in167.counter\[1\]$_DFFE_PP_ clknet_leaf_66_clk_net
+ _02732_ _01337_ VSS VSS VDD VDD network.neuron_in167.counter\[1\]
+ sky130_fd_sc_hd__edfxtp_1
Xnetwork.neuron_in167.counter\[2\]$_DFFE_PP_ clknet_leaf_66_clk_net
+ _02733_ _01337_ VSS VSS VDD VDD network.neuron_in167.counter\[2\]
+ sky130_fd_sc_hd__edfxtp_1
Xnetwork.neuron_in167.counter\[3\]$_DFFE_PP_ clknet_leaf_71_clk_net
+ _02734_ _01337_ VSS VSS VDD VDD network.neuron_in167.counter\[3\]
+ sky130_fd_sc_hd__edfxtp_1
Xnetwork.neuron_in167.spike$_SDFFE_PP0P_ clknet_leaf_71_clk_net
+ _01993_ VSS VSS VDD VDD network.in_spk07_10 sky130_fd_sc_hd__dfxtp_1
Xnetwork.neuron_in168.counter\[0\]$_DFFE_PP_ clknet_leaf_59_clk_net
+ _02735_ _01336_ VSS VSS VDD VDD network.neuron_in168.counter\[0\]
+ sky130_fd_sc_hd__edfxtp_1
Xnetwork.neuron_in168.counter\[1\]$_DFFE_PP_ clknet_leaf_59_clk_net
+ _02736_ _01336_ VSS VSS VDD VDD network.neuron_in168.counter\[1\]
+ sky130_fd_sc_hd__edfxtp_1
Xnetwork.neuron_in168.counter\[2\]$_DFFE_PP_ clknet_leaf_58_clk_net
+ _02737_ _01336_ VSS VSS VDD VDD network.neuron_in168.counter\[2\]
+ sky130_fd_sc_hd__edfxtp_1
Xnetwork.neuron_in168.counter\[3\]$_DFFE_PP_ clknet_leaf_59_clk_net
+ _02738_ _01336_ VSS VSS VDD VDD network.neuron_in168.counter\[3\]
+ sky130_fd_sc_hd__edfxtp_1
Xnetwork.neuron_in168.spike$_SDFFE_PP0P_ clknet_leaf_71_clk_net
+ _01992_ VSS VSS VDD VDD network.in_spk08_10 sky130_fd_sc_hd__dfxtp_1
Xnetwork.neuron_in169.counter\[0\]$_DFFE_PP_ clknet_leaf_79_clk_net
+ _02739_ _01335_ VSS VSS VDD VDD network.neuron_in169.counter\[0\]
+ sky130_fd_sc_hd__edfxtp_1
Xnetwork.neuron_in169.counter\[1\]$_DFFE_PP_ clknet_leaf_79_clk_net
+ _02740_ _01335_ VSS VSS VDD VDD network.neuron_in169.counter\[1\]
+ sky130_fd_sc_hd__edfxtp_1
Xnetwork.neuron_in169.counter\[2\]$_DFFE_PP_ clknet_leaf_79_clk_net
+ _02741_ _01335_ VSS VSS VDD VDD network.neuron_in169.counter\[2\]
+ sky130_fd_sc_hd__edfxtp_1
Xnetwork.neuron_in169.counter\[3\]$_DFFE_PP_ clknet_leaf_59_clk_net
+ _02742_ _01335_ VSS VSS VDD VDD network.neuron_in169.counter\[3\]
+ sky130_fd_sc_hd__edfxtp_1
Xnetwork.neuron_in169.spike$_SDFFE_PP0P_ clknet_leaf_71_clk_net
+ _01991_ VSS VSS VDD VDD network.in_spk09_10 sky130_fd_sc_hd__dfxtp_1
Xnetwork.neuron_in170.counter\[0\]$_DFFE_PP_ clknet_leaf_78_clk_net
+ _02743_ _01334_ VSS VSS VDD VDD network.neuron_in170.counter\[0\]
+ sky130_fd_sc_hd__edfxtp_1
Xnetwork.neuron_in170.counter\[1\]$_DFFE_PP_ clknet_leaf_78_clk_net
+ _02744_ _01334_ VSS VSS VDD VDD network.neuron_in170.counter\[1\]
+ sky130_fd_sc_hd__edfxtp_1
Xnetwork.neuron_in170.counter\[2\]$_DFFE_PP_ clknet_leaf_78_clk_net
+ _02745_ _01334_ VSS VSS VDD VDD network.neuron_in170.counter\[2\]
+ sky130_fd_sc_hd__edfxtp_1
Xnetwork.neuron_in170.counter\[3\]$_DFFE_PP_ clknet_leaf_73_clk_net
+ _02746_ _01334_ VSS VSS VDD VDD network.neuron_in170.counter\[3\]
+ sky130_fd_sc_hd__edfxtp_1
Xnetwork.neuron_in170.spike$_SDFFE_PP0P_ clknet_leaf_72_clk_net
+ _01990_ VSS VSS VDD VDD network.in_spk10_10 sky130_fd_sc_hd__dfxtp_1
Xnetwork.neuron_in171.counter\[0\]$_DFFE_PP_ clknet_leaf_73_clk_net
+ _02747_ _01333_ VSS VSS VDD VDD network.neuron_in171.counter\[0\]
+ sky130_fd_sc_hd__edfxtp_1
Xnetwork.neuron_in171.counter\[1\]$_DFFE_PP_ clknet_leaf_73_clk_net
+ _02748_ _01333_ VSS VSS VDD VDD network.neuron_in171.counter\[1\]
+ sky130_fd_sc_hd__edfxtp_1
Xnetwork.neuron_in171.counter\[2\]$_DFFE_PP_ clknet_leaf_73_clk_net
+ _02749_ _01333_ VSS VSS VDD VDD network.neuron_in171.counter\[2\]
+ sky130_fd_sc_hd__edfxtp_1
Xnetwork.neuron_in171.counter\[3\]$_DFFE_PP_ clknet_leaf_73_clk_net
+ _02750_ _01333_ VSS VSS VDD VDD network.neuron_in171.counter\[3\]
+ sky130_fd_sc_hd__edfxtp_1
Xnetwork.neuron_in171.spike$_SDFFE_PP0P_ clknet_leaf_73_clk_net
+ _01989_ VSS VSS VDD VDD network.in_spk11_10 sky130_fd_sc_hd__dfxtp_1
Xnetwork.neuron_in172.counter\[0\]$_DFFE_PP_ clknet_leaf_101_clk_net
+ _02751_ _01332_ VSS VSS VDD VDD network.neuron_in172.counter\[0\]
+ sky130_fd_sc_hd__edfxtp_1
Xnetwork.neuron_in172.counter\[1\]$_DFFE_PP_ clknet_leaf_101_clk_net
+ _02752_ _01332_ VSS VSS VDD VDD network.neuron_in172.counter\[1\]
+ sky130_fd_sc_hd__edfxtp_1
Xnetwork.neuron_in172.counter\[2\]$_DFFE_PP_ clknet_leaf_100_clk_net
+ _02753_ _01332_ VSS VSS VDD VDD network.neuron_in172.counter\[2\]
+ sky130_fd_sc_hd__edfxtp_1
Xnetwork.neuron_in172.counter\[3\]$_DFFE_PP_ clknet_leaf_100_clk_net
+ _02754_ _01332_ VSS VSS VDD VDD network.neuron_in172.counter\[3\]
+ sky130_fd_sc_hd__edfxtp_1
Xnetwork.neuron_in172.spike$_SDFFE_PP0P_ clknet_leaf_70_clk_net
+ _01988_ VSS VSS VDD VDD network.in_spk12_10 sky130_fd_sc_hd__dfxtp_1
Xnetwork.neuron_in173.counter\[0\]$_DFFE_PP_ clknet_leaf_74_clk_net
+ _02755_ _01331_ VSS VSS VDD VDD network.neuron_in173.counter\[0\]
+ sky130_fd_sc_hd__edfxtp_1
Xnetwork.neuron_in173.counter\[1\]$_DFFE_PP_ clknet_leaf_74_clk_net
+ _02756_ _01331_ VSS VSS VDD VDD network.neuron_in173.counter\[1\]
+ sky130_fd_sc_hd__edfxtp_1
Xnetwork.neuron_in173.counter\[2\]$_DFFE_PP_ clknet_leaf_75_clk_net
+ _02757_ _01331_ VSS VSS VDD VDD network.neuron_in173.counter\[2\]
+ sky130_fd_sc_hd__edfxtp_1
Xnetwork.neuron_in173.counter\[3\]$_DFFE_PP_ clknet_leaf_74_clk_net
+ _02758_ _01331_ VSS VSS VDD VDD network.neuron_in173.counter\[3\]
+ sky130_fd_sc_hd__edfxtp_1
Xnetwork.neuron_in173.spike$_SDFFE_PP0P_ clknet_leaf_73_clk_net
+ _01987_ VSS VSS VDD VDD network.in_spk13_10 sky130_fd_sc_hd__dfxtp_1
Xnetwork.neuron_in174.counter\[0\]$_DFFE_PP_ clknet_leaf_74_clk_net
+ _02759_ _01330_ VSS VSS VDD VDD network.neuron_in174.counter\[0\]
+ sky130_fd_sc_hd__edfxtp_1
Xnetwork.neuron_in174.counter\[1\]$_DFFE_PP_ clknet_leaf_101_clk_net
+ _02760_ _01330_ VSS VSS VDD VDD network.neuron_in174.counter\[1\]
+ sky130_fd_sc_hd__edfxtp_1
Xnetwork.neuron_in174.counter\[2\]$_DFFE_PP_ clknet_leaf_100_clk_net
+ _02761_ _01330_ VSS VSS VDD VDD network.neuron_in174.counter\[2\]
+ sky130_fd_sc_hd__edfxtp_1
Xnetwork.neuron_in174.counter\[3\]$_DFFE_PP_ clknet_leaf_74_clk_net
+ _02762_ _01330_ VSS VSS VDD VDD network.neuron_in174.counter\[3\]
+ sky130_fd_sc_hd__edfxtp_1
Xnetwork.neuron_in174.spike$_SDFFE_PP0P_ clknet_leaf_73_clk_net
+ _01986_ VSS VSS VDD VDD network.in_spk14_10 sky130_fd_sc_hd__dfxtp_1
Xnetwork.neuron_in175.counter\[0\]$_DFFE_PP_ clknet_leaf_104_clk_net
+ _02763_ _01329_ VSS VSS VDD VDD network.neuron_in175.counter\[0\]
+ sky130_fd_sc_hd__edfxtp_1
Xnetwork.neuron_in175.counter\[1\]$_DFFE_PP_ clknet_leaf_104_clk_net
+ _02764_ _01329_ VSS VSS VDD VDD network.neuron_in175.counter\[1\]
+ sky130_fd_sc_hd__edfxtp_1
Xnetwork.neuron_in175.counter\[2\]$_DFFE_PP_ clknet_leaf_101_clk_net
+ _02765_ _01329_ VSS VSS VDD VDD network.neuron_in175.counter\[2\]
+ sky130_fd_sc_hd__edfxtp_1
Xnetwork.neuron_in175.counter\[3\]$_DFFE_PP_ clknet_leaf_101_clk_net
+ _02766_ _01329_ VSS VSS VDD VDD network.neuron_in175.counter\[3\]
+ sky130_fd_sc_hd__edfxtp_1
Xnetwork.neuron_in175.spike$_SDFFE_PP0P_ clknet_leaf_70_clk_net
+ _01985_ VSS VSS VDD VDD network.in_spk15_10 sky130_fd_sc_hd__dfxtp_1
Xnetwork.neuron_in176.counter\[0\]$_DFFE_PP_ clknet_leaf_86_clk_net
+ _02767_ _01328_ VSS VSS VDD VDD network.neuron_in176.counter\[0\]
+ sky130_fd_sc_hd__edfxtp_1
Xnetwork.neuron_in176.counter\[1\]$_DFFE_PP_ clknet_leaf_86_clk_net
+ _02768_ _01328_ VSS VSS VDD VDD network.neuron_in176.counter\[1\]
+ sky130_fd_sc_hd__edfxtp_1
Xnetwork.neuron_in176.counter\[2\]$_DFFE_PP_ clknet_leaf_86_clk_net
+ _02769_ _01328_ VSS VSS VDD VDD network.neuron_in176.counter\[2\]
+ sky130_fd_sc_hd__edfxtp_1
Xnetwork.neuron_in176.counter\[3\]$_DFFE_PP_ clknet_leaf_86_clk_net
+ _02770_ _01328_ VSS VSS VDD VDD network.neuron_in176.counter\[3\]
+ sky130_fd_sc_hd__edfxtp_1
Xnetwork.neuron_in176.spike$_SDFFE_PP0P_ clknet_leaf_81_clk_net
+ _01984_ VSS VSS VDD VDD network.in_spk00_11 sky130_fd_sc_hd__dfxtp_1
Xnetwork.neuron_in177.counter\[0\]$_DFFE_PP_ clknet_leaf_82_clk_net
+ _02771_ _01327_ VSS VSS VDD VDD network.neuron_in177.counter\[0\]
+ sky130_fd_sc_hd__edfxtp_1
Xnetwork.neuron_in177.counter\[1\]$_DFFE_PP_ clknet_leaf_82_clk_net
+ _02772_ _01327_ VSS VSS VDD VDD network.neuron_in177.counter\[1\]
+ sky130_fd_sc_hd__edfxtp_1
Xnetwork.neuron_in177.counter\[2\]$_DFFE_PP_ clknet_leaf_82_clk_net
+ _02773_ _01327_ VSS VSS VDD VDD network.neuron_in177.counter\[2\]
+ sky130_fd_sc_hd__edfxtp_1
Xnetwork.neuron_in177.counter\[3\]$_DFFE_PP_ clknet_leaf_82_clk_net
+ _02774_ _01327_ VSS VSS VDD VDD network.neuron_in177.counter\[3\]
+ sky130_fd_sc_hd__edfxtp_1
Xnetwork.neuron_in177.spike$_SDFFE_PP0P_ clknet_leaf_81_clk_net
+ _01983_ VSS VSS VDD VDD network.in_spk01_11 sky130_fd_sc_hd__dfxtp_1
Xnetwork.neuron_in178.counter\[0\]$_DFFE_PP_ clknet_leaf_84_clk_net
+ _02775_ _01326_ VSS VSS VDD VDD network.neuron_in178.counter\[0\]
+ sky130_fd_sc_hd__edfxtp_1
Xnetwork.neuron_in178.counter\[1\]$_DFFE_PP_ clknet_leaf_85_clk_net
+ _02776_ _01326_ VSS VSS VDD VDD network.neuron_in178.counter\[1\]
+ sky130_fd_sc_hd__edfxtp_1
Xnetwork.neuron_in178.counter\[2\]$_DFFE_PP_ clknet_leaf_85_clk_net
+ _02777_ _01326_ VSS VSS VDD VDD network.neuron_in178.counter\[2\]
+ sky130_fd_sc_hd__edfxtp_1
Xnetwork.neuron_in178.counter\[3\]$_DFFE_PP_ clknet_leaf_85_clk_net
+ _02778_ _01326_ VSS VSS VDD VDD network.neuron_in178.counter\[3\]
+ sky130_fd_sc_hd__edfxtp_1
Xnetwork.neuron_in178.spike$_SDFFE_PP0P_ clknet_leaf_81_clk_net
+ _01982_ VSS VSS VDD VDD network.in_spk02_11 sky130_fd_sc_hd__dfxtp_1
Xnetwork.neuron_in179.counter\[0\]$_DFFE_PP_ clknet_leaf_84_clk_net
+ _02779_ _01325_ VSS VSS VDD VDD network.neuron_in179.counter\[0\]
+ sky130_fd_sc_hd__edfxtp_1
Xnetwork.neuron_in179.counter\[1\]$_DFFE_PP_ clknet_leaf_83_clk_net
+ _02780_ _01325_ VSS VSS VDD VDD network.neuron_in179.counter\[1\]
+ sky130_fd_sc_hd__edfxtp_1
Xnetwork.neuron_in179.counter\[2\]$_DFFE_PP_ clknet_leaf_83_clk_net
+ _02781_ _01325_ VSS VSS VDD VDD network.neuron_in179.counter\[2\]
+ sky130_fd_sc_hd__edfxtp_1
Xnetwork.neuron_in179.counter\[3\]$_DFFE_PP_ clknet_leaf_83_clk_net
+ _02782_ _01325_ VSS VSS VDD VDD network.neuron_in179.counter\[3\]
+ sky130_fd_sc_hd__edfxtp_1
Xnetwork.neuron_in179.spike$_SDFFE_PP0P_ clknet_leaf_81_clk_net
+ _01981_ VSS VSS VDD VDD network.in_spk03_11 sky130_fd_sc_hd__dfxtp_1
Xnetwork.neuron_in180.counter\[0\]$_DFFE_PP_ clknet_leaf_56_clk_net
+ _02783_ _01324_ VSS VSS VDD VDD network.neuron_in180.counter\[0\]
+ sky130_fd_sc_hd__edfxtp_1
Xnetwork.neuron_in180.counter\[1\]$_DFFE_PP_ clknet_leaf_56_clk_net
+ _02784_ _01324_ VSS VSS VDD VDD network.neuron_in180.counter\[1\]
+ sky130_fd_sc_hd__edfxtp_1
Xnetwork.neuron_in180.counter\[2\]$_DFFE_PP_ clknet_leaf_56_clk_net
+ _02785_ _01324_ VSS VSS VDD VDD network.neuron_in180.counter\[2\]
+ sky130_fd_sc_hd__edfxtp_1
Xnetwork.neuron_in180.counter\[3\]$_DFFE_PP_ clknet_leaf_56_clk_net
+ _02786_ _01324_ VSS VSS VDD VDD network.neuron_in180.counter\[3\]
+ sky130_fd_sc_hd__edfxtp_1
Xnetwork.neuron_in180.spike$_SDFFE_PP0P_ clknet_leaf_81_clk_net
+ _01980_ VSS VSS VDD VDD network.in_spk04_11 sky130_fd_sc_hd__dfxtp_1
Xnetwork.neuron_in181.counter\[0\]$_DFFE_PP_ clknet_leaf_56_clk_net
+ _02787_ _01323_ VSS VSS VDD VDD network.neuron_in181.counter\[0\]
+ sky130_fd_sc_hd__edfxtp_1
Xnetwork.neuron_in181.counter\[1\]$_DFFE_PP_ clknet_leaf_56_clk_net
+ _02788_ _01323_ VSS VSS VDD VDD network.neuron_in181.counter\[1\]
+ sky130_fd_sc_hd__edfxtp_1
Xnetwork.neuron_in181.counter\[2\]$_DFFE_PP_ clknet_leaf_56_clk_net
+ _02789_ _01323_ VSS VSS VDD VDD network.neuron_in181.counter\[2\]
+ sky130_fd_sc_hd__edfxtp_1
Xnetwork.neuron_in181.counter\[3\]$_DFFE_PP_ clknet_leaf_82_clk_net
+ _02790_ _01323_ VSS VSS VDD VDD network.neuron_in181.counter\[3\]
+ sky130_fd_sc_hd__edfxtp_1
Xnetwork.neuron_in181.spike$_SDFFE_PP0P_ clknet_leaf_80_clk_net
+ _01979_ VSS VSS VDD VDD network.in_spk05_11 sky130_fd_sc_hd__dfxtp_1
Xnetwork.neuron_in182.counter\[0\]$_DFFE_PP_ clknet_leaf_85_clk_net
+ _02791_ _01322_ VSS VSS VDD VDD network.neuron_in182.counter\[0\]
+ sky130_fd_sc_hd__edfxtp_1
Xnetwork.neuron_in182.counter\[1\]$_DFFE_PP_ clknet_leaf_85_clk_net
+ _02792_ _01322_ VSS VSS VDD VDD network.neuron_in182.counter\[1\]
+ sky130_fd_sc_hd__edfxtp_1
Xnetwork.neuron_in182.counter\[2\]$_DFFE_PP_ clknet_leaf_85_clk_net
+ _02793_ _01322_ VSS VSS VDD VDD network.neuron_in182.counter\[2\]
+ sky130_fd_sc_hd__edfxtp_1
Xnetwork.neuron_in182.counter\[3\]$_DFFE_PP_ clknet_leaf_85_clk_net
+ _02794_ _01322_ VSS VSS VDD VDD network.neuron_in182.counter\[3\]
+ sky130_fd_sc_hd__edfxtp_1
Xnetwork.neuron_in182.spike$_SDFFE_PP0P_ clknet_leaf_80_clk_net
+ _01978_ VSS VSS VDD VDD network.in_spk06_11 sky130_fd_sc_hd__dfxtp_1
Xnetwork.neuron_in183.counter\[0\]$_DFFE_PP_ clknet_leaf_81_clk_net
+ _02795_ _01321_ VSS VSS VDD VDD network.neuron_in183.counter\[0\]
+ sky130_fd_sc_hd__edfxtp_1
Xnetwork.neuron_in183.counter\[1\]$_DFFE_PP_ clknet_leaf_81_clk_net
+ _02796_ _01321_ VSS VSS VDD VDD network.neuron_in183.counter\[1\]
+ sky130_fd_sc_hd__edfxtp_1
Xnetwork.neuron_in183.counter\[2\]$_DFFE_PP_ clknet_leaf_81_clk_net
+ _02797_ _01321_ VSS VSS VDD VDD network.neuron_in183.counter\[2\]
+ sky130_fd_sc_hd__edfxtp_1
Xnetwork.neuron_in183.counter\[3\]$_DFFE_PP_ clknet_leaf_81_clk_net
+ _02798_ _01321_ VSS VSS VDD VDD network.neuron_in183.counter\[3\]
+ sky130_fd_sc_hd__edfxtp_1
Xnetwork.neuron_in183.spike$_SDFFE_PP0P_ clknet_leaf_81_clk_net
+ _01977_ VSS VSS VDD VDD network.in_spk07_11 sky130_fd_sc_hd__dfxtp_1
Xnetwork.neuron_in184.counter\[0\]$_DFFE_PP_ clknet_leaf_83_clk_net
+ _02799_ _01320_ VSS VSS VDD VDD network.neuron_in184.counter\[0\]
+ sky130_fd_sc_hd__edfxtp_1
Xnetwork.neuron_in184.counter\[1\]$_DFFE_PP_ clknet_leaf_83_clk_net
+ _02800_ _01320_ VSS VSS VDD VDD network.neuron_in184.counter\[1\]
+ sky130_fd_sc_hd__edfxtp_1
Xnetwork.neuron_in184.counter\[2\]$_DFFE_PP_ clknet_leaf_84_clk_net
+ _02801_ _01320_ VSS VSS VDD VDD network.neuron_in184.counter\[2\]
+ sky130_fd_sc_hd__edfxtp_1
Xnetwork.neuron_in184.counter\[3\]$_DFFE_PP_ clknet_leaf_84_clk_net
+ _02802_ _01320_ VSS VSS VDD VDD network.neuron_in184.counter\[3\]
+ sky130_fd_sc_hd__edfxtp_1
Xnetwork.neuron_in184.spike$_SDFFE_PP0P_ clknet_leaf_84_clk_net
+ _01976_ VSS VSS VDD VDD network.in_spk08_11 sky130_fd_sc_hd__dfxtp_1
Xnetwork.neuron_in185.counter\[0\]$_DFFE_PP_ clknet_leaf_82_clk_net
+ _02803_ _01319_ VSS VSS VDD VDD network.neuron_in185.counter\[0\]
+ sky130_fd_sc_hd__edfxtp_1
Xnetwork.neuron_in185.counter\[1\]$_DFFE_PP_ clknet_leaf_82_clk_net
+ _02804_ _01319_ VSS VSS VDD VDD network.neuron_in185.counter\[1\]
+ sky130_fd_sc_hd__edfxtp_1
Xnetwork.neuron_in185.counter\[2\]$_DFFE_PP_ clknet_leaf_83_clk_net
+ _02805_ _01319_ VSS VSS VDD VDD network.neuron_in185.counter\[2\]
+ sky130_fd_sc_hd__edfxtp_1
Xnetwork.neuron_in185.counter\[3\]$_DFFE_PP_ clknet_leaf_83_clk_net
+ _02806_ _01319_ VSS VSS VDD VDD network.neuron_in185.counter\[3\]
+ sky130_fd_sc_hd__edfxtp_1
Xnetwork.neuron_in185.spike$_SDFFE_PP0P_ clknet_leaf_80_clk_net
+ _01975_ VSS VSS VDD VDD network.in_spk09_11 sky130_fd_sc_hd__dfxtp_1
Xnetwork.neuron_in186.counter\[0\]$_DFFE_PP_ clknet_leaf_87_clk_net
+ _02807_ _01318_ VSS VSS VDD VDD network.neuron_in186.counter\[0\]
+ sky130_fd_sc_hd__edfxtp_1
Xnetwork.neuron_in186.counter\[1\]$_DFFE_PP_ clknet_leaf_87_clk_net
+ _02808_ _01318_ VSS VSS VDD VDD network.neuron_in186.counter\[1\]
+ sky130_fd_sc_hd__edfxtp_1
Xnetwork.neuron_in186.counter\[2\]$_DFFE_PP_ clknet_leaf_86_clk_net
+ _02809_ _01318_ VSS VSS VDD VDD network.neuron_in186.counter\[2\]
+ sky130_fd_sc_hd__edfxtp_1
Xnetwork.neuron_in186.counter\[3\]$_DFFE_PP_ clknet_leaf_86_clk_net
+ _02810_ _01318_ VSS VSS VDD VDD network.neuron_in186.counter\[3\]
+ sky130_fd_sc_hd__edfxtp_1
Xnetwork.neuron_in186.spike$_SDFFE_PP0P_ clknet_leaf_80_clk_net
+ _01974_ VSS VSS VDD VDD network.in_spk10_11 sky130_fd_sc_hd__dfxtp_1
Xnetwork.neuron_in187.counter\[0\]$_DFFE_PP_ clknet_leaf_87_clk_net
+ _02811_ _01317_ VSS VSS VDD VDD network.neuron_in187.counter\[0\]
+ sky130_fd_sc_hd__edfxtp_1
Xnetwork.neuron_in187.counter\[1\]$_DFFE_PP_ clknet_leaf_84_clk_net
+ _02812_ _01317_ VSS VSS VDD VDD network.neuron_in187.counter\[1\]
+ sky130_fd_sc_hd__edfxtp_1
Xnetwork.neuron_in187.counter\[2\]$_DFFE_PP_ clknet_leaf_84_clk_net
+ _02813_ _01317_ VSS VSS VDD VDD network.neuron_in187.counter\[2\]
+ sky130_fd_sc_hd__edfxtp_1
Xnetwork.neuron_in187.counter\[3\]$_DFFE_PP_ clknet_leaf_83_clk_net
+ _02814_ _01317_ VSS VSS VDD VDD network.neuron_in187.counter\[3\]
+ sky130_fd_sc_hd__edfxtp_1
Xnetwork.neuron_in187.spike$_SDFFE_PP0P_ clknet_leaf_80_clk_net
+ _01973_ VSS VSS VDD VDD network.in_spk11_11 sky130_fd_sc_hd__dfxtp_1
Xnetwork.neuron_in188.counter\[0\]$_DFFE_PP_ clknet_leaf_77_clk_net
+ _02815_ _01316_ VSS VSS VDD VDD network.neuron_in188.counter\[0\]
+ sky130_fd_sc_hd__edfxtp_1
Xnetwork.neuron_in188.counter\[1\]$_DFFE_PP_ clknet_leaf_77_clk_net
+ _02816_ _01316_ VSS VSS VDD VDD network.neuron_in188.counter\[1\]
+ sky130_fd_sc_hd__edfxtp_1
Xnetwork.neuron_in188.counter\[2\]$_DFFE_PP_ clknet_leaf_78_clk_net
+ _02817_ _01316_ VSS VSS VDD VDD network.neuron_in188.counter\[2\]
+ sky130_fd_sc_hd__edfxtp_1
Xnetwork.neuron_in188.counter\[3\]$_DFFE_PP_ clknet_leaf_76_clk_net
+ _02818_ _01316_ VSS VSS VDD VDD network.neuron_in188.counter\[3\]
+ sky130_fd_sc_hd__edfxtp_1
Xnetwork.neuron_in188.spike$_SDFFE_PP0P_ clknet_leaf_77_clk_net
+ _01972_ VSS VSS VDD VDD network.in_spk12_11 sky130_fd_sc_hd__dfxtp_1
Xnetwork.neuron_in189.counter\[0\]$_DFFE_PP_ clknet_leaf_75_clk_net
+ _02819_ _01315_ VSS VSS VDD VDD network.neuron_in189.counter\[0\]
+ sky130_fd_sc_hd__edfxtp_1
Xnetwork.neuron_in189.counter\[1\]$_DFFE_PP_ clknet_leaf_75_clk_net
+ _02820_ _01315_ VSS VSS VDD VDD network.neuron_in189.counter\[1\]
+ sky130_fd_sc_hd__edfxtp_1
Xnetwork.neuron_in189.counter\[2\]$_DFFE_PP_ clknet_leaf_75_clk_net
+ _02821_ _01315_ VSS VSS VDD VDD network.neuron_in189.counter\[2\]
+ sky130_fd_sc_hd__edfxtp_1
Xnetwork.neuron_in189.counter\[3\]$_DFFE_PP_ clknet_leaf_75_clk_net
+ _02822_ _01315_ VSS VSS VDD VDD network.neuron_in189.counter\[3\]
+ sky130_fd_sc_hd__edfxtp_1
Xnetwork.neuron_in189.spike$_SDFFE_PP0P_ clknet_leaf_77_clk_net
+ _01971_ VSS VSS VDD VDD network.in_spk13_11 sky130_fd_sc_hd__dfxtp_1
Xnetwork.neuron_in190.counter\[0\]$_DFFE_PP_ clknet_leaf_76_clk_net
+ _02823_ _01314_ VSS VSS VDD VDD network.neuron_in190.counter\[0\]
+ sky130_fd_sc_hd__edfxtp_1
Xnetwork.neuron_in190.counter\[1\]$_DFFE_PP_ clknet_leaf_75_clk_net
+ _02824_ _01314_ VSS VSS VDD VDD network.neuron_in190.counter\[1\]
+ sky130_fd_sc_hd__edfxtp_1
Xnetwork.neuron_in190.counter\[2\]$_DFFE_PP_ clknet_leaf_75_clk_net
+ _02825_ _01314_ VSS VSS VDD VDD network.neuron_in190.counter\[2\]
+ sky130_fd_sc_hd__edfxtp_1
Xnetwork.neuron_in190.counter\[3\]$_DFFE_PP_ clknet_leaf_76_clk_net
+ _02826_ _01314_ VSS VSS VDD VDD network.neuron_in190.counter\[3\]
+ sky130_fd_sc_hd__edfxtp_1
Xnetwork.neuron_in190.spike$_SDFFE_PP0P_ clknet_leaf_77_clk_net
+ _01970_ VSS VSS VDD VDD network.in_spk14_11 sky130_fd_sc_hd__dfxtp_1
Xnetwork.neuron_in191.counter\[0\]$_DFFE_PP_ clknet_leaf_76_clk_net
+ _02827_ _01313_ VSS VSS VDD VDD network.neuron_in191.counter\[0\]
+ sky130_fd_sc_hd__edfxtp_1
Xnetwork.neuron_in191.counter\[1\]$_DFFE_PP_ clknet_leaf_76_clk_net
+ _02828_ _01313_ VSS VSS VDD VDD network.neuron_in191.counter\[1\]
+ sky130_fd_sc_hd__edfxtp_1
Xnetwork.neuron_in191.counter\[2\]$_DFFE_PP_ clknet_leaf_87_clk_net
+ _02829_ _01313_ VSS VSS VDD VDD network.neuron_in191.counter\[2\]
+ sky130_fd_sc_hd__edfxtp_1
Xnetwork.neuron_in191.counter\[3\]$_DFFE_PP_ clknet_leaf_87_clk_net
+ _02830_ _01313_ VSS VSS VDD VDD network.neuron_in191.counter\[3\]
+ sky130_fd_sc_hd__edfxtp_1
Xnetwork.neuron_in191.spike$_SDFFE_PP0P_ clknet_leaf_80_clk_net
+ _01969_ VSS VSS VDD VDD network.in_spk15_11 sky130_fd_sc_hd__dfxtp_1
Xnetwork.neuron_in192.counter\[0\]$_DFFE_PP_ clknet_leaf_113_clk_net
+ _02831_ _01312_ VSS VSS VDD VDD network.neuron_in192.counter\[0\]
+ sky130_fd_sc_hd__edfxtp_1
Xnetwork.neuron_in192.counter\[1\]$_DFFE_PP_ clknet_leaf_113_clk_net
+ _02832_ _01312_ VSS VSS VDD VDD network.neuron_in192.counter\[1\]
+ sky130_fd_sc_hd__edfxtp_1
Xnetwork.neuron_in192.counter\[2\]$_DFFE_PP_ clknet_leaf_113_clk_net
+ _02833_ _01312_ VSS VSS VDD VDD network.neuron_in192.counter\[2\]
+ sky130_fd_sc_hd__edfxtp_1
Xnetwork.neuron_in192.counter\[3\]$_DFFE_PP_ clknet_leaf_113_clk_net
+ _02834_ _01312_ VSS VSS VDD VDD network.neuron_in192.counter\[3\]
+ sky130_fd_sc_hd__edfxtp_1
Xnetwork.neuron_in192.spike$_SDFFE_PP0P_ clknet_leaf_113_clk_net
+ _01968_ VSS VSS VDD VDD network.in_spk00_12 sky130_fd_sc_hd__dfxtp_1
Xnetwork.neuron_in193.counter\[0\]$_DFFE_PP_ clknet_leaf_112_clk_net
+ _02835_ _01311_ VSS VSS VDD VDD network.neuron_in193.counter\[0\]
+ sky130_fd_sc_hd__edfxtp_1
Xnetwork.neuron_in193.counter\[1\]$_DFFE_PP_ clknet_leaf_112_clk_net
+ _02836_ _01311_ VSS VSS VDD VDD network.neuron_in193.counter\[1\]
+ sky130_fd_sc_hd__edfxtp_1
Xnetwork.neuron_in193.counter\[2\]$_DFFE_PP_ clknet_leaf_112_clk_net
+ _02837_ _01311_ VSS VSS VDD VDD network.neuron_in193.counter\[2\]
+ sky130_fd_sc_hd__edfxtp_1
Xnetwork.neuron_in193.counter\[3\]$_DFFE_PP_ clknet_leaf_112_clk_net
+ _02838_ _01311_ VSS VSS VDD VDD network.neuron_in193.counter\[3\]
+ sky130_fd_sc_hd__edfxtp_1
Xnetwork.neuron_in193.spike$_SDFFE_PP0P_ clknet_leaf_112_clk_net
+ _01967_ VSS VSS VDD VDD network.in_spk01_12 sky130_fd_sc_hd__dfxtp_1
Xnetwork.neuron_in194.counter\[0\]$_DFFE_PP_ clknet_leaf_117_clk_net
+ _02839_ _01310_ VSS VSS VDD VDD network.neuron_in194.counter\[0\]
+ sky130_fd_sc_hd__edfxtp_1
Xnetwork.neuron_in194.counter\[1\]$_DFFE_PP_ clknet_leaf_122_clk_net
+ _02840_ _01310_ VSS VSS VDD VDD network.neuron_in194.counter\[1\]
+ sky130_fd_sc_hd__edfxtp_1
Xnetwork.neuron_in194.counter\[2\]$_DFFE_PP_ clknet_leaf_114_clk_net
+ _02841_ _01310_ VSS VSS VDD VDD network.neuron_in194.counter\[2\]
+ sky130_fd_sc_hd__edfxtp_1
Xnetwork.neuron_in194.counter\[3\]$_DFFE_PP_ clknet_leaf_117_clk_net
+ _02842_ _01310_ VSS VSS VDD VDD network.neuron_in194.counter\[3\]
+ sky130_fd_sc_hd__edfxtp_1
Xnetwork.neuron_in194.spike$_SDFFE_PP0P_ clknet_leaf_113_clk_net
+ _01966_ VSS VSS VDD VDD network.in_spk02_12 sky130_fd_sc_hd__dfxtp_1
Xnetwork.neuron_in195.counter\[0\]$_DFFE_PP_ clknet_leaf_125_clk_net
+ _02843_ _01309_ VSS VSS VDD VDD network.neuron_in195.counter\[0\]
+ sky130_fd_sc_hd__edfxtp_1
Xnetwork.neuron_in195.counter\[1\]$_DFFE_PP_ clknet_leaf_124_clk_net
+ _02844_ _01309_ VSS VSS VDD VDD network.neuron_in195.counter\[1\]
+ sky130_fd_sc_hd__edfxtp_1
Xnetwork.neuron_in195.counter\[2\]$_DFFE_PP_ clknet_leaf_125_clk_net
+ _02845_ _01309_ VSS VSS VDD VDD network.neuron_in195.counter\[2\]
+ sky130_fd_sc_hd__edfxtp_1
Xnetwork.neuron_in195.counter\[3\]$_DFFE_PP_ clknet_leaf_125_clk_net
+ _02846_ _01309_ VSS VSS VDD VDD network.neuron_in195.counter\[3\]
+ sky130_fd_sc_hd__edfxtp_1
Xnetwork.neuron_in195.spike$_SDFFE_PP0P_ clknet_leaf_113_clk_net
+ _01965_ VSS VSS VDD VDD network.in_spk03_12 sky130_fd_sc_hd__dfxtp_1
Xnetwork.neuron_in196.counter\[0\]$_DFFE_PP_ clknet_leaf_114_clk_net
+ _02847_ _01308_ VSS VSS VDD VDD network.neuron_in196.counter\[0\]
+ sky130_fd_sc_hd__edfxtp_1
Xnetwork.neuron_in196.counter\[1\]$_DFFE_PP_ clknet_leaf_114_clk_net
+ _02848_ _01308_ VSS VSS VDD VDD network.neuron_in196.counter\[1\]
+ sky130_fd_sc_hd__edfxtp_1
Xnetwork.neuron_in196.counter\[2\]$_DFFE_PP_ clknet_leaf_114_clk_net
+ _02849_ _01308_ VSS VSS VDD VDD network.neuron_in196.counter\[2\]
+ sky130_fd_sc_hd__edfxtp_1
Xnetwork.neuron_in196.counter\[3\]$_DFFE_PP_ clknet_leaf_116_clk_net
+ _02850_ _01308_ VSS VSS VDD VDD network.neuron_in196.counter\[3\]
+ sky130_fd_sc_hd__edfxtp_1
Xnetwork.neuron_in196.spike$_SDFFE_PP0P_ clknet_leaf_113_clk_net
+ _01964_ VSS VSS VDD VDD network.in_spk04_12 sky130_fd_sc_hd__dfxtp_1
Xnetwork.neuron_in197.counter\[0\]$_DFFE_PP_ clknet_leaf_124_clk_net
+ _02851_ _01307_ VSS VSS VDD VDD network.neuron_in197.counter\[0\]
+ sky130_fd_sc_hd__edfxtp_1
Xnetwork.neuron_in197.counter\[1\]$_DFFE_PP_ clknet_leaf_124_clk_net
+ _02852_ _01307_ VSS VSS VDD VDD network.neuron_in197.counter\[1\]
+ sky130_fd_sc_hd__edfxtp_1
Xnetwork.neuron_in197.counter\[2\]$_DFFE_PP_ clknet_leaf_114_clk_net
+ _02853_ _01307_ VSS VSS VDD VDD network.neuron_in197.counter\[2\]
+ sky130_fd_sc_hd__edfxtp_1
Xnetwork.neuron_in197.counter\[3\]$_DFFE_PP_ clknet_leaf_125_clk_net
+ _02854_ _01307_ VSS VSS VDD VDD network.neuron_in197.counter\[3\]
+ sky130_fd_sc_hd__edfxtp_1
Xnetwork.neuron_in197.spike$_SDFFE_PP0P_ clknet_leaf_125_clk_net
+ _01963_ VSS VSS VDD VDD network.in_spk05_12 sky130_fd_sc_hd__dfxtp_1
Xnetwork.neuron_in198.counter\[0\]$_DFFE_PP_ clknet_leaf_126_clk_net
+ _02855_ _01306_ VSS VSS VDD VDD network.neuron_in198.counter\[0\]
+ sky130_fd_sc_hd__edfxtp_1
Xnetwork.neuron_in198.counter\[1\]$_DFFE_PP_ clknet_leaf_126_clk_net
+ _02856_ _01306_ VSS VSS VDD VDD network.neuron_in198.counter\[1\]
+ sky130_fd_sc_hd__edfxtp_1
Xnetwork.neuron_in198.counter\[2\]$_DFFE_PP_ clknet_leaf_124_clk_net
+ _02857_ _01306_ VSS VSS VDD VDD network.neuron_in198.counter\[2\]
+ sky130_fd_sc_hd__edfxtp_1
Xnetwork.neuron_in198.counter\[3\]$_DFFE_PP_ clknet_leaf_124_clk_net
+ _02858_ _01306_ VSS VSS VDD VDD network.neuron_in198.counter\[3\]
+ sky130_fd_sc_hd__edfxtp_1
Xnetwork.neuron_in198.spike$_SDFFE_PP0P_ clknet_leaf_125_clk_net
+ _01962_ VSS VSS VDD VDD network.in_spk06_12 sky130_fd_sc_hd__dfxtp_1
Xnetwork.neuron_in199.counter\[0\]$_DFFE_PP_ clknet_leaf_126_clk_net
+ _02859_ _01305_ VSS VSS VDD VDD network.neuron_in199.counter\[0\]
+ sky130_fd_sc_hd__edfxtp_1
Xnetwork.neuron_in199.counter\[1\]$_DFFE_PP_ clknet_leaf_126_clk_net
+ _02860_ _01305_ VSS VSS VDD VDD network.neuron_in199.counter\[1\]
+ sky130_fd_sc_hd__edfxtp_1
Xnetwork.neuron_in199.counter\[2\]$_DFFE_PP_ clknet_leaf_126_clk_net
+ _02861_ _01305_ VSS VSS VDD VDD network.neuron_in199.counter\[2\]
+ sky130_fd_sc_hd__edfxtp_1
Xnetwork.neuron_in199.counter\[3\]$_DFFE_PP_ clknet_leaf_126_clk_net
+ _02862_ _01305_ VSS VSS VDD VDD network.neuron_in199.counter\[3\]
+ sky130_fd_sc_hd__edfxtp_1
Xnetwork.neuron_in199.spike$_SDFFE_PP0P_ clknet_leaf_125_clk_net
+ _01961_ VSS VSS VDD VDD network.in_spk07_12 sky130_fd_sc_hd__dfxtp_1
Xnetwork.neuron_in200.counter\[0\]$_DFFE_PP_ clknet_leaf_142_clk_net
+ _02863_ _01304_ VSS VSS VDD VDD network.neuron_in200.counter\[0\]
+ sky130_fd_sc_hd__edfxtp_1
Xnetwork.neuron_in200.counter\[1\]$_DFFE_PP_ clknet_leaf_141_clk_net
+ _02864_ _01304_ VSS VSS VDD VDD network.neuron_in200.counter\[1\]
+ sky130_fd_sc_hd__edfxtp_1
Xnetwork.neuron_in200.counter\[2\]$_DFFE_PP_ clknet_leaf_142_clk_net
+ _02865_ _01304_ VSS VSS VDD VDD network.neuron_in200.counter\[2\]
+ sky130_fd_sc_hd__edfxtp_1
Xnetwork.neuron_in200.counter\[3\]$_DFFE_PP_ clknet_leaf_141_clk_net
+ _02866_ _01304_ VSS VSS VDD VDD network.neuron_in200.counter\[3\]
+ sky130_fd_sc_hd__edfxtp_1
Xnetwork.neuron_in200.spike$_SDFFE_PP0P_ clknet_leaf_127_clk_net
+ _01960_ VSS VSS VDD VDD network.in_spk08_12 sky130_fd_sc_hd__dfxtp_1
Xnetwork.neuron_in201.counter\[0\]$_DFFE_PP_ clknet_leaf_154_clk_net
+ _02867_ _01303_ VSS VSS VDD VDD network.neuron_in201.counter\[0\]
+ sky130_fd_sc_hd__edfxtp_1
Xnetwork.neuron_in201.counter\[1\]$_DFFE_PP_ clknet_leaf_154_clk_net
+ _02868_ _01303_ VSS VSS VDD VDD network.neuron_in201.counter\[1\]
+ sky130_fd_sc_hd__edfxtp_1
Xnetwork.neuron_in201.counter\[2\]$_DFFE_PP_ clknet_leaf_112_clk_net
+ _02869_ _01303_ VSS VSS VDD VDD network.neuron_in201.counter\[2\]
+ sky130_fd_sc_hd__edfxtp_1
Xnetwork.neuron_in201.counter\[3\]$_DFFE_PP_ clknet_leaf_112_clk_net
+ _02870_ _01303_ VSS VSS VDD VDD network.neuron_in201.counter\[3\]
+ sky130_fd_sc_hd__edfxtp_1
Xnetwork.neuron_in201.spike$_SDFFE_PP0P_ clknet_leaf_126_clk_net
+ _01959_ VSS VSS VDD VDD network.in_spk09_12 sky130_fd_sc_hd__dfxtp_1
Xnetwork.neuron_in202.counter\[0\]$_DFFE_PP_ clknet_leaf_127_clk_net
+ _02871_ _01302_ VSS VSS VDD VDD network.neuron_in202.counter\[0\]
+ sky130_fd_sc_hd__edfxtp_1
Xnetwork.neuron_in202.counter\[1\]$_DFFE_PP_ clknet_leaf_127_clk_net
+ _02872_ _01302_ VSS VSS VDD VDD network.neuron_in202.counter\[1\]
+ sky130_fd_sc_hd__edfxtp_1
Xnetwork.neuron_in202.counter\[2\]$_DFFE_PP_ clknet_leaf_130_clk_net
+ _02873_ _01302_ VSS VSS VDD VDD network.neuron_in202.counter\[2\]
+ sky130_fd_sc_hd__edfxtp_1
Xnetwork.neuron_in202.counter\[3\]$_DFFE_PP_ clknet_leaf_130_clk_net
+ _02874_ _01302_ VSS VSS VDD VDD network.neuron_in202.counter\[3\]
+ sky130_fd_sc_hd__edfxtp_1
Xnetwork.neuron_in202.spike$_SDFFE_PP0P_ clknet_leaf_141_clk_net
+ _01957_ VSS VSS VDD VDD network.in_spk10_12 sky130_fd_sc_hd__dfxtp_1
Xnetwork.neuron_in203.counter\[0\]$_DFFE_PP_ clknet_leaf_128_clk_net
+ _02875_ _01301_ VSS VSS VDD VDD network.neuron_in203.counter\[0\]
+ sky130_fd_sc_hd__edfxtp_1
Xnetwork.neuron_in203.counter\[1\]$_DFFE_PP_ clknet_leaf_128_clk_net
+ _02876_ _01301_ VSS VSS VDD VDD network.neuron_in203.counter\[1\]
+ sky130_fd_sc_hd__edfxtp_1
Xnetwork.neuron_in203.counter\[2\]$_DFFE_PP_ clknet_leaf_127_clk_net
+ _02877_ _01301_ VSS VSS VDD VDD network.neuron_in203.counter\[2\]
+ sky130_fd_sc_hd__edfxtp_1
Xnetwork.neuron_in203.counter\[3\]$_DFFE_PP_ clknet_leaf_127_clk_net
+ _02878_ _01301_ VSS VSS VDD VDD network.neuron_in203.counter\[3\]
+ sky130_fd_sc_hd__edfxtp_1
Xnetwork.neuron_in203.spike$_SDFFE_PP0P_ clknet_leaf_127_clk_net
+ _01953_ VSS VSS VDD VDD network.in_spk11_12 sky130_fd_sc_hd__dfxtp_1
Xnetwork.neuron_in204.counter\[0\]$_DFFE_PP_ clknet_leaf_138_clk_net
+ _02879_ _01300_ VSS VSS VDD VDD network.neuron_in204.counter\[0\]
+ sky130_fd_sc_hd__edfxtp_1
Xnetwork.neuron_in204.counter\[1\]$_DFFE_PP_ clknet_leaf_138_clk_net
+ _02880_ _01300_ VSS VSS VDD VDD network.neuron_in204.counter\[1\]
+ sky130_fd_sc_hd__edfxtp_1
Xnetwork.neuron_in204.counter\[2\]$_DFFE_PP_ clknet_leaf_137_clk_net
+ _02881_ _01300_ VSS VSS VDD VDD network.neuron_in204.counter\[2\]
+ sky130_fd_sc_hd__edfxtp_1
Xnetwork.neuron_in204.counter\[3\]$_DFFE_PP_ clknet_leaf_137_clk_net
+ _02882_ _01300_ VSS VSS VDD VDD network.neuron_in204.counter\[3\]
+ sky130_fd_sc_hd__edfxtp_1
Xnetwork.neuron_in204.spike$_SDFFE_PP0P_ clknet_leaf_141_clk_net
+ _01949_ VSS VSS VDD VDD network.in_spk12_12 sky130_fd_sc_hd__dfxtp_1
Xnetwork.neuron_in205.counter\[0\]$_DFFE_PP_ clknet_leaf_140_clk_net
+ _02883_ _01299_ VSS VSS VDD VDD network.neuron_in205.counter\[0\]
+ sky130_fd_sc_hd__edfxtp_1
Xnetwork.neuron_in205.counter\[1\]$_DFFE_PP_ clknet_leaf_140_clk_net
+ _02884_ _01299_ VSS VSS VDD VDD network.neuron_in205.counter\[1\]
+ sky130_fd_sc_hd__edfxtp_1
Xnetwork.neuron_in205.counter\[2\]$_DFFE_PP_ clknet_leaf_140_clk_net
+ _02885_ _01299_ VSS VSS VDD VDD network.neuron_in205.counter\[2\]
+ sky130_fd_sc_hd__edfxtp_1
Xnetwork.neuron_in205.counter\[3\]$_DFFE_PP_ clknet_leaf_141_clk_net
+ _02886_ _01299_ VSS VSS VDD VDD network.neuron_in205.counter\[3\]
+ sky130_fd_sc_hd__edfxtp_1
Xnetwork.neuron_in205.spike$_SDFFE_PP0P_ clknet_leaf_141_clk_net
+ _01946_ VSS VSS VDD VDD network.in_spk13_12 sky130_fd_sc_hd__dfxtp_1
Xnetwork.neuron_in206.counter\[0\]$_DFFE_PP_ clknet_leaf_137_clk_net
+ _02887_ _01298_ VSS VSS VDD VDD network.neuron_in206.counter\[0\]
+ sky130_fd_sc_hd__edfxtp_1
Xnetwork.neuron_in206.counter\[1\]$_DFFE_PP_ clknet_leaf_137_clk_net
+ _02888_ _01298_ VSS VSS VDD VDD network.neuron_in206.counter\[1\]
+ sky130_fd_sc_hd__edfxtp_1
Xnetwork.neuron_in206.counter\[2\]$_DFFE_PP_ clknet_leaf_140_clk_net
+ _02889_ _01298_ VSS VSS VDD VDD network.neuron_in206.counter\[2\]
+ sky130_fd_sc_hd__edfxtp_1
Xnetwork.neuron_in206.counter\[3\]$_DFFE_PP_ clknet_leaf_140_clk_net
+ _02890_ _01298_ VSS VSS VDD VDD network.neuron_in206.counter\[3\]
+ sky130_fd_sc_hd__edfxtp_1
Xnetwork.neuron_in206.spike$_SDFFE_PP0P_ clknet_leaf_141_clk_net
+ _01944_ VSS VSS VDD VDD network.in_spk14_12 sky130_fd_sc_hd__dfxtp_1
Xnetwork.neuron_in207.counter\[0\]$_DFFE_PP_ clknet_leaf_140_clk_net
+ _02891_ _01297_ VSS VSS VDD VDD network.neuron_in207.counter\[0\]
+ sky130_fd_sc_hd__edfxtp_1
Xnetwork.neuron_in207.counter\[1\]$_DFFE_PP_ clknet_leaf_140_clk_net
+ _02892_ _01297_ VSS VSS VDD VDD network.neuron_in207.counter\[1\]
+ sky130_fd_sc_hd__edfxtp_1
Xnetwork.neuron_in207.counter\[2\]$_DFFE_PP_ clknet_leaf_128_clk_net
+ _02893_ _01297_ VSS VSS VDD VDD network.neuron_in207.counter\[2\]
+ sky130_fd_sc_hd__edfxtp_1
Xnetwork.neuron_in207.counter\[3\]$_DFFE_PP_ clknet_leaf_128_clk_net
+ _02894_ _01297_ VSS VSS VDD VDD network.neuron_in207.counter\[3\]
+ sky130_fd_sc_hd__edfxtp_1
Xnetwork.neuron_in207.spike$_SDFFE_PP0P_ clknet_leaf_141_clk_net
+ _01942_ VSS VSS VDD VDD network.in_spk15_12 sky130_fd_sc_hd__dfxtp_1
Xnetwork.neuron_in208.counter\[0\]$_DFFE_PP_ clknet_leaf_143_clk_net
+ _02895_ _01296_ VSS VSS VDD VDD network.neuron_in208.counter\[0\]
+ sky130_fd_sc_hd__edfxtp_1
Xnetwork.neuron_in208.counter\[1\]$_DFFE_PP_ clknet_leaf_143_clk_net
+ _02896_ _01296_ VSS VSS VDD VDD network.neuron_in208.counter\[1\]
+ sky130_fd_sc_hd__edfxtp_1
Xnetwork.neuron_in208.counter\[2\]$_DFFE_PP_ clknet_leaf_144_clk_net
+ _02897_ _01296_ VSS VSS VDD VDD network.neuron_in208.counter\[2\]
+ sky130_fd_sc_hd__edfxtp_1
Xnetwork.neuron_in208.counter\[3\]$_DFFE_PP_ clknet_leaf_144_clk_net
+ _02898_ _01296_ VSS VSS VDD VDD network.neuron_in208.counter\[3\]
+ sky130_fd_sc_hd__edfxtp_1
Xnetwork.neuron_in208.spike$_SDFFE_PP0P_ clknet_leaf_144_clk_net
+ _01938_ VSS VSS VDD VDD network.in_spk00_13 sky130_fd_sc_hd__dfxtp_1
Xnetwork.neuron_in209.counter\[0\]$_DFFE_PP_ clknet_leaf_146_clk_net
+ _02899_ _01295_ VSS VSS VDD VDD network.neuron_in209.counter\[0\]
+ sky130_fd_sc_hd__edfxtp_1
Xnetwork.neuron_in209.counter\[1\]$_DFFE_PP_ clknet_leaf_146_clk_net
+ _02900_ _01295_ VSS VSS VDD VDD network.neuron_in209.counter\[1\]
+ sky130_fd_sc_hd__edfxtp_1
Xnetwork.neuron_in209.counter\[2\]$_DFFE_PP_ clknet_leaf_146_clk_net
+ _02901_ _01295_ VSS VSS VDD VDD network.neuron_in209.counter\[2\]
+ sky130_fd_sc_hd__edfxtp_1
Xnetwork.neuron_in209.counter\[3\]$_DFFE_PP_ clknet_leaf_143_clk_net
+ _02902_ _01295_ VSS VSS VDD VDD network.neuron_in209.counter\[3\]
+ sky130_fd_sc_hd__edfxtp_1
Xnetwork.neuron_in209.spike$_SDFFE_PP0P_ clknet_leaf_143_clk_net
+ _01933_ VSS VSS VDD VDD network.in_spk01_13 sky130_fd_sc_hd__dfxtp_1
Xnetwork.neuron_in210.counter\[0\]$_DFFE_PP_ clknet_leaf_142_clk_net
+ _02903_ _01294_ VSS VSS VDD VDD network.neuron_in210.counter\[0\]
+ sky130_fd_sc_hd__edfxtp_1
Xnetwork.neuron_in210.counter\[1\]$_DFFE_PP_ clknet_leaf_142_clk_net
+ _02904_ _01294_ VSS VSS VDD VDD network.neuron_in210.counter\[1\]
+ sky130_fd_sc_hd__edfxtp_1
Xnetwork.neuron_in210.counter\[2\]$_DFFE_PP_ clknet_leaf_142_clk_net
+ _02905_ _01294_ VSS VSS VDD VDD network.neuron_in210.counter\[2\]
+ sky130_fd_sc_hd__edfxtp_1
Xnetwork.neuron_in210.counter\[3\]$_DFFE_PP_ clknet_leaf_142_clk_net
+ _02906_ _01294_ VSS VSS VDD VDD network.neuron_in210.counter\[3\]
+ sky130_fd_sc_hd__edfxtp_1
Xnetwork.neuron_in210.spike$_SDFFE_PP0P_ clknet_leaf_142_clk_net
+ _01929_ VSS VSS VDD VDD network.in_spk02_13 sky130_fd_sc_hd__dfxtp_1
Xnetwork.neuron_in211.counter\[0\]$_DFFE_PP_ clknet_leaf_153_clk_net
+ _02907_ _01293_ VSS VSS VDD VDD network.neuron_in211.counter\[0\]
+ sky130_fd_sc_hd__edfxtp_1
Xnetwork.neuron_in211.counter\[1\]$_DFFE_PP_ clknet_leaf_153_clk_net
+ _02908_ _01293_ VSS VSS VDD VDD network.neuron_in211.counter\[1\]
+ sky130_fd_sc_hd__edfxtp_1
Xnetwork.neuron_in211.counter\[2\]$_DFFE_PP_ clknet_leaf_143_clk_net
+ _02909_ _01293_ VSS VSS VDD VDD network.neuron_in211.counter\[2\]
+ sky130_fd_sc_hd__edfxtp_1
Xnetwork.neuron_in211.counter\[3\]$_DFFE_PP_ clknet_leaf_146_clk_net
+ _02910_ _01293_ VSS VSS VDD VDD network.neuron_in211.counter\[3\]
+ sky130_fd_sc_hd__edfxtp_1
Xnetwork.neuron_in211.spike$_SDFFE_PP0P_ clknet_leaf_143_clk_net
+ _01924_ VSS VSS VDD VDD network.in_spk03_13 sky130_fd_sc_hd__dfxtp_1
Xnetwork.neuron_in212.counter\[0\]$_DFFE_PP_ clknet_leaf_144_clk_net
+ _02911_ _01292_ VSS VSS VDD VDD network.neuron_in212.counter\[0\]
+ sky130_fd_sc_hd__edfxtp_1
Xnetwork.neuron_in212.counter\[1\]$_DFFE_PP_ clknet_leaf_139_clk_net
+ _02912_ _01292_ VSS VSS VDD VDD network.neuron_in212.counter\[1\]
+ sky130_fd_sc_hd__edfxtp_1
Xnetwork.neuron_in212.counter\[2\]$_DFFE_PP_ clknet_leaf_139_clk_net
+ _02913_ _01292_ VSS VSS VDD VDD network.neuron_in212.counter\[2\]
+ sky130_fd_sc_hd__edfxtp_1
Xnetwork.neuron_in212.counter\[3\]$_DFFE_PP_ clknet_leaf_139_clk_net
+ _02914_ _01292_ VSS VSS VDD VDD network.neuron_in212.counter\[3\]
+ sky130_fd_sc_hd__edfxtp_1
Xnetwork.neuron_in212.spike$_SDFFE_PP0P_ clknet_leaf_142_clk_net
+ _01919_ VSS VSS VDD VDD network.in_spk04_13 sky130_fd_sc_hd__dfxtp_1
Xnetwork.neuron_in213.counter\[0\]$_DFFE_PP_ clknet_leaf_140_clk_net
+ _02915_ _01291_ VSS VSS VDD VDD network.neuron_in213.counter\[0\]
+ sky130_fd_sc_hd__edfxtp_1
Xnetwork.neuron_in213.counter\[1\]$_DFFE_PP_ clknet_leaf_140_clk_net
+ _02916_ _01291_ VSS VSS VDD VDD network.neuron_in213.counter\[1\]
+ sky130_fd_sc_hd__edfxtp_1
Xnetwork.neuron_in213.counter\[2\]$_DFFE_PP_ clknet_leaf_140_clk_net
+ _02917_ _01291_ VSS VSS VDD VDD network.neuron_in213.counter\[2\]
+ sky130_fd_sc_hd__edfxtp_1
Xnetwork.neuron_in213.counter\[3\]$_DFFE_PP_ clknet_leaf_139_clk_net
+ _02918_ _01291_ VSS VSS VDD VDD network.neuron_in213.counter\[3\]
+ sky130_fd_sc_hd__edfxtp_1
Xnetwork.neuron_in213.spike$_SDFFE_PP0P_ clknet_leaf_143_clk_net
+ _01914_ VSS VSS VDD VDD network.in_spk05_13 sky130_fd_sc_hd__dfxtp_1
Xnetwork.neuron_in214.counter\[0\]$_DFFE_PP_ clknet_leaf_144_clk_net
+ _02919_ _01290_ VSS VSS VDD VDD network.neuron_in214.counter\[0\]
+ sky130_fd_sc_hd__edfxtp_1
Xnetwork.neuron_in214.counter\[1\]$_DFFE_PP_ clknet_leaf_144_clk_net
+ _02920_ _01290_ VSS VSS VDD VDD network.neuron_in214.counter\[1\]
+ sky130_fd_sc_hd__edfxtp_1
Xnetwork.neuron_in214.counter\[2\]$_DFFE_PP_ clknet_leaf_142_clk_net
+ _02921_ _01290_ VSS VSS VDD VDD network.neuron_in214.counter\[2\]
+ sky130_fd_sc_hd__edfxtp_1
Xnetwork.neuron_in214.counter\[3\]$_DFFE_PP_ clknet_leaf_144_clk_net
+ _02922_ _01290_ VSS VSS VDD VDD network.neuron_in214.counter\[3\]
+ sky130_fd_sc_hd__edfxtp_1
Xnetwork.neuron_in214.spike$_SDFFE_PP0P_ clknet_leaf_142_clk_net
+ _01910_ VSS VSS VDD VDD network.in_spk06_13 sky130_fd_sc_hd__dfxtp_1
Xnetwork.neuron_in215.counter\[0\]$_DFFE_PP_ clknet_leaf_152_clk_net
+ _02923_ _01289_ VSS VSS VDD VDD network.neuron_in215.counter\[0\]
+ sky130_fd_sc_hd__edfxtp_1
Xnetwork.neuron_in215.counter\[1\]$_DFFE_PP_ clknet_leaf_152_clk_net
+ _02924_ _01289_ VSS VSS VDD VDD network.neuron_in215.counter\[1\]
+ sky130_fd_sc_hd__edfxtp_1
Xnetwork.neuron_in215.counter\[2\]$_DFFE_PP_ clknet_leaf_153_clk_net
+ _02925_ _01289_ VSS VSS VDD VDD network.neuron_in215.counter\[2\]
+ sky130_fd_sc_hd__edfxtp_1
Xnetwork.neuron_in215.counter\[3\]$_DFFE_PP_ clknet_leaf_152_clk_net
+ _02926_ _01289_ VSS VSS VDD VDD network.neuron_in215.counter\[3\]
+ sky130_fd_sc_hd__edfxtp_1
Xnetwork.neuron_in215.spike$_SDFFE_PP0P_ clknet_leaf_153_clk_net
+ _01905_ VSS VSS VDD VDD network.in_spk07_13 sky130_fd_sc_hd__dfxtp_1
Xnetwork.neuron_in216.counter\[0\]$_DFFE_PP_ clknet_leaf_152_clk_net
+ _02927_ _01288_ VSS VSS VDD VDD network.neuron_in216.counter\[0\]
+ sky130_fd_sc_hd__edfxtp_1
Xnetwork.neuron_in216.counter\[1\]$_DFFE_PP_ clknet_leaf_152_clk_net
+ _02928_ _01288_ VSS VSS VDD VDD network.neuron_in216.counter\[1\]
+ sky130_fd_sc_hd__edfxtp_1
Xnetwork.neuron_in216.counter\[2\]$_DFFE_PP_ clknet_leaf_154_clk_net
+ _02929_ _01288_ VSS VSS VDD VDD network.neuron_in216.counter\[2\]
+ sky130_fd_sc_hd__edfxtp_1
Xnetwork.neuron_in216.counter\[3\]$_DFFE_PP_ clknet_leaf_153_clk_net
+ _02930_ _01288_ VSS VSS VDD VDD network.neuron_in216.counter\[3\]
+ sky130_fd_sc_hd__edfxtp_1
Xnetwork.neuron_in216.spike$_SDFFE_PP0P_ clknet_leaf_153_clk_net
+ _01901_ VSS VSS VDD VDD network.in_spk08_13 sky130_fd_sc_hd__dfxtp_1
Xnetwork.neuron_in217.counter\[0\]$_DFFE_PP_ clknet_leaf_152_clk_net
+ _02931_ _01287_ VSS VSS VDD VDD network.neuron_in217.counter\[0\]
+ sky130_fd_sc_hd__edfxtp_1
Xnetwork.neuron_in217.counter\[1\]$_DFFE_PP_ clknet_leaf_152_clk_net
+ _02932_ _01287_ VSS VSS VDD VDD network.neuron_in217.counter\[1\]
+ sky130_fd_sc_hd__edfxtp_1
Xnetwork.neuron_in217.counter\[2\]$_DFFE_PP_ clknet_leaf_149_clk_net
+ _02933_ _01287_ VSS VSS VDD VDD network.neuron_in217.counter\[2\]
+ sky130_fd_sc_hd__edfxtp_1
Xnetwork.neuron_in217.counter\[3\]$_DFFE_PP_ clknet_leaf_149_clk_net
+ _02934_ _01287_ VSS VSS VDD VDD network.neuron_in217.counter\[3\]
+ sky130_fd_sc_hd__edfxtp_1
Xnetwork.neuron_in217.spike$_SDFFE_PP0P_ clknet_leaf_153_clk_net
+ _01898_ VSS VSS VDD VDD network.in_spk09_13 sky130_fd_sc_hd__dfxtp_1
Xnetwork.neuron_in218.counter\[0\]$_DFFE_PP_ clknet_leaf_147_clk_net
+ _02935_ _01286_ VSS VSS VDD VDD network.neuron_in218.counter\[0\]
+ sky130_fd_sc_hd__edfxtp_1
Xnetwork.neuron_in218.counter\[1\]$_DFFE_PP_ clknet_leaf_147_clk_net
+ _02936_ _01286_ VSS VSS VDD VDD network.neuron_in218.counter\[1\]
+ sky130_fd_sc_hd__edfxtp_1
Xnetwork.neuron_in218.counter\[2\]$_DFFE_PP_ clknet_leaf_146_clk_net
+ _02937_ _01286_ VSS VSS VDD VDD network.neuron_in218.counter\[2\]
+ sky130_fd_sc_hd__edfxtp_1
Xnetwork.neuron_in218.counter\[3\]$_DFFE_PP_ clknet_leaf_147_clk_net
+ _02938_ _01286_ VSS VSS VDD VDD network.neuron_in218.counter\[3\]
+ sky130_fd_sc_hd__edfxtp_1
Xnetwork.neuron_in218.spike$_SDFFE_PP0P_ clknet_leaf_153_clk_net
+ _01895_ VSS VSS VDD VDD network.in_spk10_13 sky130_fd_sc_hd__dfxtp_1
Xnetwork.neuron_in219.counter\[0\]$_DFFE_PP_ clknet_leaf_146_clk_net
+ _02939_ _01285_ VSS VSS VDD VDD network.neuron_in219.counter\[0\]
+ sky130_fd_sc_hd__edfxtp_1
Xnetwork.neuron_in219.counter\[1\]$_DFFE_PP_ clknet_leaf_146_clk_net
+ _02940_ _01285_ VSS VSS VDD VDD network.neuron_in219.counter\[1\]
+ sky130_fd_sc_hd__edfxtp_1
Xnetwork.neuron_in219.counter\[2\]$_DFFE_PP_ clknet_leaf_149_clk_net
+ _02941_ _01285_ VSS VSS VDD VDD network.neuron_in219.counter\[2\]
+ sky130_fd_sc_hd__edfxtp_1
Xnetwork.neuron_in219.counter\[3\]$_DFFE_PP_ clknet_leaf_149_clk_net
+ _02942_ _01285_ VSS VSS VDD VDD network.neuron_in219.counter\[3\]
+ sky130_fd_sc_hd__edfxtp_1
Xnetwork.neuron_in219.spike$_SDFFE_PP0P_ clknet_leaf_153_clk_net
+ _01892_ VSS VSS VDD VDD network.in_spk11_13 sky130_fd_sc_hd__dfxtp_1
Xnetwork.neuron_in220.counter\[0\]$_DFFE_PP_ clknet_leaf_139_clk_net
+ _02943_ _01284_ VSS VSS VDD VDD network.neuron_in220.counter\[0\]
+ sky130_fd_sc_hd__edfxtp_1
Xnetwork.neuron_in220.counter\[1\]$_DFFE_PP_ clknet_leaf_138_clk_net
+ _02944_ _01284_ VSS VSS VDD VDD network.neuron_in220.counter\[1\]
+ sky130_fd_sc_hd__edfxtp_1
Xnetwork.neuron_in220.counter\[2\]$_DFFE_PP_ clknet_leaf_139_clk_net
+ _02945_ _01284_ VSS VSS VDD VDD network.neuron_in220.counter\[2\]
+ sky130_fd_sc_hd__edfxtp_1
Xnetwork.neuron_in220.counter\[3\]$_DFFE_PP_ clknet_leaf_139_clk_net
+ _02946_ _01284_ VSS VSS VDD VDD network.neuron_in220.counter\[3\]
+ sky130_fd_sc_hd__edfxtp_1
Xnetwork.neuron_in220.spike$_SDFFE_PP0P_ clknet_leaf_143_clk_net
+ _01889_ VSS VSS VDD VDD network.in_spk12_13 sky130_fd_sc_hd__dfxtp_1
Xnetwork.neuron_in221.counter\[0\]$_DFFE_PP_ clknet_leaf_145_clk_net
+ _02947_ _01283_ VSS VSS VDD VDD network.neuron_in221.counter\[0\]
+ sky130_fd_sc_hd__edfxtp_1
Xnetwork.neuron_in221.counter\[1\]$_DFFE_PP_ clknet_leaf_145_clk_net
+ _02948_ _01283_ VSS VSS VDD VDD network.neuron_in221.counter\[1\]
+ sky130_fd_sc_hd__edfxtp_1
Xnetwork.neuron_in221.counter\[2\]$_DFFE_PP_ clknet_leaf_145_clk_net
+ _02949_ _01283_ VSS VSS VDD VDD network.neuron_in221.counter\[2\]
+ sky130_fd_sc_hd__edfxtp_1
Xnetwork.neuron_in221.counter\[3\]$_DFFE_PP_ clknet_leaf_145_clk_net
+ _02950_ _01283_ VSS VSS VDD VDD network.neuron_in221.counter\[3\]
+ sky130_fd_sc_hd__edfxtp_1
Xnetwork.neuron_in221.spike$_SDFFE_PP0P_ clknet_leaf_143_clk_net
+ _01886_ VSS VSS VDD VDD network.in_spk13_13 sky130_fd_sc_hd__dfxtp_1
Xnetwork.neuron_in222.counter\[0\]$_DFFE_PP_ clknet_leaf_145_clk_net
+ _02951_ _01282_ VSS VSS VDD VDD network.neuron_in222.counter\[0\]
+ sky130_fd_sc_hd__edfxtp_1
Xnetwork.neuron_in222.counter\[1\]$_DFFE_PP_ clknet_leaf_145_clk_net
+ _02952_ _01282_ VSS VSS VDD VDD network.neuron_in222.counter\[1\]
+ sky130_fd_sc_hd__edfxtp_1
Xnetwork.neuron_in222.counter\[2\]$_DFFE_PP_ clknet_leaf_145_clk_net
+ _02953_ _01282_ VSS VSS VDD VDD network.neuron_in222.counter\[2\]
+ sky130_fd_sc_hd__edfxtp_1
Xnetwork.neuron_in222.counter\[3\]$_DFFE_PP_ clknet_leaf_145_clk_net
+ _02954_ _01282_ VSS VSS VDD VDD network.neuron_in222.counter\[3\]
+ sky130_fd_sc_hd__edfxtp_1
Xnetwork.neuron_in222.spike$_SDFFE_PP0P_ clknet_leaf_143_clk_net
+ _01883_ VSS VSS VDD VDD network.in_spk14_13 sky130_fd_sc_hd__dfxtp_1
Xnetwork.neuron_in223.counter\[0\]$_DFFE_PP_ clknet_leaf_138_clk_net
+ _02955_ _01281_ VSS VSS VDD VDD network.neuron_in223.counter\[0\]
+ sky130_fd_sc_hd__edfxtp_1
Xnetwork.neuron_in223.counter\[1\]$_DFFE_PP_ clknet_leaf_138_clk_net
+ _02956_ _01281_ VSS VSS VDD VDD network.neuron_in223.counter\[1\]
+ sky130_fd_sc_hd__edfxtp_1
Xnetwork.neuron_in223.counter\[2\]$_DFFE_PP_ clknet_leaf_138_clk_net
+ _02957_ _01281_ VSS VSS VDD VDD network.neuron_in223.counter\[2\]
+ sky130_fd_sc_hd__edfxtp_1
Xnetwork.neuron_in223.counter\[3\]$_DFFE_PP_ clknet_leaf_138_clk_net
+ _02958_ _01281_ VSS VSS VDD VDD network.neuron_in223.counter\[3\]
+ sky130_fd_sc_hd__edfxtp_1
Xnetwork.neuron_in223.spike$_SDFFE_PP0P_ clknet_leaf_143_clk_net
+ _01880_ VSS VSS VDD VDD network.in_spk15_13 sky130_fd_sc_hd__dfxtp_1
Xnetwork.neuron_in224.counter\[0\]$_DFFE_PP_ clknet_leaf_105_clk_net
+ _02959_ _01280_ VSS VSS VDD VDD network.neuron_in224.counter\[0\]
+ sky130_fd_sc_hd__edfxtp_1
Xnetwork.neuron_in224.counter\[1\]$_DFFE_PP_ clknet_leaf_105_clk_net
+ _02960_ _01280_ VSS VSS VDD VDD network.neuron_in224.counter\[1\]
+ sky130_fd_sc_hd__edfxtp_1
Xnetwork.neuron_in224.counter\[2\]$_DFFE_PP_ clknet_leaf_105_clk_net
+ _02961_ _01280_ VSS VSS VDD VDD network.neuron_in224.counter\[2\]
+ sky130_fd_sc_hd__edfxtp_1
Xnetwork.neuron_in224.counter\[3\]$_DFFE_PP_ clknet_leaf_105_clk_net
+ _02962_ _01280_ VSS VSS VDD VDD network.neuron_in224.counter\[3\]
+ sky130_fd_sc_hd__edfxtp_1
Xnetwork.neuron_in224.spike$_SDFFE_PP0P_ clknet_leaf_106_clk_net
+ _01877_ VSS VSS VDD VDD network.in_spk00_14 sky130_fd_sc_hd__dfxtp_1
Xnetwork.neuron_in225.counter\[0\]$_DFFE_PP_ clknet_leaf_107_clk_net
+ _02963_ _01279_ VSS VSS VDD VDD network.neuron_in225.counter\[0\]
+ sky130_fd_sc_hd__edfxtp_1
Xnetwork.neuron_in225.counter\[1\]$_DFFE_PP_ clknet_leaf_107_clk_net
+ _02964_ _01279_ VSS VSS VDD VDD network.neuron_in225.counter\[1\]
+ sky130_fd_sc_hd__edfxtp_1
Xnetwork.neuron_in225.counter\[2\]$_DFFE_PP_ clknet_leaf_106_clk_net
+ _02965_ _01279_ VSS VSS VDD VDD network.neuron_in225.counter\[2\]
+ sky130_fd_sc_hd__edfxtp_1
Xnetwork.neuron_in225.counter\[3\]$_DFFE_PP_ clknet_leaf_107_clk_net
+ _02966_ _01279_ VSS VSS VDD VDD network.neuron_in225.counter\[3\]
+ sky130_fd_sc_hd__edfxtp_1
Xnetwork.neuron_in225.spike$_SDFFE_PP0P_ clknet_leaf_106_clk_net
+ _01874_ VSS VSS VDD VDD network.in_spk01_14 sky130_fd_sc_hd__dfxtp_1
Xnetwork.neuron_in226.counter\[0\]$_DFFE_PP_ clknet_leaf_106_clk_net
+ _02967_ _01278_ VSS VSS VDD VDD network.neuron_in226.counter\[0\]
+ sky130_fd_sc_hd__edfxtp_1
Xnetwork.neuron_in226.counter\[1\]$_DFFE_PP_ clknet_leaf_106_clk_net
+ _02968_ _01278_ VSS VSS VDD VDD network.neuron_in226.counter\[1\]
+ sky130_fd_sc_hd__edfxtp_1
Xnetwork.neuron_in226.counter\[2\]$_DFFE_PP_ clknet_leaf_105_clk_net
+ _02969_ _01278_ VSS VSS VDD VDD network.neuron_in226.counter\[2\]
+ sky130_fd_sc_hd__edfxtp_1
Xnetwork.neuron_in226.counter\[3\]$_DFFE_PP_ clknet_leaf_69_clk_net
+ _02970_ _01278_ VSS VSS VDD VDD network.neuron_in226.counter\[3\]
+ sky130_fd_sc_hd__edfxtp_1
Xnetwork.neuron_in226.spike$_SDFFE_PP0P_ clknet_leaf_106_clk_net
+ _01945_ VSS VSS VDD VDD network.in_spk02_14 sky130_fd_sc_hd__dfxtp_1
Xnetwork.neuron_in227.counter\[0\]$_DFFE_PP_ clknet_leaf_69_clk_net
+ _02971_ _01277_ VSS VSS VDD VDD network.neuron_in227.counter\[0\]
+ sky130_fd_sc_hd__edfxtp_1
Xnetwork.neuron_in227.counter\[1\]$_DFFE_PP_ clknet_leaf_69_clk_net
+ _02972_ _01277_ VSS VSS VDD VDD network.neuron_in227.counter\[1\]
+ sky130_fd_sc_hd__edfxtp_1
Xnetwork.neuron_in227.counter\[2\]$_DFFE_PP_ clknet_leaf_70_clk_net
+ _02973_ _01277_ VSS VSS VDD VDD network.neuron_in227.counter\[2\]
+ sky130_fd_sc_hd__edfxtp_1
Xnetwork.neuron_in227.counter\[3\]$_DFFE_PP_ clknet_leaf_70_clk_net
+ _02974_ _01277_ VSS VSS VDD VDD network.neuron_in227.counter\[3\]
+ sky130_fd_sc_hd__edfxtp_1
Xnetwork.neuron_in227.spike$_SDFFE_PP0P_ clknet_leaf_106_clk_net
+ _01907_ VSS VSS VDD VDD network.in_spk03_14 sky130_fd_sc_hd__dfxtp_1
Xnetwork.neuron_in228.counter\[0\]$_DFFE_PP_ clknet_leaf_67_clk_net
+ _02975_ _01276_ VSS VSS VDD VDD network.neuron_in228.counter\[0\]
+ sky130_fd_sc_hd__edfxtp_1
Xnetwork.neuron_in228.counter\[1\]$_DFFE_PP_ clknet_leaf_67_clk_net
+ _02976_ _01276_ VSS VSS VDD VDD network.neuron_in228.counter\[1\]
+ sky130_fd_sc_hd__edfxtp_1
Xnetwork.neuron_in228.counter\[2\]$_DFFE_PP_ clknet_leaf_67_clk_net
+ _02977_ _01276_ VSS VSS VDD VDD network.neuron_in228.counter\[2\]
+ sky130_fd_sc_hd__edfxtp_1
Xnetwork.neuron_in228.counter\[3\]$_DFFE_PP_ clknet_leaf_67_clk_net
+ _02978_ _01276_ VSS VSS VDD VDD network.neuron_in228.counter\[3\]
+ sky130_fd_sc_hd__edfxtp_1
Xnetwork.neuron_in228.spike$_SDFFE_PP0P_ clknet_leaf_68_clk_net
+ _01947_ VSS VSS VDD VDD network.in_spk04_14 sky130_fd_sc_hd__dfxtp_1
Xnetwork.neuron_in229.counter\[0\]$_DFFE_PP_ clknet_leaf_29_clk_net
+ _02979_ _01275_ VSS VSS VDD VDD network.neuron_in229.counter\[0\]
+ sky130_fd_sc_hd__edfxtp_1
Xnetwork.neuron_in229.counter\[1\]$_DFFE_PP_ clknet_leaf_29_clk_net
+ _02980_ _01275_ VSS VSS VDD VDD network.neuron_in229.counter\[1\]
+ sky130_fd_sc_hd__edfxtp_1
Xnetwork.neuron_in229.counter\[2\]$_DFFE_PP_ clknet_leaf_29_clk_net
+ _02981_ _01275_ VSS VSS VDD VDD network.neuron_in229.counter\[2\]
+ sky130_fd_sc_hd__edfxtp_1
Xnetwork.neuron_in229.counter\[3\]$_DFFE_PP_ clknet_leaf_29_clk_net
+ _02982_ _01275_ VSS VSS VDD VDD network.neuron_in229.counter\[3\]
+ sky130_fd_sc_hd__edfxtp_1
Xnetwork.neuron_in229.spike$_SDFFE_PP0P_ clknet_leaf_68_clk_net
+ _01935_ VSS VSS VDD VDD network.in_spk05_14 sky130_fd_sc_hd__dfxtp_1
Xnetwork.neuron_in230.counter\[0\]$_DFFE_PP_ clknet_leaf_67_clk_net
+ _02983_ _01274_ VSS VSS VDD VDD network.neuron_in230.counter\[0\]
+ sky130_fd_sc_hd__edfxtp_1
Xnetwork.neuron_in230.counter\[1\]$_DFFE_PP_ clknet_leaf_67_clk_net
+ _02984_ _01274_ VSS VSS VDD VDD network.neuron_in230.counter\[1\]
+ sky130_fd_sc_hd__edfxtp_1
Xnetwork.neuron_in230.counter\[2\]$_DFFE_PP_ clknet_leaf_68_clk_net
+ _02985_ _01274_ VSS VSS VDD VDD network.neuron_in230.counter\[2\]
+ sky130_fd_sc_hd__edfxtp_1
Xnetwork.neuron_in230.counter\[3\]$_DFFE_PP_ clknet_leaf_67_clk_net
+ _02986_ _01274_ VSS VSS VDD VDD network.neuron_in230.counter\[3\]
+ sky130_fd_sc_hd__edfxtp_1
Xnetwork.neuron_in230.spike$_SDFFE_PP0P_ clknet_leaf_68_clk_net
+ _01926_ VSS VSS VDD VDD network.in_spk06_14 sky130_fd_sc_hd__dfxtp_1
Xnetwork.neuron_in231.counter\[0\]$_DFFE_PP_ clknet_leaf_25_clk_net
+ _02987_ _01273_ VSS VSS VDD VDD network.neuron_in231.counter\[0\]
+ sky130_fd_sc_hd__edfxtp_1
Xnetwork.neuron_in231.counter\[1\]$_DFFE_PP_ clknet_leaf_25_clk_net
+ _02988_ _01273_ VSS VSS VDD VDD network.neuron_in231.counter\[1\]
+ sky130_fd_sc_hd__edfxtp_1
Xnetwork.neuron_in231.counter\[2\]$_DFFE_PP_ clknet_leaf_25_clk_net
+ _02989_ _01273_ VSS VSS VDD VDD network.neuron_in231.counter\[2\]
+ sky130_fd_sc_hd__edfxtp_1
Xnetwork.neuron_in231.counter\[3\]$_DFFE_PP_ clknet_leaf_25_clk_net
+ _02990_ _01273_ VSS VSS VDD VDD network.neuron_in231.counter\[3\]
+ sky130_fd_sc_hd__edfxtp_1
Xnetwork.neuron_in231.spike$_SDFFE_PP0P_ clknet_leaf_68_clk_net
+ _01869_ VSS VSS VDD VDD network.in_spk07_14 sky130_fd_sc_hd__dfxtp_1
Xnetwork.neuron_in232.counter\[0\]$_DFFE_PP_ clknet_leaf_69_clk_net
+ _02991_ _01272_ VSS VSS VDD VDD network.neuron_in232.counter\[0\]
+ sky130_fd_sc_hd__edfxtp_1
Xnetwork.neuron_in232.counter\[1\]$_DFFE_PP_ clknet_leaf_69_clk_net
+ _02992_ _01272_ VSS VSS VDD VDD network.neuron_in232.counter\[1\]
+ sky130_fd_sc_hd__edfxtp_1
Xnetwork.neuron_in232.counter\[2\]$_DFFE_PP_ clknet_leaf_68_clk_net
+ _02993_ _01272_ VSS VSS VDD VDD network.neuron_in232.counter\[2\]
+ sky130_fd_sc_hd__edfxtp_1
Xnetwork.neuron_in232.counter\[3\]$_DFFE_PP_ clknet_leaf_68_clk_net
+ _02994_ _01272_ VSS VSS VDD VDD network.neuron_in232.counter\[3\]
+ sky130_fd_sc_hd__edfxtp_1
Xnetwork.neuron_in232.spike$_SDFFE_PP0P_ clknet_leaf_68_clk_net
+ _01870_ VSS VSS VDD VDD network.in_spk08_14 sky130_fd_sc_hd__dfxtp_1
Xnetwork.neuron_in233.counter\[0\]$_DFFE_PP_ clknet_leaf_71_clk_net
+ _02995_ _01271_ VSS VSS VDD VDD network.neuron_in233.counter\[0\]
+ sky130_fd_sc_hd__edfxtp_1
Xnetwork.neuron_in233.counter\[1\]$_DFFE_PP_ clknet_leaf_71_clk_net
+ _02996_ _01271_ VSS VSS VDD VDD network.neuron_in233.counter\[1\]
+ sky130_fd_sc_hd__edfxtp_1
Xnetwork.neuron_in233.counter\[2\]$_DFFE_PP_ clknet_leaf_66_clk_net
+ _02997_ _01271_ VSS VSS VDD VDD network.neuron_in233.counter\[2\]
+ sky130_fd_sc_hd__edfxtp_1
Xnetwork.neuron_in233.counter\[3\]$_DFFE_PP_ clknet_leaf_66_clk_net
+ _02998_ _01271_ VSS VSS VDD VDD network.neuron_in233.counter\[3\]
+ sky130_fd_sc_hd__edfxtp_1
Xnetwork.neuron_in233.spike$_SDFFE_PP0P_ clknet_leaf_68_clk_net
+ _01871_ VSS VSS VDD VDD network.in_spk09_14 sky130_fd_sc_hd__dfxtp_1
Xnetwork.neuron_in234.counter\[0\]$_DFFE_PP_ clknet_leaf_70_clk_net
+ _02999_ _01270_ VSS VSS VDD VDD network.neuron_in234.counter\[0\]
+ sky130_fd_sc_hd__edfxtp_1
Xnetwork.neuron_in234.counter\[1\]$_DFFE_PP_ clknet_leaf_69_clk_net
+ _03000_ _01270_ VSS VSS VDD VDD network.neuron_in234.counter\[1\]
+ sky130_fd_sc_hd__edfxtp_1
Xnetwork.neuron_in234.counter\[2\]$_DFFE_PP_ clknet_leaf_104_clk_net
+ _03001_ _01270_ VSS VSS VDD VDD network.neuron_in234.counter\[2\]
+ sky130_fd_sc_hd__edfxtp_1
Xnetwork.neuron_in234.counter\[3\]$_DFFE_PP_ clknet_leaf_105_clk_net
+ _03002_ _01270_ VSS VSS VDD VDD network.neuron_in234.counter\[3\]
+ sky130_fd_sc_hd__edfxtp_1
Xnetwork.neuron_in234.spike$_SDFFE_PP0P_ clknet_leaf_68_clk_net
+ _01872_ VSS VSS VDD VDD network.in_spk10_14 sky130_fd_sc_hd__dfxtp_1
Xnetwork.neuron_in235.counter\[0\]$_DFFE_PP_ clknet_leaf_23_clk_net
+ _03003_ _01269_ VSS VSS VDD VDD network.neuron_in235.counter\[0\]
+ sky130_fd_sc_hd__edfxtp_1
Xnetwork.neuron_in235.counter\[1\]$_DFFE_PP_ clknet_leaf_23_clk_net
+ _03004_ _01269_ VSS VSS VDD VDD network.neuron_in235.counter\[1\]
+ sky130_fd_sc_hd__edfxtp_1
Xnetwork.neuron_in235.counter\[2\]$_DFFE_PP_ clknet_leaf_161_clk_net
+ _03005_ _01269_ VSS VSS VDD VDD network.neuron_in235.counter\[2\]
+ sky130_fd_sc_hd__edfxtp_1
Xnetwork.neuron_in235.counter\[3\]$_DFFE_PP_ clknet_leaf_23_clk_net
+ _03006_ _01269_ VSS VSS VDD VDD network.neuron_in235.counter\[3\]
+ sky130_fd_sc_hd__edfxtp_1
Xnetwork.neuron_in235.spike$_SDFFE_PP0P_ clknet_leaf_24_clk_net
+ _01867_ VSS VSS VDD VDD network.in_spk11_14 sky130_fd_sc_hd__dfxtp_1
Xnetwork.neuron_in236.counter\[0\]$_DFFE_PP_ clknet_leaf_23_clk_net
+ _03007_ _01268_ VSS VSS VDD VDD network.neuron_in236.counter\[0\]
+ sky130_fd_sc_hd__edfxtp_1
Xnetwork.neuron_in236.counter\[1\]$_DFFE_PP_ clknet_leaf_161_clk_net
+ _03008_ _01268_ VSS VSS VDD VDD network.neuron_in236.counter\[1\]
+ sky130_fd_sc_hd__edfxtp_1
Xnetwork.neuron_in236.counter\[2\]$_DFFE_PP_ clknet_leaf_161_clk_net
+ _03009_ _01268_ VSS VSS VDD VDD network.neuron_in236.counter\[2\]
+ sky130_fd_sc_hd__edfxtp_1
Xnetwork.neuron_in236.counter\[3\]$_DFFE_PP_ clknet_leaf_161_clk_net
+ _03010_ _01268_ VSS VSS VDD VDD network.neuron_in236.counter\[3\]
+ sky130_fd_sc_hd__edfxtp_1
Xnetwork.neuron_in236.spike$_SDFFE_PP0P_ clknet_leaf_161_clk_net
+ _01868_ VSS VSS VDD VDD network.in_spk12_14 sky130_fd_sc_hd__dfxtp_1
Xnetwork.neuron_in237.counter\[0\]$_DFFE_PP_ clknet_leaf_22_clk_net
+ _03011_ _01267_ VSS VSS VDD VDD network.neuron_in237.counter\[0\]
+ sky130_fd_sc_hd__edfxtp_1
Xnetwork.neuron_in237.counter\[1\]$_DFFE_PP_ clknet_leaf_22_clk_net
+ _03012_ _01267_ VSS VSS VDD VDD network.neuron_in237.counter\[1\]
+ sky130_fd_sc_hd__edfxtp_1
Xnetwork.neuron_in237.counter\[2\]$_DFFE_PP_ clknet_leaf_22_clk_net
+ _03013_ _01267_ VSS VSS VDD VDD network.neuron_in237.counter\[2\]
+ sky130_fd_sc_hd__edfxtp_1
Xnetwork.neuron_in237.counter\[3\]$_DFFE_PP_ clknet_leaf_22_clk_net
+ _03014_ _01267_ VSS VSS VDD VDD network.neuron_in237.counter\[3\]
+ sky130_fd_sc_hd__edfxtp_1
Xnetwork.neuron_in237.spike$_SDFFE_PP0P_ clknet_leaf_160_clk_net
+ _01873_ VSS VSS VDD VDD network.in_spk13_14 sky130_fd_sc_hd__dfxtp_1
Xnetwork.neuron_in238.counter\[0\]$_DFFE_PP_ clknet_leaf_161_clk_net
+ _03015_ _01266_ VSS VSS VDD VDD network.neuron_in238.counter\[0\]
+ sky130_fd_sc_hd__edfxtp_1
Xnetwork.neuron_in238.counter\[1\]$_DFFE_PP_ clknet_leaf_161_clk_net
+ _03016_ _01266_ VSS VSS VDD VDD network.neuron_in238.counter\[1\]
+ sky130_fd_sc_hd__edfxtp_1
Xnetwork.neuron_in238.counter\[2\]$_DFFE_PP_ clknet_leaf_160_clk_net
+ _03017_ _01266_ VSS VSS VDD VDD network.neuron_in238.counter\[2\]
+ sky130_fd_sc_hd__edfxtp_1
Xnetwork.neuron_in238.counter\[3\]$_DFFE_PP_ clknet_leaf_161_clk_net
+ _03018_ _01266_ VSS VSS VDD VDD network.neuron_in238.counter\[3\]
+ sky130_fd_sc_hd__edfxtp_1
Xnetwork.neuron_in238.spike$_SDFFE_PP0P_ clknet_leaf_160_clk_net
+ _01875_ VSS VSS VDD VDD network.in_spk14_14 sky130_fd_sc_hd__dfxtp_1
Xnetwork.neuron_in239.counter\[0\]$_DFFE_PP_ clknet_leaf_160_clk_net
+ _03019_ _01265_ VSS VSS VDD VDD network.neuron_in239.counter\[0\]
+ sky130_fd_sc_hd__edfxtp_1
Xnetwork.neuron_in239.counter\[1\]$_DFFE_PP_ clknet_leaf_160_clk_net
+ _03020_ _01265_ VSS VSS VDD VDD network.neuron_in239.counter\[1\]
+ sky130_fd_sc_hd__edfxtp_1
Xnetwork.neuron_in239.counter\[2\]$_DFFE_PP_ clknet_leaf_159_clk_net
+ _03021_ _01265_ VSS VSS VDD VDD network.neuron_in239.counter\[2\]
+ sky130_fd_sc_hd__edfxtp_1
Xnetwork.neuron_in239.counter\[3\]$_DFFE_PP_ clknet_leaf_160_clk_net
+ _03022_ _01265_ VSS VSS VDD VDD network.neuron_in239.counter\[3\]
+ sky130_fd_sc_hd__edfxtp_1
Xnetwork.neuron_in239.spike$_SDFFE_PP0P_ clknet_leaf_160_clk_net
+ _01876_ VSS VSS VDD VDD network.in_spk15_14 sky130_fd_sc_hd__dfxtp_1
Xnetwork.neuron_in240.counter\[0\]$_DFFE_PP_ clknet_leaf_98_clk_net
+ _03023_ _01264_ VSS VSS VDD VDD network.neuron_in240.counter\[0\]
+ sky130_fd_sc_hd__edfxtp_1
Xnetwork.neuron_in240.counter\[1\]$_DFFE_PP_ clknet_leaf_99_clk_net
+ _03024_ _01264_ VSS VSS VDD VDD network.neuron_in240.counter\[1\]
+ sky130_fd_sc_hd__edfxtp_1
Xnetwork.neuron_in240.counter\[2\]$_DFFE_PP_ clknet_leaf_98_clk_net
+ _03025_ _01264_ VSS VSS VDD VDD network.neuron_in240.counter\[2\]
+ sky130_fd_sc_hd__edfxtp_1
Xnetwork.neuron_in240.counter\[3\]$_DFFE_PP_ clknet_leaf_98_clk_net
+ _03026_ _01264_ VSS VSS VDD VDD network.neuron_in240.counter\[3\]
+ sky130_fd_sc_hd__edfxtp_1
Xnetwork.neuron_in240.spike$_SDFFE_PP0P_ clknet_leaf_103_clk_net
+ _01878_ VSS VSS VDD VDD network.in_spk00_15 sky130_fd_sc_hd__dfxtp_1
Xnetwork.neuron_in241.counter\[0\]$_DFFE_PP_ clknet_leaf_98_clk_net
+ _03027_ _01263_ VSS VSS VDD VDD network.neuron_in241.counter\[0\]
+ sky130_fd_sc_hd__edfxtp_1
Xnetwork.neuron_in241.counter\[1\]$_DFFE_PP_ clknet_leaf_115_clk_net
+ _03028_ _01263_ VSS VSS VDD VDD network.neuron_in241.counter\[1\]
+ sky130_fd_sc_hd__edfxtp_1
Xnetwork.neuron_in241.counter\[2\]$_DFFE_PP_ clknet_leaf_98_clk_net
+ _03029_ _01263_ VSS VSS VDD VDD network.neuron_in241.counter\[2\]
+ sky130_fd_sc_hd__edfxtp_1
Xnetwork.neuron_in241.counter\[3\]$_DFFE_PP_ clknet_leaf_115_clk_net
+ _03030_ _01263_ VSS VSS VDD VDD network.neuron_in241.counter\[3\]
+ sky130_fd_sc_hd__edfxtp_1
Xnetwork.neuron_in241.spike$_SDFFE_PP0P_ clknet_leaf_103_clk_net
+ _01879_ VSS VSS VDD VDD network.in_spk01_15 sky130_fd_sc_hd__dfxtp_1
Xnetwork.neuron_in242.counter\[0\]$_DFFE_PP_ clknet_leaf_115_clk_net
+ _03031_ _01262_ VSS VSS VDD VDD network.neuron_in242.counter\[0\]
+ sky130_fd_sc_hd__edfxtp_1
Xnetwork.neuron_in242.counter\[1\]$_DFFE_PP_ clknet_leaf_115_clk_net
+ _03032_ _01262_ VSS VSS VDD VDD network.neuron_in242.counter\[1\]
+ sky130_fd_sc_hd__edfxtp_1
Xnetwork.neuron_in242.counter\[2\]$_DFFE_PP_ clknet_leaf_116_clk_net
+ _03033_ _01262_ VSS VSS VDD VDD network.neuron_in242.counter\[2\]
+ sky130_fd_sc_hd__edfxtp_1
Xnetwork.neuron_in242.counter\[3\]$_DFFE_PP_ clknet_leaf_115_clk_net
+ _03034_ _01262_ VSS VSS VDD VDD network.neuron_in242.counter\[3\]
+ sky130_fd_sc_hd__edfxtp_1
Xnetwork.neuron_in242.spike$_SDFFE_PP0P_ clknet_leaf_109_clk_net
+ _01881_ VSS VSS VDD VDD network.in_spk02_15 sky130_fd_sc_hd__dfxtp_1
Xnetwork.neuron_in243.counter\[0\]$_DFFE_PP_ clknet_leaf_99_clk_net
+ _03035_ _01261_ VSS VSS VDD VDD network.neuron_in243.counter\[0\]
+ sky130_fd_sc_hd__edfxtp_1
Xnetwork.neuron_in243.counter\[1\]$_DFFE_PP_ clknet_leaf_99_clk_net
+ _03036_ _01261_ VSS VSS VDD VDD network.neuron_in243.counter\[1\]
+ sky130_fd_sc_hd__edfxtp_1
Xnetwork.neuron_in243.counter\[2\]$_DFFE_PP_ clknet_leaf_99_clk_net
+ _03037_ _01261_ VSS VSS VDD VDD network.neuron_in243.counter\[2\]
+ sky130_fd_sc_hd__edfxtp_1
Xnetwork.neuron_in243.counter\[3\]$_DFFE_PP_ clknet_leaf_99_clk_net
+ _03038_ _01261_ VSS VSS VDD VDD network.neuron_in243.counter\[3\]
+ sky130_fd_sc_hd__edfxtp_1
Xnetwork.neuron_in243.spike$_SDFFE_PP0P_ clknet_leaf_103_clk_net
+ _01882_ VSS VSS VDD VDD network.in_spk03_15 sky130_fd_sc_hd__dfxtp_1
Xnetwork.neuron_in244.counter\[0\]$_DFFE_PP_ clknet_leaf_108_clk_net
+ _03039_ _01260_ VSS VSS VDD VDD network.neuron_in244.counter\[0\]
+ sky130_fd_sc_hd__edfxtp_1
Xnetwork.neuron_in244.counter\[1\]$_DFFE_PP_ clknet_leaf_108_clk_net
+ _03040_ _01260_ VSS VSS VDD VDD network.neuron_in244.counter\[1\]
+ sky130_fd_sc_hd__edfxtp_1
Xnetwork.neuron_in244.counter\[2\]$_DFFE_PP_ clknet_leaf_105_clk_net
+ _03041_ _01260_ VSS VSS VDD VDD network.neuron_in244.counter\[2\]
+ sky130_fd_sc_hd__edfxtp_1
Xnetwork.neuron_in244.counter\[3\]$_DFFE_PP_ clknet_leaf_104_clk_net
+ _03042_ _01260_ VSS VSS VDD VDD network.neuron_in244.counter\[3\]
+ sky130_fd_sc_hd__edfxtp_1
Xnetwork.neuron_in244.spike$_SDFFE_PP0P_ clknet_leaf_103_clk_net
+ _01884_ VSS VSS VDD VDD network.in_spk04_15 sky130_fd_sc_hd__dfxtp_1
Xnetwork.neuron_in245.counter\[0\]$_DFFE_PP_ clknet_leaf_104_clk_net
+ _03043_ _01259_ VSS VSS VDD VDD network.neuron_in245.counter\[0\]
+ sky130_fd_sc_hd__edfxtp_1
Xnetwork.neuron_in245.counter\[1\]$_DFFE_PP_ clknet_leaf_104_clk_net
+ _03044_ _01259_ VSS VSS VDD VDD network.neuron_in245.counter\[1\]
+ sky130_fd_sc_hd__edfxtp_1
Xnetwork.neuron_in245.counter\[2\]$_DFFE_PP_ clknet_leaf_104_clk_net
+ _03045_ _01259_ VSS VSS VDD VDD network.neuron_in245.counter\[2\]
+ sky130_fd_sc_hd__edfxtp_1
Xnetwork.neuron_in245.counter\[3\]$_DFFE_PP_ clknet_leaf_104_clk_net
+ _03046_ _01259_ VSS VSS VDD VDD network.neuron_in245.counter\[3\]
+ sky130_fd_sc_hd__edfxtp_1
Xnetwork.neuron_in245.spike$_SDFFE_PP0P_ clknet_leaf_103_clk_net
+ _01885_ VSS VSS VDD VDD network.in_spk05_15 sky130_fd_sc_hd__dfxtp_1
Xnetwork.neuron_in246.counter\[0\]$_DFFE_PP_ clknet_leaf_99_clk_net
+ _03047_ _01258_ VSS VSS VDD VDD network.neuron_in246.counter\[0\]
+ sky130_fd_sc_hd__edfxtp_1
Xnetwork.neuron_in246.counter\[1\]$_DFFE_PP_ clknet_leaf_102_clk_net
+ _03048_ _01258_ VSS VSS VDD VDD network.neuron_in246.counter\[1\]
+ sky130_fd_sc_hd__edfxtp_1
Xnetwork.neuron_in246.counter\[2\]$_DFFE_PP_ clknet_leaf_99_clk_net
+ _03049_ _01258_ VSS VSS VDD VDD network.neuron_in246.counter\[2\]
+ sky130_fd_sc_hd__edfxtp_1
Xnetwork.neuron_in246.counter\[3\]$_DFFE_PP_ clknet_leaf_99_clk_net
+ _03050_ _01258_ VSS VSS VDD VDD network.neuron_in246.counter\[3\]
+ sky130_fd_sc_hd__edfxtp_1
Xnetwork.neuron_in246.spike$_SDFFE_PP0P_ clknet_leaf_103_clk_net
+ _01887_ VSS VSS VDD VDD network.in_spk06_15 sky130_fd_sc_hd__dfxtp_1
Xnetwork.neuron_in247.counter\[0\]$_DFFE_PP_ clknet_leaf_110_clk_net
+ _03051_ _01257_ VSS VSS VDD VDD network.neuron_in247.counter\[0\]
+ sky130_fd_sc_hd__edfxtp_1
Xnetwork.neuron_in247.counter\[1\]$_DFFE_PP_ clknet_leaf_110_clk_net
+ _03052_ _01257_ VSS VSS VDD VDD network.neuron_in247.counter\[1\]
+ sky130_fd_sc_hd__edfxtp_1
Xnetwork.neuron_in247.counter\[2\]$_DFFE_PP_ clknet_leaf_110_clk_net
+ _03053_ _01257_ VSS VSS VDD VDD network.neuron_in247.counter\[2\]
+ sky130_fd_sc_hd__edfxtp_1
Xnetwork.neuron_in247.counter\[3\]$_DFFE_PP_ clknet_leaf_110_clk_net
+ _03054_ _01257_ VSS VSS VDD VDD network.neuron_in247.counter\[3\]
+ sky130_fd_sc_hd__edfxtp_1
Xnetwork.neuron_in247.spike$_SDFFE_PP0P_ clknet_leaf_109_clk_net
+ _01888_ VSS VSS VDD VDD network.in_spk07_15 sky130_fd_sc_hd__dfxtp_1
Xnetwork.neuron_in248.counter\[0\]$_DFFE_PP_ clknet_leaf_102_clk_net
+ _03055_ _01256_ VSS VSS VDD VDD network.neuron_in248.counter\[0\]
+ sky130_fd_sc_hd__edfxtp_1
Xnetwork.neuron_in248.counter\[1\]$_DFFE_PP_ clknet_leaf_102_clk_net
+ _03056_ _01256_ VSS VSS VDD VDD network.neuron_in248.counter\[1\]
+ sky130_fd_sc_hd__edfxtp_1
Xnetwork.neuron_in248.counter\[2\]$_DFFE_PP_ clknet_leaf_101_clk_net
+ _03057_ _01256_ VSS VSS VDD VDD network.neuron_in248.counter\[2\]
+ sky130_fd_sc_hd__edfxtp_1
Xnetwork.neuron_in248.counter\[3\]$_DFFE_PP_ clknet_leaf_101_clk_net
+ _03058_ _01256_ VSS VSS VDD VDD network.neuron_in248.counter\[3\]
+ sky130_fd_sc_hd__edfxtp_1
Xnetwork.neuron_in248.spike$_SDFFE_PP0P_ clknet_leaf_103_clk_net
+ _01890_ VSS VSS VDD VDD network.in_spk08_15 sky130_fd_sc_hd__dfxtp_1
Xnetwork.neuron_in249.counter\[0\]$_DFFE_PP_ clknet_leaf_103_clk_net
+ _03059_ _01255_ VSS VSS VDD VDD network.neuron_in249.counter\[0\]
+ sky130_fd_sc_hd__edfxtp_1
Xnetwork.neuron_in249.counter\[1\]$_DFFE_PP_ clknet_leaf_103_clk_net
+ _03060_ _01255_ VSS VSS VDD VDD network.neuron_in249.counter\[1\]
+ sky130_fd_sc_hd__edfxtp_1
Xnetwork.neuron_in249.counter\[2\]$_DFFE_PP_ clknet_leaf_102_clk_net
+ _03061_ _01255_ VSS VSS VDD VDD network.neuron_in249.counter\[2\]
+ sky130_fd_sc_hd__edfxtp_1
Xnetwork.neuron_in249.counter\[3\]$_DFFE_PP_ clknet_leaf_102_clk_net
+ _03062_ _01255_ VSS VSS VDD VDD network.neuron_in249.counter\[3\]
+ sky130_fd_sc_hd__edfxtp_1
Xnetwork.neuron_in249.spike$_SDFFE_PP0P_ clknet_leaf_108_clk_net
+ _01891_ VSS VSS VDD VDD network.in_spk09_15 sky130_fd_sc_hd__dfxtp_1
Xnetwork.neuron_in250.counter\[0\]$_DFFE_PP_ clknet_leaf_108_clk_net
+ _03063_ _01254_ VSS VSS VDD VDD network.neuron_in250.counter\[0\]
+ sky130_fd_sc_hd__edfxtp_1
Xnetwork.neuron_in250.counter\[1\]$_DFFE_PP_ clknet_leaf_108_clk_net
+ _03064_ _01254_ VSS VSS VDD VDD network.neuron_in250.counter\[1\]
+ sky130_fd_sc_hd__edfxtp_1
Xnetwork.neuron_in250.counter\[2\]$_DFFE_PP_ clknet_leaf_111_clk_net
+ _03065_ _01254_ VSS VSS VDD VDD network.neuron_in250.counter\[2\]
+ sky130_fd_sc_hd__edfxtp_1
Xnetwork.neuron_in250.counter\[3\]$_DFFE_PP_ clknet_leaf_111_clk_net
+ _03066_ _01254_ VSS VSS VDD VDD network.neuron_in250.counter\[3\]
+ sky130_fd_sc_hd__edfxtp_1
Xnetwork.neuron_in250.spike$_SDFFE_PP0P_ clknet_leaf_108_clk_net
+ _01893_ VSS VSS VDD VDD network.in_spk10_15 sky130_fd_sc_hd__dfxtp_1
Xnetwork.neuron_in251.counter\[0\]$_DFFE_PP_ clknet_leaf_115_clk_net
+ _03067_ _01253_ VSS VSS VDD VDD network.neuron_in251.counter\[0\]
+ sky130_fd_sc_hd__edfxtp_1
Xnetwork.neuron_in251.counter\[1\]$_DFFE_PP_ clknet_leaf_115_clk_net
+ _03068_ _01253_ VSS VSS VDD VDD network.neuron_in251.counter\[1\]
+ sky130_fd_sc_hd__edfxtp_1
Xnetwork.neuron_in251.counter\[2\]$_DFFE_PP_ clknet_leaf_110_clk_net
+ _03069_ _01253_ VSS VSS VDD VDD network.neuron_in251.counter\[2\]
+ sky130_fd_sc_hd__edfxtp_1
Xnetwork.neuron_in251.counter\[3\]$_DFFE_PP_ clknet_leaf_110_clk_net
+ _03070_ _01253_ VSS VSS VDD VDD network.neuron_in251.counter\[3\]
+ sky130_fd_sc_hd__edfxtp_1
Xnetwork.neuron_in251.spike$_SDFFE_PP0P_ clknet_leaf_109_clk_net
+ _01894_ VSS VSS VDD VDD network.in_spk11_15 sky130_fd_sc_hd__dfxtp_1
Xnetwork.neuron_in252.counter\[0\]$_DFFE_PP_ clknet_leaf_111_clk_net
+ _03071_ _01252_ VSS VSS VDD VDD network.neuron_in252.counter\[0\]
+ sky130_fd_sc_hd__edfxtp_1
Xnetwork.neuron_in252.counter\[1\]$_DFFE_PP_ clknet_leaf_111_clk_net
+ _03072_ _01252_ VSS VSS VDD VDD network.neuron_in252.counter\[1\]
+ sky130_fd_sc_hd__edfxtp_1
Xnetwork.neuron_in252.counter\[2\]$_DFFE_PP_ clknet_leaf_112_clk_net
+ _03073_ _01252_ VSS VSS VDD VDD network.neuron_in252.counter\[2\]
+ sky130_fd_sc_hd__edfxtp_1
Xnetwork.neuron_in252.counter\[3\]$_DFFE_PP_ clknet_leaf_111_clk_net
+ _03074_ _01252_ VSS VSS VDD VDD network.neuron_in252.counter\[3\]
+ sky130_fd_sc_hd__edfxtp_1
Xnetwork.neuron_in252.spike$_SDFFE_PP0P_ clknet_leaf_110_clk_net
+ _01896_ VSS VSS VDD VDD network.in_spk12_15 sky130_fd_sc_hd__dfxtp_1
Xnetwork.neuron_in253.counter\[0\]$_DFFE_PP_ clknet_leaf_111_clk_net
+ _03075_ _01251_ VSS VSS VDD VDD network.neuron_in253.counter\[0\]
+ sky130_fd_sc_hd__edfxtp_1
Xnetwork.neuron_in253.counter\[1\]$_DFFE_PP_ clknet_leaf_111_clk_net
+ _03076_ _01251_ VSS VSS VDD VDD network.neuron_in253.counter\[1\]
+ sky130_fd_sc_hd__edfxtp_1
Xnetwork.neuron_in253.counter\[2\]$_DFFE_PP_ clknet_leaf_111_clk_net
+ _03077_ _01251_ VSS VSS VDD VDD network.neuron_in253.counter\[2\]
+ sky130_fd_sc_hd__edfxtp_1
Xnetwork.neuron_in253.counter\[3\]$_DFFE_PP_ clknet_leaf_110_clk_net
+ _03078_ _01251_ VSS VSS VDD VDD network.neuron_in253.counter\[3\]
+ sky130_fd_sc_hd__edfxtp_1
Xnetwork.neuron_in253.spike$_SDFFE_PP0P_ clknet_leaf_109_clk_net
+ _01897_ VSS VSS VDD VDD network.in_spk13_15 sky130_fd_sc_hd__dfxtp_1
Xnetwork.neuron_in254.counter\[0\]$_DFFE_PP_ clknet_leaf_114_clk_net
+ _03079_ _01250_ VSS VSS VDD VDD network.neuron_in254.counter\[0\]
+ sky130_fd_sc_hd__edfxtp_1
Xnetwork.neuron_in254.counter\[1\]$_DFFE_PP_ clknet_leaf_114_clk_net
+ _03080_ _01250_ VSS VSS VDD VDD network.neuron_in254.counter\[1\]
+ sky130_fd_sc_hd__edfxtp_1
Xnetwork.neuron_in254.counter\[2\]$_DFFE_PP_ clknet_leaf_115_clk_net
+ _03081_ _01250_ VSS VSS VDD VDD network.neuron_in254.counter\[2\]
+ sky130_fd_sc_hd__edfxtp_1
Xnetwork.neuron_in254.counter\[3\]$_DFFE_PP_ clknet_leaf_115_clk_net
+ _03082_ _01250_ VSS VSS VDD VDD network.neuron_in254.counter\[3\]
+ sky130_fd_sc_hd__edfxtp_1
Xnetwork.neuron_in254.spike$_SDFFE_PP0P_ clknet_leaf_109_clk_net
+ _01899_ VSS VSS VDD VDD network.in_spk14_15 sky130_fd_sc_hd__dfxtp_1
Xnetwork.neuron_in255.counter\[0\]$_DFFE_PP_ clknet_leaf_109_clk_net
+ _03083_ _01249_ VSS VSS VDD VDD network.neuron_in255.counter\[0\]
+ sky130_fd_sc_hd__edfxtp_1
Xnetwork.neuron_in255.counter\[1\]$_DFFE_PP_ clknet_leaf_109_clk_net
+ _03084_ _01249_ VSS VSS VDD VDD network.neuron_in255.counter\[1\]
+ sky130_fd_sc_hd__edfxtp_1
Xnetwork.neuron_in255.counter\[2\]$_DFFE_PP_ clknet_leaf_103_clk_net
+ _03085_ _01249_ VSS VSS VDD VDD network.neuron_in255.counter\[2\]
+ sky130_fd_sc_hd__edfxtp_1
Xnetwork.neuron_in255.counter\[3\]$_DFFE_PP_ clknet_leaf_109_clk_net
+ _03086_ _01249_ VSS VSS VDD VDD network.neuron_in255.counter\[3\]
+ sky130_fd_sc_hd__edfxtp_1
Xnetwork.neuron_in255.spike$_SDFFE_PP0P_ clknet_leaf_109_clk_net
+ _01900_ VSS VSS VDD VDD network.in_spk15_15 sky130_fd_sc_hd__dfxtp_1
Xnetwork.neuron_out0.IF0.membrane_potential\[0\]$_SDFF_PP0_
+ clknet_leaf_132_clk_net _01624_ VSS VSS VDD VDD network.neuron_out0.IF0.membrane_potential\[0\]
+ sky130_fd_sc_hd__dfxtp_1
Xnetwork.neuron_out0.IF0.membrane_potential\[10\]$_SDFF_PP0_
+ clknet_leaf_130_clk_net net VSS VSS VDD VDD network.neuron_out0.IF0.membrane_potential\[10\]
+ sky130_fd_sc_hd__dfxtp_1
Xnetwork.neuron_out0.IF0.membrane_potential\[1\]$_SDFF_PP0_
+ clknet_leaf_132_clk_net _01623_ VSS VSS VDD VDD network.neuron_out0.IF0.membrane_potential\[1\]
+ sky130_fd_sc_hd__dfxtp_1
Xnetwork.neuron_out0.IF0.membrane_potential\[2\]$_SDFF_PP0_
+ clknet_leaf_132_clk_net _01622_ VSS VSS VDD VDD network.neuron_out0.IF0.membrane_potential\[2\]
+ sky130_fd_sc_hd__dfxtp_1
Xnetwork.neuron_out0.IF0.membrane_potential\[3\]$_SDFF_PP0_
+ clknet_leaf_132_clk_net _01621_ VSS VSS VDD VDD network.neuron_out0.IF0.membrane_potential\[3\]
+ sky130_fd_sc_hd__dfxtp_1
Xnetwork.neuron_out0.IF0.membrane_potential\[4\]$_SDFF_PP0_
+ clknet_leaf_130_clk_net _01620_ VSS VSS VDD VDD network.neuron_out0.IF0.membrane_potential\[4\]
+ sky130_fd_sc_hd__dfxtp_1
Xnetwork.neuron_out0.IF0.membrane_potential\[5\]$_SDFF_PP0_
+ clknet_leaf_129_clk_net _01619_ VSS VSS VDD VDD network.neuron_out0.IF0.membrane_potential\[5\]
+ sky130_fd_sc_hd__dfxtp_1
Xnetwork.neuron_out0.IF0.membrane_potential\[6\]$_SDFF_PP0_
+ clknet_leaf_129_clk_net _01618_ VSS VSS VDD VDD network.neuron_out0.IF0.membrane_potential\[6\]
+ sky130_fd_sc_hd__dfxtp_1
Xnetwork.neuron_out0.IF0.membrane_potential\[7\]$_SDFF_PP0_
+ clknet_leaf_130_clk_net _01617_ VSS VSS VDD VDD network.neuron_out0.IF0.membrane_potential\[7\]
+ sky130_fd_sc_hd__dfxtp_1
Xnetwork.neuron_out0.IF0.membrane_potential\[8\]$_SDFF_PP0_
+ clknet_leaf_130_clk_net net1 VSS VSS VDD VDD network.neuron_out0.IF0.membrane_potential\[8\]
+ sky130_fd_sc_hd__dfxtp_1
Xnetwork.neuron_out0.IF0.membrane_potential\[9\]$_SDFF_PP0_
+ clknet_leaf_130_clk_net net2 VSS VSS VDD VDD network.neuron_out0.IF0.membrane_potential\[9\]
+ sky130_fd_sc_hd__dfxtp_1
Xnetwork.neuron_out0.IF_in\[0\]$_SDFF_PP0_ clknet_leaf_132_clk_net
+ _01525_ VSS VSS VDD VDD network.neuron_out0.IF0.input_current\[0\]
+ sky130_fd_sc_hd__dfxtp_1
Xnetwork.neuron_out0.IF_in\[1\]$_SDFF_PP0_ clknet_leaf_132_clk_net
+ _01524_ VSS VSS VDD VDD network.neuron_out0.IF0.input_current\[1\]
+ sky130_fd_sc_hd__dfxtp_1
Xnetwork.neuron_out0.IF_in\[2\]$_SDFF_PP0_ clknet_leaf_130_clk_net
+ _01523_ VSS VSS VDD VDD network.neuron_out0.IF0.input_current\[2\]
+ sky130_fd_sc_hd__dfxtp_1
Xnetwork.neuron_out0.IF_in\[3\]$_SDFF_PP0_ clknet_leaf_132_clk_net
+ _01522_ VSS VSS VDD VDD network.neuron_out0.IF0.input_current\[3\]
+ sky130_fd_sc_hd__dfxtp_1
Xnetwork.neuron_out0.IF_in\[4\]$_SDFF_PP0_ clknet_leaf_129_clk_net
+ _01521_ VSS VSS VDD VDD network.neuron_out0.IF0.input_current\[4\]
+ sky130_fd_sc_hd__dfxtp_1
Xnetwork.neuron_out0.IF_in\[5\]$_SDFF_PP0_ clknet_leaf_129_clk_net
+ _01766_ VSS VSS VDD VDD network.neuron_out0.IF0.input_current\[5\]
+ sky130_fd_sc_hd__dfxtp_1
Xnetwork.neuron_out1.IF0.membrane_potential\[0\]$_SDFF_PP0_
+ clknet_leaf_134_clk_net _01616_ VSS VSS VDD VDD network.neuron_out1.IF0.membrane_potential\[0\]
+ sky130_fd_sc_hd__dfxtp_1
Xnetwork.neuron_out1.IF0.membrane_potential\[10\]$_SDFF_PP0_
+ clknet_leaf_136_clk_net net3 VSS VSS VDD VDD network.neuron_out1.IF0.membrane_potential\[10\]
+ sky130_fd_sc_hd__dfxtp_1
Xnetwork.neuron_out1.IF0.membrane_potential\[1\]$_SDFF_PP0_
+ clknet_leaf_134_clk_net _01615_ VSS VSS VDD VDD network.neuron_out1.IF0.membrane_potential\[1\]
+ sky130_fd_sc_hd__dfxtp_1
Xnetwork.neuron_out1.IF0.membrane_potential\[2\]$_SDFF_PP0_
+ clknet_leaf_134_clk_net _01614_ VSS VSS VDD VDD network.neuron_out1.IF0.membrane_potential\[2\]
+ sky130_fd_sc_hd__dfxtp_1
Xnetwork.neuron_out1.IF0.membrane_potential\[3\]$_SDFF_PP0_
+ clknet_leaf_137_clk_net _01613_ VSS VSS VDD VDD network.neuron_out1.IF0.membrane_potential\[3\]
+ sky130_fd_sc_hd__dfxtp_1
Xnetwork.neuron_out1.IF0.membrane_potential\[4\]$_SDFF_PP0_
+ clknet_leaf_137_clk_net _01612_ VSS VSS VDD VDD network.neuron_out1.IF0.membrane_potential\[4\]
+ sky130_fd_sc_hd__dfxtp_1
Xnetwork.neuron_out1.IF0.membrane_potential\[5\]$_SDFF_PP0_
+ clknet_leaf_137_clk_net _01611_ VSS VSS VDD VDD network.neuron_out1.IF0.membrane_potential\[5\]
+ sky130_fd_sc_hd__dfxtp_1
Xnetwork.neuron_out1.IF0.membrane_potential\[6\]$_SDFF_PP0_
+ clknet_leaf_137_clk_net _01610_ VSS VSS VDD VDD network.neuron_out1.IF0.membrane_potential\[6\]
+ sky130_fd_sc_hd__dfxtp_1
Xnetwork.neuron_out1.IF0.membrane_potential\[7\]$_SDFF_PP0_
+ clknet_leaf_137_clk_net _01609_ VSS VSS VDD VDD network.neuron_out1.IF0.membrane_potential\[7\]
+ sky130_fd_sc_hd__dfxtp_1
Xnetwork.neuron_out1.IF0.membrane_potential\[8\]$_SDFF_PP0_
+ clknet_leaf_137_clk_net net4 VSS VSS VDD VDD network.neuron_out1.IF0.membrane_potential\[8\]
+ sky130_fd_sc_hd__dfxtp_1
Xnetwork.neuron_out1.IF0.membrane_potential\[9\]$_SDFF_PP0_
+ clknet_leaf_136_clk_net net5 VSS VSS VDD VDD network.neuron_out1.IF0.membrane_potential\[9\]
+ sky130_fd_sc_hd__dfxtp_1
Xnetwork.neuron_out1.IF_in\[0\]$_SDFF_PP0_ clknet_leaf_134_clk_net
+ _01529_ VSS VSS VDD VDD network.neuron_out1.IF0.input_current\[0\]
+ sky130_fd_sc_hd__dfxtp_1
Xnetwork.neuron_out1.IF_in\[1\]$_SDFF_PP0_ clknet_leaf_134_clk_net
+ _01528_ VSS VSS VDD VDD network.neuron_out1.IF0.input_current\[1\]
+ sky130_fd_sc_hd__dfxtp_1
Xnetwork.neuron_out1.IF_in\[2\]$_SDFF_PP0_ clknet_leaf_134_clk_net
+ _01527_ VSS VSS VDD VDD network.neuron_out1.IF0.input_current\[2\]
+ sky130_fd_sc_hd__dfxtp_1
Xnetwork.neuron_out1.IF_in\[3\]$_SDFF_PP0_ clknet_leaf_134_clk_net
+ _01526_ VSS VSS VDD VDD network.neuron_out1.IF0.input_current\[3\]
+ sky130_fd_sc_hd__dfxtp_1
Xnetwork.neuron_out1.IF_in\[4\]$_SDFF_PP0_ clknet_leaf_134_clk_net
+ _01765_ VSS VSS VDD VDD network.neuron_out1.IF0.input_current\[4\]
+ sky130_fd_sc_hd__dfxtp_1
Xnetwork.neuron_out2.IF0.membrane_potential\[0\]$_SDFF_PP0_
+ clknet_leaf_129_clk_net _01608_ VSS VSS VDD VDD network.neuron_out2.IF0.membrane_potential\[0\]
+ sky130_fd_sc_hd__dfxtp_1
Xnetwork.neuron_out2.IF0.membrane_potential\[10\]$_SDFF_PP0_
+ clknet_leaf_128_clk_net net6 VSS VSS VDD VDD network.neuron_out2.IF0.membrane_potential\[10\]
+ sky130_fd_sc_hd__dfxtp_1
Xnetwork.neuron_out2.IF0.membrane_potential\[1\]$_SDFF_PP0_
+ clknet_leaf_134_clk_net _01607_ VSS VSS VDD VDD network.neuron_out2.IF0.membrane_potential\[1\]
+ sky130_fd_sc_hd__dfxtp_1
Xnetwork.neuron_out2.IF0.membrane_potential\[2\]$_SDFF_PP0_
+ clknet_leaf_129_clk_net _01606_ VSS VSS VDD VDD network.neuron_out2.IF0.membrane_potential\[2\]
+ sky130_fd_sc_hd__dfxtp_1
Xnetwork.neuron_out2.IF0.membrane_potential\[3\]$_SDFF_PP0_
+ clknet_leaf_129_clk_net _01605_ VSS VSS VDD VDD network.neuron_out2.IF0.membrane_potential\[3\]
+ sky130_fd_sc_hd__dfxtp_1
Xnetwork.neuron_out2.IF0.membrane_potential\[4\]$_SDFF_PP0_
+ clknet_leaf_129_clk_net _01604_ VSS VSS VDD VDD network.neuron_out2.IF0.membrane_potential\[4\]
+ sky130_fd_sc_hd__dfxtp_1
Xnetwork.neuron_out2.IF0.membrane_potential\[5\]$_SDFF_PP0_
+ clknet_leaf_127_clk_net _01603_ VSS VSS VDD VDD network.neuron_out2.IF0.membrane_potential\[5\]
+ sky130_fd_sc_hd__dfxtp_1
Xnetwork.neuron_out2.IF0.membrane_potential\[6\]$_SDFF_PP0_
+ clknet_leaf_127_clk_net _01602_ VSS VSS VDD VDD network.neuron_out2.IF0.membrane_potential\[6\]
+ sky130_fd_sc_hd__dfxtp_1
Xnetwork.neuron_out2.IF0.membrane_potential\[7\]$_SDFF_PP0_
+ clknet_leaf_128_clk_net _01601_ VSS VSS VDD VDD network.neuron_out2.IF0.membrane_potential\[7\]
+ sky130_fd_sc_hd__dfxtp_1
Xnetwork.neuron_out2.IF0.membrane_potential\[8\]$_SDFF_PP0_
+ clknet_leaf_128_clk_net net7 VSS VSS VDD VDD network.neuron_out2.IF0.membrane_potential\[8\]
+ sky130_fd_sc_hd__dfxtp_1
Xnetwork.neuron_out2.IF0.membrane_potential\[9\]$_SDFF_PP0_
+ clknet_leaf_128_clk_net net8 VSS VSS VDD VDD network.neuron_out2.IF0.membrane_potential\[9\]
+ sky130_fd_sc_hd__dfxtp_1
Xnetwork.neuron_out2.IF_in\[0\]$_SDFF_PP0_ clknet_leaf_133_clk_net
+ _01533_ VSS VSS VDD VDD network.neuron_out2.IF0.input_current\[0\]
+ sky130_fd_sc_hd__dfxtp_1
Xnetwork.neuron_out2.IF_in\[1\]$_SDFF_PP0_ clknet_leaf_133_clk_net
+ _01532_ VSS VSS VDD VDD network.neuron_out2.IF0.input_current\[1\]
+ sky130_fd_sc_hd__dfxtp_1
Xnetwork.neuron_out2.IF_in\[2\]$_SDFF_PP0_ clknet_leaf_133_clk_net
+ _01531_ VSS VSS VDD VDD network.neuron_out2.IF0.input_current\[2\]
+ sky130_fd_sc_hd__dfxtp_1
Xnetwork.neuron_out2.IF_in\[3\]$_SDFF_PP0_ clknet_leaf_133_clk_net
+ _01530_ VSS VSS VDD VDD network.neuron_out2.IF0.input_current\[3\]
+ sky130_fd_sc_hd__dfxtp_1
Xnetwork.neuron_out2.IF_in\[4\]$_SDFF_PP0_ clknet_leaf_129_clk_net
+ _01762_ VSS VSS VDD VDD network.neuron_out2.IF0.input_current\[4\]
+ sky130_fd_sc_hd__dfxtp_1
Xnetwork.neuron_out3.IF0.membrane_potential\[0\]$_SDFF_PP0_
+ clknet_leaf_132_clk_net _01600_ VSS VSS VDD VDD network.neuron_out3.IF0.membrane_potential\[0\]
+ sky130_fd_sc_hd__dfxtp_1
Xnetwork.neuron_out3.IF0.membrane_potential\[10\]$_SDFF_PP0_
+ clknet_leaf_135_clk_net net9 VSS VSS VDD VDD network.neuron_out3.IF0.membrane_potential\[10\]
+ sky130_fd_sc_hd__dfxtp_1
Xnetwork.neuron_out3.IF0.membrane_potential\[1\]$_SDFF_PP0_
+ clknet_leaf_132_clk_net _01599_ VSS VSS VDD VDD network.neuron_out3.IF0.membrane_potential\[1\]
+ sky130_fd_sc_hd__dfxtp_1
Xnetwork.neuron_out3.IF0.membrane_potential\[2\]$_SDFF_PP0_
+ clknet_leaf_133_clk_net _01598_ VSS VSS VDD VDD network.neuron_out3.IF0.membrane_potential\[2\]
+ sky130_fd_sc_hd__dfxtp_1
Xnetwork.neuron_out3.IF0.membrane_potential\[3\]$_SDFF_PP0_
+ clknet_leaf_133_clk_net _01597_ VSS VSS VDD VDD network.neuron_out3.IF0.membrane_potential\[3\]
+ sky130_fd_sc_hd__dfxtp_1
Xnetwork.neuron_out3.IF0.membrane_potential\[4\]$_SDFF_PP0_
+ clknet_leaf_135_clk_net _01596_ VSS VSS VDD VDD network.neuron_out3.IF0.membrane_potential\[4\]
+ sky130_fd_sc_hd__dfxtp_1
Xnetwork.neuron_out3.IF0.membrane_potential\[5\]$_SDFF_PP0_
+ clknet_leaf_135_clk_net _01595_ VSS VSS VDD VDD network.neuron_out3.IF0.membrane_potential\[5\]
+ sky130_fd_sc_hd__dfxtp_1
Xnetwork.neuron_out3.IF0.membrane_potential\[6\]$_SDFF_PP0_
+ clknet_leaf_135_clk_net _01594_ VSS VSS VDD VDD network.neuron_out3.IF0.membrane_potential\[6\]
+ sky130_fd_sc_hd__dfxtp_1
Xnetwork.neuron_out3.IF0.membrane_potential\[7\]$_SDFF_PP0_
+ clknet_leaf_135_clk_net _01593_ VSS VSS VDD VDD network.neuron_out3.IF0.membrane_potential\[7\]
+ sky130_fd_sc_hd__dfxtp_1
Xnetwork.neuron_out3.IF0.membrane_potential\[8\]$_SDFF_PP0_
+ clknet_leaf_135_clk_net net10 VSS VSS VDD VDD network.neuron_out3.IF0.membrane_potential\[8\]
+ sky130_fd_sc_hd__dfxtp_1
Xnetwork.neuron_out3.IF0.membrane_potential\[9\]$_SDFF_PP0_
+ clknet_leaf_135_clk_net net11 VSS VSS VDD VDD network.neuron_out3.IF0.membrane_potential\[9\]
+ sky130_fd_sc_hd__dfxtp_1
Xnetwork.neuron_out3.IF_in\[0\]$_SDFF_PP0_ clknet_leaf_132_clk_net
+ _01537_ VSS VSS VDD VDD network.neuron_out3.IF0.input_current\[0\]
+ sky130_fd_sc_hd__dfxtp_1
Xnetwork.neuron_out3.IF_in\[1\]$_SDFF_PP0_ clknet_leaf_133_clk_net
+ _01536_ VSS VSS VDD VDD network.neuron_out3.IF0.input_current\[1\]
+ sky130_fd_sc_hd__dfxtp_1
Xnetwork.neuron_out3.IF_in\[2\]$_SDFF_PP0_ clknet_leaf_133_clk_net
+ _01535_ VSS VSS VDD VDD network.neuron_out3.IF0.input_current\[2\]
+ sky130_fd_sc_hd__dfxtp_1
Xnetwork.neuron_out3.IF_in\[3\]$_SDFF_PP0_ clknet_leaf_133_clk_net
+ _01534_ VSS VSS VDD VDD network.neuron_out3.IF0.input_current\[3\]
+ sky130_fd_sc_hd__dfxtp_1
Xnetwork.neuron_out3.IF_in\[4\]$_SDFF_PP0_ clknet_leaf_135_clk_net
+ _01761_ VSS VSS VDD VDD network.neuron_out3.IF0.input_current\[4\]
+ sky130_fd_sc_hd__dfxtp_1
Xnetwork.neuron_out4.IF0.membrane_potential\[0\]$_SDFF_PP0_
+ clknet_leaf_136_clk_net _01592_ VSS VSS VDD VDD network.neuron_out4.IF0.membrane_potential\[0\]
+ sky130_fd_sc_hd__dfxtp_1
Xnetwork.neuron_out4.IF0.membrane_potential\[10\]$_SDFF_PP0_
+ clknet_leaf_136_clk_net net12 VSS VSS VDD VDD network.neuron_out4.IF0.membrane_potential\[10\]
+ sky130_fd_sc_hd__dfxtp_1
Xnetwork.neuron_out4.IF0.membrane_potential\[1\]$_SDFF_PP0_
+ clknet_leaf_136_clk_net _01591_ VSS VSS VDD VDD network.neuron_out4.IF0.membrane_potential\[1\]
+ sky130_fd_sc_hd__dfxtp_1
Xnetwork.neuron_out4.IF0.membrane_potential\[2\]$_SDFF_PP0_
+ clknet_leaf_134_clk_net _01590_ VSS VSS VDD VDD network.neuron_out4.IF0.membrane_potential\[2\]
+ sky130_fd_sc_hd__dfxtp_1
Xnetwork.neuron_out4.IF0.membrane_potential\[3\]$_SDFF_PP0_
+ clknet_leaf_134_clk_net _01589_ VSS VSS VDD VDD network.neuron_out4.IF0.membrane_potential\[3\]
+ sky130_fd_sc_hd__dfxtp_1
Xnetwork.neuron_out4.IF0.membrane_potential\[4\]$_SDFF_PP0_
+ clknet_leaf_136_clk_net _01588_ VSS VSS VDD VDD network.neuron_out4.IF0.membrane_potential\[4\]
+ sky130_fd_sc_hd__dfxtp_1
Xnetwork.neuron_out4.IF0.membrane_potential\[5\]$_SDFF_PP0_
+ clknet_leaf_136_clk_net _01587_ VSS VSS VDD VDD network.neuron_out4.IF0.membrane_potential\[5\]
+ sky130_fd_sc_hd__dfxtp_1
Xnetwork.neuron_out4.IF0.membrane_potential\[6\]$_SDFF_PP0_
+ clknet_leaf_136_clk_net _01586_ VSS VSS VDD VDD network.neuron_out4.IF0.membrane_potential\[6\]
+ sky130_fd_sc_hd__dfxtp_1
Xnetwork.neuron_out4.IF0.membrane_potential\[7\]$_SDFF_PP0_
+ clknet_leaf_136_clk_net _01585_ VSS VSS VDD VDD network.neuron_out4.IF0.membrane_potential\[7\]
+ sky130_fd_sc_hd__dfxtp_1
Xnetwork.neuron_out4.IF0.membrane_potential\[8\]$_SDFF_PP0_
+ clknet_leaf_136_clk_net net13 VSS VSS VDD VDD network.neuron_out4.IF0.membrane_potential\[8\]
+ sky130_fd_sc_hd__dfxtp_1
Xnetwork.neuron_out4.IF0.membrane_potential\[9\]$_SDFF_PP0_
+ clknet_leaf_136_clk_net net14 VSS VSS VDD VDD network.neuron_out4.IF0.membrane_potential\[9\]
+ sky130_fd_sc_hd__dfxtp_1
Xnetwork.neuron_out4.IF_in\[1\]$_SDFF_PP0_ clknet_leaf_135_clk_net
+ _01539_ VSS VSS VDD VDD network.neuron_out4.IF0.input_current\[1\]
+ sky130_fd_sc_hd__dfxtp_1
Xnetwork.neuron_out4.IF_in\[3\]$_SDFF_PP0_ clknet_leaf_134_clk_net
+ _01538_ VSS VSS VDD VDD network.neuron_out4.IF0.input_current\[0\]
+ sky130_fd_sc_hd__dfxtp_1
Xnetwork.neuron_out4.IF_in\[4\]$_SDFF_PP0_ clknet_leaf_135_clk_net
+ _01760_ VSS VSS VDD VDD network.neuron_out4.IF0.input_current\[4\]
+ sky130_fd_sc_hd__dfxtp_1
Xnetwork.neuron_out5.IF0.membrane_potential\[0\]$_SDFF_PP0_
+ clknet_leaf_131_clk_net _01584_ VSS VSS VDD VDD network.neuron_out5.IF0.membrane_potential\[0\]
+ sky130_fd_sc_hd__dfxtp_1
Xnetwork.neuron_out5.IF0.membrane_potential\[10\]$_SDFF_PP0_
+ clknet_leaf_123_clk_net net15 VSS VSS VDD VDD network.neuron_out5.IF0.membrane_potential\[10\]
+ sky130_fd_sc_hd__dfxtp_1
Xnetwork.neuron_out5.IF0.membrane_potential\[1\]$_SDFF_PP0_
+ clknet_leaf_131_clk_net _01583_ VSS VSS VDD VDD network.neuron_out5.IF0.membrane_potential\[1\]
+ sky130_fd_sc_hd__dfxtp_1
Xnetwork.neuron_out5.IF0.membrane_potential\[2\]$_SDFF_PP0_
+ clknet_leaf_131_clk_net _01582_ VSS VSS VDD VDD network.neuron_out5.IF0.membrane_potential\[2\]
+ sky130_fd_sc_hd__dfxtp_1
Xnetwork.neuron_out5.IF0.membrane_potential\[3\]$_SDFF_PP0_
+ clknet_leaf_123_clk_net _01581_ VSS VSS VDD VDD network.neuron_out5.IF0.membrane_potential\[3\]
+ sky130_fd_sc_hd__dfxtp_1
Xnetwork.neuron_out5.IF0.membrane_potential\[4\]$_SDFF_PP0_
+ clknet_leaf_123_clk_net _01580_ VSS VSS VDD VDD network.neuron_out5.IF0.membrane_potential\[4\]
+ sky130_fd_sc_hd__dfxtp_1
Xnetwork.neuron_out5.IF0.membrane_potential\[5\]$_SDFF_PP0_
+ clknet_leaf_123_clk_net _01579_ VSS VSS VDD VDD network.neuron_out5.IF0.membrane_potential\[5\]
+ sky130_fd_sc_hd__dfxtp_1
Xnetwork.neuron_out5.IF0.membrane_potential\[6\]$_SDFF_PP0_
+ clknet_leaf_123_clk_net _01578_ VSS VSS VDD VDD network.neuron_out5.IF0.membrane_potential\[6\]
+ sky130_fd_sc_hd__dfxtp_1
Xnetwork.neuron_out5.IF0.membrane_potential\[7\]$_SDFF_PP0_
+ clknet_leaf_123_clk_net _01577_ VSS VSS VDD VDD network.neuron_out5.IF0.membrane_potential\[7\]
+ sky130_fd_sc_hd__dfxtp_1
Xnetwork.neuron_out5.IF0.membrane_potential\[8\]$_SDFF_PP0_
+ clknet_leaf_123_clk_net net16 VSS VSS VDD VDD network.neuron_out5.IF0.membrane_potential\[8\]
+ sky130_fd_sc_hd__dfxtp_1
Xnetwork.neuron_out5.IF0.membrane_potential\[9\]$_SDFF_PP0_
+ clknet_leaf_123_clk_net net17 VSS VSS VDD VDD network.neuron_out5.IF0.membrane_potential\[9\]
+ sky130_fd_sc_hd__dfxtp_1
Xnetwork.neuron_out5.IF_in\[0\]$_SDFF_PP0_ clknet_leaf_131_clk_net
+ _01545_ VSS VSS VDD VDD network.neuron_out5.IF0.input_current\[0\]
+ sky130_fd_sc_hd__dfxtp_1
Xnetwork.neuron_out5.IF_in\[1\]$_SDFF_PP0_ clknet_leaf_131_clk_net
+ _01544_ VSS VSS VDD VDD network.neuron_out5.IF0.input_current\[1\]
+ sky130_fd_sc_hd__dfxtp_1
Xnetwork.neuron_out5.IF_in\[3\]$_SDFF_PP0_ clknet_leaf_131_clk_net
+ _01543_ VSS VSS VDD VDD network.neuron_out5.IF0.input_current\[3\]
+ sky130_fd_sc_hd__dfxtp_1
Xnetwork.neuron_out5.IF_in\[4\]$_SDFF_PP0_ clknet_leaf_131_clk_net
+ _01542_ VSS VSS VDD VDD network.neuron_out5.IF0.input_current\[4\]
+ sky130_fd_sc_hd__dfxtp_1
Xnetwork.neuron_out5.IF_in\[5\]$_SDFF_PP0_ clknet_leaf_131_clk_net
+ _01541_ VSS VSS VDD VDD network.neuron_out5.IF0.input_current\[5\]
+ sky130_fd_sc_hd__dfxtp_1
Xnetwork.neuron_out5.IF_in\[6\]$_SDFF_PP0_ clknet_leaf_131_clk_net
+ _01755_ VSS VSS VDD VDD network.neuron_out5.IF0.input_current\[6\]
+ sky130_fd_sc_hd__dfxtp_1
Xnetwork.out_controller.addr_out\[0\]$_SDFF_PP0_ clknet_leaf_122_clk_net
+ _01626_ VSS VSS VDD VDD network.neuron_out0.ROM0.address\[0\]
+ sky130_fd_sc_hd__dfxtp_1
Xnetwork.out_controller.addr_out\[1\]$_SDFF_PP0_ clknet_leaf_124_clk_net
+ _01625_ VSS VSS VDD VDD network.neuron_out0.ROM0.address\[1\]
+ sky130_fd_sc_hd__dfxtp_1
Xnetwork.out_controller.addr_out\[2\]$_SDFF_PP0_ clknet_leaf_121_clk_net
+ _01940_ VSS VSS VDD VDD network.neuron_out0.ROM0.address\[2\]
+ sky130_fd_sc_hd__dfxtp_1
Xnetwork.out_controller.spike_out$_SDFF_PP0_ clknet_leaf_124_clk_net
+ _01943_ VSS VSS VDD VDD network.neuron_out0.ROM0.read_en sky130_fd_sc_hd__dfxtp_1
Xno_spike$_SDFFE_PP0P_ clknet_2_3__leaf_clk_regs _01952_ VSS
+ VSS VDD VDD net45 sky130_fd_sc_hd__dfxtp_1
Xresult_class\[0\]$_SDFFE_PP1P_ clknet_2_2__leaf_clk_regs
+ _01549_ VSS VSS VDD VDD net46 sky130_fd_sc_hd__dfxtp_1
Xresult_class\[1\]$_SDFFE_PP1P_ clknet_2_2__leaf_clk_regs
+ _01956_ VSS VSS VDD VDD net47 sky130_fd_sc_hd__dfxtp_1
Xstate\[0\]$_SDFFE_PP0P_ clknet_2_0__leaf_clk_regs _01573_
+ VSS VSS VDD VDD state\[0\] sky130_fd_sc_hd__dfxtp_1
Xstate\[1\]$_SDFFE_PP0P_ clknet_2_0__leaf_clk_regs _01951_
+ VSS VSS VDD VDD state\[1\] sky130_fd_sc_hd__dfxtp_1
Xnetwork.neuron_out0.IF0.membrane_potential\[10\]$_SDFF_PP0__1
+ VSS VSS VDD VDD _unconnected_37 net sky130_fd_sc_hd__conb_1
Xnetwork.neuron_out0.IF0.membrane_potential\[8\]$_SDFF_PP0__2
+ VSS VSS VDD VDD _unconnected_38 net1 sky130_fd_sc_hd__conb_1
Xnetwork.neuron_out0.IF0.membrane_potential\[9\]$_SDFF_PP0__3
+ VSS VSS VDD VDD _unconnected_39 net2 sky130_fd_sc_hd__conb_1
Xnetwork.neuron_out1.IF0.membrane_potential\[10\]$_SDFF_PP0__4
+ VSS VSS VDD VDD _unconnected_40 net3 sky130_fd_sc_hd__conb_1
Xnetwork.neuron_out1.IF0.membrane_potential\[8\]$_SDFF_PP0__5
+ VSS VSS VDD VDD _unconnected_41 net4 sky130_fd_sc_hd__conb_1
Xnetwork.neuron_out1.IF0.membrane_potential\[9\]$_SDFF_PP0__6
+ VSS VSS VDD VDD _unconnected_42 net5 sky130_fd_sc_hd__conb_1
Xnetwork.neuron_out2.IF0.membrane_potential\[10\]$_SDFF_PP0__7
+ VSS VSS VDD VDD _unconnected_43 net6 sky130_fd_sc_hd__conb_1
Xnetwork.neuron_out2.IF0.membrane_potential\[8\]$_SDFF_PP0__8
+ VSS VSS VDD VDD _unconnected_44 net7 sky130_fd_sc_hd__conb_1
Xnetwork.neuron_out2.IF0.membrane_potential\[9\]$_SDFF_PP0__9
+ VSS VSS VDD VDD _unconnected_45 net8 sky130_fd_sc_hd__conb_1
Xnetwork.neuron_out3.IF0.membrane_potential\[10\]$_SDFF_PP0__10
+ VSS VSS VDD VDD _unconnected_46 net9 sky130_fd_sc_hd__conb_1
Xnetwork.neuron_out3.IF0.membrane_potential\[8\]$_SDFF_PP0__11
+ VSS VSS VDD VDD _unconnected_47 net10 sky130_fd_sc_hd__conb_1
Xnetwork.neuron_out3.IF0.membrane_potential\[9\]$_SDFF_PP0__12
+ VSS VSS VDD VDD _unconnected_48 net11 sky130_fd_sc_hd__conb_1
Xnetwork.neuron_out4.IF0.membrane_potential\[10\]$_SDFF_PP0__13
+ VSS VSS VDD VDD _unconnected_49 net12 sky130_fd_sc_hd__conb_1
Xnetwork.neuron_out4.IF0.membrane_potential\[8\]$_SDFF_PP0__14
+ VSS VSS VDD VDD _unconnected_50 net13 sky130_fd_sc_hd__conb_1
Xnetwork.neuron_out4.IF0.membrane_potential\[9\]$_SDFF_PP0__15
+ VSS VSS VDD VDD _unconnected_51 net14 sky130_fd_sc_hd__conb_1
Xnetwork.neuron_out5.IF0.membrane_potential\[10\]$_SDFF_PP0__16
+ VSS VSS VDD VDD _unconnected_52 net15 sky130_fd_sc_hd__conb_1
Xnetwork.neuron_out5.IF0.membrane_potential\[8\]$_SDFF_PP0__17
+ VSS VSS VDD VDD _unconnected_53 net16 sky130_fd_sc_hd__conb_1
Xnetwork.neuron_out5.IF0.membrane_potential\[9\]$_SDFF_PP0__18
+ VSS VSS VDD VDD _unconnected_54 net17 sky130_fd_sc_hd__conb_1
XTAP_TAPCELL_ROW_0_1 VSS VDD sky130_fd_sc_hd__tapvpwrvgnd_1
XTAP_TAPCELL_ROW_0_2 VSS VDD sky130_fd_sc_hd__tapvpwrvgnd_1
XTAP_TAPCELL_ROW_0_3 VSS VDD sky130_fd_sc_hd__tapvpwrvgnd_1
XTAP_TAPCELL_ROW_0_4 VSS VDD sky130_fd_sc_hd__tapvpwrvgnd_1
XTAP_TAPCELL_ROW_0_5 VSS VDD sky130_fd_sc_hd__tapvpwrvgnd_1
XTAP_TAPCELL_ROW_0_6 VSS VDD sky130_fd_sc_hd__tapvpwrvgnd_1
XTAP_TAPCELL_ROW_0_7 VSS VDD sky130_fd_sc_hd__tapvpwrvgnd_1
XTAP_TAPCELL_ROW_0_8 VSS VDD sky130_fd_sc_hd__tapvpwrvgnd_1
XTAP_TAPCELL_ROW_0_9 VSS VDD sky130_fd_sc_hd__tapvpwrvgnd_1
XTAP_TAPCELL_ROW_0_10 VSS VDD sky130_fd_sc_hd__tapvpwrvgnd_1
XTAP_TAPCELL_ROW_0_11 VSS VDD sky130_fd_sc_hd__tapvpwrvgnd_1
XTAP_TAPCELL_ROW_0_12 VSS VDD sky130_fd_sc_hd__tapvpwrvgnd_1
XTAP_TAPCELL_ROW_0_13 VSS VDD sky130_fd_sc_hd__tapvpwrvgnd_1
XTAP_TAPCELL_ROW_0_14 VSS VDD sky130_fd_sc_hd__tapvpwrvgnd_1
XTAP_TAPCELL_ROW_0_15 VSS VDD sky130_fd_sc_hd__tapvpwrvgnd_1
XTAP_TAPCELL_ROW_0_16 VSS VDD sky130_fd_sc_hd__tapvpwrvgnd_1
XTAP_TAPCELL_ROW_0_17 VSS VDD sky130_fd_sc_hd__tapvpwrvgnd_1
XTAP_TAPCELL_ROW_0_18 VSS VDD sky130_fd_sc_hd__tapvpwrvgnd_1
XTAP_TAPCELL_ROW_0_19 VSS VDD sky130_fd_sc_hd__tapvpwrvgnd_1
XTAP_TAPCELL_ROW_0_20 VSS VDD sky130_fd_sc_hd__tapvpwrvgnd_1
XTAP_TAPCELL_ROW_0_21 VSS VDD sky130_fd_sc_hd__tapvpwrvgnd_1
XTAP_TAPCELL_ROW_0_22 VSS VDD sky130_fd_sc_hd__tapvpwrvgnd_1
XTAP_TAPCELL_ROW_0_23 VSS VDD sky130_fd_sc_hd__tapvpwrvgnd_1
XTAP_TAPCELL_ROW_0_24 VSS VDD sky130_fd_sc_hd__tapvpwrvgnd_1
XTAP_TAPCELL_ROW_0_25 VSS VDD sky130_fd_sc_hd__tapvpwrvgnd_1
XTAP_TAPCELL_ROW_0_26 VSS VDD sky130_fd_sc_hd__tapvpwrvgnd_1
XTAP_TAPCELL_ROW_0_27 VSS VDD sky130_fd_sc_hd__tapvpwrvgnd_1
XTAP_TAPCELL_ROW_0_28 VSS VDD sky130_fd_sc_hd__tapvpwrvgnd_1
XTAP_TAPCELL_ROW_0_29 VSS VDD sky130_fd_sc_hd__tapvpwrvgnd_1
XTAP_TAPCELL_ROW_0_30 VSS VDD sky130_fd_sc_hd__tapvpwrvgnd_1
XTAP_TAPCELL_ROW_0_31 VSS VDD sky130_fd_sc_hd__tapvpwrvgnd_1
XTAP_TAPCELL_ROW_0_32 VSS VDD sky130_fd_sc_hd__tapvpwrvgnd_1
XTAP_TAPCELL_ROW_0_33 VSS VDD sky130_fd_sc_hd__tapvpwrvgnd_1
XTAP_TAPCELL_ROW_0_34 VSS VDD sky130_fd_sc_hd__tapvpwrvgnd_1
XTAP_TAPCELL_ROW_0_35 VSS VDD sky130_fd_sc_hd__tapvpwrvgnd_1
XTAP_TAPCELL_ROW_0_36 VSS VDD sky130_fd_sc_hd__tapvpwrvgnd_1
XTAP_TAPCELL_ROW_0_37 VSS VDD sky130_fd_sc_hd__tapvpwrvgnd_1
XTAP_TAPCELL_ROW_0_38 VSS VDD sky130_fd_sc_hd__tapvpwrvgnd_1
XTAP_TAPCELL_ROW_0_39 VSS VDD sky130_fd_sc_hd__tapvpwrvgnd_1
XTAP_TAPCELL_ROW_0_40 VSS VDD sky130_fd_sc_hd__tapvpwrvgnd_1
XTAP_TAPCELL_ROW_0_41 VSS VDD sky130_fd_sc_hd__tapvpwrvgnd_1
XTAP_TAPCELL_ROW_0_42 VSS VDD sky130_fd_sc_hd__tapvpwrvgnd_1
XTAP_TAPCELL_ROW_1_43 VSS VDD sky130_fd_sc_hd__tapvpwrvgnd_1
XTAP_TAPCELL_ROW_1_44 VSS VDD sky130_fd_sc_hd__tapvpwrvgnd_1
XTAP_TAPCELL_ROW_1_45 VSS VDD sky130_fd_sc_hd__tapvpwrvgnd_1
XTAP_TAPCELL_ROW_1_46 VSS VDD sky130_fd_sc_hd__tapvpwrvgnd_1
XTAP_TAPCELL_ROW_1_47 VSS VDD sky130_fd_sc_hd__tapvpwrvgnd_1
XTAP_TAPCELL_ROW_1_48 VSS VDD sky130_fd_sc_hd__tapvpwrvgnd_1
XTAP_TAPCELL_ROW_1_49 VSS VDD sky130_fd_sc_hd__tapvpwrvgnd_1
XTAP_TAPCELL_ROW_1_50 VSS VDD sky130_fd_sc_hd__tapvpwrvgnd_1
XTAP_TAPCELL_ROW_1_51 VSS VDD sky130_fd_sc_hd__tapvpwrvgnd_1
XTAP_TAPCELL_ROW_1_52 VSS VDD sky130_fd_sc_hd__tapvpwrvgnd_1
XTAP_TAPCELL_ROW_1_53 VSS VDD sky130_fd_sc_hd__tapvpwrvgnd_1
XTAP_TAPCELL_ROW_1_54 VSS VDD sky130_fd_sc_hd__tapvpwrvgnd_1
XTAP_TAPCELL_ROW_1_55 VSS VDD sky130_fd_sc_hd__tapvpwrvgnd_1
XTAP_TAPCELL_ROW_1_56 VSS VDD sky130_fd_sc_hd__tapvpwrvgnd_1
XTAP_TAPCELL_ROW_1_57 VSS VDD sky130_fd_sc_hd__tapvpwrvgnd_1
XTAP_TAPCELL_ROW_1_58 VSS VDD sky130_fd_sc_hd__tapvpwrvgnd_1
XTAP_TAPCELL_ROW_1_59 VSS VDD sky130_fd_sc_hd__tapvpwrvgnd_1
XTAP_TAPCELL_ROW_1_60 VSS VDD sky130_fd_sc_hd__tapvpwrvgnd_1
XTAP_TAPCELL_ROW_1_61 VSS VDD sky130_fd_sc_hd__tapvpwrvgnd_1
XTAP_TAPCELL_ROW_1_62 VSS VDD sky130_fd_sc_hd__tapvpwrvgnd_1
XTAP_TAPCELL_ROW_1_63 VSS VDD sky130_fd_sc_hd__tapvpwrvgnd_1
XTAP_TAPCELL_ROW_2_64 VSS VDD sky130_fd_sc_hd__tapvpwrvgnd_1
XTAP_TAPCELL_ROW_2_65 VSS VDD sky130_fd_sc_hd__tapvpwrvgnd_1
XTAP_TAPCELL_ROW_2_66 VSS VDD sky130_fd_sc_hd__tapvpwrvgnd_1
XTAP_TAPCELL_ROW_2_67 VSS VDD sky130_fd_sc_hd__tapvpwrvgnd_1
XTAP_TAPCELL_ROW_2_68 VSS VDD sky130_fd_sc_hd__tapvpwrvgnd_1
XTAP_TAPCELL_ROW_2_69 VSS VDD sky130_fd_sc_hd__tapvpwrvgnd_1
XTAP_TAPCELL_ROW_2_70 VSS VDD sky130_fd_sc_hd__tapvpwrvgnd_1
XTAP_TAPCELL_ROW_2_71 VSS VDD sky130_fd_sc_hd__tapvpwrvgnd_1
XTAP_TAPCELL_ROW_2_72 VSS VDD sky130_fd_sc_hd__tapvpwrvgnd_1
XTAP_TAPCELL_ROW_2_73 VSS VDD sky130_fd_sc_hd__tapvpwrvgnd_1
XTAP_TAPCELL_ROW_2_74 VSS VDD sky130_fd_sc_hd__tapvpwrvgnd_1
XTAP_TAPCELL_ROW_2_75 VSS VDD sky130_fd_sc_hd__tapvpwrvgnd_1
XTAP_TAPCELL_ROW_2_76 VSS VDD sky130_fd_sc_hd__tapvpwrvgnd_1
XTAP_TAPCELL_ROW_2_77 VSS VDD sky130_fd_sc_hd__tapvpwrvgnd_1
XTAP_TAPCELL_ROW_2_78 VSS VDD sky130_fd_sc_hd__tapvpwrvgnd_1
XTAP_TAPCELL_ROW_2_79 VSS VDD sky130_fd_sc_hd__tapvpwrvgnd_1
XTAP_TAPCELL_ROW_2_80 VSS VDD sky130_fd_sc_hd__tapvpwrvgnd_1
XTAP_TAPCELL_ROW_2_81 VSS VDD sky130_fd_sc_hd__tapvpwrvgnd_1
XTAP_TAPCELL_ROW_2_82 VSS VDD sky130_fd_sc_hd__tapvpwrvgnd_1
XTAP_TAPCELL_ROW_2_83 VSS VDD sky130_fd_sc_hd__tapvpwrvgnd_1
XTAP_TAPCELL_ROW_2_84 VSS VDD sky130_fd_sc_hd__tapvpwrvgnd_1
XTAP_TAPCELL_ROW_2_85 VSS VDD sky130_fd_sc_hd__tapvpwrvgnd_1
XTAP_TAPCELL_ROW_3_86 VSS VDD sky130_fd_sc_hd__tapvpwrvgnd_1
XTAP_TAPCELL_ROW_3_87 VSS VDD sky130_fd_sc_hd__tapvpwrvgnd_1
XTAP_TAPCELL_ROW_3_88 VSS VDD sky130_fd_sc_hd__tapvpwrvgnd_1
XTAP_TAPCELL_ROW_3_89 VSS VDD sky130_fd_sc_hd__tapvpwrvgnd_1
XTAP_TAPCELL_ROW_3_90 VSS VDD sky130_fd_sc_hd__tapvpwrvgnd_1
XTAP_TAPCELL_ROW_3_91 VSS VDD sky130_fd_sc_hd__tapvpwrvgnd_1
XTAP_TAPCELL_ROW_3_92 VSS VDD sky130_fd_sc_hd__tapvpwrvgnd_1
XTAP_TAPCELL_ROW_3_93 VSS VDD sky130_fd_sc_hd__tapvpwrvgnd_1
XTAP_TAPCELL_ROW_3_94 VSS VDD sky130_fd_sc_hd__tapvpwrvgnd_1
XTAP_TAPCELL_ROW_3_95 VSS VDD sky130_fd_sc_hd__tapvpwrvgnd_1
XTAP_TAPCELL_ROW_3_96 VSS VDD sky130_fd_sc_hd__tapvpwrvgnd_1
XTAP_TAPCELL_ROW_3_97 VSS VDD sky130_fd_sc_hd__tapvpwrvgnd_1
XTAP_TAPCELL_ROW_3_98 VSS VDD sky130_fd_sc_hd__tapvpwrvgnd_1
XTAP_TAPCELL_ROW_3_99 VSS VDD sky130_fd_sc_hd__tapvpwrvgnd_1
XTAP_TAPCELL_ROW_3_100 VSS VDD sky130_fd_sc_hd__tapvpwrvgnd_1
XTAP_TAPCELL_ROW_3_101 VSS VDD sky130_fd_sc_hd__tapvpwrvgnd_1
XTAP_TAPCELL_ROW_3_102 VSS VDD sky130_fd_sc_hd__tapvpwrvgnd_1
XTAP_TAPCELL_ROW_3_103 VSS VDD sky130_fd_sc_hd__tapvpwrvgnd_1
XTAP_TAPCELL_ROW_3_104 VSS VDD sky130_fd_sc_hd__tapvpwrvgnd_1
XTAP_TAPCELL_ROW_3_105 VSS VDD sky130_fd_sc_hd__tapvpwrvgnd_1
XTAP_TAPCELL_ROW_3_106 VSS VDD sky130_fd_sc_hd__tapvpwrvgnd_1
XTAP_TAPCELL_ROW_4_107 VSS VDD sky130_fd_sc_hd__tapvpwrvgnd_1
XTAP_TAPCELL_ROW_4_108 VSS VDD sky130_fd_sc_hd__tapvpwrvgnd_1
XTAP_TAPCELL_ROW_4_109 VSS VDD sky130_fd_sc_hd__tapvpwrvgnd_1
XTAP_TAPCELL_ROW_4_110 VSS VDD sky130_fd_sc_hd__tapvpwrvgnd_1
XTAP_TAPCELL_ROW_4_111 VSS VDD sky130_fd_sc_hd__tapvpwrvgnd_1
XTAP_TAPCELL_ROW_4_112 VSS VDD sky130_fd_sc_hd__tapvpwrvgnd_1
XTAP_TAPCELL_ROW_4_113 VSS VDD sky130_fd_sc_hd__tapvpwrvgnd_1
XTAP_TAPCELL_ROW_4_114 VSS VDD sky130_fd_sc_hd__tapvpwrvgnd_1
XTAP_TAPCELL_ROW_4_115 VSS VDD sky130_fd_sc_hd__tapvpwrvgnd_1
XTAP_TAPCELL_ROW_4_116 VSS VDD sky130_fd_sc_hd__tapvpwrvgnd_1
XTAP_TAPCELL_ROW_4_117 VSS VDD sky130_fd_sc_hd__tapvpwrvgnd_1
XTAP_TAPCELL_ROW_4_118 VSS VDD sky130_fd_sc_hd__tapvpwrvgnd_1
XTAP_TAPCELL_ROW_4_119 VSS VDD sky130_fd_sc_hd__tapvpwrvgnd_1
XTAP_TAPCELL_ROW_4_120 VSS VDD sky130_fd_sc_hd__tapvpwrvgnd_1
XTAP_TAPCELL_ROW_4_121 VSS VDD sky130_fd_sc_hd__tapvpwrvgnd_1
XTAP_TAPCELL_ROW_4_122 VSS VDD sky130_fd_sc_hd__tapvpwrvgnd_1
XTAP_TAPCELL_ROW_4_123 VSS VDD sky130_fd_sc_hd__tapvpwrvgnd_1
XTAP_TAPCELL_ROW_4_124 VSS VDD sky130_fd_sc_hd__tapvpwrvgnd_1
XTAP_TAPCELL_ROW_4_125 VSS VDD sky130_fd_sc_hd__tapvpwrvgnd_1
XTAP_TAPCELL_ROW_4_126 VSS VDD sky130_fd_sc_hd__tapvpwrvgnd_1
XTAP_TAPCELL_ROW_4_127 VSS VDD sky130_fd_sc_hd__tapvpwrvgnd_1
XTAP_TAPCELL_ROW_4_128 VSS VDD sky130_fd_sc_hd__tapvpwrvgnd_1
XTAP_TAPCELL_ROW_5_129 VSS VDD sky130_fd_sc_hd__tapvpwrvgnd_1
XTAP_TAPCELL_ROW_5_130 VSS VDD sky130_fd_sc_hd__tapvpwrvgnd_1
XTAP_TAPCELL_ROW_5_131 VSS VDD sky130_fd_sc_hd__tapvpwrvgnd_1
XTAP_TAPCELL_ROW_5_132 VSS VDD sky130_fd_sc_hd__tapvpwrvgnd_1
XTAP_TAPCELL_ROW_5_133 VSS VDD sky130_fd_sc_hd__tapvpwrvgnd_1
XTAP_TAPCELL_ROW_5_134 VSS VDD sky130_fd_sc_hd__tapvpwrvgnd_1
XTAP_TAPCELL_ROW_5_135 VSS VDD sky130_fd_sc_hd__tapvpwrvgnd_1
XTAP_TAPCELL_ROW_5_136 VSS VDD sky130_fd_sc_hd__tapvpwrvgnd_1
XTAP_TAPCELL_ROW_5_137 VSS VDD sky130_fd_sc_hd__tapvpwrvgnd_1
XTAP_TAPCELL_ROW_5_138 VSS VDD sky130_fd_sc_hd__tapvpwrvgnd_1
XTAP_TAPCELL_ROW_5_139 VSS VDD sky130_fd_sc_hd__tapvpwrvgnd_1
XTAP_TAPCELL_ROW_5_140 VSS VDD sky130_fd_sc_hd__tapvpwrvgnd_1
XTAP_TAPCELL_ROW_5_141 VSS VDD sky130_fd_sc_hd__tapvpwrvgnd_1
XTAP_TAPCELL_ROW_5_142 VSS VDD sky130_fd_sc_hd__tapvpwrvgnd_1
XTAP_TAPCELL_ROW_5_143 VSS VDD sky130_fd_sc_hd__tapvpwrvgnd_1
XTAP_TAPCELL_ROW_5_144 VSS VDD sky130_fd_sc_hd__tapvpwrvgnd_1
XTAP_TAPCELL_ROW_5_145 VSS VDD sky130_fd_sc_hd__tapvpwrvgnd_1
XTAP_TAPCELL_ROW_5_146 VSS VDD sky130_fd_sc_hd__tapvpwrvgnd_1
XTAP_TAPCELL_ROW_5_147 VSS VDD sky130_fd_sc_hd__tapvpwrvgnd_1
XTAP_TAPCELL_ROW_5_148 VSS VDD sky130_fd_sc_hd__tapvpwrvgnd_1
XTAP_TAPCELL_ROW_5_149 VSS VDD sky130_fd_sc_hd__tapvpwrvgnd_1
XTAP_TAPCELL_ROW_6_150 VSS VDD sky130_fd_sc_hd__tapvpwrvgnd_1
XTAP_TAPCELL_ROW_6_151 VSS VDD sky130_fd_sc_hd__tapvpwrvgnd_1
XTAP_TAPCELL_ROW_6_152 VSS VDD sky130_fd_sc_hd__tapvpwrvgnd_1
XTAP_TAPCELL_ROW_6_153 VSS VDD sky130_fd_sc_hd__tapvpwrvgnd_1
XTAP_TAPCELL_ROW_6_154 VSS VDD sky130_fd_sc_hd__tapvpwrvgnd_1
XTAP_TAPCELL_ROW_6_155 VSS VDD sky130_fd_sc_hd__tapvpwrvgnd_1
XTAP_TAPCELL_ROW_6_156 VSS VDD sky130_fd_sc_hd__tapvpwrvgnd_1
XTAP_TAPCELL_ROW_6_157 VSS VDD sky130_fd_sc_hd__tapvpwrvgnd_1
XTAP_TAPCELL_ROW_6_158 VSS VDD sky130_fd_sc_hd__tapvpwrvgnd_1
XTAP_TAPCELL_ROW_6_159 VSS VDD sky130_fd_sc_hd__tapvpwrvgnd_1
XTAP_TAPCELL_ROW_6_160 VSS VDD sky130_fd_sc_hd__tapvpwrvgnd_1
XTAP_TAPCELL_ROW_6_161 VSS VDD sky130_fd_sc_hd__tapvpwrvgnd_1
XTAP_TAPCELL_ROW_6_162 VSS VDD sky130_fd_sc_hd__tapvpwrvgnd_1
XTAP_TAPCELL_ROW_6_163 VSS VDD sky130_fd_sc_hd__tapvpwrvgnd_1
XTAP_TAPCELL_ROW_6_164 VSS VDD sky130_fd_sc_hd__tapvpwrvgnd_1
XTAP_TAPCELL_ROW_6_165 VSS VDD sky130_fd_sc_hd__tapvpwrvgnd_1
XTAP_TAPCELL_ROW_6_166 VSS VDD sky130_fd_sc_hd__tapvpwrvgnd_1
XTAP_TAPCELL_ROW_6_167 VSS VDD sky130_fd_sc_hd__tapvpwrvgnd_1
XTAP_TAPCELL_ROW_6_168 VSS VDD sky130_fd_sc_hd__tapvpwrvgnd_1
XTAP_TAPCELL_ROW_6_169 VSS VDD sky130_fd_sc_hd__tapvpwrvgnd_1
XTAP_TAPCELL_ROW_6_170 VSS VDD sky130_fd_sc_hd__tapvpwrvgnd_1
XTAP_TAPCELL_ROW_6_171 VSS VDD sky130_fd_sc_hd__tapvpwrvgnd_1
XTAP_TAPCELL_ROW_7_172 VSS VDD sky130_fd_sc_hd__tapvpwrvgnd_1
XTAP_TAPCELL_ROW_7_173 VSS VDD sky130_fd_sc_hd__tapvpwrvgnd_1
XTAP_TAPCELL_ROW_7_174 VSS VDD sky130_fd_sc_hd__tapvpwrvgnd_1
XTAP_TAPCELL_ROW_7_175 VSS VDD sky130_fd_sc_hd__tapvpwrvgnd_1
XTAP_TAPCELL_ROW_7_176 VSS VDD sky130_fd_sc_hd__tapvpwrvgnd_1
XTAP_TAPCELL_ROW_7_177 VSS VDD sky130_fd_sc_hd__tapvpwrvgnd_1
XTAP_TAPCELL_ROW_7_178 VSS VDD sky130_fd_sc_hd__tapvpwrvgnd_1
XTAP_TAPCELL_ROW_7_179 VSS VDD sky130_fd_sc_hd__tapvpwrvgnd_1
XTAP_TAPCELL_ROW_7_180 VSS VDD sky130_fd_sc_hd__tapvpwrvgnd_1
XTAP_TAPCELL_ROW_7_181 VSS VDD sky130_fd_sc_hd__tapvpwrvgnd_1
XTAP_TAPCELL_ROW_7_182 VSS VDD sky130_fd_sc_hd__tapvpwrvgnd_1
XTAP_TAPCELL_ROW_7_183 VSS VDD sky130_fd_sc_hd__tapvpwrvgnd_1
XTAP_TAPCELL_ROW_7_184 VSS VDD sky130_fd_sc_hd__tapvpwrvgnd_1
XTAP_TAPCELL_ROW_7_185 VSS VDD sky130_fd_sc_hd__tapvpwrvgnd_1
XTAP_TAPCELL_ROW_7_186 VSS VDD sky130_fd_sc_hd__tapvpwrvgnd_1
XTAP_TAPCELL_ROW_7_187 VSS VDD sky130_fd_sc_hd__tapvpwrvgnd_1
XTAP_TAPCELL_ROW_7_188 VSS VDD sky130_fd_sc_hd__tapvpwrvgnd_1
XTAP_TAPCELL_ROW_7_189 VSS VDD sky130_fd_sc_hd__tapvpwrvgnd_1
XTAP_TAPCELL_ROW_7_190 VSS VDD sky130_fd_sc_hd__tapvpwrvgnd_1
XTAP_TAPCELL_ROW_7_191 VSS VDD sky130_fd_sc_hd__tapvpwrvgnd_1
XTAP_TAPCELL_ROW_7_192 VSS VDD sky130_fd_sc_hd__tapvpwrvgnd_1
XTAP_TAPCELL_ROW_8_193 VSS VDD sky130_fd_sc_hd__tapvpwrvgnd_1
XTAP_TAPCELL_ROW_8_194 VSS VDD sky130_fd_sc_hd__tapvpwrvgnd_1
XTAP_TAPCELL_ROW_8_195 VSS VDD sky130_fd_sc_hd__tapvpwrvgnd_1
XTAP_TAPCELL_ROW_8_196 VSS VDD sky130_fd_sc_hd__tapvpwrvgnd_1
XTAP_TAPCELL_ROW_8_197 VSS VDD sky130_fd_sc_hd__tapvpwrvgnd_1
XTAP_TAPCELL_ROW_8_198 VSS VDD sky130_fd_sc_hd__tapvpwrvgnd_1
XTAP_TAPCELL_ROW_8_199 VSS VDD sky130_fd_sc_hd__tapvpwrvgnd_1
XTAP_TAPCELL_ROW_8_200 VSS VDD sky130_fd_sc_hd__tapvpwrvgnd_1
XTAP_TAPCELL_ROW_8_201 VSS VDD sky130_fd_sc_hd__tapvpwrvgnd_1
XTAP_TAPCELL_ROW_8_202 VSS VDD sky130_fd_sc_hd__tapvpwrvgnd_1
XTAP_TAPCELL_ROW_8_203 VSS VDD sky130_fd_sc_hd__tapvpwrvgnd_1
XTAP_TAPCELL_ROW_8_204 VSS VDD sky130_fd_sc_hd__tapvpwrvgnd_1
XTAP_TAPCELL_ROW_8_205 VSS VDD sky130_fd_sc_hd__tapvpwrvgnd_1
XTAP_TAPCELL_ROW_8_206 VSS VDD sky130_fd_sc_hd__tapvpwrvgnd_1
XTAP_TAPCELL_ROW_8_207 VSS VDD sky130_fd_sc_hd__tapvpwrvgnd_1
XTAP_TAPCELL_ROW_8_208 VSS VDD sky130_fd_sc_hd__tapvpwrvgnd_1
XTAP_TAPCELL_ROW_8_209 VSS VDD sky130_fd_sc_hd__tapvpwrvgnd_1
XTAP_TAPCELL_ROW_8_210 VSS VDD sky130_fd_sc_hd__tapvpwrvgnd_1
XTAP_TAPCELL_ROW_8_211 VSS VDD sky130_fd_sc_hd__tapvpwrvgnd_1
XTAP_TAPCELL_ROW_8_212 VSS VDD sky130_fd_sc_hd__tapvpwrvgnd_1
XTAP_TAPCELL_ROW_8_213 VSS VDD sky130_fd_sc_hd__tapvpwrvgnd_1
XTAP_TAPCELL_ROW_8_214 VSS VDD sky130_fd_sc_hd__tapvpwrvgnd_1
XTAP_TAPCELL_ROW_9_215 VSS VDD sky130_fd_sc_hd__tapvpwrvgnd_1
XTAP_TAPCELL_ROW_9_216 VSS VDD sky130_fd_sc_hd__tapvpwrvgnd_1
XTAP_TAPCELL_ROW_9_217 VSS VDD sky130_fd_sc_hd__tapvpwrvgnd_1
XTAP_TAPCELL_ROW_9_218 VSS VDD sky130_fd_sc_hd__tapvpwrvgnd_1
XTAP_TAPCELL_ROW_9_219 VSS VDD sky130_fd_sc_hd__tapvpwrvgnd_1
XTAP_TAPCELL_ROW_9_220 VSS VDD sky130_fd_sc_hd__tapvpwrvgnd_1
XTAP_TAPCELL_ROW_9_221 VSS VDD sky130_fd_sc_hd__tapvpwrvgnd_1
XTAP_TAPCELL_ROW_9_222 VSS VDD sky130_fd_sc_hd__tapvpwrvgnd_1
XTAP_TAPCELL_ROW_9_223 VSS VDD sky130_fd_sc_hd__tapvpwrvgnd_1
XTAP_TAPCELL_ROW_9_224 VSS VDD sky130_fd_sc_hd__tapvpwrvgnd_1
XTAP_TAPCELL_ROW_9_225 VSS VDD sky130_fd_sc_hd__tapvpwrvgnd_1
XTAP_TAPCELL_ROW_9_226 VSS VDD sky130_fd_sc_hd__tapvpwrvgnd_1
XTAP_TAPCELL_ROW_9_227 VSS VDD sky130_fd_sc_hd__tapvpwrvgnd_1
XTAP_TAPCELL_ROW_9_228 VSS VDD sky130_fd_sc_hd__tapvpwrvgnd_1
XTAP_TAPCELL_ROW_9_229 VSS VDD sky130_fd_sc_hd__tapvpwrvgnd_1
XTAP_TAPCELL_ROW_9_230 VSS VDD sky130_fd_sc_hd__tapvpwrvgnd_1
XTAP_TAPCELL_ROW_9_231 VSS VDD sky130_fd_sc_hd__tapvpwrvgnd_1
XTAP_TAPCELL_ROW_9_232 VSS VDD sky130_fd_sc_hd__tapvpwrvgnd_1
XTAP_TAPCELL_ROW_9_233 VSS VDD sky130_fd_sc_hd__tapvpwrvgnd_1
XTAP_TAPCELL_ROW_9_234 VSS VDD sky130_fd_sc_hd__tapvpwrvgnd_1
XTAP_TAPCELL_ROW_9_235 VSS VDD sky130_fd_sc_hd__tapvpwrvgnd_1
XTAP_TAPCELL_ROW_10_236 VSS VDD sky130_fd_sc_hd__tapvpwrvgnd_1
XTAP_TAPCELL_ROW_10_237 VSS VDD sky130_fd_sc_hd__tapvpwrvgnd_1
XTAP_TAPCELL_ROW_10_238 VSS VDD sky130_fd_sc_hd__tapvpwrvgnd_1
XTAP_TAPCELL_ROW_10_239 VSS VDD sky130_fd_sc_hd__tapvpwrvgnd_1
XTAP_TAPCELL_ROW_10_240 VSS VDD sky130_fd_sc_hd__tapvpwrvgnd_1
XTAP_TAPCELL_ROW_10_241 VSS VDD sky130_fd_sc_hd__tapvpwrvgnd_1
XTAP_TAPCELL_ROW_10_242 VSS VDD sky130_fd_sc_hd__tapvpwrvgnd_1
XTAP_TAPCELL_ROW_10_243 VSS VDD sky130_fd_sc_hd__tapvpwrvgnd_1
XTAP_TAPCELL_ROW_10_244 VSS VDD sky130_fd_sc_hd__tapvpwrvgnd_1
XTAP_TAPCELL_ROW_10_245 VSS VDD sky130_fd_sc_hd__tapvpwrvgnd_1
XTAP_TAPCELL_ROW_10_246 VSS VDD sky130_fd_sc_hd__tapvpwrvgnd_1
XTAP_TAPCELL_ROW_10_247 VSS VDD sky130_fd_sc_hd__tapvpwrvgnd_1
XTAP_TAPCELL_ROW_10_248 VSS VDD sky130_fd_sc_hd__tapvpwrvgnd_1
XTAP_TAPCELL_ROW_10_249 VSS VDD sky130_fd_sc_hd__tapvpwrvgnd_1
XTAP_TAPCELL_ROW_10_250 VSS VDD sky130_fd_sc_hd__tapvpwrvgnd_1
XTAP_TAPCELL_ROW_10_251 VSS VDD sky130_fd_sc_hd__tapvpwrvgnd_1
XTAP_TAPCELL_ROW_10_252 VSS VDD sky130_fd_sc_hd__tapvpwrvgnd_1
XTAP_TAPCELL_ROW_10_253 VSS VDD sky130_fd_sc_hd__tapvpwrvgnd_1
XTAP_TAPCELL_ROW_10_254 VSS VDD sky130_fd_sc_hd__tapvpwrvgnd_1
XTAP_TAPCELL_ROW_10_255 VSS VDD sky130_fd_sc_hd__tapvpwrvgnd_1
XTAP_TAPCELL_ROW_10_256 VSS VDD sky130_fd_sc_hd__tapvpwrvgnd_1
XTAP_TAPCELL_ROW_10_257 VSS VDD sky130_fd_sc_hd__tapvpwrvgnd_1
XTAP_TAPCELL_ROW_11_258 VSS VDD sky130_fd_sc_hd__tapvpwrvgnd_1
XTAP_TAPCELL_ROW_11_259 VSS VDD sky130_fd_sc_hd__tapvpwrvgnd_1
XTAP_TAPCELL_ROW_11_260 VSS VDD sky130_fd_sc_hd__tapvpwrvgnd_1
XTAP_TAPCELL_ROW_11_261 VSS VDD sky130_fd_sc_hd__tapvpwrvgnd_1
XTAP_TAPCELL_ROW_11_262 VSS VDD sky130_fd_sc_hd__tapvpwrvgnd_1
XTAP_TAPCELL_ROW_11_263 VSS VDD sky130_fd_sc_hd__tapvpwrvgnd_1
XTAP_TAPCELL_ROW_11_264 VSS VDD sky130_fd_sc_hd__tapvpwrvgnd_1
XTAP_TAPCELL_ROW_11_265 VSS VDD sky130_fd_sc_hd__tapvpwrvgnd_1
XTAP_TAPCELL_ROW_11_266 VSS VDD sky130_fd_sc_hd__tapvpwrvgnd_1
XTAP_TAPCELL_ROW_11_267 VSS VDD sky130_fd_sc_hd__tapvpwrvgnd_1
XTAP_TAPCELL_ROW_11_268 VSS VDD sky130_fd_sc_hd__tapvpwrvgnd_1
XTAP_TAPCELL_ROW_11_269 VSS VDD sky130_fd_sc_hd__tapvpwrvgnd_1
XTAP_TAPCELL_ROW_11_270 VSS VDD sky130_fd_sc_hd__tapvpwrvgnd_1
XTAP_TAPCELL_ROW_11_271 VSS VDD sky130_fd_sc_hd__tapvpwrvgnd_1
XTAP_TAPCELL_ROW_11_272 VSS VDD sky130_fd_sc_hd__tapvpwrvgnd_1
XTAP_TAPCELL_ROW_11_273 VSS VDD sky130_fd_sc_hd__tapvpwrvgnd_1
XTAP_TAPCELL_ROW_11_274 VSS VDD sky130_fd_sc_hd__tapvpwrvgnd_1
XTAP_TAPCELL_ROW_11_275 VSS VDD sky130_fd_sc_hd__tapvpwrvgnd_1
XTAP_TAPCELL_ROW_11_276 VSS VDD sky130_fd_sc_hd__tapvpwrvgnd_1
XTAP_TAPCELL_ROW_11_277 VSS VDD sky130_fd_sc_hd__tapvpwrvgnd_1
XTAP_TAPCELL_ROW_11_278 VSS VDD sky130_fd_sc_hd__tapvpwrvgnd_1
XTAP_TAPCELL_ROW_12_279 VSS VDD sky130_fd_sc_hd__tapvpwrvgnd_1
XTAP_TAPCELL_ROW_12_280 VSS VDD sky130_fd_sc_hd__tapvpwrvgnd_1
XTAP_TAPCELL_ROW_12_281 VSS VDD sky130_fd_sc_hd__tapvpwrvgnd_1
XTAP_TAPCELL_ROW_12_282 VSS VDD sky130_fd_sc_hd__tapvpwrvgnd_1
XTAP_TAPCELL_ROW_12_283 VSS VDD sky130_fd_sc_hd__tapvpwrvgnd_1
XTAP_TAPCELL_ROW_12_284 VSS VDD sky130_fd_sc_hd__tapvpwrvgnd_1
XTAP_TAPCELL_ROW_12_285 VSS VDD sky130_fd_sc_hd__tapvpwrvgnd_1
XTAP_TAPCELL_ROW_12_286 VSS VDD sky130_fd_sc_hd__tapvpwrvgnd_1
XTAP_TAPCELL_ROW_12_287 VSS VDD sky130_fd_sc_hd__tapvpwrvgnd_1
XTAP_TAPCELL_ROW_12_288 VSS VDD sky130_fd_sc_hd__tapvpwrvgnd_1
XTAP_TAPCELL_ROW_12_289 VSS VDD sky130_fd_sc_hd__tapvpwrvgnd_1
XTAP_TAPCELL_ROW_12_290 VSS VDD sky130_fd_sc_hd__tapvpwrvgnd_1
XTAP_TAPCELL_ROW_12_291 VSS VDD sky130_fd_sc_hd__tapvpwrvgnd_1
XTAP_TAPCELL_ROW_12_292 VSS VDD sky130_fd_sc_hd__tapvpwrvgnd_1
XTAP_TAPCELL_ROW_12_293 VSS VDD sky130_fd_sc_hd__tapvpwrvgnd_1
XTAP_TAPCELL_ROW_12_294 VSS VDD sky130_fd_sc_hd__tapvpwrvgnd_1
XTAP_TAPCELL_ROW_12_295 VSS VDD sky130_fd_sc_hd__tapvpwrvgnd_1
XTAP_TAPCELL_ROW_12_296 VSS VDD sky130_fd_sc_hd__tapvpwrvgnd_1
XTAP_TAPCELL_ROW_12_297 VSS VDD sky130_fd_sc_hd__tapvpwrvgnd_1
XTAP_TAPCELL_ROW_12_298 VSS VDD sky130_fd_sc_hd__tapvpwrvgnd_1
XTAP_TAPCELL_ROW_12_299 VSS VDD sky130_fd_sc_hd__tapvpwrvgnd_1
XTAP_TAPCELL_ROW_12_300 VSS VDD sky130_fd_sc_hd__tapvpwrvgnd_1
XTAP_TAPCELL_ROW_13_301 VSS VDD sky130_fd_sc_hd__tapvpwrvgnd_1
XTAP_TAPCELL_ROW_13_302 VSS VDD sky130_fd_sc_hd__tapvpwrvgnd_1
XTAP_TAPCELL_ROW_13_303 VSS VDD sky130_fd_sc_hd__tapvpwrvgnd_1
XTAP_TAPCELL_ROW_13_304 VSS VDD sky130_fd_sc_hd__tapvpwrvgnd_1
XTAP_TAPCELL_ROW_13_305 VSS VDD sky130_fd_sc_hd__tapvpwrvgnd_1
XTAP_TAPCELL_ROW_13_306 VSS VDD sky130_fd_sc_hd__tapvpwrvgnd_1
XTAP_TAPCELL_ROW_13_307 VSS VDD sky130_fd_sc_hd__tapvpwrvgnd_1
XTAP_TAPCELL_ROW_13_308 VSS VDD sky130_fd_sc_hd__tapvpwrvgnd_1
XTAP_TAPCELL_ROW_13_309 VSS VDD sky130_fd_sc_hd__tapvpwrvgnd_1
XTAP_TAPCELL_ROW_13_310 VSS VDD sky130_fd_sc_hd__tapvpwrvgnd_1
XTAP_TAPCELL_ROW_13_311 VSS VDD sky130_fd_sc_hd__tapvpwrvgnd_1
XTAP_TAPCELL_ROW_13_312 VSS VDD sky130_fd_sc_hd__tapvpwrvgnd_1
XTAP_TAPCELL_ROW_13_313 VSS VDD sky130_fd_sc_hd__tapvpwrvgnd_1
XTAP_TAPCELL_ROW_13_314 VSS VDD sky130_fd_sc_hd__tapvpwrvgnd_1
XTAP_TAPCELL_ROW_13_315 VSS VDD sky130_fd_sc_hd__tapvpwrvgnd_1
XTAP_TAPCELL_ROW_13_316 VSS VDD sky130_fd_sc_hd__tapvpwrvgnd_1
XTAP_TAPCELL_ROW_13_317 VSS VDD sky130_fd_sc_hd__tapvpwrvgnd_1
XTAP_TAPCELL_ROW_13_318 VSS VDD sky130_fd_sc_hd__tapvpwrvgnd_1
XTAP_TAPCELL_ROW_13_319 VSS VDD sky130_fd_sc_hd__tapvpwrvgnd_1
XTAP_TAPCELL_ROW_13_320 VSS VDD sky130_fd_sc_hd__tapvpwrvgnd_1
XTAP_TAPCELL_ROW_13_321 VSS VDD sky130_fd_sc_hd__tapvpwrvgnd_1
XTAP_TAPCELL_ROW_14_322 VSS VDD sky130_fd_sc_hd__tapvpwrvgnd_1
XTAP_TAPCELL_ROW_14_323 VSS VDD sky130_fd_sc_hd__tapvpwrvgnd_1
XTAP_TAPCELL_ROW_14_324 VSS VDD sky130_fd_sc_hd__tapvpwrvgnd_1
XTAP_TAPCELL_ROW_14_325 VSS VDD sky130_fd_sc_hd__tapvpwrvgnd_1
XTAP_TAPCELL_ROW_14_326 VSS VDD sky130_fd_sc_hd__tapvpwrvgnd_1
XTAP_TAPCELL_ROW_14_327 VSS VDD sky130_fd_sc_hd__tapvpwrvgnd_1
XTAP_TAPCELL_ROW_14_328 VSS VDD sky130_fd_sc_hd__tapvpwrvgnd_1
XTAP_TAPCELL_ROW_14_329 VSS VDD sky130_fd_sc_hd__tapvpwrvgnd_1
XTAP_TAPCELL_ROW_14_330 VSS VDD sky130_fd_sc_hd__tapvpwrvgnd_1
XTAP_TAPCELL_ROW_14_331 VSS VDD sky130_fd_sc_hd__tapvpwrvgnd_1
XTAP_TAPCELL_ROW_14_332 VSS VDD sky130_fd_sc_hd__tapvpwrvgnd_1
XTAP_TAPCELL_ROW_14_333 VSS VDD sky130_fd_sc_hd__tapvpwrvgnd_1
XTAP_TAPCELL_ROW_14_334 VSS VDD sky130_fd_sc_hd__tapvpwrvgnd_1
XTAP_TAPCELL_ROW_14_335 VSS VDD sky130_fd_sc_hd__tapvpwrvgnd_1
XTAP_TAPCELL_ROW_14_336 VSS VDD sky130_fd_sc_hd__tapvpwrvgnd_1
XTAP_TAPCELL_ROW_14_337 VSS VDD sky130_fd_sc_hd__tapvpwrvgnd_1
XTAP_TAPCELL_ROW_14_338 VSS VDD sky130_fd_sc_hd__tapvpwrvgnd_1
XTAP_TAPCELL_ROW_14_339 VSS VDD sky130_fd_sc_hd__tapvpwrvgnd_1
XTAP_TAPCELL_ROW_14_340 VSS VDD sky130_fd_sc_hd__tapvpwrvgnd_1
XTAP_TAPCELL_ROW_14_341 VSS VDD sky130_fd_sc_hd__tapvpwrvgnd_1
XTAP_TAPCELL_ROW_14_342 VSS VDD sky130_fd_sc_hd__tapvpwrvgnd_1
XTAP_TAPCELL_ROW_14_343 VSS VDD sky130_fd_sc_hd__tapvpwrvgnd_1
XTAP_TAPCELL_ROW_15_344 VSS VDD sky130_fd_sc_hd__tapvpwrvgnd_1
XTAP_TAPCELL_ROW_15_345 VSS VDD sky130_fd_sc_hd__tapvpwrvgnd_1
XTAP_TAPCELL_ROW_15_346 VSS VDD sky130_fd_sc_hd__tapvpwrvgnd_1
XTAP_TAPCELL_ROW_15_347 VSS VDD sky130_fd_sc_hd__tapvpwrvgnd_1
XTAP_TAPCELL_ROW_15_348 VSS VDD sky130_fd_sc_hd__tapvpwrvgnd_1
XTAP_TAPCELL_ROW_15_349 VSS VDD sky130_fd_sc_hd__tapvpwrvgnd_1
XTAP_TAPCELL_ROW_15_350 VSS VDD sky130_fd_sc_hd__tapvpwrvgnd_1
XTAP_TAPCELL_ROW_15_351 VSS VDD sky130_fd_sc_hd__tapvpwrvgnd_1
XTAP_TAPCELL_ROW_15_352 VSS VDD sky130_fd_sc_hd__tapvpwrvgnd_1
XTAP_TAPCELL_ROW_15_353 VSS VDD sky130_fd_sc_hd__tapvpwrvgnd_1
XTAP_TAPCELL_ROW_15_354 VSS VDD sky130_fd_sc_hd__tapvpwrvgnd_1
XTAP_TAPCELL_ROW_15_355 VSS VDD sky130_fd_sc_hd__tapvpwrvgnd_1
XTAP_TAPCELL_ROW_15_356 VSS VDD sky130_fd_sc_hd__tapvpwrvgnd_1
XTAP_TAPCELL_ROW_15_357 VSS VDD sky130_fd_sc_hd__tapvpwrvgnd_1
XTAP_TAPCELL_ROW_15_358 VSS VDD sky130_fd_sc_hd__tapvpwrvgnd_1
XTAP_TAPCELL_ROW_15_359 VSS VDD sky130_fd_sc_hd__tapvpwrvgnd_1
XTAP_TAPCELL_ROW_15_360 VSS VDD sky130_fd_sc_hd__tapvpwrvgnd_1
XTAP_TAPCELL_ROW_15_361 VSS VDD sky130_fd_sc_hd__tapvpwrvgnd_1
XTAP_TAPCELL_ROW_15_362 VSS VDD sky130_fd_sc_hd__tapvpwrvgnd_1
XTAP_TAPCELL_ROW_15_363 VSS VDD sky130_fd_sc_hd__tapvpwrvgnd_1
XTAP_TAPCELL_ROW_15_364 VSS VDD sky130_fd_sc_hd__tapvpwrvgnd_1
XTAP_TAPCELL_ROW_16_365 VSS VDD sky130_fd_sc_hd__tapvpwrvgnd_1
XTAP_TAPCELL_ROW_16_366 VSS VDD sky130_fd_sc_hd__tapvpwrvgnd_1
XTAP_TAPCELL_ROW_16_367 VSS VDD sky130_fd_sc_hd__tapvpwrvgnd_1
XTAP_TAPCELL_ROW_16_368 VSS VDD sky130_fd_sc_hd__tapvpwrvgnd_1
XTAP_TAPCELL_ROW_16_369 VSS VDD sky130_fd_sc_hd__tapvpwrvgnd_1
XTAP_TAPCELL_ROW_16_370 VSS VDD sky130_fd_sc_hd__tapvpwrvgnd_1
XTAP_TAPCELL_ROW_16_371 VSS VDD sky130_fd_sc_hd__tapvpwrvgnd_1
XTAP_TAPCELL_ROW_16_372 VSS VDD sky130_fd_sc_hd__tapvpwrvgnd_1
XTAP_TAPCELL_ROW_16_373 VSS VDD sky130_fd_sc_hd__tapvpwrvgnd_1
XTAP_TAPCELL_ROW_16_374 VSS VDD sky130_fd_sc_hd__tapvpwrvgnd_1
XTAP_TAPCELL_ROW_16_375 VSS VDD sky130_fd_sc_hd__tapvpwrvgnd_1
XTAP_TAPCELL_ROW_16_376 VSS VDD sky130_fd_sc_hd__tapvpwrvgnd_1
XTAP_TAPCELL_ROW_16_377 VSS VDD sky130_fd_sc_hd__tapvpwrvgnd_1
XTAP_TAPCELL_ROW_16_378 VSS VDD sky130_fd_sc_hd__tapvpwrvgnd_1
XTAP_TAPCELL_ROW_16_379 VSS VDD sky130_fd_sc_hd__tapvpwrvgnd_1
XTAP_TAPCELL_ROW_16_380 VSS VDD sky130_fd_sc_hd__tapvpwrvgnd_1
XTAP_TAPCELL_ROW_16_381 VSS VDD sky130_fd_sc_hd__tapvpwrvgnd_1
XTAP_TAPCELL_ROW_16_382 VSS VDD sky130_fd_sc_hd__tapvpwrvgnd_1
XTAP_TAPCELL_ROW_16_383 VSS VDD sky130_fd_sc_hd__tapvpwrvgnd_1
XTAP_TAPCELL_ROW_16_384 VSS VDD sky130_fd_sc_hd__tapvpwrvgnd_1
XTAP_TAPCELL_ROW_16_385 VSS VDD sky130_fd_sc_hd__tapvpwrvgnd_1
XTAP_TAPCELL_ROW_16_386 VSS VDD sky130_fd_sc_hd__tapvpwrvgnd_1
XTAP_TAPCELL_ROW_17_387 VSS VDD sky130_fd_sc_hd__tapvpwrvgnd_1
XTAP_TAPCELL_ROW_17_388 VSS VDD sky130_fd_sc_hd__tapvpwrvgnd_1
XTAP_TAPCELL_ROW_17_389 VSS VDD sky130_fd_sc_hd__tapvpwrvgnd_1
XTAP_TAPCELL_ROW_17_390 VSS VDD sky130_fd_sc_hd__tapvpwrvgnd_1
XTAP_TAPCELL_ROW_17_391 VSS VDD sky130_fd_sc_hd__tapvpwrvgnd_1
XTAP_TAPCELL_ROW_17_392 VSS VDD sky130_fd_sc_hd__tapvpwrvgnd_1
XTAP_TAPCELL_ROW_17_393 VSS VDD sky130_fd_sc_hd__tapvpwrvgnd_1
XTAP_TAPCELL_ROW_17_394 VSS VDD sky130_fd_sc_hd__tapvpwrvgnd_1
XTAP_TAPCELL_ROW_17_395 VSS VDD sky130_fd_sc_hd__tapvpwrvgnd_1
XTAP_TAPCELL_ROW_17_396 VSS VDD sky130_fd_sc_hd__tapvpwrvgnd_1
XTAP_TAPCELL_ROW_17_397 VSS VDD sky130_fd_sc_hd__tapvpwrvgnd_1
XTAP_TAPCELL_ROW_17_398 VSS VDD sky130_fd_sc_hd__tapvpwrvgnd_1
XTAP_TAPCELL_ROW_17_399 VSS VDD sky130_fd_sc_hd__tapvpwrvgnd_1
XTAP_TAPCELL_ROW_17_400 VSS VDD sky130_fd_sc_hd__tapvpwrvgnd_1
XTAP_TAPCELL_ROW_17_401 VSS VDD sky130_fd_sc_hd__tapvpwrvgnd_1
XTAP_TAPCELL_ROW_17_402 VSS VDD sky130_fd_sc_hd__tapvpwrvgnd_1
XTAP_TAPCELL_ROW_17_403 VSS VDD sky130_fd_sc_hd__tapvpwrvgnd_1
XTAP_TAPCELL_ROW_17_404 VSS VDD sky130_fd_sc_hd__tapvpwrvgnd_1
XTAP_TAPCELL_ROW_17_405 VSS VDD sky130_fd_sc_hd__tapvpwrvgnd_1
XTAP_TAPCELL_ROW_17_406 VSS VDD sky130_fd_sc_hd__tapvpwrvgnd_1
XTAP_TAPCELL_ROW_17_407 VSS VDD sky130_fd_sc_hd__tapvpwrvgnd_1
XTAP_TAPCELL_ROW_18_408 VSS VDD sky130_fd_sc_hd__tapvpwrvgnd_1
XTAP_TAPCELL_ROW_18_409 VSS VDD sky130_fd_sc_hd__tapvpwrvgnd_1
XTAP_TAPCELL_ROW_18_410 VSS VDD sky130_fd_sc_hd__tapvpwrvgnd_1
XTAP_TAPCELL_ROW_18_411 VSS VDD sky130_fd_sc_hd__tapvpwrvgnd_1
XTAP_TAPCELL_ROW_18_412 VSS VDD sky130_fd_sc_hd__tapvpwrvgnd_1
XTAP_TAPCELL_ROW_18_413 VSS VDD sky130_fd_sc_hd__tapvpwrvgnd_1
XTAP_TAPCELL_ROW_18_414 VSS VDD sky130_fd_sc_hd__tapvpwrvgnd_1
XTAP_TAPCELL_ROW_18_415 VSS VDD sky130_fd_sc_hd__tapvpwrvgnd_1
XTAP_TAPCELL_ROW_18_416 VSS VDD sky130_fd_sc_hd__tapvpwrvgnd_1
XTAP_TAPCELL_ROW_18_417 VSS VDD sky130_fd_sc_hd__tapvpwrvgnd_1
XTAP_TAPCELL_ROW_18_418 VSS VDD sky130_fd_sc_hd__tapvpwrvgnd_1
XTAP_TAPCELL_ROW_18_419 VSS VDD sky130_fd_sc_hd__tapvpwrvgnd_1
XTAP_TAPCELL_ROW_18_420 VSS VDD sky130_fd_sc_hd__tapvpwrvgnd_1
XTAP_TAPCELL_ROW_18_421 VSS VDD sky130_fd_sc_hd__tapvpwrvgnd_1
XTAP_TAPCELL_ROW_18_422 VSS VDD sky130_fd_sc_hd__tapvpwrvgnd_1
XTAP_TAPCELL_ROW_18_423 VSS VDD sky130_fd_sc_hd__tapvpwrvgnd_1
XTAP_TAPCELL_ROW_18_424 VSS VDD sky130_fd_sc_hd__tapvpwrvgnd_1
XTAP_TAPCELL_ROW_18_425 VSS VDD sky130_fd_sc_hd__tapvpwrvgnd_1
XTAP_TAPCELL_ROW_18_426 VSS VDD sky130_fd_sc_hd__tapvpwrvgnd_1
XTAP_TAPCELL_ROW_18_427 VSS VDD sky130_fd_sc_hd__tapvpwrvgnd_1
XTAP_TAPCELL_ROW_18_428 VSS VDD sky130_fd_sc_hd__tapvpwrvgnd_1
XTAP_TAPCELL_ROW_18_429 VSS VDD sky130_fd_sc_hd__tapvpwrvgnd_1
XTAP_TAPCELL_ROW_19_430 VSS VDD sky130_fd_sc_hd__tapvpwrvgnd_1
XTAP_TAPCELL_ROW_19_431 VSS VDD sky130_fd_sc_hd__tapvpwrvgnd_1
XTAP_TAPCELL_ROW_19_432 VSS VDD sky130_fd_sc_hd__tapvpwrvgnd_1
XTAP_TAPCELL_ROW_19_433 VSS VDD sky130_fd_sc_hd__tapvpwrvgnd_1
XTAP_TAPCELL_ROW_19_434 VSS VDD sky130_fd_sc_hd__tapvpwrvgnd_1
XTAP_TAPCELL_ROW_19_435 VSS VDD sky130_fd_sc_hd__tapvpwrvgnd_1
XTAP_TAPCELL_ROW_19_436 VSS VDD sky130_fd_sc_hd__tapvpwrvgnd_1
XTAP_TAPCELL_ROW_19_437 VSS VDD sky130_fd_sc_hd__tapvpwrvgnd_1
XTAP_TAPCELL_ROW_19_438 VSS VDD sky130_fd_sc_hd__tapvpwrvgnd_1
XTAP_TAPCELL_ROW_19_439 VSS VDD sky130_fd_sc_hd__tapvpwrvgnd_1
XTAP_TAPCELL_ROW_19_440 VSS VDD sky130_fd_sc_hd__tapvpwrvgnd_1
XTAP_TAPCELL_ROW_19_441 VSS VDD sky130_fd_sc_hd__tapvpwrvgnd_1
XTAP_TAPCELL_ROW_19_442 VSS VDD sky130_fd_sc_hd__tapvpwrvgnd_1
XTAP_TAPCELL_ROW_19_443 VSS VDD sky130_fd_sc_hd__tapvpwrvgnd_1
XTAP_TAPCELL_ROW_19_444 VSS VDD sky130_fd_sc_hd__tapvpwrvgnd_1
XTAP_TAPCELL_ROW_19_445 VSS VDD sky130_fd_sc_hd__tapvpwrvgnd_1
XTAP_TAPCELL_ROW_19_446 VSS VDD sky130_fd_sc_hd__tapvpwrvgnd_1
XTAP_TAPCELL_ROW_19_447 VSS VDD sky130_fd_sc_hd__tapvpwrvgnd_1
XTAP_TAPCELL_ROW_19_448 VSS VDD sky130_fd_sc_hd__tapvpwrvgnd_1
XTAP_TAPCELL_ROW_19_449 VSS VDD sky130_fd_sc_hd__tapvpwrvgnd_1
XTAP_TAPCELL_ROW_19_450 VSS VDD sky130_fd_sc_hd__tapvpwrvgnd_1
XTAP_TAPCELL_ROW_20_451 VSS VDD sky130_fd_sc_hd__tapvpwrvgnd_1
XTAP_TAPCELL_ROW_20_452 VSS VDD sky130_fd_sc_hd__tapvpwrvgnd_1
XTAP_TAPCELL_ROW_20_453 VSS VDD sky130_fd_sc_hd__tapvpwrvgnd_1
XTAP_TAPCELL_ROW_20_454 VSS VDD sky130_fd_sc_hd__tapvpwrvgnd_1
XTAP_TAPCELL_ROW_20_455 VSS VDD sky130_fd_sc_hd__tapvpwrvgnd_1
XTAP_TAPCELL_ROW_20_456 VSS VDD sky130_fd_sc_hd__tapvpwrvgnd_1
XTAP_TAPCELL_ROW_20_457 VSS VDD sky130_fd_sc_hd__tapvpwrvgnd_1
XTAP_TAPCELL_ROW_20_458 VSS VDD sky130_fd_sc_hd__tapvpwrvgnd_1
XTAP_TAPCELL_ROW_20_459 VSS VDD sky130_fd_sc_hd__tapvpwrvgnd_1
XTAP_TAPCELL_ROW_20_460 VSS VDD sky130_fd_sc_hd__tapvpwrvgnd_1
XTAP_TAPCELL_ROW_20_461 VSS VDD sky130_fd_sc_hd__tapvpwrvgnd_1
XTAP_TAPCELL_ROW_20_462 VSS VDD sky130_fd_sc_hd__tapvpwrvgnd_1
XTAP_TAPCELL_ROW_20_463 VSS VDD sky130_fd_sc_hd__tapvpwrvgnd_1
XTAP_TAPCELL_ROW_20_464 VSS VDD sky130_fd_sc_hd__tapvpwrvgnd_1
XTAP_TAPCELL_ROW_20_465 VSS VDD sky130_fd_sc_hd__tapvpwrvgnd_1
XTAP_TAPCELL_ROW_20_466 VSS VDD sky130_fd_sc_hd__tapvpwrvgnd_1
XTAP_TAPCELL_ROW_20_467 VSS VDD sky130_fd_sc_hd__tapvpwrvgnd_1
XTAP_TAPCELL_ROW_20_468 VSS VDD sky130_fd_sc_hd__tapvpwrvgnd_1
XTAP_TAPCELL_ROW_20_469 VSS VDD sky130_fd_sc_hd__tapvpwrvgnd_1
XTAP_TAPCELL_ROW_20_470 VSS VDD sky130_fd_sc_hd__tapvpwrvgnd_1
XTAP_TAPCELL_ROW_20_471 VSS VDD sky130_fd_sc_hd__tapvpwrvgnd_1
XTAP_TAPCELL_ROW_20_472 VSS VDD sky130_fd_sc_hd__tapvpwrvgnd_1
XTAP_TAPCELL_ROW_21_473 VSS VDD sky130_fd_sc_hd__tapvpwrvgnd_1
XTAP_TAPCELL_ROW_21_474 VSS VDD sky130_fd_sc_hd__tapvpwrvgnd_1
XTAP_TAPCELL_ROW_21_475 VSS VDD sky130_fd_sc_hd__tapvpwrvgnd_1
XTAP_TAPCELL_ROW_21_476 VSS VDD sky130_fd_sc_hd__tapvpwrvgnd_1
XTAP_TAPCELL_ROW_21_477 VSS VDD sky130_fd_sc_hd__tapvpwrvgnd_1
XTAP_TAPCELL_ROW_21_478 VSS VDD sky130_fd_sc_hd__tapvpwrvgnd_1
XTAP_TAPCELL_ROW_21_479 VSS VDD sky130_fd_sc_hd__tapvpwrvgnd_1
XTAP_TAPCELL_ROW_21_480 VSS VDD sky130_fd_sc_hd__tapvpwrvgnd_1
XTAP_TAPCELL_ROW_21_481 VSS VDD sky130_fd_sc_hd__tapvpwrvgnd_1
XTAP_TAPCELL_ROW_21_482 VSS VDD sky130_fd_sc_hd__tapvpwrvgnd_1
XTAP_TAPCELL_ROW_21_483 VSS VDD sky130_fd_sc_hd__tapvpwrvgnd_1
XTAP_TAPCELL_ROW_21_484 VSS VDD sky130_fd_sc_hd__tapvpwrvgnd_1
XTAP_TAPCELL_ROW_21_485 VSS VDD sky130_fd_sc_hd__tapvpwrvgnd_1
XTAP_TAPCELL_ROW_21_486 VSS VDD sky130_fd_sc_hd__tapvpwrvgnd_1
XTAP_TAPCELL_ROW_21_487 VSS VDD sky130_fd_sc_hd__tapvpwrvgnd_1
XTAP_TAPCELL_ROW_21_488 VSS VDD sky130_fd_sc_hd__tapvpwrvgnd_1
XTAP_TAPCELL_ROW_21_489 VSS VDD sky130_fd_sc_hd__tapvpwrvgnd_1
XTAP_TAPCELL_ROW_21_490 VSS VDD sky130_fd_sc_hd__tapvpwrvgnd_1
XTAP_TAPCELL_ROW_21_491 VSS VDD sky130_fd_sc_hd__tapvpwrvgnd_1
XTAP_TAPCELL_ROW_21_492 VSS VDD sky130_fd_sc_hd__tapvpwrvgnd_1
XTAP_TAPCELL_ROW_21_493 VSS VDD sky130_fd_sc_hd__tapvpwrvgnd_1
XTAP_TAPCELL_ROW_22_494 VSS VDD sky130_fd_sc_hd__tapvpwrvgnd_1
XTAP_TAPCELL_ROW_22_495 VSS VDD sky130_fd_sc_hd__tapvpwrvgnd_1
XTAP_TAPCELL_ROW_22_496 VSS VDD sky130_fd_sc_hd__tapvpwrvgnd_1
XTAP_TAPCELL_ROW_22_497 VSS VDD sky130_fd_sc_hd__tapvpwrvgnd_1
XTAP_TAPCELL_ROW_22_498 VSS VDD sky130_fd_sc_hd__tapvpwrvgnd_1
XTAP_TAPCELL_ROW_22_499 VSS VDD sky130_fd_sc_hd__tapvpwrvgnd_1
XTAP_TAPCELL_ROW_22_500 VSS VDD sky130_fd_sc_hd__tapvpwrvgnd_1
XTAP_TAPCELL_ROW_22_501 VSS VDD sky130_fd_sc_hd__tapvpwrvgnd_1
XTAP_TAPCELL_ROW_22_502 VSS VDD sky130_fd_sc_hd__tapvpwrvgnd_1
XTAP_TAPCELL_ROW_22_503 VSS VDD sky130_fd_sc_hd__tapvpwrvgnd_1
XTAP_TAPCELL_ROW_22_504 VSS VDD sky130_fd_sc_hd__tapvpwrvgnd_1
XTAP_TAPCELL_ROW_22_505 VSS VDD sky130_fd_sc_hd__tapvpwrvgnd_1
XTAP_TAPCELL_ROW_22_506 VSS VDD sky130_fd_sc_hd__tapvpwrvgnd_1
XTAP_TAPCELL_ROW_22_507 VSS VDD sky130_fd_sc_hd__tapvpwrvgnd_1
XTAP_TAPCELL_ROW_22_508 VSS VDD sky130_fd_sc_hd__tapvpwrvgnd_1
XTAP_TAPCELL_ROW_22_509 VSS VDD sky130_fd_sc_hd__tapvpwrvgnd_1
XTAP_TAPCELL_ROW_22_510 VSS VDD sky130_fd_sc_hd__tapvpwrvgnd_1
XTAP_TAPCELL_ROW_22_511 VSS VDD sky130_fd_sc_hd__tapvpwrvgnd_1
XTAP_TAPCELL_ROW_22_512 VSS VDD sky130_fd_sc_hd__tapvpwrvgnd_1
XTAP_TAPCELL_ROW_22_513 VSS VDD sky130_fd_sc_hd__tapvpwrvgnd_1
XTAP_TAPCELL_ROW_22_514 VSS VDD sky130_fd_sc_hd__tapvpwrvgnd_1
XTAP_TAPCELL_ROW_22_515 VSS VDD sky130_fd_sc_hd__tapvpwrvgnd_1
XTAP_TAPCELL_ROW_23_516 VSS VDD sky130_fd_sc_hd__tapvpwrvgnd_1
XTAP_TAPCELL_ROW_23_517 VSS VDD sky130_fd_sc_hd__tapvpwrvgnd_1
XTAP_TAPCELL_ROW_23_518 VSS VDD sky130_fd_sc_hd__tapvpwrvgnd_1
XTAP_TAPCELL_ROW_23_519 VSS VDD sky130_fd_sc_hd__tapvpwrvgnd_1
XTAP_TAPCELL_ROW_23_520 VSS VDD sky130_fd_sc_hd__tapvpwrvgnd_1
XTAP_TAPCELL_ROW_23_521 VSS VDD sky130_fd_sc_hd__tapvpwrvgnd_1
XTAP_TAPCELL_ROW_23_522 VSS VDD sky130_fd_sc_hd__tapvpwrvgnd_1
XTAP_TAPCELL_ROW_23_523 VSS VDD sky130_fd_sc_hd__tapvpwrvgnd_1
XTAP_TAPCELL_ROW_23_524 VSS VDD sky130_fd_sc_hd__tapvpwrvgnd_1
XTAP_TAPCELL_ROW_23_525 VSS VDD sky130_fd_sc_hd__tapvpwrvgnd_1
XTAP_TAPCELL_ROW_23_526 VSS VDD sky130_fd_sc_hd__tapvpwrvgnd_1
XTAP_TAPCELL_ROW_23_527 VSS VDD sky130_fd_sc_hd__tapvpwrvgnd_1
XTAP_TAPCELL_ROW_23_528 VSS VDD sky130_fd_sc_hd__tapvpwrvgnd_1
XTAP_TAPCELL_ROW_23_529 VSS VDD sky130_fd_sc_hd__tapvpwrvgnd_1
XTAP_TAPCELL_ROW_23_530 VSS VDD sky130_fd_sc_hd__tapvpwrvgnd_1
XTAP_TAPCELL_ROW_23_531 VSS VDD sky130_fd_sc_hd__tapvpwrvgnd_1
XTAP_TAPCELL_ROW_23_532 VSS VDD sky130_fd_sc_hd__tapvpwrvgnd_1
XTAP_TAPCELL_ROW_23_533 VSS VDD sky130_fd_sc_hd__tapvpwrvgnd_1
XTAP_TAPCELL_ROW_23_534 VSS VDD sky130_fd_sc_hd__tapvpwrvgnd_1
XTAP_TAPCELL_ROW_23_535 VSS VDD sky130_fd_sc_hd__tapvpwrvgnd_1
XTAP_TAPCELL_ROW_23_536 VSS VDD sky130_fd_sc_hd__tapvpwrvgnd_1
XTAP_TAPCELL_ROW_24_537 VSS VDD sky130_fd_sc_hd__tapvpwrvgnd_1
XTAP_TAPCELL_ROW_24_538 VSS VDD sky130_fd_sc_hd__tapvpwrvgnd_1
XTAP_TAPCELL_ROW_24_539 VSS VDD sky130_fd_sc_hd__tapvpwrvgnd_1
XTAP_TAPCELL_ROW_24_540 VSS VDD sky130_fd_sc_hd__tapvpwrvgnd_1
XTAP_TAPCELL_ROW_24_541 VSS VDD sky130_fd_sc_hd__tapvpwrvgnd_1
XTAP_TAPCELL_ROW_24_542 VSS VDD sky130_fd_sc_hd__tapvpwrvgnd_1
XTAP_TAPCELL_ROW_24_543 VSS VDD sky130_fd_sc_hd__tapvpwrvgnd_1
XTAP_TAPCELL_ROW_24_544 VSS VDD sky130_fd_sc_hd__tapvpwrvgnd_1
XTAP_TAPCELL_ROW_24_545 VSS VDD sky130_fd_sc_hd__tapvpwrvgnd_1
XTAP_TAPCELL_ROW_24_546 VSS VDD sky130_fd_sc_hd__tapvpwrvgnd_1
XTAP_TAPCELL_ROW_24_547 VSS VDD sky130_fd_sc_hd__tapvpwrvgnd_1
XTAP_TAPCELL_ROW_24_548 VSS VDD sky130_fd_sc_hd__tapvpwrvgnd_1
XTAP_TAPCELL_ROW_24_549 VSS VDD sky130_fd_sc_hd__tapvpwrvgnd_1
XTAP_TAPCELL_ROW_24_550 VSS VDD sky130_fd_sc_hd__tapvpwrvgnd_1
XTAP_TAPCELL_ROW_24_551 VSS VDD sky130_fd_sc_hd__tapvpwrvgnd_1
XTAP_TAPCELL_ROW_24_552 VSS VDD sky130_fd_sc_hd__tapvpwrvgnd_1
XTAP_TAPCELL_ROW_24_553 VSS VDD sky130_fd_sc_hd__tapvpwrvgnd_1
XTAP_TAPCELL_ROW_24_554 VSS VDD sky130_fd_sc_hd__tapvpwrvgnd_1
XTAP_TAPCELL_ROW_24_555 VSS VDD sky130_fd_sc_hd__tapvpwrvgnd_1
XTAP_TAPCELL_ROW_24_556 VSS VDD sky130_fd_sc_hd__tapvpwrvgnd_1
XTAP_TAPCELL_ROW_24_557 VSS VDD sky130_fd_sc_hd__tapvpwrvgnd_1
XTAP_TAPCELL_ROW_24_558 VSS VDD sky130_fd_sc_hd__tapvpwrvgnd_1
XTAP_TAPCELL_ROW_25_559 VSS VDD sky130_fd_sc_hd__tapvpwrvgnd_1
XTAP_TAPCELL_ROW_25_560 VSS VDD sky130_fd_sc_hd__tapvpwrvgnd_1
XTAP_TAPCELL_ROW_25_561 VSS VDD sky130_fd_sc_hd__tapvpwrvgnd_1
XTAP_TAPCELL_ROW_25_562 VSS VDD sky130_fd_sc_hd__tapvpwrvgnd_1
XTAP_TAPCELL_ROW_25_563 VSS VDD sky130_fd_sc_hd__tapvpwrvgnd_1
XTAP_TAPCELL_ROW_25_564 VSS VDD sky130_fd_sc_hd__tapvpwrvgnd_1
XTAP_TAPCELL_ROW_25_565 VSS VDD sky130_fd_sc_hd__tapvpwrvgnd_1
XTAP_TAPCELL_ROW_25_566 VSS VDD sky130_fd_sc_hd__tapvpwrvgnd_1
XTAP_TAPCELL_ROW_25_567 VSS VDD sky130_fd_sc_hd__tapvpwrvgnd_1
XTAP_TAPCELL_ROW_25_568 VSS VDD sky130_fd_sc_hd__tapvpwrvgnd_1
XTAP_TAPCELL_ROW_25_569 VSS VDD sky130_fd_sc_hd__tapvpwrvgnd_1
XTAP_TAPCELL_ROW_25_570 VSS VDD sky130_fd_sc_hd__tapvpwrvgnd_1
XTAP_TAPCELL_ROW_25_571 VSS VDD sky130_fd_sc_hd__tapvpwrvgnd_1
XTAP_TAPCELL_ROW_25_572 VSS VDD sky130_fd_sc_hd__tapvpwrvgnd_1
XTAP_TAPCELL_ROW_25_573 VSS VDD sky130_fd_sc_hd__tapvpwrvgnd_1
XTAP_TAPCELL_ROW_25_574 VSS VDD sky130_fd_sc_hd__tapvpwrvgnd_1
XTAP_TAPCELL_ROW_25_575 VSS VDD sky130_fd_sc_hd__tapvpwrvgnd_1
XTAP_TAPCELL_ROW_25_576 VSS VDD sky130_fd_sc_hd__tapvpwrvgnd_1
XTAP_TAPCELL_ROW_25_577 VSS VDD sky130_fd_sc_hd__tapvpwrvgnd_1
XTAP_TAPCELL_ROW_25_578 VSS VDD sky130_fd_sc_hd__tapvpwrvgnd_1
XTAP_TAPCELL_ROW_25_579 VSS VDD sky130_fd_sc_hd__tapvpwrvgnd_1
XTAP_TAPCELL_ROW_26_580 VSS VDD sky130_fd_sc_hd__tapvpwrvgnd_1
XTAP_TAPCELL_ROW_26_581 VSS VDD sky130_fd_sc_hd__tapvpwrvgnd_1
XTAP_TAPCELL_ROW_26_582 VSS VDD sky130_fd_sc_hd__tapvpwrvgnd_1
XTAP_TAPCELL_ROW_26_583 VSS VDD sky130_fd_sc_hd__tapvpwrvgnd_1
XTAP_TAPCELL_ROW_26_584 VSS VDD sky130_fd_sc_hd__tapvpwrvgnd_1
XTAP_TAPCELL_ROW_26_585 VSS VDD sky130_fd_sc_hd__tapvpwrvgnd_1
XTAP_TAPCELL_ROW_26_586 VSS VDD sky130_fd_sc_hd__tapvpwrvgnd_1
XTAP_TAPCELL_ROW_26_587 VSS VDD sky130_fd_sc_hd__tapvpwrvgnd_1
XTAP_TAPCELL_ROW_26_588 VSS VDD sky130_fd_sc_hd__tapvpwrvgnd_1
XTAP_TAPCELL_ROW_26_589 VSS VDD sky130_fd_sc_hd__tapvpwrvgnd_1
XTAP_TAPCELL_ROW_26_590 VSS VDD sky130_fd_sc_hd__tapvpwrvgnd_1
XTAP_TAPCELL_ROW_26_591 VSS VDD sky130_fd_sc_hd__tapvpwrvgnd_1
XTAP_TAPCELL_ROW_26_592 VSS VDD sky130_fd_sc_hd__tapvpwrvgnd_1
XTAP_TAPCELL_ROW_26_593 VSS VDD sky130_fd_sc_hd__tapvpwrvgnd_1
XTAP_TAPCELL_ROW_26_594 VSS VDD sky130_fd_sc_hd__tapvpwrvgnd_1
XTAP_TAPCELL_ROW_26_595 VSS VDD sky130_fd_sc_hd__tapvpwrvgnd_1
XTAP_TAPCELL_ROW_26_596 VSS VDD sky130_fd_sc_hd__tapvpwrvgnd_1
XTAP_TAPCELL_ROW_26_597 VSS VDD sky130_fd_sc_hd__tapvpwrvgnd_1
XTAP_TAPCELL_ROW_26_598 VSS VDD sky130_fd_sc_hd__tapvpwrvgnd_1
XTAP_TAPCELL_ROW_26_599 VSS VDD sky130_fd_sc_hd__tapvpwrvgnd_1
XTAP_TAPCELL_ROW_26_600 VSS VDD sky130_fd_sc_hd__tapvpwrvgnd_1
XTAP_TAPCELL_ROW_26_601 VSS VDD sky130_fd_sc_hd__tapvpwrvgnd_1
XTAP_TAPCELL_ROW_27_602 VSS VDD sky130_fd_sc_hd__tapvpwrvgnd_1
XTAP_TAPCELL_ROW_27_603 VSS VDD sky130_fd_sc_hd__tapvpwrvgnd_1
XTAP_TAPCELL_ROW_27_604 VSS VDD sky130_fd_sc_hd__tapvpwrvgnd_1
XTAP_TAPCELL_ROW_27_605 VSS VDD sky130_fd_sc_hd__tapvpwrvgnd_1
XTAP_TAPCELL_ROW_27_606 VSS VDD sky130_fd_sc_hd__tapvpwrvgnd_1
XTAP_TAPCELL_ROW_27_607 VSS VDD sky130_fd_sc_hd__tapvpwrvgnd_1
XTAP_TAPCELL_ROW_27_608 VSS VDD sky130_fd_sc_hd__tapvpwrvgnd_1
XTAP_TAPCELL_ROW_27_609 VSS VDD sky130_fd_sc_hd__tapvpwrvgnd_1
XTAP_TAPCELL_ROW_27_610 VSS VDD sky130_fd_sc_hd__tapvpwrvgnd_1
XTAP_TAPCELL_ROW_27_611 VSS VDD sky130_fd_sc_hd__tapvpwrvgnd_1
XTAP_TAPCELL_ROW_27_612 VSS VDD sky130_fd_sc_hd__tapvpwrvgnd_1
XTAP_TAPCELL_ROW_27_613 VSS VDD sky130_fd_sc_hd__tapvpwrvgnd_1
XTAP_TAPCELL_ROW_27_614 VSS VDD sky130_fd_sc_hd__tapvpwrvgnd_1
XTAP_TAPCELL_ROW_27_615 VSS VDD sky130_fd_sc_hd__tapvpwrvgnd_1
XTAP_TAPCELL_ROW_27_616 VSS VDD sky130_fd_sc_hd__tapvpwrvgnd_1
XTAP_TAPCELL_ROW_27_617 VSS VDD sky130_fd_sc_hd__tapvpwrvgnd_1
XTAP_TAPCELL_ROW_27_618 VSS VDD sky130_fd_sc_hd__tapvpwrvgnd_1
XTAP_TAPCELL_ROW_27_619 VSS VDD sky130_fd_sc_hd__tapvpwrvgnd_1
XTAP_TAPCELL_ROW_27_620 VSS VDD sky130_fd_sc_hd__tapvpwrvgnd_1
XTAP_TAPCELL_ROW_27_621 VSS VDD sky130_fd_sc_hd__tapvpwrvgnd_1
XTAP_TAPCELL_ROW_27_622 VSS VDD sky130_fd_sc_hd__tapvpwrvgnd_1
XTAP_TAPCELL_ROW_28_623 VSS VDD sky130_fd_sc_hd__tapvpwrvgnd_1
XTAP_TAPCELL_ROW_28_624 VSS VDD sky130_fd_sc_hd__tapvpwrvgnd_1
XTAP_TAPCELL_ROW_28_625 VSS VDD sky130_fd_sc_hd__tapvpwrvgnd_1
XTAP_TAPCELL_ROW_28_626 VSS VDD sky130_fd_sc_hd__tapvpwrvgnd_1
XTAP_TAPCELL_ROW_28_627 VSS VDD sky130_fd_sc_hd__tapvpwrvgnd_1
XTAP_TAPCELL_ROW_28_628 VSS VDD sky130_fd_sc_hd__tapvpwrvgnd_1
XTAP_TAPCELL_ROW_28_629 VSS VDD sky130_fd_sc_hd__tapvpwrvgnd_1
XTAP_TAPCELL_ROW_28_630 VSS VDD sky130_fd_sc_hd__tapvpwrvgnd_1
XTAP_TAPCELL_ROW_28_631 VSS VDD sky130_fd_sc_hd__tapvpwrvgnd_1
XTAP_TAPCELL_ROW_28_632 VSS VDD sky130_fd_sc_hd__tapvpwrvgnd_1
XTAP_TAPCELL_ROW_28_633 VSS VDD sky130_fd_sc_hd__tapvpwrvgnd_1
XTAP_TAPCELL_ROW_28_634 VSS VDD sky130_fd_sc_hd__tapvpwrvgnd_1
XTAP_TAPCELL_ROW_28_635 VSS VDD sky130_fd_sc_hd__tapvpwrvgnd_1
XTAP_TAPCELL_ROW_28_636 VSS VDD sky130_fd_sc_hd__tapvpwrvgnd_1
XTAP_TAPCELL_ROW_28_637 VSS VDD sky130_fd_sc_hd__tapvpwrvgnd_1
XTAP_TAPCELL_ROW_28_638 VSS VDD sky130_fd_sc_hd__tapvpwrvgnd_1
XTAP_TAPCELL_ROW_28_639 VSS VDD sky130_fd_sc_hd__tapvpwrvgnd_1
XTAP_TAPCELL_ROW_28_640 VSS VDD sky130_fd_sc_hd__tapvpwrvgnd_1
XTAP_TAPCELL_ROW_28_641 VSS VDD sky130_fd_sc_hd__tapvpwrvgnd_1
XTAP_TAPCELL_ROW_28_642 VSS VDD sky130_fd_sc_hd__tapvpwrvgnd_1
XTAP_TAPCELL_ROW_28_643 VSS VDD sky130_fd_sc_hd__tapvpwrvgnd_1
XTAP_TAPCELL_ROW_28_644 VSS VDD sky130_fd_sc_hd__tapvpwrvgnd_1
XTAP_TAPCELL_ROW_29_645 VSS VDD sky130_fd_sc_hd__tapvpwrvgnd_1
XTAP_TAPCELL_ROW_29_646 VSS VDD sky130_fd_sc_hd__tapvpwrvgnd_1
XTAP_TAPCELL_ROW_29_647 VSS VDD sky130_fd_sc_hd__tapvpwrvgnd_1
XTAP_TAPCELL_ROW_29_648 VSS VDD sky130_fd_sc_hd__tapvpwrvgnd_1
XTAP_TAPCELL_ROW_29_649 VSS VDD sky130_fd_sc_hd__tapvpwrvgnd_1
XTAP_TAPCELL_ROW_29_650 VSS VDD sky130_fd_sc_hd__tapvpwrvgnd_1
XTAP_TAPCELL_ROW_29_651 VSS VDD sky130_fd_sc_hd__tapvpwrvgnd_1
XTAP_TAPCELL_ROW_29_652 VSS VDD sky130_fd_sc_hd__tapvpwrvgnd_1
XTAP_TAPCELL_ROW_29_653 VSS VDD sky130_fd_sc_hd__tapvpwrvgnd_1
XTAP_TAPCELL_ROW_29_654 VSS VDD sky130_fd_sc_hd__tapvpwrvgnd_1
XTAP_TAPCELL_ROW_29_655 VSS VDD sky130_fd_sc_hd__tapvpwrvgnd_1
XTAP_TAPCELL_ROW_29_656 VSS VDD sky130_fd_sc_hd__tapvpwrvgnd_1
XTAP_TAPCELL_ROW_29_657 VSS VDD sky130_fd_sc_hd__tapvpwrvgnd_1
XTAP_TAPCELL_ROW_29_658 VSS VDD sky130_fd_sc_hd__tapvpwrvgnd_1
XTAP_TAPCELL_ROW_29_659 VSS VDD sky130_fd_sc_hd__tapvpwrvgnd_1
XTAP_TAPCELL_ROW_29_660 VSS VDD sky130_fd_sc_hd__tapvpwrvgnd_1
XTAP_TAPCELL_ROW_29_661 VSS VDD sky130_fd_sc_hd__tapvpwrvgnd_1
XTAP_TAPCELL_ROW_29_662 VSS VDD sky130_fd_sc_hd__tapvpwrvgnd_1
XTAP_TAPCELL_ROW_29_663 VSS VDD sky130_fd_sc_hd__tapvpwrvgnd_1
XTAP_TAPCELL_ROW_29_664 VSS VDD sky130_fd_sc_hd__tapvpwrvgnd_1
XTAP_TAPCELL_ROW_29_665 VSS VDD sky130_fd_sc_hd__tapvpwrvgnd_1
XTAP_TAPCELL_ROW_30_666 VSS VDD sky130_fd_sc_hd__tapvpwrvgnd_1
XTAP_TAPCELL_ROW_30_667 VSS VDD sky130_fd_sc_hd__tapvpwrvgnd_1
XTAP_TAPCELL_ROW_30_668 VSS VDD sky130_fd_sc_hd__tapvpwrvgnd_1
XTAP_TAPCELL_ROW_30_669 VSS VDD sky130_fd_sc_hd__tapvpwrvgnd_1
XTAP_TAPCELL_ROW_30_670 VSS VDD sky130_fd_sc_hd__tapvpwrvgnd_1
XTAP_TAPCELL_ROW_30_671 VSS VDD sky130_fd_sc_hd__tapvpwrvgnd_1
XTAP_TAPCELL_ROW_30_672 VSS VDD sky130_fd_sc_hd__tapvpwrvgnd_1
XTAP_TAPCELL_ROW_30_673 VSS VDD sky130_fd_sc_hd__tapvpwrvgnd_1
XTAP_TAPCELL_ROW_30_674 VSS VDD sky130_fd_sc_hd__tapvpwrvgnd_1
XTAP_TAPCELL_ROW_30_675 VSS VDD sky130_fd_sc_hd__tapvpwrvgnd_1
XTAP_TAPCELL_ROW_30_676 VSS VDD sky130_fd_sc_hd__tapvpwrvgnd_1
XTAP_TAPCELL_ROW_30_677 VSS VDD sky130_fd_sc_hd__tapvpwrvgnd_1
XTAP_TAPCELL_ROW_30_678 VSS VDD sky130_fd_sc_hd__tapvpwrvgnd_1
XTAP_TAPCELL_ROW_30_679 VSS VDD sky130_fd_sc_hd__tapvpwrvgnd_1
XTAP_TAPCELL_ROW_30_680 VSS VDD sky130_fd_sc_hd__tapvpwrvgnd_1
XTAP_TAPCELL_ROW_30_681 VSS VDD sky130_fd_sc_hd__tapvpwrvgnd_1
XTAP_TAPCELL_ROW_30_682 VSS VDD sky130_fd_sc_hd__tapvpwrvgnd_1
XTAP_TAPCELL_ROW_30_683 VSS VDD sky130_fd_sc_hd__tapvpwrvgnd_1
XTAP_TAPCELL_ROW_30_684 VSS VDD sky130_fd_sc_hd__tapvpwrvgnd_1
XTAP_TAPCELL_ROW_30_685 VSS VDD sky130_fd_sc_hd__tapvpwrvgnd_1
XTAP_TAPCELL_ROW_30_686 VSS VDD sky130_fd_sc_hd__tapvpwrvgnd_1
XTAP_TAPCELL_ROW_30_687 VSS VDD sky130_fd_sc_hd__tapvpwrvgnd_1
XTAP_TAPCELL_ROW_31_688 VSS VDD sky130_fd_sc_hd__tapvpwrvgnd_1
XTAP_TAPCELL_ROW_31_689 VSS VDD sky130_fd_sc_hd__tapvpwrvgnd_1
XTAP_TAPCELL_ROW_31_690 VSS VDD sky130_fd_sc_hd__tapvpwrvgnd_1
XTAP_TAPCELL_ROW_31_691 VSS VDD sky130_fd_sc_hd__tapvpwrvgnd_1
XTAP_TAPCELL_ROW_31_692 VSS VDD sky130_fd_sc_hd__tapvpwrvgnd_1
XTAP_TAPCELL_ROW_31_693 VSS VDD sky130_fd_sc_hd__tapvpwrvgnd_1
XTAP_TAPCELL_ROW_31_694 VSS VDD sky130_fd_sc_hd__tapvpwrvgnd_1
XTAP_TAPCELL_ROW_31_695 VSS VDD sky130_fd_sc_hd__tapvpwrvgnd_1
XTAP_TAPCELL_ROW_31_696 VSS VDD sky130_fd_sc_hd__tapvpwrvgnd_1
XTAP_TAPCELL_ROW_31_697 VSS VDD sky130_fd_sc_hd__tapvpwrvgnd_1
XTAP_TAPCELL_ROW_31_698 VSS VDD sky130_fd_sc_hd__tapvpwrvgnd_1
XTAP_TAPCELL_ROW_31_699 VSS VDD sky130_fd_sc_hd__tapvpwrvgnd_1
XTAP_TAPCELL_ROW_31_700 VSS VDD sky130_fd_sc_hd__tapvpwrvgnd_1
XTAP_TAPCELL_ROW_31_701 VSS VDD sky130_fd_sc_hd__tapvpwrvgnd_1
XTAP_TAPCELL_ROW_31_702 VSS VDD sky130_fd_sc_hd__tapvpwrvgnd_1
XTAP_TAPCELL_ROW_31_703 VSS VDD sky130_fd_sc_hd__tapvpwrvgnd_1
XTAP_TAPCELL_ROW_31_704 VSS VDD sky130_fd_sc_hd__tapvpwrvgnd_1
XTAP_TAPCELL_ROW_31_705 VSS VDD sky130_fd_sc_hd__tapvpwrvgnd_1
XTAP_TAPCELL_ROW_31_706 VSS VDD sky130_fd_sc_hd__tapvpwrvgnd_1
XTAP_TAPCELL_ROW_31_707 VSS VDD sky130_fd_sc_hd__tapvpwrvgnd_1
XTAP_TAPCELL_ROW_31_708 VSS VDD sky130_fd_sc_hd__tapvpwrvgnd_1
XTAP_TAPCELL_ROW_32_709 VSS VDD sky130_fd_sc_hd__tapvpwrvgnd_1
XTAP_TAPCELL_ROW_32_710 VSS VDD sky130_fd_sc_hd__tapvpwrvgnd_1
XTAP_TAPCELL_ROW_32_711 VSS VDD sky130_fd_sc_hd__tapvpwrvgnd_1
XTAP_TAPCELL_ROW_32_712 VSS VDD sky130_fd_sc_hd__tapvpwrvgnd_1
XTAP_TAPCELL_ROW_32_713 VSS VDD sky130_fd_sc_hd__tapvpwrvgnd_1
XTAP_TAPCELL_ROW_32_714 VSS VDD sky130_fd_sc_hd__tapvpwrvgnd_1
XTAP_TAPCELL_ROW_32_715 VSS VDD sky130_fd_sc_hd__tapvpwrvgnd_1
XTAP_TAPCELL_ROW_32_716 VSS VDD sky130_fd_sc_hd__tapvpwrvgnd_1
XTAP_TAPCELL_ROW_32_717 VSS VDD sky130_fd_sc_hd__tapvpwrvgnd_1
XTAP_TAPCELL_ROW_32_718 VSS VDD sky130_fd_sc_hd__tapvpwrvgnd_1
XTAP_TAPCELL_ROW_32_719 VSS VDD sky130_fd_sc_hd__tapvpwrvgnd_1
XTAP_TAPCELL_ROW_32_720 VSS VDD sky130_fd_sc_hd__tapvpwrvgnd_1
XTAP_TAPCELL_ROW_32_721 VSS VDD sky130_fd_sc_hd__tapvpwrvgnd_1
XTAP_TAPCELL_ROW_32_722 VSS VDD sky130_fd_sc_hd__tapvpwrvgnd_1
XTAP_TAPCELL_ROW_32_723 VSS VDD sky130_fd_sc_hd__tapvpwrvgnd_1
XTAP_TAPCELL_ROW_32_724 VSS VDD sky130_fd_sc_hd__tapvpwrvgnd_1
XTAP_TAPCELL_ROW_32_725 VSS VDD sky130_fd_sc_hd__tapvpwrvgnd_1
XTAP_TAPCELL_ROW_32_726 VSS VDD sky130_fd_sc_hd__tapvpwrvgnd_1
XTAP_TAPCELL_ROW_32_727 VSS VDD sky130_fd_sc_hd__tapvpwrvgnd_1
XTAP_TAPCELL_ROW_32_728 VSS VDD sky130_fd_sc_hd__tapvpwrvgnd_1
XTAP_TAPCELL_ROW_32_729 VSS VDD sky130_fd_sc_hd__tapvpwrvgnd_1
XTAP_TAPCELL_ROW_32_730 VSS VDD sky130_fd_sc_hd__tapvpwrvgnd_1
XTAP_TAPCELL_ROW_33_731 VSS VDD sky130_fd_sc_hd__tapvpwrvgnd_1
XTAP_TAPCELL_ROW_33_732 VSS VDD sky130_fd_sc_hd__tapvpwrvgnd_1
XTAP_TAPCELL_ROW_33_733 VSS VDD sky130_fd_sc_hd__tapvpwrvgnd_1
XTAP_TAPCELL_ROW_33_734 VSS VDD sky130_fd_sc_hd__tapvpwrvgnd_1
XTAP_TAPCELL_ROW_33_735 VSS VDD sky130_fd_sc_hd__tapvpwrvgnd_1
XTAP_TAPCELL_ROW_33_736 VSS VDD sky130_fd_sc_hd__tapvpwrvgnd_1
XTAP_TAPCELL_ROW_33_737 VSS VDD sky130_fd_sc_hd__tapvpwrvgnd_1
XTAP_TAPCELL_ROW_33_738 VSS VDD sky130_fd_sc_hd__tapvpwrvgnd_1
XTAP_TAPCELL_ROW_33_739 VSS VDD sky130_fd_sc_hd__tapvpwrvgnd_1
XTAP_TAPCELL_ROW_33_740 VSS VDD sky130_fd_sc_hd__tapvpwrvgnd_1
XTAP_TAPCELL_ROW_33_741 VSS VDD sky130_fd_sc_hd__tapvpwrvgnd_1
XTAP_TAPCELL_ROW_33_742 VSS VDD sky130_fd_sc_hd__tapvpwrvgnd_1
XTAP_TAPCELL_ROW_33_743 VSS VDD sky130_fd_sc_hd__tapvpwrvgnd_1
XTAP_TAPCELL_ROW_33_744 VSS VDD sky130_fd_sc_hd__tapvpwrvgnd_1
XTAP_TAPCELL_ROW_33_745 VSS VDD sky130_fd_sc_hd__tapvpwrvgnd_1
XTAP_TAPCELL_ROW_33_746 VSS VDD sky130_fd_sc_hd__tapvpwrvgnd_1
XTAP_TAPCELL_ROW_33_747 VSS VDD sky130_fd_sc_hd__tapvpwrvgnd_1
XTAP_TAPCELL_ROW_33_748 VSS VDD sky130_fd_sc_hd__tapvpwrvgnd_1
XTAP_TAPCELL_ROW_33_749 VSS VDD sky130_fd_sc_hd__tapvpwrvgnd_1
XTAP_TAPCELL_ROW_33_750 VSS VDD sky130_fd_sc_hd__tapvpwrvgnd_1
XTAP_TAPCELL_ROW_33_751 VSS VDD sky130_fd_sc_hd__tapvpwrvgnd_1
XTAP_TAPCELL_ROW_34_752 VSS VDD sky130_fd_sc_hd__tapvpwrvgnd_1
XTAP_TAPCELL_ROW_34_753 VSS VDD sky130_fd_sc_hd__tapvpwrvgnd_1
XTAP_TAPCELL_ROW_34_754 VSS VDD sky130_fd_sc_hd__tapvpwrvgnd_1
XTAP_TAPCELL_ROW_34_755 VSS VDD sky130_fd_sc_hd__tapvpwrvgnd_1
XTAP_TAPCELL_ROW_34_756 VSS VDD sky130_fd_sc_hd__tapvpwrvgnd_1
XTAP_TAPCELL_ROW_34_757 VSS VDD sky130_fd_sc_hd__tapvpwrvgnd_1
XTAP_TAPCELL_ROW_34_758 VSS VDD sky130_fd_sc_hd__tapvpwrvgnd_1
XTAP_TAPCELL_ROW_34_759 VSS VDD sky130_fd_sc_hd__tapvpwrvgnd_1
XTAP_TAPCELL_ROW_34_760 VSS VDD sky130_fd_sc_hd__tapvpwrvgnd_1
XTAP_TAPCELL_ROW_34_761 VSS VDD sky130_fd_sc_hd__tapvpwrvgnd_1
XTAP_TAPCELL_ROW_34_762 VSS VDD sky130_fd_sc_hd__tapvpwrvgnd_1
XTAP_TAPCELL_ROW_34_763 VSS VDD sky130_fd_sc_hd__tapvpwrvgnd_1
XTAP_TAPCELL_ROW_34_764 VSS VDD sky130_fd_sc_hd__tapvpwrvgnd_1
XTAP_TAPCELL_ROW_34_765 VSS VDD sky130_fd_sc_hd__tapvpwrvgnd_1
XTAP_TAPCELL_ROW_34_766 VSS VDD sky130_fd_sc_hd__tapvpwrvgnd_1
XTAP_TAPCELL_ROW_34_767 VSS VDD sky130_fd_sc_hd__tapvpwrvgnd_1
XTAP_TAPCELL_ROW_34_768 VSS VDD sky130_fd_sc_hd__tapvpwrvgnd_1
XTAP_TAPCELL_ROW_34_769 VSS VDD sky130_fd_sc_hd__tapvpwrvgnd_1
XTAP_TAPCELL_ROW_34_770 VSS VDD sky130_fd_sc_hd__tapvpwrvgnd_1
XTAP_TAPCELL_ROW_34_771 VSS VDD sky130_fd_sc_hd__tapvpwrvgnd_1
XTAP_TAPCELL_ROW_34_772 VSS VDD sky130_fd_sc_hd__tapvpwrvgnd_1
XTAP_TAPCELL_ROW_34_773 VSS VDD sky130_fd_sc_hd__tapvpwrvgnd_1
XTAP_TAPCELL_ROW_35_774 VSS VDD sky130_fd_sc_hd__tapvpwrvgnd_1
XTAP_TAPCELL_ROW_35_775 VSS VDD sky130_fd_sc_hd__tapvpwrvgnd_1
XTAP_TAPCELL_ROW_35_776 VSS VDD sky130_fd_sc_hd__tapvpwrvgnd_1
XTAP_TAPCELL_ROW_35_777 VSS VDD sky130_fd_sc_hd__tapvpwrvgnd_1
XTAP_TAPCELL_ROW_35_778 VSS VDD sky130_fd_sc_hd__tapvpwrvgnd_1
XTAP_TAPCELL_ROW_35_779 VSS VDD sky130_fd_sc_hd__tapvpwrvgnd_1
XTAP_TAPCELL_ROW_35_780 VSS VDD sky130_fd_sc_hd__tapvpwrvgnd_1
XTAP_TAPCELL_ROW_35_781 VSS VDD sky130_fd_sc_hd__tapvpwrvgnd_1
XTAP_TAPCELL_ROW_35_782 VSS VDD sky130_fd_sc_hd__tapvpwrvgnd_1
XTAP_TAPCELL_ROW_35_783 VSS VDD sky130_fd_sc_hd__tapvpwrvgnd_1
XTAP_TAPCELL_ROW_35_784 VSS VDD sky130_fd_sc_hd__tapvpwrvgnd_1
XTAP_TAPCELL_ROW_35_785 VSS VDD sky130_fd_sc_hd__tapvpwrvgnd_1
XTAP_TAPCELL_ROW_35_786 VSS VDD sky130_fd_sc_hd__tapvpwrvgnd_1
XTAP_TAPCELL_ROW_35_787 VSS VDD sky130_fd_sc_hd__tapvpwrvgnd_1
XTAP_TAPCELL_ROW_35_788 VSS VDD sky130_fd_sc_hd__tapvpwrvgnd_1
XTAP_TAPCELL_ROW_35_789 VSS VDD sky130_fd_sc_hd__tapvpwrvgnd_1
XTAP_TAPCELL_ROW_35_790 VSS VDD sky130_fd_sc_hd__tapvpwrvgnd_1
XTAP_TAPCELL_ROW_35_791 VSS VDD sky130_fd_sc_hd__tapvpwrvgnd_1
XTAP_TAPCELL_ROW_35_792 VSS VDD sky130_fd_sc_hd__tapvpwrvgnd_1
XTAP_TAPCELL_ROW_35_793 VSS VDD sky130_fd_sc_hd__tapvpwrvgnd_1
XTAP_TAPCELL_ROW_35_794 VSS VDD sky130_fd_sc_hd__tapvpwrvgnd_1
XTAP_TAPCELL_ROW_36_795 VSS VDD sky130_fd_sc_hd__tapvpwrvgnd_1
XTAP_TAPCELL_ROW_36_796 VSS VDD sky130_fd_sc_hd__tapvpwrvgnd_1
XTAP_TAPCELL_ROW_36_797 VSS VDD sky130_fd_sc_hd__tapvpwrvgnd_1
XTAP_TAPCELL_ROW_36_798 VSS VDD sky130_fd_sc_hd__tapvpwrvgnd_1
XTAP_TAPCELL_ROW_36_799 VSS VDD sky130_fd_sc_hd__tapvpwrvgnd_1
XTAP_TAPCELL_ROW_36_800 VSS VDD sky130_fd_sc_hd__tapvpwrvgnd_1
XTAP_TAPCELL_ROW_36_801 VSS VDD sky130_fd_sc_hd__tapvpwrvgnd_1
XTAP_TAPCELL_ROW_36_802 VSS VDD sky130_fd_sc_hd__tapvpwrvgnd_1
XTAP_TAPCELL_ROW_36_803 VSS VDD sky130_fd_sc_hd__tapvpwrvgnd_1
XTAP_TAPCELL_ROW_36_804 VSS VDD sky130_fd_sc_hd__tapvpwrvgnd_1
XTAP_TAPCELL_ROW_36_805 VSS VDD sky130_fd_sc_hd__tapvpwrvgnd_1
XTAP_TAPCELL_ROW_36_806 VSS VDD sky130_fd_sc_hd__tapvpwrvgnd_1
XTAP_TAPCELL_ROW_36_807 VSS VDD sky130_fd_sc_hd__tapvpwrvgnd_1
XTAP_TAPCELL_ROW_36_808 VSS VDD sky130_fd_sc_hd__tapvpwrvgnd_1
XTAP_TAPCELL_ROW_36_809 VSS VDD sky130_fd_sc_hd__tapvpwrvgnd_1
XTAP_TAPCELL_ROW_36_810 VSS VDD sky130_fd_sc_hd__tapvpwrvgnd_1
XTAP_TAPCELL_ROW_36_811 VSS VDD sky130_fd_sc_hd__tapvpwrvgnd_1
XTAP_TAPCELL_ROW_36_812 VSS VDD sky130_fd_sc_hd__tapvpwrvgnd_1
XTAP_TAPCELL_ROW_36_813 VSS VDD sky130_fd_sc_hd__tapvpwrvgnd_1
XTAP_TAPCELL_ROW_36_814 VSS VDD sky130_fd_sc_hd__tapvpwrvgnd_1
XTAP_TAPCELL_ROW_36_815 VSS VDD sky130_fd_sc_hd__tapvpwrvgnd_1
XTAP_TAPCELL_ROW_36_816 VSS VDD sky130_fd_sc_hd__tapvpwrvgnd_1
XTAP_TAPCELL_ROW_37_817 VSS VDD sky130_fd_sc_hd__tapvpwrvgnd_1
XTAP_TAPCELL_ROW_37_818 VSS VDD sky130_fd_sc_hd__tapvpwrvgnd_1
XTAP_TAPCELL_ROW_37_819 VSS VDD sky130_fd_sc_hd__tapvpwrvgnd_1
XTAP_TAPCELL_ROW_37_820 VSS VDD sky130_fd_sc_hd__tapvpwrvgnd_1
XTAP_TAPCELL_ROW_37_821 VSS VDD sky130_fd_sc_hd__tapvpwrvgnd_1
XTAP_TAPCELL_ROW_37_822 VSS VDD sky130_fd_sc_hd__tapvpwrvgnd_1
XTAP_TAPCELL_ROW_37_823 VSS VDD sky130_fd_sc_hd__tapvpwrvgnd_1
XTAP_TAPCELL_ROW_37_824 VSS VDD sky130_fd_sc_hd__tapvpwrvgnd_1
XTAP_TAPCELL_ROW_37_825 VSS VDD sky130_fd_sc_hd__tapvpwrvgnd_1
XTAP_TAPCELL_ROW_37_826 VSS VDD sky130_fd_sc_hd__tapvpwrvgnd_1
XTAP_TAPCELL_ROW_37_827 VSS VDD sky130_fd_sc_hd__tapvpwrvgnd_1
XTAP_TAPCELL_ROW_37_828 VSS VDD sky130_fd_sc_hd__tapvpwrvgnd_1
XTAP_TAPCELL_ROW_37_829 VSS VDD sky130_fd_sc_hd__tapvpwrvgnd_1
XTAP_TAPCELL_ROW_37_830 VSS VDD sky130_fd_sc_hd__tapvpwrvgnd_1
XTAP_TAPCELL_ROW_37_831 VSS VDD sky130_fd_sc_hd__tapvpwrvgnd_1
XTAP_TAPCELL_ROW_37_832 VSS VDD sky130_fd_sc_hd__tapvpwrvgnd_1
XTAP_TAPCELL_ROW_37_833 VSS VDD sky130_fd_sc_hd__tapvpwrvgnd_1
XTAP_TAPCELL_ROW_37_834 VSS VDD sky130_fd_sc_hd__tapvpwrvgnd_1
XTAP_TAPCELL_ROW_37_835 VSS VDD sky130_fd_sc_hd__tapvpwrvgnd_1
XTAP_TAPCELL_ROW_37_836 VSS VDD sky130_fd_sc_hd__tapvpwrvgnd_1
XTAP_TAPCELL_ROW_37_837 VSS VDD sky130_fd_sc_hd__tapvpwrvgnd_1
XTAP_TAPCELL_ROW_38_838 VSS VDD sky130_fd_sc_hd__tapvpwrvgnd_1
XTAP_TAPCELL_ROW_38_839 VSS VDD sky130_fd_sc_hd__tapvpwrvgnd_1
XTAP_TAPCELL_ROW_38_840 VSS VDD sky130_fd_sc_hd__tapvpwrvgnd_1
XTAP_TAPCELL_ROW_38_841 VSS VDD sky130_fd_sc_hd__tapvpwrvgnd_1
XTAP_TAPCELL_ROW_38_842 VSS VDD sky130_fd_sc_hd__tapvpwrvgnd_1
XTAP_TAPCELL_ROW_38_843 VSS VDD sky130_fd_sc_hd__tapvpwrvgnd_1
XTAP_TAPCELL_ROW_38_844 VSS VDD sky130_fd_sc_hd__tapvpwrvgnd_1
XTAP_TAPCELL_ROW_38_845 VSS VDD sky130_fd_sc_hd__tapvpwrvgnd_1
XTAP_TAPCELL_ROW_38_846 VSS VDD sky130_fd_sc_hd__tapvpwrvgnd_1
XTAP_TAPCELL_ROW_38_847 VSS VDD sky130_fd_sc_hd__tapvpwrvgnd_1
XTAP_TAPCELL_ROW_38_848 VSS VDD sky130_fd_sc_hd__tapvpwrvgnd_1
XTAP_TAPCELL_ROW_38_849 VSS VDD sky130_fd_sc_hd__tapvpwrvgnd_1
XTAP_TAPCELL_ROW_38_850 VSS VDD sky130_fd_sc_hd__tapvpwrvgnd_1
XTAP_TAPCELL_ROW_38_851 VSS VDD sky130_fd_sc_hd__tapvpwrvgnd_1
XTAP_TAPCELL_ROW_38_852 VSS VDD sky130_fd_sc_hd__tapvpwrvgnd_1
XTAP_TAPCELL_ROW_38_853 VSS VDD sky130_fd_sc_hd__tapvpwrvgnd_1
XTAP_TAPCELL_ROW_38_854 VSS VDD sky130_fd_sc_hd__tapvpwrvgnd_1
XTAP_TAPCELL_ROW_38_855 VSS VDD sky130_fd_sc_hd__tapvpwrvgnd_1
XTAP_TAPCELL_ROW_38_856 VSS VDD sky130_fd_sc_hd__tapvpwrvgnd_1
XTAP_TAPCELL_ROW_38_857 VSS VDD sky130_fd_sc_hd__tapvpwrvgnd_1
XTAP_TAPCELL_ROW_38_858 VSS VDD sky130_fd_sc_hd__tapvpwrvgnd_1
XTAP_TAPCELL_ROW_38_859 VSS VDD sky130_fd_sc_hd__tapvpwrvgnd_1
XTAP_TAPCELL_ROW_39_860 VSS VDD sky130_fd_sc_hd__tapvpwrvgnd_1
XTAP_TAPCELL_ROW_39_861 VSS VDD sky130_fd_sc_hd__tapvpwrvgnd_1
XTAP_TAPCELL_ROW_39_862 VSS VDD sky130_fd_sc_hd__tapvpwrvgnd_1
XTAP_TAPCELL_ROW_39_863 VSS VDD sky130_fd_sc_hd__tapvpwrvgnd_1
XTAP_TAPCELL_ROW_39_864 VSS VDD sky130_fd_sc_hd__tapvpwrvgnd_1
XTAP_TAPCELL_ROW_39_865 VSS VDD sky130_fd_sc_hd__tapvpwrvgnd_1
XTAP_TAPCELL_ROW_39_866 VSS VDD sky130_fd_sc_hd__tapvpwrvgnd_1
XTAP_TAPCELL_ROW_39_867 VSS VDD sky130_fd_sc_hd__tapvpwrvgnd_1
XTAP_TAPCELL_ROW_39_868 VSS VDD sky130_fd_sc_hd__tapvpwrvgnd_1
XTAP_TAPCELL_ROW_39_869 VSS VDD sky130_fd_sc_hd__tapvpwrvgnd_1
XTAP_TAPCELL_ROW_39_870 VSS VDD sky130_fd_sc_hd__tapvpwrvgnd_1
XTAP_TAPCELL_ROW_39_871 VSS VDD sky130_fd_sc_hd__tapvpwrvgnd_1
XTAP_TAPCELL_ROW_39_872 VSS VDD sky130_fd_sc_hd__tapvpwrvgnd_1
XTAP_TAPCELL_ROW_39_873 VSS VDD sky130_fd_sc_hd__tapvpwrvgnd_1
XTAP_TAPCELL_ROW_39_874 VSS VDD sky130_fd_sc_hd__tapvpwrvgnd_1
XTAP_TAPCELL_ROW_39_875 VSS VDD sky130_fd_sc_hd__tapvpwrvgnd_1
XTAP_TAPCELL_ROW_39_876 VSS VDD sky130_fd_sc_hd__tapvpwrvgnd_1
XTAP_TAPCELL_ROW_39_877 VSS VDD sky130_fd_sc_hd__tapvpwrvgnd_1
XTAP_TAPCELL_ROW_39_878 VSS VDD sky130_fd_sc_hd__tapvpwrvgnd_1
XTAP_TAPCELL_ROW_39_879 VSS VDD sky130_fd_sc_hd__tapvpwrvgnd_1
XTAP_TAPCELL_ROW_39_880 VSS VDD sky130_fd_sc_hd__tapvpwrvgnd_1
XTAP_TAPCELL_ROW_40_881 VSS VDD sky130_fd_sc_hd__tapvpwrvgnd_1
XTAP_TAPCELL_ROW_40_882 VSS VDD sky130_fd_sc_hd__tapvpwrvgnd_1
XTAP_TAPCELL_ROW_40_883 VSS VDD sky130_fd_sc_hd__tapvpwrvgnd_1
XTAP_TAPCELL_ROW_40_884 VSS VDD sky130_fd_sc_hd__tapvpwrvgnd_1
XTAP_TAPCELL_ROW_40_885 VSS VDD sky130_fd_sc_hd__tapvpwrvgnd_1
XTAP_TAPCELL_ROW_40_886 VSS VDD sky130_fd_sc_hd__tapvpwrvgnd_1
XTAP_TAPCELL_ROW_40_887 VSS VDD sky130_fd_sc_hd__tapvpwrvgnd_1
XTAP_TAPCELL_ROW_40_888 VSS VDD sky130_fd_sc_hd__tapvpwrvgnd_1
XTAP_TAPCELL_ROW_40_889 VSS VDD sky130_fd_sc_hd__tapvpwrvgnd_1
XTAP_TAPCELL_ROW_40_890 VSS VDD sky130_fd_sc_hd__tapvpwrvgnd_1
XTAP_TAPCELL_ROW_40_891 VSS VDD sky130_fd_sc_hd__tapvpwrvgnd_1
XTAP_TAPCELL_ROW_40_892 VSS VDD sky130_fd_sc_hd__tapvpwrvgnd_1
XTAP_TAPCELL_ROW_40_893 VSS VDD sky130_fd_sc_hd__tapvpwrvgnd_1
XTAP_TAPCELL_ROW_40_894 VSS VDD sky130_fd_sc_hd__tapvpwrvgnd_1
XTAP_TAPCELL_ROW_40_895 VSS VDD sky130_fd_sc_hd__tapvpwrvgnd_1
XTAP_TAPCELL_ROW_40_896 VSS VDD sky130_fd_sc_hd__tapvpwrvgnd_1
XTAP_TAPCELL_ROW_40_897 VSS VDD sky130_fd_sc_hd__tapvpwrvgnd_1
XTAP_TAPCELL_ROW_40_898 VSS VDD sky130_fd_sc_hd__tapvpwrvgnd_1
XTAP_TAPCELL_ROW_40_899 VSS VDD sky130_fd_sc_hd__tapvpwrvgnd_1
XTAP_TAPCELL_ROW_40_900 VSS VDD sky130_fd_sc_hd__tapvpwrvgnd_1
XTAP_TAPCELL_ROW_40_901 VSS VDD sky130_fd_sc_hd__tapvpwrvgnd_1
XTAP_TAPCELL_ROW_40_902 VSS VDD sky130_fd_sc_hd__tapvpwrvgnd_1
XTAP_TAPCELL_ROW_41_903 VSS VDD sky130_fd_sc_hd__tapvpwrvgnd_1
XTAP_TAPCELL_ROW_41_904 VSS VDD sky130_fd_sc_hd__tapvpwrvgnd_1
XTAP_TAPCELL_ROW_41_905 VSS VDD sky130_fd_sc_hd__tapvpwrvgnd_1
XTAP_TAPCELL_ROW_41_906 VSS VDD sky130_fd_sc_hd__tapvpwrvgnd_1
XTAP_TAPCELL_ROW_41_907 VSS VDD sky130_fd_sc_hd__tapvpwrvgnd_1
XTAP_TAPCELL_ROW_41_908 VSS VDD sky130_fd_sc_hd__tapvpwrvgnd_1
XTAP_TAPCELL_ROW_41_909 VSS VDD sky130_fd_sc_hd__tapvpwrvgnd_1
XTAP_TAPCELL_ROW_41_910 VSS VDD sky130_fd_sc_hd__tapvpwrvgnd_1
XTAP_TAPCELL_ROW_41_911 VSS VDD sky130_fd_sc_hd__tapvpwrvgnd_1
XTAP_TAPCELL_ROW_41_912 VSS VDD sky130_fd_sc_hd__tapvpwrvgnd_1
XTAP_TAPCELL_ROW_41_913 VSS VDD sky130_fd_sc_hd__tapvpwrvgnd_1
XTAP_TAPCELL_ROW_41_914 VSS VDD sky130_fd_sc_hd__tapvpwrvgnd_1
XTAP_TAPCELL_ROW_41_915 VSS VDD sky130_fd_sc_hd__tapvpwrvgnd_1
XTAP_TAPCELL_ROW_41_916 VSS VDD sky130_fd_sc_hd__tapvpwrvgnd_1
XTAP_TAPCELL_ROW_41_917 VSS VDD sky130_fd_sc_hd__tapvpwrvgnd_1
XTAP_TAPCELL_ROW_41_918 VSS VDD sky130_fd_sc_hd__tapvpwrvgnd_1
XTAP_TAPCELL_ROW_41_919 VSS VDD sky130_fd_sc_hd__tapvpwrvgnd_1
XTAP_TAPCELL_ROW_41_920 VSS VDD sky130_fd_sc_hd__tapvpwrvgnd_1
XTAP_TAPCELL_ROW_41_921 VSS VDD sky130_fd_sc_hd__tapvpwrvgnd_1
XTAP_TAPCELL_ROW_41_922 VSS VDD sky130_fd_sc_hd__tapvpwrvgnd_1
XTAP_TAPCELL_ROW_41_923 VSS VDD sky130_fd_sc_hd__tapvpwrvgnd_1
XTAP_TAPCELL_ROW_42_924 VSS VDD sky130_fd_sc_hd__tapvpwrvgnd_1
XTAP_TAPCELL_ROW_42_925 VSS VDD sky130_fd_sc_hd__tapvpwrvgnd_1
XTAP_TAPCELL_ROW_42_926 VSS VDD sky130_fd_sc_hd__tapvpwrvgnd_1
XTAP_TAPCELL_ROW_42_927 VSS VDD sky130_fd_sc_hd__tapvpwrvgnd_1
XTAP_TAPCELL_ROW_42_928 VSS VDD sky130_fd_sc_hd__tapvpwrvgnd_1
XTAP_TAPCELL_ROW_42_929 VSS VDD sky130_fd_sc_hd__tapvpwrvgnd_1
XTAP_TAPCELL_ROW_42_930 VSS VDD sky130_fd_sc_hd__tapvpwrvgnd_1
XTAP_TAPCELL_ROW_42_931 VSS VDD sky130_fd_sc_hd__tapvpwrvgnd_1
XTAP_TAPCELL_ROW_42_932 VSS VDD sky130_fd_sc_hd__tapvpwrvgnd_1
XTAP_TAPCELL_ROW_42_933 VSS VDD sky130_fd_sc_hd__tapvpwrvgnd_1
XTAP_TAPCELL_ROW_42_934 VSS VDD sky130_fd_sc_hd__tapvpwrvgnd_1
XTAP_TAPCELL_ROW_42_935 VSS VDD sky130_fd_sc_hd__tapvpwrvgnd_1
XTAP_TAPCELL_ROW_42_936 VSS VDD sky130_fd_sc_hd__tapvpwrvgnd_1
XTAP_TAPCELL_ROW_42_937 VSS VDD sky130_fd_sc_hd__tapvpwrvgnd_1
XTAP_TAPCELL_ROW_42_938 VSS VDD sky130_fd_sc_hd__tapvpwrvgnd_1
XTAP_TAPCELL_ROW_42_939 VSS VDD sky130_fd_sc_hd__tapvpwrvgnd_1
XTAP_TAPCELL_ROW_42_940 VSS VDD sky130_fd_sc_hd__tapvpwrvgnd_1
XTAP_TAPCELL_ROW_42_941 VSS VDD sky130_fd_sc_hd__tapvpwrvgnd_1
XTAP_TAPCELL_ROW_42_942 VSS VDD sky130_fd_sc_hd__tapvpwrvgnd_1
XTAP_TAPCELL_ROW_42_943 VSS VDD sky130_fd_sc_hd__tapvpwrvgnd_1
XTAP_TAPCELL_ROW_42_944 VSS VDD sky130_fd_sc_hd__tapvpwrvgnd_1
XTAP_TAPCELL_ROW_42_945 VSS VDD sky130_fd_sc_hd__tapvpwrvgnd_1
XTAP_TAPCELL_ROW_43_946 VSS VDD sky130_fd_sc_hd__tapvpwrvgnd_1
XTAP_TAPCELL_ROW_43_947 VSS VDD sky130_fd_sc_hd__tapvpwrvgnd_1
XTAP_TAPCELL_ROW_43_948 VSS VDD sky130_fd_sc_hd__tapvpwrvgnd_1
XTAP_TAPCELL_ROW_43_949 VSS VDD sky130_fd_sc_hd__tapvpwrvgnd_1
XTAP_TAPCELL_ROW_43_950 VSS VDD sky130_fd_sc_hd__tapvpwrvgnd_1
XTAP_TAPCELL_ROW_43_951 VSS VDD sky130_fd_sc_hd__tapvpwrvgnd_1
XTAP_TAPCELL_ROW_43_952 VSS VDD sky130_fd_sc_hd__tapvpwrvgnd_1
XTAP_TAPCELL_ROW_43_953 VSS VDD sky130_fd_sc_hd__tapvpwrvgnd_1
XTAP_TAPCELL_ROW_43_954 VSS VDD sky130_fd_sc_hd__tapvpwrvgnd_1
XTAP_TAPCELL_ROW_43_955 VSS VDD sky130_fd_sc_hd__tapvpwrvgnd_1
XTAP_TAPCELL_ROW_43_956 VSS VDD sky130_fd_sc_hd__tapvpwrvgnd_1
XTAP_TAPCELL_ROW_43_957 VSS VDD sky130_fd_sc_hd__tapvpwrvgnd_1
XTAP_TAPCELL_ROW_43_958 VSS VDD sky130_fd_sc_hd__tapvpwrvgnd_1
XTAP_TAPCELL_ROW_43_959 VSS VDD sky130_fd_sc_hd__tapvpwrvgnd_1
XTAP_TAPCELL_ROW_43_960 VSS VDD sky130_fd_sc_hd__tapvpwrvgnd_1
XTAP_TAPCELL_ROW_43_961 VSS VDD sky130_fd_sc_hd__tapvpwrvgnd_1
XTAP_TAPCELL_ROW_43_962 VSS VDD sky130_fd_sc_hd__tapvpwrvgnd_1
XTAP_TAPCELL_ROW_43_963 VSS VDD sky130_fd_sc_hd__tapvpwrvgnd_1
XTAP_TAPCELL_ROW_43_964 VSS VDD sky130_fd_sc_hd__tapvpwrvgnd_1
XTAP_TAPCELL_ROW_43_965 VSS VDD sky130_fd_sc_hd__tapvpwrvgnd_1
XTAP_TAPCELL_ROW_43_966 VSS VDD sky130_fd_sc_hd__tapvpwrvgnd_1
XTAP_TAPCELL_ROW_44_967 VSS VDD sky130_fd_sc_hd__tapvpwrvgnd_1
XTAP_TAPCELL_ROW_44_968 VSS VDD sky130_fd_sc_hd__tapvpwrvgnd_1
XTAP_TAPCELL_ROW_44_969 VSS VDD sky130_fd_sc_hd__tapvpwrvgnd_1
XTAP_TAPCELL_ROW_44_970 VSS VDD sky130_fd_sc_hd__tapvpwrvgnd_1
XTAP_TAPCELL_ROW_44_971 VSS VDD sky130_fd_sc_hd__tapvpwrvgnd_1
XTAP_TAPCELL_ROW_44_972 VSS VDD sky130_fd_sc_hd__tapvpwrvgnd_1
XTAP_TAPCELL_ROW_44_973 VSS VDD sky130_fd_sc_hd__tapvpwrvgnd_1
XTAP_TAPCELL_ROW_44_974 VSS VDD sky130_fd_sc_hd__tapvpwrvgnd_1
XTAP_TAPCELL_ROW_44_975 VSS VDD sky130_fd_sc_hd__tapvpwrvgnd_1
XTAP_TAPCELL_ROW_44_976 VSS VDD sky130_fd_sc_hd__tapvpwrvgnd_1
XTAP_TAPCELL_ROW_44_977 VSS VDD sky130_fd_sc_hd__tapvpwrvgnd_1
XTAP_TAPCELL_ROW_44_978 VSS VDD sky130_fd_sc_hd__tapvpwrvgnd_1
XTAP_TAPCELL_ROW_44_979 VSS VDD sky130_fd_sc_hd__tapvpwrvgnd_1
XTAP_TAPCELL_ROW_44_980 VSS VDD sky130_fd_sc_hd__tapvpwrvgnd_1
XTAP_TAPCELL_ROW_44_981 VSS VDD sky130_fd_sc_hd__tapvpwrvgnd_1
XTAP_TAPCELL_ROW_44_982 VSS VDD sky130_fd_sc_hd__tapvpwrvgnd_1
XTAP_TAPCELL_ROW_44_983 VSS VDD sky130_fd_sc_hd__tapvpwrvgnd_1
XTAP_TAPCELL_ROW_44_984 VSS VDD sky130_fd_sc_hd__tapvpwrvgnd_1
XTAP_TAPCELL_ROW_44_985 VSS VDD sky130_fd_sc_hd__tapvpwrvgnd_1
XTAP_TAPCELL_ROW_44_986 VSS VDD sky130_fd_sc_hd__tapvpwrvgnd_1
XTAP_TAPCELL_ROW_44_987 VSS VDD sky130_fd_sc_hd__tapvpwrvgnd_1
XTAP_TAPCELL_ROW_44_988 VSS VDD sky130_fd_sc_hd__tapvpwrvgnd_1
XTAP_TAPCELL_ROW_45_989 VSS VDD sky130_fd_sc_hd__tapvpwrvgnd_1
XTAP_TAPCELL_ROW_45_990 VSS VDD sky130_fd_sc_hd__tapvpwrvgnd_1
XTAP_TAPCELL_ROW_45_991 VSS VDD sky130_fd_sc_hd__tapvpwrvgnd_1
XTAP_TAPCELL_ROW_45_992 VSS VDD sky130_fd_sc_hd__tapvpwrvgnd_1
XTAP_TAPCELL_ROW_45_993 VSS VDD sky130_fd_sc_hd__tapvpwrvgnd_1
XTAP_TAPCELL_ROW_45_994 VSS VDD sky130_fd_sc_hd__tapvpwrvgnd_1
XTAP_TAPCELL_ROW_45_995 VSS VDD sky130_fd_sc_hd__tapvpwrvgnd_1
XTAP_TAPCELL_ROW_45_996 VSS VDD sky130_fd_sc_hd__tapvpwrvgnd_1
XTAP_TAPCELL_ROW_45_997 VSS VDD sky130_fd_sc_hd__tapvpwrvgnd_1
XTAP_TAPCELL_ROW_45_998 VSS VDD sky130_fd_sc_hd__tapvpwrvgnd_1
XTAP_TAPCELL_ROW_45_999 VSS VDD sky130_fd_sc_hd__tapvpwrvgnd_1
XTAP_TAPCELL_ROW_45_1000 VSS VDD sky130_fd_sc_hd__tapvpwrvgnd_1
XTAP_TAPCELL_ROW_45_1001 VSS VDD sky130_fd_sc_hd__tapvpwrvgnd_1
XTAP_TAPCELL_ROW_45_1002 VSS VDD sky130_fd_sc_hd__tapvpwrvgnd_1
XTAP_TAPCELL_ROW_45_1003 VSS VDD sky130_fd_sc_hd__tapvpwrvgnd_1
XTAP_TAPCELL_ROW_45_1004 VSS VDD sky130_fd_sc_hd__tapvpwrvgnd_1
XTAP_TAPCELL_ROW_45_1005 VSS VDD sky130_fd_sc_hd__tapvpwrvgnd_1
XTAP_TAPCELL_ROW_45_1006 VSS VDD sky130_fd_sc_hd__tapvpwrvgnd_1
XTAP_TAPCELL_ROW_45_1007 VSS VDD sky130_fd_sc_hd__tapvpwrvgnd_1
XTAP_TAPCELL_ROW_45_1008 VSS VDD sky130_fd_sc_hd__tapvpwrvgnd_1
XTAP_TAPCELL_ROW_45_1009 VSS VDD sky130_fd_sc_hd__tapvpwrvgnd_1
XTAP_TAPCELL_ROW_46_1010 VSS VDD sky130_fd_sc_hd__tapvpwrvgnd_1
XTAP_TAPCELL_ROW_46_1011 VSS VDD sky130_fd_sc_hd__tapvpwrvgnd_1
XTAP_TAPCELL_ROW_46_1012 VSS VDD sky130_fd_sc_hd__tapvpwrvgnd_1
XTAP_TAPCELL_ROW_46_1013 VSS VDD sky130_fd_sc_hd__tapvpwrvgnd_1
XTAP_TAPCELL_ROW_46_1014 VSS VDD sky130_fd_sc_hd__tapvpwrvgnd_1
XTAP_TAPCELL_ROW_46_1015 VSS VDD sky130_fd_sc_hd__tapvpwrvgnd_1
XTAP_TAPCELL_ROW_46_1016 VSS VDD sky130_fd_sc_hd__tapvpwrvgnd_1
XTAP_TAPCELL_ROW_46_1017 VSS VDD sky130_fd_sc_hd__tapvpwrvgnd_1
XTAP_TAPCELL_ROW_46_1018 VSS VDD sky130_fd_sc_hd__tapvpwrvgnd_1
XTAP_TAPCELL_ROW_46_1019 VSS VDD sky130_fd_sc_hd__tapvpwrvgnd_1
XTAP_TAPCELL_ROW_46_1020 VSS VDD sky130_fd_sc_hd__tapvpwrvgnd_1
XTAP_TAPCELL_ROW_46_1021 VSS VDD sky130_fd_sc_hd__tapvpwrvgnd_1
XTAP_TAPCELL_ROW_46_1022 VSS VDD sky130_fd_sc_hd__tapvpwrvgnd_1
XTAP_TAPCELL_ROW_46_1023 VSS VDD sky130_fd_sc_hd__tapvpwrvgnd_1
XTAP_TAPCELL_ROW_46_1024 VSS VDD sky130_fd_sc_hd__tapvpwrvgnd_1
XTAP_TAPCELL_ROW_46_1025 VSS VDD sky130_fd_sc_hd__tapvpwrvgnd_1
XTAP_TAPCELL_ROW_46_1026 VSS VDD sky130_fd_sc_hd__tapvpwrvgnd_1
XTAP_TAPCELL_ROW_46_1027 VSS VDD sky130_fd_sc_hd__tapvpwrvgnd_1
XTAP_TAPCELL_ROW_46_1028 VSS VDD sky130_fd_sc_hd__tapvpwrvgnd_1
XTAP_TAPCELL_ROW_46_1029 VSS VDD sky130_fd_sc_hd__tapvpwrvgnd_1
XTAP_TAPCELL_ROW_46_1030 VSS VDD sky130_fd_sc_hd__tapvpwrvgnd_1
XTAP_TAPCELL_ROW_46_1031 VSS VDD sky130_fd_sc_hd__tapvpwrvgnd_1
XTAP_TAPCELL_ROW_47_1032 VSS VDD sky130_fd_sc_hd__tapvpwrvgnd_1
XTAP_TAPCELL_ROW_47_1033 VSS VDD sky130_fd_sc_hd__tapvpwrvgnd_1
XTAP_TAPCELL_ROW_47_1034 VSS VDD sky130_fd_sc_hd__tapvpwrvgnd_1
XTAP_TAPCELL_ROW_47_1035 VSS VDD sky130_fd_sc_hd__tapvpwrvgnd_1
XTAP_TAPCELL_ROW_47_1036 VSS VDD sky130_fd_sc_hd__tapvpwrvgnd_1
XTAP_TAPCELL_ROW_47_1037 VSS VDD sky130_fd_sc_hd__tapvpwrvgnd_1
XTAP_TAPCELL_ROW_47_1038 VSS VDD sky130_fd_sc_hd__tapvpwrvgnd_1
XTAP_TAPCELL_ROW_47_1039 VSS VDD sky130_fd_sc_hd__tapvpwrvgnd_1
XTAP_TAPCELL_ROW_47_1040 VSS VDD sky130_fd_sc_hd__tapvpwrvgnd_1
XTAP_TAPCELL_ROW_47_1041 VSS VDD sky130_fd_sc_hd__tapvpwrvgnd_1
XTAP_TAPCELL_ROW_47_1042 VSS VDD sky130_fd_sc_hd__tapvpwrvgnd_1
XTAP_TAPCELL_ROW_47_1043 VSS VDD sky130_fd_sc_hd__tapvpwrvgnd_1
XTAP_TAPCELL_ROW_47_1044 VSS VDD sky130_fd_sc_hd__tapvpwrvgnd_1
XTAP_TAPCELL_ROW_47_1045 VSS VDD sky130_fd_sc_hd__tapvpwrvgnd_1
XTAP_TAPCELL_ROW_47_1046 VSS VDD sky130_fd_sc_hd__tapvpwrvgnd_1
XTAP_TAPCELL_ROW_47_1047 VSS VDD sky130_fd_sc_hd__tapvpwrvgnd_1
XTAP_TAPCELL_ROW_47_1048 VSS VDD sky130_fd_sc_hd__tapvpwrvgnd_1
XTAP_TAPCELL_ROW_47_1049 VSS VDD sky130_fd_sc_hd__tapvpwrvgnd_1
XTAP_TAPCELL_ROW_47_1050 VSS VDD sky130_fd_sc_hd__tapvpwrvgnd_1
XTAP_TAPCELL_ROW_47_1051 VSS VDD sky130_fd_sc_hd__tapvpwrvgnd_1
XTAP_TAPCELL_ROW_47_1052 VSS VDD sky130_fd_sc_hd__tapvpwrvgnd_1
XTAP_TAPCELL_ROW_48_1053 VSS VDD sky130_fd_sc_hd__tapvpwrvgnd_1
XTAP_TAPCELL_ROW_48_1054 VSS VDD sky130_fd_sc_hd__tapvpwrvgnd_1
XTAP_TAPCELL_ROW_48_1055 VSS VDD sky130_fd_sc_hd__tapvpwrvgnd_1
XTAP_TAPCELL_ROW_48_1056 VSS VDD sky130_fd_sc_hd__tapvpwrvgnd_1
XTAP_TAPCELL_ROW_48_1057 VSS VDD sky130_fd_sc_hd__tapvpwrvgnd_1
XTAP_TAPCELL_ROW_48_1058 VSS VDD sky130_fd_sc_hd__tapvpwrvgnd_1
XTAP_TAPCELL_ROW_48_1059 VSS VDD sky130_fd_sc_hd__tapvpwrvgnd_1
XTAP_TAPCELL_ROW_48_1060 VSS VDD sky130_fd_sc_hd__tapvpwrvgnd_1
XTAP_TAPCELL_ROW_48_1061 VSS VDD sky130_fd_sc_hd__tapvpwrvgnd_1
XTAP_TAPCELL_ROW_48_1062 VSS VDD sky130_fd_sc_hd__tapvpwrvgnd_1
XTAP_TAPCELL_ROW_48_1063 VSS VDD sky130_fd_sc_hd__tapvpwrvgnd_1
XTAP_TAPCELL_ROW_48_1064 VSS VDD sky130_fd_sc_hd__tapvpwrvgnd_1
XTAP_TAPCELL_ROW_48_1065 VSS VDD sky130_fd_sc_hd__tapvpwrvgnd_1
XTAP_TAPCELL_ROW_48_1066 VSS VDD sky130_fd_sc_hd__tapvpwrvgnd_1
XTAP_TAPCELL_ROW_48_1067 VSS VDD sky130_fd_sc_hd__tapvpwrvgnd_1
XTAP_TAPCELL_ROW_48_1068 VSS VDD sky130_fd_sc_hd__tapvpwrvgnd_1
XTAP_TAPCELL_ROW_48_1069 VSS VDD sky130_fd_sc_hd__tapvpwrvgnd_1
XTAP_TAPCELL_ROW_48_1070 VSS VDD sky130_fd_sc_hd__tapvpwrvgnd_1
XTAP_TAPCELL_ROW_48_1071 VSS VDD sky130_fd_sc_hd__tapvpwrvgnd_1
XTAP_TAPCELL_ROW_48_1072 VSS VDD sky130_fd_sc_hd__tapvpwrvgnd_1
XTAP_TAPCELL_ROW_48_1073 VSS VDD sky130_fd_sc_hd__tapvpwrvgnd_1
XTAP_TAPCELL_ROW_48_1074 VSS VDD sky130_fd_sc_hd__tapvpwrvgnd_1
XTAP_TAPCELL_ROW_49_1075 VSS VDD sky130_fd_sc_hd__tapvpwrvgnd_1
XTAP_TAPCELL_ROW_49_1076 VSS VDD sky130_fd_sc_hd__tapvpwrvgnd_1
XTAP_TAPCELL_ROW_49_1077 VSS VDD sky130_fd_sc_hd__tapvpwrvgnd_1
XTAP_TAPCELL_ROW_49_1078 VSS VDD sky130_fd_sc_hd__tapvpwrvgnd_1
XTAP_TAPCELL_ROW_49_1079 VSS VDD sky130_fd_sc_hd__tapvpwrvgnd_1
XTAP_TAPCELL_ROW_49_1080 VSS VDD sky130_fd_sc_hd__tapvpwrvgnd_1
XTAP_TAPCELL_ROW_49_1081 VSS VDD sky130_fd_sc_hd__tapvpwrvgnd_1
XTAP_TAPCELL_ROW_49_1082 VSS VDD sky130_fd_sc_hd__tapvpwrvgnd_1
XTAP_TAPCELL_ROW_49_1083 VSS VDD sky130_fd_sc_hd__tapvpwrvgnd_1
XTAP_TAPCELL_ROW_49_1084 VSS VDD sky130_fd_sc_hd__tapvpwrvgnd_1
XTAP_TAPCELL_ROW_49_1085 VSS VDD sky130_fd_sc_hd__tapvpwrvgnd_1
XTAP_TAPCELL_ROW_49_1086 VSS VDD sky130_fd_sc_hd__tapvpwrvgnd_1
XTAP_TAPCELL_ROW_49_1087 VSS VDD sky130_fd_sc_hd__tapvpwrvgnd_1
XTAP_TAPCELL_ROW_49_1088 VSS VDD sky130_fd_sc_hd__tapvpwrvgnd_1
XTAP_TAPCELL_ROW_49_1089 VSS VDD sky130_fd_sc_hd__tapvpwrvgnd_1
XTAP_TAPCELL_ROW_49_1090 VSS VDD sky130_fd_sc_hd__tapvpwrvgnd_1
XTAP_TAPCELL_ROW_49_1091 VSS VDD sky130_fd_sc_hd__tapvpwrvgnd_1
XTAP_TAPCELL_ROW_49_1092 VSS VDD sky130_fd_sc_hd__tapvpwrvgnd_1
XTAP_TAPCELL_ROW_49_1093 VSS VDD sky130_fd_sc_hd__tapvpwrvgnd_1
XTAP_TAPCELL_ROW_49_1094 VSS VDD sky130_fd_sc_hd__tapvpwrvgnd_1
XTAP_TAPCELL_ROW_49_1095 VSS VDD sky130_fd_sc_hd__tapvpwrvgnd_1
XTAP_TAPCELL_ROW_50_1096 VSS VDD sky130_fd_sc_hd__tapvpwrvgnd_1
XTAP_TAPCELL_ROW_50_1097 VSS VDD sky130_fd_sc_hd__tapvpwrvgnd_1
XTAP_TAPCELL_ROW_50_1098 VSS VDD sky130_fd_sc_hd__tapvpwrvgnd_1
XTAP_TAPCELL_ROW_50_1099 VSS VDD sky130_fd_sc_hd__tapvpwrvgnd_1
XTAP_TAPCELL_ROW_50_1100 VSS VDD sky130_fd_sc_hd__tapvpwrvgnd_1
XTAP_TAPCELL_ROW_50_1101 VSS VDD sky130_fd_sc_hd__tapvpwrvgnd_1
XTAP_TAPCELL_ROW_50_1102 VSS VDD sky130_fd_sc_hd__tapvpwrvgnd_1
XTAP_TAPCELL_ROW_50_1103 VSS VDD sky130_fd_sc_hd__tapvpwrvgnd_1
XTAP_TAPCELL_ROW_50_1104 VSS VDD sky130_fd_sc_hd__tapvpwrvgnd_1
XTAP_TAPCELL_ROW_50_1105 VSS VDD sky130_fd_sc_hd__tapvpwrvgnd_1
XTAP_TAPCELL_ROW_50_1106 VSS VDD sky130_fd_sc_hd__tapvpwrvgnd_1
XTAP_TAPCELL_ROW_50_1107 VSS VDD sky130_fd_sc_hd__tapvpwrvgnd_1
XTAP_TAPCELL_ROW_50_1108 VSS VDD sky130_fd_sc_hd__tapvpwrvgnd_1
XTAP_TAPCELL_ROW_50_1109 VSS VDD sky130_fd_sc_hd__tapvpwrvgnd_1
XTAP_TAPCELL_ROW_50_1110 VSS VDD sky130_fd_sc_hd__tapvpwrvgnd_1
XTAP_TAPCELL_ROW_50_1111 VSS VDD sky130_fd_sc_hd__tapvpwrvgnd_1
XTAP_TAPCELL_ROW_50_1112 VSS VDD sky130_fd_sc_hd__tapvpwrvgnd_1
XTAP_TAPCELL_ROW_50_1113 VSS VDD sky130_fd_sc_hd__tapvpwrvgnd_1
XTAP_TAPCELL_ROW_50_1114 VSS VDD sky130_fd_sc_hd__tapvpwrvgnd_1
XTAP_TAPCELL_ROW_50_1115 VSS VDD sky130_fd_sc_hd__tapvpwrvgnd_1
XTAP_TAPCELL_ROW_50_1116 VSS VDD sky130_fd_sc_hd__tapvpwrvgnd_1
XTAP_TAPCELL_ROW_50_1117 VSS VDD sky130_fd_sc_hd__tapvpwrvgnd_1
XTAP_TAPCELL_ROW_51_1118 VSS VDD sky130_fd_sc_hd__tapvpwrvgnd_1
XTAP_TAPCELL_ROW_51_1119 VSS VDD sky130_fd_sc_hd__tapvpwrvgnd_1
XTAP_TAPCELL_ROW_51_1120 VSS VDD sky130_fd_sc_hd__tapvpwrvgnd_1
XTAP_TAPCELL_ROW_51_1121 VSS VDD sky130_fd_sc_hd__tapvpwrvgnd_1
XTAP_TAPCELL_ROW_51_1122 VSS VDD sky130_fd_sc_hd__tapvpwrvgnd_1
XTAP_TAPCELL_ROW_51_1123 VSS VDD sky130_fd_sc_hd__tapvpwrvgnd_1
XTAP_TAPCELL_ROW_51_1124 VSS VDD sky130_fd_sc_hd__tapvpwrvgnd_1
XTAP_TAPCELL_ROW_51_1125 VSS VDD sky130_fd_sc_hd__tapvpwrvgnd_1
XTAP_TAPCELL_ROW_51_1126 VSS VDD sky130_fd_sc_hd__tapvpwrvgnd_1
XTAP_TAPCELL_ROW_51_1127 VSS VDD sky130_fd_sc_hd__tapvpwrvgnd_1
XTAP_TAPCELL_ROW_51_1128 VSS VDD sky130_fd_sc_hd__tapvpwrvgnd_1
XTAP_TAPCELL_ROW_51_1129 VSS VDD sky130_fd_sc_hd__tapvpwrvgnd_1
XTAP_TAPCELL_ROW_51_1130 VSS VDD sky130_fd_sc_hd__tapvpwrvgnd_1
XTAP_TAPCELL_ROW_51_1131 VSS VDD sky130_fd_sc_hd__tapvpwrvgnd_1
XTAP_TAPCELL_ROW_51_1132 VSS VDD sky130_fd_sc_hd__tapvpwrvgnd_1
XTAP_TAPCELL_ROW_51_1133 VSS VDD sky130_fd_sc_hd__tapvpwrvgnd_1
XTAP_TAPCELL_ROW_51_1134 VSS VDD sky130_fd_sc_hd__tapvpwrvgnd_1
XTAP_TAPCELL_ROW_51_1135 VSS VDD sky130_fd_sc_hd__tapvpwrvgnd_1
XTAP_TAPCELL_ROW_51_1136 VSS VDD sky130_fd_sc_hd__tapvpwrvgnd_1
XTAP_TAPCELL_ROW_51_1137 VSS VDD sky130_fd_sc_hd__tapvpwrvgnd_1
XTAP_TAPCELL_ROW_51_1138 VSS VDD sky130_fd_sc_hd__tapvpwrvgnd_1
XTAP_TAPCELL_ROW_52_1139 VSS VDD sky130_fd_sc_hd__tapvpwrvgnd_1
XTAP_TAPCELL_ROW_52_1140 VSS VDD sky130_fd_sc_hd__tapvpwrvgnd_1
XTAP_TAPCELL_ROW_52_1141 VSS VDD sky130_fd_sc_hd__tapvpwrvgnd_1
XTAP_TAPCELL_ROW_52_1142 VSS VDD sky130_fd_sc_hd__tapvpwrvgnd_1
XTAP_TAPCELL_ROW_52_1143 VSS VDD sky130_fd_sc_hd__tapvpwrvgnd_1
XTAP_TAPCELL_ROW_52_1144 VSS VDD sky130_fd_sc_hd__tapvpwrvgnd_1
XTAP_TAPCELL_ROW_52_1145 VSS VDD sky130_fd_sc_hd__tapvpwrvgnd_1
XTAP_TAPCELL_ROW_52_1146 VSS VDD sky130_fd_sc_hd__tapvpwrvgnd_1
XTAP_TAPCELL_ROW_52_1147 VSS VDD sky130_fd_sc_hd__tapvpwrvgnd_1
XTAP_TAPCELL_ROW_52_1148 VSS VDD sky130_fd_sc_hd__tapvpwrvgnd_1
XTAP_TAPCELL_ROW_52_1149 VSS VDD sky130_fd_sc_hd__tapvpwrvgnd_1
XTAP_TAPCELL_ROW_52_1150 VSS VDD sky130_fd_sc_hd__tapvpwrvgnd_1
XTAP_TAPCELL_ROW_52_1151 VSS VDD sky130_fd_sc_hd__tapvpwrvgnd_1
XTAP_TAPCELL_ROW_52_1152 VSS VDD sky130_fd_sc_hd__tapvpwrvgnd_1
XTAP_TAPCELL_ROW_52_1153 VSS VDD sky130_fd_sc_hd__tapvpwrvgnd_1
XTAP_TAPCELL_ROW_52_1154 VSS VDD sky130_fd_sc_hd__tapvpwrvgnd_1
XTAP_TAPCELL_ROW_52_1155 VSS VDD sky130_fd_sc_hd__tapvpwrvgnd_1
XTAP_TAPCELL_ROW_52_1156 VSS VDD sky130_fd_sc_hd__tapvpwrvgnd_1
XTAP_TAPCELL_ROW_52_1157 VSS VDD sky130_fd_sc_hd__tapvpwrvgnd_1
XTAP_TAPCELL_ROW_52_1158 VSS VDD sky130_fd_sc_hd__tapvpwrvgnd_1
XTAP_TAPCELL_ROW_52_1159 VSS VDD sky130_fd_sc_hd__tapvpwrvgnd_1
XTAP_TAPCELL_ROW_52_1160 VSS VDD sky130_fd_sc_hd__tapvpwrvgnd_1
XTAP_TAPCELL_ROW_53_1161 VSS VDD sky130_fd_sc_hd__tapvpwrvgnd_1
XTAP_TAPCELL_ROW_53_1162 VSS VDD sky130_fd_sc_hd__tapvpwrvgnd_1
XTAP_TAPCELL_ROW_53_1163 VSS VDD sky130_fd_sc_hd__tapvpwrvgnd_1
XTAP_TAPCELL_ROW_53_1164 VSS VDD sky130_fd_sc_hd__tapvpwrvgnd_1
XTAP_TAPCELL_ROW_53_1165 VSS VDD sky130_fd_sc_hd__tapvpwrvgnd_1
XTAP_TAPCELL_ROW_53_1166 VSS VDD sky130_fd_sc_hd__tapvpwrvgnd_1
XTAP_TAPCELL_ROW_53_1167 VSS VDD sky130_fd_sc_hd__tapvpwrvgnd_1
XTAP_TAPCELL_ROW_53_1168 VSS VDD sky130_fd_sc_hd__tapvpwrvgnd_1
XTAP_TAPCELL_ROW_53_1169 VSS VDD sky130_fd_sc_hd__tapvpwrvgnd_1
XTAP_TAPCELL_ROW_53_1170 VSS VDD sky130_fd_sc_hd__tapvpwrvgnd_1
XTAP_TAPCELL_ROW_53_1171 VSS VDD sky130_fd_sc_hd__tapvpwrvgnd_1
XTAP_TAPCELL_ROW_53_1172 VSS VDD sky130_fd_sc_hd__tapvpwrvgnd_1
XTAP_TAPCELL_ROW_53_1173 VSS VDD sky130_fd_sc_hd__tapvpwrvgnd_1
XTAP_TAPCELL_ROW_53_1174 VSS VDD sky130_fd_sc_hd__tapvpwrvgnd_1
XTAP_TAPCELL_ROW_53_1175 VSS VDD sky130_fd_sc_hd__tapvpwrvgnd_1
XTAP_TAPCELL_ROW_53_1176 VSS VDD sky130_fd_sc_hd__tapvpwrvgnd_1
XTAP_TAPCELL_ROW_53_1177 VSS VDD sky130_fd_sc_hd__tapvpwrvgnd_1
XTAP_TAPCELL_ROW_53_1178 VSS VDD sky130_fd_sc_hd__tapvpwrvgnd_1
XTAP_TAPCELL_ROW_53_1179 VSS VDD sky130_fd_sc_hd__tapvpwrvgnd_1
XTAP_TAPCELL_ROW_53_1180 VSS VDD sky130_fd_sc_hd__tapvpwrvgnd_1
XTAP_TAPCELL_ROW_53_1181 VSS VDD sky130_fd_sc_hd__tapvpwrvgnd_1
XTAP_TAPCELL_ROW_54_1182 VSS VDD sky130_fd_sc_hd__tapvpwrvgnd_1
XTAP_TAPCELL_ROW_54_1183 VSS VDD sky130_fd_sc_hd__tapvpwrvgnd_1
XTAP_TAPCELL_ROW_54_1184 VSS VDD sky130_fd_sc_hd__tapvpwrvgnd_1
XTAP_TAPCELL_ROW_54_1185 VSS VDD sky130_fd_sc_hd__tapvpwrvgnd_1
XTAP_TAPCELL_ROW_54_1186 VSS VDD sky130_fd_sc_hd__tapvpwrvgnd_1
XTAP_TAPCELL_ROW_54_1187 VSS VDD sky130_fd_sc_hd__tapvpwrvgnd_1
XTAP_TAPCELL_ROW_54_1188 VSS VDD sky130_fd_sc_hd__tapvpwrvgnd_1
XTAP_TAPCELL_ROW_54_1189 VSS VDD sky130_fd_sc_hd__tapvpwrvgnd_1
XTAP_TAPCELL_ROW_54_1190 VSS VDD sky130_fd_sc_hd__tapvpwrvgnd_1
XTAP_TAPCELL_ROW_54_1191 VSS VDD sky130_fd_sc_hd__tapvpwrvgnd_1
XTAP_TAPCELL_ROW_54_1192 VSS VDD sky130_fd_sc_hd__tapvpwrvgnd_1
XTAP_TAPCELL_ROW_54_1193 VSS VDD sky130_fd_sc_hd__tapvpwrvgnd_1
XTAP_TAPCELL_ROW_54_1194 VSS VDD sky130_fd_sc_hd__tapvpwrvgnd_1
XTAP_TAPCELL_ROW_54_1195 VSS VDD sky130_fd_sc_hd__tapvpwrvgnd_1
XTAP_TAPCELL_ROW_54_1196 VSS VDD sky130_fd_sc_hd__tapvpwrvgnd_1
XTAP_TAPCELL_ROW_54_1197 VSS VDD sky130_fd_sc_hd__tapvpwrvgnd_1
XTAP_TAPCELL_ROW_54_1198 VSS VDD sky130_fd_sc_hd__tapvpwrvgnd_1
XTAP_TAPCELL_ROW_54_1199 VSS VDD sky130_fd_sc_hd__tapvpwrvgnd_1
XTAP_TAPCELL_ROW_54_1200 VSS VDD sky130_fd_sc_hd__tapvpwrvgnd_1
XTAP_TAPCELL_ROW_54_1201 VSS VDD sky130_fd_sc_hd__tapvpwrvgnd_1
XTAP_TAPCELL_ROW_54_1202 VSS VDD sky130_fd_sc_hd__tapvpwrvgnd_1
XTAP_TAPCELL_ROW_54_1203 VSS VDD sky130_fd_sc_hd__tapvpwrvgnd_1
XTAP_TAPCELL_ROW_55_1204 VSS VDD sky130_fd_sc_hd__tapvpwrvgnd_1
XTAP_TAPCELL_ROW_55_1205 VSS VDD sky130_fd_sc_hd__tapvpwrvgnd_1
XTAP_TAPCELL_ROW_55_1206 VSS VDD sky130_fd_sc_hd__tapvpwrvgnd_1
XTAP_TAPCELL_ROW_55_1207 VSS VDD sky130_fd_sc_hd__tapvpwrvgnd_1
XTAP_TAPCELL_ROW_55_1208 VSS VDD sky130_fd_sc_hd__tapvpwrvgnd_1
XTAP_TAPCELL_ROW_55_1209 VSS VDD sky130_fd_sc_hd__tapvpwrvgnd_1
XTAP_TAPCELL_ROW_55_1210 VSS VDD sky130_fd_sc_hd__tapvpwrvgnd_1
XTAP_TAPCELL_ROW_55_1211 VSS VDD sky130_fd_sc_hd__tapvpwrvgnd_1
XTAP_TAPCELL_ROW_55_1212 VSS VDD sky130_fd_sc_hd__tapvpwrvgnd_1
XTAP_TAPCELL_ROW_55_1213 VSS VDD sky130_fd_sc_hd__tapvpwrvgnd_1
XTAP_TAPCELL_ROW_55_1214 VSS VDD sky130_fd_sc_hd__tapvpwrvgnd_1
XTAP_TAPCELL_ROW_55_1215 VSS VDD sky130_fd_sc_hd__tapvpwrvgnd_1
XTAP_TAPCELL_ROW_55_1216 VSS VDD sky130_fd_sc_hd__tapvpwrvgnd_1
XTAP_TAPCELL_ROW_55_1217 VSS VDD sky130_fd_sc_hd__tapvpwrvgnd_1
XTAP_TAPCELL_ROW_55_1218 VSS VDD sky130_fd_sc_hd__tapvpwrvgnd_1
XTAP_TAPCELL_ROW_55_1219 VSS VDD sky130_fd_sc_hd__tapvpwrvgnd_1
XTAP_TAPCELL_ROW_55_1220 VSS VDD sky130_fd_sc_hd__tapvpwrvgnd_1
XTAP_TAPCELL_ROW_55_1221 VSS VDD sky130_fd_sc_hd__tapvpwrvgnd_1
XTAP_TAPCELL_ROW_55_1222 VSS VDD sky130_fd_sc_hd__tapvpwrvgnd_1
XTAP_TAPCELL_ROW_55_1223 VSS VDD sky130_fd_sc_hd__tapvpwrvgnd_1
XTAP_TAPCELL_ROW_55_1224 VSS VDD sky130_fd_sc_hd__tapvpwrvgnd_1
XTAP_TAPCELL_ROW_56_1225 VSS VDD sky130_fd_sc_hd__tapvpwrvgnd_1
XTAP_TAPCELL_ROW_56_1226 VSS VDD sky130_fd_sc_hd__tapvpwrvgnd_1
XTAP_TAPCELL_ROW_56_1227 VSS VDD sky130_fd_sc_hd__tapvpwrvgnd_1
XTAP_TAPCELL_ROW_56_1228 VSS VDD sky130_fd_sc_hd__tapvpwrvgnd_1
XTAP_TAPCELL_ROW_56_1229 VSS VDD sky130_fd_sc_hd__tapvpwrvgnd_1
XTAP_TAPCELL_ROW_56_1230 VSS VDD sky130_fd_sc_hd__tapvpwrvgnd_1
XTAP_TAPCELL_ROW_56_1231 VSS VDD sky130_fd_sc_hd__tapvpwrvgnd_1
XTAP_TAPCELL_ROW_56_1232 VSS VDD sky130_fd_sc_hd__tapvpwrvgnd_1
XTAP_TAPCELL_ROW_56_1233 VSS VDD sky130_fd_sc_hd__tapvpwrvgnd_1
XTAP_TAPCELL_ROW_56_1234 VSS VDD sky130_fd_sc_hd__tapvpwrvgnd_1
XTAP_TAPCELL_ROW_56_1235 VSS VDD sky130_fd_sc_hd__tapvpwrvgnd_1
XTAP_TAPCELL_ROW_56_1236 VSS VDD sky130_fd_sc_hd__tapvpwrvgnd_1
XTAP_TAPCELL_ROW_56_1237 VSS VDD sky130_fd_sc_hd__tapvpwrvgnd_1
XTAP_TAPCELL_ROW_56_1238 VSS VDD sky130_fd_sc_hd__tapvpwrvgnd_1
XTAP_TAPCELL_ROW_56_1239 VSS VDD sky130_fd_sc_hd__tapvpwrvgnd_1
XTAP_TAPCELL_ROW_56_1240 VSS VDD sky130_fd_sc_hd__tapvpwrvgnd_1
XTAP_TAPCELL_ROW_56_1241 VSS VDD sky130_fd_sc_hd__tapvpwrvgnd_1
XTAP_TAPCELL_ROW_56_1242 VSS VDD sky130_fd_sc_hd__tapvpwrvgnd_1
XTAP_TAPCELL_ROW_56_1243 VSS VDD sky130_fd_sc_hd__tapvpwrvgnd_1
XTAP_TAPCELL_ROW_56_1244 VSS VDD sky130_fd_sc_hd__tapvpwrvgnd_1
XTAP_TAPCELL_ROW_56_1245 VSS VDD sky130_fd_sc_hd__tapvpwrvgnd_1
XTAP_TAPCELL_ROW_56_1246 VSS VDD sky130_fd_sc_hd__tapvpwrvgnd_1
XTAP_TAPCELL_ROW_57_1247 VSS VDD sky130_fd_sc_hd__tapvpwrvgnd_1
XTAP_TAPCELL_ROW_57_1248 VSS VDD sky130_fd_sc_hd__tapvpwrvgnd_1
XTAP_TAPCELL_ROW_57_1249 VSS VDD sky130_fd_sc_hd__tapvpwrvgnd_1
XTAP_TAPCELL_ROW_57_1250 VSS VDD sky130_fd_sc_hd__tapvpwrvgnd_1
XTAP_TAPCELL_ROW_57_1251 VSS VDD sky130_fd_sc_hd__tapvpwrvgnd_1
XTAP_TAPCELL_ROW_57_1252 VSS VDD sky130_fd_sc_hd__tapvpwrvgnd_1
XTAP_TAPCELL_ROW_57_1253 VSS VDD sky130_fd_sc_hd__tapvpwrvgnd_1
XTAP_TAPCELL_ROW_57_1254 VSS VDD sky130_fd_sc_hd__tapvpwrvgnd_1
XTAP_TAPCELL_ROW_57_1255 VSS VDD sky130_fd_sc_hd__tapvpwrvgnd_1
XTAP_TAPCELL_ROW_57_1256 VSS VDD sky130_fd_sc_hd__tapvpwrvgnd_1
XTAP_TAPCELL_ROW_57_1257 VSS VDD sky130_fd_sc_hd__tapvpwrvgnd_1
XTAP_TAPCELL_ROW_57_1258 VSS VDD sky130_fd_sc_hd__tapvpwrvgnd_1
XTAP_TAPCELL_ROW_57_1259 VSS VDD sky130_fd_sc_hd__tapvpwrvgnd_1
XTAP_TAPCELL_ROW_57_1260 VSS VDD sky130_fd_sc_hd__tapvpwrvgnd_1
XTAP_TAPCELL_ROW_57_1261 VSS VDD sky130_fd_sc_hd__tapvpwrvgnd_1
XTAP_TAPCELL_ROW_57_1262 VSS VDD sky130_fd_sc_hd__tapvpwrvgnd_1
XTAP_TAPCELL_ROW_57_1263 VSS VDD sky130_fd_sc_hd__tapvpwrvgnd_1
XTAP_TAPCELL_ROW_57_1264 VSS VDD sky130_fd_sc_hd__tapvpwrvgnd_1
XTAP_TAPCELL_ROW_57_1265 VSS VDD sky130_fd_sc_hd__tapvpwrvgnd_1
XTAP_TAPCELL_ROW_57_1266 VSS VDD sky130_fd_sc_hd__tapvpwrvgnd_1
XTAP_TAPCELL_ROW_57_1267 VSS VDD sky130_fd_sc_hd__tapvpwrvgnd_1
XTAP_TAPCELL_ROW_58_1268 VSS VDD sky130_fd_sc_hd__tapvpwrvgnd_1
XTAP_TAPCELL_ROW_58_1269 VSS VDD sky130_fd_sc_hd__tapvpwrvgnd_1
XTAP_TAPCELL_ROW_58_1270 VSS VDD sky130_fd_sc_hd__tapvpwrvgnd_1
XTAP_TAPCELL_ROW_58_1271 VSS VDD sky130_fd_sc_hd__tapvpwrvgnd_1
XTAP_TAPCELL_ROW_58_1272 VSS VDD sky130_fd_sc_hd__tapvpwrvgnd_1
XTAP_TAPCELL_ROW_58_1273 VSS VDD sky130_fd_sc_hd__tapvpwrvgnd_1
XTAP_TAPCELL_ROW_58_1274 VSS VDD sky130_fd_sc_hd__tapvpwrvgnd_1
XTAP_TAPCELL_ROW_58_1275 VSS VDD sky130_fd_sc_hd__tapvpwrvgnd_1
XTAP_TAPCELL_ROW_58_1276 VSS VDD sky130_fd_sc_hd__tapvpwrvgnd_1
XTAP_TAPCELL_ROW_58_1277 VSS VDD sky130_fd_sc_hd__tapvpwrvgnd_1
XTAP_TAPCELL_ROW_58_1278 VSS VDD sky130_fd_sc_hd__tapvpwrvgnd_1
XTAP_TAPCELL_ROW_58_1279 VSS VDD sky130_fd_sc_hd__tapvpwrvgnd_1
XTAP_TAPCELL_ROW_58_1280 VSS VDD sky130_fd_sc_hd__tapvpwrvgnd_1
XTAP_TAPCELL_ROW_58_1281 VSS VDD sky130_fd_sc_hd__tapvpwrvgnd_1
XTAP_TAPCELL_ROW_58_1282 VSS VDD sky130_fd_sc_hd__tapvpwrvgnd_1
XTAP_TAPCELL_ROW_58_1283 VSS VDD sky130_fd_sc_hd__tapvpwrvgnd_1
XTAP_TAPCELL_ROW_58_1284 VSS VDD sky130_fd_sc_hd__tapvpwrvgnd_1
XTAP_TAPCELL_ROW_58_1285 VSS VDD sky130_fd_sc_hd__tapvpwrvgnd_1
XTAP_TAPCELL_ROW_58_1286 VSS VDD sky130_fd_sc_hd__tapvpwrvgnd_1
XTAP_TAPCELL_ROW_58_1287 VSS VDD sky130_fd_sc_hd__tapvpwrvgnd_1
XTAP_TAPCELL_ROW_58_1288 VSS VDD sky130_fd_sc_hd__tapvpwrvgnd_1
XTAP_TAPCELL_ROW_58_1289 VSS VDD sky130_fd_sc_hd__tapvpwrvgnd_1
XTAP_TAPCELL_ROW_59_1290 VSS VDD sky130_fd_sc_hd__tapvpwrvgnd_1
XTAP_TAPCELL_ROW_59_1291 VSS VDD sky130_fd_sc_hd__tapvpwrvgnd_1
XTAP_TAPCELL_ROW_59_1292 VSS VDD sky130_fd_sc_hd__tapvpwrvgnd_1
XTAP_TAPCELL_ROW_59_1293 VSS VDD sky130_fd_sc_hd__tapvpwrvgnd_1
XTAP_TAPCELL_ROW_59_1294 VSS VDD sky130_fd_sc_hd__tapvpwrvgnd_1
XTAP_TAPCELL_ROW_59_1295 VSS VDD sky130_fd_sc_hd__tapvpwrvgnd_1
XTAP_TAPCELL_ROW_59_1296 VSS VDD sky130_fd_sc_hd__tapvpwrvgnd_1
XTAP_TAPCELL_ROW_59_1297 VSS VDD sky130_fd_sc_hd__tapvpwrvgnd_1
XTAP_TAPCELL_ROW_59_1298 VSS VDD sky130_fd_sc_hd__tapvpwrvgnd_1
XTAP_TAPCELL_ROW_59_1299 VSS VDD sky130_fd_sc_hd__tapvpwrvgnd_1
XTAP_TAPCELL_ROW_59_1300 VSS VDD sky130_fd_sc_hd__tapvpwrvgnd_1
XTAP_TAPCELL_ROW_59_1301 VSS VDD sky130_fd_sc_hd__tapvpwrvgnd_1
XTAP_TAPCELL_ROW_59_1302 VSS VDD sky130_fd_sc_hd__tapvpwrvgnd_1
XTAP_TAPCELL_ROW_59_1303 VSS VDD sky130_fd_sc_hd__tapvpwrvgnd_1
XTAP_TAPCELL_ROW_59_1304 VSS VDD sky130_fd_sc_hd__tapvpwrvgnd_1
XTAP_TAPCELL_ROW_59_1305 VSS VDD sky130_fd_sc_hd__tapvpwrvgnd_1
XTAP_TAPCELL_ROW_59_1306 VSS VDD sky130_fd_sc_hd__tapvpwrvgnd_1
XTAP_TAPCELL_ROW_59_1307 VSS VDD sky130_fd_sc_hd__tapvpwrvgnd_1
XTAP_TAPCELL_ROW_59_1308 VSS VDD sky130_fd_sc_hd__tapvpwrvgnd_1
XTAP_TAPCELL_ROW_59_1309 VSS VDD sky130_fd_sc_hd__tapvpwrvgnd_1
XTAP_TAPCELL_ROW_59_1310 VSS VDD sky130_fd_sc_hd__tapvpwrvgnd_1
XTAP_TAPCELL_ROW_60_1311 VSS VDD sky130_fd_sc_hd__tapvpwrvgnd_1
XTAP_TAPCELL_ROW_60_1312 VSS VDD sky130_fd_sc_hd__tapvpwrvgnd_1
XTAP_TAPCELL_ROW_60_1313 VSS VDD sky130_fd_sc_hd__tapvpwrvgnd_1
XTAP_TAPCELL_ROW_60_1314 VSS VDD sky130_fd_sc_hd__tapvpwrvgnd_1
XTAP_TAPCELL_ROW_60_1315 VSS VDD sky130_fd_sc_hd__tapvpwrvgnd_1
XTAP_TAPCELL_ROW_60_1316 VSS VDD sky130_fd_sc_hd__tapvpwrvgnd_1
XTAP_TAPCELL_ROW_60_1317 VSS VDD sky130_fd_sc_hd__tapvpwrvgnd_1
XTAP_TAPCELL_ROW_60_1318 VSS VDD sky130_fd_sc_hd__tapvpwrvgnd_1
XTAP_TAPCELL_ROW_60_1319 VSS VDD sky130_fd_sc_hd__tapvpwrvgnd_1
XTAP_TAPCELL_ROW_60_1320 VSS VDD sky130_fd_sc_hd__tapvpwrvgnd_1
XTAP_TAPCELL_ROW_60_1321 VSS VDD sky130_fd_sc_hd__tapvpwrvgnd_1
XTAP_TAPCELL_ROW_60_1322 VSS VDD sky130_fd_sc_hd__tapvpwrvgnd_1
XTAP_TAPCELL_ROW_60_1323 VSS VDD sky130_fd_sc_hd__tapvpwrvgnd_1
XTAP_TAPCELL_ROW_60_1324 VSS VDD sky130_fd_sc_hd__tapvpwrvgnd_1
XTAP_TAPCELL_ROW_60_1325 VSS VDD sky130_fd_sc_hd__tapvpwrvgnd_1
XTAP_TAPCELL_ROW_60_1326 VSS VDD sky130_fd_sc_hd__tapvpwrvgnd_1
XTAP_TAPCELL_ROW_60_1327 VSS VDD sky130_fd_sc_hd__tapvpwrvgnd_1
XTAP_TAPCELL_ROW_60_1328 VSS VDD sky130_fd_sc_hd__tapvpwrvgnd_1
XTAP_TAPCELL_ROW_60_1329 VSS VDD sky130_fd_sc_hd__tapvpwrvgnd_1
XTAP_TAPCELL_ROW_60_1330 VSS VDD sky130_fd_sc_hd__tapvpwrvgnd_1
XTAP_TAPCELL_ROW_60_1331 VSS VDD sky130_fd_sc_hd__tapvpwrvgnd_1
XTAP_TAPCELL_ROW_60_1332 VSS VDD sky130_fd_sc_hd__tapvpwrvgnd_1
XTAP_TAPCELL_ROW_61_1333 VSS VDD sky130_fd_sc_hd__tapvpwrvgnd_1
XTAP_TAPCELL_ROW_61_1334 VSS VDD sky130_fd_sc_hd__tapvpwrvgnd_1
XTAP_TAPCELL_ROW_61_1335 VSS VDD sky130_fd_sc_hd__tapvpwrvgnd_1
XTAP_TAPCELL_ROW_61_1336 VSS VDD sky130_fd_sc_hd__tapvpwrvgnd_1
XTAP_TAPCELL_ROW_61_1337 VSS VDD sky130_fd_sc_hd__tapvpwrvgnd_1
XTAP_TAPCELL_ROW_61_1338 VSS VDD sky130_fd_sc_hd__tapvpwrvgnd_1
XTAP_TAPCELL_ROW_61_1339 VSS VDD sky130_fd_sc_hd__tapvpwrvgnd_1
XTAP_TAPCELL_ROW_61_1340 VSS VDD sky130_fd_sc_hd__tapvpwrvgnd_1
XTAP_TAPCELL_ROW_61_1341 VSS VDD sky130_fd_sc_hd__tapvpwrvgnd_1
XTAP_TAPCELL_ROW_61_1342 VSS VDD sky130_fd_sc_hd__tapvpwrvgnd_1
XTAP_TAPCELL_ROW_61_1343 VSS VDD sky130_fd_sc_hd__tapvpwrvgnd_1
XTAP_TAPCELL_ROW_61_1344 VSS VDD sky130_fd_sc_hd__tapvpwrvgnd_1
XTAP_TAPCELL_ROW_61_1345 VSS VDD sky130_fd_sc_hd__tapvpwrvgnd_1
XTAP_TAPCELL_ROW_61_1346 VSS VDD sky130_fd_sc_hd__tapvpwrvgnd_1
XTAP_TAPCELL_ROW_61_1347 VSS VDD sky130_fd_sc_hd__tapvpwrvgnd_1
XTAP_TAPCELL_ROW_61_1348 VSS VDD sky130_fd_sc_hd__tapvpwrvgnd_1
XTAP_TAPCELL_ROW_61_1349 VSS VDD sky130_fd_sc_hd__tapvpwrvgnd_1
XTAP_TAPCELL_ROW_61_1350 VSS VDD sky130_fd_sc_hd__tapvpwrvgnd_1
XTAP_TAPCELL_ROW_61_1351 VSS VDD sky130_fd_sc_hd__tapvpwrvgnd_1
XTAP_TAPCELL_ROW_61_1352 VSS VDD sky130_fd_sc_hd__tapvpwrvgnd_1
XTAP_TAPCELL_ROW_61_1353 VSS VDD sky130_fd_sc_hd__tapvpwrvgnd_1
XTAP_TAPCELL_ROW_62_1354 VSS VDD sky130_fd_sc_hd__tapvpwrvgnd_1
XTAP_TAPCELL_ROW_62_1355 VSS VDD sky130_fd_sc_hd__tapvpwrvgnd_1
XTAP_TAPCELL_ROW_62_1356 VSS VDD sky130_fd_sc_hd__tapvpwrvgnd_1
XTAP_TAPCELL_ROW_62_1357 VSS VDD sky130_fd_sc_hd__tapvpwrvgnd_1
XTAP_TAPCELL_ROW_62_1358 VSS VDD sky130_fd_sc_hd__tapvpwrvgnd_1
XTAP_TAPCELL_ROW_62_1359 VSS VDD sky130_fd_sc_hd__tapvpwrvgnd_1
XTAP_TAPCELL_ROW_62_1360 VSS VDD sky130_fd_sc_hd__tapvpwrvgnd_1
XTAP_TAPCELL_ROW_62_1361 VSS VDD sky130_fd_sc_hd__tapvpwrvgnd_1
XTAP_TAPCELL_ROW_62_1362 VSS VDD sky130_fd_sc_hd__tapvpwrvgnd_1
XTAP_TAPCELL_ROW_62_1363 VSS VDD sky130_fd_sc_hd__tapvpwrvgnd_1
XTAP_TAPCELL_ROW_62_1364 VSS VDD sky130_fd_sc_hd__tapvpwrvgnd_1
XTAP_TAPCELL_ROW_62_1365 VSS VDD sky130_fd_sc_hd__tapvpwrvgnd_1
XTAP_TAPCELL_ROW_62_1366 VSS VDD sky130_fd_sc_hd__tapvpwrvgnd_1
XTAP_TAPCELL_ROW_62_1367 VSS VDD sky130_fd_sc_hd__tapvpwrvgnd_1
XTAP_TAPCELL_ROW_62_1368 VSS VDD sky130_fd_sc_hd__tapvpwrvgnd_1
XTAP_TAPCELL_ROW_62_1369 VSS VDD sky130_fd_sc_hd__tapvpwrvgnd_1
XTAP_TAPCELL_ROW_62_1370 VSS VDD sky130_fd_sc_hd__tapvpwrvgnd_1
XTAP_TAPCELL_ROW_62_1371 VSS VDD sky130_fd_sc_hd__tapvpwrvgnd_1
XTAP_TAPCELL_ROW_62_1372 VSS VDD sky130_fd_sc_hd__tapvpwrvgnd_1
XTAP_TAPCELL_ROW_62_1373 VSS VDD sky130_fd_sc_hd__tapvpwrvgnd_1
XTAP_TAPCELL_ROW_62_1374 VSS VDD sky130_fd_sc_hd__tapvpwrvgnd_1
XTAP_TAPCELL_ROW_62_1375 VSS VDD sky130_fd_sc_hd__tapvpwrvgnd_1
XTAP_TAPCELL_ROW_63_1376 VSS VDD sky130_fd_sc_hd__tapvpwrvgnd_1
XTAP_TAPCELL_ROW_63_1377 VSS VDD sky130_fd_sc_hd__tapvpwrvgnd_1
XTAP_TAPCELL_ROW_63_1378 VSS VDD sky130_fd_sc_hd__tapvpwrvgnd_1
XTAP_TAPCELL_ROW_63_1379 VSS VDD sky130_fd_sc_hd__tapvpwrvgnd_1
XTAP_TAPCELL_ROW_63_1380 VSS VDD sky130_fd_sc_hd__tapvpwrvgnd_1
XTAP_TAPCELL_ROW_63_1381 VSS VDD sky130_fd_sc_hd__tapvpwrvgnd_1
XTAP_TAPCELL_ROW_63_1382 VSS VDD sky130_fd_sc_hd__tapvpwrvgnd_1
XTAP_TAPCELL_ROW_63_1383 VSS VDD sky130_fd_sc_hd__tapvpwrvgnd_1
XTAP_TAPCELL_ROW_63_1384 VSS VDD sky130_fd_sc_hd__tapvpwrvgnd_1
XTAP_TAPCELL_ROW_63_1385 VSS VDD sky130_fd_sc_hd__tapvpwrvgnd_1
XTAP_TAPCELL_ROW_63_1386 VSS VDD sky130_fd_sc_hd__tapvpwrvgnd_1
XTAP_TAPCELL_ROW_63_1387 VSS VDD sky130_fd_sc_hd__tapvpwrvgnd_1
XTAP_TAPCELL_ROW_63_1388 VSS VDD sky130_fd_sc_hd__tapvpwrvgnd_1
XTAP_TAPCELL_ROW_63_1389 VSS VDD sky130_fd_sc_hd__tapvpwrvgnd_1
XTAP_TAPCELL_ROW_63_1390 VSS VDD sky130_fd_sc_hd__tapvpwrvgnd_1
XTAP_TAPCELL_ROW_63_1391 VSS VDD sky130_fd_sc_hd__tapvpwrvgnd_1
XTAP_TAPCELL_ROW_63_1392 VSS VDD sky130_fd_sc_hd__tapvpwrvgnd_1
XTAP_TAPCELL_ROW_63_1393 VSS VDD sky130_fd_sc_hd__tapvpwrvgnd_1
XTAP_TAPCELL_ROW_63_1394 VSS VDD sky130_fd_sc_hd__tapvpwrvgnd_1
XTAP_TAPCELL_ROW_63_1395 VSS VDD sky130_fd_sc_hd__tapvpwrvgnd_1
XTAP_TAPCELL_ROW_63_1396 VSS VDD sky130_fd_sc_hd__tapvpwrvgnd_1
XTAP_TAPCELL_ROW_64_1397 VSS VDD sky130_fd_sc_hd__tapvpwrvgnd_1
XTAP_TAPCELL_ROW_64_1398 VSS VDD sky130_fd_sc_hd__tapvpwrvgnd_1
XTAP_TAPCELL_ROW_64_1399 VSS VDD sky130_fd_sc_hd__tapvpwrvgnd_1
XTAP_TAPCELL_ROW_64_1400 VSS VDD sky130_fd_sc_hd__tapvpwrvgnd_1
XTAP_TAPCELL_ROW_64_1401 VSS VDD sky130_fd_sc_hd__tapvpwrvgnd_1
XTAP_TAPCELL_ROW_64_1402 VSS VDD sky130_fd_sc_hd__tapvpwrvgnd_1
XTAP_TAPCELL_ROW_64_1403 VSS VDD sky130_fd_sc_hd__tapvpwrvgnd_1
XTAP_TAPCELL_ROW_64_1404 VSS VDD sky130_fd_sc_hd__tapvpwrvgnd_1
XTAP_TAPCELL_ROW_64_1405 VSS VDD sky130_fd_sc_hd__tapvpwrvgnd_1
XTAP_TAPCELL_ROW_64_1406 VSS VDD sky130_fd_sc_hd__tapvpwrvgnd_1
XTAP_TAPCELL_ROW_64_1407 VSS VDD sky130_fd_sc_hd__tapvpwrvgnd_1
XTAP_TAPCELL_ROW_64_1408 VSS VDD sky130_fd_sc_hd__tapvpwrvgnd_1
XTAP_TAPCELL_ROW_64_1409 VSS VDD sky130_fd_sc_hd__tapvpwrvgnd_1
XTAP_TAPCELL_ROW_64_1410 VSS VDD sky130_fd_sc_hd__tapvpwrvgnd_1
XTAP_TAPCELL_ROW_64_1411 VSS VDD sky130_fd_sc_hd__tapvpwrvgnd_1
XTAP_TAPCELL_ROW_64_1412 VSS VDD sky130_fd_sc_hd__tapvpwrvgnd_1
XTAP_TAPCELL_ROW_64_1413 VSS VDD sky130_fd_sc_hd__tapvpwrvgnd_1
XTAP_TAPCELL_ROW_64_1414 VSS VDD sky130_fd_sc_hd__tapvpwrvgnd_1
XTAP_TAPCELL_ROW_64_1415 VSS VDD sky130_fd_sc_hd__tapvpwrvgnd_1
XTAP_TAPCELL_ROW_64_1416 VSS VDD sky130_fd_sc_hd__tapvpwrvgnd_1
XTAP_TAPCELL_ROW_64_1417 VSS VDD sky130_fd_sc_hd__tapvpwrvgnd_1
XTAP_TAPCELL_ROW_64_1418 VSS VDD sky130_fd_sc_hd__tapvpwrvgnd_1
XTAP_TAPCELL_ROW_65_1419 VSS VDD sky130_fd_sc_hd__tapvpwrvgnd_1
XTAP_TAPCELL_ROW_65_1420 VSS VDD sky130_fd_sc_hd__tapvpwrvgnd_1
XTAP_TAPCELL_ROW_65_1421 VSS VDD sky130_fd_sc_hd__tapvpwrvgnd_1
XTAP_TAPCELL_ROW_65_1422 VSS VDD sky130_fd_sc_hd__tapvpwrvgnd_1
XTAP_TAPCELL_ROW_65_1423 VSS VDD sky130_fd_sc_hd__tapvpwrvgnd_1
XTAP_TAPCELL_ROW_65_1424 VSS VDD sky130_fd_sc_hd__tapvpwrvgnd_1
XTAP_TAPCELL_ROW_65_1425 VSS VDD sky130_fd_sc_hd__tapvpwrvgnd_1
XTAP_TAPCELL_ROW_65_1426 VSS VDD sky130_fd_sc_hd__tapvpwrvgnd_1
XTAP_TAPCELL_ROW_65_1427 VSS VDD sky130_fd_sc_hd__tapvpwrvgnd_1
XTAP_TAPCELL_ROW_65_1428 VSS VDD sky130_fd_sc_hd__tapvpwrvgnd_1
XTAP_TAPCELL_ROW_65_1429 VSS VDD sky130_fd_sc_hd__tapvpwrvgnd_1
XTAP_TAPCELL_ROW_65_1430 VSS VDD sky130_fd_sc_hd__tapvpwrvgnd_1
XTAP_TAPCELL_ROW_65_1431 VSS VDD sky130_fd_sc_hd__tapvpwrvgnd_1
XTAP_TAPCELL_ROW_65_1432 VSS VDD sky130_fd_sc_hd__tapvpwrvgnd_1
XTAP_TAPCELL_ROW_65_1433 VSS VDD sky130_fd_sc_hd__tapvpwrvgnd_1
XTAP_TAPCELL_ROW_65_1434 VSS VDD sky130_fd_sc_hd__tapvpwrvgnd_1
XTAP_TAPCELL_ROW_65_1435 VSS VDD sky130_fd_sc_hd__tapvpwrvgnd_1
XTAP_TAPCELL_ROW_65_1436 VSS VDD sky130_fd_sc_hd__tapvpwrvgnd_1
XTAP_TAPCELL_ROW_65_1437 VSS VDD sky130_fd_sc_hd__tapvpwrvgnd_1
XTAP_TAPCELL_ROW_65_1438 VSS VDD sky130_fd_sc_hd__tapvpwrvgnd_1
XTAP_TAPCELL_ROW_65_1439 VSS VDD sky130_fd_sc_hd__tapvpwrvgnd_1
XTAP_TAPCELL_ROW_66_1440 VSS VDD sky130_fd_sc_hd__tapvpwrvgnd_1
XTAP_TAPCELL_ROW_66_1441 VSS VDD sky130_fd_sc_hd__tapvpwrvgnd_1
XTAP_TAPCELL_ROW_66_1442 VSS VDD sky130_fd_sc_hd__tapvpwrvgnd_1
XTAP_TAPCELL_ROW_66_1443 VSS VDD sky130_fd_sc_hd__tapvpwrvgnd_1
XTAP_TAPCELL_ROW_66_1444 VSS VDD sky130_fd_sc_hd__tapvpwrvgnd_1
XTAP_TAPCELL_ROW_66_1445 VSS VDD sky130_fd_sc_hd__tapvpwrvgnd_1
XTAP_TAPCELL_ROW_66_1446 VSS VDD sky130_fd_sc_hd__tapvpwrvgnd_1
XTAP_TAPCELL_ROW_66_1447 VSS VDD sky130_fd_sc_hd__tapvpwrvgnd_1
XTAP_TAPCELL_ROW_66_1448 VSS VDD sky130_fd_sc_hd__tapvpwrvgnd_1
XTAP_TAPCELL_ROW_66_1449 VSS VDD sky130_fd_sc_hd__tapvpwrvgnd_1
XTAP_TAPCELL_ROW_66_1450 VSS VDD sky130_fd_sc_hd__tapvpwrvgnd_1
XTAP_TAPCELL_ROW_66_1451 VSS VDD sky130_fd_sc_hd__tapvpwrvgnd_1
XTAP_TAPCELL_ROW_66_1452 VSS VDD sky130_fd_sc_hd__tapvpwrvgnd_1
XTAP_TAPCELL_ROW_66_1453 VSS VDD sky130_fd_sc_hd__tapvpwrvgnd_1
XTAP_TAPCELL_ROW_66_1454 VSS VDD sky130_fd_sc_hd__tapvpwrvgnd_1
XTAP_TAPCELL_ROW_66_1455 VSS VDD sky130_fd_sc_hd__tapvpwrvgnd_1
XTAP_TAPCELL_ROW_66_1456 VSS VDD sky130_fd_sc_hd__tapvpwrvgnd_1
XTAP_TAPCELL_ROW_66_1457 VSS VDD sky130_fd_sc_hd__tapvpwrvgnd_1
XTAP_TAPCELL_ROW_66_1458 VSS VDD sky130_fd_sc_hd__tapvpwrvgnd_1
XTAP_TAPCELL_ROW_66_1459 VSS VDD sky130_fd_sc_hd__tapvpwrvgnd_1
XTAP_TAPCELL_ROW_66_1460 VSS VDD sky130_fd_sc_hd__tapvpwrvgnd_1
XTAP_TAPCELL_ROW_66_1461 VSS VDD sky130_fd_sc_hd__tapvpwrvgnd_1
XTAP_TAPCELL_ROW_67_1462 VSS VDD sky130_fd_sc_hd__tapvpwrvgnd_1
XTAP_TAPCELL_ROW_67_1463 VSS VDD sky130_fd_sc_hd__tapvpwrvgnd_1
XTAP_TAPCELL_ROW_67_1464 VSS VDD sky130_fd_sc_hd__tapvpwrvgnd_1
XTAP_TAPCELL_ROW_67_1465 VSS VDD sky130_fd_sc_hd__tapvpwrvgnd_1
XTAP_TAPCELL_ROW_67_1466 VSS VDD sky130_fd_sc_hd__tapvpwrvgnd_1
XTAP_TAPCELL_ROW_67_1467 VSS VDD sky130_fd_sc_hd__tapvpwrvgnd_1
XTAP_TAPCELL_ROW_67_1468 VSS VDD sky130_fd_sc_hd__tapvpwrvgnd_1
XTAP_TAPCELL_ROW_67_1469 VSS VDD sky130_fd_sc_hd__tapvpwrvgnd_1
XTAP_TAPCELL_ROW_67_1470 VSS VDD sky130_fd_sc_hd__tapvpwrvgnd_1
XTAP_TAPCELL_ROW_67_1471 VSS VDD sky130_fd_sc_hd__tapvpwrvgnd_1
XTAP_TAPCELL_ROW_67_1472 VSS VDD sky130_fd_sc_hd__tapvpwrvgnd_1
XTAP_TAPCELL_ROW_67_1473 VSS VDD sky130_fd_sc_hd__tapvpwrvgnd_1
XTAP_TAPCELL_ROW_67_1474 VSS VDD sky130_fd_sc_hd__tapvpwrvgnd_1
XTAP_TAPCELL_ROW_67_1475 VSS VDD sky130_fd_sc_hd__tapvpwrvgnd_1
XTAP_TAPCELL_ROW_67_1476 VSS VDD sky130_fd_sc_hd__tapvpwrvgnd_1
XTAP_TAPCELL_ROW_67_1477 VSS VDD sky130_fd_sc_hd__tapvpwrvgnd_1
XTAP_TAPCELL_ROW_67_1478 VSS VDD sky130_fd_sc_hd__tapvpwrvgnd_1
XTAP_TAPCELL_ROW_67_1479 VSS VDD sky130_fd_sc_hd__tapvpwrvgnd_1
XTAP_TAPCELL_ROW_67_1480 VSS VDD sky130_fd_sc_hd__tapvpwrvgnd_1
XTAP_TAPCELL_ROW_67_1481 VSS VDD sky130_fd_sc_hd__tapvpwrvgnd_1
XTAP_TAPCELL_ROW_67_1482 VSS VDD sky130_fd_sc_hd__tapvpwrvgnd_1
XTAP_TAPCELL_ROW_68_1483 VSS VDD sky130_fd_sc_hd__tapvpwrvgnd_1
XTAP_TAPCELL_ROW_68_1484 VSS VDD sky130_fd_sc_hd__tapvpwrvgnd_1
XTAP_TAPCELL_ROW_68_1485 VSS VDD sky130_fd_sc_hd__tapvpwrvgnd_1
XTAP_TAPCELL_ROW_68_1486 VSS VDD sky130_fd_sc_hd__tapvpwrvgnd_1
XTAP_TAPCELL_ROW_68_1487 VSS VDD sky130_fd_sc_hd__tapvpwrvgnd_1
XTAP_TAPCELL_ROW_68_1488 VSS VDD sky130_fd_sc_hd__tapvpwrvgnd_1
XTAP_TAPCELL_ROW_68_1489 VSS VDD sky130_fd_sc_hd__tapvpwrvgnd_1
XTAP_TAPCELL_ROW_68_1490 VSS VDD sky130_fd_sc_hd__tapvpwrvgnd_1
XTAP_TAPCELL_ROW_68_1491 VSS VDD sky130_fd_sc_hd__tapvpwrvgnd_1
XTAP_TAPCELL_ROW_68_1492 VSS VDD sky130_fd_sc_hd__tapvpwrvgnd_1
XTAP_TAPCELL_ROW_68_1493 VSS VDD sky130_fd_sc_hd__tapvpwrvgnd_1
XTAP_TAPCELL_ROW_68_1494 VSS VDD sky130_fd_sc_hd__tapvpwrvgnd_1
XTAP_TAPCELL_ROW_68_1495 VSS VDD sky130_fd_sc_hd__tapvpwrvgnd_1
XTAP_TAPCELL_ROW_68_1496 VSS VDD sky130_fd_sc_hd__tapvpwrvgnd_1
XTAP_TAPCELL_ROW_68_1497 VSS VDD sky130_fd_sc_hd__tapvpwrvgnd_1
XTAP_TAPCELL_ROW_68_1498 VSS VDD sky130_fd_sc_hd__tapvpwrvgnd_1
XTAP_TAPCELL_ROW_68_1499 VSS VDD sky130_fd_sc_hd__tapvpwrvgnd_1
XTAP_TAPCELL_ROW_68_1500 VSS VDD sky130_fd_sc_hd__tapvpwrvgnd_1
XTAP_TAPCELL_ROW_68_1501 VSS VDD sky130_fd_sc_hd__tapvpwrvgnd_1
XTAP_TAPCELL_ROW_68_1502 VSS VDD sky130_fd_sc_hd__tapvpwrvgnd_1
XTAP_TAPCELL_ROW_68_1503 VSS VDD sky130_fd_sc_hd__tapvpwrvgnd_1
XTAP_TAPCELL_ROW_68_1504 VSS VDD sky130_fd_sc_hd__tapvpwrvgnd_1
XTAP_TAPCELL_ROW_69_1505 VSS VDD sky130_fd_sc_hd__tapvpwrvgnd_1
XTAP_TAPCELL_ROW_69_1506 VSS VDD sky130_fd_sc_hd__tapvpwrvgnd_1
XTAP_TAPCELL_ROW_69_1507 VSS VDD sky130_fd_sc_hd__tapvpwrvgnd_1
XTAP_TAPCELL_ROW_69_1508 VSS VDD sky130_fd_sc_hd__tapvpwrvgnd_1
XTAP_TAPCELL_ROW_69_1509 VSS VDD sky130_fd_sc_hd__tapvpwrvgnd_1
XTAP_TAPCELL_ROW_69_1510 VSS VDD sky130_fd_sc_hd__tapvpwrvgnd_1
XTAP_TAPCELL_ROW_69_1511 VSS VDD sky130_fd_sc_hd__tapvpwrvgnd_1
XTAP_TAPCELL_ROW_69_1512 VSS VDD sky130_fd_sc_hd__tapvpwrvgnd_1
XTAP_TAPCELL_ROW_69_1513 VSS VDD sky130_fd_sc_hd__tapvpwrvgnd_1
XTAP_TAPCELL_ROW_69_1514 VSS VDD sky130_fd_sc_hd__tapvpwrvgnd_1
XTAP_TAPCELL_ROW_69_1515 VSS VDD sky130_fd_sc_hd__tapvpwrvgnd_1
XTAP_TAPCELL_ROW_69_1516 VSS VDD sky130_fd_sc_hd__tapvpwrvgnd_1
XTAP_TAPCELL_ROW_69_1517 VSS VDD sky130_fd_sc_hd__tapvpwrvgnd_1
XTAP_TAPCELL_ROW_69_1518 VSS VDD sky130_fd_sc_hd__tapvpwrvgnd_1
XTAP_TAPCELL_ROW_69_1519 VSS VDD sky130_fd_sc_hd__tapvpwrvgnd_1
XTAP_TAPCELL_ROW_69_1520 VSS VDD sky130_fd_sc_hd__tapvpwrvgnd_1
XTAP_TAPCELL_ROW_69_1521 VSS VDD sky130_fd_sc_hd__tapvpwrvgnd_1
XTAP_TAPCELL_ROW_69_1522 VSS VDD sky130_fd_sc_hd__tapvpwrvgnd_1
XTAP_TAPCELL_ROW_69_1523 VSS VDD sky130_fd_sc_hd__tapvpwrvgnd_1
XTAP_TAPCELL_ROW_69_1524 VSS VDD sky130_fd_sc_hd__tapvpwrvgnd_1
XTAP_TAPCELL_ROW_69_1525 VSS VDD sky130_fd_sc_hd__tapvpwrvgnd_1
XTAP_TAPCELL_ROW_70_1526 VSS VDD sky130_fd_sc_hd__tapvpwrvgnd_1
XTAP_TAPCELL_ROW_70_1527 VSS VDD sky130_fd_sc_hd__tapvpwrvgnd_1
XTAP_TAPCELL_ROW_70_1528 VSS VDD sky130_fd_sc_hd__tapvpwrvgnd_1
XTAP_TAPCELL_ROW_70_1529 VSS VDD sky130_fd_sc_hd__tapvpwrvgnd_1
XTAP_TAPCELL_ROW_70_1530 VSS VDD sky130_fd_sc_hd__tapvpwrvgnd_1
XTAP_TAPCELL_ROW_70_1531 VSS VDD sky130_fd_sc_hd__tapvpwrvgnd_1
XTAP_TAPCELL_ROW_70_1532 VSS VDD sky130_fd_sc_hd__tapvpwrvgnd_1
XTAP_TAPCELL_ROW_70_1533 VSS VDD sky130_fd_sc_hd__tapvpwrvgnd_1
XTAP_TAPCELL_ROW_70_1534 VSS VDD sky130_fd_sc_hd__tapvpwrvgnd_1
XTAP_TAPCELL_ROW_70_1535 VSS VDD sky130_fd_sc_hd__tapvpwrvgnd_1
XTAP_TAPCELL_ROW_70_1536 VSS VDD sky130_fd_sc_hd__tapvpwrvgnd_1
XTAP_TAPCELL_ROW_70_1537 VSS VDD sky130_fd_sc_hd__tapvpwrvgnd_1
XTAP_TAPCELL_ROW_70_1538 VSS VDD sky130_fd_sc_hd__tapvpwrvgnd_1
XTAP_TAPCELL_ROW_70_1539 VSS VDD sky130_fd_sc_hd__tapvpwrvgnd_1
XTAP_TAPCELL_ROW_70_1540 VSS VDD sky130_fd_sc_hd__tapvpwrvgnd_1
XTAP_TAPCELL_ROW_70_1541 VSS VDD sky130_fd_sc_hd__tapvpwrvgnd_1
XTAP_TAPCELL_ROW_70_1542 VSS VDD sky130_fd_sc_hd__tapvpwrvgnd_1
XTAP_TAPCELL_ROW_70_1543 VSS VDD sky130_fd_sc_hd__tapvpwrvgnd_1
XTAP_TAPCELL_ROW_70_1544 VSS VDD sky130_fd_sc_hd__tapvpwrvgnd_1
XTAP_TAPCELL_ROW_70_1545 VSS VDD sky130_fd_sc_hd__tapvpwrvgnd_1
XTAP_TAPCELL_ROW_70_1546 VSS VDD sky130_fd_sc_hd__tapvpwrvgnd_1
XTAP_TAPCELL_ROW_70_1547 VSS VDD sky130_fd_sc_hd__tapvpwrvgnd_1
XTAP_TAPCELL_ROW_71_1548 VSS VDD sky130_fd_sc_hd__tapvpwrvgnd_1
XTAP_TAPCELL_ROW_71_1549 VSS VDD sky130_fd_sc_hd__tapvpwrvgnd_1
XTAP_TAPCELL_ROW_71_1550 VSS VDD sky130_fd_sc_hd__tapvpwrvgnd_1
XTAP_TAPCELL_ROW_71_1551 VSS VDD sky130_fd_sc_hd__tapvpwrvgnd_1
XTAP_TAPCELL_ROW_71_1552 VSS VDD sky130_fd_sc_hd__tapvpwrvgnd_1
XTAP_TAPCELL_ROW_71_1553 VSS VDD sky130_fd_sc_hd__tapvpwrvgnd_1
XTAP_TAPCELL_ROW_71_1554 VSS VDD sky130_fd_sc_hd__tapvpwrvgnd_1
XTAP_TAPCELL_ROW_71_1555 VSS VDD sky130_fd_sc_hd__tapvpwrvgnd_1
XTAP_TAPCELL_ROW_71_1556 VSS VDD sky130_fd_sc_hd__tapvpwrvgnd_1
XTAP_TAPCELL_ROW_71_1557 VSS VDD sky130_fd_sc_hd__tapvpwrvgnd_1
XTAP_TAPCELL_ROW_71_1558 VSS VDD sky130_fd_sc_hd__tapvpwrvgnd_1
XTAP_TAPCELL_ROW_71_1559 VSS VDD sky130_fd_sc_hd__tapvpwrvgnd_1
XTAP_TAPCELL_ROW_71_1560 VSS VDD sky130_fd_sc_hd__tapvpwrvgnd_1
XTAP_TAPCELL_ROW_71_1561 VSS VDD sky130_fd_sc_hd__tapvpwrvgnd_1
XTAP_TAPCELL_ROW_71_1562 VSS VDD sky130_fd_sc_hd__tapvpwrvgnd_1
XTAP_TAPCELL_ROW_71_1563 VSS VDD sky130_fd_sc_hd__tapvpwrvgnd_1
XTAP_TAPCELL_ROW_71_1564 VSS VDD sky130_fd_sc_hd__tapvpwrvgnd_1
XTAP_TAPCELL_ROW_71_1565 VSS VDD sky130_fd_sc_hd__tapvpwrvgnd_1
XTAP_TAPCELL_ROW_71_1566 VSS VDD sky130_fd_sc_hd__tapvpwrvgnd_1
XTAP_TAPCELL_ROW_71_1567 VSS VDD sky130_fd_sc_hd__tapvpwrvgnd_1
XTAP_TAPCELL_ROW_71_1568 VSS VDD sky130_fd_sc_hd__tapvpwrvgnd_1
XTAP_TAPCELL_ROW_72_1569 VSS VDD sky130_fd_sc_hd__tapvpwrvgnd_1
XTAP_TAPCELL_ROW_72_1570 VSS VDD sky130_fd_sc_hd__tapvpwrvgnd_1
XTAP_TAPCELL_ROW_72_1571 VSS VDD sky130_fd_sc_hd__tapvpwrvgnd_1
XTAP_TAPCELL_ROW_72_1572 VSS VDD sky130_fd_sc_hd__tapvpwrvgnd_1
XTAP_TAPCELL_ROW_72_1573 VSS VDD sky130_fd_sc_hd__tapvpwrvgnd_1
XTAP_TAPCELL_ROW_72_1574 VSS VDD sky130_fd_sc_hd__tapvpwrvgnd_1
XTAP_TAPCELL_ROW_72_1575 VSS VDD sky130_fd_sc_hd__tapvpwrvgnd_1
XTAP_TAPCELL_ROW_72_1576 VSS VDD sky130_fd_sc_hd__tapvpwrvgnd_1
XTAP_TAPCELL_ROW_72_1577 VSS VDD sky130_fd_sc_hd__tapvpwrvgnd_1
XTAP_TAPCELL_ROW_72_1578 VSS VDD sky130_fd_sc_hd__tapvpwrvgnd_1
XTAP_TAPCELL_ROW_72_1579 VSS VDD sky130_fd_sc_hd__tapvpwrvgnd_1
XTAP_TAPCELL_ROW_72_1580 VSS VDD sky130_fd_sc_hd__tapvpwrvgnd_1
XTAP_TAPCELL_ROW_72_1581 VSS VDD sky130_fd_sc_hd__tapvpwrvgnd_1
XTAP_TAPCELL_ROW_72_1582 VSS VDD sky130_fd_sc_hd__tapvpwrvgnd_1
XTAP_TAPCELL_ROW_72_1583 VSS VDD sky130_fd_sc_hd__tapvpwrvgnd_1
XTAP_TAPCELL_ROW_72_1584 VSS VDD sky130_fd_sc_hd__tapvpwrvgnd_1
XTAP_TAPCELL_ROW_72_1585 VSS VDD sky130_fd_sc_hd__tapvpwrvgnd_1
XTAP_TAPCELL_ROW_72_1586 VSS VDD sky130_fd_sc_hd__tapvpwrvgnd_1
XTAP_TAPCELL_ROW_72_1587 VSS VDD sky130_fd_sc_hd__tapvpwrvgnd_1
XTAP_TAPCELL_ROW_72_1588 VSS VDD sky130_fd_sc_hd__tapvpwrvgnd_1
XTAP_TAPCELL_ROW_72_1589 VSS VDD sky130_fd_sc_hd__tapvpwrvgnd_1
XTAP_TAPCELL_ROW_72_1590 VSS VDD sky130_fd_sc_hd__tapvpwrvgnd_1
XTAP_TAPCELL_ROW_73_1591 VSS VDD sky130_fd_sc_hd__tapvpwrvgnd_1
XTAP_TAPCELL_ROW_73_1592 VSS VDD sky130_fd_sc_hd__tapvpwrvgnd_1
XTAP_TAPCELL_ROW_73_1593 VSS VDD sky130_fd_sc_hd__tapvpwrvgnd_1
XTAP_TAPCELL_ROW_73_1594 VSS VDD sky130_fd_sc_hd__tapvpwrvgnd_1
XTAP_TAPCELL_ROW_73_1595 VSS VDD sky130_fd_sc_hd__tapvpwrvgnd_1
XTAP_TAPCELL_ROW_73_1596 VSS VDD sky130_fd_sc_hd__tapvpwrvgnd_1
XTAP_TAPCELL_ROW_73_1597 VSS VDD sky130_fd_sc_hd__tapvpwrvgnd_1
XTAP_TAPCELL_ROW_73_1598 VSS VDD sky130_fd_sc_hd__tapvpwrvgnd_1
XTAP_TAPCELL_ROW_73_1599 VSS VDD sky130_fd_sc_hd__tapvpwrvgnd_1
XTAP_TAPCELL_ROW_73_1600 VSS VDD sky130_fd_sc_hd__tapvpwrvgnd_1
XTAP_TAPCELL_ROW_73_1601 VSS VDD sky130_fd_sc_hd__tapvpwrvgnd_1
XTAP_TAPCELL_ROW_73_1602 VSS VDD sky130_fd_sc_hd__tapvpwrvgnd_1
XTAP_TAPCELL_ROW_73_1603 VSS VDD sky130_fd_sc_hd__tapvpwrvgnd_1
XTAP_TAPCELL_ROW_73_1604 VSS VDD sky130_fd_sc_hd__tapvpwrvgnd_1
XTAP_TAPCELL_ROW_73_1605 VSS VDD sky130_fd_sc_hd__tapvpwrvgnd_1
XTAP_TAPCELL_ROW_73_1606 VSS VDD sky130_fd_sc_hd__tapvpwrvgnd_1
XTAP_TAPCELL_ROW_73_1607 VSS VDD sky130_fd_sc_hd__tapvpwrvgnd_1
XTAP_TAPCELL_ROW_73_1608 VSS VDD sky130_fd_sc_hd__tapvpwrvgnd_1
XTAP_TAPCELL_ROW_73_1609 VSS VDD sky130_fd_sc_hd__tapvpwrvgnd_1
XTAP_TAPCELL_ROW_73_1610 VSS VDD sky130_fd_sc_hd__tapvpwrvgnd_1
XTAP_TAPCELL_ROW_73_1611 VSS VDD sky130_fd_sc_hd__tapvpwrvgnd_1
XTAP_TAPCELL_ROW_74_1612 VSS VDD sky130_fd_sc_hd__tapvpwrvgnd_1
XTAP_TAPCELL_ROW_74_1613 VSS VDD sky130_fd_sc_hd__tapvpwrvgnd_1
XTAP_TAPCELL_ROW_74_1614 VSS VDD sky130_fd_sc_hd__tapvpwrvgnd_1
XTAP_TAPCELL_ROW_74_1615 VSS VDD sky130_fd_sc_hd__tapvpwrvgnd_1
XTAP_TAPCELL_ROW_74_1616 VSS VDD sky130_fd_sc_hd__tapvpwrvgnd_1
XTAP_TAPCELL_ROW_74_1617 VSS VDD sky130_fd_sc_hd__tapvpwrvgnd_1
XTAP_TAPCELL_ROW_74_1618 VSS VDD sky130_fd_sc_hd__tapvpwrvgnd_1
XTAP_TAPCELL_ROW_74_1619 VSS VDD sky130_fd_sc_hd__tapvpwrvgnd_1
XTAP_TAPCELL_ROW_74_1620 VSS VDD sky130_fd_sc_hd__tapvpwrvgnd_1
XTAP_TAPCELL_ROW_74_1621 VSS VDD sky130_fd_sc_hd__tapvpwrvgnd_1
XTAP_TAPCELL_ROW_74_1622 VSS VDD sky130_fd_sc_hd__tapvpwrvgnd_1
XTAP_TAPCELL_ROW_74_1623 VSS VDD sky130_fd_sc_hd__tapvpwrvgnd_1
XTAP_TAPCELL_ROW_74_1624 VSS VDD sky130_fd_sc_hd__tapvpwrvgnd_1
XTAP_TAPCELL_ROW_74_1625 VSS VDD sky130_fd_sc_hd__tapvpwrvgnd_1
XTAP_TAPCELL_ROW_74_1626 VSS VDD sky130_fd_sc_hd__tapvpwrvgnd_1
XTAP_TAPCELL_ROW_74_1627 VSS VDD sky130_fd_sc_hd__tapvpwrvgnd_1
XTAP_TAPCELL_ROW_74_1628 VSS VDD sky130_fd_sc_hd__tapvpwrvgnd_1
XTAP_TAPCELL_ROW_74_1629 VSS VDD sky130_fd_sc_hd__tapvpwrvgnd_1
XTAP_TAPCELL_ROW_74_1630 VSS VDD sky130_fd_sc_hd__tapvpwrvgnd_1
XTAP_TAPCELL_ROW_74_1631 VSS VDD sky130_fd_sc_hd__tapvpwrvgnd_1
XTAP_TAPCELL_ROW_74_1632 VSS VDD sky130_fd_sc_hd__tapvpwrvgnd_1
XTAP_TAPCELL_ROW_74_1633 VSS VDD sky130_fd_sc_hd__tapvpwrvgnd_1
XTAP_TAPCELL_ROW_75_1634 VSS VDD sky130_fd_sc_hd__tapvpwrvgnd_1
XTAP_TAPCELL_ROW_75_1635 VSS VDD sky130_fd_sc_hd__tapvpwrvgnd_1
XTAP_TAPCELL_ROW_75_1636 VSS VDD sky130_fd_sc_hd__tapvpwrvgnd_1
XTAP_TAPCELL_ROW_75_1637 VSS VDD sky130_fd_sc_hd__tapvpwrvgnd_1
XTAP_TAPCELL_ROW_75_1638 VSS VDD sky130_fd_sc_hd__tapvpwrvgnd_1
XTAP_TAPCELL_ROW_75_1639 VSS VDD sky130_fd_sc_hd__tapvpwrvgnd_1
XTAP_TAPCELL_ROW_75_1640 VSS VDD sky130_fd_sc_hd__tapvpwrvgnd_1
XTAP_TAPCELL_ROW_75_1641 VSS VDD sky130_fd_sc_hd__tapvpwrvgnd_1
XTAP_TAPCELL_ROW_75_1642 VSS VDD sky130_fd_sc_hd__tapvpwrvgnd_1
XTAP_TAPCELL_ROW_75_1643 VSS VDD sky130_fd_sc_hd__tapvpwrvgnd_1
XTAP_TAPCELL_ROW_75_1644 VSS VDD sky130_fd_sc_hd__tapvpwrvgnd_1
XTAP_TAPCELL_ROW_75_1645 VSS VDD sky130_fd_sc_hd__tapvpwrvgnd_1
XTAP_TAPCELL_ROW_75_1646 VSS VDD sky130_fd_sc_hd__tapvpwrvgnd_1
XTAP_TAPCELL_ROW_75_1647 VSS VDD sky130_fd_sc_hd__tapvpwrvgnd_1
XTAP_TAPCELL_ROW_75_1648 VSS VDD sky130_fd_sc_hd__tapvpwrvgnd_1
XTAP_TAPCELL_ROW_75_1649 VSS VDD sky130_fd_sc_hd__tapvpwrvgnd_1
XTAP_TAPCELL_ROW_75_1650 VSS VDD sky130_fd_sc_hd__tapvpwrvgnd_1
XTAP_TAPCELL_ROW_75_1651 VSS VDD sky130_fd_sc_hd__tapvpwrvgnd_1
XTAP_TAPCELL_ROW_75_1652 VSS VDD sky130_fd_sc_hd__tapvpwrvgnd_1
XTAP_TAPCELL_ROW_75_1653 VSS VDD sky130_fd_sc_hd__tapvpwrvgnd_1
XTAP_TAPCELL_ROW_75_1654 VSS VDD sky130_fd_sc_hd__tapvpwrvgnd_1
XTAP_TAPCELL_ROW_76_1655 VSS VDD sky130_fd_sc_hd__tapvpwrvgnd_1
XTAP_TAPCELL_ROW_76_1656 VSS VDD sky130_fd_sc_hd__tapvpwrvgnd_1
XTAP_TAPCELL_ROW_76_1657 VSS VDD sky130_fd_sc_hd__tapvpwrvgnd_1
XTAP_TAPCELL_ROW_76_1658 VSS VDD sky130_fd_sc_hd__tapvpwrvgnd_1
XTAP_TAPCELL_ROW_76_1659 VSS VDD sky130_fd_sc_hd__tapvpwrvgnd_1
XTAP_TAPCELL_ROW_76_1660 VSS VDD sky130_fd_sc_hd__tapvpwrvgnd_1
XTAP_TAPCELL_ROW_76_1661 VSS VDD sky130_fd_sc_hd__tapvpwrvgnd_1
XTAP_TAPCELL_ROW_76_1662 VSS VDD sky130_fd_sc_hd__tapvpwrvgnd_1
XTAP_TAPCELL_ROW_76_1663 VSS VDD sky130_fd_sc_hd__tapvpwrvgnd_1
XTAP_TAPCELL_ROW_76_1664 VSS VDD sky130_fd_sc_hd__tapvpwrvgnd_1
XTAP_TAPCELL_ROW_76_1665 VSS VDD sky130_fd_sc_hd__tapvpwrvgnd_1
XTAP_TAPCELL_ROW_76_1666 VSS VDD sky130_fd_sc_hd__tapvpwrvgnd_1
XTAP_TAPCELL_ROW_76_1667 VSS VDD sky130_fd_sc_hd__tapvpwrvgnd_1
XTAP_TAPCELL_ROW_76_1668 VSS VDD sky130_fd_sc_hd__tapvpwrvgnd_1
XTAP_TAPCELL_ROW_76_1669 VSS VDD sky130_fd_sc_hd__tapvpwrvgnd_1
XTAP_TAPCELL_ROW_76_1670 VSS VDD sky130_fd_sc_hd__tapvpwrvgnd_1
XTAP_TAPCELL_ROW_76_1671 VSS VDD sky130_fd_sc_hd__tapvpwrvgnd_1
XTAP_TAPCELL_ROW_76_1672 VSS VDD sky130_fd_sc_hd__tapvpwrvgnd_1
XTAP_TAPCELL_ROW_76_1673 VSS VDD sky130_fd_sc_hd__tapvpwrvgnd_1
XTAP_TAPCELL_ROW_76_1674 VSS VDD sky130_fd_sc_hd__tapvpwrvgnd_1
XTAP_TAPCELL_ROW_76_1675 VSS VDD sky130_fd_sc_hd__tapvpwrvgnd_1
XTAP_TAPCELL_ROW_76_1676 VSS VDD sky130_fd_sc_hd__tapvpwrvgnd_1
XTAP_TAPCELL_ROW_77_1677 VSS VDD sky130_fd_sc_hd__tapvpwrvgnd_1
XTAP_TAPCELL_ROW_77_1678 VSS VDD sky130_fd_sc_hd__tapvpwrvgnd_1
XTAP_TAPCELL_ROW_77_1679 VSS VDD sky130_fd_sc_hd__tapvpwrvgnd_1
XTAP_TAPCELL_ROW_77_1680 VSS VDD sky130_fd_sc_hd__tapvpwrvgnd_1
XTAP_TAPCELL_ROW_77_1681 VSS VDD sky130_fd_sc_hd__tapvpwrvgnd_1
XTAP_TAPCELL_ROW_77_1682 VSS VDD sky130_fd_sc_hd__tapvpwrvgnd_1
XTAP_TAPCELL_ROW_77_1683 VSS VDD sky130_fd_sc_hd__tapvpwrvgnd_1
XTAP_TAPCELL_ROW_77_1684 VSS VDD sky130_fd_sc_hd__tapvpwrvgnd_1
XTAP_TAPCELL_ROW_77_1685 VSS VDD sky130_fd_sc_hd__tapvpwrvgnd_1
XTAP_TAPCELL_ROW_77_1686 VSS VDD sky130_fd_sc_hd__tapvpwrvgnd_1
XTAP_TAPCELL_ROW_77_1687 VSS VDD sky130_fd_sc_hd__tapvpwrvgnd_1
XTAP_TAPCELL_ROW_77_1688 VSS VDD sky130_fd_sc_hd__tapvpwrvgnd_1
XTAP_TAPCELL_ROW_77_1689 VSS VDD sky130_fd_sc_hd__tapvpwrvgnd_1
XTAP_TAPCELL_ROW_77_1690 VSS VDD sky130_fd_sc_hd__tapvpwrvgnd_1
XTAP_TAPCELL_ROW_77_1691 VSS VDD sky130_fd_sc_hd__tapvpwrvgnd_1
XTAP_TAPCELL_ROW_77_1692 VSS VDD sky130_fd_sc_hd__tapvpwrvgnd_1
XTAP_TAPCELL_ROW_77_1693 VSS VDD sky130_fd_sc_hd__tapvpwrvgnd_1
XTAP_TAPCELL_ROW_77_1694 VSS VDD sky130_fd_sc_hd__tapvpwrvgnd_1
XTAP_TAPCELL_ROW_77_1695 VSS VDD sky130_fd_sc_hd__tapvpwrvgnd_1
XTAP_TAPCELL_ROW_77_1696 VSS VDD sky130_fd_sc_hd__tapvpwrvgnd_1
XTAP_TAPCELL_ROW_77_1697 VSS VDD sky130_fd_sc_hd__tapvpwrvgnd_1
XTAP_TAPCELL_ROW_78_1698 VSS VDD sky130_fd_sc_hd__tapvpwrvgnd_1
XTAP_TAPCELL_ROW_78_1699 VSS VDD sky130_fd_sc_hd__tapvpwrvgnd_1
XTAP_TAPCELL_ROW_78_1700 VSS VDD sky130_fd_sc_hd__tapvpwrvgnd_1
XTAP_TAPCELL_ROW_78_1701 VSS VDD sky130_fd_sc_hd__tapvpwrvgnd_1
XTAP_TAPCELL_ROW_78_1702 VSS VDD sky130_fd_sc_hd__tapvpwrvgnd_1
XTAP_TAPCELL_ROW_78_1703 VSS VDD sky130_fd_sc_hd__tapvpwrvgnd_1
XTAP_TAPCELL_ROW_78_1704 VSS VDD sky130_fd_sc_hd__tapvpwrvgnd_1
XTAP_TAPCELL_ROW_78_1705 VSS VDD sky130_fd_sc_hd__tapvpwrvgnd_1
XTAP_TAPCELL_ROW_78_1706 VSS VDD sky130_fd_sc_hd__tapvpwrvgnd_1
XTAP_TAPCELL_ROW_78_1707 VSS VDD sky130_fd_sc_hd__tapvpwrvgnd_1
XTAP_TAPCELL_ROW_78_1708 VSS VDD sky130_fd_sc_hd__tapvpwrvgnd_1
XTAP_TAPCELL_ROW_78_1709 VSS VDD sky130_fd_sc_hd__tapvpwrvgnd_1
XTAP_TAPCELL_ROW_78_1710 VSS VDD sky130_fd_sc_hd__tapvpwrvgnd_1
XTAP_TAPCELL_ROW_78_1711 VSS VDD sky130_fd_sc_hd__tapvpwrvgnd_1
XTAP_TAPCELL_ROW_78_1712 VSS VDD sky130_fd_sc_hd__tapvpwrvgnd_1
XTAP_TAPCELL_ROW_78_1713 VSS VDD sky130_fd_sc_hd__tapvpwrvgnd_1
XTAP_TAPCELL_ROW_78_1714 VSS VDD sky130_fd_sc_hd__tapvpwrvgnd_1
XTAP_TAPCELL_ROW_78_1715 VSS VDD sky130_fd_sc_hd__tapvpwrvgnd_1
XTAP_TAPCELL_ROW_78_1716 VSS VDD sky130_fd_sc_hd__tapvpwrvgnd_1
XTAP_TAPCELL_ROW_78_1717 VSS VDD sky130_fd_sc_hd__tapvpwrvgnd_1
XTAP_TAPCELL_ROW_78_1718 VSS VDD sky130_fd_sc_hd__tapvpwrvgnd_1
XTAP_TAPCELL_ROW_78_1719 VSS VDD sky130_fd_sc_hd__tapvpwrvgnd_1
XTAP_TAPCELL_ROW_79_1720 VSS VDD sky130_fd_sc_hd__tapvpwrvgnd_1
XTAP_TAPCELL_ROW_79_1721 VSS VDD sky130_fd_sc_hd__tapvpwrvgnd_1
XTAP_TAPCELL_ROW_79_1722 VSS VDD sky130_fd_sc_hd__tapvpwrvgnd_1
XTAP_TAPCELL_ROW_79_1723 VSS VDD sky130_fd_sc_hd__tapvpwrvgnd_1
XTAP_TAPCELL_ROW_79_1724 VSS VDD sky130_fd_sc_hd__tapvpwrvgnd_1
XTAP_TAPCELL_ROW_79_1725 VSS VDD sky130_fd_sc_hd__tapvpwrvgnd_1
XTAP_TAPCELL_ROW_79_1726 VSS VDD sky130_fd_sc_hd__tapvpwrvgnd_1
XTAP_TAPCELL_ROW_79_1727 VSS VDD sky130_fd_sc_hd__tapvpwrvgnd_1
XTAP_TAPCELL_ROW_79_1728 VSS VDD sky130_fd_sc_hd__tapvpwrvgnd_1
XTAP_TAPCELL_ROW_79_1729 VSS VDD sky130_fd_sc_hd__tapvpwrvgnd_1
XTAP_TAPCELL_ROW_79_1730 VSS VDD sky130_fd_sc_hd__tapvpwrvgnd_1
XTAP_TAPCELL_ROW_79_1731 VSS VDD sky130_fd_sc_hd__tapvpwrvgnd_1
XTAP_TAPCELL_ROW_79_1732 VSS VDD sky130_fd_sc_hd__tapvpwrvgnd_1
XTAP_TAPCELL_ROW_79_1733 VSS VDD sky130_fd_sc_hd__tapvpwrvgnd_1
XTAP_TAPCELL_ROW_79_1734 VSS VDD sky130_fd_sc_hd__tapvpwrvgnd_1
XTAP_TAPCELL_ROW_79_1735 VSS VDD sky130_fd_sc_hd__tapvpwrvgnd_1
XTAP_TAPCELL_ROW_79_1736 VSS VDD sky130_fd_sc_hd__tapvpwrvgnd_1
XTAP_TAPCELL_ROW_79_1737 VSS VDD sky130_fd_sc_hd__tapvpwrvgnd_1
XTAP_TAPCELL_ROW_79_1738 VSS VDD sky130_fd_sc_hd__tapvpwrvgnd_1
XTAP_TAPCELL_ROW_79_1739 VSS VDD sky130_fd_sc_hd__tapvpwrvgnd_1
XTAP_TAPCELL_ROW_79_1740 VSS VDD sky130_fd_sc_hd__tapvpwrvgnd_1
XTAP_TAPCELL_ROW_80_1741 VSS VDD sky130_fd_sc_hd__tapvpwrvgnd_1
XTAP_TAPCELL_ROW_80_1742 VSS VDD sky130_fd_sc_hd__tapvpwrvgnd_1
XTAP_TAPCELL_ROW_80_1743 VSS VDD sky130_fd_sc_hd__tapvpwrvgnd_1
XTAP_TAPCELL_ROW_80_1744 VSS VDD sky130_fd_sc_hd__tapvpwrvgnd_1
XTAP_TAPCELL_ROW_80_1745 VSS VDD sky130_fd_sc_hd__tapvpwrvgnd_1
XTAP_TAPCELL_ROW_80_1746 VSS VDD sky130_fd_sc_hd__tapvpwrvgnd_1
XTAP_TAPCELL_ROW_80_1747 VSS VDD sky130_fd_sc_hd__tapvpwrvgnd_1
XTAP_TAPCELL_ROW_80_1748 VSS VDD sky130_fd_sc_hd__tapvpwrvgnd_1
XTAP_TAPCELL_ROW_80_1749 VSS VDD sky130_fd_sc_hd__tapvpwrvgnd_1
XTAP_TAPCELL_ROW_80_1750 VSS VDD sky130_fd_sc_hd__tapvpwrvgnd_1
XTAP_TAPCELL_ROW_80_1751 VSS VDD sky130_fd_sc_hd__tapvpwrvgnd_1
XTAP_TAPCELL_ROW_80_1752 VSS VDD sky130_fd_sc_hd__tapvpwrvgnd_1
XTAP_TAPCELL_ROW_80_1753 VSS VDD sky130_fd_sc_hd__tapvpwrvgnd_1
XTAP_TAPCELL_ROW_80_1754 VSS VDD sky130_fd_sc_hd__tapvpwrvgnd_1
XTAP_TAPCELL_ROW_80_1755 VSS VDD sky130_fd_sc_hd__tapvpwrvgnd_1
XTAP_TAPCELL_ROW_80_1756 VSS VDD sky130_fd_sc_hd__tapvpwrvgnd_1
XTAP_TAPCELL_ROW_80_1757 VSS VDD sky130_fd_sc_hd__tapvpwrvgnd_1
XTAP_TAPCELL_ROW_80_1758 VSS VDD sky130_fd_sc_hd__tapvpwrvgnd_1
XTAP_TAPCELL_ROW_80_1759 VSS VDD sky130_fd_sc_hd__tapvpwrvgnd_1
XTAP_TAPCELL_ROW_80_1760 VSS VDD sky130_fd_sc_hd__tapvpwrvgnd_1
XTAP_TAPCELL_ROW_80_1761 VSS VDD sky130_fd_sc_hd__tapvpwrvgnd_1
XTAP_TAPCELL_ROW_80_1762 VSS VDD sky130_fd_sc_hd__tapvpwrvgnd_1
XTAP_TAPCELL_ROW_81_1763 VSS VDD sky130_fd_sc_hd__tapvpwrvgnd_1
XTAP_TAPCELL_ROW_81_1764 VSS VDD sky130_fd_sc_hd__tapvpwrvgnd_1
XTAP_TAPCELL_ROW_81_1765 VSS VDD sky130_fd_sc_hd__tapvpwrvgnd_1
XTAP_TAPCELL_ROW_81_1766 VSS VDD sky130_fd_sc_hd__tapvpwrvgnd_1
XTAP_TAPCELL_ROW_81_1767 VSS VDD sky130_fd_sc_hd__tapvpwrvgnd_1
XTAP_TAPCELL_ROW_81_1768 VSS VDD sky130_fd_sc_hd__tapvpwrvgnd_1
XTAP_TAPCELL_ROW_81_1769 VSS VDD sky130_fd_sc_hd__tapvpwrvgnd_1
XTAP_TAPCELL_ROW_81_1770 VSS VDD sky130_fd_sc_hd__tapvpwrvgnd_1
XTAP_TAPCELL_ROW_81_1771 VSS VDD sky130_fd_sc_hd__tapvpwrvgnd_1
XTAP_TAPCELL_ROW_81_1772 VSS VDD sky130_fd_sc_hd__tapvpwrvgnd_1
XTAP_TAPCELL_ROW_81_1773 VSS VDD sky130_fd_sc_hd__tapvpwrvgnd_1
XTAP_TAPCELL_ROW_81_1774 VSS VDD sky130_fd_sc_hd__tapvpwrvgnd_1
XTAP_TAPCELL_ROW_81_1775 VSS VDD sky130_fd_sc_hd__tapvpwrvgnd_1
XTAP_TAPCELL_ROW_81_1776 VSS VDD sky130_fd_sc_hd__tapvpwrvgnd_1
XTAP_TAPCELL_ROW_81_1777 VSS VDD sky130_fd_sc_hd__tapvpwrvgnd_1
XTAP_TAPCELL_ROW_81_1778 VSS VDD sky130_fd_sc_hd__tapvpwrvgnd_1
XTAP_TAPCELL_ROW_81_1779 VSS VDD sky130_fd_sc_hd__tapvpwrvgnd_1
XTAP_TAPCELL_ROW_81_1780 VSS VDD sky130_fd_sc_hd__tapvpwrvgnd_1
XTAP_TAPCELL_ROW_81_1781 VSS VDD sky130_fd_sc_hd__tapvpwrvgnd_1
XTAP_TAPCELL_ROW_81_1782 VSS VDD sky130_fd_sc_hd__tapvpwrvgnd_1
XTAP_TAPCELL_ROW_81_1783 VSS VDD sky130_fd_sc_hd__tapvpwrvgnd_1
XTAP_TAPCELL_ROW_82_1784 VSS VDD sky130_fd_sc_hd__tapvpwrvgnd_1
XTAP_TAPCELL_ROW_82_1785 VSS VDD sky130_fd_sc_hd__tapvpwrvgnd_1
XTAP_TAPCELL_ROW_82_1786 VSS VDD sky130_fd_sc_hd__tapvpwrvgnd_1
XTAP_TAPCELL_ROW_82_1787 VSS VDD sky130_fd_sc_hd__tapvpwrvgnd_1
XTAP_TAPCELL_ROW_82_1788 VSS VDD sky130_fd_sc_hd__tapvpwrvgnd_1
XTAP_TAPCELL_ROW_82_1789 VSS VDD sky130_fd_sc_hd__tapvpwrvgnd_1
XTAP_TAPCELL_ROW_82_1790 VSS VDD sky130_fd_sc_hd__tapvpwrvgnd_1
XTAP_TAPCELL_ROW_82_1791 VSS VDD sky130_fd_sc_hd__tapvpwrvgnd_1
XTAP_TAPCELL_ROW_82_1792 VSS VDD sky130_fd_sc_hd__tapvpwrvgnd_1
XTAP_TAPCELL_ROW_82_1793 VSS VDD sky130_fd_sc_hd__tapvpwrvgnd_1
XTAP_TAPCELL_ROW_82_1794 VSS VDD sky130_fd_sc_hd__tapvpwrvgnd_1
XTAP_TAPCELL_ROW_82_1795 VSS VDD sky130_fd_sc_hd__tapvpwrvgnd_1
XTAP_TAPCELL_ROW_82_1796 VSS VDD sky130_fd_sc_hd__tapvpwrvgnd_1
XTAP_TAPCELL_ROW_82_1797 VSS VDD sky130_fd_sc_hd__tapvpwrvgnd_1
XTAP_TAPCELL_ROW_82_1798 VSS VDD sky130_fd_sc_hd__tapvpwrvgnd_1
XTAP_TAPCELL_ROW_82_1799 VSS VDD sky130_fd_sc_hd__tapvpwrvgnd_1
XTAP_TAPCELL_ROW_82_1800 VSS VDD sky130_fd_sc_hd__tapvpwrvgnd_1
XTAP_TAPCELL_ROW_82_1801 VSS VDD sky130_fd_sc_hd__tapvpwrvgnd_1
XTAP_TAPCELL_ROW_82_1802 VSS VDD sky130_fd_sc_hd__tapvpwrvgnd_1
XTAP_TAPCELL_ROW_82_1803 VSS VDD sky130_fd_sc_hd__tapvpwrvgnd_1
XTAP_TAPCELL_ROW_82_1804 VSS VDD sky130_fd_sc_hd__tapvpwrvgnd_1
XTAP_TAPCELL_ROW_82_1805 VSS VDD sky130_fd_sc_hd__tapvpwrvgnd_1
XTAP_TAPCELL_ROW_83_1806 VSS VDD sky130_fd_sc_hd__tapvpwrvgnd_1
XTAP_TAPCELL_ROW_83_1807 VSS VDD sky130_fd_sc_hd__tapvpwrvgnd_1
XTAP_TAPCELL_ROW_83_1808 VSS VDD sky130_fd_sc_hd__tapvpwrvgnd_1
XTAP_TAPCELL_ROW_83_1809 VSS VDD sky130_fd_sc_hd__tapvpwrvgnd_1
XTAP_TAPCELL_ROW_83_1810 VSS VDD sky130_fd_sc_hd__tapvpwrvgnd_1
XTAP_TAPCELL_ROW_83_1811 VSS VDD sky130_fd_sc_hd__tapvpwrvgnd_1
XTAP_TAPCELL_ROW_83_1812 VSS VDD sky130_fd_sc_hd__tapvpwrvgnd_1
XTAP_TAPCELL_ROW_83_1813 VSS VDD sky130_fd_sc_hd__tapvpwrvgnd_1
XTAP_TAPCELL_ROW_83_1814 VSS VDD sky130_fd_sc_hd__tapvpwrvgnd_1
XTAP_TAPCELL_ROW_83_1815 VSS VDD sky130_fd_sc_hd__tapvpwrvgnd_1
XTAP_TAPCELL_ROW_83_1816 VSS VDD sky130_fd_sc_hd__tapvpwrvgnd_1
XTAP_TAPCELL_ROW_83_1817 VSS VDD sky130_fd_sc_hd__tapvpwrvgnd_1
XTAP_TAPCELL_ROW_83_1818 VSS VDD sky130_fd_sc_hd__tapvpwrvgnd_1
XTAP_TAPCELL_ROW_83_1819 VSS VDD sky130_fd_sc_hd__tapvpwrvgnd_1
XTAP_TAPCELL_ROW_83_1820 VSS VDD sky130_fd_sc_hd__tapvpwrvgnd_1
XTAP_TAPCELL_ROW_83_1821 VSS VDD sky130_fd_sc_hd__tapvpwrvgnd_1
XTAP_TAPCELL_ROW_83_1822 VSS VDD sky130_fd_sc_hd__tapvpwrvgnd_1
XTAP_TAPCELL_ROW_83_1823 VSS VDD sky130_fd_sc_hd__tapvpwrvgnd_1
XTAP_TAPCELL_ROW_83_1824 VSS VDD sky130_fd_sc_hd__tapvpwrvgnd_1
XTAP_TAPCELL_ROW_83_1825 VSS VDD sky130_fd_sc_hd__tapvpwrvgnd_1
XTAP_TAPCELL_ROW_83_1826 VSS VDD sky130_fd_sc_hd__tapvpwrvgnd_1
XTAP_TAPCELL_ROW_84_1827 VSS VDD sky130_fd_sc_hd__tapvpwrvgnd_1
XTAP_TAPCELL_ROW_84_1828 VSS VDD sky130_fd_sc_hd__tapvpwrvgnd_1
XTAP_TAPCELL_ROW_84_1829 VSS VDD sky130_fd_sc_hd__tapvpwrvgnd_1
XTAP_TAPCELL_ROW_84_1830 VSS VDD sky130_fd_sc_hd__tapvpwrvgnd_1
XTAP_TAPCELL_ROW_84_1831 VSS VDD sky130_fd_sc_hd__tapvpwrvgnd_1
XTAP_TAPCELL_ROW_84_1832 VSS VDD sky130_fd_sc_hd__tapvpwrvgnd_1
XTAP_TAPCELL_ROW_84_1833 VSS VDD sky130_fd_sc_hd__tapvpwrvgnd_1
XTAP_TAPCELL_ROW_84_1834 VSS VDD sky130_fd_sc_hd__tapvpwrvgnd_1
XTAP_TAPCELL_ROW_84_1835 VSS VDD sky130_fd_sc_hd__tapvpwrvgnd_1
XTAP_TAPCELL_ROW_84_1836 VSS VDD sky130_fd_sc_hd__tapvpwrvgnd_1
XTAP_TAPCELL_ROW_84_1837 VSS VDD sky130_fd_sc_hd__tapvpwrvgnd_1
XTAP_TAPCELL_ROW_84_1838 VSS VDD sky130_fd_sc_hd__tapvpwrvgnd_1
XTAP_TAPCELL_ROW_84_1839 VSS VDD sky130_fd_sc_hd__tapvpwrvgnd_1
XTAP_TAPCELL_ROW_84_1840 VSS VDD sky130_fd_sc_hd__tapvpwrvgnd_1
XTAP_TAPCELL_ROW_84_1841 VSS VDD sky130_fd_sc_hd__tapvpwrvgnd_1
XTAP_TAPCELL_ROW_84_1842 VSS VDD sky130_fd_sc_hd__tapvpwrvgnd_1
XTAP_TAPCELL_ROW_84_1843 VSS VDD sky130_fd_sc_hd__tapvpwrvgnd_1
XTAP_TAPCELL_ROW_84_1844 VSS VDD sky130_fd_sc_hd__tapvpwrvgnd_1
XTAP_TAPCELL_ROW_84_1845 VSS VDD sky130_fd_sc_hd__tapvpwrvgnd_1
XTAP_TAPCELL_ROW_84_1846 VSS VDD sky130_fd_sc_hd__tapvpwrvgnd_1
XTAP_TAPCELL_ROW_84_1847 VSS VDD sky130_fd_sc_hd__tapvpwrvgnd_1
XTAP_TAPCELL_ROW_84_1848 VSS VDD sky130_fd_sc_hd__tapvpwrvgnd_1
XTAP_TAPCELL_ROW_85_1849 VSS VDD sky130_fd_sc_hd__tapvpwrvgnd_1
XTAP_TAPCELL_ROW_85_1850 VSS VDD sky130_fd_sc_hd__tapvpwrvgnd_1
XTAP_TAPCELL_ROW_85_1851 VSS VDD sky130_fd_sc_hd__tapvpwrvgnd_1
XTAP_TAPCELL_ROW_85_1852 VSS VDD sky130_fd_sc_hd__tapvpwrvgnd_1
XTAP_TAPCELL_ROW_85_1853 VSS VDD sky130_fd_sc_hd__tapvpwrvgnd_1
XTAP_TAPCELL_ROW_85_1854 VSS VDD sky130_fd_sc_hd__tapvpwrvgnd_1
XTAP_TAPCELL_ROW_85_1855 VSS VDD sky130_fd_sc_hd__tapvpwrvgnd_1
XTAP_TAPCELL_ROW_85_1856 VSS VDD sky130_fd_sc_hd__tapvpwrvgnd_1
XTAP_TAPCELL_ROW_85_1857 VSS VDD sky130_fd_sc_hd__tapvpwrvgnd_1
XTAP_TAPCELL_ROW_85_1858 VSS VDD sky130_fd_sc_hd__tapvpwrvgnd_1
XTAP_TAPCELL_ROW_85_1859 VSS VDD sky130_fd_sc_hd__tapvpwrvgnd_1
XTAP_TAPCELL_ROW_85_1860 VSS VDD sky130_fd_sc_hd__tapvpwrvgnd_1
XTAP_TAPCELL_ROW_85_1861 VSS VDD sky130_fd_sc_hd__tapvpwrvgnd_1
XTAP_TAPCELL_ROW_85_1862 VSS VDD sky130_fd_sc_hd__tapvpwrvgnd_1
XTAP_TAPCELL_ROW_85_1863 VSS VDD sky130_fd_sc_hd__tapvpwrvgnd_1
XTAP_TAPCELL_ROW_85_1864 VSS VDD sky130_fd_sc_hd__tapvpwrvgnd_1
XTAP_TAPCELL_ROW_85_1865 VSS VDD sky130_fd_sc_hd__tapvpwrvgnd_1
XTAP_TAPCELL_ROW_85_1866 VSS VDD sky130_fd_sc_hd__tapvpwrvgnd_1
XTAP_TAPCELL_ROW_85_1867 VSS VDD sky130_fd_sc_hd__tapvpwrvgnd_1
XTAP_TAPCELL_ROW_85_1868 VSS VDD sky130_fd_sc_hd__tapvpwrvgnd_1
XTAP_TAPCELL_ROW_85_1869 VSS VDD sky130_fd_sc_hd__tapvpwrvgnd_1
XTAP_TAPCELL_ROW_86_1870 VSS VDD sky130_fd_sc_hd__tapvpwrvgnd_1
XTAP_TAPCELL_ROW_86_1871 VSS VDD sky130_fd_sc_hd__tapvpwrvgnd_1
XTAP_TAPCELL_ROW_86_1872 VSS VDD sky130_fd_sc_hd__tapvpwrvgnd_1
XTAP_TAPCELL_ROW_86_1873 VSS VDD sky130_fd_sc_hd__tapvpwrvgnd_1
XTAP_TAPCELL_ROW_86_1874 VSS VDD sky130_fd_sc_hd__tapvpwrvgnd_1
XTAP_TAPCELL_ROW_86_1875 VSS VDD sky130_fd_sc_hd__tapvpwrvgnd_1
XTAP_TAPCELL_ROW_86_1876 VSS VDD sky130_fd_sc_hd__tapvpwrvgnd_1
XTAP_TAPCELL_ROW_86_1877 VSS VDD sky130_fd_sc_hd__tapvpwrvgnd_1
XTAP_TAPCELL_ROW_86_1878 VSS VDD sky130_fd_sc_hd__tapvpwrvgnd_1
XTAP_TAPCELL_ROW_86_1879 VSS VDD sky130_fd_sc_hd__tapvpwrvgnd_1
XTAP_TAPCELL_ROW_86_1880 VSS VDD sky130_fd_sc_hd__tapvpwrvgnd_1
XTAP_TAPCELL_ROW_86_1881 VSS VDD sky130_fd_sc_hd__tapvpwrvgnd_1
XTAP_TAPCELL_ROW_86_1882 VSS VDD sky130_fd_sc_hd__tapvpwrvgnd_1
XTAP_TAPCELL_ROW_86_1883 VSS VDD sky130_fd_sc_hd__tapvpwrvgnd_1
XTAP_TAPCELL_ROW_86_1884 VSS VDD sky130_fd_sc_hd__tapvpwrvgnd_1
XTAP_TAPCELL_ROW_86_1885 VSS VDD sky130_fd_sc_hd__tapvpwrvgnd_1
XTAP_TAPCELL_ROW_86_1886 VSS VDD sky130_fd_sc_hd__tapvpwrvgnd_1
XTAP_TAPCELL_ROW_86_1887 VSS VDD sky130_fd_sc_hd__tapvpwrvgnd_1
XTAP_TAPCELL_ROW_86_1888 VSS VDD sky130_fd_sc_hd__tapvpwrvgnd_1
XTAP_TAPCELL_ROW_86_1889 VSS VDD sky130_fd_sc_hd__tapvpwrvgnd_1
XTAP_TAPCELL_ROW_86_1890 VSS VDD sky130_fd_sc_hd__tapvpwrvgnd_1
XTAP_TAPCELL_ROW_86_1891 VSS VDD sky130_fd_sc_hd__tapvpwrvgnd_1
XTAP_TAPCELL_ROW_87_1892 VSS VDD sky130_fd_sc_hd__tapvpwrvgnd_1
XTAP_TAPCELL_ROW_87_1893 VSS VDD sky130_fd_sc_hd__tapvpwrvgnd_1
XTAP_TAPCELL_ROW_87_1894 VSS VDD sky130_fd_sc_hd__tapvpwrvgnd_1
XTAP_TAPCELL_ROW_87_1895 VSS VDD sky130_fd_sc_hd__tapvpwrvgnd_1
XTAP_TAPCELL_ROW_87_1896 VSS VDD sky130_fd_sc_hd__tapvpwrvgnd_1
XTAP_TAPCELL_ROW_87_1897 VSS VDD sky130_fd_sc_hd__tapvpwrvgnd_1
XTAP_TAPCELL_ROW_87_1898 VSS VDD sky130_fd_sc_hd__tapvpwrvgnd_1
XTAP_TAPCELL_ROW_87_1899 VSS VDD sky130_fd_sc_hd__tapvpwrvgnd_1
XTAP_TAPCELL_ROW_87_1900 VSS VDD sky130_fd_sc_hd__tapvpwrvgnd_1
XTAP_TAPCELL_ROW_87_1901 VSS VDD sky130_fd_sc_hd__tapvpwrvgnd_1
XTAP_TAPCELL_ROW_87_1902 VSS VDD sky130_fd_sc_hd__tapvpwrvgnd_1
XTAP_TAPCELL_ROW_87_1903 VSS VDD sky130_fd_sc_hd__tapvpwrvgnd_1
XTAP_TAPCELL_ROW_87_1904 VSS VDD sky130_fd_sc_hd__tapvpwrvgnd_1
XTAP_TAPCELL_ROW_87_1905 VSS VDD sky130_fd_sc_hd__tapvpwrvgnd_1
XTAP_TAPCELL_ROW_87_1906 VSS VDD sky130_fd_sc_hd__tapvpwrvgnd_1
XTAP_TAPCELL_ROW_87_1907 VSS VDD sky130_fd_sc_hd__tapvpwrvgnd_1
XTAP_TAPCELL_ROW_87_1908 VSS VDD sky130_fd_sc_hd__tapvpwrvgnd_1
XTAP_TAPCELL_ROW_87_1909 VSS VDD sky130_fd_sc_hd__tapvpwrvgnd_1
XTAP_TAPCELL_ROW_87_1910 VSS VDD sky130_fd_sc_hd__tapvpwrvgnd_1
XTAP_TAPCELL_ROW_87_1911 VSS VDD sky130_fd_sc_hd__tapvpwrvgnd_1
XTAP_TAPCELL_ROW_87_1912 VSS VDD sky130_fd_sc_hd__tapvpwrvgnd_1
XTAP_TAPCELL_ROW_88_1913 VSS VDD sky130_fd_sc_hd__tapvpwrvgnd_1
XTAP_TAPCELL_ROW_88_1914 VSS VDD sky130_fd_sc_hd__tapvpwrvgnd_1
XTAP_TAPCELL_ROW_88_1915 VSS VDD sky130_fd_sc_hd__tapvpwrvgnd_1
XTAP_TAPCELL_ROW_88_1916 VSS VDD sky130_fd_sc_hd__tapvpwrvgnd_1
XTAP_TAPCELL_ROW_88_1917 VSS VDD sky130_fd_sc_hd__tapvpwrvgnd_1
XTAP_TAPCELL_ROW_88_1918 VSS VDD sky130_fd_sc_hd__tapvpwrvgnd_1
XTAP_TAPCELL_ROW_88_1919 VSS VDD sky130_fd_sc_hd__tapvpwrvgnd_1
XTAP_TAPCELL_ROW_88_1920 VSS VDD sky130_fd_sc_hd__tapvpwrvgnd_1
XTAP_TAPCELL_ROW_88_1921 VSS VDD sky130_fd_sc_hd__tapvpwrvgnd_1
XTAP_TAPCELL_ROW_88_1922 VSS VDD sky130_fd_sc_hd__tapvpwrvgnd_1
XTAP_TAPCELL_ROW_88_1923 VSS VDD sky130_fd_sc_hd__tapvpwrvgnd_1
XTAP_TAPCELL_ROW_88_1924 VSS VDD sky130_fd_sc_hd__tapvpwrvgnd_1
XTAP_TAPCELL_ROW_88_1925 VSS VDD sky130_fd_sc_hd__tapvpwrvgnd_1
XTAP_TAPCELL_ROW_88_1926 VSS VDD sky130_fd_sc_hd__tapvpwrvgnd_1
XTAP_TAPCELL_ROW_88_1927 VSS VDD sky130_fd_sc_hd__tapvpwrvgnd_1
XTAP_TAPCELL_ROW_88_1928 VSS VDD sky130_fd_sc_hd__tapvpwrvgnd_1
XTAP_TAPCELL_ROW_88_1929 VSS VDD sky130_fd_sc_hd__tapvpwrvgnd_1
XTAP_TAPCELL_ROW_88_1930 VSS VDD sky130_fd_sc_hd__tapvpwrvgnd_1
XTAP_TAPCELL_ROW_88_1931 VSS VDD sky130_fd_sc_hd__tapvpwrvgnd_1
XTAP_TAPCELL_ROW_88_1932 VSS VDD sky130_fd_sc_hd__tapvpwrvgnd_1
XTAP_TAPCELL_ROW_88_1933 VSS VDD sky130_fd_sc_hd__tapvpwrvgnd_1
XTAP_TAPCELL_ROW_88_1934 VSS VDD sky130_fd_sc_hd__tapvpwrvgnd_1
XTAP_TAPCELL_ROW_89_1935 VSS VDD sky130_fd_sc_hd__tapvpwrvgnd_1
XTAP_TAPCELL_ROW_89_1936 VSS VDD sky130_fd_sc_hd__tapvpwrvgnd_1
XTAP_TAPCELL_ROW_89_1937 VSS VDD sky130_fd_sc_hd__tapvpwrvgnd_1
XTAP_TAPCELL_ROW_89_1938 VSS VDD sky130_fd_sc_hd__tapvpwrvgnd_1
XTAP_TAPCELL_ROW_89_1939 VSS VDD sky130_fd_sc_hd__tapvpwrvgnd_1
XTAP_TAPCELL_ROW_89_1940 VSS VDD sky130_fd_sc_hd__tapvpwrvgnd_1
XTAP_TAPCELL_ROW_89_1941 VSS VDD sky130_fd_sc_hd__tapvpwrvgnd_1
XTAP_TAPCELL_ROW_89_1942 VSS VDD sky130_fd_sc_hd__tapvpwrvgnd_1
XTAP_TAPCELL_ROW_89_1943 VSS VDD sky130_fd_sc_hd__tapvpwrvgnd_1
XTAP_TAPCELL_ROW_89_1944 VSS VDD sky130_fd_sc_hd__tapvpwrvgnd_1
XTAP_TAPCELL_ROW_89_1945 VSS VDD sky130_fd_sc_hd__tapvpwrvgnd_1
XTAP_TAPCELL_ROW_89_1946 VSS VDD sky130_fd_sc_hd__tapvpwrvgnd_1
XTAP_TAPCELL_ROW_89_1947 VSS VDD sky130_fd_sc_hd__tapvpwrvgnd_1
XTAP_TAPCELL_ROW_89_1948 VSS VDD sky130_fd_sc_hd__tapvpwrvgnd_1
XTAP_TAPCELL_ROW_89_1949 VSS VDD sky130_fd_sc_hd__tapvpwrvgnd_1
XTAP_TAPCELL_ROW_89_1950 VSS VDD sky130_fd_sc_hd__tapvpwrvgnd_1
XTAP_TAPCELL_ROW_89_1951 VSS VDD sky130_fd_sc_hd__tapvpwrvgnd_1
XTAP_TAPCELL_ROW_89_1952 VSS VDD sky130_fd_sc_hd__tapvpwrvgnd_1
XTAP_TAPCELL_ROW_89_1953 VSS VDD sky130_fd_sc_hd__tapvpwrvgnd_1
XTAP_TAPCELL_ROW_89_1954 VSS VDD sky130_fd_sc_hd__tapvpwrvgnd_1
XTAP_TAPCELL_ROW_89_1955 VSS VDD sky130_fd_sc_hd__tapvpwrvgnd_1
XTAP_TAPCELL_ROW_90_1956 VSS VDD sky130_fd_sc_hd__tapvpwrvgnd_1
XTAP_TAPCELL_ROW_90_1957 VSS VDD sky130_fd_sc_hd__tapvpwrvgnd_1
XTAP_TAPCELL_ROW_90_1958 VSS VDD sky130_fd_sc_hd__tapvpwrvgnd_1
XTAP_TAPCELL_ROW_90_1959 VSS VDD sky130_fd_sc_hd__tapvpwrvgnd_1
XTAP_TAPCELL_ROW_90_1960 VSS VDD sky130_fd_sc_hd__tapvpwrvgnd_1
XTAP_TAPCELL_ROW_90_1961 VSS VDD sky130_fd_sc_hd__tapvpwrvgnd_1
XTAP_TAPCELL_ROW_90_1962 VSS VDD sky130_fd_sc_hd__tapvpwrvgnd_1
XTAP_TAPCELL_ROW_90_1963 VSS VDD sky130_fd_sc_hd__tapvpwrvgnd_1
XTAP_TAPCELL_ROW_90_1964 VSS VDD sky130_fd_sc_hd__tapvpwrvgnd_1
XTAP_TAPCELL_ROW_90_1965 VSS VDD sky130_fd_sc_hd__tapvpwrvgnd_1
XTAP_TAPCELL_ROW_90_1966 VSS VDD sky130_fd_sc_hd__tapvpwrvgnd_1
XTAP_TAPCELL_ROW_90_1967 VSS VDD sky130_fd_sc_hd__tapvpwrvgnd_1
XTAP_TAPCELL_ROW_90_1968 VSS VDD sky130_fd_sc_hd__tapvpwrvgnd_1
XTAP_TAPCELL_ROW_90_1969 VSS VDD sky130_fd_sc_hd__tapvpwrvgnd_1
XTAP_TAPCELL_ROW_90_1970 VSS VDD sky130_fd_sc_hd__tapvpwrvgnd_1
XTAP_TAPCELL_ROW_90_1971 VSS VDD sky130_fd_sc_hd__tapvpwrvgnd_1
XTAP_TAPCELL_ROW_90_1972 VSS VDD sky130_fd_sc_hd__tapvpwrvgnd_1
XTAP_TAPCELL_ROW_90_1973 VSS VDD sky130_fd_sc_hd__tapvpwrvgnd_1
XTAP_TAPCELL_ROW_90_1974 VSS VDD sky130_fd_sc_hd__tapvpwrvgnd_1
XTAP_TAPCELL_ROW_90_1975 VSS VDD sky130_fd_sc_hd__tapvpwrvgnd_1
XTAP_TAPCELL_ROW_90_1976 VSS VDD sky130_fd_sc_hd__tapvpwrvgnd_1
XTAP_TAPCELL_ROW_90_1977 VSS VDD sky130_fd_sc_hd__tapvpwrvgnd_1
XTAP_TAPCELL_ROW_91_1978 VSS VDD sky130_fd_sc_hd__tapvpwrvgnd_1
XTAP_TAPCELL_ROW_91_1979 VSS VDD sky130_fd_sc_hd__tapvpwrvgnd_1
XTAP_TAPCELL_ROW_91_1980 VSS VDD sky130_fd_sc_hd__tapvpwrvgnd_1
XTAP_TAPCELL_ROW_91_1981 VSS VDD sky130_fd_sc_hd__tapvpwrvgnd_1
XTAP_TAPCELL_ROW_91_1982 VSS VDD sky130_fd_sc_hd__tapvpwrvgnd_1
XTAP_TAPCELL_ROW_91_1983 VSS VDD sky130_fd_sc_hd__tapvpwrvgnd_1
XTAP_TAPCELL_ROW_91_1984 VSS VDD sky130_fd_sc_hd__tapvpwrvgnd_1
XTAP_TAPCELL_ROW_91_1985 VSS VDD sky130_fd_sc_hd__tapvpwrvgnd_1
XTAP_TAPCELL_ROW_91_1986 VSS VDD sky130_fd_sc_hd__tapvpwrvgnd_1
XTAP_TAPCELL_ROW_91_1987 VSS VDD sky130_fd_sc_hd__tapvpwrvgnd_1
XTAP_TAPCELL_ROW_91_1988 VSS VDD sky130_fd_sc_hd__tapvpwrvgnd_1
XTAP_TAPCELL_ROW_91_1989 VSS VDD sky130_fd_sc_hd__tapvpwrvgnd_1
XTAP_TAPCELL_ROW_91_1990 VSS VDD sky130_fd_sc_hd__tapvpwrvgnd_1
XTAP_TAPCELL_ROW_91_1991 VSS VDD sky130_fd_sc_hd__tapvpwrvgnd_1
XTAP_TAPCELL_ROW_91_1992 VSS VDD sky130_fd_sc_hd__tapvpwrvgnd_1
XTAP_TAPCELL_ROW_91_1993 VSS VDD sky130_fd_sc_hd__tapvpwrvgnd_1
XTAP_TAPCELL_ROW_91_1994 VSS VDD sky130_fd_sc_hd__tapvpwrvgnd_1
XTAP_TAPCELL_ROW_91_1995 VSS VDD sky130_fd_sc_hd__tapvpwrvgnd_1
XTAP_TAPCELL_ROW_91_1996 VSS VDD sky130_fd_sc_hd__tapvpwrvgnd_1
XTAP_TAPCELL_ROW_91_1997 VSS VDD sky130_fd_sc_hd__tapvpwrvgnd_1
XTAP_TAPCELL_ROW_91_1998 VSS VDD sky130_fd_sc_hd__tapvpwrvgnd_1
XTAP_TAPCELL_ROW_92_1999 VSS VDD sky130_fd_sc_hd__tapvpwrvgnd_1
XTAP_TAPCELL_ROW_92_2000 VSS VDD sky130_fd_sc_hd__tapvpwrvgnd_1
XTAP_TAPCELL_ROW_92_2001 VSS VDD sky130_fd_sc_hd__tapvpwrvgnd_1
XTAP_TAPCELL_ROW_92_2002 VSS VDD sky130_fd_sc_hd__tapvpwrvgnd_1
XTAP_TAPCELL_ROW_92_2003 VSS VDD sky130_fd_sc_hd__tapvpwrvgnd_1
XTAP_TAPCELL_ROW_92_2004 VSS VDD sky130_fd_sc_hd__tapvpwrvgnd_1
XTAP_TAPCELL_ROW_92_2005 VSS VDD sky130_fd_sc_hd__tapvpwrvgnd_1
XTAP_TAPCELL_ROW_92_2006 VSS VDD sky130_fd_sc_hd__tapvpwrvgnd_1
XTAP_TAPCELL_ROW_92_2007 VSS VDD sky130_fd_sc_hd__tapvpwrvgnd_1
XTAP_TAPCELL_ROW_92_2008 VSS VDD sky130_fd_sc_hd__tapvpwrvgnd_1
XTAP_TAPCELL_ROW_92_2009 VSS VDD sky130_fd_sc_hd__tapvpwrvgnd_1
XTAP_TAPCELL_ROW_92_2010 VSS VDD sky130_fd_sc_hd__tapvpwrvgnd_1
XTAP_TAPCELL_ROW_92_2011 VSS VDD sky130_fd_sc_hd__tapvpwrvgnd_1
XTAP_TAPCELL_ROW_92_2012 VSS VDD sky130_fd_sc_hd__tapvpwrvgnd_1
XTAP_TAPCELL_ROW_92_2013 VSS VDD sky130_fd_sc_hd__tapvpwrvgnd_1
XTAP_TAPCELL_ROW_92_2014 VSS VDD sky130_fd_sc_hd__tapvpwrvgnd_1
XTAP_TAPCELL_ROW_92_2015 VSS VDD sky130_fd_sc_hd__tapvpwrvgnd_1
XTAP_TAPCELL_ROW_92_2016 VSS VDD sky130_fd_sc_hd__tapvpwrvgnd_1
XTAP_TAPCELL_ROW_92_2017 VSS VDD sky130_fd_sc_hd__tapvpwrvgnd_1
XTAP_TAPCELL_ROW_92_2018 VSS VDD sky130_fd_sc_hd__tapvpwrvgnd_1
XTAP_TAPCELL_ROW_92_2019 VSS VDD sky130_fd_sc_hd__tapvpwrvgnd_1
XTAP_TAPCELL_ROW_92_2020 VSS VDD sky130_fd_sc_hd__tapvpwrvgnd_1
XTAP_TAPCELL_ROW_93_2021 VSS VDD sky130_fd_sc_hd__tapvpwrvgnd_1
XTAP_TAPCELL_ROW_93_2022 VSS VDD sky130_fd_sc_hd__tapvpwrvgnd_1
XTAP_TAPCELL_ROW_93_2023 VSS VDD sky130_fd_sc_hd__tapvpwrvgnd_1
XTAP_TAPCELL_ROW_93_2024 VSS VDD sky130_fd_sc_hd__tapvpwrvgnd_1
XTAP_TAPCELL_ROW_93_2025 VSS VDD sky130_fd_sc_hd__tapvpwrvgnd_1
XTAP_TAPCELL_ROW_93_2026 VSS VDD sky130_fd_sc_hd__tapvpwrvgnd_1
XTAP_TAPCELL_ROW_93_2027 VSS VDD sky130_fd_sc_hd__tapvpwrvgnd_1
XTAP_TAPCELL_ROW_93_2028 VSS VDD sky130_fd_sc_hd__tapvpwrvgnd_1
XTAP_TAPCELL_ROW_93_2029 VSS VDD sky130_fd_sc_hd__tapvpwrvgnd_1
XTAP_TAPCELL_ROW_93_2030 VSS VDD sky130_fd_sc_hd__tapvpwrvgnd_1
XTAP_TAPCELL_ROW_93_2031 VSS VDD sky130_fd_sc_hd__tapvpwrvgnd_1
XTAP_TAPCELL_ROW_93_2032 VSS VDD sky130_fd_sc_hd__tapvpwrvgnd_1
XTAP_TAPCELL_ROW_93_2033 VSS VDD sky130_fd_sc_hd__tapvpwrvgnd_1
XTAP_TAPCELL_ROW_93_2034 VSS VDD sky130_fd_sc_hd__tapvpwrvgnd_1
XTAP_TAPCELL_ROW_93_2035 VSS VDD sky130_fd_sc_hd__tapvpwrvgnd_1
XTAP_TAPCELL_ROW_93_2036 VSS VDD sky130_fd_sc_hd__tapvpwrvgnd_1
XTAP_TAPCELL_ROW_93_2037 VSS VDD sky130_fd_sc_hd__tapvpwrvgnd_1
XTAP_TAPCELL_ROW_93_2038 VSS VDD sky130_fd_sc_hd__tapvpwrvgnd_1
XTAP_TAPCELL_ROW_93_2039 VSS VDD sky130_fd_sc_hd__tapvpwrvgnd_1
XTAP_TAPCELL_ROW_93_2040 VSS VDD sky130_fd_sc_hd__tapvpwrvgnd_1
XTAP_TAPCELL_ROW_93_2041 VSS VDD sky130_fd_sc_hd__tapvpwrvgnd_1
XTAP_TAPCELL_ROW_94_2042 VSS VDD sky130_fd_sc_hd__tapvpwrvgnd_1
XTAP_TAPCELL_ROW_94_2043 VSS VDD sky130_fd_sc_hd__tapvpwrvgnd_1
XTAP_TAPCELL_ROW_94_2044 VSS VDD sky130_fd_sc_hd__tapvpwrvgnd_1
XTAP_TAPCELL_ROW_94_2045 VSS VDD sky130_fd_sc_hd__tapvpwrvgnd_1
XTAP_TAPCELL_ROW_94_2046 VSS VDD sky130_fd_sc_hd__tapvpwrvgnd_1
XTAP_TAPCELL_ROW_94_2047 VSS VDD sky130_fd_sc_hd__tapvpwrvgnd_1
XTAP_TAPCELL_ROW_94_2048 VSS VDD sky130_fd_sc_hd__tapvpwrvgnd_1
XTAP_TAPCELL_ROW_94_2049 VSS VDD sky130_fd_sc_hd__tapvpwrvgnd_1
XTAP_TAPCELL_ROW_94_2050 VSS VDD sky130_fd_sc_hd__tapvpwrvgnd_1
XTAP_TAPCELL_ROW_94_2051 VSS VDD sky130_fd_sc_hd__tapvpwrvgnd_1
XTAP_TAPCELL_ROW_94_2052 VSS VDD sky130_fd_sc_hd__tapvpwrvgnd_1
XTAP_TAPCELL_ROW_94_2053 VSS VDD sky130_fd_sc_hd__tapvpwrvgnd_1
XTAP_TAPCELL_ROW_94_2054 VSS VDD sky130_fd_sc_hd__tapvpwrvgnd_1
XTAP_TAPCELL_ROW_94_2055 VSS VDD sky130_fd_sc_hd__tapvpwrvgnd_1
XTAP_TAPCELL_ROW_94_2056 VSS VDD sky130_fd_sc_hd__tapvpwrvgnd_1
XTAP_TAPCELL_ROW_94_2057 VSS VDD sky130_fd_sc_hd__tapvpwrvgnd_1
XTAP_TAPCELL_ROW_94_2058 VSS VDD sky130_fd_sc_hd__tapvpwrvgnd_1
XTAP_TAPCELL_ROW_94_2059 VSS VDD sky130_fd_sc_hd__tapvpwrvgnd_1
XTAP_TAPCELL_ROW_94_2060 VSS VDD sky130_fd_sc_hd__tapvpwrvgnd_1
XTAP_TAPCELL_ROW_94_2061 VSS VDD sky130_fd_sc_hd__tapvpwrvgnd_1
XTAP_TAPCELL_ROW_94_2062 VSS VDD sky130_fd_sc_hd__tapvpwrvgnd_1
XTAP_TAPCELL_ROW_94_2063 VSS VDD sky130_fd_sc_hd__tapvpwrvgnd_1
XTAP_TAPCELL_ROW_95_2064 VSS VDD sky130_fd_sc_hd__tapvpwrvgnd_1
XTAP_TAPCELL_ROW_95_2065 VSS VDD sky130_fd_sc_hd__tapvpwrvgnd_1
XTAP_TAPCELL_ROW_95_2066 VSS VDD sky130_fd_sc_hd__tapvpwrvgnd_1
XTAP_TAPCELL_ROW_95_2067 VSS VDD sky130_fd_sc_hd__tapvpwrvgnd_1
XTAP_TAPCELL_ROW_95_2068 VSS VDD sky130_fd_sc_hd__tapvpwrvgnd_1
XTAP_TAPCELL_ROW_95_2069 VSS VDD sky130_fd_sc_hd__tapvpwrvgnd_1
XTAP_TAPCELL_ROW_95_2070 VSS VDD sky130_fd_sc_hd__tapvpwrvgnd_1
XTAP_TAPCELL_ROW_95_2071 VSS VDD sky130_fd_sc_hd__tapvpwrvgnd_1
XTAP_TAPCELL_ROW_95_2072 VSS VDD sky130_fd_sc_hd__tapvpwrvgnd_1
XTAP_TAPCELL_ROW_95_2073 VSS VDD sky130_fd_sc_hd__tapvpwrvgnd_1
XTAP_TAPCELL_ROW_95_2074 VSS VDD sky130_fd_sc_hd__tapvpwrvgnd_1
XTAP_TAPCELL_ROW_95_2075 VSS VDD sky130_fd_sc_hd__tapvpwrvgnd_1
XTAP_TAPCELL_ROW_95_2076 VSS VDD sky130_fd_sc_hd__tapvpwrvgnd_1
XTAP_TAPCELL_ROW_95_2077 VSS VDD sky130_fd_sc_hd__tapvpwrvgnd_1
XTAP_TAPCELL_ROW_95_2078 VSS VDD sky130_fd_sc_hd__tapvpwrvgnd_1
XTAP_TAPCELL_ROW_95_2079 VSS VDD sky130_fd_sc_hd__tapvpwrvgnd_1
XTAP_TAPCELL_ROW_95_2080 VSS VDD sky130_fd_sc_hd__tapvpwrvgnd_1
XTAP_TAPCELL_ROW_95_2081 VSS VDD sky130_fd_sc_hd__tapvpwrvgnd_1
XTAP_TAPCELL_ROW_95_2082 VSS VDD sky130_fd_sc_hd__tapvpwrvgnd_1
XTAP_TAPCELL_ROW_95_2083 VSS VDD sky130_fd_sc_hd__tapvpwrvgnd_1
XTAP_TAPCELL_ROW_95_2084 VSS VDD sky130_fd_sc_hd__tapvpwrvgnd_1
XTAP_TAPCELL_ROW_96_2085 VSS VDD sky130_fd_sc_hd__tapvpwrvgnd_1
XTAP_TAPCELL_ROW_96_2086 VSS VDD sky130_fd_sc_hd__tapvpwrvgnd_1
XTAP_TAPCELL_ROW_96_2087 VSS VDD sky130_fd_sc_hd__tapvpwrvgnd_1
XTAP_TAPCELL_ROW_96_2088 VSS VDD sky130_fd_sc_hd__tapvpwrvgnd_1
XTAP_TAPCELL_ROW_96_2089 VSS VDD sky130_fd_sc_hd__tapvpwrvgnd_1
XTAP_TAPCELL_ROW_96_2090 VSS VDD sky130_fd_sc_hd__tapvpwrvgnd_1
XTAP_TAPCELL_ROW_96_2091 VSS VDD sky130_fd_sc_hd__tapvpwrvgnd_1
XTAP_TAPCELL_ROW_96_2092 VSS VDD sky130_fd_sc_hd__tapvpwrvgnd_1
XTAP_TAPCELL_ROW_96_2093 VSS VDD sky130_fd_sc_hd__tapvpwrvgnd_1
XTAP_TAPCELL_ROW_96_2094 VSS VDD sky130_fd_sc_hd__tapvpwrvgnd_1
XTAP_TAPCELL_ROW_96_2095 VSS VDD sky130_fd_sc_hd__tapvpwrvgnd_1
XTAP_TAPCELL_ROW_96_2096 VSS VDD sky130_fd_sc_hd__tapvpwrvgnd_1
XTAP_TAPCELL_ROW_96_2097 VSS VDD sky130_fd_sc_hd__tapvpwrvgnd_1
XTAP_TAPCELL_ROW_96_2098 VSS VDD sky130_fd_sc_hd__tapvpwrvgnd_1
XTAP_TAPCELL_ROW_96_2099 VSS VDD sky130_fd_sc_hd__tapvpwrvgnd_1
XTAP_TAPCELL_ROW_96_2100 VSS VDD sky130_fd_sc_hd__tapvpwrvgnd_1
XTAP_TAPCELL_ROW_96_2101 VSS VDD sky130_fd_sc_hd__tapvpwrvgnd_1
XTAP_TAPCELL_ROW_96_2102 VSS VDD sky130_fd_sc_hd__tapvpwrvgnd_1
XTAP_TAPCELL_ROW_96_2103 VSS VDD sky130_fd_sc_hd__tapvpwrvgnd_1
XTAP_TAPCELL_ROW_96_2104 VSS VDD sky130_fd_sc_hd__tapvpwrvgnd_1
XTAP_TAPCELL_ROW_96_2105 VSS VDD sky130_fd_sc_hd__tapvpwrvgnd_1
XTAP_TAPCELL_ROW_96_2106 VSS VDD sky130_fd_sc_hd__tapvpwrvgnd_1
XTAP_TAPCELL_ROW_97_2107 VSS VDD sky130_fd_sc_hd__tapvpwrvgnd_1
XTAP_TAPCELL_ROW_97_2108 VSS VDD sky130_fd_sc_hd__tapvpwrvgnd_1
XTAP_TAPCELL_ROW_97_2109 VSS VDD sky130_fd_sc_hd__tapvpwrvgnd_1
XTAP_TAPCELL_ROW_97_2110 VSS VDD sky130_fd_sc_hd__tapvpwrvgnd_1
XTAP_TAPCELL_ROW_97_2111 VSS VDD sky130_fd_sc_hd__tapvpwrvgnd_1
XTAP_TAPCELL_ROW_97_2112 VSS VDD sky130_fd_sc_hd__tapvpwrvgnd_1
XTAP_TAPCELL_ROW_97_2113 VSS VDD sky130_fd_sc_hd__tapvpwrvgnd_1
XTAP_TAPCELL_ROW_97_2114 VSS VDD sky130_fd_sc_hd__tapvpwrvgnd_1
XTAP_TAPCELL_ROW_97_2115 VSS VDD sky130_fd_sc_hd__tapvpwrvgnd_1
XTAP_TAPCELL_ROW_97_2116 VSS VDD sky130_fd_sc_hd__tapvpwrvgnd_1
XTAP_TAPCELL_ROW_97_2117 VSS VDD sky130_fd_sc_hd__tapvpwrvgnd_1
XTAP_TAPCELL_ROW_97_2118 VSS VDD sky130_fd_sc_hd__tapvpwrvgnd_1
XTAP_TAPCELL_ROW_97_2119 VSS VDD sky130_fd_sc_hd__tapvpwrvgnd_1
XTAP_TAPCELL_ROW_97_2120 VSS VDD sky130_fd_sc_hd__tapvpwrvgnd_1
XTAP_TAPCELL_ROW_97_2121 VSS VDD sky130_fd_sc_hd__tapvpwrvgnd_1
XTAP_TAPCELL_ROW_97_2122 VSS VDD sky130_fd_sc_hd__tapvpwrvgnd_1
XTAP_TAPCELL_ROW_97_2123 VSS VDD sky130_fd_sc_hd__tapvpwrvgnd_1
XTAP_TAPCELL_ROW_97_2124 VSS VDD sky130_fd_sc_hd__tapvpwrvgnd_1
XTAP_TAPCELL_ROW_97_2125 VSS VDD sky130_fd_sc_hd__tapvpwrvgnd_1
XTAP_TAPCELL_ROW_97_2126 VSS VDD sky130_fd_sc_hd__tapvpwrvgnd_1
XTAP_TAPCELL_ROW_97_2127 VSS VDD sky130_fd_sc_hd__tapvpwrvgnd_1
XTAP_TAPCELL_ROW_98_2128 VSS VDD sky130_fd_sc_hd__tapvpwrvgnd_1
XTAP_TAPCELL_ROW_98_2129 VSS VDD sky130_fd_sc_hd__tapvpwrvgnd_1
XTAP_TAPCELL_ROW_98_2130 VSS VDD sky130_fd_sc_hd__tapvpwrvgnd_1
XTAP_TAPCELL_ROW_98_2131 VSS VDD sky130_fd_sc_hd__tapvpwrvgnd_1
XTAP_TAPCELL_ROW_98_2132 VSS VDD sky130_fd_sc_hd__tapvpwrvgnd_1
XTAP_TAPCELL_ROW_98_2133 VSS VDD sky130_fd_sc_hd__tapvpwrvgnd_1
XTAP_TAPCELL_ROW_98_2134 VSS VDD sky130_fd_sc_hd__tapvpwrvgnd_1
XTAP_TAPCELL_ROW_98_2135 VSS VDD sky130_fd_sc_hd__tapvpwrvgnd_1
XTAP_TAPCELL_ROW_98_2136 VSS VDD sky130_fd_sc_hd__tapvpwrvgnd_1
XTAP_TAPCELL_ROW_98_2137 VSS VDD sky130_fd_sc_hd__tapvpwrvgnd_1
XTAP_TAPCELL_ROW_98_2138 VSS VDD sky130_fd_sc_hd__tapvpwrvgnd_1
XTAP_TAPCELL_ROW_98_2139 VSS VDD sky130_fd_sc_hd__tapvpwrvgnd_1
XTAP_TAPCELL_ROW_98_2140 VSS VDD sky130_fd_sc_hd__tapvpwrvgnd_1
XTAP_TAPCELL_ROW_98_2141 VSS VDD sky130_fd_sc_hd__tapvpwrvgnd_1
XTAP_TAPCELL_ROW_98_2142 VSS VDD sky130_fd_sc_hd__tapvpwrvgnd_1
XTAP_TAPCELL_ROW_98_2143 VSS VDD sky130_fd_sc_hd__tapvpwrvgnd_1
XTAP_TAPCELL_ROW_98_2144 VSS VDD sky130_fd_sc_hd__tapvpwrvgnd_1
XTAP_TAPCELL_ROW_98_2145 VSS VDD sky130_fd_sc_hd__tapvpwrvgnd_1
XTAP_TAPCELL_ROW_98_2146 VSS VDD sky130_fd_sc_hd__tapvpwrvgnd_1
XTAP_TAPCELL_ROW_98_2147 VSS VDD sky130_fd_sc_hd__tapvpwrvgnd_1
XTAP_TAPCELL_ROW_98_2148 VSS VDD sky130_fd_sc_hd__tapvpwrvgnd_1
XTAP_TAPCELL_ROW_98_2149 VSS VDD sky130_fd_sc_hd__tapvpwrvgnd_1
XTAP_TAPCELL_ROW_99_2150 VSS VDD sky130_fd_sc_hd__tapvpwrvgnd_1
XTAP_TAPCELL_ROW_99_2151 VSS VDD sky130_fd_sc_hd__tapvpwrvgnd_1
XTAP_TAPCELL_ROW_99_2152 VSS VDD sky130_fd_sc_hd__tapvpwrvgnd_1
XTAP_TAPCELL_ROW_99_2153 VSS VDD sky130_fd_sc_hd__tapvpwrvgnd_1
XTAP_TAPCELL_ROW_99_2154 VSS VDD sky130_fd_sc_hd__tapvpwrvgnd_1
XTAP_TAPCELL_ROW_99_2155 VSS VDD sky130_fd_sc_hd__tapvpwrvgnd_1
XTAP_TAPCELL_ROW_99_2156 VSS VDD sky130_fd_sc_hd__tapvpwrvgnd_1
XTAP_TAPCELL_ROW_99_2157 VSS VDD sky130_fd_sc_hd__tapvpwrvgnd_1
XTAP_TAPCELL_ROW_99_2158 VSS VDD sky130_fd_sc_hd__tapvpwrvgnd_1
XTAP_TAPCELL_ROW_99_2159 VSS VDD sky130_fd_sc_hd__tapvpwrvgnd_1
XTAP_TAPCELL_ROW_99_2160 VSS VDD sky130_fd_sc_hd__tapvpwrvgnd_1
XTAP_TAPCELL_ROW_99_2161 VSS VDD sky130_fd_sc_hd__tapvpwrvgnd_1
XTAP_TAPCELL_ROW_99_2162 VSS VDD sky130_fd_sc_hd__tapvpwrvgnd_1
XTAP_TAPCELL_ROW_99_2163 VSS VDD sky130_fd_sc_hd__tapvpwrvgnd_1
XTAP_TAPCELL_ROW_99_2164 VSS VDD sky130_fd_sc_hd__tapvpwrvgnd_1
XTAP_TAPCELL_ROW_99_2165 VSS VDD sky130_fd_sc_hd__tapvpwrvgnd_1
XTAP_TAPCELL_ROW_99_2166 VSS VDD sky130_fd_sc_hd__tapvpwrvgnd_1
XTAP_TAPCELL_ROW_99_2167 VSS VDD sky130_fd_sc_hd__tapvpwrvgnd_1
XTAP_TAPCELL_ROW_99_2168 VSS VDD sky130_fd_sc_hd__tapvpwrvgnd_1
XTAP_TAPCELL_ROW_99_2169 VSS VDD sky130_fd_sc_hd__tapvpwrvgnd_1
XTAP_TAPCELL_ROW_99_2170 VSS VDD sky130_fd_sc_hd__tapvpwrvgnd_1
XTAP_TAPCELL_ROW_100_2171 VSS VDD sky130_fd_sc_hd__tapvpwrvgnd_1
XTAP_TAPCELL_ROW_100_2172 VSS VDD sky130_fd_sc_hd__tapvpwrvgnd_1
XTAP_TAPCELL_ROW_100_2173 VSS VDD sky130_fd_sc_hd__tapvpwrvgnd_1
XTAP_TAPCELL_ROW_100_2174 VSS VDD sky130_fd_sc_hd__tapvpwrvgnd_1
XTAP_TAPCELL_ROW_100_2175 VSS VDD sky130_fd_sc_hd__tapvpwrvgnd_1
XTAP_TAPCELL_ROW_100_2176 VSS VDD sky130_fd_sc_hd__tapvpwrvgnd_1
XTAP_TAPCELL_ROW_100_2177 VSS VDD sky130_fd_sc_hd__tapvpwrvgnd_1
XTAP_TAPCELL_ROW_100_2178 VSS VDD sky130_fd_sc_hd__tapvpwrvgnd_1
XTAP_TAPCELL_ROW_100_2179 VSS VDD sky130_fd_sc_hd__tapvpwrvgnd_1
XTAP_TAPCELL_ROW_100_2180 VSS VDD sky130_fd_sc_hd__tapvpwrvgnd_1
XTAP_TAPCELL_ROW_100_2181 VSS VDD sky130_fd_sc_hd__tapvpwrvgnd_1
XTAP_TAPCELL_ROW_100_2182 VSS VDD sky130_fd_sc_hd__tapvpwrvgnd_1
XTAP_TAPCELL_ROW_100_2183 VSS VDD sky130_fd_sc_hd__tapvpwrvgnd_1
XTAP_TAPCELL_ROW_100_2184 VSS VDD sky130_fd_sc_hd__tapvpwrvgnd_1
XTAP_TAPCELL_ROW_100_2185 VSS VDD sky130_fd_sc_hd__tapvpwrvgnd_1
XTAP_TAPCELL_ROW_100_2186 VSS VDD sky130_fd_sc_hd__tapvpwrvgnd_1
XTAP_TAPCELL_ROW_100_2187 VSS VDD sky130_fd_sc_hd__tapvpwrvgnd_1
XTAP_TAPCELL_ROW_100_2188 VSS VDD sky130_fd_sc_hd__tapvpwrvgnd_1
XTAP_TAPCELL_ROW_100_2189 VSS VDD sky130_fd_sc_hd__tapvpwrvgnd_1
XTAP_TAPCELL_ROW_100_2190 VSS VDD sky130_fd_sc_hd__tapvpwrvgnd_1
XTAP_TAPCELL_ROW_100_2191 VSS VDD sky130_fd_sc_hd__tapvpwrvgnd_1
XTAP_TAPCELL_ROW_100_2192 VSS VDD sky130_fd_sc_hd__tapvpwrvgnd_1
XTAP_TAPCELL_ROW_101_2193 VSS VDD sky130_fd_sc_hd__tapvpwrvgnd_1
XTAP_TAPCELL_ROW_101_2194 VSS VDD sky130_fd_sc_hd__tapvpwrvgnd_1
XTAP_TAPCELL_ROW_101_2195 VSS VDD sky130_fd_sc_hd__tapvpwrvgnd_1
XTAP_TAPCELL_ROW_101_2196 VSS VDD sky130_fd_sc_hd__tapvpwrvgnd_1
XTAP_TAPCELL_ROW_101_2197 VSS VDD sky130_fd_sc_hd__tapvpwrvgnd_1
XTAP_TAPCELL_ROW_101_2198 VSS VDD sky130_fd_sc_hd__tapvpwrvgnd_1
XTAP_TAPCELL_ROW_101_2199 VSS VDD sky130_fd_sc_hd__tapvpwrvgnd_1
XTAP_TAPCELL_ROW_101_2200 VSS VDD sky130_fd_sc_hd__tapvpwrvgnd_1
XTAP_TAPCELL_ROW_101_2201 VSS VDD sky130_fd_sc_hd__tapvpwrvgnd_1
XTAP_TAPCELL_ROW_101_2202 VSS VDD sky130_fd_sc_hd__tapvpwrvgnd_1
XTAP_TAPCELL_ROW_101_2203 VSS VDD sky130_fd_sc_hd__tapvpwrvgnd_1
XTAP_TAPCELL_ROW_101_2204 VSS VDD sky130_fd_sc_hd__tapvpwrvgnd_1
XTAP_TAPCELL_ROW_101_2205 VSS VDD sky130_fd_sc_hd__tapvpwrvgnd_1
XTAP_TAPCELL_ROW_101_2206 VSS VDD sky130_fd_sc_hd__tapvpwrvgnd_1
XTAP_TAPCELL_ROW_101_2207 VSS VDD sky130_fd_sc_hd__tapvpwrvgnd_1
XTAP_TAPCELL_ROW_101_2208 VSS VDD sky130_fd_sc_hd__tapvpwrvgnd_1
XTAP_TAPCELL_ROW_101_2209 VSS VDD sky130_fd_sc_hd__tapvpwrvgnd_1
XTAP_TAPCELL_ROW_101_2210 VSS VDD sky130_fd_sc_hd__tapvpwrvgnd_1
XTAP_TAPCELL_ROW_101_2211 VSS VDD sky130_fd_sc_hd__tapvpwrvgnd_1
XTAP_TAPCELL_ROW_101_2212 VSS VDD sky130_fd_sc_hd__tapvpwrvgnd_1
XTAP_TAPCELL_ROW_101_2213 VSS VDD sky130_fd_sc_hd__tapvpwrvgnd_1
XTAP_TAPCELL_ROW_102_2214 VSS VDD sky130_fd_sc_hd__tapvpwrvgnd_1
XTAP_TAPCELL_ROW_102_2215 VSS VDD sky130_fd_sc_hd__tapvpwrvgnd_1
XTAP_TAPCELL_ROW_102_2216 VSS VDD sky130_fd_sc_hd__tapvpwrvgnd_1
XTAP_TAPCELL_ROW_102_2217 VSS VDD sky130_fd_sc_hd__tapvpwrvgnd_1
XTAP_TAPCELL_ROW_102_2218 VSS VDD sky130_fd_sc_hd__tapvpwrvgnd_1
XTAP_TAPCELL_ROW_102_2219 VSS VDD sky130_fd_sc_hd__tapvpwrvgnd_1
XTAP_TAPCELL_ROW_102_2220 VSS VDD sky130_fd_sc_hd__tapvpwrvgnd_1
XTAP_TAPCELL_ROW_102_2221 VSS VDD sky130_fd_sc_hd__tapvpwrvgnd_1
XTAP_TAPCELL_ROW_102_2222 VSS VDD sky130_fd_sc_hd__tapvpwrvgnd_1
XTAP_TAPCELL_ROW_102_2223 VSS VDD sky130_fd_sc_hd__tapvpwrvgnd_1
XTAP_TAPCELL_ROW_102_2224 VSS VDD sky130_fd_sc_hd__tapvpwrvgnd_1
XTAP_TAPCELL_ROW_102_2225 VSS VDD sky130_fd_sc_hd__tapvpwrvgnd_1
XTAP_TAPCELL_ROW_102_2226 VSS VDD sky130_fd_sc_hd__tapvpwrvgnd_1
XTAP_TAPCELL_ROW_102_2227 VSS VDD sky130_fd_sc_hd__tapvpwrvgnd_1
XTAP_TAPCELL_ROW_102_2228 VSS VDD sky130_fd_sc_hd__tapvpwrvgnd_1
XTAP_TAPCELL_ROW_102_2229 VSS VDD sky130_fd_sc_hd__tapvpwrvgnd_1
XTAP_TAPCELL_ROW_102_2230 VSS VDD sky130_fd_sc_hd__tapvpwrvgnd_1
XTAP_TAPCELL_ROW_102_2231 VSS VDD sky130_fd_sc_hd__tapvpwrvgnd_1
XTAP_TAPCELL_ROW_102_2232 VSS VDD sky130_fd_sc_hd__tapvpwrvgnd_1
XTAP_TAPCELL_ROW_102_2233 VSS VDD sky130_fd_sc_hd__tapvpwrvgnd_1
XTAP_TAPCELL_ROW_102_2234 VSS VDD sky130_fd_sc_hd__tapvpwrvgnd_1
XTAP_TAPCELL_ROW_102_2235 VSS VDD sky130_fd_sc_hd__tapvpwrvgnd_1
XTAP_TAPCELL_ROW_103_2236 VSS VDD sky130_fd_sc_hd__tapvpwrvgnd_1
XTAP_TAPCELL_ROW_103_2237 VSS VDD sky130_fd_sc_hd__tapvpwrvgnd_1
XTAP_TAPCELL_ROW_103_2238 VSS VDD sky130_fd_sc_hd__tapvpwrvgnd_1
XTAP_TAPCELL_ROW_103_2239 VSS VDD sky130_fd_sc_hd__tapvpwrvgnd_1
XTAP_TAPCELL_ROW_103_2240 VSS VDD sky130_fd_sc_hd__tapvpwrvgnd_1
XTAP_TAPCELL_ROW_103_2241 VSS VDD sky130_fd_sc_hd__tapvpwrvgnd_1
XTAP_TAPCELL_ROW_103_2242 VSS VDD sky130_fd_sc_hd__tapvpwrvgnd_1
XTAP_TAPCELL_ROW_103_2243 VSS VDD sky130_fd_sc_hd__tapvpwrvgnd_1
XTAP_TAPCELL_ROW_103_2244 VSS VDD sky130_fd_sc_hd__tapvpwrvgnd_1
XTAP_TAPCELL_ROW_103_2245 VSS VDD sky130_fd_sc_hd__tapvpwrvgnd_1
XTAP_TAPCELL_ROW_103_2246 VSS VDD sky130_fd_sc_hd__tapvpwrvgnd_1
XTAP_TAPCELL_ROW_103_2247 VSS VDD sky130_fd_sc_hd__tapvpwrvgnd_1
XTAP_TAPCELL_ROW_103_2248 VSS VDD sky130_fd_sc_hd__tapvpwrvgnd_1
XTAP_TAPCELL_ROW_103_2249 VSS VDD sky130_fd_sc_hd__tapvpwrvgnd_1
XTAP_TAPCELL_ROW_103_2250 VSS VDD sky130_fd_sc_hd__tapvpwrvgnd_1
XTAP_TAPCELL_ROW_103_2251 VSS VDD sky130_fd_sc_hd__tapvpwrvgnd_1
XTAP_TAPCELL_ROW_103_2252 VSS VDD sky130_fd_sc_hd__tapvpwrvgnd_1
XTAP_TAPCELL_ROW_103_2253 VSS VDD sky130_fd_sc_hd__tapvpwrvgnd_1
XTAP_TAPCELL_ROW_103_2254 VSS VDD sky130_fd_sc_hd__tapvpwrvgnd_1
XTAP_TAPCELL_ROW_103_2255 VSS VDD sky130_fd_sc_hd__tapvpwrvgnd_1
XTAP_TAPCELL_ROW_103_2256 VSS VDD sky130_fd_sc_hd__tapvpwrvgnd_1
XTAP_TAPCELL_ROW_104_2257 VSS VDD sky130_fd_sc_hd__tapvpwrvgnd_1
XTAP_TAPCELL_ROW_104_2258 VSS VDD sky130_fd_sc_hd__tapvpwrvgnd_1
XTAP_TAPCELL_ROW_104_2259 VSS VDD sky130_fd_sc_hd__tapvpwrvgnd_1
XTAP_TAPCELL_ROW_104_2260 VSS VDD sky130_fd_sc_hd__tapvpwrvgnd_1
XTAP_TAPCELL_ROW_104_2261 VSS VDD sky130_fd_sc_hd__tapvpwrvgnd_1
XTAP_TAPCELL_ROW_104_2262 VSS VDD sky130_fd_sc_hd__tapvpwrvgnd_1
XTAP_TAPCELL_ROW_104_2263 VSS VDD sky130_fd_sc_hd__tapvpwrvgnd_1
XTAP_TAPCELL_ROW_104_2264 VSS VDD sky130_fd_sc_hd__tapvpwrvgnd_1
XTAP_TAPCELL_ROW_104_2265 VSS VDD sky130_fd_sc_hd__tapvpwrvgnd_1
XTAP_TAPCELL_ROW_104_2266 VSS VDD sky130_fd_sc_hd__tapvpwrvgnd_1
XTAP_TAPCELL_ROW_104_2267 VSS VDD sky130_fd_sc_hd__tapvpwrvgnd_1
XTAP_TAPCELL_ROW_104_2268 VSS VDD sky130_fd_sc_hd__tapvpwrvgnd_1
XTAP_TAPCELL_ROW_104_2269 VSS VDD sky130_fd_sc_hd__tapvpwrvgnd_1
XTAP_TAPCELL_ROW_104_2270 VSS VDD sky130_fd_sc_hd__tapvpwrvgnd_1
XTAP_TAPCELL_ROW_104_2271 VSS VDD sky130_fd_sc_hd__tapvpwrvgnd_1
XTAP_TAPCELL_ROW_104_2272 VSS VDD sky130_fd_sc_hd__tapvpwrvgnd_1
XTAP_TAPCELL_ROW_104_2273 VSS VDD sky130_fd_sc_hd__tapvpwrvgnd_1
XTAP_TAPCELL_ROW_104_2274 VSS VDD sky130_fd_sc_hd__tapvpwrvgnd_1
XTAP_TAPCELL_ROW_104_2275 VSS VDD sky130_fd_sc_hd__tapvpwrvgnd_1
XTAP_TAPCELL_ROW_104_2276 VSS VDD sky130_fd_sc_hd__tapvpwrvgnd_1
XTAP_TAPCELL_ROW_104_2277 VSS VDD sky130_fd_sc_hd__tapvpwrvgnd_1
XTAP_TAPCELL_ROW_104_2278 VSS VDD sky130_fd_sc_hd__tapvpwrvgnd_1
XTAP_TAPCELL_ROW_105_2279 VSS VDD sky130_fd_sc_hd__tapvpwrvgnd_1
XTAP_TAPCELL_ROW_105_2280 VSS VDD sky130_fd_sc_hd__tapvpwrvgnd_1
XTAP_TAPCELL_ROW_105_2281 VSS VDD sky130_fd_sc_hd__tapvpwrvgnd_1
XTAP_TAPCELL_ROW_105_2282 VSS VDD sky130_fd_sc_hd__tapvpwrvgnd_1
XTAP_TAPCELL_ROW_105_2283 VSS VDD sky130_fd_sc_hd__tapvpwrvgnd_1
XTAP_TAPCELL_ROW_105_2284 VSS VDD sky130_fd_sc_hd__tapvpwrvgnd_1
XTAP_TAPCELL_ROW_105_2285 VSS VDD sky130_fd_sc_hd__tapvpwrvgnd_1
XTAP_TAPCELL_ROW_105_2286 VSS VDD sky130_fd_sc_hd__tapvpwrvgnd_1
XTAP_TAPCELL_ROW_105_2287 VSS VDD sky130_fd_sc_hd__tapvpwrvgnd_1
XTAP_TAPCELL_ROW_105_2288 VSS VDD sky130_fd_sc_hd__tapvpwrvgnd_1
XTAP_TAPCELL_ROW_105_2289 VSS VDD sky130_fd_sc_hd__tapvpwrvgnd_1
XTAP_TAPCELL_ROW_105_2290 VSS VDD sky130_fd_sc_hd__tapvpwrvgnd_1
XTAP_TAPCELL_ROW_105_2291 VSS VDD sky130_fd_sc_hd__tapvpwrvgnd_1
XTAP_TAPCELL_ROW_105_2292 VSS VDD sky130_fd_sc_hd__tapvpwrvgnd_1
XTAP_TAPCELL_ROW_105_2293 VSS VDD sky130_fd_sc_hd__tapvpwrvgnd_1
XTAP_TAPCELL_ROW_105_2294 VSS VDD sky130_fd_sc_hd__tapvpwrvgnd_1
XTAP_TAPCELL_ROW_105_2295 VSS VDD sky130_fd_sc_hd__tapvpwrvgnd_1
XTAP_TAPCELL_ROW_105_2296 VSS VDD sky130_fd_sc_hd__tapvpwrvgnd_1
XTAP_TAPCELL_ROW_105_2297 VSS VDD sky130_fd_sc_hd__tapvpwrvgnd_1
XTAP_TAPCELL_ROW_105_2298 VSS VDD sky130_fd_sc_hd__tapvpwrvgnd_1
XTAP_TAPCELL_ROW_105_2299 VSS VDD sky130_fd_sc_hd__tapvpwrvgnd_1
XTAP_TAPCELL_ROW_106_2300 VSS VDD sky130_fd_sc_hd__tapvpwrvgnd_1
XTAP_TAPCELL_ROW_106_2301 VSS VDD sky130_fd_sc_hd__tapvpwrvgnd_1
XTAP_TAPCELL_ROW_106_2302 VSS VDD sky130_fd_sc_hd__tapvpwrvgnd_1
XTAP_TAPCELL_ROW_106_2303 VSS VDD sky130_fd_sc_hd__tapvpwrvgnd_1
XTAP_TAPCELL_ROW_106_2304 VSS VDD sky130_fd_sc_hd__tapvpwrvgnd_1
XTAP_TAPCELL_ROW_106_2305 VSS VDD sky130_fd_sc_hd__tapvpwrvgnd_1
XTAP_TAPCELL_ROW_106_2306 VSS VDD sky130_fd_sc_hd__tapvpwrvgnd_1
XTAP_TAPCELL_ROW_106_2307 VSS VDD sky130_fd_sc_hd__tapvpwrvgnd_1
XTAP_TAPCELL_ROW_106_2308 VSS VDD sky130_fd_sc_hd__tapvpwrvgnd_1
XTAP_TAPCELL_ROW_106_2309 VSS VDD sky130_fd_sc_hd__tapvpwrvgnd_1
XTAP_TAPCELL_ROW_106_2310 VSS VDD sky130_fd_sc_hd__tapvpwrvgnd_1
XTAP_TAPCELL_ROW_106_2311 VSS VDD sky130_fd_sc_hd__tapvpwrvgnd_1
XTAP_TAPCELL_ROW_106_2312 VSS VDD sky130_fd_sc_hd__tapvpwrvgnd_1
XTAP_TAPCELL_ROW_106_2313 VSS VDD sky130_fd_sc_hd__tapvpwrvgnd_1
XTAP_TAPCELL_ROW_106_2314 VSS VDD sky130_fd_sc_hd__tapvpwrvgnd_1
XTAP_TAPCELL_ROW_106_2315 VSS VDD sky130_fd_sc_hd__tapvpwrvgnd_1
XTAP_TAPCELL_ROW_106_2316 VSS VDD sky130_fd_sc_hd__tapvpwrvgnd_1
XTAP_TAPCELL_ROW_106_2317 VSS VDD sky130_fd_sc_hd__tapvpwrvgnd_1
XTAP_TAPCELL_ROW_106_2318 VSS VDD sky130_fd_sc_hd__tapvpwrvgnd_1
XTAP_TAPCELL_ROW_106_2319 VSS VDD sky130_fd_sc_hd__tapvpwrvgnd_1
XTAP_TAPCELL_ROW_106_2320 VSS VDD sky130_fd_sc_hd__tapvpwrvgnd_1
XTAP_TAPCELL_ROW_106_2321 VSS VDD sky130_fd_sc_hd__tapvpwrvgnd_1
XTAP_TAPCELL_ROW_107_2322 VSS VDD sky130_fd_sc_hd__tapvpwrvgnd_1
XTAP_TAPCELL_ROW_107_2323 VSS VDD sky130_fd_sc_hd__tapvpwrvgnd_1
XTAP_TAPCELL_ROW_107_2324 VSS VDD sky130_fd_sc_hd__tapvpwrvgnd_1
XTAP_TAPCELL_ROW_107_2325 VSS VDD sky130_fd_sc_hd__tapvpwrvgnd_1
XTAP_TAPCELL_ROW_107_2326 VSS VDD sky130_fd_sc_hd__tapvpwrvgnd_1
XTAP_TAPCELL_ROW_107_2327 VSS VDD sky130_fd_sc_hd__tapvpwrvgnd_1
XTAP_TAPCELL_ROW_107_2328 VSS VDD sky130_fd_sc_hd__tapvpwrvgnd_1
XTAP_TAPCELL_ROW_107_2329 VSS VDD sky130_fd_sc_hd__tapvpwrvgnd_1
XTAP_TAPCELL_ROW_107_2330 VSS VDD sky130_fd_sc_hd__tapvpwrvgnd_1
XTAP_TAPCELL_ROW_107_2331 VSS VDD sky130_fd_sc_hd__tapvpwrvgnd_1
XTAP_TAPCELL_ROW_107_2332 VSS VDD sky130_fd_sc_hd__tapvpwrvgnd_1
XTAP_TAPCELL_ROW_107_2333 VSS VDD sky130_fd_sc_hd__tapvpwrvgnd_1
XTAP_TAPCELL_ROW_107_2334 VSS VDD sky130_fd_sc_hd__tapvpwrvgnd_1
XTAP_TAPCELL_ROW_107_2335 VSS VDD sky130_fd_sc_hd__tapvpwrvgnd_1
XTAP_TAPCELL_ROW_107_2336 VSS VDD sky130_fd_sc_hd__tapvpwrvgnd_1
XTAP_TAPCELL_ROW_107_2337 VSS VDD sky130_fd_sc_hd__tapvpwrvgnd_1
XTAP_TAPCELL_ROW_107_2338 VSS VDD sky130_fd_sc_hd__tapvpwrvgnd_1
XTAP_TAPCELL_ROW_107_2339 VSS VDD sky130_fd_sc_hd__tapvpwrvgnd_1
XTAP_TAPCELL_ROW_107_2340 VSS VDD sky130_fd_sc_hd__tapvpwrvgnd_1
XTAP_TAPCELL_ROW_107_2341 VSS VDD sky130_fd_sc_hd__tapvpwrvgnd_1
XTAP_TAPCELL_ROW_107_2342 VSS VDD sky130_fd_sc_hd__tapvpwrvgnd_1
XTAP_TAPCELL_ROW_108_2343 VSS VDD sky130_fd_sc_hd__tapvpwrvgnd_1
XTAP_TAPCELL_ROW_108_2344 VSS VDD sky130_fd_sc_hd__tapvpwrvgnd_1
XTAP_TAPCELL_ROW_108_2345 VSS VDD sky130_fd_sc_hd__tapvpwrvgnd_1
XTAP_TAPCELL_ROW_108_2346 VSS VDD sky130_fd_sc_hd__tapvpwrvgnd_1
XTAP_TAPCELL_ROW_108_2347 VSS VDD sky130_fd_sc_hd__tapvpwrvgnd_1
XTAP_TAPCELL_ROW_108_2348 VSS VDD sky130_fd_sc_hd__tapvpwrvgnd_1
XTAP_TAPCELL_ROW_108_2349 VSS VDD sky130_fd_sc_hd__tapvpwrvgnd_1
XTAP_TAPCELL_ROW_108_2350 VSS VDD sky130_fd_sc_hd__tapvpwrvgnd_1
XTAP_TAPCELL_ROW_108_2351 VSS VDD sky130_fd_sc_hd__tapvpwrvgnd_1
XTAP_TAPCELL_ROW_108_2352 VSS VDD sky130_fd_sc_hd__tapvpwrvgnd_1
XTAP_TAPCELL_ROW_108_2353 VSS VDD sky130_fd_sc_hd__tapvpwrvgnd_1
XTAP_TAPCELL_ROW_108_2354 VSS VDD sky130_fd_sc_hd__tapvpwrvgnd_1
XTAP_TAPCELL_ROW_108_2355 VSS VDD sky130_fd_sc_hd__tapvpwrvgnd_1
XTAP_TAPCELL_ROW_108_2356 VSS VDD sky130_fd_sc_hd__tapvpwrvgnd_1
XTAP_TAPCELL_ROW_108_2357 VSS VDD sky130_fd_sc_hd__tapvpwrvgnd_1
XTAP_TAPCELL_ROW_108_2358 VSS VDD sky130_fd_sc_hd__tapvpwrvgnd_1
XTAP_TAPCELL_ROW_108_2359 VSS VDD sky130_fd_sc_hd__tapvpwrvgnd_1
XTAP_TAPCELL_ROW_108_2360 VSS VDD sky130_fd_sc_hd__tapvpwrvgnd_1
XTAP_TAPCELL_ROW_108_2361 VSS VDD sky130_fd_sc_hd__tapvpwrvgnd_1
XTAP_TAPCELL_ROW_108_2362 VSS VDD sky130_fd_sc_hd__tapvpwrvgnd_1
XTAP_TAPCELL_ROW_108_2363 VSS VDD sky130_fd_sc_hd__tapvpwrvgnd_1
XTAP_TAPCELL_ROW_108_2364 VSS VDD sky130_fd_sc_hd__tapvpwrvgnd_1
XTAP_TAPCELL_ROW_109_2365 VSS VDD sky130_fd_sc_hd__tapvpwrvgnd_1
XTAP_TAPCELL_ROW_109_2366 VSS VDD sky130_fd_sc_hd__tapvpwrvgnd_1
XTAP_TAPCELL_ROW_109_2367 VSS VDD sky130_fd_sc_hd__tapvpwrvgnd_1
XTAP_TAPCELL_ROW_109_2368 VSS VDD sky130_fd_sc_hd__tapvpwrvgnd_1
XTAP_TAPCELL_ROW_109_2369 VSS VDD sky130_fd_sc_hd__tapvpwrvgnd_1
XTAP_TAPCELL_ROW_109_2370 VSS VDD sky130_fd_sc_hd__tapvpwrvgnd_1
XTAP_TAPCELL_ROW_109_2371 VSS VDD sky130_fd_sc_hd__tapvpwrvgnd_1
XTAP_TAPCELL_ROW_109_2372 VSS VDD sky130_fd_sc_hd__tapvpwrvgnd_1
XTAP_TAPCELL_ROW_109_2373 VSS VDD sky130_fd_sc_hd__tapvpwrvgnd_1
XTAP_TAPCELL_ROW_109_2374 VSS VDD sky130_fd_sc_hd__tapvpwrvgnd_1
XTAP_TAPCELL_ROW_109_2375 VSS VDD sky130_fd_sc_hd__tapvpwrvgnd_1
XTAP_TAPCELL_ROW_109_2376 VSS VDD sky130_fd_sc_hd__tapvpwrvgnd_1
XTAP_TAPCELL_ROW_109_2377 VSS VDD sky130_fd_sc_hd__tapvpwrvgnd_1
XTAP_TAPCELL_ROW_109_2378 VSS VDD sky130_fd_sc_hd__tapvpwrvgnd_1
XTAP_TAPCELL_ROW_109_2379 VSS VDD sky130_fd_sc_hd__tapvpwrvgnd_1
XTAP_TAPCELL_ROW_109_2380 VSS VDD sky130_fd_sc_hd__tapvpwrvgnd_1
XTAP_TAPCELL_ROW_109_2381 VSS VDD sky130_fd_sc_hd__tapvpwrvgnd_1
XTAP_TAPCELL_ROW_109_2382 VSS VDD sky130_fd_sc_hd__tapvpwrvgnd_1
XTAP_TAPCELL_ROW_109_2383 VSS VDD sky130_fd_sc_hd__tapvpwrvgnd_1
XTAP_TAPCELL_ROW_109_2384 VSS VDD sky130_fd_sc_hd__tapvpwrvgnd_1
XTAP_TAPCELL_ROW_109_2385 VSS VDD sky130_fd_sc_hd__tapvpwrvgnd_1
XTAP_TAPCELL_ROW_110_2386 VSS VDD sky130_fd_sc_hd__tapvpwrvgnd_1
XTAP_TAPCELL_ROW_110_2387 VSS VDD sky130_fd_sc_hd__tapvpwrvgnd_1
XTAP_TAPCELL_ROW_110_2388 VSS VDD sky130_fd_sc_hd__tapvpwrvgnd_1
XTAP_TAPCELL_ROW_110_2389 VSS VDD sky130_fd_sc_hd__tapvpwrvgnd_1
XTAP_TAPCELL_ROW_110_2390 VSS VDD sky130_fd_sc_hd__tapvpwrvgnd_1
XTAP_TAPCELL_ROW_110_2391 VSS VDD sky130_fd_sc_hd__tapvpwrvgnd_1
XTAP_TAPCELL_ROW_110_2392 VSS VDD sky130_fd_sc_hd__tapvpwrvgnd_1
XTAP_TAPCELL_ROW_110_2393 VSS VDD sky130_fd_sc_hd__tapvpwrvgnd_1
XTAP_TAPCELL_ROW_110_2394 VSS VDD sky130_fd_sc_hd__tapvpwrvgnd_1
XTAP_TAPCELL_ROW_110_2395 VSS VDD sky130_fd_sc_hd__tapvpwrvgnd_1
XTAP_TAPCELL_ROW_110_2396 VSS VDD sky130_fd_sc_hd__tapvpwrvgnd_1
XTAP_TAPCELL_ROW_110_2397 VSS VDD sky130_fd_sc_hd__tapvpwrvgnd_1
XTAP_TAPCELL_ROW_110_2398 VSS VDD sky130_fd_sc_hd__tapvpwrvgnd_1
XTAP_TAPCELL_ROW_110_2399 VSS VDD sky130_fd_sc_hd__tapvpwrvgnd_1
XTAP_TAPCELL_ROW_110_2400 VSS VDD sky130_fd_sc_hd__tapvpwrvgnd_1
XTAP_TAPCELL_ROW_110_2401 VSS VDD sky130_fd_sc_hd__tapvpwrvgnd_1
XTAP_TAPCELL_ROW_110_2402 VSS VDD sky130_fd_sc_hd__tapvpwrvgnd_1
XTAP_TAPCELL_ROW_110_2403 VSS VDD sky130_fd_sc_hd__tapvpwrvgnd_1
XTAP_TAPCELL_ROW_110_2404 VSS VDD sky130_fd_sc_hd__tapvpwrvgnd_1
XTAP_TAPCELL_ROW_110_2405 VSS VDD sky130_fd_sc_hd__tapvpwrvgnd_1
XTAP_TAPCELL_ROW_110_2406 VSS VDD sky130_fd_sc_hd__tapvpwrvgnd_1
XTAP_TAPCELL_ROW_110_2407 VSS VDD sky130_fd_sc_hd__tapvpwrvgnd_1
XTAP_TAPCELL_ROW_111_2408 VSS VDD sky130_fd_sc_hd__tapvpwrvgnd_1
XTAP_TAPCELL_ROW_111_2409 VSS VDD sky130_fd_sc_hd__tapvpwrvgnd_1
XTAP_TAPCELL_ROW_111_2410 VSS VDD sky130_fd_sc_hd__tapvpwrvgnd_1
XTAP_TAPCELL_ROW_111_2411 VSS VDD sky130_fd_sc_hd__tapvpwrvgnd_1
XTAP_TAPCELL_ROW_111_2412 VSS VDD sky130_fd_sc_hd__tapvpwrvgnd_1
XTAP_TAPCELL_ROW_111_2413 VSS VDD sky130_fd_sc_hd__tapvpwrvgnd_1
XTAP_TAPCELL_ROW_111_2414 VSS VDD sky130_fd_sc_hd__tapvpwrvgnd_1
XTAP_TAPCELL_ROW_111_2415 VSS VDD sky130_fd_sc_hd__tapvpwrvgnd_1
XTAP_TAPCELL_ROW_111_2416 VSS VDD sky130_fd_sc_hd__tapvpwrvgnd_1
XTAP_TAPCELL_ROW_111_2417 VSS VDD sky130_fd_sc_hd__tapvpwrvgnd_1
XTAP_TAPCELL_ROW_111_2418 VSS VDD sky130_fd_sc_hd__tapvpwrvgnd_1
XTAP_TAPCELL_ROW_111_2419 VSS VDD sky130_fd_sc_hd__tapvpwrvgnd_1
XTAP_TAPCELL_ROW_111_2420 VSS VDD sky130_fd_sc_hd__tapvpwrvgnd_1
XTAP_TAPCELL_ROW_111_2421 VSS VDD sky130_fd_sc_hd__tapvpwrvgnd_1
XTAP_TAPCELL_ROW_111_2422 VSS VDD sky130_fd_sc_hd__tapvpwrvgnd_1
XTAP_TAPCELL_ROW_111_2423 VSS VDD sky130_fd_sc_hd__tapvpwrvgnd_1
XTAP_TAPCELL_ROW_111_2424 VSS VDD sky130_fd_sc_hd__tapvpwrvgnd_1
XTAP_TAPCELL_ROW_111_2425 VSS VDD sky130_fd_sc_hd__tapvpwrvgnd_1
XTAP_TAPCELL_ROW_111_2426 VSS VDD sky130_fd_sc_hd__tapvpwrvgnd_1
XTAP_TAPCELL_ROW_111_2427 VSS VDD sky130_fd_sc_hd__tapvpwrvgnd_1
XTAP_TAPCELL_ROW_111_2428 VSS VDD sky130_fd_sc_hd__tapvpwrvgnd_1
XTAP_TAPCELL_ROW_112_2429 VSS VDD sky130_fd_sc_hd__tapvpwrvgnd_1
XTAP_TAPCELL_ROW_112_2430 VSS VDD sky130_fd_sc_hd__tapvpwrvgnd_1
XTAP_TAPCELL_ROW_112_2431 VSS VDD sky130_fd_sc_hd__tapvpwrvgnd_1
XTAP_TAPCELL_ROW_112_2432 VSS VDD sky130_fd_sc_hd__tapvpwrvgnd_1
XTAP_TAPCELL_ROW_112_2433 VSS VDD sky130_fd_sc_hd__tapvpwrvgnd_1
XTAP_TAPCELL_ROW_112_2434 VSS VDD sky130_fd_sc_hd__tapvpwrvgnd_1
XTAP_TAPCELL_ROW_112_2435 VSS VDD sky130_fd_sc_hd__tapvpwrvgnd_1
XTAP_TAPCELL_ROW_112_2436 VSS VDD sky130_fd_sc_hd__tapvpwrvgnd_1
XTAP_TAPCELL_ROW_112_2437 VSS VDD sky130_fd_sc_hd__tapvpwrvgnd_1
XTAP_TAPCELL_ROW_112_2438 VSS VDD sky130_fd_sc_hd__tapvpwrvgnd_1
XTAP_TAPCELL_ROW_112_2439 VSS VDD sky130_fd_sc_hd__tapvpwrvgnd_1
XTAP_TAPCELL_ROW_112_2440 VSS VDD sky130_fd_sc_hd__tapvpwrvgnd_1
XTAP_TAPCELL_ROW_112_2441 VSS VDD sky130_fd_sc_hd__tapvpwrvgnd_1
XTAP_TAPCELL_ROW_112_2442 VSS VDD sky130_fd_sc_hd__tapvpwrvgnd_1
XTAP_TAPCELL_ROW_112_2443 VSS VDD sky130_fd_sc_hd__tapvpwrvgnd_1
XTAP_TAPCELL_ROW_112_2444 VSS VDD sky130_fd_sc_hd__tapvpwrvgnd_1
XTAP_TAPCELL_ROW_112_2445 VSS VDD sky130_fd_sc_hd__tapvpwrvgnd_1
XTAP_TAPCELL_ROW_112_2446 VSS VDD sky130_fd_sc_hd__tapvpwrvgnd_1
XTAP_TAPCELL_ROW_112_2447 VSS VDD sky130_fd_sc_hd__tapvpwrvgnd_1
XTAP_TAPCELL_ROW_112_2448 VSS VDD sky130_fd_sc_hd__tapvpwrvgnd_1
XTAP_TAPCELL_ROW_112_2449 VSS VDD sky130_fd_sc_hd__tapvpwrvgnd_1
XTAP_TAPCELL_ROW_112_2450 VSS VDD sky130_fd_sc_hd__tapvpwrvgnd_1
XTAP_TAPCELL_ROW_113_2451 VSS VDD sky130_fd_sc_hd__tapvpwrvgnd_1
XTAP_TAPCELL_ROW_113_2452 VSS VDD sky130_fd_sc_hd__tapvpwrvgnd_1
XTAP_TAPCELL_ROW_113_2453 VSS VDD sky130_fd_sc_hd__tapvpwrvgnd_1
XTAP_TAPCELL_ROW_113_2454 VSS VDD sky130_fd_sc_hd__tapvpwrvgnd_1
XTAP_TAPCELL_ROW_113_2455 VSS VDD sky130_fd_sc_hd__tapvpwrvgnd_1
XTAP_TAPCELL_ROW_113_2456 VSS VDD sky130_fd_sc_hd__tapvpwrvgnd_1
XTAP_TAPCELL_ROW_113_2457 VSS VDD sky130_fd_sc_hd__tapvpwrvgnd_1
XTAP_TAPCELL_ROW_113_2458 VSS VDD sky130_fd_sc_hd__tapvpwrvgnd_1
XTAP_TAPCELL_ROW_113_2459 VSS VDD sky130_fd_sc_hd__tapvpwrvgnd_1
XTAP_TAPCELL_ROW_113_2460 VSS VDD sky130_fd_sc_hd__tapvpwrvgnd_1
XTAP_TAPCELL_ROW_113_2461 VSS VDD sky130_fd_sc_hd__tapvpwrvgnd_1
XTAP_TAPCELL_ROW_113_2462 VSS VDD sky130_fd_sc_hd__tapvpwrvgnd_1
XTAP_TAPCELL_ROW_113_2463 VSS VDD sky130_fd_sc_hd__tapvpwrvgnd_1
XTAP_TAPCELL_ROW_113_2464 VSS VDD sky130_fd_sc_hd__tapvpwrvgnd_1
XTAP_TAPCELL_ROW_113_2465 VSS VDD sky130_fd_sc_hd__tapvpwrvgnd_1
XTAP_TAPCELL_ROW_113_2466 VSS VDD sky130_fd_sc_hd__tapvpwrvgnd_1
XTAP_TAPCELL_ROW_113_2467 VSS VDD sky130_fd_sc_hd__tapvpwrvgnd_1
XTAP_TAPCELL_ROW_113_2468 VSS VDD sky130_fd_sc_hd__tapvpwrvgnd_1
XTAP_TAPCELL_ROW_113_2469 VSS VDD sky130_fd_sc_hd__tapvpwrvgnd_1
XTAP_TAPCELL_ROW_113_2470 VSS VDD sky130_fd_sc_hd__tapvpwrvgnd_1
XTAP_TAPCELL_ROW_113_2471 VSS VDD sky130_fd_sc_hd__tapvpwrvgnd_1
XTAP_TAPCELL_ROW_114_2472 VSS VDD sky130_fd_sc_hd__tapvpwrvgnd_1
XTAP_TAPCELL_ROW_114_2473 VSS VDD sky130_fd_sc_hd__tapvpwrvgnd_1
XTAP_TAPCELL_ROW_114_2474 VSS VDD sky130_fd_sc_hd__tapvpwrvgnd_1
XTAP_TAPCELL_ROW_114_2475 VSS VDD sky130_fd_sc_hd__tapvpwrvgnd_1
XTAP_TAPCELL_ROW_114_2476 VSS VDD sky130_fd_sc_hd__tapvpwrvgnd_1
XTAP_TAPCELL_ROW_114_2477 VSS VDD sky130_fd_sc_hd__tapvpwrvgnd_1
XTAP_TAPCELL_ROW_114_2478 VSS VDD sky130_fd_sc_hd__tapvpwrvgnd_1
XTAP_TAPCELL_ROW_114_2479 VSS VDD sky130_fd_sc_hd__tapvpwrvgnd_1
XTAP_TAPCELL_ROW_114_2480 VSS VDD sky130_fd_sc_hd__tapvpwrvgnd_1
XTAP_TAPCELL_ROW_114_2481 VSS VDD sky130_fd_sc_hd__tapvpwrvgnd_1
XTAP_TAPCELL_ROW_114_2482 VSS VDD sky130_fd_sc_hd__tapvpwrvgnd_1
XTAP_TAPCELL_ROW_114_2483 VSS VDD sky130_fd_sc_hd__tapvpwrvgnd_1
XTAP_TAPCELL_ROW_114_2484 VSS VDD sky130_fd_sc_hd__tapvpwrvgnd_1
XTAP_TAPCELL_ROW_114_2485 VSS VDD sky130_fd_sc_hd__tapvpwrvgnd_1
XTAP_TAPCELL_ROW_114_2486 VSS VDD sky130_fd_sc_hd__tapvpwrvgnd_1
XTAP_TAPCELL_ROW_114_2487 VSS VDD sky130_fd_sc_hd__tapvpwrvgnd_1
XTAP_TAPCELL_ROW_114_2488 VSS VDD sky130_fd_sc_hd__tapvpwrvgnd_1
XTAP_TAPCELL_ROW_114_2489 VSS VDD sky130_fd_sc_hd__tapvpwrvgnd_1
XTAP_TAPCELL_ROW_114_2490 VSS VDD sky130_fd_sc_hd__tapvpwrvgnd_1
XTAP_TAPCELL_ROW_114_2491 VSS VDD sky130_fd_sc_hd__tapvpwrvgnd_1
XTAP_TAPCELL_ROW_114_2492 VSS VDD sky130_fd_sc_hd__tapvpwrvgnd_1
XTAP_TAPCELL_ROW_114_2493 VSS VDD sky130_fd_sc_hd__tapvpwrvgnd_1
XTAP_TAPCELL_ROW_115_2494 VSS VDD sky130_fd_sc_hd__tapvpwrvgnd_1
XTAP_TAPCELL_ROW_115_2495 VSS VDD sky130_fd_sc_hd__tapvpwrvgnd_1
XTAP_TAPCELL_ROW_115_2496 VSS VDD sky130_fd_sc_hd__tapvpwrvgnd_1
XTAP_TAPCELL_ROW_115_2497 VSS VDD sky130_fd_sc_hd__tapvpwrvgnd_1
XTAP_TAPCELL_ROW_115_2498 VSS VDD sky130_fd_sc_hd__tapvpwrvgnd_1
XTAP_TAPCELL_ROW_115_2499 VSS VDD sky130_fd_sc_hd__tapvpwrvgnd_1
XTAP_TAPCELL_ROW_115_2500 VSS VDD sky130_fd_sc_hd__tapvpwrvgnd_1
XTAP_TAPCELL_ROW_115_2501 VSS VDD sky130_fd_sc_hd__tapvpwrvgnd_1
XTAP_TAPCELL_ROW_115_2502 VSS VDD sky130_fd_sc_hd__tapvpwrvgnd_1
XTAP_TAPCELL_ROW_115_2503 VSS VDD sky130_fd_sc_hd__tapvpwrvgnd_1
XTAP_TAPCELL_ROW_115_2504 VSS VDD sky130_fd_sc_hd__tapvpwrvgnd_1
XTAP_TAPCELL_ROW_115_2505 VSS VDD sky130_fd_sc_hd__tapvpwrvgnd_1
XTAP_TAPCELL_ROW_115_2506 VSS VDD sky130_fd_sc_hd__tapvpwrvgnd_1
XTAP_TAPCELL_ROW_115_2507 VSS VDD sky130_fd_sc_hd__tapvpwrvgnd_1
XTAP_TAPCELL_ROW_115_2508 VSS VDD sky130_fd_sc_hd__tapvpwrvgnd_1
XTAP_TAPCELL_ROW_115_2509 VSS VDD sky130_fd_sc_hd__tapvpwrvgnd_1
XTAP_TAPCELL_ROW_115_2510 VSS VDD sky130_fd_sc_hd__tapvpwrvgnd_1
XTAP_TAPCELL_ROW_115_2511 VSS VDD sky130_fd_sc_hd__tapvpwrvgnd_1
XTAP_TAPCELL_ROW_115_2512 VSS VDD sky130_fd_sc_hd__tapvpwrvgnd_1
XTAP_TAPCELL_ROW_115_2513 VSS VDD sky130_fd_sc_hd__tapvpwrvgnd_1
XTAP_TAPCELL_ROW_115_2514 VSS VDD sky130_fd_sc_hd__tapvpwrvgnd_1
XTAP_TAPCELL_ROW_116_2515 VSS VDD sky130_fd_sc_hd__tapvpwrvgnd_1
XTAP_TAPCELL_ROW_116_2516 VSS VDD sky130_fd_sc_hd__tapvpwrvgnd_1
XTAP_TAPCELL_ROW_116_2517 VSS VDD sky130_fd_sc_hd__tapvpwrvgnd_1
XTAP_TAPCELL_ROW_116_2518 VSS VDD sky130_fd_sc_hd__tapvpwrvgnd_1
XTAP_TAPCELL_ROW_116_2519 VSS VDD sky130_fd_sc_hd__tapvpwrvgnd_1
XTAP_TAPCELL_ROW_116_2520 VSS VDD sky130_fd_sc_hd__tapvpwrvgnd_1
XTAP_TAPCELL_ROW_116_2521 VSS VDD sky130_fd_sc_hd__tapvpwrvgnd_1
XTAP_TAPCELL_ROW_116_2522 VSS VDD sky130_fd_sc_hd__tapvpwrvgnd_1
XTAP_TAPCELL_ROW_116_2523 VSS VDD sky130_fd_sc_hd__tapvpwrvgnd_1
XTAP_TAPCELL_ROW_116_2524 VSS VDD sky130_fd_sc_hd__tapvpwrvgnd_1
XTAP_TAPCELL_ROW_116_2525 VSS VDD sky130_fd_sc_hd__tapvpwrvgnd_1
XTAP_TAPCELL_ROW_116_2526 VSS VDD sky130_fd_sc_hd__tapvpwrvgnd_1
XTAP_TAPCELL_ROW_116_2527 VSS VDD sky130_fd_sc_hd__tapvpwrvgnd_1
XTAP_TAPCELL_ROW_116_2528 VSS VDD sky130_fd_sc_hd__tapvpwrvgnd_1
XTAP_TAPCELL_ROW_116_2529 VSS VDD sky130_fd_sc_hd__tapvpwrvgnd_1
XTAP_TAPCELL_ROW_116_2530 VSS VDD sky130_fd_sc_hd__tapvpwrvgnd_1
XTAP_TAPCELL_ROW_116_2531 VSS VDD sky130_fd_sc_hd__tapvpwrvgnd_1
XTAP_TAPCELL_ROW_116_2532 VSS VDD sky130_fd_sc_hd__tapvpwrvgnd_1
XTAP_TAPCELL_ROW_116_2533 VSS VDD sky130_fd_sc_hd__tapvpwrvgnd_1
XTAP_TAPCELL_ROW_116_2534 VSS VDD sky130_fd_sc_hd__tapvpwrvgnd_1
XTAP_TAPCELL_ROW_116_2535 VSS VDD sky130_fd_sc_hd__tapvpwrvgnd_1
XTAP_TAPCELL_ROW_116_2536 VSS VDD sky130_fd_sc_hd__tapvpwrvgnd_1
XTAP_TAPCELL_ROW_117_2537 VSS VDD sky130_fd_sc_hd__tapvpwrvgnd_1
XTAP_TAPCELL_ROW_117_2538 VSS VDD sky130_fd_sc_hd__tapvpwrvgnd_1
XTAP_TAPCELL_ROW_117_2539 VSS VDD sky130_fd_sc_hd__tapvpwrvgnd_1
XTAP_TAPCELL_ROW_117_2540 VSS VDD sky130_fd_sc_hd__tapvpwrvgnd_1
XTAP_TAPCELL_ROW_117_2541 VSS VDD sky130_fd_sc_hd__tapvpwrvgnd_1
XTAP_TAPCELL_ROW_117_2542 VSS VDD sky130_fd_sc_hd__tapvpwrvgnd_1
XTAP_TAPCELL_ROW_117_2543 VSS VDD sky130_fd_sc_hd__tapvpwrvgnd_1
XTAP_TAPCELL_ROW_117_2544 VSS VDD sky130_fd_sc_hd__tapvpwrvgnd_1
XTAP_TAPCELL_ROW_117_2545 VSS VDD sky130_fd_sc_hd__tapvpwrvgnd_1
XTAP_TAPCELL_ROW_117_2546 VSS VDD sky130_fd_sc_hd__tapvpwrvgnd_1
XTAP_TAPCELL_ROW_117_2547 VSS VDD sky130_fd_sc_hd__tapvpwrvgnd_1
XTAP_TAPCELL_ROW_117_2548 VSS VDD sky130_fd_sc_hd__tapvpwrvgnd_1
XTAP_TAPCELL_ROW_117_2549 VSS VDD sky130_fd_sc_hd__tapvpwrvgnd_1
XTAP_TAPCELL_ROW_117_2550 VSS VDD sky130_fd_sc_hd__tapvpwrvgnd_1
XTAP_TAPCELL_ROW_117_2551 VSS VDD sky130_fd_sc_hd__tapvpwrvgnd_1
XTAP_TAPCELL_ROW_117_2552 VSS VDD sky130_fd_sc_hd__tapvpwrvgnd_1
XTAP_TAPCELL_ROW_117_2553 VSS VDD sky130_fd_sc_hd__tapvpwrvgnd_1
XTAP_TAPCELL_ROW_117_2554 VSS VDD sky130_fd_sc_hd__tapvpwrvgnd_1
XTAP_TAPCELL_ROW_117_2555 VSS VDD sky130_fd_sc_hd__tapvpwrvgnd_1
XTAP_TAPCELL_ROW_117_2556 VSS VDD sky130_fd_sc_hd__tapvpwrvgnd_1
XTAP_TAPCELL_ROW_117_2557 VSS VDD sky130_fd_sc_hd__tapvpwrvgnd_1
XTAP_TAPCELL_ROW_118_2558 VSS VDD sky130_fd_sc_hd__tapvpwrvgnd_1
XTAP_TAPCELL_ROW_118_2559 VSS VDD sky130_fd_sc_hd__tapvpwrvgnd_1
XTAP_TAPCELL_ROW_118_2560 VSS VDD sky130_fd_sc_hd__tapvpwrvgnd_1
XTAP_TAPCELL_ROW_118_2561 VSS VDD sky130_fd_sc_hd__tapvpwrvgnd_1
XTAP_TAPCELL_ROW_118_2562 VSS VDD sky130_fd_sc_hd__tapvpwrvgnd_1
XTAP_TAPCELL_ROW_118_2563 VSS VDD sky130_fd_sc_hd__tapvpwrvgnd_1
XTAP_TAPCELL_ROW_118_2564 VSS VDD sky130_fd_sc_hd__tapvpwrvgnd_1
XTAP_TAPCELL_ROW_118_2565 VSS VDD sky130_fd_sc_hd__tapvpwrvgnd_1
XTAP_TAPCELL_ROW_118_2566 VSS VDD sky130_fd_sc_hd__tapvpwrvgnd_1
XTAP_TAPCELL_ROW_118_2567 VSS VDD sky130_fd_sc_hd__tapvpwrvgnd_1
XTAP_TAPCELL_ROW_118_2568 VSS VDD sky130_fd_sc_hd__tapvpwrvgnd_1
XTAP_TAPCELL_ROW_118_2569 VSS VDD sky130_fd_sc_hd__tapvpwrvgnd_1
XTAP_TAPCELL_ROW_118_2570 VSS VDD sky130_fd_sc_hd__tapvpwrvgnd_1
XTAP_TAPCELL_ROW_118_2571 VSS VDD sky130_fd_sc_hd__tapvpwrvgnd_1
XTAP_TAPCELL_ROW_118_2572 VSS VDD sky130_fd_sc_hd__tapvpwrvgnd_1
XTAP_TAPCELL_ROW_118_2573 VSS VDD sky130_fd_sc_hd__tapvpwrvgnd_1
XTAP_TAPCELL_ROW_118_2574 VSS VDD sky130_fd_sc_hd__tapvpwrvgnd_1
XTAP_TAPCELL_ROW_118_2575 VSS VDD sky130_fd_sc_hd__tapvpwrvgnd_1
XTAP_TAPCELL_ROW_118_2576 VSS VDD sky130_fd_sc_hd__tapvpwrvgnd_1
XTAP_TAPCELL_ROW_118_2577 VSS VDD sky130_fd_sc_hd__tapvpwrvgnd_1
XTAP_TAPCELL_ROW_118_2578 VSS VDD sky130_fd_sc_hd__tapvpwrvgnd_1
XTAP_TAPCELL_ROW_118_2579 VSS VDD sky130_fd_sc_hd__tapvpwrvgnd_1
XTAP_TAPCELL_ROW_119_2580 VSS VDD sky130_fd_sc_hd__tapvpwrvgnd_1
XTAP_TAPCELL_ROW_119_2581 VSS VDD sky130_fd_sc_hd__tapvpwrvgnd_1
XTAP_TAPCELL_ROW_119_2582 VSS VDD sky130_fd_sc_hd__tapvpwrvgnd_1
XTAP_TAPCELL_ROW_119_2583 VSS VDD sky130_fd_sc_hd__tapvpwrvgnd_1
XTAP_TAPCELL_ROW_119_2584 VSS VDD sky130_fd_sc_hd__tapvpwrvgnd_1
XTAP_TAPCELL_ROW_119_2585 VSS VDD sky130_fd_sc_hd__tapvpwrvgnd_1
XTAP_TAPCELL_ROW_119_2586 VSS VDD sky130_fd_sc_hd__tapvpwrvgnd_1
XTAP_TAPCELL_ROW_119_2587 VSS VDD sky130_fd_sc_hd__tapvpwrvgnd_1
XTAP_TAPCELL_ROW_119_2588 VSS VDD sky130_fd_sc_hd__tapvpwrvgnd_1
XTAP_TAPCELL_ROW_119_2589 VSS VDD sky130_fd_sc_hd__tapvpwrvgnd_1
XTAP_TAPCELL_ROW_119_2590 VSS VDD sky130_fd_sc_hd__tapvpwrvgnd_1
XTAP_TAPCELL_ROW_119_2591 VSS VDD sky130_fd_sc_hd__tapvpwrvgnd_1
XTAP_TAPCELL_ROW_119_2592 VSS VDD sky130_fd_sc_hd__tapvpwrvgnd_1
XTAP_TAPCELL_ROW_119_2593 VSS VDD sky130_fd_sc_hd__tapvpwrvgnd_1
XTAP_TAPCELL_ROW_119_2594 VSS VDD sky130_fd_sc_hd__tapvpwrvgnd_1
XTAP_TAPCELL_ROW_119_2595 VSS VDD sky130_fd_sc_hd__tapvpwrvgnd_1
XTAP_TAPCELL_ROW_119_2596 VSS VDD sky130_fd_sc_hd__tapvpwrvgnd_1
XTAP_TAPCELL_ROW_119_2597 VSS VDD sky130_fd_sc_hd__tapvpwrvgnd_1
XTAP_TAPCELL_ROW_119_2598 VSS VDD sky130_fd_sc_hd__tapvpwrvgnd_1
XTAP_TAPCELL_ROW_119_2599 VSS VDD sky130_fd_sc_hd__tapvpwrvgnd_1
XTAP_TAPCELL_ROW_119_2600 VSS VDD sky130_fd_sc_hd__tapvpwrvgnd_1
XTAP_TAPCELL_ROW_120_2601 VSS VDD sky130_fd_sc_hd__tapvpwrvgnd_1
XTAP_TAPCELL_ROW_120_2602 VSS VDD sky130_fd_sc_hd__tapvpwrvgnd_1
XTAP_TAPCELL_ROW_120_2603 VSS VDD sky130_fd_sc_hd__tapvpwrvgnd_1
XTAP_TAPCELL_ROW_120_2604 VSS VDD sky130_fd_sc_hd__tapvpwrvgnd_1
XTAP_TAPCELL_ROW_120_2605 VSS VDD sky130_fd_sc_hd__tapvpwrvgnd_1
XTAP_TAPCELL_ROW_120_2606 VSS VDD sky130_fd_sc_hd__tapvpwrvgnd_1
XTAP_TAPCELL_ROW_120_2607 VSS VDD sky130_fd_sc_hd__tapvpwrvgnd_1
XTAP_TAPCELL_ROW_120_2608 VSS VDD sky130_fd_sc_hd__tapvpwrvgnd_1
XTAP_TAPCELL_ROW_120_2609 VSS VDD sky130_fd_sc_hd__tapvpwrvgnd_1
XTAP_TAPCELL_ROW_120_2610 VSS VDD sky130_fd_sc_hd__tapvpwrvgnd_1
XTAP_TAPCELL_ROW_120_2611 VSS VDD sky130_fd_sc_hd__tapvpwrvgnd_1
XTAP_TAPCELL_ROW_120_2612 VSS VDD sky130_fd_sc_hd__tapvpwrvgnd_1
XTAP_TAPCELL_ROW_120_2613 VSS VDD sky130_fd_sc_hd__tapvpwrvgnd_1
XTAP_TAPCELL_ROW_120_2614 VSS VDD sky130_fd_sc_hd__tapvpwrvgnd_1
XTAP_TAPCELL_ROW_120_2615 VSS VDD sky130_fd_sc_hd__tapvpwrvgnd_1
XTAP_TAPCELL_ROW_120_2616 VSS VDD sky130_fd_sc_hd__tapvpwrvgnd_1
XTAP_TAPCELL_ROW_120_2617 VSS VDD sky130_fd_sc_hd__tapvpwrvgnd_1
XTAP_TAPCELL_ROW_120_2618 VSS VDD sky130_fd_sc_hd__tapvpwrvgnd_1
XTAP_TAPCELL_ROW_120_2619 VSS VDD sky130_fd_sc_hd__tapvpwrvgnd_1
XTAP_TAPCELL_ROW_120_2620 VSS VDD sky130_fd_sc_hd__tapvpwrvgnd_1
XTAP_TAPCELL_ROW_120_2621 VSS VDD sky130_fd_sc_hd__tapvpwrvgnd_1
XTAP_TAPCELL_ROW_120_2622 VSS VDD sky130_fd_sc_hd__tapvpwrvgnd_1
XTAP_TAPCELL_ROW_121_2623 VSS VDD sky130_fd_sc_hd__tapvpwrvgnd_1
XTAP_TAPCELL_ROW_121_2624 VSS VDD sky130_fd_sc_hd__tapvpwrvgnd_1
XTAP_TAPCELL_ROW_121_2625 VSS VDD sky130_fd_sc_hd__tapvpwrvgnd_1
XTAP_TAPCELL_ROW_121_2626 VSS VDD sky130_fd_sc_hd__tapvpwrvgnd_1
XTAP_TAPCELL_ROW_121_2627 VSS VDD sky130_fd_sc_hd__tapvpwrvgnd_1
XTAP_TAPCELL_ROW_121_2628 VSS VDD sky130_fd_sc_hd__tapvpwrvgnd_1
XTAP_TAPCELL_ROW_121_2629 VSS VDD sky130_fd_sc_hd__tapvpwrvgnd_1
XTAP_TAPCELL_ROW_121_2630 VSS VDD sky130_fd_sc_hd__tapvpwrvgnd_1
XTAP_TAPCELL_ROW_121_2631 VSS VDD sky130_fd_sc_hd__tapvpwrvgnd_1
XTAP_TAPCELL_ROW_121_2632 VSS VDD sky130_fd_sc_hd__tapvpwrvgnd_1
XTAP_TAPCELL_ROW_121_2633 VSS VDD sky130_fd_sc_hd__tapvpwrvgnd_1
XTAP_TAPCELL_ROW_121_2634 VSS VDD sky130_fd_sc_hd__tapvpwrvgnd_1
XTAP_TAPCELL_ROW_121_2635 VSS VDD sky130_fd_sc_hd__tapvpwrvgnd_1
XTAP_TAPCELL_ROW_121_2636 VSS VDD sky130_fd_sc_hd__tapvpwrvgnd_1
XTAP_TAPCELL_ROW_121_2637 VSS VDD sky130_fd_sc_hd__tapvpwrvgnd_1
XTAP_TAPCELL_ROW_121_2638 VSS VDD sky130_fd_sc_hd__tapvpwrvgnd_1
XTAP_TAPCELL_ROW_121_2639 VSS VDD sky130_fd_sc_hd__tapvpwrvgnd_1
XTAP_TAPCELL_ROW_121_2640 VSS VDD sky130_fd_sc_hd__tapvpwrvgnd_1
XTAP_TAPCELL_ROW_121_2641 VSS VDD sky130_fd_sc_hd__tapvpwrvgnd_1
XTAP_TAPCELL_ROW_121_2642 VSS VDD sky130_fd_sc_hd__tapvpwrvgnd_1
XTAP_TAPCELL_ROW_121_2643 VSS VDD sky130_fd_sc_hd__tapvpwrvgnd_1
XTAP_TAPCELL_ROW_122_2644 VSS VDD sky130_fd_sc_hd__tapvpwrvgnd_1
XTAP_TAPCELL_ROW_122_2645 VSS VDD sky130_fd_sc_hd__tapvpwrvgnd_1
XTAP_TAPCELL_ROW_122_2646 VSS VDD sky130_fd_sc_hd__tapvpwrvgnd_1
XTAP_TAPCELL_ROW_122_2647 VSS VDD sky130_fd_sc_hd__tapvpwrvgnd_1
XTAP_TAPCELL_ROW_122_2648 VSS VDD sky130_fd_sc_hd__tapvpwrvgnd_1
XTAP_TAPCELL_ROW_122_2649 VSS VDD sky130_fd_sc_hd__tapvpwrvgnd_1
XTAP_TAPCELL_ROW_122_2650 VSS VDD sky130_fd_sc_hd__tapvpwrvgnd_1
XTAP_TAPCELL_ROW_122_2651 VSS VDD sky130_fd_sc_hd__tapvpwrvgnd_1
XTAP_TAPCELL_ROW_122_2652 VSS VDD sky130_fd_sc_hd__tapvpwrvgnd_1
XTAP_TAPCELL_ROW_122_2653 VSS VDD sky130_fd_sc_hd__tapvpwrvgnd_1
XTAP_TAPCELL_ROW_122_2654 VSS VDD sky130_fd_sc_hd__tapvpwrvgnd_1
XTAP_TAPCELL_ROW_122_2655 VSS VDD sky130_fd_sc_hd__tapvpwrvgnd_1
XTAP_TAPCELL_ROW_122_2656 VSS VDD sky130_fd_sc_hd__tapvpwrvgnd_1
XTAP_TAPCELL_ROW_122_2657 VSS VDD sky130_fd_sc_hd__tapvpwrvgnd_1
XTAP_TAPCELL_ROW_122_2658 VSS VDD sky130_fd_sc_hd__tapvpwrvgnd_1
XTAP_TAPCELL_ROW_122_2659 VSS VDD sky130_fd_sc_hd__tapvpwrvgnd_1
XTAP_TAPCELL_ROW_122_2660 VSS VDD sky130_fd_sc_hd__tapvpwrvgnd_1
XTAP_TAPCELL_ROW_122_2661 VSS VDD sky130_fd_sc_hd__tapvpwrvgnd_1
XTAP_TAPCELL_ROW_122_2662 VSS VDD sky130_fd_sc_hd__tapvpwrvgnd_1
XTAP_TAPCELL_ROW_122_2663 VSS VDD sky130_fd_sc_hd__tapvpwrvgnd_1
XTAP_TAPCELL_ROW_122_2664 VSS VDD sky130_fd_sc_hd__tapvpwrvgnd_1
XTAP_TAPCELL_ROW_122_2665 VSS VDD sky130_fd_sc_hd__tapvpwrvgnd_1
XTAP_TAPCELL_ROW_123_2666 VSS VDD sky130_fd_sc_hd__tapvpwrvgnd_1
XTAP_TAPCELL_ROW_123_2667 VSS VDD sky130_fd_sc_hd__tapvpwrvgnd_1
XTAP_TAPCELL_ROW_123_2668 VSS VDD sky130_fd_sc_hd__tapvpwrvgnd_1
XTAP_TAPCELL_ROW_123_2669 VSS VDD sky130_fd_sc_hd__tapvpwrvgnd_1
XTAP_TAPCELL_ROW_123_2670 VSS VDD sky130_fd_sc_hd__tapvpwrvgnd_1
XTAP_TAPCELL_ROW_123_2671 VSS VDD sky130_fd_sc_hd__tapvpwrvgnd_1
XTAP_TAPCELL_ROW_123_2672 VSS VDD sky130_fd_sc_hd__tapvpwrvgnd_1
XTAP_TAPCELL_ROW_123_2673 VSS VDD sky130_fd_sc_hd__tapvpwrvgnd_1
XTAP_TAPCELL_ROW_123_2674 VSS VDD sky130_fd_sc_hd__tapvpwrvgnd_1
XTAP_TAPCELL_ROW_123_2675 VSS VDD sky130_fd_sc_hd__tapvpwrvgnd_1
XTAP_TAPCELL_ROW_123_2676 VSS VDD sky130_fd_sc_hd__tapvpwrvgnd_1
XTAP_TAPCELL_ROW_123_2677 VSS VDD sky130_fd_sc_hd__tapvpwrvgnd_1
XTAP_TAPCELL_ROW_123_2678 VSS VDD sky130_fd_sc_hd__tapvpwrvgnd_1
XTAP_TAPCELL_ROW_123_2679 VSS VDD sky130_fd_sc_hd__tapvpwrvgnd_1
XTAP_TAPCELL_ROW_123_2680 VSS VDD sky130_fd_sc_hd__tapvpwrvgnd_1
XTAP_TAPCELL_ROW_123_2681 VSS VDD sky130_fd_sc_hd__tapvpwrvgnd_1
XTAP_TAPCELL_ROW_123_2682 VSS VDD sky130_fd_sc_hd__tapvpwrvgnd_1
XTAP_TAPCELL_ROW_123_2683 VSS VDD sky130_fd_sc_hd__tapvpwrvgnd_1
XTAP_TAPCELL_ROW_123_2684 VSS VDD sky130_fd_sc_hd__tapvpwrvgnd_1
XTAP_TAPCELL_ROW_123_2685 VSS VDD sky130_fd_sc_hd__tapvpwrvgnd_1
XTAP_TAPCELL_ROW_123_2686 VSS VDD sky130_fd_sc_hd__tapvpwrvgnd_1
XTAP_TAPCELL_ROW_124_2687 VSS VDD sky130_fd_sc_hd__tapvpwrvgnd_1
XTAP_TAPCELL_ROW_124_2688 VSS VDD sky130_fd_sc_hd__tapvpwrvgnd_1
XTAP_TAPCELL_ROW_124_2689 VSS VDD sky130_fd_sc_hd__tapvpwrvgnd_1
XTAP_TAPCELL_ROW_124_2690 VSS VDD sky130_fd_sc_hd__tapvpwrvgnd_1
XTAP_TAPCELL_ROW_124_2691 VSS VDD sky130_fd_sc_hd__tapvpwrvgnd_1
XTAP_TAPCELL_ROW_124_2692 VSS VDD sky130_fd_sc_hd__tapvpwrvgnd_1
XTAP_TAPCELL_ROW_124_2693 VSS VDD sky130_fd_sc_hd__tapvpwrvgnd_1
XTAP_TAPCELL_ROW_124_2694 VSS VDD sky130_fd_sc_hd__tapvpwrvgnd_1
XTAP_TAPCELL_ROW_124_2695 VSS VDD sky130_fd_sc_hd__tapvpwrvgnd_1
XTAP_TAPCELL_ROW_124_2696 VSS VDD sky130_fd_sc_hd__tapvpwrvgnd_1
XTAP_TAPCELL_ROW_124_2697 VSS VDD sky130_fd_sc_hd__tapvpwrvgnd_1
XTAP_TAPCELL_ROW_124_2698 VSS VDD sky130_fd_sc_hd__tapvpwrvgnd_1
XTAP_TAPCELL_ROW_124_2699 VSS VDD sky130_fd_sc_hd__tapvpwrvgnd_1
XTAP_TAPCELL_ROW_124_2700 VSS VDD sky130_fd_sc_hd__tapvpwrvgnd_1
XTAP_TAPCELL_ROW_124_2701 VSS VDD sky130_fd_sc_hd__tapvpwrvgnd_1
XTAP_TAPCELL_ROW_124_2702 VSS VDD sky130_fd_sc_hd__tapvpwrvgnd_1
XTAP_TAPCELL_ROW_124_2703 VSS VDD sky130_fd_sc_hd__tapvpwrvgnd_1
XTAP_TAPCELL_ROW_124_2704 VSS VDD sky130_fd_sc_hd__tapvpwrvgnd_1
XTAP_TAPCELL_ROW_124_2705 VSS VDD sky130_fd_sc_hd__tapvpwrvgnd_1
XTAP_TAPCELL_ROW_124_2706 VSS VDD sky130_fd_sc_hd__tapvpwrvgnd_1
XTAP_TAPCELL_ROW_124_2707 VSS VDD sky130_fd_sc_hd__tapvpwrvgnd_1
XTAP_TAPCELL_ROW_124_2708 VSS VDD sky130_fd_sc_hd__tapvpwrvgnd_1
XTAP_TAPCELL_ROW_125_2709 VSS VDD sky130_fd_sc_hd__tapvpwrvgnd_1
XTAP_TAPCELL_ROW_125_2710 VSS VDD sky130_fd_sc_hd__tapvpwrvgnd_1
XTAP_TAPCELL_ROW_125_2711 VSS VDD sky130_fd_sc_hd__tapvpwrvgnd_1
XTAP_TAPCELL_ROW_125_2712 VSS VDD sky130_fd_sc_hd__tapvpwrvgnd_1
XTAP_TAPCELL_ROW_125_2713 VSS VDD sky130_fd_sc_hd__tapvpwrvgnd_1
XTAP_TAPCELL_ROW_125_2714 VSS VDD sky130_fd_sc_hd__tapvpwrvgnd_1
XTAP_TAPCELL_ROW_125_2715 VSS VDD sky130_fd_sc_hd__tapvpwrvgnd_1
XTAP_TAPCELL_ROW_125_2716 VSS VDD sky130_fd_sc_hd__tapvpwrvgnd_1
XTAP_TAPCELL_ROW_125_2717 VSS VDD sky130_fd_sc_hd__tapvpwrvgnd_1
XTAP_TAPCELL_ROW_125_2718 VSS VDD sky130_fd_sc_hd__tapvpwrvgnd_1
XTAP_TAPCELL_ROW_125_2719 VSS VDD sky130_fd_sc_hd__tapvpwrvgnd_1
XTAP_TAPCELL_ROW_125_2720 VSS VDD sky130_fd_sc_hd__tapvpwrvgnd_1
XTAP_TAPCELL_ROW_125_2721 VSS VDD sky130_fd_sc_hd__tapvpwrvgnd_1
XTAP_TAPCELL_ROW_125_2722 VSS VDD sky130_fd_sc_hd__tapvpwrvgnd_1
XTAP_TAPCELL_ROW_125_2723 VSS VDD sky130_fd_sc_hd__tapvpwrvgnd_1
XTAP_TAPCELL_ROW_125_2724 VSS VDD sky130_fd_sc_hd__tapvpwrvgnd_1
XTAP_TAPCELL_ROW_125_2725 VSS VDD sky130_fd_sc_hd__tapvpwrvgnd_1
XTAP_TAPCELL_ROW_125_2726 VSS VDD sky130_fd_sc_hd__tapvpwrvgnd_1
XTAP_TAPCELL_ROW_125_2727 VSS VDD sky130_fd_sc_hd__tapvpwrvgnd_1
XTAP_TAPCELL_ROW_125_2728 VSS VDD sky130_fd_sc_hd__tapvpwrvgnd_1
XTAP_TAPCELL_ROW_125_2729 VSS VDD sky130_fd_sc_hd__tapvpwrvgnd_1
XTAP_TAPCELL_ROW_126_2730 VSS VDD sky130_fd_sc_hd__tapvpwrvgnd_1
XTAP_TAPCELL_ROW_126_2731 VSS VDD sky130_fd_sc_hd__tapvpwrvgnd_1
XTAP_TAPCELL_ROW_126_2732 VSS VDD sky130_fd_sc_hd__tapvpwrvgnd_1
XTAP_TAPCELL_ROW_126_2733 VSS VDD sky130_fd_sc_hd__tapvpwrvgnd_1
XTAP_TAPCELL_ROW_126_2734 VSS VDD sky130_fd_sc_hd__tapvpwrvgnd_1
XTAP_TAPCELL_ROW_126_2735 VSS VDD sky130_fd_sc_hd__tapvpwrvgnd_1
XTAP_TAPCELL_ROW_126_2736 VSS VDD sky130_fd_sc_hd__tapvpwrvgnd_1
XTAP_TAPCELL_ROW_126_2737 VSS VDD sky130_fd_sc_hd__tapvpwrvgnd_1
XTAP_TAPCELL_ROW_126_2738 VSS VDD sky130_fd_sc_hd__tapvpwrvgnd_1
XTAP_TAPCELL_ROW_126_2739 VSS VDD sky130_fd_sc_hd__tapvpwrvgnd_1
XTAP_TAPCELL_ROW_126_2740 VSS VDD sky130_fd_sc_hd__tapvpwrvgnd_1
XTAP_TAPCELL_ROW_126_2741 VSS VDD sky130_fd_sc_hd__tapvpwrvgnd_1
XTAP_TAPCELL_ROW_126_2742 VSS VDD sky130_fd_sc_hd__tapvpwrvgnd_1
XTAP_TAPCELL_ROW_126_2743 VSS VDD sky130_fd_sc_hd__tapvpwrvgnd_1
XTAP_TAPCELL_ROW_126_2744 VSS VDD sky130_fd_sc_hd__tapvpwrvgnd_1
XTAP_TAPCELL_ROW_126_2745 VSS VDD sky130_fd_sc_hd__tapvpwrvgnd_1
XTAP_TAPCELL_ROW_126_2746 VSS VDD sky130_fd_sc_hd__tapvpwrvgnd_1
XTAP_TAPCELL_ROW_126_2747 VSS VDD sky130_fd_sc_hd__tapvpwrvgnd_1
XTAP_TAPCELL_ROW_126_2748 VSS VDD sky130_fd_sc_hd__tapvpwrvgnd_1
XTAP_TAPCELL_ROW_126_2749 VSS VDD sky130_fd_sc_hd__tapvpwrvgnd_1
XTAP_TAPCELL_ROW_126_2750 VSS VDD sky130_fd_sc_hd__tapvpwrvgnd_1
XTAP_TAPCELL_ROW_126_2751 VSS VDD sky130_fd_sc_hd__tapvpwrvgnd_1
XTAP_TAPCELL_ROW_127_2752 VSS VDD sky130_fd_sc_hd__tapvpwrvgnd_1
XTAP_TAPCELL_ROW_127_2753 VSS VDD sky130_fd_sc_hd__tapvpwrvgnd_1
XTAP_TAPCELL_ROW_127_2754 VSS VDD sky130_fd_sc_hd__tapvpwrvgnd_1
XTAP_TAPCELL_ROW_127_2755 VSS VDD sky130_fd_sc_hd__tapvpwrvgnd_1
XTAP_TAPCELL_ROW_127_2756 VSS VDD sky130_fd_sc_hd__tapvpwrvgnd_1
XTAP_TAPCELL_ROW_127_2757 VSS VDD sky130_fd_sc_hd__tapvpwrvgnd_1
XTAP_TAPCELL_ROW_127_2758 VSS VDD sky130_fd_sc_hd__tapvpwrvgnd_1
XTAP_TAPCELL_ROW_127_2759 VSS VDD sky130_fd_sc_hd__tapvpwrvgnd_1
XTAP_TAPCELL_ROW_127_2760 VSS VDD sky130_fd_sc_hd__tapvpwrvgnd_1
XTAP_TAPCELL_ROW_127_2761 VSS VDD sky130_fd_sc_hd__tapvpwrvgnd_1
XTAP_TAPCELL_ROW_127_2762 VSS VDD sky130_fd_sc_hd__tapvpwrvgnd_1
XTAP_TAPCELL_ROW_127_2763 VSS VDD sky130_fd_sc_hd__tapvpwrvgnd_1
XTAP_TAPCELL_ROW_127_2764 VSS VDD sky130_fd_sc_hd__tapvpwrvgnd_1
XTAP_TAPCELL_ROW_127_2765 VSS VDD sky130_fd_sc_hd__tapvpwrvgnd_1
XTAP_TAPCELL_ROW_127_2766 VSS VDD sky130_fd_sc_hd__tapvpwrvgnd_1
XTAP_TAPCELL_ROW_127_2767 VSS VDD sky130_fd_sc_hd__tapvpwrvgnd_1
XTAP_TAPCELL_ROW_127_2768 VSS VDD sky130_fd_sc_hd__tapvpwrvgnd_1
XTAP_TAPCELL_ROW_127_2769 VSS VDD sky130_fd_sc_hd__tapvpwrvgnd_1
XTAP_TAPCELL_ROW_127_2770 VSS VDD sky130_fd_sc_hd__tapvpwrvgnd_1
XTAP_TAPCELL_ROW_127_2771 VSS VDD sky130_fd_sc_hd__tapvpwrvgnd_1
XTAP_TAPCELL_ROW_127_2772 VSS VDD sky130_fd_sc_hd__tapvpwrvgnd_1
XTAP_TAPCELL_ROW_128_2773 VSS VDD sky130_fd_sc_hd__tapvpwrvgnd_1
XTAP_TAPCELL_ROW_128_2774 VSS VDD sky130_fd_sc_hd__tapvpwrvgnd_1
XTAP_TAPCELL_ROW_128_2775 VSS VDD sky130_fd_sc_hd__tapvpwrvgnd_1
XTAP_TAPCELL_ROW_128_2776 VSS VDD sky130_fd_sc_hd__tapvpwrvgnd_1
XTAP_TAPCELL_ROW_128_2777 VSS VDD sky130_fd_sc_hd__tapvpwrvgnd_1
XTAP_TAPCELL_ROW_128_2778 VSS VDD sky130_fd_sc_hd__tapvpwrvgnd_1
XTAP_TAPCELL_ROW_128_2779 VSS VDD sky130_fd_sc_hd__tapvpwrvgnd_1
XTAP_TAPCELL_ROW_128_2780 VSS VDD sky130_fd_sc_hd__tapvpwrvgnd_1
XTAP_TAPCELL_ROW_128_2781 VSS VDD sky130_fd_sc_hd__tapvpwrvgnd_1
XTAP_TAPCELL_ROW_128_2782 VSS VDD sky130_fd_sc_hd__tapvpwrvgnd_1
XTAP_TAPCELL_ROW_128_2783 VSS VDD sky130_fd_sc_hd__tapvpwrvgnd_1
XTAP_TAPCELL_ROW_128_2784 VSS VDD sky130_fd_sc_hd__tapvpwrvgnd_1
XTAP_TAPCELL_ROW_128_2785 VSS VDD sky130_fd_sc_hd__tapvpwrvgnd_1
XTAP_TAPCELL_ROW_128_2786 VSS VDD sky130_fd_sc_hd__tapvpwrvgnd_1
XTAP_TAPCELL_ROW_128_2787 VSS VDD sky130_fd_sc_hd__tapvpwrvgnd_1
XTAP_TAPCELL_ROW_128_2788 VSS VDD sky130_fd_sc_hd__tapvpwrvgnd_1
XTAP_TAPCELL_ROW_128_2789 VSS VDD sky130_fd_sc_hd__tapvpwrvgnd_1
XTAP_TAPCELL_ROW_128_2790 VSS VDD sky130_fd_sc_hd__tapvpwrvgnd_1
XTAP_TAPCELL_ROW_128_2791 VSS VDD sky130_fd_sc_hd__tapvpwrvgnd_1
XTAP_TAPCELL_ROW_128_2792 VSS VDD sky130_fd_sc_hd__tapvpwrvgnd_1
XTAP_TAPCELL_ROW_128_2793 VSS VDD sky130_fd_sc_hd__tapvpwrvgnd_1
XTAP_TAPCELL_ROW_128_2794 VSS VDD sky130_fd_sc_hd__tapvpwrvgnd_1
XTAP_TAPCELL_ROW_129_2795 VSS VDD sky130_fd_sc_hd__tapvpwrvgnd_1
XTAP_TAPCELL_ROW_129_2796 VSS VDD sky130_fd_sc_hd__tapvpwrvgnd_1
XTAP_TAPCELL_ROW_129_2797 VSS VDD sky130_fd_sc_hd__tapvpwrvgnd_1
XTAP_TAPCELL_ROW_129_2798 VSS VDD sky130_fd_sc_hd__tapvpwrvgnd_1
XTAP_TAPCELL_ROW_129_2799 VSS VDD sky130_fd_sc_hd__tapvpwrvgnd_1
XTAP_TAPCELL_ROW_129_2800 VSS VDD sky130_fd_sc_hd__tapvpwrvgnd_1
XTAP_TAPCELL_ROW_129_2801 VSS VDD sky130_fd_sc_hd__tapvpwrvgnd_1
XTAP_TAPCELL_ROW_129_2802 VSS VDD sky130_fd_sc_hd__tapvpwrvgnd_1
XTAP_TAPCELL_ROW_129_2803 VSS VDD sky130_fd_sc_hd__tapvpwrvgnd_1
XTAP_TAPCELL_ROW_129_2804 VSS VDD sky130_fd_sc_hd__tapvpwrvgnd_1
XTAP_TAPCELL_ROW_129_2805 VSS VDD sky130_fd_sc_hd__tapvpwrvgnd_1
XTAP_TAPCELL_ROW_129_2806 VSS VDD sky130_fd_sc_hd__tapvpwrvgnd_1
XTAP_TAPCELL_ROW_129_2807 VSS VDD sky130_fd_sc_hd__tapvpwrvgnd_1
XTAP_TAPCELL_ROW_129_2808 VSS VDD sky130_fd_sc_hd__tapvpwrvgnd_1
XTAP_TAPCELL_ROW_129_2809 VSS VDD sky130_fd_sc_hd__tapvpwrvgnd_1
XTAP_TAPCELL_ROW_129_2810 VSS VDD sky130_fd_sc_hd__tapvpwrvgnd_1
XTAP_TAPCELL_ROW_129_2811 VSS VDD sky130_fd_sc_hd__tapvpwrvgnd_1
XTAP_TAPCELL_ROW_129_2812 VSS VDD sky130_fd_sc_hd__tapvpwrvgnd_1
XTAP_TAPCELL_ROW_129_2813 VSS VDD sky130_fd_sc_hd__tapvpwrvgnd_1
XTAP_TAPCELL_ROW_129_2814 VSS VDD sky130_fd_sc_hd__tapvpwrvgnd_1
XTAP_TAPCELL_ROW_129_2815 VSS VDD sky130_fd_sc_hd__tapvpwrvgnd_1
XTAP_TAPCELL_ROW_130_2816 VSS VDD sky130_fd_sc_hd__tapvpwrvgnd_1
XTAP_TAPCELL_ROW_130_2817 VSS VDD sky130_fd_sc_hd__tapvpwrvgnd_1
XTAP_TAPCELL_ROW_130_2818 VSS VDD sky130_fd_sc_hd__tapvpwrvgnd_1
XTAP_TAPCELL_ROW_130_2819 VSS VDD sky130_fd_sc_hd__tapvpwrvgnd_1
XTAP_TAPCELL_ROW_130_2820 VSS VDD sky130_fd_sc_hd__tapvpwrvgnd_1
XTAP_TAPCELL_ROW_130_2821 VSS VDD sky130_fd_sc_hd__tapvpwrvgnd_1
XTAP_TAPCELL_ROW_130_2822 VSS VDD sky130_fd_sc_hd__tapvpwrvgnd_1
XTAP_TAPCELL_ROW_130_2823 VSS VDD sky130_fd_sc_hd__tapvpwrvgnd_1
XTAP_TAPCELL_ROW_130_2824 VSS VDD sky130_fd_sc_hd__tapvpwrvgnd_1
XTAP_TAPCELL_ROW_130_2825 VSS VDD sky130_fd_sc_hd__tapvpwrvgnd_1
XTAP_TAPCELL_ROW_130_2826 VSS VDD sky130_fd_sc_hd__tapvpwrvgnd_1
XTAP_TAPCELL_ROW_130_2827 VSS VDD sky130_fd_sc_hd__tapvpwrvgnd_1
XTAP_TAPCELL_ROW_130_2828 VSS VDD sky130_fd_sc_hd__tapvpwrvgnd_1
XTAP_TAPCELL_ROW_130_2829 VSS VDD sky130_fd_sc_hd__tapvpwrvgnd_1
XTAP_TAPCELL_ROW_130_2830 VSS VDD sky130_fd_sc_hd__tapvpwrvgnd_1
XTAP_TAPCELL_ROW_130_2831 VSS VDD sky130_fd_sc_hd__tapvpwrvgnd_1
XTAP_TAPCELL_ROW_130_2832 VSS VDD sky130_fd_sc_hd__tapvpwrvgnd_1
XTAP_TAPCELL_ROW_130_2833 VSS VDD sky130_fd_sc_hd__tapvpwrvgnd_1
XTAP_TAPCELL_ROW_130_2834 VSS VDD sky130_fd_sc_hd__tapvpwrvgnd_1
XTAP_TAPCELL_ROW_130_2835 VSS VDD sky130_fd_sc_hd__tapvpwrvgnd_1
XTAP_TAPCELL_ROW_130_2836 VSS VDD sky130_fd_sc_hd__tapvpwrvgnd_1
XTAP_TAPCELL_ROW_130_2837 VSS VDD sky130_fd_sc_hd__tapvpwrvgnd_1
XTAP_TAPCELL_ROW_131_2838 VSS VDD sky130_fd_sc_hd__tapvpwrvgnd_1
XTAP_TAPCELL_ROW_131_2839 VSS VDD sky130_fd_sc_hd__tapvpwrvgnd_1
XTAP_TAPCELL_ROW_131_2840 VSS VDD sky130_fd_sc_hd__tapvpwrvgnd_1
XTAP_TAPCELL_ROW_131_2841 VSS VDD sky130_fd_sc_hd__tapvpwrvgnd_1
XTAP_TAPCELL_ROW_131_2842 VSS VDD sky130_fd_sc_hd__tapvpwrvgnd_1
XTAP_TAPCELL_ROW_131_2843 VSS VDD sky130_fd_sc_hd__tapvpwrvgnd_1
XTAP_TAPCELL_ROW_131_2844 VSS VDD sky130_fd_sc_hd__tapvpwrvgnd_1
XTAP_TAPCELL_ROW_131_2845 VSS VDD sky130_fd_sc_hd__tapvpwrvgnd_1
XTAP_TAPCELL_ROW_131_2846 VSS VDD sky130_fd_sc_hd__tapvpwrvgnd_1
XTAP_TAPCELL_ROW_131_2847 VSS VDD sky130_fd_sc_hd__tapvpwrvgnd_1
XTAP_TAPCELL_ROW_131_2848 VSS VDD sky130_fd_sc_hd__tapvpwrvgnd_1
XTAP_TAPCELL_ROW_131_2849 VSS VDD sky130_fd_sc_hd__tapvpwrvgnd_1
XTAP_TAPCELL_ROW_131_2850 VSS VDD sky130_fd_sc_hd__tapvpwrvgnd_1
XTAP_TAPCELL_ROW_131_2851 VSS VDD sky130_fd_sc_hd__tapvpwrvgnd_1
XTAP_TAPCELL_ROW_131_2852 VSS VDD sky130_fd_sc_hd__tapvpwrvgnd_1
XTAP_TAPCELL_ROW_131_2853 VSS VDD sky130_fd_sc_hd__tapvpwrvgnd_1
XTAP_TAPCELL_ROW_131_2854 VSS VDD sky130_fd_sc_hd__tapvpwrvgnd_1
XTAP_TAPCELL_ROW_131_2855 VSS VDD sky130_fd_sc_hd__tapvpwrvgnd_1
XTAP_TAPCELL_ROW_131_2856 VSS VDD sky130_fd_sc_hd__tapvpwrvgnd_1
XTAP_TAPCELL_ROW_131_2857 VSS VDD sky130_fd_sc_hd__tapvpwrvgnd_1
XTAP_TAPCELL_ROW_131_2858 VSS VDD sky130_fd_sc_hd__tapvpwrvgnd_1
XTAP_TAPCELL_ROW_132_2859 VSS VDD sky130_fd_sc_hd__tapvpwrvgnd_1
XTAP_TAPCELL_ROW_132_2860 VSS VDD sky130_fd_sc_hd__tapvpwrvgnd_1
XTAP_TAPCELL_ROW_132_2861 VSS VDD sky130_fd_sc_hd__tapvpwrvgnd_1
XTAP_TAPCELL_ROW_132_2862 VSS VDD sky130_fd_sc_hd__tapvpwrvgnd_1
XTAP_TAPCELL_ROW_132_2863 VSS VDD sky130_fd_sc_hd__tapvpwrvgnd_1
XTAP_TAPCELL_ROW_132_2864 VSS VDD sky130_fd_sc_hd__tapvpwrvgnd_1
XTAP_TAPCELL_ROW_132_2865 VSS VDD sky130_fd_sc_hd__tapvpwrvgnd_1
XTAP_TAPCELL_ROW_132_2866 VSS VDD sky130_fd_sc_hd__tapvpwrvgnd_1
XTAP_TAPCELL_ROW_132_2867 VSS VDD sky130_fd_sc_hd__tapvpwrvgnd_1
XTAP_TAPCELL_ROW_132_2868 VSS VDD sky130_fd_sc_hd__tapvpwrvgnd_1
XTAP_TAPCELL_ROW_132_2869 VSS VDD sky130_fd_sc_hd__tapvpwrvgnd_1
XTAP_TAPCELL_ROW_132_2870 VSS VDD sky130_fd_sc_hd__tapvpwrvgnd_1
XTAP_TAPCELL_ROW_132_2871 VSS VDD sky130_fd_sc_hd__tapvpwrvgnd_1
XTAP_TAPCELL_ROW_132_2872 VSS VDD sky130_fd_sc_hd__tapvpwrvgnd_1
XTAP_TAPCELL_ROW_132_2873 VSS VDD sky130_fd_sc_hd__tapvpwrvgnd_1
XTAP_TAPCELL_ROW_132_2874 VSS VDD sky130_fd_sc_hd__tapvpwrvgnd_1
XTAP_TAPCELL_ROW_132_2875 VSS VDD sky130_fd_sc_hd__tapvpwrvgnd_1
XTAP_TAPCELL_ROW_132_2876 VSS VDD sky130_fd_sc_hd__tapvpwrvgnd_1
XTAP_TAPCELL_ROW_132_2877 VSS VDD sky130_fd_sc_hd__tapvpwrvgnd_1
XTAP_TAPCELL_ROW_132_2878 VSS VDD sky130_fd_sc_hd__tapvpwrvgnd_1
XTAP_TAPCELL_ROW_132_2879 VSS VDD sky130_fd_sc_hd__tapvpwrvgnd_1
XTAP_TAPCELL_ROW_132_2880 VSS VDD sky130_fd_sc_hd__tapvpwrvgnd_1
XTAP_TAPCELL_ROW_133_2881 VSS VDD sky130_fd_sc_hd__tapvpwrvgnd_1
XTAP_TAPCELL_ROW_133_2882 VSS VDD sky130_fd_sc_hd__tapvpwrvgnd_1
XTAP_TAPCELL_ROW_133_2883 VSS VDD sky130_fd_sc_hd__tapvpwrvgnd_1
XTAP_TAPCELL_ROW_133_2884 VSS VDD sky130_fd_sc_hd__tapvpwrvgnd_1
XTAP_TAPCELL_ROW_133_2885 VSS VDD sky130_fd_sc_hd__tapvpwrvgnd_1
XTAP_TAPCELL_ROW_133_2886 VSS VDD sky130_fd_sc_hd__tapvpwrvgnd_1
XTAP_TAPCELL_ROW_133_2887 VSS VDD sky130_fd_sc_hd__tapvpwrvgnd_1
XTAP_TAPCELL_ROW_133_2888 VSS VDD sky130_fd_sc_hd__tapvpwrvgnd_1
XTAP_TAPCELL_ROW_133_2889 VSS VDD sky130_fd_sc_hd__tapvpwrvgnd_1
XTAP_TAPCELL_ROW_133_2890 VSS VDD sky130_fd_sc_hd__tapvpwrvgnd_1
XTAP_TAPCELL_ROW_133_2891 VSS VDD sky130_fd_sc_hd__tapvpwrvgnd_1
XTAP_TAPCELL_ROW_133_2892 VSS VDD sky130_fd_sc_hd__tapvpwrvgnd_1
XTAP_TAPCELL_ROW_133_2893 VSS VDD sky130_fd_sc_hd__tapvpwrvgnd_1
XTAP_TAPCELL_ROW_133_2894 VSS VDD sky130_fd_sc_hd__tapvpwrvgnd_1
XTAP_TAPCELL_ROW_133_2895 VSS VDD sky130_fd_sc_hd__tapvpwrvgnd_1
XTAP_TAPCELL_ROW_133_2896 VSS VDD sky130_fd_sc_hd__tapvpwrvgnd_1
XTAP_TAPCELL_ROW_133_2897 VSS VDD sky130_fd_sc_hd__tapvpwrvgnd_1
XTAP_TAPCELL_ROW_133_2898 VSS VDD sky130_fd_sc_hd__tapvpwrvgnd_1
XTAP_TAPCELL_ROW_133_2899 VSS VDD sky130_fd_sc_hd__tapvpwrvgnd_1
XTAP_TAPCELL_ROW_133_2900 VSS VDD sky130_fd_sc_hd__tapvpwrvgnd_1
XTAP_TAPCELL_ROW_133_2901 VSS VDD sky130_fd_sc_hd__tapvpwrvgnd_1
XTAP_TAPCELL_ROW_134_2902 VSS VDD sky130_fd_sc_hd__tapvpwrvgnd_1
XTAP_TAPCELL_ROW_134_2903 VSS VDD sky130_fd_sc_hd__tapvpwrvgnd_1
XTAP_TAPCELL_ROW_134_2904 VSS VDD sky130_fd_sc_hd__tapvpwrvgnd_1
XTAP_TAPCELL_ROW_134_2905 VSS VDD sky130_fd_sc_hd__tapvpwrvgnd_1
XTAP_TAPCELL_ROW_134_2906 VSS VDD sky130_fd_sc_hd__tapvpwrvgnd_1
XTAP_TAPCELL_ROW_134_2907 VSS VDD sky130_fd_sc_hd__tapvpwrvgnd_1
XTAP_TAPCELL_ROW_134_2908 VSS VDD sky130_fd_sc_hd__tapvpwrvgnd_1
XTAP_TAPCELL_ROW_134_2909 VSS VDD sky130_fd_sc_hd__tapvpwrvgnd_1
XTAP_TAPCELL_ROW_134_2910 VSS VDD sky130_fd_sc_hd__tapvpwrvgnd_1
XTAP_TAPCELL_ROW_134_2911 VSS VDD sky130_fd_sc_hd__tapvpwrvgnd_1
XTAP_TAPCELL_ROW_134_2912 VSS VDD sky130_fd_sc_hd__tapvpwrvgnd_1
XTAP_TAPCELL_ROW_134_2913 VSS VDD sky130_fd_sc_hd__tapvpwrvgnd_1
XTAP_TAPCELL_ROW_134_2914 VSS VDD sky130_fd_sc_hd__tapvpwrvgnd_1
XTAP_TAPCELL_ROW_134_2915 VSS VDD sky130_fd_sc_hd__tapvpwrvgnd_1
XTAP_TAPCELL_ROW_134_2916 VSS VDD sky130_fd_sc_hd__tapvpwrvgnd_1
XTAP_TAPCELL_ROW_134_2917 VSS VDD sky130_fd_sc_hd__tapvpwrvgnd_1
XTAP_TAPCELL_ROW_134_2918 VSS VDD sky130_fd_sc_hd__tapvpwrvgnd_1
XTAP_TAPCELL_ROW_134_2919 VSS VDD sky130_fd_sc_hd__tapvpwrvgnd_1
XTAP_TAPCELL_ROW_134_2920 VSS VDD sky130_fd_sc_hd__tapvpwrvgnd_1
XTAP_TAPCELL_ROW_134_2921 VSS VDD sky130_fd_sc_hd__tapvpwrvgnd_1
XTAP_TAPCELL_ROW_134_2922 VSS VDD sky130_fd_sc_hd__tapvpwrvgnd_1
XTAP_TAPCELL_ROW_134_2923 VSS VDD sky130_fd_sc_hd__tapvpwrvgnd_1
XTAP_TAPCELL_ROW_135_2924 VSS VDD sky130_fd_sc_hd__tapvpwrvgnd_1
XTAP_TAPCELL_ROW_135_2925 VSS VDD sky130_fd_sc_hd__tapvpwrvgnd_1
XTAP_TAPCELL_ROW_135_2926 VSS VDD sky130_fd_sc_hd__tapvpwrvgnd_1
XTAP_TAPCELL_ROW_135_2927 VSS VDD sky130_fd_sc_hd__tapvpwrvgnd_1
XTAP_TAPCELL_ROW_135_2928 VSS VDD sky130_fd_sc_hd__tapvpwrvgnd_1
XTAP_TAPCELL_ROW_135_2929 VSS VDD sky130_fd_sc_hd__tapvpwrvgnd_1
XTAP_TAPCELL_ROW_135_2930 VSS VDD sky130_fd_sc_hd__tapvpwrvgnd_1
XTAP_TAPCELL_ROW_135_2931 VSS VDD sky130_fd_sc_hd__tapvpwrvgnd_1
XTAP_TAPCELL_ROW_135_2932 VSS VDD sky130_fd_sc_hd__tapvpwrvgnd_1
XTAP_TAPCELL_ROW_135_2933 VSS VDD sky130_fd_sc_hd__tapvpwrvgnd_1
XTAP_TAPCELL_ROW_135_2934 VSS VDD sky130_fd_sc_hd__tapvpwrvgnd_1
XTAP_TAPCELL_ROW_135_2935 VSS VDD sky130_fd_sc_hd__tapvpwrvgnd_1
XTAP_TAPCELL_ROW_135_2936 VSS VDD sky130_fd_sc_hd__tapvpwrvgnd_1
XTAP_TAPCELL_ROW_135_2937 VSS VDD sky130_fd_sc_hd__tapvpwrvgnd_1
XTAP_TAPCELL_ROW_135_2938 VSS VDD sky130_fd_sc_hd__tapvpwrvgnd_1
XTAP_TAPCELL_ROW_135_2939 VSS VDD sky130_fd_sc_hd__tapvpwrvgnd_1
XTAP_TAPCELL_ROW_135_2940 VSS VDD sky130_fd_sc_hd__tapvpwrvgnd_1
XTAP_TAPCELL_ROW_135_2941 VSS VDD sky130_fd_sc_hd__tapvpwrvgnd_1
XTAP_TAPCELL_ROW_135_2942 VSS VDD sky130_fd_sc_hd__tapvpwrvgnd_1
XTAP_TAPCELL_ROW_135_2943 VSS VDD sky130_fd_sc_hd__tapvpwrvgnd_1
XTAP_TAPCELL_ROW_135_2944 VSS VDD sky130_fd_sc_hd__tapvpwrvgnd_1
XTAP_TAPCELL_ROW_136_2945 VSS VDD sky130_fd_sc_hd__tapvpwrvgnd_1
XTAP_TAPCELL_ROW_136_2946 VSS VDD sky130_fd_sc_hd__tapvpwrvgnd_1
XTAP_TAPCELL_ROW_136_2947 VSS VDD sky130_fd_sc_hd__tapvpwrvgnd_1
XTAP_TAPCELL_ROW_136_2948 VSS VDD sky130_fd_sc_hd__tapvpwrvgnd_1
XTAP_TAPCELL_ROW_136_2949 VSS VDD sky130_fd_sc_hd__tapvpwrvgnd_1
XTAP_TAPCELL_ROW_136_2950 VSS VDD sky130_fd_sc_hd__tapvpwrvgnd_1
XTAP_TAPCELL_ROW_136_2951 VSS VDD sky130_fd_sc_hd__tapvpwrvgnd_1
XTAP_TAPCELL_ROW_136_2952 VSS VDD sky130_fd_sc_hd__tapvpwrvgnd_1
XTAP_TAPCELL_ROW_136_2953 VSS VDD sky130_fd_sc_hd__tapvpwrvgnd_1
XTAP_TAPCELL_ROW_136_2954 VSS VDD sky130_fd_sc_hd__tapvpwrvgnd_1
XTAP_TAPCELL_ROW_136_2955 VSS VDD sky130_fd_sc_hd__tapvpwrvgnd_1
XTAP_TAPCELL_ROW_136_2956 VSS VDD sky130_fd_sc_hd__tapvpwrvgnd_1
XTAP_TAPCELL_ROW_136_2957 VSS VDD sky130_fd_sc_hd__tapvpwrvgnd_1
XTAP_TAPCELL_ROW_136_2958 VSS VDD sky130_fd_sc_hd__tapvpwrvgnd_1
XTAP_TAPCELL_ROW_136_2959 VSS VDD sky130_fd_sc_hd__tapvpwrvgnd_1
XTAP_TAPCELL_ROW_136_2960 VSS VDD sky130_fd_sc_hd__tapvpwrvgnd_1
XTAP_TAPCELL_ROW_136_2961 VSS VDD sky130_fd_sc_hd__tapvpwrvgnd_1
XTAP_TAPCELL_ROW_136_2962 VSS VDD sky130_fd_sc_hd__tapvpwrvgnd_1
XTAP_TAPCELL_ROW_136_2963 VSS VDD sky130_fd_sc_hd__tapvpwrvgnd_1
XTAP_TAPCELL_ROW_136_2964 VSS VDD sky130_fd_sc_hd__tapvpwrvgnd_1
XTAP_TAPCELL_ROW_136_2965 VSS VDD sky130_fd_sc_hd__tapvpwrvgnd_1
XTAP_TAPCELL_ROW_136_2966 VSS VDD sky130_fd_sc_hd__tapvpwrvgnd_1
XTAP_TAPCELL_ROW_137_2967 VSS VDD sky130_fd_sc_hd__tapvpwrvgnd_1
XTAP_TAPCELL_ROW_137_2968 VSS VDD sky130_fd_sc_hd__tapvpwrvgnd_1
XTAP_TAPCELL_ROW_137_2969 VSS VDD sky130_fd_sc_hd__tapvpwrvgnd_1
XTAP_TAPCELL_ROW_137_2970 VSS VDD sky130_fd_sc_hd__tapvpwrvgnd_1
XTAP_TAPCELL_ROW_137_2971 VSS VDD sky130_fd_sc_hd__tapvpwrvgnd_1
XTAP_TAPCELL_ROW_137_2972 VSS VDD sky130_fd_sc_hd__tapvpwrvgnd_1
XTAP_TAPCELL_ROW_137_2973 VSS VDD sky130_fd_sc_hd__tapvpwrvgnd_1
XTAP_TAPCELL_ROW_137_2974 VSS VDD sky130_fd_sc_hd__tapvpwrvgnd_1
XTAP_TAPCELL_ROW_137_2975 VSS VDD sky130_fd_sc_hd__tapvpwrvgnd_1
XTAP_TAPCELL_ROW_137_2976 VSS VDD sky130_fd_sc_hd__tapvpwrvgnd_1
XTAP_TAPCELL_ROW_137_2977 VSS VDD sky130_fd_sc_hd__tapvpwrvgnd_1
XTAP_TAPCELL_ROW_137_2978 VSS VDD sky130_fd_sc_hd__tapvpwrvgnd_1
XTAP_TAPCELL_ROW_137_2979 VSS VDD sky130_fd_sc_hd__tapvpwrvgnd_1
XTAP_TAPCELL_ROW_137_2980 VSS VDD sky130_fd_sc_hd__tapvpwrvgnd_1
XTAP_TAPCELL_ROW_137_2981 VSS VDD sky130_fd_sc_hd__tapvpwrvgnd_1
XTAP_TAPCELL_ROW_137_2982 VSS VDD sky130_fd_sc_hd__tapvpwrvgnd_1
XTAP_TAPCELL_ROW_137_2983 VSS VDD sky130_fd_sc_hd__tapvpwrvgnd_1
XTAP_TAPCELL_ROW_137_2984 VSS VDD sky130_fd_sc_hd__tapvpwrvgnd_1
XTAP_TAPCELL_ROW_137_2985 VSS VDD sky130_fd_sc_hd__tapvpwrvgnd_1
XTAP_TAPCELL_ROW_137_2986 VSS VDD sky130_fd_sc_hd__tapvpwrvgnd_1
XTAP_TAPCELL_ROW_137_2987 VSS VDD sky130_fd_sc_hd__tapvpwrvgnd_1
XTAP_TAPCELL_ROW_138_2988 VSS VDD sky130_fd_sc_hd__tapvpwrvgnd_1
XTAP_TAPCELL_ROW_138_2989 VSS VDD sky130_fd_sc_hd__tapvpwrvgnd_1
XTAP_TAPCELL_ROW_138_2990 VSS VDD sky130_fd_sc_hd__tapvpwrvgnd_1
XTAP_TAPCELL_ROW_138_2991 VSS VDD sky130_fd_sc_hd__tapvpwrvgnd_1
XTAP_TAPCELL_ROW_138_2992 VSS VDD sky130_fd_sc_hd__tapvpwrvgnd_1
XTAP_TAPCELL_ROW_138_2993 VSS VDD sky130_fd_sc_hd__tapvpwrvgnd_1
XTAP_TAPCELL_ROW_138_2994 VSS VDD sky130_fd_sc_hd__tapvpwrvgnd_1
XTAP_TAPCELL_ROW_138_2995 VSS VDD sky130_fd_sc_hd__tapvpwrvgnd_1
XTAP_TAPCELL_ROW_138_2996 VSS VDD sky130_fd_sc_hd__tapvpwrvgnd_1
XTAP_TAPCELL_ROW_138_2997 VSS VDD sky130_fd_sc_hd__tapvpwrvgnd_1
XTAP_TAPCELL_ROW_138_2998 VSS VDD sky130_fd_sc_hd__tapvpwrvgnd_1
XTAP_TAPCELL_ROW_138_2999 VSS VDD sky130_fd_sc_hd__tapvpwrvgnd_1
XTAP_TAPCELL_ROW_138_3000 VSS VDD sky130_fd_sc_hd__tapvpwrvgnd_1
XTAP_TAPCELL_ROW_138_3001 VSS VDD sky130_fd_sc_hd__tapvpwrvgnd_1
XTAP_TAPCELL_ROW_138_3002 VSS VDD sky130_fd_sc_hd__tapvpwrvgnd_1
XTAP_TAPCELL_ROW_138_3003 VSS VDD sky130_fd_sc_hd__tapvpwrvgnd_1
XTAP_TAPCELL_ROW_138_3004 VSS VDD sky130_fd_sc_hd__tapvpwrvgnd_1
XTAP_TAPCELL_ROW_138_3005 VSS VDD sky130_fd_sc_hd__tapvpwrvgnd_1
XTAP_TAPCELL_ROW_138_3006 VSS VDD sky130_fd_sc_hd__tapvpwrvgnd_1
XTAP_TAPCELL_ROW_138_3007 VSS VDD sky130_fd_sc_hd__tapvpwrvgnd_1
XTAP_TAPCELL_ROW_138_3008 VSS VDD sky130_fd_sc_hd__tapvpwrvgnd_1
XTAP_TAPCELL_ROW_138_3009 VSS VDD sky130_fd_sc_hd__tapvpwrvgnd_1
XTAP_TAPCELL_ROW_139_3010 VSS VDD sky130_fd_sc_hd__tapvpwrvgnd_1
XTAP_TAPCELL_ROW_139_3011 VSS VDD sky130_fd_sc_hd__tapvpwrvgnd_1
XTAP_TAPCELL_ROW_139_3012 VSS VDD sky130_fd_sc_hd__tapvpwrvgnd_1
XTAP_TAPCELL_ROW_139_3013 VSS VDD sky130_fd_sc_hd__tapvpwrvgnd_1
XTAP_TAPCELL_ROW_139_3014 VSS VDD sky130_fd_sc_hd__tapvpwrvgnd_1
XTAP_TAPCELL_ROW_139_3015 VSS VDD sky130_fd_sc_hd__tapvpwrvgnd_1
XTAP_TAPCELL_ROW_139_3016 VSS VDD sky130_fd_sc_hd__tapvpwrvgnd_1
XTAP_TAPCELL_ROW_139_3017 VSS VDD sky130_fd_sc_hd__tapvpwrvgnd_1
XTAP_TAPCELL_ROW_139_3018 VSS VDD sky130_fd_sc_hd__tapvpwrvgnd_1
XTAP_TAPCELL_ROW_139_3019 VSS VDD sky130_fd_sc_hd__tapvpwrvgnd_1
XTAP_TAPCELL_ROW_139_3020 VSS VDD sky130_fd_sc_hd__tapvpwrvgnd_1
XTAP_TAPCELL_ROW_139_3021 VSS VDD sky130_fd_sc_hd__tapvpwrvgnd_1
XTAP_TAPCELL_ROW_139_3022 VSS VDD sky130_fd_sc_hd__tapvpwrvgnd_1
XTAP_TAPCELL_ROW_139_3023 VSS VDD sky130_fd_sc_hd__tapvpwrvgnd_1
XTAP_TAPCELL_ROW_139_3024 VSS VDD sky130_fd_sc_hd__tapvpwrvgnd_1
XTAP_TAPCELL_ROW_139_3025 VSS VDD sky130_fd_sc_hd__tapvpwrvgnd_1
XTAP_TAPCELL_ROW_139_3026 VSS VDD sky130_fd_sc_hd__tapvpwrvgnd_1
XTAP_TAPCELL_ROW_139_3027 VSS VDD sky130_fd_sc_hd__tapvpwrvgnd_1
XTAP_TAPCELL_ROW_139_3028 VSS VDD sky130_fd_sc_hd__tapvpwrvgnd_1
XTAP_TAPCELL_ROW_139_3029 VSS VDD sky130_fd_sc_hd__tapvpwrvgnd_1
XTAP_TAPCELL_ROW_139_3030 VSS VDD sky130_fd_sc_hd__tapvpwrvgnd_1
XTAP_TAPCELL_ROW_140_3031 VSS VDD sky130_fd_sc_hd__tapvpwrvgnd_1
XTAP_TAPCELL_ROW_140_3032 VSS VDD sky130_fd_sc_hd__tapvpwrvgnd_1
XTAP_TAPCELL_ROW_140_3033 VSS VDD sky130_fd_sc_hd__tapvpwrvgnd_1
XTAP_TAPCELL_ROW_140_3034 VSS VDD sky130_fd_sc_hd__tapvpwrvgnd_1
XTAP_TAPCELL_ROW_140_3035 VSS VDD sky130_fd_sc_hd__tapvpwrvgnd_1
XTAP_TAPCELL_ROW_140_3036 VSS VDD sky130_fd_sc_hd__tapvpwrvgnd_1
XTAP_TAPCELL_ROW_140_3037 VSS VDD sky130_fd_sc_hd__tapvpwrvgnd_1
XTAP_TAPCELL_ROW_140_3038 VSS VDD sky130_fd_sc_hd__tapvpwrvgnd_1
XTAP_TAPCELL_ROW_140_3039 VSS VDD sky130_fd_sc_hd__tapvpwrvgnd_1
XTAP_TAPCELL_ROW_140_3040 VSS VDD sky130_fd_sc_hd__tapvpwrvgnd_1
XTAP_TAPCELL_ROW_140_3041 VSS VDD sky130_fd_sc_hd__tapvpwrvgnd_1
XTAP_TAPCELL_ROW_140_3042 VSS VDD sky130_fd_sc_hd__tapvpwrvgnd_1
XTAP_TAPCELL_ROW_140_3043 VSS VDD sky130_fd_sc_hd__tapvpwrvgnd_1
XTAP_TAPCELL_ROW_140_3044 VSS VDD sky130_fd_sc_hd__tapvpwrvgnd_1
XTAP_TAPCELL_ROW_140_3045 VSS VDD sky130_fd_sc_hd__tapvpwrvgnd_1
XTAP_TAPCELL_ROW_140_3046 VSS VDD sky130_fd_sc_hd__tapvpwrvgnd_1
XTAP_TAPCELL_ROW_140_3047 VSS VDD sky130_fd_sc_hd__tapvpwrvgnd_1
XTAP_TAPCELL_ROW_140_3048 VSS VDD sky130_fd_sc_hd__tapvpwrvgnd_1
XTAP_TAPCELL_ROW_140_3049 VSS VDD sky130_fd_sc_hd__tapvpwrvgnd_1
XTAP_TAPCELL_ROW_140_3050 VSS VDD sky130_fd_sc_hd__tapvpwrvgnd_1
XTAP_TAPCELL_ROW_140_3051 VSS VDD sky130_fd_sc_hd__tapvpwrvgnd_1
XTAP_TAPCELL_ROW_140_3052 VSS VDD sky130_fd_sc_hd__tapvpwrvgnd_1
XTAP_TAPCELL_ROW_141_3053 VSS VDD sky130_fd_sc_hd__tapvpwrvgnd_1
XTAP_TAPCELL_ROW_141_3054 VSS VDD sky130_fd_sc_hd__tapvpwrvgnd_1
XTAP_TAPCELL_ROW_141_3055 VSS VDD sky130_fd_sc_hd__tapvpwrvgnd_1
XTAP_TAPCELL_ROW_141_3056 VSS VDD sky130_fd_sc_hd__tapvpwrvgnd_1
XTAP_TAPCELL_ROW_141_3057 VSS VDD sky130_fd_sc_hd__tapvpwrvgnd_1
XTAP_TAPCELL_ROW_141_3058 VSS VDD sky130_fd_sc_hd__tapvpwrvgnd_1
XTAP_TAPCELL_ROW_141_3059 VSS VDD sky130_fd_sc_hd__tapvpwrvgnd_1
XTAP_TAPCELL_ROW_141_3060 VSS VDD sky130_fd_sc_hd__tapvpwrvgnd_1
XTAP_TAPCELL_ROW_141_3061 VSS VDD sky130_fd_sc_hd__tapvpwrvgnd_1
XTAP_TAPCELL_ROW_141_3062 VSS VDD sky130_fd_sc_hd__tapvpwrvgnd_1
XTAP_TAPCELL_ROW_141_3063 VSS VDD sky130_fd_sc_hd__tapvpwrvgnd_1
XTAP_TAPCELL_ROW_141_3064 VSS VDD sky130_fd_sc_hd__tapvpwrvgnd_1
XTAP_TAPCELL_ROW_141_3065 VSS VDD sky130_fd_sc_hd__tapvpwrvgnd_1
XTAP_TAPCELL_ROW_141_3066 VSS VDD sky130_fd_sc_hd__tapvpwrvgnd_1
XTAP_TAPCELL_ROW_141_3067 VSS VDD sky130_fd_sc_hd__tapvpwrvgnd_1
XTAP_TAPCELL_ROW_141_3068 VSS VDD sky130_fd_sc_hd__tapvpwrvgnd_1
XTAP_TAPCELL_ROW_141_3069 VSS VDD sky130_fd_sc_hd__tapvpwrvgnd_1
XTAP_TAPCELL_ROW_141_3070 VSS VDD sky130_fd_sc_hd__tapvpwrvgnd_1
XTAP_TAPCELL_ROW_141_3071 VSS VDD sky130_fd_sc_hd__tapvpwrvgnd_1
XTAP_TAPCELL_ROW_141_3072 VSS VDD sky130_fd_sc_hd__tapvpwrvgnd_1
XTAP_TAPCELL_ROW_141_3073 VSS VDD sky130_fd_sc_hd__tapvpwrvgnd_1
XTAP_TAPCELL_ROW_142_3074 VSS VDD sky130_fd_sc_hd__tapvpwrvgnd_1
XTAP_TAPCELL_ROW_142_3075 VSS VDD sky130_fd_sc_hd__tapvpwrvgnd_1
XTAP_TAPCELL_ROW_142_3076 VSS VDD sky130_fd_sc_hd__tapvpwrvgnd_1
XTAP_TAPCELL_ROW_142_3077 VSS VDD sky130_fd_sc_hd__tapvpwrvgnd_1
XTAP_TAPCELL_ROW_142_3078 VSS VDD sky130_fd_sc_hd__tapvpwrvgnd_1
XTAP_TAPCELL_ROW_142_3079 VSS VDD sky130_fd_sc_hd__tapvpwrvgnd_1
XTAP_TAPCELL_ROW_142_3080 VSS VDD sky130_fd_sc_hd__tapvpwrvgnd_1
XTAP_TAPCELL_ROW_142_3081 VSS VDD sky130_fd_sc_hd__tapvpwrvgnd_1
XTAP_TAPCELL_ROW_142_3082 VSS VDD sky130_fd_sc_hd__tapvpwrvgnd_1
XTAP_TAPCELL_ROW_142_3083 VSS VDD sky130_fd_sc_hd__tapvpwrvgnd_1
XTAP_TAPCELL_ROW_142_3084 VSS VDD sky130_fd_sc_hd__tapvpwrvgnd_1
XTAP_TAPCELL_ROW_142_3085 VSS VDD sky130_fd_sc_hd__tapvpwrvgnd_1
XTAP_TAPCELL_ROW_142_3086 VSS VDD sky130_fd_sc_hd__tapvpwrvgnd_1
XTAP_TAPCELL_ROW_142_3087 VSS VDD sky130_fd_sc_hd__tapvpwrvgnd_1
XTAP_TAPCELL_ROW_142_3088 VSS VDD sky130_fd_sc_hd__tapvpwrvgnd_1
XTAP_TAPCELL_ROW_142_3089 VSS VDD sky130_fd_sc_hd__tapvpwrvgnd_1
XTAP_TAPCELL_ROW_142_3090 VSS VDD sky130_fd_sc_hd__tapvpwrvgnd_1
XTAP_TAPCELL_ROW_142_3091 VSS VDD sky130_fd_sc_hd__tapvpwrvgnd_1
XTAP_TAPCELL_ROW_142_3092 VSS VDD sky130_fd_sc_hd__tapvpwrvgnd_1
XTAP_TAPCELL_ROW_142_3093 VSS VDD sky130_fd_sc_hd__tapvpwrvgnd_1
XTAP_TAPCELL_ROW_142_3094 VSS VDD sky130_fd_sc_hd__tapvpwrvgnd_1
XTAP_TAPCELL_ROW_142_3095 VSS VDD sky130_fd_sc_hd__tapvpwrvgnd_1
XTAP_TAPCELL_ROW_143_3096 VSS VDD sky130_fd_sc_hd__tapvpwrvgnd_1
XTAP_TAPCELL_ROW_143_3097 VSS VDD sky130_fd_sc_hd__tapvpwrvgnd_1
XTAP_TAPCELL_ROW_143_3098 VSS VDD sky130_fd_sc_hd__tapvpwrvgnd_1
XTAP_TAPCELL_ROW_143_3099 VSS VDD sky130_fd_sc_hd__tapvpwrvgnd_1
XTAP_TAPCELL_ROW_143_3100 VSS VDD sky130_fd_sc_hd__tapvpwrvgnd_1
XTAP_TAPCELL_ROW_143_3101 VSS VDD sky130_fd_sc_hd__tapvpwrvgnd_1
XTAP_TAPCELL_ROW_143_3102 VSS VDD sky130_fd_sc_hd__tapvpwrvgnd_1
XTAP_TAPCELL_ROW_143_3103 VSS VDD sky130_fd_sc_hd__tapvpwrvgnd_1
XTAP_TAPCELL_ROW_143_3104 VSS VDD sky130_fd_sc_hd__tapvpwrvgnd_1
XTAP_TAPCELL_ROW_143_3105 VSS VDD sky130_fd_sc_hd__tapvpwrvgnd_1
XTAP_TAPCELL_ROW_143_3106 VSS VDD sky130_fd_sc_hd__tapvpwrvgnd_1
XTAP_TAPCELL_ROW_143_3107 VSS VDD sky130_fd_sc_hd__tapvpwrvgnd_1
XTAP_TAPCELL_ROW_143_3108 VSS VDD sky130_fd_sc_hd__tapvpwrvgnd_1
XTAP_TAPCELL_ROW_143_3109 VSS VDD sky130_fd_sc_hd__tapvpwrvgnd_1
XTAP_TAPCELL_ROW_143_3110 VSS VDD sky130_fd_sc_hd__tapvpwrvgnd_1
XTAP_TAPCELL_ROW_143_3111 VSS VDD sky130_fd_sc_hd__tapvpwrvgnd_1
XTAP_TAPCELL_ROW_143_3112 VSS VDD sky130_fd_sc_hd__tapvpwrvgnd_1
XTAP_TAPCELL_ROW_143_3113 VSS VDD sky130_fd_sc_hd__tapvpwrvgnd_1
XTAP_TAPCELL_ROW_143_3114 VSS VDD sky130_fd_sc_hd__tapvpwrvgnd_1
XTAP_TAPCELL_ROW_143_3115 VSS VDD sky130_fd_sc_hd__tapvpwrvgnd_1
XTAP_TAPCELL_ROW_143_3116 VSS VDD sky130_fd_sc_hd__tapvpwrvgnd_1
XTAP_TAPCELL_ROW_144_3117 VSS VDD sky130_fd_sc_hd__tapvpwrvgnd_1
XTAP_TAPCELL_ROW_144_3118 VSS VDD sky130_fd_sc_hd__tapvpwrvgnd_1
XTAP_TAPCELL_ROW_144_3119 VSS VDD sky130_fd_sc_hd__tapvpwrvgnd_1
XTAP_TAPCELL_ROW_144_3120 VSS VDD sky130_fd_sc_hd__tapvpwrvgnd_1
XTAP_TAPCELL_ROW_144_3121 VSS VDD sky130_fd_sc_hd__tapvpwrvgnd_1
XTAP_TAPCELL_ROW_144_3122 VSS VDD sky130_fd_sc_hd__tapvpwrvgnd_1
XTAP_TAPCELL_ROW_144_3123 VSS VDD sky130_fd_sc_hd__tapvpwrvgnd_1
XTAP_TAPCELL_ROW_144_3124 VSS VDD sky130_fd_sc_hd__tapvpwrvgnd_1
XTAP_TAPCELL_ROW_144_3125 VSS VDD sky130_fd_sc_hd__tapvpwrvgnd_1
XTAP_TAPCELL_ROW_144_3126 VSS VDD sky130_fd_sc_hd__tapvpwrvgnd_1
XTAP_TAPCELL_ROW_144_3127 VSS VDD sky130_fd_sc_hd__tapvpwrvgnd_1
XTAP_TAPCELL_ROW_144_3128 VSS VDD sky130_fd_sc_hd__tapvpwrvgnd_1
XTAP_TAPCELL_ROW_144_3129 VSS VDD sky130_fd_sc_hd__tapvpwrvgnd_1
XTAP_TAPCELL_ROW_144_3130 VSS VDD sky130_fd_sc_hd__tapvpwrvgnd_1
XTAP_TAPCELL_ROW_144_3131 VSS VDD sky130_fd_sc_hd__tapvpwrvgnd_1
XTAP_TAPCELL_ROW_144_3132 VSS VDD sky130_fd_sc_hd__tapvpwrvgnd_1
XTAP_TAPCELL_ROW_144_3133 VSS VDD sky130_fd_sc_hd__tapvpwrvgnd_1
XTAP_TAPCELL_ROW_144_3134 VSS VDD sky130_fd_sc_hd__tapvpwrvgnd_1
XTAP_TAPCELL_ROW_144_3135 VSS VDD sky130_fd_sc_hd__tapvpwrvgnd_1
XTAP_TAPCELL_ROW_144_3136 VSS VDD sky130_fd_sc_hd__tapvpwrvgnd_1
XTAP_TAPCELL_ROW_144_3137 VSS VDD sky130_fd_sc_hd__tapvpwrvgnd_1
XTAP_TAPCELL_ROW_144_3138 VSS VDD sky130_fd_sc_hd__tapvpwrvgnd_1
XTAP_TAPCELL_ROW_145_3139 VSS VDD sky130_fd_sc_hd__tapvpwrvgnd_1
XTAP_TAPCELL_ROW_145_3140 VSS VDD sky130_fd_sc_hd__tapvpwrvgnd_1
XTAP_TAPCELL_ROW_145_3141 VSS VDD sky130_fd_sc_hd__tapvpwrvgnd_1
XTAP_TAPCELL_ROW_145_3142 VSS VDD sky130_fd_sc_hd__tapvpwrvgnd_1
XTAP_TAPCELL_ROW_145_3143 VSS VDD sky130_fd_sc_hd__tapvpwrvgnd_1
XTAP_TAPCELL_ROW_145_3144 VSS VDD sky130_fd_sc_hd__tapvpwrvgnd_1
XTAP_TAPCELL_ROW_145_3145 VSS VDD sky130_fd_sc_hd__tapvpwrvgnd_1
XTAP_TAPCELL_ROW_145_3146 VSS VDD sky130_fd_sc_hd__tapvpwrvgnd_1
XTAP_TAPCELL_ROW_145_3147 VSS VDD sky130_fd_sc_hd__tapvpwrvgnd_1
XTAP_TAPCELL_ROW_145_3148 VSS VDD sky130_fd_sc_hd__tapvpwrvgnd_1
XTAP_TAPCELL_ROW_145_3149 VSS VDD sky130_fd_sc_hd__tapvpwrvgnd_1
XTAP_TAPCELL_ROW_145_3150 VSS VDD sky130_fd_sc_hd__tapvpwrvgnd_1
XTAP_TAPCELL_ROW_145_3151 VSS VDD sky130_fd_sc_hd__tapvpwrvgnd_1
XTAP_TAPCELL_ROW_145_3152 VSS VDD sky130_fd_sc_hd__tapvpwrvgnd_1
XTAP_TAPCELL_ROW_145_3153 VSS VDD sky130_fd_sc_hd__tapvpwrvgnd_1
XTAP_TAPCELL_ROW_145_3154 VSS VDD sky130_fd_sc_hd__tapvpwrvgnd_1
XTAP_TAPCELL_ROW_145_3155 VSS VDD sky130_fd_sc_hd__tapvpwrvgnd_1
XTAP_TAPCELL_ROW_145_3156 VSS VDD sky130_fd_sc_hd__tapvpwrvgnd_1
XTAP_TAPCELL_ROW_145_3157 VSS VDD sky130_fd_sc_hd__tapvpwrvgnd_1
XTAP_TAPCELL_ROW_145_3158 VSS VDD sky130_fd_sc_hd__tapvpwrvgnd_1
XTAP_TAPCELL_ROW_145_3159 VSS VDD sky130_fd_sc_hd__tapvpwrvgnd_1
XTAP_TAPCELL_ROW_146_3160 VSS VDD sky130_fd_sc_hd__tapvpwrvgnd_1
XTAP_TAPCELL_ROW_146_3161 VSS VDD sky130_fd_sc_hd__tapvpwrvgnd_1
XTAP_TAPCELL_ROW_146_3162 VSS VDD sky130_fd_sc_hd__tapvpwrvgnd_1
XTAP_TAPCELL_ROW_146_3163 VSS VDD sky130_fd_sc_hd__tapvpwrvgnd_1
XTAP_TAPCELL_ROW_146_3164 VSS VDD sky130_fd_sc_hd__tapvpwrvgnd_1
XTAP_TAPCELL_ROW_146_3165 VSS VDD sky130_fd_sc_hd__tapvpwrvgnd_1
XTAP_TAPCELL_ROW_146_3166 VSS VDD sky130_fd_sc_hd__tapvpwrvgnd_1
XTAP_TAPCELL_ROW_146_3167 VSS VDD sky130_fd_sc_hd__tapvpwrvgnd_1
XTAP_TAPCELL_ROW_146_3168 VSS VDD sky130_fd_sc_hd__tapvpwrvgnd_1
XTAP_TAPCELL_ROW_146_3169 VSS VDD sky130_fd_sc_hd__tapvpwrvgnd_1
XTAP_TAPCELL_ROW_146_3170 VSS VDD sky130_fd_sc_hd__tapvpwrvgnd_1
XTAP_TAPCELL_ROW_146_3171 VSS VDD sky130_fd_sc_hd__tapvpwrvgnd_1
XTAP_TAPCELL_ROW_146_3172 VSS VDD sky130_fd_sc_hd__tapvpwrvgnd_1
XTAP_TAPCELL_ROW_146_3173 VSS VDD sky130_fd_sc_hd__tapvpwrvgnd_1
XTAP_TAPCELL_ROW_146_3174 VSS VDD sky130_fd_sc_hd__tapvpwrvgnd_1
XTAP_TAPCELL_ROW_146_3175 VSS VDD sky130_fd_sc_hd__tapvpwrvgnd_1
XTAP_TAPCELL_ROW_146_3176 VSS VDD sky130_fd_sc_hd__tapvpwrvgnd_1
XTAP_TAPCELL_ROW_146_3177 VSS VDD sky130_fd_sc_hd__tapvpwrvgnd_1
XTAP_TAPCELL_ROW_146_3178 VSS VDD sky130_fd_sc_hd__tapvpwrvgnd_1
XTAP_TAPCELL_ROW_146_3179 VSS VDD sky130_fd_sc_hd__tapvpwrvgnd_1
XTAP_TAPCELL_ROW_146_3180 VSS VDD sky130_fd_sc_hd__tapvpwrvgnd_1
XTAP_TAPCELL_ROW_146_3181 VSS VDD sky130_fd_sc_hd__tapvpwrvgnd_1
XTAP_TAPCELL_ROW_147_3182 VSS VDD sky130_fd_sc_hd__tapvpwrvgnd_1
XTAP_TAPCELL_ROW_147_3183 VSS VDD sky130_fd_sc_hd__tapvpwrvgnd_1
XTAP_TAPCELL_ROW_147_3184 VSS VDD sky130_fd_sc_hd__tapvpwrvgnd_1
XTAP_TAPCELL_ROW_147_3185 VSS VDD sky130_fd_sc_hd__tapvpwrvgnd_1
XTAP_TAPCELL_ROW_147_3186 VSS VDD sky130_fd_sc_hd__tapvpwrvgnd_1
XTAP_TAPCELL_ROW_147_3187 VSS VDD sky130_fd_sc_hd__tapvpwrvgnd_1
XTAP_TAPCELL_ROW_147_3188 VSS VDD sky130_fd_sc_hd__tapvpwrvgnd_1
XTAP_TAPCELL_ROW_147_3189 VSS VDD sky130_fd_sc_hd__tapvpwrvgnd_1
XTAP_TAPCELL_ROW_147_3190 VSS VDD sky130_fd_sc_hd__tapvpwrvgnd_1
XTAP_TAPCELL_ROW_147_3191 VSS VDD sky130_fd_sc_hd__tapvpwrvgnd_1
XTAP_TAPCELL_ROW_147_3192 VSS VDD sky130_fd_sc_hd__tapvpwrvgnd_1
XTAP_TAPCELL_ROW_147_3193 VSS VDD sky130_fd_sc_hd__tapvpwrvgnd_1
XTAP_TAPCELL_ROW_147_3194 VSS VDD sky130_fd_sc_hd__tapvpwrvgnd_1
XTAP_TAPCELL_ROW_147_3195 VSS VDD sky130_fd_sc_hd__tapvpwrvgnd_1
XTAP_TAPCELL_ROW_147_3196 VSS VDD sky130_fd_sc_hd__tapvpwrvgnd_1
XTAP_TAPCELL_ROW_147_3197 VSS VDD sky130_fd_sc_hd__tapvpwrvgnd_1
XTAP_TAPCELL_ROW_147_3198 VSS VDD sky130_fd_sc_hd__tapvpwrvgnd_1
XTAP_TAPCELL_ROW_147_3199 VSS VDD sky130_fd_sc_hd__tapvpwrvgnd_1
XTAP_TAPCELL_ROW_147_3200 VSS VDD sky130_fd_sc_hd__tapvpwrvgnd_1
XTAP_TAPCELL_ROW_147_3201 VSS VDD sky130_fd_sc_hd__tapvpwrvgnd_1
XTAP_TAPCELL_ROW_147_3202 VSS VDD sky130_fd_sc_hd__tapvpwrvgnd_1
XTAP_TAPCELL_ROW_148_3203 VSS VDD sky130_fd_sc_hd__tapvpwrvgnd_1
XTAP_TAPCELL_ROW_148_3204 VSS VDD sky130_fd_sc_hd__tapvpwrvgnd_1
XTAP_TAPCELL_ROW_148_3205 VSS VDD sky130_fd_sc_hd__tapvpwrvgnd_1
XTAP_TAPCELL_ROW_148_3206 VSS VDD sky130_fd_sc_hd__tapvpwrvgnd_1
XTAP_TAPCELL_ROW_148_3207 VSS VDD sky130_fd_sc_hd__tapvpwrvgnd_1
XTAP_TAPCELL_ROW_148_3208 VSS VDD sky130_fd_sc_hd__tapvpwrvgnd_1
XTAP_TAPCELL_ROW_148_3209 VSS VDD sky130_fd_sc_hd__tapvpwrvgnd_1
XTAP_TAPCELL_ROW_148_3210 VSS VDD sky130_fd_sc_hd__tapvpwrvgnd_1
XTAP_TAPCELL_ROW_148_3211 VSS VDD sky130_fd_sc_hd__tapvpwrvgnd_1
XTAP_TAPCELL_ROW_148_3212 VSS VDD sky130_fd_sc_hd__tapvpwrvgnd_1
XTAP_TAPCELL_ROW_148_3213 VSS VDD sky130_fd_sc_hd__tapvpwrvgnd_1
XTAP_TAPCELL_ROW_148_3214 VSS VDD sky130_fd_sc_hd__tapvpwrvgnd_1
XTAP_TAPCELL_ROW_148_3215 VSS VDD sky130_fd_sc_hd__tapvpwrvgnd_1
XTAP_TAPCELL_ROW_148_3216 VSS VDD sky130_fd_sc_hd__tapvpwrvgnd_1
XTAP_TAPCELL_ROW_148_3217 VSS VDD sky130_fd_sc_hd__tapvpwrvgnd_1
XTAP_TAPCELL_ROW_148_3218 VSS VDD sky130_fd_sc_hd__tapvpwrvgnd_1
XTAP_TAPCELL_ROW_148_3219 VSS VDD sky130_fd_sc_hd__tapvpwrvgnd_1
XTAP_TAPCELL_ROW_148_3220 VSS VDD sky130_fd_sc_hd__tapvpwrvgnd_1
XTAP_TAPCELL_ROW_148_3221 VSS VDD sky130_fd_sc_hd__tapvpwrvgnd_1
XTAP_TAPCELL_ROW_148_3222 VSS VDD sky130_fd_sc_hd__tapvpwrvgnd_1
XTAP_TAPCELL_ROW_148_3223 VSS VDD sky130_fd_sc_hd__tapvpwrvgnd_1
XTAP_TAPCELL_ROW_148_3224 VSS VDD sky130_fd_sc_hd__tapvpwrvgnd_1
XTAP_TAPCELL_ROW_149_3225 VSS VDD sky130_fd_sc_hd__tapvpwrvgnd_1
XTAP_TAPCELL_ROW_149_3226 VSS VDD sky130_fd_sc_hd__tapvpwrvgnd_1
XTAP_TAPCELL_ROW_149_3227 VSS VDD sky130_fd_sc_hd__tapvpwrvgnd_1
XTAP_TAPCELL_ROW_149_3228 VSS VDD sky130_fd_sc_hd__tapvpwrvgnd_1
XTAP_TAPCELL_ROW_149_3229 VSS VDD sky130_fd_sc_hd__tapvpwrvgnd_1
XTAP_TAPCELL_ROW_149_3230 VSS VDD sky130_fd_sc_hd__tapvpwrvgnd_1
XTAP_TAPCELL_ROW_149_3231 VSS VDD sky130_fd_sc_hd__tapvpwrvgnd_1
XTAP_TAPCELL_ROW_149_3232 VSS VDD sky130_fd_sc_hd__tapvpwrvgnd_1
XTAP_TAPCELL_ROW_149_3233 VSS VDD sky130_fd_sc_hd__tapvpwrvgnd_1
XTAP_TAPCELL_ROW_149_3234 VSS VDD sky130_fd_sc_hd__tapvpwrvgnd_1
XTAP_TAPCELL_ROW_149_3235 VSS VDD sky130_fd_sc_hd__tapvpwrvgnd_1
XTAP_TAPCELL_ROW_149_3236 VSS VDD sky130_fd_sc_hd__tapvpwrvgnd_1
XTAP_TAPCELL_ROW_149_3237 VSS VDD sky130_fd_sc_hd__tapvpwrvgnd_1
XTAP_TAPCELL_ROW_149_3238 VSS VDD sky130_fd_sc_hd__tapvpwrvgnd_1
XTAP_TAPCELL_ROW_149_3239 VSS VDD sky130_fd_sc_hd__tapvpwrvgnd_1
XTAP_TAPCELL_ROW_149_3240 VSS VDD sky130_fd_sc_hd__tapvpwrvgnd_1
XTAP_TAPCELL_ROW_149_3241 VSS VDD sky130_fd_sc_hd__tapvpwrvgnd_1
XTAP_TAPCELL_ROW_149_3242 VSS VDD sky130_fd_sc_hd__tapvpwrvgnd_1
XTAP_TAPCELL_ROW_149_3243 VSS VDD sky130_fd_sc_hd__tapvpwrvgnd_1
XTAP_TAPCELL_ROW_149_3244 VSS VDD sky130_fd_sc_hd__tapvpwrvgnd_1
XTAP_TAPCELL_ROW_149_3245 VSS VDD sky130_fd_sc_hd__tapvpwrvgnd_1
XTAP_TAPCELL_ROW_150_3246 VSS VDD sky130_fd_sc_hd__tapvpwrvgnd_1
XTAP_TAPCELL_ROW_150_3247 VSS VDD sky130_fd_sc_hd__tapvpwrvgnd_1
XTAP_TAPCELL_ROW_150_3248 VSS VDD sky130_fd_sc_hd__tapvpwrvgnd_1
XTAP_TAPCELL_ROW_150_3249 VSS VDD sky130_fd_sc_hd__tapvpwrvgnd_1
XTAP_TAPCELL_ROW_150_3250 VSS VDD sky130_fd_sc_hd__tapvpwrvgnd_1
XTAP_TAPCELL_ROW_150_3251 VSS VDD sky130_fd_sc_hd__tapvpwrvgnd_1
XTAP_TAPCELL_ROW_150_3252 VSS VDD sky130_fd_sc_hd__tapvpwrvgnd_1
XTAP_TAPCELL_ROW_150_3253 VSS VDD sky130_fd_sc_hd__tapvpwrvgnd_1
XTAP_TAPCELL_ROW_150_3254 VSS VDD sky130_fd_sc_hd__tapvpwrvgnd_1
XTAP_TAPCELL_ROW_150_3255 VSS VDD sky130_fd_sc_hd__tapvpwrvgnd_1
XTAP_TAPCELL_ROW_150_3256 VSS VDD sky130_fd_sc_hd__tapvpwrvgnd_1
XTAP_TAPCELL_ROW_150_3257 VSS VDD sky130_fd_sc_hd__tapvpwrvgnd_1
XTAP_TAPCELL_ROW_150_3258 VSS VDD sky130_fd_sc_hd__tapvpwrvgnd_1
XTAP_TAPCELL_ROW_150_3259 VSS VDD sky130_fd_sc_hd__tapvpwrvgnd_1
XTAP_TAPCELL_ROW_150_3260 VSS VDD sky130_fd_sc_hd__tapvpwrvgnd_1
XTAP_TAPCELL_ROW_150_3261 VSS VDD sky130_fd_sc_hd__tapvpwrvgnd_1
XTAP_TAPCELL_ROW_150_3262 VSS VDD sky130_fd_sc_hd__tapvpwrvgnd_1
XTAP_TAPCELL_ROW_150_3263 VSS VDD sky130_fd_sc_hd__tapvpwrvgnd_1
XTAP_TAPCELL_ROW_150_3264 VSS VDD sky130_fd_sc_hd__tapvpwrvgnd_1
XTAP_TAPCELL_ROW_150_3265 VSS VDD sky130_fd_sc_hd__tapvpwrvgnd_1
XTAP_TAPCELL_ROW_150_3266 VSS VDD sky130_fd_sc_hd__tapvpwrvgnd_1
XTAP_TAPCELL_ROW_150_3267 VSS VDD sky130_fd_sc_hd__tapvpwrvgnd_1
XTAP_TAPCELL_ROW_151_3268 VSS VDD sky130_fd_sc_hd__tapvpwrvgnd_1
XTAP_TAPCELL_ROW_151_3269 VSS VDD sky130_fd_sc_hd__tapvpwrvgnd_1
XTAP_TAPCELL_ROW_151_3270 VSS VDD sky130_fd_sc_hd__tapvpwrvgnd_1
XTAP_TAPCELL_ROW_151_3271 VSS VDD sky130_fd_sc_hd__tapvpwrvgnd_1
XTAP_TAPCELL_ROW_151_3272 VSS VDD sky130_fd_sc_hd__tapvpwrvgnd_1
XTAP_TAPCELL_ROW_151_3273 VSS VDD sky130_fd_sc_hd__tapvpwrvgnd_1
XTAP_TAPCELL_ROW_151_3274 VSS VDD sky130_fd_sc_hd__tapvpwrvgnd_1
XTAP_TAPCELL_ROW_151_3275 VSS VDD sky130_fd_sc_hd__tapvpwrvgnd_1
XTAP_TAPCELL_ROW_151_3276 VSS VDD sky130_fd_sc_hd__tapvpwrvgnd_1
XTAP_TAPCELL_ROW_151_3277 VSS VDD sky130_fd_sc_hd__tapvpwrvgnd_1
XTAP_TAPCELL_ROW_151_3278 VSS VDD sky130_fd_sc_hd__tapvpwrvgnd_1
XTAP_TAPCELL_ROW_151_3279 VSS VDD sky130_fd_sc_hd__tapvpwrvgnd_1
XTAP_TAPCELL_ROW_151_3280 VSS VDD sky130_fd_sc_hd__tapvpwrvgnd_1
XTAP_TAPCELL_ROW_151_3281 VSS VDD sky130_fd_sc_hd__tapvpwrvgnd_1
XTAP_TAPCELL_ROW_151_3282 VSS VDD sky130_fd_sc_hd__tapvpwrvgnd_1
XTAP_TAPCELL_ROW_151_3283 VSS VDD sky130_fd_sc_hd__tapvpwrvgnd_1
XTAP_TAPCELL_ROW_151_3284 VSS VDD sky130_fd_sc_hd__tapvpwrvgnd_1
XTAP_TAPCELL_ROW_151_3285 VSS VDD sky130_fd_sc_hd__tapvpwrvgnd_1
XTAP_TAPCELL_ROW_151_3286 VSS VDD sky130_fd_sc_hd__tapvpwrvgnd_1
XTAP_TAPCELL_ROW_151_3287 VSS VDD sky130_fd_sc_hd__tapvpwrvgnd_1
XTAP_TAPCELL_ROW_151_3288 VSS VDD sky130_fd_sc_hd__tapvpwrvgnd_1
XTAP_TAPCELL_ROW_152_3289 VSS VDD sky130_fd_sc_hd__tapvpwrvgnd_1
XTAP_TAPCELL_ROW_152_3290 VSS VDD sky130_fd_sc_hd__tapvpwrvgnd_1
XTAP_TAPCELL_ROW_152_3291 VSS VDD sky130_fd_sc_hd__tapvpwrvgnd_1
XTAP_TAPCELL_ROW_152_3292 VSS VDD sky130_fd_sc_hd__tapvpwrvgnd_1
XTAP_TAPCELL_ROW_152_3293 VSS VDD sky130_fd_sc_hd__tapvpwrvgnd_1
XTAP_TAPCELL_ROW_152_3294 VSS VDD sky130_fd_sc_hd__tapvpwrvgnd_1
XTAP_TAPCELL_ROW_152_3295 VSS VDD sky130_fd_sc_hd__tapvpwrvgnd_1
XTAP_TAPCELL_ROW_152_3296 VSS VDD sky130_fd_sc_hd__tapvpwrvgnd_1
XTAP_TAPCELL_ROW_152_3297 VSS VDD sky130_fd_sc_hd__tapvpwrvgnd_1
XTAP_TAPCELL_ROW_152_3298 VSS VDD sky130_fd_sc_hd__tapvpwrvgnd_1
XTAP_TAPCELL_ROW_152_3299 VSS VDD sky130_fd_sc_hd__tapvpwrvgnd_1
XTAP_TAPCELL_ROW_152_3300 VSS VDD sky130_fd_sc_hd__tapvpwrvgnd_1
XTAP_TAPCELL_ROW_152_3301 VSS VDD sky130_fd_sc_hd__tapvpwrvgnd_1
XTAP_TAPCELL_ROW_152_3302 VSS VDD sky130_fd_sc_hd__tapvpwrvgnd_1
XTAP_TAPCELL_ROW_152_3303 VSS VDD sky130_fd_sc_hd__tapvpwrvgnd_1
XTAP_TAPCELL_ROW_152_3304 VSS VDD sky130_fd_sc_hd__tapvpwrvgnd_1
XTAP_TAPCELL_ROW_152_3305 VSS VDD sky130_fd_sc_hd__tapvpwrvgnd_1
XTAP_TAPCELL_ROW_152_3306 VSS VDD sky130_fd_sc_hd__tapvpwrvgnd_1
XTAP_TAPCELL_ROW_152_3307 VSS VDD sky130_fd_sc_hd__tapvpwrvgnd_1
XTAP_TAPCELL_ROW_152_3308 VSS VDD sky130_fd_sc_hd__tapvpwrvgnd_1
XTAP_TAPCELL_ROW_152_3309 VSS VDD sky130_fd_sc_hd__tapvpwrvgnd_1
XTAP_TAPCELL_ROW_152_3310 VSS VDD sky130_fd_sc_hd__tapvpwrvgnd_1
XTAP_TAPCELL_ROW_153_3311 VSS VDD sky130_fd_sc_hd__tapvpwrvgnd_1
XTAP_TAPCELL_ROW_153_3312 VSS VDD sky130_fd_sc_hd__tapvpwrvgnd_1
XTAP_TAPCELL_ROW_153_3313 VSS VDD sky130_fd_sc_hd__tapvpwrvgnd_1
XTAP_TAPCELL_ROW_153_3314 VSS VDD sky130_fd_sc_hd__tapvpwrvgnd_1
XTAP_TAPCELL_ROW_153_3315 VSS VDD sky130_fd_sc_hd__tapvpwrvgnd_1
XTAP_TAPCELL_ROW_153_3316 VSS VDD sky130_fd_sc_hd__tapvpwrvgnd_1
XTAP_TAPCELL_ROW_153_3317 VSS VDD sky130_fd_sc_hd__tapvpwrvgnd_1
XTAP_TAPCELL_ROW_153_3318 VSS VDD sky130_fd_sc_hd__tapvpwrvgnd_1
XTAP_TAPCELL_ROW_153_3319 VSS VDD sky130_fd_sc_hd__tapvpwrvgnd_1
XTAP_TAPCELL_ROW_153_3320 VSS VDD sky130_fd_sc_hd__tapvpwrvgnd_1
XTAP_TAPCELL_ROW_153_3321 VSS VDD sky130_fd_sc_hd__tapvpwrvgnd_1
XTAP_TAPCELL_ROW_153_3322 VSS VDD sky130_fd_sc_hd__tapvpwrvgnd_1
XTAP_TAPCELL_ROW_153_3323 VSS VDD sky130_fd_sc_hd__tapvpwrvgnd_1
XTAP_TAPCELL_ROW_153_3324 VSS VDD sky130_fd_sc_hd__tapvpwrvgnd_1
XTAP_TAPCELL_ROW_153_3325 VSS VDD sky130_fd_sc_hd__tapvpwrvgnd_1
XTAP_TAPCELL_ROW_153_3326 VSS VDD sky130_fd_sc_hd__tapvpwrvgnd_1
XTAP_TAPCELL_ROW_153_3327 VSS VDD sky130_fd_sc_hd__tapvpwrvgnd_1
XTAP_TAPCELL_ROW_153_3328 VSS VDD sky130_fd_sc_hd__tapvpwrvgnd_1
XTAP_TAPCELL_ROW_153_3329 VSS VDD sky130_fd_sc_hd__tapvpwrvgnd_1
XTAP_TAPCELL_ROW_153_3330 VSS VDD sky130_fd_sc_hd__tapvpwrvgnd_1
XTAP_TAPCELL_ROW_153_3331 VSS VDD sky130_fd_sc_hd__tapvpwrvgnd_1
XTAP_TAPCELL_ROW_154_3332 VSS VDD sky130_fd_sc_hd__tapvpwrvgnd_1
XTAP_TAPCELL_ROW_154_3333 VSS VDD sky130_fd_sc_hd__tapvpwrvgnd_1
XTAP_TAPCELL_ROW_154_3334 VSS VDD sky130_fd_sc_hd__tapvpwrvgnd_1
XTAP_TAPCELL_ROW_154_3335 VSS VDD sky130_fd_sc_hd__tapvpwrvgnd_1
XTAP_TAPCELL_ROW_154_3336 VSS VDD sky130_fd_sc_hd__tapvpwrvgnd_1
XTAP_TAPCELL_ROW_154_3337 VSS VDD sky130_fd_sc_hd__tapvpwrvgnd_1
XTAP_TAPCELL_ROW_154_3338 VSS VDD sky130_fd_sc_hd__tapvpwrvgnd_1
XTAP_TAPCELL_ROW_154_3339 VSS VDD sky130_fd_sc_hd__tapvpwrvgnd_1
XTAP_TAPCELL_ROW_154_3340 VSS VDD sky130_fd_sc_hd__tapvpwrvgnd_1
XTAP_TAPCELL_ROW_154_3341 VSS VDD sky130_fd_sc_hd__tapvpwrvgnd_1
XTAP_TAPCELL_ROW_154_3342 VSS VDD sky130_fd_sc_hd__tapvpwrvgnd_1
XTAP_TAPCELL_ROW_154_3343 VSS VDD sky130_fd_sc_hd__tapvpwrvgnd_1
XTAP_TAPCELL_ROW_154_3344 VSS VDD sky130_fd_sc_hd__tapvpwrvgnd_1
XTAP_TAPCELL_ROW_154_3345 VSS VDD sky130_fd_sc_hd__tapvpwrvgnd_1
XTAP_TAPCELL_ROW_154_3346 VSS VDD sky130_fd_sc_hd__tapvpwrvgnd_1
XTAP_TAPCELL_ROW_154_3347 VSS VDD sky130_fd_sc_hd__tapvpwrvgnd_1
XTAP_TAPCELL_ROW_154_3348 VSS VDD sky130_fd_sc_hd__tapvpwrvgnd_1
XTAP_TAPCELL_ROW_154_3349 VSS VDD sky130_fd_sc_hd__tapvpwrvgnd_1
XTAP_TAPCELL_ROW_154_3350 VSS VDD sky130_fd_sc_hd__tapvpwrvgnd_1
XTAP_TAPCELL_ROW_154_3351 VSS VDD sky130_fd_sc_hd__tapvpwrvgnd_1
XTAP_TAPCELL_ROW_154_3352 VSS VDD sky130_fd_sc_hd__tapvpwrvgnd_1
XTAP_TAPCELL_ROW_154_3353 VSS VDD sky130_fd_sc_hd__tapvpwrvgnd_1
XTAP_TAPCELL_ROW_155_3354 VSS VDD sky130_fd_sc_hd__tapvpwrvgnd_1
XTAP_TAPCELL_ROW_155_3355 VSS VDD sky130_fd_sc_hd__tapvpwrvgnd_1
XTAP_TAPCELL_ROW_155_3356 VSS VDD sky130_fd_sc_hd__tapvpwrvgnd_1
XTAP_TAPCELL_ROW_155_3357 VSS VDD sky130_fd_sc_hd__tapvpwrvgnd_1
XTAP_TAPCELL_ROW_155_3358 VSS VDD sky130_fd_sc_hd__tapvpwrvgnd_1
XTAP_TAPCELL_ROW_155_3359 VSS VDD sky130_fd_sc_hd__tapvpwrvgnd_1
XTAP_TAPCELL_ROW_155_3360 VSS VDD sky130_fd_sc_hd__tapvpwrvgnd_1
XTAP_TAPCELL_ROW_155_3361 VSS VDD sky130_fd_sc_hd__tapvpwrvgnd_1
XTAP_TAPCELL_ROW_155_3362 VSS VDD sky130_fd_sc_hd__tapvpwrvgnd_1
XTAP_TAPCELL_ROW_155_3363 VSS VDD sky130_fd_sc_hd__tapvpwrvgnd_1
XTAP_TAPCELL_ROW_155_3364 VSS VDD sky130_fd_sc_hd__tapvpwrvgnd_1
XTAP_TAPCELL_ROW_155_3365 VSS VDD sky130_fd_sc_hd__tapvpwrvgnd_1
XTAP_TAPCELL_ROW_155_3366 VSS VDD sky130_fd_sc_hd__tapvpwrvgnd_1
XTAP_TAPCELL_ROW_155_3367 VSS VDD sky130_fd_sc_hd__tapvpwrvgnd_1
XTAP_TAPCELL_ROW_155_3368 VSS VDD sky130_fd_sc_hd__tapvpwrvgnd_1
XTAP_TAPCELL_ROW_155_3369 VSS VDD sky130_fd_sc_hd__tapvpwrvgnd_1
XTAP_TAPCELL_ROW_155_3370 VSS VDD sky130_fd_sc_hd__tapvpwrvgnd_1
XTAP_TAPCELL_ROW_155_3371 VSS VDD sky130_fd_sc_hd__tapvpwrvgnd_1
XTAP_TAPCELL_ROW_155_3372 VSS VDD sky130_fd_sc_hd__tapvpwrvgnd_1
XTAP_TAPCELL_ROW_155_3373 VSS VDD sky130_fd_sc_hd__tapvpwrvgnd_1
XTAP_TAPCELL_ROW_155_3374 VSS VDD sky130_fd_sc_hd__tapvpwrvgnd_1
XTAP_TAPCELL_ROW_156_3375 VSS VDD sky130_fd_sc_hd__tapvpwrvgnd_1
XTAP_TAPCELL_ROW_156_3376 VSS VDD sky130_fd_sc_hd__tapvpwrvgnd_1
XTAP_TAPCELL_ROW_156_3377 VSS VDD sky130_fd_sc_hd__tapvpwrvgnd_1
XTAP_TAPCELL_ROW_156_3378 VSS VDD sky130_fd_sc_hd__tapvpwrvgnd_1
XTAP_TAPCELL_ROW_156_3379 VSS VDD sky130_fd_sc_hd__tapvpwrvgnd_1
XTAP_TAPCELL_ROW_156_3380 VSS VDD sky130_fd_sc_hd__tapvpwrvgnd_1
XTAP_TAPCELL_ROW_156_3381 VSS VDD sky130_fd_sc_hd__tapvpwrvgnd_1
XTAP_TAPCELL_ROW_156_3382 VSS VDD sky130_fd_sc_hd__tapvpwrvgnd_1
XTAP_TAPCELL_ROW_156_3383 VSS VDD sky130_fd_sc_hd__tapvpwrvgnd_1
XTAP_TAPCELL_ROW_156_3384 VSS VDD sky130_fd_sc_hd__tapvpwrvgnd_1
XTAP_TAPCELL_ROW_156_3385 VSS VDD sky130_fd_sc_hd__tapvpwrvgnd_1
XTAP_TAPCELL_ROW_156_3386 VSS VDD sky130_fd_sc_hd__tapvpwrvgnd_1
XTAP_TAPCELL_ROW_156_3387 VSS VDD sky130_fd_sc_hd__tapvpwrvgnd_1
XTAP_TAPCELL_ROW_156_3388 VSS VDD sky130_fd_sc_hd__tapvpwrvgnd_1
XTAP_TAPCELL_ROW_156_3389 VSS VDD sky130_fd_sc_hd__tapvpwrvgnd_1
XTAP_TAPCELL_ROW_156_3390 VSS VDD sky130_fd_sc_hd__tapvpwrvgnd_1
XTAP_TAPCELL_ROW_156_3391 VSS VDD sky130_fd_sc_hd__tapvpwrvgnd_1
XTAP_TAPCELL_ROW_156_3392 VSS VDD sky130_fd_sc_hd__tapvpwrvgnd_1
XTAP_TAPCELL_ROW_156_3393 VSS VDD sky130_fd_sc_hd__tapvpwrvgnd_1
XTAP_TAPCELL_ROW_156_3394 VSS VDD sky130_fd_sc_hd__tapvpwrvgnd_1
XTAP_TAPCELL_ROW_156_3395 VSS VDD sky130_fd_sc_hd__tapvpwrvgnd_1
XTAP_TAPCELL_ROW_156_3396 VSS VDD sky130_fd_sc_hd__tapvpwrvgnd_1
XTAP_TAPCELL_ROW_157_3397 VSS VDD sky130_fd_sc_hd__tapvpwrvgnd_1
XTAP_TAPCELL_ROW_157_3398 VSS VDD sky130_fd_sc_hd__tapvpwrvgnd_1
XTAP_TAPCELL_ROW_157_3399 VSS VDD sky130_fd_sc_hd__tapvpwrvgnd_1
XTAP_TAPCELL_ROW_157_3400 VSS VDD sky130_fd_sc_hd__tapvpwrvgnd_1
XTAP_TAPCELL_ROW_157_3401 VSS VDD sky130_fd_sc_hd__tapvpwrvgnd_1
XTAP_TAPCELL_ROW_157_3402 VSS VDD sky130_fd_sc_hd__tapvpwrvgnd_1
XTAP_TAPCELL_ROW_157_3403 VSS VDD sky130_fd_sc_hd__tapvpwrvgnd_1
XTAP_TAPCELL_ROW_157_3404 VSS VDD sky130_fd_sc_hd__tapvpwrvgnd_1
XTAP_TAPCELL_ROW_157_3405 VSS VDD sky130_fd_sc_hd__tapvpwrvgnd_1
XTAP_TAPCELL_ROW_157_3406 VSS VDD sky130_fd_sc_hd__tapvpwrvgnd_1
XTAP_TAPCELL_ROW_157_3407 VSS VDD sky130_fd_sc_hd__tapvpwrvgnd_1
XTAP_TAPCELL_ROW_157_3408 VSS VDD sky130_fd_sc_hd__tapvpwrvgnd_1
XTAP_TAPCELL_ROW_157_3409 VSS VDD sky130_fd_sc_hd__tapvpwrvgnd_1
XTAP_TAPCELL_ROW_157_3410 VSS VDD sky130_fd_sc_hd__tapvpwrvgnd_1
XTAP_TAPCELL_ROW_157_3411 VSS VDD sky130_fd_sc_hd__tapvpwrvgnd_1
XTAP_TAPCELL_ROW_157_3412 VSS VDD sky130_fd_sc_hd__tapvpwrvgnd_1
XTAP_TAPCELL_ROW_157_3413 VSS VDD sky130_fd_sc_hd__tapvpwrvgnd_1
XTAP_TAPCELL_ROW_157_3414 VSS VDD sky130_fd_sc_hd__tapvpwrvgnd_1
XTAP_TAPCELL_ROW_157_3415 VSS VDD sky130_fd_sc_hd__tapvpwrvgnd_1
XTAP_TAPCELL_ROW_157_3416 VSS VDD sky130_fd_sc_hd__tapvpwrvgnd_1
XTAP_TAPCELL_ROW_157_3417 VSS VDD sky130_fd_sc_hd__tapvpwrvgnd_1
XTAP_TAPCELL_ROW_158_3418 VSS VDD sky130_fd_sc_hd__tapvpwrvgnd_1
XTAP_TAPCELL_ROW_158_3419 VSS VDD sky130_fd_sc_hd__tapvpwrvgnd_1
XTAP_TAPCELL_ROW_158_3420 VSS VDD sky130_fd_sc_hd__tapvpwrvgnd_1
XTAP_TAPCELL_ROW_158_3421 VSS VDD sky130_fd_sc_hd__tapvpwrvgnd_1
XTAP_TAPCELL_ROW_158_3422 VSS VDD sky130_fd_sc_hd__tapvpwrvgnd_1
XTAP_TAPCELL_ROW_158_3423 VSS VDD sky130_fd_sc_hd__tapvpwrvgnd_1
XTAP_TAPCELL_ROW_158_3424 VSS VDD sky130_fd_sc_hd__tapvpwrvgnd_1
XTAP_TAPCELL_ROW_158_3425 VSS VDD sky130_fd_sc_hd__tapvpwrvgnd_1
XTAP_TAPCELL_ROW_158_3426 VSS VDD sky130_fd_sc_hd__tapvpwrvgnd_1
XTAP_TAPCELL_ROW_158_3427 VSS VDD sky130_fd_sc_hd__tapvpwrvgnd_1
XTAP_TAPCELL_ROW_158_3428 VSS VDD sky130_fd_sc_hd__tapvpwrvgnd_1
XTAP_TAPCELL_ROW_158_3429 VSS VDD sky130_fd_sc_hd__tapvpwrvgnd_1
XTAP_TAPCELL_ROW_158_3430 VSS VDD sky130_fd_sc_hd__tapvpwrvgnd_1
XTAP_TAPCELL_ROW_158_3431 VSS VDD sky130_fd_sc_hd__tapvpwrvgnd_1
XTAP_TAPCELL_ROW_158_3432 VSS VDD sky130_fd_sc_hd__tapvpwrvgnd_1
XTAP_TAPCELL_ROW_158_3433 VSS VDD sky130_fd_sc_hd__tapvpwrvgnd_1
XTAP_TAPCELL_ROW_158_3434 VSS VDD sky130_fd_sc_hd__tapvpwrvgnd_1
XTAP_TAPCELL_ROW_158_3435 VSS VDD sky130_fd_sc_hd__tapvpwrvgnd_1
XTAP_TAPCELL_ROW_158_3436 VSS VDD sky130_fd_sc_hd__tapvpwrvgnd_1
XTAP_TAPCELL_ROW_158_3437 VSS VDD sky130_fd_sc_hd__tapvpwrvgnd_1
XTAP_TAPCELL_ROW_158_3438 VSS VDD sky130_fd_sc_hd__tapvpwrvgnd_1
XTAP_TAPCELL_ROW_158_3439 VSS VDD sky130_fd_sc_hd__tapvpwrvgnd_1
XTAP_TAPCELL_ROW_159_3440 VSS VDD sky130_fd_sc_hd__tapvpwrvgnd_1
XTAP_TAPCELL_ROW_159_3441 VSS VDD sky130_fd_sc_hd__tapvpwrvgnd_1
XTAP_TAPCELL_ROW_159_3442 VSS VDD sky130_fd_sc_hd__tapvpwrvgnd_1
XTAP_TAPCELL_ROW_159_3443 VSS VDD sky130_fd_sc_hd__tapvpwrvgnd_1
XTAP_TAPCELL_ROW_159_3444 VSS VDD sky130_fd_sc_hd__tapvpwrvgnd_1
XTAP_TAPCELL_ROW_159_3445 VSS VDD sky130_fd_sc_hd__tapvpwrvgnd_1
XTAP_TAPCELL_ROW_159_3446 VSS VDD sky130_fd_sc_hd__tapvpwrvgnd_1
XTAP_TAPCELL_ROW_159_3447 VSS VDD sky130_fd_sc_hd__tapvpwrvgnd_1
XTAP_TAPCELL_ROW_159_3448 VSS VDD sky130_fd_sc_hd__tapvpwrvgnd_1
XTAP_TAPCELL_ROW_159_3449 VSS VDD sky130_fd_sc_hd__tapvpwrvgnd_1
XTAP_TAPCELL_ROW_159_3450 VSS VDD sky130_fd_sc_hd__tapvpwrvgnd_1
XTAP_TAPCELL_ROW_159_3451 VSS VDD sky130_fd_sc_hd__tapvpwrvgnd_1
XTAP_TAPCELL_ROW_159_3452 VSS VDD sky130_fd_sc_hd__tapvpwrvgnd_1
XTAP_TAPCELL_ROW_159_3453 VSS VDD sky130_fd_sc_hd__tapvpwrvgnd_1
XTAP_TAPCELL_ROW_159_3454 VSS VDD sky130_fd_sc_hd__tapvpwrvgnd_1
XTAP_TAPCELL_ROW_159_3455 VSS VDD sky130_fd_sc_hd__tapvpwrvgnd_1
XTAP_TAPCELL_ROW_159_3456 VSS VDD sky130_fd_sc_hd__tapvpwrvgnd_1
XTAP_TAPCELL_ROW_159_3457 VSS VDD sky130_fd_sc_hd__tapvpwrvgnd_1
XTAP_TAPCELL_ROW_159_3458 VSS VDD sky130_fd_sc_hd__tapvpwrvgnd_1
XTAP_TAPCELL_ROW_159_3459 VSS VDD sky130_fd_sc_hd__tapvpwrvgnd_1
XTAP_TAPCELL_ROW_159_3460 VSS VDD sky130_fd_sc_hd__tapvpwrvgnd_1
XTAP_TAPCELL_ROW_160_3461 VSS VDD sky130_fd_sc_hd__tapvpwrvgnd_1
XTAP_TAPCELL_ROW_160_3462 VSS VDD sky130_fd_sc_hd__tapvpwrvgnd_1
XTAP_TAPCELL_ROW_160_3463 VSS VDD sky130_fd_sc_hd__tapvpwrvgnd_1
XTAP_TAPCELL_ROW_160_3464 VSS VDD sky130_fd_sc_hd__tapvpwrvgnd_1
XTAP_TAPCELL_ROW_160_3465 VSS VDD sky130_fd_sc_hd__tapvpwrvgnd_1
XTAP_TAPCELL_ROW_160_3466 VSS VDD sky130_fd_sc_hd__tapvpwrvgnd_1
XTAP_TAPCELL_ROW_160_3467 VSS VDD sky130_fd_sc_hd__tapvpwrvgnd_1
XTAP_TAPCELL_ROW_160_3468 VSS VDD sky130_fd_sc_hd__tapvpwrvgnd_1
XTAP_TAPCELL_ROW_160_3469 VSS VDD sky130_fd_sc_hd__tapvpwrvgnd_1
XTAP_TAPCELL_ROW_160_3470 VSS VDD sky130_fd_sc_hd__tapvpwrvgnd_1
XTAP_TAPCELL_ROW_160_3471 VSS VDD sky130_fd_sc_hd__tapvpwrvgnd_1
XTAP_TAPCELL_ROW_160_3472 VSS VDD sky130_fd_sc_hd__tapvpwrvgnd_1
XTAP_TAPCELL_ROW_160_3473 VSS VDD sky130_fd_sc_hd__tapvpwrvgnd_1
XTAP_TAPCELL_ROW_160_3474 VSS VDD sky130_fd_sc_hd__tapvpwrvgnd_1
XTAP_TAPCELL_ROW_160_3475 VSS VDD sky130_fd_sc_hd__tapvpwrvgnd_1
XTAP_TAPCELL_ROW_160_3476 VSS VDD sky130_fd_sc_hd__tapvpwrvgnd_1
XTAP_TAPCELL_ROW_160_3477 VSS VDD sky130_fd_sc_hd__tapvpwrvgnd_1
XTAP_TAPCELL_ROW_160_3478 VSS VDD sky130_fd_sc_hd__tapvpwrvgnd_1
XTAP_TAPCELL_ROW_160_3479 VSS VDD sky130_fd_sc_hd__tapvpwrvgnd_1
XTAP_TAPCELL_ROW_160_3480 VSS VDD sky130_fd_sc_hd__tapvpwrvgnd_1
XTAP_TAPCELL_ROW_160_3481 VSS VDD sky130_fd_sc_hd__tapvpwrvgnd_1
XTAP_TAPCELL_ROW_160_3482 VSS VDD sky130_fd_sc_hd__tapvpwrvgnd_1
XTAP_TAPCELL_ROW_161_3483 VSS VDD sky130_fd_sc_hd__tapvpwrvgnd_1
XTAP_TAPCELL_ROW_161_3484 VSS VDD sky130_fd_sc_hd__tapvpwrvgnd_1
XTAP_TAPCELL_ROW_161_3485 VSS VDD sky130_fd_sc_hd__tapvpwrvgnd_1
XTAP_TAPCELL_ROW_161_3486 VSS VDD sky130_fd_sc_hd__tapvpwrvgnd_1
XTAP_TAPCELL_ROW_161_3487 VSS VDD sky130_fd_sc_hd__tapvpwrvgnd_1
XTAP_TAPCELL_ROW_161_3488 VSS VDD sky130_fd_sc_hd__tapvpwrvgnd_1
XTAP_TAPCELL_ROW_161_3489 VSS VDD sky130_fd_sc_hd__tapvpwrvgnd_1
XTAP_TAPCELL_ROW_161_3490 VSS VDD sky130_fd_sc_hd__tapvpwrvgnd_1
XTAP_TAPCELL_ROW_161_3491 VSS VDD sky130_fd_sc_hd__tapvpwrvgnd_1
XTAP_TAPCELL_ROW_161_3492 VSS VDD sky130_fd_sc_hd__tapvpwrvgnd_1
XTAP_TAPCELL_ROW_161_3493 VSS VDD sky130_fd_sc_hd__tapvpwrvgnd_1
XTAP_TAPCELL_ROW_161_3494 VSS VDD sky130_fd_sc_hd__tapvpwrvgnd_1
XTAP_TAPCELL_ROW_161_3495 VSS VDD sky130_fd_sc_hd__tapvpwrvgnd_1
XTAP_TAPCELL_ROW_161_3496 VSS VDD sky130_fd_sc_hd__tapvpwrvgnd_1
XTAP_TAPCELL_ROW_161_3497 VSS VDD sky130_fd_sc_hd__tapvpwrvgnd_1
XTAP_TAPCELL_ROW_161_3498 VSS VDD sky130_fd_sc_hd__tapvpwrvgnd_1
XTAP_TAPCELL_ROW_161_3499 VSS VDD sky130_fd_sc_hd__tapvpwrvgnd_1
XTAP_TAPCELL_ROW_161_3500 VSS VDD sky130_fd_sc_hd__tapvpwrvgnd_1
XTAP_TAPCELL_ROW_161_3501 VSS VDD sky130_fd_sc_hd__tapvpwrvgnd_1
XTAP_TAPCELL_ROW_161_3502 VSS VDD sky130_fd_sc_hd__tapvpwrvgnd_1
XTAP_TAPCELL_ROW_161_3503 VSS VDD sky130_fd_sc_hd__tapvpwrvgnd_1
XTAP_TAPCELL_ROW_162_3504 VSS VDD sky130_fd_sc_hd__tapvpwrvgnd_1
XTAP_TAPCELL_ROW_162_3505 VSS VDD sky130_fd_sc_hd__tapvpwrvgnd_1
XTAP_TAPCELL_ROW_162_3506 VSS VDD sky130_fd_sc_hd__tapvpwrvgnd_1
XTAP_TAPCELL_ROW_162_3507 VSS VDD sky130_fd_sc_hd__tapvpwrvgnd_1
XTAP_TAPCELL_ROW_162_3508 VSS VDD sky130_fd_sc_hd__tapvpwrvgnd_1
XTAP_TAPCELL_ROW_162_3509 VSS VDD sky130_fd_sc_hd__tapvpwrvgnd_1
XTAP_TAPCELL_ROW_162_3510 VSS VDD sky130_fd_sc_hd__tapvpwrvgnd_1
XTAP_TAPCELL_ROW_162_3511 VSS VDD sky130_fd_sc_hd__tapvpwrvgnd_1
XTAP_TAPCELL_ROW_162_3512 VSS VDD sky130_fd_sc_hd__tapvpwrvgnd_1
XTAP_TAPCELL_ROW_162_3513 VSS VDD sky130_fd_sc_hd__tapvpwrvgnd_1
XTAP_TAPCELL_ROW_162_3514 VSS VDD sky130_fd_sc_hd__tapvpwrvgnd_1
XTAP_TAPCELL_ROW_162_3515 VSS VDD sky130_fd_sc_hd__tapvpwrvgnd_1
XTAP_TAPCELL_ROW_162_3516 VSS VDD sky130_fd_sc_hd__tapvpwrvgnd_1
XTAP_TAPCELL_ROW_162_3517 VSS VDD sky130_fd_sc_hd__tapvpwrvgnd_1
XTAP_TAPCELL_ROW_162_3518 VSS VDD sky130_fd_sc_hd__tapvpwrvgnd_1
XTAP_TAPCELL_ROW_162_3519 VSS VDD sky130_fd_sc_hd__tapvpwrvgnd_1
XTAP_TAPCELL_ROW_162_3520 VSS VDD sky130_fd_sc_hd__tapvpwrvgnd_1
XTAP_TAPCELL_ROW_162_3521 VSS VDD sky130_fd_sc_hd__tapvpwrvgnd_1
XTAP_TAPCELL_ROW_162_3522 VSS VDD sky130_fd_sc_hd__tapvpwrvgnd_1
XTAP_TAPCELL_ROW_162_3523 VSS VDD sky130_fd_sc_hd__tapvpwrvgnd_1
XTAP_TAPCELL_ROW_162_3524 VSS VDD sky130_fd_sc_hd__tapvpwrvgnd_1
XTAP_TAPCELL_ROW_162_3525 VSS VDD sky130_fd_sc_hd__tapvpwrvgnd_1
XTAP_TAPCELL_ROW_163_3526 VSS VDD sky130_fd_sc_hd__tapvpwrvgnd_1
XTAP_TAPCELL_ROW_163_3527 VSS VDD sky130_fd_sc_hd__tapvpwrvgnd_1
XTAP_TAPCELL_ROW_163_3528 VSS VDD sky130_fd_sc_hd__tapvpwrvgnd_1
XTAP_TAPCELL_ROW_163_3529 VSS VDD sky130_fd_sc_hd__tapvpwrvgnd_1
XTAP_TAPCELL_ROW_163_3530 VSS VDD sky130_fd_sc_hd__tapvpwrvgnd_1
XTAP_TAPCELL_ROW_163_3531 VSS VDD sky130_fd_sc_hd__tapvpwrvgnd_1
XTAP_TAPCELL_ROW_163_3532 VSS VDD sky130_fd_sc_hd__tapvpwrvgnd_1
XTAP_TAPCELL_ROW_163_3533 VSS VDD sky130_fd_sc_hd__tapvpwrvgnd_1
XTAP_TAPCELL_ROW_163_3534 VSS VDD sky130_fd_sc_hd__tapvpwrvgnd_1
XTAP_TAPCELL_ROW_163_3535 VSS VDD sky130_fd_sc_hd__tapvpwrvgnd_1
XTAP_TAPCELL_ROW_163_3536 VSS VDD sky130_fd_sc_hd__tapvpwrvgnd_1
XTAP_TAPCELL_ROW_163_3537 VSS VDD sky130_fd_sc_hd__tapvpwrvgnd_1
XTAP_TAPCELL_ROW_163_3538 VSS VDD sky130_fd_sc_hd__tapvpwrvgnd_1
XTAP_TAPCELL_ROW_163_3539 VSS VDD sky130_fd_sc_hd__tapvpwrvgnd_1
XTAP_TAPCELL_ROW_163_3540 VSS VDD sky130_fd_sc_hd__tapvpwrvgnd_1
XTAP_TAPCELL_ROW_163_3541 VSS VDD sky130_fd_sc_hd__tapvpwrvgnd_1
XTAP_TAPCELL_ROW_163_3542 VSS VDD sky130_fd_sc_hd__tapvpwrvgnd_1
XTAP_TAPCELL_ROW_163_3543 VSS VDD sky130_fd_sc_hd__tapvpwrvgnd_1
XTAP_TAPCELL_ROW_163_3544 VSS VDD sky130_fd_sc_hd__tapvpwrvgnd_1
XTAP_TAPCELL_ROW_163_3545 VSS VDD sky130_fd_sc_hd__tapvpwrvgnd_1
XTAP_TAPCELL_ROW_163_3546 VSS VDD sky130_fd_sc_hd__tapvpwrvgnd_1
XTAP_TAPCELL_ROW_164_3547 VSS VDD sky130_fd_sc_hd__tapvpwrvgnd_1
XTAP_TAPCELL_ROW_164_3548 VSS VDD sky130_fd_sc_hd__tapvpwrvgnd_1
XTAP_TAPCELL_ROW_164_3549 VSS VDD sky130_fd_sc_hd__tapvpwrvgnd_1
XTAP_TAPCELL_ROW_164_3550 VSS VDD sky130_fd_sc_hd__tapvpwrvgnd_1
XTAP_TAPCELL_ROW_164_3551 VSS VDD sky130_fd_sc_hd__tapvpwrvgnd_1
XTAP_TAPCELL_ROW_164_3552 VSS VDD sky130_fd_sc_hd__tapvpwrvgnd_1
XTAP_TAPCELL_ROW_164_3553 VSS VDD sky130_fd_sc_hd__tapvpwrvgnd_1
XTAP_TAPCELL_ROW_164_3554 VSS VDD sky130_fd_sc_hd__tapvpwrvgnd_1
XTAP_TAPCELL_ROW_164_3555 VSS VDD sky130_fd_sc_hd__tapvpwrvgnd_1
XTAP_TAPCELL_ROW_164_3556 VSS VDD sky130_fd_sc_hd__tapvpwrvgnd_1
XTAP_TAPCELL_ROW_164_3557 VSS VDD sky130_fd_sc_hd__tapvpwrvgnd_1
XTAP_TAPCELL_ROW_164_3558 VSS VDD sky130_fd_sc_hd__tapvpwrvgnd_1
XTAP_TAPCELL_ROW_164_3559 VSS VDD sky130_fd_sc_hd__tapvpwrvgnd_1
XTAP_TAPCELL_ROW_164_3560 VSS VDD sky130_fd_sc_hd__tapvpwrvgnd_1
XTAP_TAPCELL_ROW_164_3561 VSS VDD sky130_fd_sc_hd__tapvpwrvgnd_1
XTAP_TAPCELL_ROW_164_3562 VSS VDD sky130_fd_sc_hd__tapvpwrvgnd_1
XTAP_TAPCELL_ROW_164_3563 VSS VDD sky130_fd_sc_hd__tapvpwrvgnd_1
XTAP_TAPCELL_ROW_164_3564 VSS VDD sky130_fd_sc_hd__tapvpwrvgnd_1
XTAP_TAPCELL_ROW_164_3565 VSS VDD sky130_fd_sc_hd__tapvpwrvgnd_1
XTAP_TAPCELL_ROW_164_3566 VSS VDD sky130_fd_sc_hd__tapvpwrvgnd_1
XTAP_TAPCELL_ROW_164_3567 VSS VDD sky130_fd_sc_hd__tapvpwrvgnd_1
XTAP_TAPCELL_ROW_164_3568 VSS VDD sky130_fd_sc_hd__tapvpwrvgnd_1
XTAP_TAPCELL_ROW_165_3569 VSS VDD sky130_fd_sc_hd__tapvpwrvgnd_1
XTAP_TAPCELL_ROW_165_3570 VSS VDD sky130_fd_sc_hd__tapvpwrvgnd_1
XTAP_TAPCELL_ROW_165_3571 VSS VDD sky130_fd_sc_hd__tapvpwrvgnd_1
XTAP_TAPCELL_ROW_165_3572 VSS VDD sky130_fd_sc_hd__tapvpwrvgnd_1
XTAP_TAPCELL_ROW_165_3573 VSS VDD sky130_fd_sc_hd__tapvpwrvgnd_1
XTAP_TAPCELL_ROW_165_3574 VSS VDD sky130_fd_sc_hd__tapvpwrvgnd_1
XTAP_TAPCELL_ROW_165_3575 VSS VDD sky130_fd_sc_hd__tapvpwrvgnd_1
XTAP_TAPCELL_ROW_165_3576 VSS VDD sky130_fd_sc_hd__tapvpwrvgnd_1
XTAP_TAPCELL_ROW_165_3577 VSS VDD sky130_fd_sc_hd__tapvpwrvgnd_1
XTAP_TAPCELL_ROW_165_3578 VSS VDD sky130_fd_sc_hd__tapvpwrvgnd_1
XTAP_TAPCELL_ROW_165_3579 VSS VDD sky130_fd_sc_hd__tapvpwrvgnd_1
XTAP_TAPCELL_ROW_165_3580 VSS VDD sky130_fd_sc_hd__tapvpwrvgnd_1
XTAP_TAPCELL_ROW_165_3581 VSS VDD sky130_fd_sc_hd__tapvpwrvgnd_1
XTAP_TAPCELL_ROW_165_3582 VSS VDD sky130_fd_sc_hd__tapvpwrvgnd_1
XTAP_TAPCELL_ROW_165_3583 VSS VDD sky130_fd_sc_hd__tapvpwrvgnd_1
XTAP_TAPCELL_ROW_165_3584 VSS VDD sky130_fd_sc_hd__tapvpwrvgnd_1
XTAP_TAPCELL_ROW_165_3585 VSS VDD sky130_fd_sc_hd__tapvpwrvgnd_1
XTAP_TAPCELL_ROW_165_3586 VSS VDD sky130_fd_sc_hd__tapvpwrvgnd_1
XTAP_TAPCELL_ROW_165_3587 VSS VDD sky130_fd_sc_hd__tapvpwrvgnd_1
XTAP_TAPCELL_ROW_165_3588 VSS VDD sky130_fd_sc_hd__tapvpwrvgnd_1
XTAP_TAPCELL_ROW_165_3589 VSS VDD sky130_fd_sc_hd__tapvpwrvgnd_1
XTAP_TAPCELL_ROW_166_3590 VSS VDD sky130_fd_sc_hd__tapvpwrvgnd_1
XTAP_TAPCELL_ROW_166_3591 VSS VDD sky130_fd_sc_hd__tapvpwrvgnd_1
XTAP_TAPCELL_ROW_166_3592 VSS VDD sky130_fd_sc_hd__tapvpwrvgnd_1
XTAP_TAPCELL_ROW_166_3593 VSS VDD sky130_fd_sc_hd__tapvpwrvgnd_1
XTAP_TAPCELL_ROW_166_3594 VSS VDD sky130_fd_sc_hd__tapvpwrvgnd_1
XTAP_TAPCELL_ROW_166_3595 VSS VDD sky130_fd_sc_hd__tapvpwrvgnd_1
XTAP_TAPCELL_ROW_166_3596 VSS VDD sky130_fd_sc_hd__tapvpwrvgnd_1
XTAP_TAPCELL_ROW_166_3597 VSS VDD sky130_fd_sc_hd__tapvpwrvgnd_1
XTAP_TAPCELL_ROW_166_3598 VSS VDD sky130_fd_sc_hd__tapvpwrvgnd_1
XTAP_TAPCELL_ROW_166_3599 VSS VDD sky130_fd_sc_hd__tapvpwrvgnd_1
XTAP_TAPCELL_ROW_166_3600 VSS VDD sky130_fd_sc_hd__tapvpwrvgnd_1
XTAP_TAPCELL_ROW_166_3601 VSS VDD sky130_fd_sc_hd__tapvpwrvgnd_1
XTAP_TAPCELL_ROW_166_3602 VSS VDD sky130_fd_sc_hd__tapvpwrvgnd_1
XTAP_TAPCELL_ROW_166_3603 VSS VDD sky130_fd_sc_hd__tapvpwrvgnd_1
XTAP_TAPCELL_ROW_166_3604 VSS VDD sky130_fd_sc_hd__tapvpwrvgnd_1
XTAP_TAPCELL_ROW_166_3605 VSS VDD sky130_fd_sc_hd__tapvpwrvgnd_1
XTAP_TAPCELL_ROW_166_3606 VSS VDD sky130_fd_sc_hd__tapvpwrvgnd_1
XTAP_TAPCELL_ROW_166_3607 VSS VDD sky130_fd_sc_hd__tapvpwrvgnd_1
XTAP_TAPCELL_ROW_166_3608 VSS VDD sky130_fd_sc_hd__tapvpwrvgnd_1
XTAP_TAPCELL_ROW_166_3609 VSS VDD sky130_fd_sc_hd__tapvpwrvgnd_1
XTAP_TAPCELL_ROW_166_3610 VSS VDD sky130_fd_sc_hd__tapvpwrvgnd_1
XTAP_TAPCELL_ROW_166_3611 VSS VDD sky130_fd_sc_hd__tapvpwrvgnd_1
XTAP_TAPCELL_ROW_167_3612 VSS VDD sky130_fd_sc_hd__tapvpwrvgnd_1
XTAP_TAPCELL_ROW_167_3613 VSS VDD sky130_fd_sc_hd__tapvpwrvgnd_1
XTAP_TAPCELL_ROW_167_3614 VSS VDD sky130_fd_sc_hd__tapvpwrvgnd_1
XTAP_TAPCELL_ROW_167_3615 VSS VDD sky130_fd_sc_hd__tapvpwrvgnd_1
XTAP_TAPCELL_ROW_167_3616 VSS VDD sky130_fd_sc_hd__tapvpwrvgnd_1
XTAP_TAPCELL_ROW_167_3617 VSS VDD sky130_fd_sc_hd__tapvpwrvgnd_1
XTAP_TAPCELL_ROW_167_3618 VSS VDD sky130_fd_sc_hd__tapvpwrvgnd_1
XTAP_TAPCELL_ROW_167_3619 VSS VDD sky130_fd_sc_hd__tapvpwrvgnd_1
XTAP_TAPCELL_ROW_167_3620 VSS VDD sky130_fd_sc_hd__tapvpwrvgnd_1
XTAP_TAPCELL_ROW_167_3621 VSS VDD sky130_fd_sc_hd__tapvpwrvgnd_1
XTAP_TAPCELL_ROW_167_3622 VSS VDD sky130_fd_sc_hd__tapvpwrvgnd_1
XTAP_TAPCELL_ROW_167_3623 VSS VDD sky130_fd_sc_hd__tapvpwrvgnd_1
XTAP_TAPCELL_ROW_167_3624 VSS VDD sky130_fd_sc_hd__tapvpwrvgnd_1
XTAP_TAPCELL_ROW_167_3625 VSS VDD sky130_fd_sc_hd__tapvpwrvgnd_1
XTAP_TAPCELL_ROW_167_3626 VSS VDD sky130_fd_sc_hd__tapvpwrvgnd_1
XTAP_TAPCELL_ROW_167_3627 VSS VDD sky130_fd_sc_hd__tapvpwrvgnd_1
XTAP_TAPCELL_ROW_167_3628 VSS VDD sky130_fd_sc_hd__tapvpwrvgnd_1
XTAP_TAPCELL_ROW_167_3629 VSS VDD sky130_fd_sc_hd__tapvpwrvgnd_1
XTAP_TAPCELL_ROW_167_3630 VSS VDD sky130_fd_sc_hd__tapvpwrvgnd_1
XTAP_TAPCELL_ROW_167_3631 VSS VDD sky130_fd_sc_hd__tapvpwrvgnd_1
XTAP_TAPCELL_ROW_167_3632 VSS VDD sky130_fd_sc_hd__tapvpwrvgnd_1
XTAP_TAPCELL_ROW_168_3633 VSS VDD sky130_fd_sc_hd__tapvpwrvgnd_1
XTAP_TAPCELL_ROW_168_3634 VSS VDD sky130_fd_sc_hd__tapvpwrvgnd_1
XTAP_TAPCELL_ROW_168_3635 VSS VDD sky130_fd_sc_hd__tapvpwrvgnd_1
XTAP_TAPCELL_ROW_168_3636 VSS VDD sky130_fd_sc_hd__tapvpwrvgnd_1
XTAP_TAPCELL_ROW_168_3637 VSS VDD sky130_fd_sc_hd__tapvpwrvgnd_1
XTAP_TAPCELL_ROW_168_3638 VSS VDD sky130_fd_sc_hd__tapvpwrvgnd_1
XTAP_TAPCELL_ROW_168_3639 VSS VDD sky130_fd_sc_hd__tapvpwrvgnd_1
XTAP_TAPCELL_ROW_168_3640 VSS VDD sky130_fd_sc_hd__tapvpwrvgnd_1
XTAP_TAPCELL_ROW_168_3641 VSS VDD sky130_fd_sc_hd__tapvpwrvgnd_1
XTAP_TAPCELL_ROW_168_3642 VSS VDD sky130_fd_sc_hd__tapvpwrvgnd_1
XTAP_TAPCELL_ROW_168_3643 VSS VDD sky130_fd_sc_hd__tapvpwrvgnd_1
XTAP_TAPCELL_ROW_168_3644 VSS VDD sky130_fd_sc_hd__tapvpwrvgnd_1
XTAP_TAPCELL_ROW_168_3645 VSS VDD sky130_fd_sc_hd__tapvpwrvgnd_1
XTAP_TAPCELL_ROW_168_3646 VSS VDD sky130_fd_sc_hd__tapvpwrvgnd_1
XTAP_TAPCELL_ROW_168_3647 VSS VDD sky130_fd_sc_hd__tapvpwrvgnd_1
XTAP_TAPCELL_ROW_168_3648 VSS VDD sky130_fd_sc_hd__tapvpwrvgnd_1
XTAP_TAPCELL_ROW_168_3649 VSS VDD sky130_fd_sc_hd__tapvpwrvgnd_1
XTAP_TAPCELL_ROW_168_3650 VSS VDD sky130_fd_sc_hd__tapvpwrvgnd_1
XTAP_TAPCELL_ROW_168_3651 VSS VDD sky130_fd_sc_hd__tapvpwrvgnd_1
XTAP_TAPCELL_ROW_168_3652 VSS VDD sky130_fd_sc_hd__tapvpwrvgnd_1
XTAP_TAPCELL_ROW_168_3653 VSS VDD sky130_fd_sc_hd__tapvpwrvgnd_1
XTAP_TAPCELL_ROW_168_3654 VSS VDD sky130_fd_sc_hd__tapvpwrvgnd_1
XTAP_TAPCELL_ROW_169_3655 VSS VDD sky130_fd_sc_hd__tapvpwrvgnd_1
XTAP_TAPCELL_ROW_169_3656 VSS VDD sky130_fd_sc_hd__tapvpwrvgnd_1
XTAP_TAPCELL_ROW_169_3657 VSS VDD sky130_fd_sc_hd__tapvpwrvgnd_1
XTAP_TAPCELL_ROW_169_3658 VSS VDD sky130_fd_sc_hd__tapvpwrvgnd_1
XTAP_TAPCELL_ROW_169_3659 VSS VDD sky130_fd_sc_hd__tapvpwrvgnd_1
XTAP_TAPCELL_ROW_169_3660 VSS VDD sky130_fd_sc_hd__tapvpwrvgnd_1
XTAP_TAPCELL_ROW_169_3661 VSS VDD sky130_fd_sc_hd__tapvpwrvgnd_1
XTAP_TAPCELL_ROW_169_3662 VSS VDD sky130_fd_sc_hd__tapvpwrvgnd_1
XTAP_TAPCELL_ROW_169_3663 VSS VDD sky130_fd_sc_hd__tapvpwrvgnd_1
XTAP_TAPCELL_ROW_169_3664 VSS VDD sky130_fd_sc_hd__tapvpwrvgnd_1
XTAP_TAPCELL_ROW_169_3665 VSS VDD sky130_fd_sc_hd__tapvpwrvgnd_1
XTAP_TAPCELL_ROW_169_3666 VSS VDD sky130_fd_sc_hd__tapvpwrvgnd_1
XTAP_TAPCELL_ROW_169_3667 VSS VDD sky130_fd_sc_hd__tapvpwrvgnd_1
XTAP_TAPCELL_ROW_169_3668 VSS VDD sky130_fd_sc_hd__tapvpwrvgnd_1
XTAP_TAPCELL_ROW_169_3669 VSS VDD sky130_fd_sc_hd__tapvpwrvgnd_1
XTAP_TAPCELL_ROW_169_3670 VSS VDD sky130_fd_sc_hd__tapvpwrvgnd_1
XTAP_TAPCELL_ROW_169_3671 VSS VDD sky130_fd_sc_hd__tapvpwrvgnd_1
XTAP_TAPCELL_ROW_169_3672 VSS VDD sky130_fd_sc_hd__tapvpwrvgnd_1
XTAP_TAPCELL_ROW_169_3673 VSS VDD sky130_fd_sc_hd__tapvpwrvgnd_1
XTAP_TAPCELL_ROW_169_3674 VSS VDD sky130_fd_sc_hd__tapvpwrvgnd_1
XTAP_TAPCELL_ROW_169_3675 VSS VDD sky130_fd_sc_hd__tapvpwrvgnd_1
XTAP_TAPCELL_ROW_170_3676 VSS VDD sky130_fd_sc_hd__tapvpwrvgnd_1
XTAP_TAPCELL_ROW_170_3677 VSS VDD sky130_fd_sc_hd__tapvpwrvgnd_1
XTAP_TAPCELL_ROW_170_3678 VSS VDD sky130_fd_sc_hd__tapvpwrvgnd_1
XTAP_TAPCELL_ROW_170_3679 VSS VDD sky130_fd_sc_hd__tapvpwrvgnd_1
XTAP_TAPCELL_ROW_170_3680 VSS VDD sky130_fd_sc_hd__tapvpwrvgnd_1
XTAP_TAPCELL_ROW_170_3681 VSS VDD sky130_fd_sc_hd__tapvpwrvgnd_1
XTAP_TAPCELL_ROW_170_3682 VSS VDD sky130_fd_sc_hd__tapvpwrvgnd_1
XTAP_TAPCELL_ROW_170_3683 VSS VDD sky130_fd_sc_hd__tapvpwrvgnd_1
XTAP_TAPCELL_ROW_170_3684 VSS VDD sky130_fd_sc_hd__tapvpwrvgnd_1
XTAP_TAPCELL_ROW_170_3685 VSS VDD sky130_fd_sc_hd__tapvpwrvgnd_1
XTAP_TAPCELL_ROW_170_3686 VSS VDD sky130_fd_sc_hd__tapvpwrvgnd_1
XTAP_TAPCELL_ROW_170_3687 VSS VDD sky130_fd_sc_hd__tapvpwrvgnd_1
XTAP_TAPCELL_ROW_170_3688 VSS VDD sky130_fd_sc_hd__tapvpwrvgnd_1
XTAP_TAPCELL_ROW_170_3689 VSS VDD sky130_fd_sc_hd__tapvpwrvgnd_1
XTAP_TAPCELL_ROW_170_3690 VSS VDD sky130_fd_sc_hd__tapvpwrvgnd_1
XTAP_TAPCELL_ROW_170_3691 VSS VDD sky130_fd_sc_hd__tapvpwrvgnd_1
XTAP_TAPCELL_ROW_170_3692 VSS VDD sky130_fd_sc_hd__tapvpwrvgnd_1
XTAP_TAPCELL_ROW_170_3693 VSS VDD sky130_fd_sc_hd__tapvpwrvgnd_1
XTAP_TAPCELL_ROW_170_3694 VSS VDD sky130_fd_sc_hd__tapvpwrvgnd_1
XTAP_TAPCELL_ROW_170_3695 VSS VDD sky130_fd_sc_hd__tapvpwrvgnd_1
XTAP_TAPCELL_ROW_170_3696 VSS VDD sky130_fd_sc_hd__tapvpwrvgnd_1
XTAP_TAPCELL_ROW_170_3697 VSS VDD sky130_fd_sc_hd__tapvpwrvgnd_1
XTAP_TAPCELL_ROW_171_3698 VSS VDD sky130_fd_sc_hd__tapvpwrvgnd_1
XTAP_TAPCELL_ROW_171_3699 VSS VDD sky130_fd_sc_hd__tapvpwrvgnd_1
XTAP_TAPCELL_ROW_171_3700 VSS VDD sky130_fd_sc_hd__tapvpwrvgnd_1
XTAP_TAPCELL_ROW_171_3701 VSS VDD sky130_fd_sc_hd__tapvpwrvgnd_1
XTAP_TAPCELL_ROW_171_3702 VSS VDD sky130_fd_sc_hd__tapvpwrvgnd_1
XTAP_TAPCELL_ROW_171_3703 VSS VDD sky130_fd_sc_hd__tapvpwrvgnd_1
XTAP_TAPCELL_ROW_171_3704 VSS VDD sky130_fd_sc_hd__tapvpwrvgnd_1
XTAP_TAPCELL_ROW_171_3705 VSS VDD sky130_fd_sc_hd__tapvpwrvgnd_1
XTAP_TAPCELL_ROW_171_3706 VSS VDD sky130_fd_sc_hd__tapvpwrvgnd_1
XTAP_TAPCELL_ROW_171_3707 VSS VDD sky130_fd_sc_hd__tapvpwrvgnd_1
XTAP_TAPCELL_ROW_171_3708 VSS VDD sky130_fd_sc_hd__tapvpwrvgnd_1
XTAP_TAPCELL_ROW_171_3709 VSS VDD sky130_fd_sc_hd__tapvpwrvgnd_1
XTAP_TAPCELL_ROW_171_3710 VSS VDD sky130_fd_sc_hd__tapvpwrvgnd_1
XTAP_TAPCELL_ROW_171_3711 VSS VDD sky130_fd_sc_hd__tapvpwrvgnd_1
XTAP_TAPCELL_ROW_171_3712 VSS VDD sky130_fd_sc_hd__tapvpwrvgnd_1
XTAP_TAPCELL_ROW_171_3713 VSS VDD sky130_fd_sc_hd__tapvpwrvgnd_1
XTAP_TAPCELL_ROW_171_3714 VSS VDD sky130_fd_sc_hd__tapvpwrvgnd_1
XTAP_TAPCELL_ROW_171_3715 VSS VDD sky130_fd_sc_hd__tapvpwrvgnd_1
XTAP_TAPCELL_ROW_171_3716 VSS VDD sky130_fd_sc_hd__tapvpwrvgnd_1
XTAP_TAPCELL_ROW_171_3717 VSS VDD sky130_fd_sc_hd__tapvpwrvgnd_1
XTAP_TAPCELL_ROW_171_3718 VSS VDD sky130_fd_sc_hd__tapvpwrvgnd_1
XTAP_TAPCELL_ROW_172_3719 VSS VDD sky130_fd_sc_hd__tapvpwrvgnd_1
XTAP_TAPCELL_ROW_172_3720 VSS VDD sky130_fd_sc_hd__tapvpwrvgnd_1
XTAP_TAPCELL_ROW_172_3721 VSS VDD sky130_fd_sc_hd__tapvpwrvgnd_1
XTAP_TAPCELL_ROW_172_3722 VSS VDD sky130_fd_sc_hd__tapvpwrvgnd_1
XTAP_TAPCELL_ROW_172_3723 VSS VDD sky130_fd_sc_hd__tapvpwrvgnd_1
XTAP_TAPCELL_ROW_172_3724 VSS VDD sky130_fd_sc_hd__tapvpwrvgnd_1
XTAP_TAPCELL_ROW_172_3725 VSS VDD sky130_fd_sc_hd__tapvpwrvgnd_1
XTAP_TAPCELL_ROW_172_3726 VSS VDD sky130_fd_sc_hd__tapvpwrvgnd_1
XTAP_TAPCELL_ROW_172_3727 VSS VDD sky130_fd_sc_hd__tapvpwrvgnd_1
XTAP_TAPCELL_ROW_172_3728 VSS VDD sky130_fd_sc_hd__tapvpwrvgnd_1
XTAP_TAPCELL_ROW_172_3729 VSS VDD sky130_fd_sc_hd__tapvpwrvgnd_1
XTAP_TAPCELL_ROW_172_3730 VSS VDD sky130_fd_sc_hd__tapvpwrvgnd_1
XTAP_TAPCELL_ROW_172_3731 VSS VDD sky130_fd_sc_hd__tapvpwrvgnd_1
XTAP_TAPCELL_ROW_172_3732 VSS VDD sky130_fd_sc_hd__tapvpwrvgnd_1
XTAP_TAPCELL_ROW_172_3733 VSS VDD sky130_fd_sc_hd__tapvpwrvgnd_1
XTAP_TAPCELL_ROW_172_3734 VSS VDD sky130_fd_sc_hd__tapvpwrvgnd_1
XTAP_TAPCELL_ROW_172_3735 VSS VDD sky130_fd_sc_hd__tapvpwrvgnd_1
XTAP_TAPCELL_ROW_172_3736 VSS VDD sky130_fd_sc_hd__tapvpwrvgnd_1
XTAP_TAPCELL_ROW_172_3737 VSS VDD sky130_fd_sc_hd__tapvpwrvgnd_1
XTAP_TAPCELL_ROW_172_3738 VSS VDD sky130_fd_sc_hd__tapvpwrvgnd_1
XTAP_TAPCELL_ROW_172_3739 VSS VDD sky130_fd_sc_hd__tapvpwrvgnd_1
XTAP_TAPCELL_ROW_172_3740 VSS VDD sky130_fd_sc_hd__tapvpwrvgnd_1
XTAP_TAPCELL_ROW_173_3741 VSS VDD sky130_fd_sc_hd__tapvpwrvgnd_1
XTAP_TAPCELL_ROW_173_3742 VSS VDD sky130_fd_sc_hd__tapvpwrvgnd_1
XTAP_TAPCELL_ROW_173_3743 VSS VDD sky130_fd_sc_hd__tapvpwrvgnd_1
XTAP_TAPCELL_ROW_173_3744 VSS VDD sky130_fd_sc_hd__tapvpwrvgnd_1
XTAP_TAPCELL_ROW_173_3745 VSS VDD sky130_fd_sc_hd__tapvpwrvgnd_1
XTAP_TAPCELL_ROW_173_3746 VSS VDD sky130_fd_sc_hd__tapvpwrvgnd_1
XTAP_TAPCELL_ROW_173_3747 VSS VDD sky130_fd_sc_hd__tapvpwrvgnd_1
XTAP_TAPCELL_ROW_173_3748 VSS VDD sky130_fd_sc_hd__tapvpwrvgnd_1
XTAP_TAPCELL_ROW_173_3749 VSS VDD sky130_fd_sc_hd__tapvpwrvgnd_1
XTAP_TAPCELL_ROW_173_3750 VSS VDD sky130_fd_sc_hd__tapvpwrvgnd_1
XTAP_TAPCELL_ROW_173_3751 VSS VDD sky130_fd_sc_hd__tapvpwrvgnd_1
XTAP_TAPCELL_ROW_173_3752 VSS VDD sky130_fd_sc_hd__tapvpwrvgnd_1
XTAP_TAPCELL_ROW_173_3753 VSS VDD sky130_fd_sc_hd__tapvpwrvgnd_1
XTAP_TAPCELL_ROW_173_3754 VSS VDD sky130_fd_sc_hd__tapvpwrvgnd_1
XTAP_TAPCELL_ROW_173_3755 VSS VDD sky130_fd_sc_hd__tapvpwrvgnd_1
XTAP_TAPCELL_ROW_173_3756 VSS VDD sky130_fd_sc_hd__tapvpwrvgnd_1
XTAP_TAPCELL_ROW_173_3757 VSS VDD sky130_fd_sc_hd__tapvpwrvgnd_1
XTAP_TAPCELL_ROW_173_3758 VSS VDD sky130_fd_sc_hd__tapvpwrvgnd_1
XTAP_TAPCELL_ROW_173_3759 VSS VDD sky130_fd_sc_hd__tapvpwrvgnd_1
XTAP_TAPCELL_ROW_173_3760 VSS VDD sky130_fd_sc_hd__tapvpwrvgnd_1
XTAP_TAPCELL_ROW_173_3761 VSS VDD sky130_fd_sc_hd__tapvpwrvgnd_1
XTAP_TAPCELL_ROW_174_3762 VSS VDD sky130_fd_sc_hd__tapvpwrvgnd_1
XTAP_TAPCELL_ROW_174_3763 VSS VDD sky130_fd_sc_hd__tapvpwrvgnd_1
XTAP_TAPCELL_ROW_174_3764 VSS VDD sky130_fd_sc_hd__tapvpwrvgnd_1
XTAP_TAPCELL_ROW_174_3765 VSS VDD sky130_fd_sc_hd__tapvpwrvgnd_1
XTAP_TAPCELL_ROW_174_3766 VSS VDD sky130_fd_sc_hd__tapvpwrvgnd_1
XTAP_TAPCELL_ROW_174_3767 VSS VDD sky130_fd_sc_hd__tapvpwrvgnd_1
XTAP_TAPCELL_ROW_174_3768 VSS VDD sky130_fd_sc_hd__tapvpwrvgnd_1
XTAP_TAPCELL_ROW_174_3769 VSS VDD sky130_fd_sc_hd__tapvpwrvgnd_1
XTAP_TAPCELL_ROW_174_3770 VSS VDD sky130_fd_sc_hd__tapvpwrvgnd_1
XTAP_TAPCELL_ROW_174_3771 VSS VDD sky130_fd_sc_hd__tapvpwrvgnd_1
XTAP_TAPCELL_ROW_174_3772 VSS VDD sky130_fd_sc_hd__tapvpwrvgnd_1
XTAP_TAPCELL_ROW_174_3773 VSS VDD sky130_fd_sc_hd__tapvpwrvgnd_1
XTAP_TAPCELL_ROW_174_3774 VSS VDD sky130_fd_sc_hd__tapvpwrvgnd_1
XTAP_TAPCELL_ROW_174_3775 VSS VDD sky130_fd_sc_hd__tapvpwrvgnd_1
XTAP_TAPCELL_ROW_174_3776 VSS VDD sky130_fd_sc_hd__tapvpwrvgnd_1
XTAP_TAPCELL_ROW_174_3777 VSS VDD sky130_fd_sc_hd__tapvpwrvgnd_1
XTAP_TAPCELL_ROW_174_3778 VSS VDD sky130_fd_sc_hd__tapvpwrvgnd_1
XTAP_TAPCELL_ROW_174_3779 VSS VDD sky130_fd_sc_hd__tapvpwrvgnd_1
XTAP_TAPCELL_ROW_174_3780 VSS VDD sky130_fd_sc_hd__tapvpwrvgnd_1
XTAP_TAPCELL_ROW_174_3781 VSS VDD sky130_fd_sc_hd__tapvpwrvgnd_1
XTAP_TAPCELL_ROW_174_3782 VSS VDD sky130_fd_sc_hd__tapvpwrvgnd_1
XTAP_TAPCELL_ROW_174_3783 VSS VDD sky130_fd_sc_hd__tapvpwrvgnd_1
XTAP_TAPCELL_ROW_175_3784 VSS VDD sky130_fd_sc_hd__tapvpwrvgnd_1
XTAP_TAPCELL_ROW_175_3785 VSS VDD sky130_fd_sc_hd__tapvpwrvgnd_1
XTAP_TAPCELL_ROW_175_3786 VSS VDD sky130_fd_sc_hd__tapvpwrvgnd_1
XTAP_TAPCELL_ROW_175_3787 VSS VDD sky130_fd_sc_hd__tapvpwrvgnd_1
XTAP_TAPCELL_ROW_175_3788 VSS VDD sky130_fd_sc_hd__tapvpwrvgnd_1
XTAP_TAPCELL_ROW_175_3789 VSS VDD sky130_fd_sc_hd__tapvpwrvgnd_1
XTAP_TAPCELL_ROW_175_3790 VSS VDD sky130_fd_sc_hd__tapvpwrvgnd_1
XTAP_TAPCELL_ROW_175_3791 VSS VDD sky130_fd_sc_hd__tapvpwrvgnd_1
XTAP_TAPCELL_ROW_175_3792 VSS VDD sky130_fd_sc_hd__tapvpwrvgnd_1
XTAP_TAPCELL_ROW_175_3793 VSS VDD sky130_fd_sc_hd__tapvpwrvgnd_1
XTAP_TAPCELL_ROW_175_3794 VSS VDD sky130_fd_sc_hd__tapvpwrvgnd_1
XTAP_TAPCELL_ROW_175_3795 VSS VDD sky130_fd_sc_hd__tapvpwrvgnd_1
XTAP_TAPCELL_ROW_175_3796 VSS VDD sky130_fd_sc_hd__tapvpwrvgnd_1
XTAP_TAPCELL_ROW_175_3797 VSS VDD sky130_fd_sc_hd__tapvpwrvgnd_1
XTAP_TAPCELL_ROW_175_3798 VSS VDD sky130_fd_sc_hd__tapvpwrvgnd_1
XTAP_TAPCELL_ROW_175_3799 VSS VDD sky130_fd_sc_hd__tapvpwrvgnd_1
XTAP_TAPCELL_ROW_175_3800 VSS VDD sky130_fd_sc_hd__tapvpwrvgnd_1
XTAP_TAPCELL_ROW_175_3801 VSS VDD sky130_fd_sc_hd__tapvpwrvgnd_1
XTAP_TAPCELL_ROW_175_3802 VSS VDD sky130_fd_sc_hd__tapvpwrvgnd_1
XTAP_TAPCELL_ROW_175_3803 VSS VDD sky130_fd_sc_hd__tapvpwrvgnd_1
XTAP_TAPCELL_ROW_175_3804 VSS VDD sky130_fd_sc_hd__tapvpwrvgnd_1
XTAP_TAPCELL_ROW_176_3805 VSS VDD sky130_fd_sc_hd__tapvpwrvgnd_1
XTAP_TAPCELL_ROW_176_3806 VSS VDD sky130_fd_sc_hd__tapvpwrvgnd_1
XTAP_TAPCELL_ROW_176_3807 VSS VDD sky130_fd_sc_hd__tapvpwrvgnd_1
XTAP_TAPCELL_ROW_176_3808 VSS VDD sky130_fd_sc_hd__tapvpwrvgnd_1
XTAP_TAPCELL_ROW_176_3809 VSS VDD sky130_fd_sc_hd__tapvpwrvgnd_1
XTAP_TAPCELL_ROW_176_3810 VSS VDD sky130_fd_sc_hd__tapvpwrvgnd_1
XTAP_TAPCELL_ROW_176_3811 VSS VDD sky130_fd_sc_hd__tapvpwrvgnd_1
XTAP_TAPCELL_ROW_176_3812 VSS VDD sky130_fd_sc_hd__tapvpwrvgnd_1
XTAP_TAPCELL_ROW_176_3813 VSS VDD sky130_fd_sc_hd__tapvpwrvgnd_1
XTAP_TAPCELL_ROW_176_3814 VSS VDD sky130_fd_sc_hd__tapvpwrvgnd_1
XTAP_TAPCELL_ROW_176_3815 VSS VDD sky130_fd_sc_hd__tapvpwrvgnd_1
XTAP_TAPCELL_ROW_176_3816 VSS VDD sky130_fd_sc_hd__tapvpwrvgnd_1
XTAP_TAPCELL_ROW_176_3817 VSS VDD sky130_fd_sc_hd__tapvpwrvgnd_1
XTAP_TAPCELL_ROW_176_3818 VSS VDD sky130_fd_sc_hd__tapvpwrvgnd_1
XTAP_TAPCELL_ROW_176_3819 VSS VDD sky130_fd_sc_hd__tapvpwrvgnd_1
XTAP_TAPCELL_ROW_176_3820 VSS VDD sky130_fd_sc_hd__tapvpwrvgnd_1
XTAP_TAPCELL_ROW_176_3821 VSS VDD sky130_fd_sc_hd__tapvpwrvgnd_1
XTAP_TAPCELL_ROW_176_3822 VSS VDD sky130_fd_sc_hd__tapvpwrvgnd_1
XTAP_TAPCELL_ROW_176_3823 VSS VDD sky130_fd_sc_hd__tapvpwrvgnd_1
XTAP_TAPCELL_ROW_176_3824 VSS VDD sky130_fd_sc_hd__tapvpwrvgnd_1
XTAP_TAPCELL_ROW_176_3825 VSS VDD sky130_fd_sc_hd__tapvpwrvgnd_1
XTAP_TAPCELL_ROW_176_3826 VSS VDD sky130_fd_sc_hd__tapvpwrvgnd_1
XTAP_TAPCELL_ROW_177_3827 VSS VDD sky130_fd_sc_hd__tapvpwrvgnd_1
XTAP_TAPCELL_ROW_177_3828 VSS VDD sky130_fd_sc_hd__tapvpwrvgnd_1
XTAP_TAPCELL_ROW_177_3829 VSS VDD sky130_fd_sc_hd__tapvpwrvgnd_1
XTAP_TAPCELL_ROW_177_3830 VSS VDD sky130_fd_sc_hd__tapvpwrvgnd_1
XTAP_TAPCELL_ROW_177_3831 VSS VDD sky130_fd_sc_hd__tapvpwrvgnd_1
XTAP_TAPCELL_ROW_177_3832 VSS VDD sky130_fd_sc_hd__tapvpwrvgnd_1
XTAP_TAPCELL_ROW_177_3833 VSS VDD sky130_fd_sc_hd__tapvpwrvgnd_1
XTAP_TAPCELL_ROW_177_3834 VSS VDD sky130_fd_sc_hd__tapvpwrvgnd_1
XTAP_TAPCELL_ROW_177_3835 VSS VDD sky130_fd_sc_hd__tapvpwrvgnd_1
XTAP_TAPCELL_ROW_177_3836 VSS VDD sky130_fd_sc_hd__tapvpwrvgnd_1
XTAP_TAPCELL_ROW_177_3837 VSS VDD sky130_fd_sc_hd__tapvpwrvgnd_1
XTAP_TAPCELL_ROW_177_3838 VSS VDD sky130_fd_sc_hd__tapvpwrvgnd_1
XTAP_TAPCELL_ROW_177_3839 VSS VDD sky130_fd_sc_hd__tapvpwrvgnd_1
XTAP_TAPCELL_ROW_177_3840 VSS VDD sky130_fd_sc_hd__tapvpwrvgnd_1
XTAP_TAPCELL_ROW_177_3841 VSS VDD sky130_fd_sc_hd__tapvpwrvgnd_1
XTAP_TAPCELL_ROW_177_3842 VSS VDD sky130_fd_sc_hd__tapvpwrvgnd_1
XTAP_TAPCELL_ROW_177_3843 VSS VDD sky130_fd_sc_hd__tapvpwrvgnd_1
XTAP_TAPCELL_ROW_177_3844 VSS VDD sky130_fd_sc_hd__tapvpwrvgnd_1
XTAP_TAPCELL_ROW_177_3845 VSS VDD sky130_fd_sc_hd__tapvpwrvgnd_1
XTAP_TAPCELL_ROW_177_3846 VSS VDD sky130_fd_sc_hd__tapvpwrvgnd_1
XTAP_TAPCELL_ROW_177_3847 VSS VDD sky130_fd_sc_hd__tapvpwrvgnd_1
XTAP_TAPCELL_ROW_178_3848 VSS VDD sky130_fd_sc_hd__tapvpwrvgnd_1
XTAP_TAPCELL_ROW_178_3849 VSS VDD sky130_fd_sc_hd__tapvpwrvgnd_1
XTAP_TAPCELL_ROW_178_3850 VSS VDD sky130_fd_sc_hd__tapvpwrvgnd_1
XTAP_TAPCELL_ROW_178_3851 VSS VDD sky130_fd_sc_hd__tapvpwrvgnd_1
XTAP_TAPCELL_ROW_178_3852 VSS VDD sky130_fd_sc_hd__tapvpwrvgnd_1
XTAP_TAPCELL_ROW_178_3853 VSS VDD sky130_fd_sc_hd__tapvpwrvgnd_1
XTAP_TAPCELL_ROW_178_3854 VSS VDD sky130_fd_sc_hd__tapvpwrvgnd_1
XTAP_TAPCELL_ROW_178_3855 VSS VDD sky130_fd_sc_hd__tapvpwrvgnd_1
XTAP_TAPCELL_ROW_178_3856 VSS VDD sky130_fd_sc_hd__tapvpwrvgnd_1
XTAP_TAPCELL_ROW_178_3857 VSS VDD sky130_fd_sc_hd__tapvpwrvgnd_1
XTAP_TAPCELL_ROW_178_3858 VSS VDD sky130_fd_sc_hd__tapvpwrvgnd_1
XTAP_TAPCELL_ROW_178_3859 VSS VDD sky130_fd_sc_hd__tapvpwrvgnd_1
XTAP_TAPCELL_ROW_178_3860 VSS VDD sky130_fd_sc_hd__tapvpwrvgnd_1
XTAP_TAPCELL_ROW_178_3861 VSS VDD sky130_fd_sc_hd__tapvpwrvgnd_1
XTAP_TAPCELL_ROW_178_3862 VSS VDD sky130_fd_sc_hd__tapvpwrvgnd_1
XTAP_TAPCELL_ROW_178_3863 VSS VDD sky130_fd_sc_hd__tapvpwrvgnd_1
XTAP_TAPCELL_ROW_178_3864 VSS VDD sky130_fd_sc_hd__tapvpwrvgnd_1
XTAP_TAPCELL_ROW_178_3865 VSS VDD sky130_fd_sc_hd__tapvpwrvgnd_1
XTAP_TAPCELL_ROW_178_3866 VSS VDD sky130_fd_sc_hd__tapvpwrvgnd_1
XTAP_TAPCELL_ROW_178_3867 VSS VDD sky130_fd_sc_hd__tapvpwrvgnd_1
XTAP_TAPCELL_ROW_178_3868 VSS VDD sky130_fd_sc_hd__tapvpwrvgnd_1
XTAP_TAPCELL_ROW_178_3869 VSS VDD sky130_fd_sc_hd__tapvpwrvgnd_1
XTAP_TAPCELL_ROW_179_3870 VSS VDD sky130_fd_sc_hd__tapvpwrvgnd_1
XTAP_TAPCELL_ROW_179_3871 VSS VDD sky130_fd_sc_hd__tapvpwrvgnd_1
XTAP_TAPCELL_ROW_179_3872 VSS VDD sky130_fd_sc_hd__tapvpwrvgnd_1
XTAP_TAPCELL_ROW_179_3873 VSS VDD sky130_fd_sc_hd__tapvpwrvgnd_1
XTAP_TAPCELL_ROW_179_3874 VSS VDD sky130_fd_sc_hd__tapvpwrvgnd_1
XTAP_TAPCELL_ROW_179_3875 VSS VDD sky130_fd_sc_hd__tapvpwrvgnd_1
XTAP_TAPCELL_ROW_179_3876 VSS VDD sky130_fd_sc_hd__tapvpwrvgnd_1
XTAP_TAPCELL_ROW_179_3877 VSS VDD sky130_fd_sc_hd__tapvpwrvgnd_1
XTAP_TAPCELL_ROW_179_3878 VSS VDD sky130_fd_sc_hd__tapvpwrvgnd_1
XTAP_TAPCELL_ROW_179_3879 VSS VDD sky130_fd_sc_hd__tapvpwrvgnd_1
XTAP_TAPCELL_ROW_179_3880 VSS VDD sky130_fd_sc_hd__tapvpwrvgnd_1
XTAP_TAPCELL_ROW_179_3881 VSS VDD sky130_fd_sc_hd__tapvpwrvgnd_1
XTAP_TAPCELL_ROW_179_3882 VSS VDD sky130_fd_sc_hd__tapvpwrvgnd_1
XTAP_TAPCELL_ROW_179_3883 VSS VDD sky130_fd_sc_hd__tapvpwrvgnd_1
XTAP_TAPCELL_ROW_179_3884 VSS VDD sky130_fd_sc_hd__tapvpwrvgnd_1
XTAP_TAPCELL_ROW_179_3885 VSS VDD sky130_fd_sc_hd__tapvpwrvgnd_1
XTAP_TAPCELL_ROW_179_3886 VSS VDD sky130_fd_sc_hd__tapvpwrvgnd_1
XTAP_TAPCELL_ROW_179_3887 VSS VDD sky130_fd_sc_hd__tapvpwrvgnd_1
XTAP_TAPCELL_ROW_179_3888 VSS VDD sky130_fd_sc_hd__tapvpwrvgnd_1
XTAP_TAPCELL_ROW_179_3889 VSS VDD sky130_fd_sc_hd__tapvpwrvgnd_1
XTAP_TAPCELL_ROW_179_3890 VSS VDD sky130_fd_sc_hd__tapvpwrvgnd_1
XTAP_TAPCELL_ROW_180_3891 VSS VDD sky130_fd_sc_hd__tapvpwrvgnd_1
XTAP_TAPCELL_ROW_180_3892 VSS VDD sky130_fd_sc_hd__tapvpwrvgnd_1
XTAP_TAPCELL_ROW_180_3893 VSS VDD sky130_fd_sc_hd__tapvpwrvgnd_1
XTAP_TAPCELL_ROW_180_3894 VSS VDD sky130_fd_sc_hd__tapvpwrvgnd_1
XTAP_TAPCELL_ROW_180_3895 VSS VDD sky130_fd_sc_hd__tapvpwrvgnd_1
XTAP_TAPCELL_ROW_180_3896 VSS VDD sky130_fd_sc_hd__tapvpwrvgnd_1
XTAP_TAPCELL_ROW_180_3897 VSS VDD sky130_fd_sc_hd__tapvpwrvgnd_1
XTAP_TAPCELL_ROW_180_3898 VSS VDD sky130_fd_sc_hd__tapvpwrvgnd_1
XTAP_TAPCELL_ROW_180_3899 VSS VDD sky130_fd_sc_hd__tapvpwrvgnd_1
XTAP_TAPCELL_ROW_180_3900 VSS VDD sky130_fd_sc_hd__tapvpwrvgnd_1
XTAP_TAPCELL_ROW_180_3901 VSS VDD sky130_fd_sc_hd__tapvpwrvgnd_1
XTAP_TAPCELL_ROW_180_3902 VSS VDD sky130_fd_sc_hd__tapvpwrvgnd_1
XTAP_TAPCELL_ROW_180_3903 VSS VDD sky130_fd_sc_hd__tapvpwrvgnd_1
XTAP_TAPCELL_ROW_180_3904 VSS VDD sky130_fd_sc_hd__tapvpwrvgnd_1
XTAP_TAPCELL_ROW_180_3905 VSS VDD sky130_fd_sc_hd__tapvpwrvgnd_1
XTAP_TAPCELL_ROW_180_3906 VSS VDD sky130_fd_sc_hd__tapvpwrvgnd_1
XTAP_TAPCELL_ROW_180_3907 VSS VDD sky130_fd_sc_hd__tapvpwrvgnd_1
XTAP_TAPCELL_ROW_180_3908 VSS VDD sky130_fd_sc_hd__tapvpwrvgnd_1
XTAP_TAPCELL_ROW_180_3909 VSS VDD sky130_fd_sc_hd__tapvpwrvgnd_1
XTAP_TAPCELL_ROW_180_3910 VSS VDD sky130_fd_sc_hd__tapvpwrvgnd_1
XTAP_TAPCELL_ROW_180_3911 VSS VDD sky130_fd_sc_hd__tapvpwrvgnd_1
XTAP_TAPCELL_ROW_180_3912 VSS VDD sky130_fd_sc_hd__tapvpwrvgnd_1
XTAP_TAPCELL_ROW_181_3913 VSS VDD sky130_fd_sc_hd__tapvpwrvgnd_1
XTAP_TAPCELL_ROW_181_3914 VSS VDD sky130_fd_sc_hd__tapvpwrvgnd_1
XTAP_TAPCELL_ROW_181_3915 VSS VDD sky130_fd_sc_hd__tapvpwrvgnd_1
XTAP_TAPCELL_ROW_181_3916 VSS VDD sky130_fd_sc_hd__tapvpwrvgnd_1
XTAP_TAPCELL_ROW_181_3917 VSS VDD sky130_fd_sc_hd__tapvpwrvgnd_1
XTAP_TAPCELL_ROW_181_3918 VSS VDD sky130_fd_sc_hd__tapvpwrvgnd_1
XTAP_TAPCELL_ROW_181_3919 VSS VDD sky130_fd_sc_hd__tapvpwrvgnd_1
XTAP_TAPCELL_ROW_181_3920 VSS VDD sky130_fd_sc_hd__tapvpwrvgnd_1
XTAP_TAPCELL_ROW_181_3921 VSS VDD sky130_fd_sc_hd__tapvpwrvgnd_1
XTAP_TAPCELL_ROW_181_3922 VSS VDD sky130_fd_sc_hd__tapvpwrvgnd_1
XTAP_TAPCELL_ROW_181_3923 VSS VDD sky130_fd_sc_hd__tapvpwrvgnd_1
XTAP_TAPCELL_ROW_181_3924 VSS VDD sky130_fd_sc_hd__tapvpwrvgnd_1
XTAP_TAPCELL_ROW_181_3925 VSS VDD sky130_fd_sc_hd__tapvpwrvgnd_1
XTAP_TAPCELL_ROW_181_3926 VSS VDD sky130_fd_sc_hd__tapvpwrvgnd_1
XTAP_TAPCELL_ROW_181_3927 VSS VDD sky130_fd_sc_hd__tapvpwrvgnd_1
XTAP_TAPCELL_ROW_181_3928 VSS VDD sky130_fd_sc_hd__tapvpwrvgnd_1
XTAP_TAPCELL_ROW_181_3929 VSS VDD sky130_fd_sc_hd__tapvpwrvgnd_1
XTAP_TAPCELL_ROW_181_3930 VSS VDD sky130_fd_sc_hd__tapvpwrvgnd_1
XTAP_TAPCELL_ROW_181_3931 VSS VDD sky130_fd_sc_hd__tapvpwrvgnd_1
XTAP_TAPCELL_ROW_181_3932 VSS VDD sky130_fd_sc_hd__tapvpwrvgnd_1
XTAP_TAPCELL_ROW_181_3933 VSS VDD sky130_fd_sc_hd__tapvpwrvgnd_1
XTAP_TAPCELL_ROW_182_3934 VSS VDD sky130_fd_sc_hd__tapvpwrvgnd_1
XTAP_TAPCELL_ROW_182_3935 VSS VDD sky130_fd_sc_hd__tapvpwrvgnd_1
XTAP_TAPCELL_ROW_182_3936 VSS VDD sky130_fd_sc_hd__tapvpwrvgnd_1
XTAP_TAPCELL_ROW_182_3937 VSS VDD sky130_fd_sc_hd__tapvpwrvgnd_1
XTAP_TAPCELL_ROW_182_3938 VSS VDD sky130_fd_sc_hd__tapvpwrvgnd_1
XTAP_TAPCELL_ROW_182_3939 VSS VDD sky130_fd_sc_hd__tapvpwrvgnd_1
XTAP_TAPCELL_ROW_182_3940 VSS VDD sky130_fd_sc_hd__tapvpwrvgnd_1
XTAP_TAPCELL_ROW_182_3941 VSS VDD sky130_fd_sc_hd__tapvpwrvgnd_1
XTAP_TAPCELL_ROW_182_3942 VSS VDD sky130_fd_sc_hd__tapvpwrvgnd_1
XTAP_TAPCELL_ROW_182_3943 VSS VDD sky130_fd_sc_hd__tapvpwrvgnd_1
XTAP_TAPCELL_ROW_182_3944 VSS VDD sky130_fd_sc_hd__tapvpwrvgnd_1
XTAP_TAPCELL_ROW_182_3945 VSS VDD sky130_fd_sc_hd__tapvpwrvgnd_1
XTAP_TAPCELL_ROW_182_3946 VSS VDD sky130_fd_sc_hd__tapvpwrvgnd_1
XTAP_TAPCELL_ROW_182_3947 VSS VDD sky130_fd_sc_hd__tapvpwrvgnd_1
XTAP_TAPCELL_ROW_182_3948 VSS VDD sky130_fd_sc_hd__tapvpwrvgnd_1
XTAP_TAPCELL_ROW_182_3949 VSS VDD sky130_fd_sc_hd__tapvpwrvgnd_1
XTAP_TAPCELL_ROW_182_3950 VSS VDD sky130_fd_sc_hd__tapvpwrvgnd_1
XTAP_TAPCELL_ROW_182_3951 VSS VDD sky130_fd_sc_hd__tapvpwrvgnd_1
XTAP_TAPCELL_ROW_182_3952 VSS VDD sky130_fd_sc_hd__tapvpwrvgnd_1
XTAP_TAPCELL_ROW_182_3953 VSS VDD sky130_fd_sc_hd__tapvpwrvgnd_1
XTAP_TAPCELL_ROW_182_3954 VSS VDD sky130_fd_sc_hd__tapvpwrvgnd_1
XTAP_TAPCELL_ROW_182_3955 VSS VDD sky130_fd_sc_hd__tapvpwrvgnd_1
XTAP_TAPCELL_ROW_183_3956 VSS VDD sky130_fd_sc_hd__tapvpwrvgnd_1
XTAP_TAPCELL_ROW_183_3957 VSS VDD sky130_fd_sc_hd__tapvpwrvgnd_1
XTAP_TAPCELL_ROW_183_3958 VSS VDD sky130_fd_sc_hd__tapvpwrvgnd_1
XTAP_TAPCELL_ROW_183_3959 VSS VDD sky130_fd_sc_hd__tapvpwrvgnd_1
XTAP_TAPCELL_ROW_183_3960 VSS VDD sky130_fd_sc_hd__tapvpwrvgnd_1
XTAP_TAPCELL_ROW_183_3961 VSS VDD sky130_fd_sc_hd__tapvpwrvgnd_1
XTAP_TAPCELL_ROW_183_3962 VSS VDD sky130_fd_sc_hd__tapvpwrvgnd_1
XTAP_TAPCELL_ROW_183_3963 VSS VDD sky130_fd_sc_hd__tapvpwrvgnd_1
XTAP_TAPCELL_ROW_183_3964 VSS VDD sky130_fd_sc_hd__tapvpwrvgnd_1
XTAP_TAPCELL_ROW_183_3965 VSS VDD sky130_fd_sc_hd__tapvpwrvgnd_1
XTAP_TAPCELL_ROW_183_3966 VSS VDD sky130_fd_sc_hd__tapvpwrvgnd_1
XTAP_TAPCELL_ROW_183_3967 VSS VDD sky130_fd_sc_hd__tapvpwrvgnd_1
XTAP_TAPCELL_ROW_183_3968 VSS VDD sky130_fd_sc_hd__tapvpwrvgnd_1
XTAP_TAPCELL_ROW_183_3969 VSS VDD sky130_fd_sc_hd__tapvpwrvgnd_1
XTAP_TAPCELL_ROW_183_3970 VSS VDD sky130_fd_sc_hd__tapvpwrvgnd_1
XTAP_TAPCELL_ROW_183_3971 VSS VDD sky130_fd_sc_hd__tapvpwrvgnd_1
XTAP_TAPCELL_ROW_183_3972 VSS VDD sky130_fd_sc_hd__tapvpwrvgnd_1
XTAP_TAPCELL_ROW_183_3973 VSS VDD sky130_fd_sc_hd__tapvpwrvgnd_1
XTAP_TAPCELL_ROW_183_3974 VSS VDD sky130_fd_sc_hd__tapvpwrvgnd_1
XTAP_TAPCELL_ROW_183_3975 VSS VDD sky130_fd_sc_hd__tapvpwrvgnd_1
XTAP_TAPCELL_ROW_183_3976 VSS VDD sky130_fd_sc_hd__tapvpwrvgnd_1
XTAP_TAPCELL_ROW_184_3977 VSS VDD sky130_fd_sc_hd__tapvpwrvgnd_1
XTAP_TAPCELL_ROW_184_3978 VSS VDD sky130_fd_sc_hd__tapvpwrvgnd_1
XTAP_TAPCELL_ROW_184_3979 VSS VDD sky130_fd_sc_hd__tapvpwrvgnd_1
XTAP_TAPCELL_ROW_184_3980 VSS VDD sky130_fd_sc_hd__tapvpwrvgnd_1
XTAP_TAPCELL_ROW_184_3981 VSS VDD sky130_fd_sc_hd__tapvpwrvgnd_1
XTAP_TAPCELL_ROW_184_3982 VSS VDD sky130_fd_sc_hd__tapvpwrvgnd_1
XTAP_TAPCELL_ROW_184_3983 VSS VDD sky130_fd_sc_hd__tapvpwrvgnd_1
XTAP_TAPCELL_ROW_184_3984 VSS VDD sky130_fd_sc_hd__tapvpwrvgnd_1
XTAP_TAPCELL_ROW_184_3985 VSS VDD sky130_fd_sc_hd__tapvpwrvgnd_1
XTAP_TAPCELL_ROW_184_3986 VSS VDD sky130_fd_sc_hd__tapvpwrvgnd_1
XTAP_TAPCELL_ROW_184_3987 VSS VDD sky130_fd_sc_hd__tapvpwrvgnd_1
XTAP_TAPCELL_ROW_184_3988 VSS VDD sky130_fd_sc_hd__tapvpwrvgnd_1
XTAP_TAPCELL_ROW_184_3989 VSS VDD sky130_fd_sc_hd__tapvpwrvgnd_1
XTAP_TAPCELL_ROW_184_3990 VSS VDD sky130_fd_sc_hd__tapvpwrvgnd_1
XTAP_TAPCELL_ROW_184_3991 VSS VDD sky130_fd_sc_hd__tapvpwrvgnd_1
XTAP_TAPCELL_ROW_184_3992 VSS VDD sky130_fd_sc_hd__tapvpwrvgnd_1
XTAP_TAPCELL_ROW_184_3993 VSS VDD sky130_fd_sc_hd__tapvpwrvgnd_1
XTAP_TAPCELL_ROW_184_3994 VSS VDD sky130_fd_sc_hd__tapvpwrvgnd_1
XTAP_TAPCELL_ROW_184_3995 VSS VDD sky130_fd_sc_hd__tapvpwrvgnd_1
XTAP_TAPCELL_ROW_184_3996 VSS VDD sky130_fd_sc_hd__tapvpwrvgnd_1
XTAP_TAPCELL_ROW_184_3997 VSS VDD sky130_fd_sc_hd__tapvpwrvgnd_1
XTAP_TAPCELL_ROW_184_3998 VSS VDD sky130_fd_sc_hd__tapvpwrvgnd_1
XTAP_TAPCELL_ROW_185_3999 VSS VDD sky130_fd_sc_hd__tapvpwrvgnd_1
XTAP_TAPCELL_ROW_185_4000 VSS VDD sky130_fd_sc_hd__tapvpwrvgnd_1
XTAP_TAPCELL_ROW_185_4001 VSS VDD sky130_fd_sc_hd__tapvpwrvgnd_1
XTAP_TAPCELL_ROW_185_4002 VSS VDD sky130_fd_sc_hd__tapvpwrvgnd_1
XTAP_TAPCELL_ROW_185_4003 VSS VDD sky130_fd_sc_hd__tapvpwrvgnd_1
XTAP_TAPCELL_ROW_185_4004 VSS VDD sky130_fd_sc_hd__tapvpwrvgnd_1
XTAP_TAPCELL_ROW_185_4005 VSS VDD sky130_fd_sc_hd__tapvpwrvgnd_1
XTAP_TAPCELL_ROW_185_4006 VSS VDD sky130_fd_sc_hd__tapvpwrvgnd_1
XTAP_TAPCELL_ROW_185_4007 VSS VDD sky130_fd_sc_hd__tapvpwrvgnd_1
XTAP_TAPCELL_ROW_185_4008 VSS VDD sky130_fd_sc_hd__tapvpwrvgnd_1
XTAP_TAPCELL_ROW_185_4009 VSS VDD sky130_fd_sc_hd__tapvpwrvgnd_1
XTAP_TAPCELL_ROW_185_4010 VSS VDD sky130_fd_sc_hd__tapvpwrvgnd_1
XTAP_TAPCELL_ROW_185_4011 VSS VDD sky130_fd_sc_hd__tapvpwrvgnd_1
XTAP_TAPCELL_ROW_185_4012 VSS VDD sky130_fd_sc_hd__tapvpwrvgnd_1
XTAP_TAPCELL_ROW_185_4013 VSS VDD sky130_fd_sc_hd__tapvpwrvgnd_1
XTAP_TAPCELL_ROW_185_4014 VSS VDD sky130_fd_sc_hd__tapvpwrvgnd_1
XTAP_TAPCELL_ROW_185_4015 VSS VDD sky130_fd_sc_hd__tapvpwrvgnd_1
XTAP_TAPCELL_ROW_185_4016 VSS VDD sky130_fd_sc_hd__tapvpwrvgnd_1
XTAP_TAPCELL_ROW_185_4017 VSS VDD sky130_fd_sc_hd__tapvpwrvgnd_1
XTAP_TAPCELL_ROW_185_4018 VSS VDD sky130_fd_sc_hd__tapvpwrvgnd_1
XTAP_TAPCELL_ROW_185_4019 VSS VDD sky130_fd_sc_hd__tapvpwrvgnd_1
XTAP_TAPCELL_ROW_186_4020 VSS VDD sky130_fd_sc_hd__tapvpwrvgnd_1
XTAP_TAPCELL_ROW_186_4021 VSS VDD sky130_fd_sc_hd__tapvpwrvgnd_1
XTAP_TAPCELL_ROW_186_4022 VSS VDD sky130_fd_sc_hd__tapvpwrvgnd_1
XTAP_TAPCELL_ROW_186_4023 VSS VDD sky130_fd_sc_hd__tapvpwrvgnd_1
XTAP_TAPCELL_ROW_186_4024 VSS VDD sky130_fd_sc_hd__tapvpwrvgnd_1
XTAP_TAPCELL_ROW_186_4025 VSS VDD sky130_fd_sc_hd__tapvpwrvgnd_1
XTAP_TAPCELL_ROW_186_4026 VSS VDD sky130_fd_sc_hd__tapvpwrvgnd_1
XTAP_TAPCELL_ROW_186_4027 VSS VDD sky130_fd_sc_hd__tapvpwrvgnd_1
XTAP_TAPCELL_ROW_186_4028 VSS VDD sky130_fd_sc_hd__tapvpwrvgnd_1
XTAP_TAPCELL_ROW_186_4029 VSS VDD sky130_fd_sc_hd__tapvpwrvgnd_1
XTAP_TAPCELL_ROW_186_4030 VSS VDD sky130_fd_sc_hd__tapvpwrvgnd_1
XTAP_TAPCELL_ROW_186_4031 VSS VDD sky130_fd_sc_hd__tapvpwrvgnd_1
XTAP_TAPCELL_ROW_186_4032 VSS VDD sky130_fd_sc_hd__tapvpwrvgnd_1
XTAP_TAPCELL_ROW_186_4033 VSS VDD sky130_fd_sc_hd__tapvpwrvgnd_1
XTAP_TAPCELL_ROW_186_4034 VSS VDD sky130_fd_sc_hd__tapvpwrvgnd_1
XTAP_TAPCELL_ROW_186_4035 VSS VDD sky130_fd_sc_hd__tapvpwrvgnd_1
XTAP_TAPCELL_ROW_186_4036 VSS VDD sky130_fd_sc_hd__tapvpwrvgnd_1
XTAP_TAPCELL_ROW_186_4037 VSS VDD sky130_fd_sc_hd__tapvpwrvgnd_1
XTAP_TAPCELL_ROW_186_4038 VSS VDD sky130_fd_sc_hd__tapvpwrvgnd_1
XTAP_TAPCELL_ROW_186_4039 VSS VDD sky130_fd_sc_hd__tapvpwrvgnd_1
XTAP_TAPCELL_ROW_186_4040 VSS VDD sky130_fd_sc_hd__tapvpwrvgnd_1
XTAP_TAPCELL_ROW_186_4041 VSS VDD sky130_fd_sc_hd__tapvpwrvgnd_1
XTAP_TAPCELL_ROW_187_4042 VSS VDD sky130_fd_sc_hd__tapvpwrvgnd_1
XTAP_TAPCELL_ROW_187_4043 VSS VDD sky130_fd_sc_hd__tapvpwrvgnd_1
XTAP_TAPCELL_ROW_187_4044 VSS VDD sky130_fd_sc_hd__tapvpwrvgnd_1
XTAP_TAPCELL_ROW_187_4045 VSS VDD sky130_fd_sc_hd__tapvpwrvgnd_1
XTAP_TAPCELL_ROW_187_4046 VSS VDD sky130_fd_sc_hd__tapvpwrvgnd_1
XTAP_TAPCELL_ROW_187_4047 VSS VDD sky130_fd_sc_hd__tapvpwrvgnd_1
XTAP_TAPCELL_ROW_187_4048 VSS VDD sky130_fd_sc_hd__tapvpwrvgnd_1
XTAP_TAPCELL_ROW_187_4049 VSS VDD sky130_fd_sc_hd__tapvpwrvgnd_1
XTAP_TAPCELL_ROW_187_4050 VSS VDD sky130_fd_sc_hd__tapvpwrvgnd_1
XTAP_TAPCELL_ROW_187_4051 VSS VDD sky130_fd_sc_hd__tapvpwrvgnd_1
XTAP_TAPCELL_ROW_187_4052 VSS VDD sky130_fd_sc_hd__tapvpwrvgnd_1
XTAP_TAPCELL_ROW_187_4053 VSS VDD sky130_fd_sc_hd__tapvpwrvgnd_1
XTAP_TAPCELL_ROW_187_4054 VSS VDD sky130_fd_sc_hd__tapvpwrvgnd_1
XTAP_TAPCELL_ROW_187_4055 VSS VDD sky130_fd_sc_hd__tapvpwrvgnd_1
XTAP_TAPCELL_ROW_187_4056 VSS VDD sky130_fd_sc_hd__tapvpwrvgnd_1
XTAP_TAPCELL_ROW_187_4057 VSS VDD sky130_fd_sc_hd__tapvpwrvgnd_1
XTAP_TAPCELL_ROW_187_4058 VSS VDD sky130_fd_sc_hd__tapvpwrvgnd_1
XTAP_TAPCELL_ROW_187_4059 VSS VDD sky130_fd_sc_hd__tapvpwrvgnd_1
XTAP_TAPCELL_ROW_187_4060 VSS VDD sky130_fd_sc_hd__tapvpwrvgnd_1
XTAP_TAPCELL_ROW_187_4061 VSS VDD sky130_fd_sc_hd__tapvpwrvgnd_1
XTAP_TAPCELL_ROW_187_4062 VSS VDD sky130_fd_sc_hd__tapvpwrvgnd_1
XTAP_TAPCELL_ROW_188_4063 VSS VDD sky130_fd_sc_hd__tapvpwrvgnd_1
XTAP_TAPCELL_ROW_188_4064 VSS VDD sky130_fd_sc_hd__tapvpwrvgnd_1
XTAP_TAPCELL_ROW_188_4065 VSS VDD sky130_fd_sc_hd__tapvpwrvgnd_1
XTAP_TAPCELL_ROW_188_4066 VSS VDD sky130_fd_sc_hd__tapvpwrvgnd_1
XTAP_TAPCELL_ROW_188_4067 VSS VDD sky130_fd_sc_hd__tapvpwrvgnd_1
XTAP_TAPCELL_ROW_188_4068 VSS VDD sky130_fd_sc_hd__tapvpwrvgnd_1
XTAP_TAPCELL_ROW_188_4069 VSS VDD sky130_fd_sc_hd__tapvpwrvgnd_1
XTAP_TAPCELL_ROW_188_4070 VSS VDD sky130_fd_sc_hd__tapvpwrvgnd_1
XTAP_TAPCELL_ROW_188_4071 VSS VDD sky130_fd_sc_hd__tapvpwrvgnd_1
XTAP_TAPCELL_ROW_188_4072 VSS VDD sky130_fd_sc_hd__tapvpwrvgnd_1
XTAP_TAPCELL_ROW_188_4073 VSS VDD sky130_fd_sc_hd__tapvpwrvgnd_1
XTAP_TAPCELL_ROW_188_4074 VSS VDD sky130_fd_sc_hd__tapvpwrvgnd_1
XTAP_TAPCELL_ROW_188_4075 VSS VDD sky130_fd_sc_hd__tapvpwrvgnd_1
XTAP_TAPCELL_ROW_188_4076 VSS VDD sky130_fd_sc_hd__tapvpwrvgnd_1
XTAP_TAPCELL_ROW_188_4077 VSS VDD sky130_fd_sc_hd__tapvpwrvgnd_1
XTAP_TAPCELL_ROW_188_4078 VSS VDD sky130_fd_sc_hd__tapvpwrvgnd_1
XTAP_TAPCELL_ROW_188_4079 VSS VDD sky130_fd_sc_hd__tapvpwrvgnd_1
XTAP_TAPCELL_ROW_188_4080 VSS VDD sky130_fd_sc_hd__tapvpwrvgnd_1
XTAP_TAPCELL_ROW_188_4081 VSS VDD sky130_fd_sc_hd__tapvpwrvgnd_1
XTAP_TAPCELL_ROW_188_4082 VSS VDD sky130_fd_sc_hd__tapvpwrvgnd_1
XTAP_TAPCELL_ROW_188_4083 VSS VDD sky130_fd_sc_hd__tapvpwrvgnd_1
XTAP_TAPCELL_ROW_188_4084 VSS VDD sky130_fd_sc_hd__tapvpwrvgnd_1
XTAP_TAPCELL_ROW_189_4085 VSS VDD sky130_fd_sc_hd__tapvpwrvgnd_1
XTAP_TAPCELL_ROW_189_4086 VSS VDD sky130_fd_sc_hd__tapvpwrvgnd_1
XTAP_TAPCELL_ROW_189_4087 VSS VDD sky130_fd_sc_hd__tapvpwrvgnd_1
XTAP_TAPCELL_ROW_189_4088 VSS VDD sky130_fd_sc_hd__tapvpwrvgnd_1
XTAP_TAPCELL_ROW_189_4089 VSS VDD sky130_fd_sc_hd__tapvpwrvgnd_1
XTAP_TAPCELL_ROW_189_4090 VSS VDD sky130_fd_sc_hd__tapvpwrvgnd_1
XTAP_TAPCELL_ROW_189_4091 VSS VDD sky130_fd_sc_hd__tapvpwrvgnd_1
XTAP_TAPCELL_ROW_189_4092 VSS VDD sky130_fd_sc_hd__tapvpwrvgnd_1
XTAP_TAPCELL_ROW_189_4093 VSS VDD sky130_fd_sc_hd__tapvpwrvgnd_1
XTAP_TAPCELL_ROW_189_4094 VSS VDD sky130_fd_sc_hd__tapvpwrvgnd_1
XTAP_TAPCELL_ROW_189_4095 VSS VDD sky130_fd_sc_hd__tapvpwrvgnd_1
XTAP_TAPCELL_ROW_189_4096 VSS VDD sky130_fd_sc_hd__tapvpwrvgnd_1
XTAP_TAPCELL_ROW_189_4097 VSS VDD sky130_fd_sc_hd__tapvpwrvgnd_1
XTAP_TAPCELL_ROW_189_4098 VSS VDD sky130_fd_sc_hd__tapvpwrvgnd_1
XTAP_TAPCELL_ROW_189_4099 VSS VDD sky130_fd_sc_hd__tapvpwrvgnd_1
XTAP_TAPCELL_ROW_189_4100 VSS VDD sky130_fd_sc_hd__tapvpwrvgnd_1
XTAP_TAPCELL_ROW_189_4101 VSS VDD sky130_fd_sc_hd__tapvpwrvgnd_1
XTAP_TAPCELL_ROW_189_4102 VSS VDD sky130_fd_sc_hd__tapvpwrvgnd_1
XTAP_TAPCELL_ROW_189_4103 VSS VDD sky130_fd_sc_hd__tapvpwrvgnd_1
XTAP_TAPCELL_ROW_189_4104 VSS VDD sky130_fd_sc_hd__tapvpwrvgnd_1
XTAP_TAPCELL_ROW_189_4105 VSS VDD sky130_fd_sc_hd__tapvpwrvgnd_1
XTAP_TAPCELL_ROW_190_4106 VSS VDD sky130_fd_sc_hd__tapvpwrvgnd_1
XTAP_TAPCELL_ROW_190_4107 VSS VDD sky130_fd_sc_hd__tapvpwrvgnd_1
XTAP_TAPCELL_ROW_190_4108 VSS VDD sky130_fd_sc_hd__tapvpwrvgnd_1
XTAP_TAPCELL_ROW_190_4109 VSS VDD sky130_fd_sc_hd__tapvpwrvgnd_1
XTAP_TAPCELL_ROW_190_4110 VSS VDD sky130_fd_sc_hd__tapvpwrvgnd_1
XTAP_TAPCELL_ROW_190_4111 VSS VDD sky130_fd_sc_hd__tapvpwrvgnd_1
XTAP_TAPCELL_ROW_190_4112 VSS VDD sky130_fd_sc_hd__tapvpwrvgnd_1
XTAP_TAPCELL_ROW_190_4113 VSS VDD sky130_fd_sc_hd__tapvpwrvgnd_1
XTAP_TAPCELL_ROW_190_4114 VSS VDD sky130_fd_sc_hd__tapvpwrvgnd_1
XTAP_TAPCELL_ROW_190_4115 VSS VDD sky130_fd_sc_hd__tapvpwrvgnd_1
XTAP_TAPCELL_ROW_190_4116 VSS VDD sky130_fd_sc_hd__tapvpwrvgnd_1
XTAP_TAPCELL_ROW_190_4117 VSS VDD sky130_fd_sc_hd__tapvpwrvgnd_1
XTAP_TAPCELL_ROW_190_4118 VSS VDD sky130_fd_sc_hd__tapvpwrvgnd_1
XTAP_TAPCELL_ROW_190_4119 VSS VDD sky130_fd_sc_hd__tapvpwrvgnd_1
XTAP_TAPCELL_ROW_190_4120 VSS VDD sky130_fd_sc_hd__tapvpwrvgnd_1
XTAP_TAPCELL_ROW_190_4121 VSS VDD sky130_fd_sc_hd__tapvpwrvgnd_1
XTAP_TAPCELL_ROW_190_4122 VSS VDD sky130_fd_sc_hd__tapvpwrvgnd_1
XTAP_TAPCELL_ROW_190_4123 VSS VDD sky130_fd_sc_hd__tapvpwrvgnd_1
XTAP_TAPCELL_ROW_190_4124 VSS VDD sky130_fd_sc_hd__tapvpwrvgnd_1
XTAP_TAPCELL_ROW_190_4125 VSS VDD sky130_fd_sc_hd__tapvpwrvgnd_1
XTAP_TAPCELL_ROW_190_4126 VSS VDD sky130_fd_sc_hd__tapvpwrvgnd_1
XTAP_TAPCELL_ROW_190_4127 VSS VDD sky130_fd_sc_hd__tapvpwrvgnd_1
XTAP_TAPCELL_ROW_191_4128 VSS VDD sky130_fd_sc_hd__tapvpwrvgnd_1
XTAP_TAPCELL_ROW_191_4129 VSS VDD sky130_fd_sc_hd__tapvpwrvgnd_1
XTAP_TAPCELL_ROW_191_4130 VSS VDD sky130_fd_sc_hd__tapvpwrvgnd_1
XTAP_TAPCELL_ROW_191_4131 VSS VDD sky130_fd_sc_hd__tapvpwrvgnd_1
XTAP_TAPCELL_ROW_191_4132 VSS VDD sky130_fd_sc_hd__tapvpwrvgnd_1
XTAP_TAPCELL_ROW_191_4133 VSS VDD sky130_fd_sc_hd__tapvpwrvgnd_1
XTAP_TAPCELL_ROW_191_4134 VSS VDD sky130_fd_sc_hd__tapvpwrvgnd_1
XTAP_TAPCELL_ROW_191_4135 VSS VDD sky130_fd_sc_hd__tapvpwrvgnd_1
XTAP_TAPCELL_ROW_191_4136 VSS VDD sky130_fd_sc_hd__tapvpwrvgnd_1
XTAP_TAPCELL_ROW_191_4137 VSS VDD sky130_fd_sc_hd__tapvpwrvgnd_1
XTAP_TAPCELL_ROW_191_4138 VSS VDD sky130_fd_sc_hd__tapvpwrvgnd_1
XTAP_TAPCELL_ROW_191_4139 VSS VDD sky130_fd_sc_hd__tapvpwrvgnd_1
XTAP_TAPCELL_ROW_191_4140 VSS VDD sky130_fd_sc_hd__tapvpwrvgnd_1
XTAP_TAPCELL_ROW_191_4141 VSS VDD sky130_fd_sc_hd__tapvpwrvgnd_1
XTAP_TAPCELL_ROW_191_4142 VSS VDD sky130_fd_sc_hd__tapvpwrvgnd_1
XTAP_TAPCELL_ROW_191_4143 VSS VDD sky130_fd_sc_hd__tapvpwrvgnd_1
XTAP_TAPCELL_ROW_191_4144 VSS VDD sky130_fd_sc_hd__tapvpwrvgnd_1
XTAP_TAPCELL_ROW_191_4145 VSS VDD sky130_fd_sc_hd__tapvpwrvgnd_1
XTAP_TAPCELL_ROW_191_4146 VSS VDD sky130_fd_sc_hd__tapvpwrvgnd_1
XTAP_TAPCELL_ROW_191_4147 VSS VDD sky130_fd_sc_hd__tapvpwrvgnd_1
XTAP_TAPCELL_ROW_191_4148 VSS VDD sky130_fd_sc_hd__tapvpwrvgnd_1
XTAP_TAPCELL_ROW_192_4149 VSS VDD sky130_fd_sc_hd__tapvpwrvgnd_1
XTAP_TAPCELL_ROW_192_4150 VSS VDD sky130_fd_sc_hd__tapvpwrvgnd_1
XTAP_TAPCELL_ROW_192_4151 VSS VDD sky130_fd_sc_hd__tapvpwrvgnd_1
XTAP_TAPCELL_ROW_192_4152 VSS VDD sky130_fd_sc_hd__tapvpwrvgnd_1
XTAP_TAPCELL_ROW_192_4153 VSS VDD sky130_fd_sc_hd__tapvpwrvgnd_1
XTAP_TAPCELL_ROW_192_4154 VSS VDD sky130_fd_sc_hd__tapvpwrvgnd_1
XTAP_TAPCELL_ROW_192_4155 VSS VDD sky130_fd_sc_hd__tapvpwrvgnd_1
XTAP_TAPCELL_ROW_192_4156 VSS VDD sky130_fd_sc_hd__tapvpwrvgnd_1
XTAP_TAPCELL_ROW_192_4157 VSS VDD sky130_fd_sc_hd__tapvpwrvgnd_1
XTAP_TAPCELL_ROW_192_4158 VSS VDD sky130_fd_sc_hd__tapvpwrvgnd_1
XTAP_TAPCELL_ROW_192_4159 VSS VDD sky130_fd_sc_hd__tapvpwrvgnd_1
XTAP_TAPCELL_ROW_192_4160 VSS VDD sky130_fd_sc_hd__tapvpwrvgnd_1
XTAP_TAPCELL_ROW_192_4161 VSS VDD sky130_fd_sc_hd__tapvpwrvgnd_1
XTAP_TAPCELL_ROW_192_4162 VSS VDD sky130_fd_sc_hd__tapvpwrvgnd_1
XTAP_TAPCELL_ROW_192_4163 VSS VDD sky130_fd_sc_hd__tapvpwrvgnd_1
XTAP_TAPCELL_ROW_192_4164 VSS VDD sky130_fd_sc_hd__tapvpwrvgnd_1
XTAP_TAPCELL_ROW_192_4165 VSS VDD sky130_fd_sc_hd__tapvpwrvgnd_1
XTAP_TAPCELL_ROW_192_4166 VSS VDD sky130_fd_sc_hd__tapvpwrvgnd_1
XTAP_TAPCELL_ROW_192_4167 VSS VDD sky130_fd_sc_hd__tapvpwrvgnd_1
XTAP_TAPCELL_ROW_192_4168 VSS VDD sky130_fd_sc_hd__tapvpwrvgnd_1
XTAP_TAPCELL_ROW_192_4169 VSS VDD sky130_fd_sc_hd__tapvpwrvgnd_1
XTAP_TAPCELL_ROW_192_4170 VSS VDD sky130_fd_sc_hd__tapvpwrvgnd_1
XTAP_TAPCELL_ROW_193_4171 VSS VDD sky130_fd_sc_hd__tapvpwrvgnd_1
XTAP_TAPCELL_ROW_193_4172 VSS VDD sky130_fd_sc_hd__tapvpwrvgnd_1
XTAP_TAPCELL_ROW_193_4173 VSS VDD sky130_fd_sc_hd__tapvpwrvgnd_1
XTAP_TAPCELL_ROW_193_4174 VSS VDD sky130_fd_sc_hd__tapvpwrvgnd_1
XTAP_TAPCELL_ROW_193_4175 VSS VDD sky130_fd_sc_hd__tapvpwrvgnd_1
XTAP_TAPCELL_ROW_193_4176 VSS VDD sky130_fd_sc_hd__tapvpwrvgnd_1
XTAP_TAPCELL_ROW_193_4177 VSS VDD sky130_fd_sc_hd__tapvpwrvgnd_1
XTAP_TAPCELL_ROW_193_4178 VSS VDD sky130_fd_sc_hd__tapvpwrvgnd_1
XTAP_TAPCELL_ROW_193_4179 VSS VDD sky130_fd_sc_hd__tapvpwrvgnd_1
XTAP_TAPCELL_ROW_193_4180 VSS VDD sky130_fd_sc_hd__tapvpwrvgnd_1
XTAP_TAPCELL_ROW_193_4181 VSS VDD sky130_fd_sc_hd__tapvpwrvgnd_1
XTAP_TAPCELL_ROW_193_4182 VSS VDD sky130_fd_sc_hd__tapvpwrvgnd_1
XTAP_TAPCELL_ROW_193_4183 VSS VDD sky130_fd_sc_hd__tapvpwrvgnd_1
XTAP_TAPCELL_ROW_193_4184 VSS VDD sky130_fd_sc_hd__tapvpwrvgnd_1
XTAP_TAPCELL_ROW_193_4185 VSS VDD sky130_fd_sc_hd__tapvpwrvgnd_1
XTAP_TAPCELL_ROW_193_4186 VSS VDD sky130_fd_sc_hd__tapvpwrvgnd_1
XTAP_TAPCELL_ROW_193_4187 VSS VDD sky130_fd_sc_hd__tapvpwrvgnd_1
XTAP_TAPCELL_ROW_193_4188 VSS VDD sky130_fd_sc_hd__tapvpwrvgnd_1
XTAP_TAPCELL_ROW_193_4189 VSS VDD sky130_fd_sc_hd__tapvpwrvgnd_1
XTAP_TAPCELL_ROW_193_4190 VSS VDD sky130_fd_sc_hd__tapvpwrvgnd_1
XTAP_TAPCELL_ROW_193_4191 VSS VDD sky130_fd_sc_hd__tapvpwrvgnd_1
XTAP_TAPCELL_ROW_194_4192 VSS VDD sky130_fd_sc_hd__tapvpwrvgnd_1
XTAP_TAPCELL_ROW_194_4193 VSS VDD sky130_fd_sc_hd__tapvpwrvgnd_1
XTAP_TAPCELL_ROW_194_4194 VSS VDD sky130_fd_sc_hd__tapvpwrvgnd_1
XTAP_TAPCELL_ROW_194_4195 VSS VDD sky130_fd_sc_hd__tapvpwrvgnd_1
XTAP_TAPCELL_ROW_194_4196 VSS VDD sky130_fd_sc_hd__tapvpwrvgnd_1
XTAP_TAPCELL_ROW_194_4197 VSS VDD sky130_fd_sc_hd__tapvpwrvgnd_1
XTAP_TAPCELL_ROW_194_4198 VSS VDD sky130_fd_sc_hd__tapvpwrvgnd_1
XTAP_TAPCELL_ROW_194_4199 VSS VDD sky130_fd_sc_hd__tapvpwrvgnd_1
XTAP_TAPCELL_ROW_194_4200 VSS VDD sky130_fd_sc_hd__tapvpwrvgnd_1
XTAP_TAPCELL_ROW_194_4201 VSS VDD sky130_fd_sc_hd__tapvpwrvgnd_1
XTAP_TAPCELL_ROW_194_4202 VSS VDD sky130_fd_sc_hd__tapvpwrvgnd_1
XTAP_TAPCELL_ROW_194_4203 VSS VDD sky130_fd_sc_hd__tapvpwrvgnd_1
XTAP_TAPCELL_ROW_194_4204 VSS VDD sky130_fd_sc_hd__tapvpwrvgnd_1
XTAP_TAPCELL_ROW_194_4205 VSS VDD sky130_fd_sc_hd__tapvpwrvgnd_1
XTAP_TAPCELL_ROW_194_4206 VSS VDD sky130_fd_sc_hd__tapvpwrvgnd_1
XTAP_TAPCELL_ROW_194_4207 VSS VDD sky130_fd_sc_hd__tapvpwrvgnd_1
XTAP_TAPCELL_ROW_194_4208 VSS VDD sky130_fd_sc_hd__tapvpwrvgnd_1
XTAP_TAPCELL_ROW_194_4209 VSS VDD sky130_fd_sc_hd__tapvpwrvgnd_1
XTAP_TAPCELL_ROW_194_4210 VSS VDD sky130_fd_sc_hd__tapvpwrvgnd_1
XTAP_TAPCELL_ROW_194_4211 VSS VDD sky130_fd_sc_hd__tapvpwrvgnd_1
XTAP_TAPCELL_ROW_194_4212 VSS VDD sky130_fd_sc_hd__tapvpwrvgnd_1
XTAP_TAPCELL_ROW_194_4213 VSS VDD sky130_fd_sc_hd__tapvpwrvgnd_1
XTAP_TAPCELL_ROW_195_4214 VSS VDD sky130_fd_sc_hd__tapvpwrvgnd_1
XTAP_TAPCELL_ROW_195_4215 VSS VDD sky130_fd_sc_hd__tapvpwrvgnd_1
XTAP_TAPCELL_ROW_195_4216 VSS VDD sky130_fd_sc_hd__tapvpwrvgnd_1
XTAP_TAPCELL_ROW_195_4217 VSS VDD sky130_fd_sc_hd__tapvpwrvgnd_1
XTAP_TAPCELL_ROW_195_4218 VSS VDD sky130_fd_sc_hd__tapvpwrvgnd_1
XTAP_TAPCELL_ROW_195_4219 VSS VDD sky130_fd_sc_hd__tapvpwrvgnd_1
XTAP_TAPCELL_ROW_195_4220 VSS VDD sky130_fd_sc_hd__tapvpwrvgnd_1
XTAP_TAPCELL_ROW_195_4221 VSS VDD sky130_fd_sc_hd__tapvpwrvgnd_1
XTAP_TAPCELL_ROW_195_4222 VSS VDD sky130_fd_sc_hd__tapvpwrvgnd_1
XTAP_TAPCELL_ROW_195_4223 VSS VDD sky130_fd_sc_hd__tapvpwrvgnd_1
XTAP_TAPCELL_ROW_195_4224 VSS VDD sky130_fd_sc_hd__tapvpwrvgnd_1
XTAP_TAPCELL_ROW_195_4225 VSS VDD sky130_fd_sc_hd__tapvpwrvgnd_1
XTAP_TAPCELL_ROW_195_4226 VSS VDD sky130_fd_sc_hd__tapvpwrvgnd_1
XTAP_TAPCELL_ROW_195_4227 VSS VDD sky130_fd_sc_hd__tapvpwrvgnd_1
XTAP_TAPCELL_ROW_195_4228 VSS VDD sky130_fd_sc_hd__tapvpwrvgnd_1
XTAP_TAPCELL_ROW_195_4229 VSS VDD sky130_fd_sc_hd__tapvpwrvgnd_1
XTAP_TAPCELL_ROW_195_4230 VSS VDD sky130_fd_sc_hd__tapvpwrvgnd_1
XTAP_TAPCELL_ROW_195_4231 VSS VDD sky130_fd_sc_hd__tapvpwrvgnd_1
XTAP_TAPCELL_ROW_195_4232 VSS VDD sky130_fd_sc_hd__tapvpwrvgnd_1
XTAP_TAPCELL_ROW_195_4233 VSS VDD sky130_fd_sc_hd__tapvpwrvgnd_1
XTAP_TAPCELL_ROW_195_4234 VSS VDD sky130_fd_sc_hd__tapvpwrvgnd_1
XTAP_TAPCELL_ROW_196_4235 VSS VDD sky130_fd_sc_hd__tapvpwrvgnd_1
XTAP_TAPCELL_ROW_196_4236 VSS VDD sky130_fd_sc_hd__tapvpwrvgnd_1
XTAP_TAPCELL_ROW_196_4237 VSS VDD sky130_fd_sc_hd__tapvpwrvgnd_1
XTAP_TAPCELL_ROW_196_4238 VSS VDD sky130_fd_sc_hd__tapvpwrvgnd_1
XTAP_TAPCELL_ROW_196_4239 VSS VDD sky130_fd_sc_hd__tapvpwrvgnd_1
XTAP_TAPCELL_ROW_196_4240 VSS VDD sky130_fd_sc_hd__tapvpwrvgnd_1
XTAP_TAPCELL_ROW_196_4241 VSS VDD sky130_fd_sc_hd__tapvpwrvgnd_1
XTAP_TAPCELL_ROW_196_4242 VSS VDD sky130_fd_sc_hd__tapvpwrvgnd_1
XTAP_TAPCELL_ROW_196_4243 VSS VDD sky130_fd_sc_hd__tapvpwrvgnd_1
XTAP_TAPCELL_ROW_196_4244 VSS VDD sky130_fd_sc_hd__tapvpwrvgnd_1
XTAP_TAPCELL_ROW_196_4245 VSS VDD sky130_fd_sc_hd__tapvpwrvgnd_1
XTAP_TAPCELL_ROW_196_4246 VSS VDD sky130_fd_sc_hd__tapvpwrvgnd_1
XTAP_TAPCELL_ROW_196_4247 VSS VDD sky130_fd_sc_hd__tapvpwrvgnd_1
XTAP_TAPCELL_ROW_196_4248 VSS VDD sky130_fd_sc_hd__tapvpwrvgnd_1
XTAP_TAPCELL_ROW_196_4249 VSS VDD sky130_fd_sc_hd__tapvpwrvgnd_1
XTAP_TAPCELL_ROW_196_4250 VSS VDD sky130_fd_sc_hd__tapvpwrvgnd_1
XTAP_TAPCELL_ROW_196_4251 VSS VDD sky130_fd_sc_hd__tapvpwrvgnd_1
XTAP_TAPCELL_ROW_196_4252 VSS VDD sky130_fd_sc_hd__tapvpwrvgnd_1
XTAP_TAPCELL_ROW_196_4253 VSS VDD sky130_fd_sc_hd__tapvpwrvgnd_1
XTAP_TAPCELL_ROW_196_4254 VSS VDD sky130_fd_sc_hd__tapvpwrvgnd_1
XTAP_TAPCELL_ROW_196_4255 VSS VDD sky130_fd_sc_hd__tapvpwrvgnd_1
XTAP_TAPCELL_ROW_196_4256 VSS VDD sky130_fd_sc_hd__tapvpwrvgnd_1
XTAP_TAPCELL_ROW_197_4257 VSS VDD sky130_fd_sc_hd__tapvpwrvgnd_1
XTAP_TAPCELL_ROW_197_4258 VSS VDD sky130_fd_sc_hd__tapvpwrvgnd_1
XTAP_TAPCELL_ROW_197_4259 VSS VDD sky130_fd_sc_hd__tapvpwrvgnd_1
XTAP_TAPCELL_ROW_197_4260 VSS VDD sky130_fd_sc_hd__tapvpwrvgnd_1
XTAP_TAPCELL_ROW_197_4261 VSS VDD sky130_fd_sc_hd__tapvpwrvgnd_1
XTAP_TAPCELL_ROW_197_4262 VSS VDD sky130_fd_sc_hd__tapvpwrvgnd_1
XTAP_TAPCELL_ROW_197_4263 VSS VDD sky130_fd_sc_hd__tapvpwrvgnd_1
XTAP_TAPCELL_ROW_197_4264 VSS VDD sky130_fd_sc_hd__tapvpwrvgnd_1
XTAP_TAPCELL_ROW_197_4265 VSS VDD sky130_fd_sc_hd__tapvpwrvgnd_1
XTAP_TAPCELL_ROW_197_4266 VSS VDD sky130_fd_sc_hd__tapvpwrvgnd_1
XTAP_TAPCELL_ROW_197_4267 VSS VDD sky130_fd_sc_hd__tapvpwrvgnd_1
XTAP_TAPCELL_ROW_197_4268 VSS VDD sky130_fd_sc_hd__tapvpwrvgnd_1
XTAP_TAPCELL_ROW_197_4269 VSS VDD sky130_fd_sc_hd__tapvpwrvgnd_1
XTAP_TAPCELL_ROW_197_4270 VSS VDD sky130_fd_sc_hd__tapvpwrvgnd_1
XTAP_TAPCELL_ROW_197_4271 VSS VDD sky130_fd_sc_hd__tapvpwrvgnd_1
XTAP_TAPCELL_ROW_197_4272 VSS VDD sky130_fd_sc_hd__tapvpwrvgnd_1
XTAP_TAPCELL_ROW_197_4273 VSS VDD sky130_fd_sc_hd__tapvpwrvgnd_1
XTAP_TAPCELL_ROW_197_4274 VSS VDD sky130_fd_sc_hd__tapvpwrvgnd_1
XTAP_TAPCELL_ROW_197_4275 VSS VDD sky130_fd_sc_hd__tapvpwrvgnd_1
XTAP_TAPCELL_ROW_197_4276 VSS VDD sky130_fd_sc_hd__tapvpwrvgnd_1
XTAP_TAPCELL_ROW_197_4277 VSS VDD sky130_fd_sc_hd__tapvpwrvgnd_1
XTAP_TAPCELL_ROW_198_4278 VSS VDD sky130_fd_sc_hd__tapvpwrvgnd_1
XTAP_TAPCELL_ROW_198_4279 VSS VDD sky130_fd_sc_hd__tapvpwrvgnd_1
XTAP_TAPCELL_ROW_198_4280 VSS VDD sky130_fd_sc_hd__tapvpwrvgnd_1
XTAP_TAPCELL_ROW_198_4281 VSS VDD sky130_fd_sc_hd__tapvpwrvgnd_1
XTAP_TAPCELL_ROW_198_4282 VSS VDD sky130_fd_sc_hd__tapvpwrvgnd_1
XTAP_TAPCELL_ROW_198_4283 VSS VDD sky130_fd_sc_hd__tapvpwrvgnd_1
XTAP_TAPCELL_ROW_198_4284 VSS VDD sky130_fd_sc_hd__tapvpwrvgnd_1
XTAP_TAPCELL_ROW_198_4285 VSS VDD sky130_fd_sc_hd__tapvpwrvgnd_1
XTAP_TAPCELL_ROW_198_4286 VSS VDD sky130_fd_sc_hd__tapvpwrvgnd_1
XTAP_TAPCELL_ROW_198_4287 VSS VDD sky130_fd_sc_hd__tapvpwrvgnd_1
XTAP_TAPCELL_ROW_198_4288 VSS VDD sky130_fd_sc_hd__tapvpwrvgnd_1
XTAP_TAPCELL_ROW_198_4289 VSS VDD sky130_fd_sc_hd__tapvpwrvgnd_1
XTAP_TAPCELL_ROW_198_4290 VSS VDD sky130_fd_sc_hd__tapvpwrvgnd_1
XTAP_TAPCELL_ROW_198_4291 VSS VDD sky130_fd_sc_hd__tapvpwrvgnd_1
XTAP_TAPCELL_ROW_198_4292 VSS VDD sky130_fd_sc_hd__tapvpwrvgnd_1
XTAP_TAPCELL_ROW_198_4293 VSS VDD sky130_fd_sc_hd__tapvpwrvgnd_1
XTAP_TAPCELL_ROW_198_4294 VSS VDD sky130_fd_sc_hd__tapvpwrvgnd_1
XTAP_TAPCELL_ROW_198_4295 VSS VDD sky130_fd_sc_hd__tapvpwrvgnd_1
XTAP_TAPCELL_ROW_198_4296 VSS VDD sky130_fd_sc_hd__tapvpwrvgnd_1
XTAP_TAPCELL_ROW_198_4297 VSS VDD sky130_fd_sc_hd__tapvpwrvgnd_1
XTAP_TAPCELL_ROW_198_4298 VSS VDD sky130_fd_sc_hd__tapvpwrvgnd_1
XTAP_TAPCELL_ROW_198_4299 VSS VDD sky130_fd_sc_hd__tapvpwrvgnd_1
XTAP_TAPCELL_ROW_199_4300 VSS VDD sky130_fd_sc_hd__tapvpwrvgnd_1
XTAP_TAPCELL_ROW_199_4301 VSS VDD sky130_fd_sc_hd__tapvpwrvgnd_1
XTAP_TAPCELL_ROW_199_4302 VSS VDD sky130_fd_sc_hd__tapvpwrvgnd_1
XTAP_TAPCELL_ROW_199_4303 VSS VDD sky130_fd_sc_hd__tapvpwrvgnd_1
XTAP_TAPCELL_ROW_199_4304 VSS VDD sky130_fd_sc_hd__tapvpwrvgnd_1
XTAP_TAPCELL_ROW_199_4305 VSS VDD sky130_fd_sc_hd__tapvpwrvgnd_1
XTAP_TAPCELL_ROW_199_4306 VSS VDD sky130_fd_sc_hd__tapvpwrvgnd_1
XTAP_TAPCELL_ROW_199_4307 VSS VDD sky130_fd_sc_hd__tapvpwrvgnd_1
XTAP_TAPCELL_ROW_199_4308 VSS VDD sky130_fd_sc_hd__tapvpwrvgnd_1
XTAP_TAPCELL_ROW_199_4309 VSS VDD sky130_fd_sc_hd__tapvpwrvgnd_1
XTAP_TAPCELL_ROW_199_4310 VSS VDD sky130_fd_sc_hd__tapvpwrvgnd_1
XTAP_TAPCELL_ROW_199_4311 VSS VDD sky130_fd_sc_hd__tapvpwrvgnd_1
XTAP_TAPCELL_ROW_199_4312 VSS VDD sky130_fd_sc_hd__tapvpwrvgnd_1
XTAP_TAPCELL_ROW_199_4313 VSS VDD sky130_fd_sc_hd__tapvpwrvgnd_1
XTAP_TAPCELL_ROW_199_4314 VSS VDD sky130_fd_sc_hd__tapvpwrvgnd_1
XTAP_TAPCELL_ROW_199_4315 VSS VDD sky130_fd_sc_hd__tapvpwrvgnd_1
XTAP_TAPCELL_ROW_199_4316 VSS VDD sky130_fd_sc_hd__tapvpwrvgnd_1
XTAP_TAPCELL_ROW_199_4317 VSS VDD sky130_fd_sc_hd__tapvpwrvgnd_1
XTAP_TAPCELL_ROW_199_4318 VSS VDD sky130_fd_sc_hd__tapvpwrvgnd_1
XTAP_TAPCELL_ROW_199_4319 VSS VDD sky130_fd_sc_hd__tapvpwrvgnd_1
XTAP_TAPCELL_ROW_199_4320 VSS VDD sky130_fd_sc_hd__tapvpwrvgnd_1
XTAP_TAPCELL_ROW_200_4321 VSS VDD sky130_fd_sc_hd__tapvpwrvgnd_1
XTAP_TAPCELL_ROW_200_4322 VSS VDD sky130_fd_sc_hd__tapvpwrvgnd_1
XTAP_TAPCELL_ROW_200_4323 VSS VDD sky130_fd_sc_hd__tapvpwrvgnd_1
XTAP_TAPCELL_ROW_200_4324 VSS VDD sky130_fd_sc_hd__tapvpwrvgnd_1
XTAP_TAPCELL_ROW_200_4325 VSS VDD sky130_fd_sc_hd__tapvpwrvgnd_1
XTAP_TAPCELL_ROW_200_4326 VSS VDD sky130_fd_sc_hd__tapvpwrvgnd_1
XTAP_TAPCELL_ROW_200_4327 VSS VDD sky130_fd_sc_hd__tapvpwrvgnd_1
XTAP_TAPCELL_ROW_200_4328 VSS VDD sky130_fd_sc_hd__tapvpwrvgnd_1
XTAP_TAPCELL_ROW_200_4329 VSS VDD sky130_fd_sc_hd__tapvpwrvgnd_1
XTAP_TAPCELL_ROW_200_4330 VSS VDD sky130_fd_sc_hd__tapvpwrvgnd_1
XTAP_TAPCELL_ROW_200_4331 VSS VDD sky130_fd_sc_hd__tapvpwrvgnd_1
XTAP_TAPCELL_ROW_200_4332 VSS VDD sky130_fd_sc_hd__tapvpwrvgnd_1
XTAP_TAPCELL_ROW_200_4333 VSS VDD sky130_fd_sc_hd__tapvpwrvgnd_1
XTAP_TAPCELL_ROW_200_4334 VSS VDD sky130_fd_sc_hd__tapvpwrvgnd_1
XTAP_TAPCELL_ROW_200_4335 VSS VDD sky130_fd_sc_hd__tapvpwrvgnd_1
XTAP_TAPCELL_ROW_200_4336 VSS VDD sky130_fd_sc_hd__tapvpwrvgnd_1
XTAP_TAPCELL_ROW_200_4337 VSS VDD sky130_fd_sc_hd__tapvpwrvgnd_1
XTAP_TAPCELL_ROW_200_4338 VSS VDD sky130_fd_sc_hd__tapvpwrvgnd_1
XTAP_TAPCELL_ROW_200_4339 VSS VDD sky130_fd_sc_hd__tapvpwrvgnd_1
XTAP_TAPCELL_ROW_200_4340 VSS VDD sky130_fd_sc_hd__tapvpwrvgnd_1
XTAP_TAPCELL_ROW_200_4341 VSS VDD sky130_fd_sc_hd__tapvpwrvgnd_1
XTAP_TAPCELL_ROW_200_4342 VSS VDD sky130_fd_sc_hd__tapvpwrvgnd_1
XTAP_TAPCELL_ROW_201_4343 VSS VDD sky130_fd_sc_hd__tapvpwrvgnd_1
XTAP_TAPCELL_ROW_201_4344 VSS VDD sky130_fd_sc_hd__tapvpwrvgnd_1
XTAP_TAPCELL_ROW_201_4345 VSS VDD sky130_fd_sc_hd__tapvpwrvgnd_1
XTAP_TAPCELL_ROW_201_4346 VSS VDD sky130_fd_sc_hd__tapvpwrvgnd_1
XTAP_TAPCELL_ROW_201_4347 VSS VDD sky130_fd_sc_hd__tapvpwrvgnd_1
XTAP_TAPCELL_ROW_201_4348 VSS VDD sky130_fd_sc_hd__tapvpwrvgnd_1
XTAP_TAPCELL_ROW_201_4349 VSS VDD sky130_fd_sc_hd__tapvpwrvgnd_1
XTAP_TAPCELL_ROW_201_4350 VSS VDD sky130_fd_sc_hd__tapvpwrvgnd_1
XTAP_TAPCELL_ROW_201_4351 VSS VDD sky130_fd_sc_hd__tapvpwrvgnd_1
XTAP_TAPCELL_ROW_201_4352 VSS VDD sky130_fd_sc_hd__tapvpwrvgnd_1
XTAP_TAPCELL_ROW_201_4353 VSS VDD sky130_fd_sc_hd__tapvpwrvgnd_1
XTAP_TAPCELL_ROW_201_4354 VSS VDD sky130_fd_sc_hd__tapvpwrvgnd_1
XTAP_TAPCELL_ROW_201_4355 VSS VDD sky130_fd_sc_hd__tapvpwrvgnd_1
XTAP_TAPCELL_ROW_201_4356 VSS VDD sky130_fd_sc_hd__tapvpwrvgnd_1
XTAP_TAPCELL_ROW_201_4357 VSS VDD sky130_fd_sc_hd__tapvpwrvgnd_1
XTAP_TAPCELL_ROW_201_4358 VSS VDD sky130_fd_sc_hd__tapvpwrvgnd_1
XTAP_TAPCELL_ROW_201_4359 VSS VDD sky130_fd_sc_hd__tapvpwrvgnd_1
XTAP_TAPCELL_ROW_201_4360 VSS VDD sky130_fd_sc_hd__tapvpwrvgnd_1
XTAP_TAPCELL_ROW_201_4361 VSS VDD sky130_fd_sc_hd__tapvpwrvgnd_1
XTAP_TAPCELL_ROW_201_4362 VSS VDD sky130_fd_sc_hd__tapvpwrvgnd_1
XTAP_TAPCELL_ROW_201_4363 VSS VDD sky130_fd_sc_hd__tapvpwrvgnd_1
XTAP_TAPCELL_ROW_202_4364 VSS VDD sky130_fd_sc_hd__tapvpwrvgnd_1
XTAP_TAPCELL_ROW_202_4365 VSS VDD sky130_fd_sc_hd__tapvpwrvgnd_1
XTAP_TAPCELL_ROW_202_4366 VSS VDD sky130_fd_sc_hd__tapvpwrvgnd_1
XTAP_TAPCELL_ROW_202_4367 VSS VDD sky130_fd_sc_hd__tapvpwrvgnd_1
XTAP_TAPCELL_ROW_202_4368 VSS VDD sky130_fd_sc_hd__tapvpwrvgnd_1
XTAP_TAPCELL_ROW_202_4369 VSS VDD sky130_fd_sc_hd__tapvpwrvgnd_1
XTAP_TAPCELL_ROW_202_4370 VSS VDD sky130_fd_sc_hd__tapvpwrvgnd_1
XTAP_TAPCELL_ROW_202_4371 VSS VDD sky130_fd_sc_hd__tapvpwrvgnd_1
XTAP_TAPCELL_ROW_202_4372 VSS VDD sky130_fd_sc_hd__tapvpwrvgnd_1
XTAP_TAPCELL_ROW_202_4373 VSS VDD sky130_fd_sc_hd__tapvpwrvgnd_1
XTAP_TAPCELL_ROW_202_4374 VSS VDD sky130_fd_sc_hd__tapvpwrvgnd_1
XTAP_TAPCELL_ROW_202_4375 VSS VDD sky130_fd_sc_hd__tapvpwrvgnd_1
XTAP_TAPCELL_ROW_202_4376 VSS VDD sky130_fd_sc_hd__tapvpwrvgnd_1
XTAP_TAPCELL_ROW_202_4377 VSS VDD sky130_fd_sc_hd__tapvpwrvgnd_1
XTAP_TAPCELL_ROW_202_4378 VSS VDD sky130_fd_sc_hd__tapvpwrvgnd_1
XTAP_TAPCELL_ROW_202_4379 VSS VDD sky130_fd_sc_hd__tapvpwrvgnd_1
XTAP_TAPCELL_ROW_202_4380 VSS VDD sky130_fd_sc_hd__tapvpwrvgnd_1
XTAP_TAPCELL_ROW_202_4381 VSS VDD sky130_fd_sc_hd__tapvpwrvgnd_1
XTAP_TAPCELL_ROW_202_4382 VSS VDD sky130_fd_sc_hd__tapvpwrvgnd_1
XTAP_TAPCELL_ROW_202_4383 VSS VDD sky130_fd_sc_hd__tapvpwrvgnd_1
XTAP_TAPCELL_ROW_202_4384 VSS VDD sky130_fd_sc_hd__tapvpwrvgnd_1
XTAP_TAPCELL_ROW_202_4385 VSS VDD sky130_fd_sc_hd__tapvpwrvgnd_1
XTAP_TAPCELL_ROW_203_4386 VSS VDD sky130_fd_sc_hd__tapvpwrvgnd_1
XTAP_TAPCELL_ROW_203_4387 VSS VDD sky130_fd_sc_hd__tapvpwrvgnd_1
XTAP_TAPCELL_ROW_203_4388 VSS VDD sky130_fd_sc_hd__tapvpwrvgnd_1
XTAP_TAPCELL_ROW_203_4389 VSS VDD sky130_fd_sc_hd__tapvpwrvgnd_1
XTAP_TAPCELL_ROW_203_4390 VSS VDD sky130_fd_sc_hd__tapvpwrvgnd_1
XTAP_TAPCELL_ROW_203_4391 VSS VDD sky130_fd_sc_hd__tapvpwrvgnd_1
XTAP_TAPCELL_ROW_203_4392 VSS VDD sky130_fd_sc_hd__tapvpwrvgnd_1
XTAP_TAPCELL_ROW_203_4393 VSS VDD sky130_fd_sc_hd__tapvpwrvgnd_1
XTAP_TAPCELL_ROW_203_4394 VSS VDD sky130_fd_sc_hd__tapvpwrvgnd_1
XTAP_TAPCELL_ROW_203_4395 VSS VDD sky130_fd_sc_hd__tapvpwrvgnd_1
XTAP_TAPCELL_ROW_203_4396 VSS VDD sky130_fd_sc_hd__tapvpwrvgnd_1
XTAP_TAPCELL_ROW_203_4397 VSS VDD sky130_fd_sc_hd__tapvpwrvgnd_1
XTAP_TAPCELL_ROW_203_4398 VSS VDD sky130_fd_sc_hd__tapvpwrvgnd_1
XTAP_TAPCELL_ROW_203_4399 VSS VDD sky130_fd_sc_hd__tapvpwrvgnd_1
XTAP_TAPCELL_ROW_203_4400 VSS VDD sky130_fd_sc_hd__tapvpwrvgnd_1
XTAP_TAPCELL_ROW_203_4401 VSS VDD sky130_fd_sc_hd__tapvpwrvgnd_1
XTAP_TAPCELL_ROW_203_4402 VSS VDD sky130_fd_sc_hd__tapvpwrvgnd_1
XTAP_TAPCELL_ROW_203_4403 VSS VDD sky130_fd_sc_hd__tapvpwrvgnd_1
XTAP_TAPCELL_ROW_203_4404 VSS VDD sky130_fd_sc_hd__tapvpwrvgnd_1
XTAP_TAPCELL_ROW_203_4405 VSS VDD sky130_fd_sc_hd__tapvpwrvgnd_1
XTAP_TAPCELL_ROW_203_4406 VSS VDD sky130_fd_sc_hd__tapvpwrvgnd_1
XTAP_TAPCELL_ROW_204_4407 VSS VDD sky130_fd_sc_hd__tapvpwrvgnd_1
XTAP_TAPCELL_ROW_204_4408 VSS VDD sky130_fd_sc_hd__tapvpwrvgnd_1
XTAP_TAPCELL_ROW_204_4409 VSS VDD sky130_fd_sc_hd__tapvpwrvgnd_1
XTAP_TAPCELL_ROW_204_4410 VSS VDD sky130_fd_sc_hd__tapvpwrvgnd_1
XTAP_TAPCELL_ROW_204_4411 VSS VDD sky130_fd_sc_hd__tapvpwrvgnd_1
XTAP_TAPCELL_ROW_204_4412 VSS VDD sky130_fd_sc_hd__tapvpwrvgnd_1
XTAP_TAPCELL_ROW_204_4413 VSS VDD sky130_fd_sc_hd__tapvpwrvgnd_1
XTAP_TAPCELL_ROW_204_4414 VSS VDD sky130_fd_sc_hd__tapvpwrvgnd_1
XTAP_TAPCELL_ROW_204_4415 VSS VDD sky130_fd_sc_hd__tapvpwrvgnd_1
XTAP_TAPCELL_ROW_204_4416 VSS VDD sky130_fd_sc_hd__tapvpwrvgnd_1
XTAP_TAPCELL_ROW_204_4417 VSS VDD sky130_fd_sc_hd__tapvpwrvgnd_1
XTAP_TAPCELL_ROW_204_4418 VSS VDD sky130_fd_sc_hd__tapvpwrvgnd_1
XTAP_TAPCELL_ROW_204_4419 VSS VDD sky130_fd_sc_hd__tapvpwrvgnd_1
XTAP_TAPCELL_ROW_204_4420 VSS VDD sky130_fd_sc_hd__tapvpwrvgnd_1
XTAP_TAPCELL_ROW_204_4421 VSS VDD sky130_fd_sc_hd__tapvpwrvgnd_1
XTAP_TAPCELL_ROW_204_4422 VSS VDD sky130_fd_sc_hd__tapvpwrvgnd_1
XTAP_TAPCELL_ROW_204_4423 VSS VDD sky130_fd_sc_hd__tapvpwrvgnd_1
XTAP_TAPCELL_ROW_204_4424 VSS VDD sky130_fd_sc_hd__tapvpwrvgnd_1
XTAP_TAPCELL_ROW_204_4425 VSS VDD sky130_fd_sc_hd__tapvpwrvgnd_1
XTAP_TAPCELL_ROW_204_4426 VSS VDD sky130_fd_sc_hd__tapvpwrvgnd_1
XTAP_TAPCELL_ROW_204_4427 VSS VDD sky130_fd_sc_hd__tapvpwrvgnd_1
XTAP_TAPCELL_ROW_204_4428 VSS VDD sky130_fd_sc_hd__tapvpwrvgnd_1
XTAP_TAPCELL_ROW_205_4429 VSS VDD sky130_fd_sc_hd__tapvpwrvgnd_1
XTAP_TAPCELL_ROW_205_4430 VSS VDD sky130_fd_sc_hd__tapvpwrvgnd_1
XTAP_TAPCELL_ROW_205_4431 VSS VDD sky130_fd_sc_hd__tapvpwrvgnd_1
XTAP_TAPCELL_ROW_205_4432 VSS VDD sky130_fd_sc_hd__tapvpwrvgnd_1
XTAP_TAPCELL_ROW_205_4433 VSS VDD sky130_fd_sc_hd__tapvpwrvgnd_1
XTAP_TAPCELL_ROW_205_4434 VSS VDD sky130_fd_sc_hd__tapvpwrvgnd_1
XTAP_TAPCELL_ROW_205_4435 VSS VDD sky130_fd_sc_hd__tapvpwrvgnd_1
XTAP_TAPCELL_ROW_205_4436 VSS VDD sky130_fd_sc_hd__tapvpwrvgnd_1
XTAP_TAPCELL_ROW_205_4437 VSS VDD sky130_fd_sc_hd__tapvpwrvgnd_1
XTAP_TAPCELL_ROW_205_4438 VSS VDD sky130_fd_sc_hd__tapvpwrvgnd_1
XTAP_TAPCELL_ROW_205_4439 VSS VDD sky130_fd_sc_hd__tapvpwrvgnd_1
XTAP_TAPCELL_ROW_205_4440 VSS VDD sky130_fd_sc_hd__tapvpwrvgnd_1
XTAP_TAPCELL_ROW_205_4441 VSS VDD sky130_fd_sc_hd__tapvpwrvgnd_1
XTAP_TAPCELL_ROW_205_4442 VSS VDD sky130_fd_sc_hd__tapvpwrvgnd_1
XTAP_TAPCELL_ROW_205_4443 VSS VDD sky130_fd_sc_hd__tapvpwrvgnd_1
XTAP_TAPCELL_ROW_205_4444 VSS VDD sky130_fd_sc_hd__tapvpwrvgnd_1
XTAP_TAPCELL_ROW_205_4445 VSS VDD sky130_fd_sc_hd__tapvpwrvgnd_1
XTAP_TAPCELL_ROW_205_4446 VSS VDD sky130_fd_sc_hd__tapvpwrvgnd_1
XTAP_TAPCELL_ROW_205_4447 VSS VDD sky130_fd_sc_hd__tapvpwrvgnd_1
XTAP_TAPCELL_ROW_205_4448 VSS VDD sky130_fd_sc_hd__tapvpwrvgnd_1
XTAP_TAPCELL_ROW_205_4449 VSS VDD sky130_fd_sc_hd__tapvpwrvgnd_1
XTAP_TAPCELL_ROW_206_4450 VSS VDD sky130_fd_sc_hd__tapvpwrvgnd_1
XTAP_TAPCELL_ROW_206_4451 VSS VDD sky130_fd_sc_hd__tapvpwrvgnd_1
XTAP_TAPCELL_ROW_206_4452 VSS VDD sky130_fd_sc_hd__tapvpwrvgnd_1
XTAP_TAPCELL_ROW_206_4453 VSS VDD sky130_fd_sc_hd__tapvpwrvgnd_1
XTAP_TAPCELL_ROW_206_4454 VSS VDD sky130_fd_sc_hd__tapvpwrvgnd_1
XTAP_TAPCELL_ROW_206_4455 VSS VDD sky130_fd_sc_hd__tapvpwrvgnd_1
XTAP_TAPCELL_ROW_206_4456 VSS VDD sky130_fd_sc_hd__tapvpwrvgnd_1
XTAP_TAPCELL_ROW_206_4457 VSS VDD sky130_fd_sc_hd__tapvpwrvgnd_1
XTAP_TAPCELL_ROW_206_4458 VSS VDD sky130_fd_sc_hd__tapvpwrvgnd_1
XTAP_TAPCELL_ROW_206_4459 VSS VDD sky130_fd_sc_hd__tapvpwrvgnd_1
XTAP_TAPCELL_ROW_206_4460 VSS VDD sky130_fd_sc_hd__tapvpwrvgnd_1
XTAP_TAPCELL_ROW_206_4461 VSS VDD sky130_fd_sc_hd__tapvpwrvgnd_1
XTAP_TAPCELL_ROW_206_4462 VSS VDD sky130_fd_sc_hd__tapvpwrvgnd_1
XTAP_TAPCELL_ROW_206_4463 VSS VDD sky130_fd_sc_hd__tapvpwrvgnd_1
XTAP_TAPCELL_ROW_206_4464 VSS VDD sky130_fd_sc_hd__tapvpwrvgnd_1
XTAP_TAPCELL_ROW_206_4465 VSS VDD sky130_fd_sc_hd__tapvpwrvgnd_1
XTAP_TAPCELL_ROW_206_4466 VSS VDD sky130_fd_sc_hd__tapvpwrvgnd_1
XTAP_TAPCELL_ROW_206_4467 VSS VDD sky130_fd_sc_hd__tapvpwrvgnd_1
XTAP_TAPCELL_ROW_206_4468 VSS VDD sky130_fd_sc_hd__tapvpwrvgnd_1
XTAP_TAPCELL_ROW_206_4469 VSS VDD sky130_fd_sc_hd__tapvpwrvgnd_1
XTAP_TAPCELL_ROW_206_4470 VSS VDD sky130_fd_sc_hd__tapvpwrvgnd_1
XTAP_TAPCELL_ROW_206_4471 VSS VDD sky130_fd_sc_hd__tapvpwrvgnd_1
XTAP_TAPCELL_ROW_207_4472 VSS VDD sky130_fd_sc_hd__tapvpwrvgnd_1
XTAP_TAPCELL_ROW_207_4473 VSS VDD sky130_fd_sc_hd__tapvpwrvgnd_1
XTAP_TAPCELL_ROW_207_4474 VSS VDD sky130_fd_sc_hd__tapvpwrvgnd_1
XTAP_TAPCELL_ROW_207_4475 VSS VDD sky130_fd_sc_hd__tapvpwrvgnd_1
XTAP_TAPCELL_ROW_207_4476 VSS VDD sky130_fd_sc_hd__tapvpwrvgnd_1
XTAP_TAPCELL_ROW_207_4477 VSS VDD sky130_fd_sc_hd__tapvpwrvgnd_1
XTAP_TAPCELL_ROW_207_4478 VSS VDD sky130_fd_sc_hd__tapvpwrvgnd_1
XTAP_TAPCELL_ROW_207_4479 VSS VDD sky130_fd_sc_hd__tapvpwrvgnd_1
XTAP_TAPCELL_ROW_207_4480 VSS VDD sky130_fd_sc_hd__tapvpwrvgnd_1
XTAP_TAPCELL_ROW_207_4481 VSS VDD sky130_fd_sc_hd__tapvpwrvgnd_1
XTAP_TAPCELL_ROW_207_4482 VSS VDD sky130_fd_sc_hd__tapvpwrvgnd_1
XTAP_TAPCELL_ROW_207_4483 VSS VDD sky130_fd_sc_hd__tapvpwrvgnd_1
XTAP_TAPCELL_ROW_207_4484 VSS VDD sky130_fd_sc_hd__tapvpwrvgnd_1
XTAP_TAPCELL_ROW_207_4485 VSS VDD sky130_fd_sc_hd__tapvpwrvgnd_1
XTAP_TAPCELL_ROW_207_4486 VSS VDD sky130_fd_sc_hd__tapvpwrvgnd_1
XTAP_TAPCELL_ROW_207_4487 VSS VDD sky130_fd_sc_hd__tapvpwrvgnd_1
XTAP_TAPCELL_ROW_207_4488 VSS VDD sky130_fd_sc_hd__tapvpwrvgnd_1
XTAP_TAPCELL_ROW_207_4489 VSS VDD sky130_fd_sc_hd__tapvpwrvgnd_1
XTAP_TAPCELL_ROW_207_4490 VSS VDD sky130_fd_sc_hd__tapvpwrvgnd_1
XTAP_TAPCELL_ROW_207_4491 VSS VDD sky130_fd_sc_hd__tapvpwrvgnd_1
XTAP_TAPCELL_ROW_207_4492 VSS VDD sky130_fd_sc_hd__tapvpwrvgnd_1
XTAP_TAPCELL_ROW_208_4493 VSS VDD sky130_fd_sc_hd__tapvpwrvgnd_1
XTAP_TAPCELL_ROW_208_4494 VSS VDD sky130_fd_sc_hd__tapvpwrvgnd_1
XTAP_TAPCELL_ROW_208_4495 VSS VDD sky130_fd_sc_hd__tapvpwrvgnd_1
XTAP_TAPCELL_ROW_208_4496 VSS VDD sky130_fd_sc_hd__tapvpwrvgnd_1
XTAP_TAPCELL_ROW_208_4497 VSS VDD sky130_fd_sc_hd__tapvpwrvgnd_1
XTAP_TAPCELL_ROW_208_4498 VSS VDD sky130_fd_sc_hd__tapvpwrvgnd_1
XTAP_TAPCELL_ROW_208_4499 VSS VDD sky130_fd_sc_hd__tapvpwrvgnd_1
XTAP_TAPCELL_ROW_208_4500 VSS VDD sky130_fd_sc_hd__tapvpwrvgnd_1
XTAP_TAPCELL_ROW_208_4501 VSS VDD sky130_fd_sc_hd__tapvpwrvgnd_1
XTAP_TAPCELL_ROW_208_4502 VSS VDD sky130_fd_sc_hd__tapvpwrvgnd_1
XTAP_TAPCELL_ROW_208_4503 VSS VDD sky130_fd_sc_hd__tapvpwrvgnd_1
XTAP_TAPCELL_ROW_208_4504 VSS VDD sky130_fd_sc_hd__tapvpwrvgnd_1
XTAP_TAPCELL_ROW_208_4505 VSS VDD sky130_fd_sc_hd__tapvpwrvgnd_1
XTAP_TAPCELL_ROW_208_4506 VSS VDD sky130_fd_sc_hd__tapvpwrvgnd_1
XTAP_TAPCELL_ROW_208_4507 VSS VDD sky130_fd_sc_hd__tapvpwrvgnd_1
XTAP_TAPCELL_ROW_208_4508 VSS VDD sky130_fd_sc_hd__tapvpwrvgnd_1
XTAP_TAPCELL_ROW_208_4509 VSS VDD sky130_fd_sc_hd__tapvpwrvgnd_1
XTAP_TAPCELL_ROW_208_4510 VSS VDD sky130_fd_sc_hd__tapvpwrvgnd_1
XTAP_TAPCELL_ROW_208_4511 VSS VDD sky130_fd_sc_hd__tapvpwrvgnd_1
XTAP_TAPCELL_ROW_208_4512 VSS VDD sky130_fd_sc_hd__tapvpwrvgnd_1
XTAP_TAPCELL_ROW_208_4513 VSS VDD sky130_fd_sc_hd__tapvpwrvgnd_1
XTAP_TAPCELL_ROW_208_4514 VSS VDD sky130_fd_sc_hd__tapvpwrvgnd_1
XTAP_TAPCELL_ROW_209_4515 VSS VDD sky130_fd_sc_hd__tapvpwrvgnd_1
XTAP_TAPCELL_ROW_209_4516 VSS VDD sky130_fd_sc_hd__tapvpwrvgnd_1
XTAP_TAPCELL_ROW_209_4517 VSS VDD sky130_fd_sc_hd__tapvpwrvgnd_1
XTAP_TAPCELL_ROW_209_4518 VSS VDD sky130_fd_sc_hd__tapvpwrvgnd_1
XTAP_TAPCELL_ROW_209_4519 VSS VDD sky130_fd_sc_hd__tapvpwrvgnd_1
XTAP_TAPCELL_ROW_209_4520 VSS VDD sky130_fd_sc_hd__tapvpwrvgnd_1
XTAP_TAPCELL_ROW_209_4521 VSS VDD sky130_fd_sc_hd__tapvpwrvgnd_1
XTAP_TAPCELL_ROW_209_4522 VSS VDD sky130_fd_sc_hd__tapvpwrvgnd_1
XTAP_TAPCELL_ROW_209_4523 VSS VDD sky130_fd_sc_hd__tapvpwrvgnd_1
XTAP_TAPCELL_ROW_209_4524 VSS VDD sky130_fd_sc_hd__tapvpwrvgnd_1
XTAP_TAPCELL_ROW_209_4525 VSS VDD sky130_fd_sc_hd__tapvpwrvgnd_1
XTAP_TAPCELL_ROW_209_4526 VSS VDD sky130_fd_sc_hd__tapvpwrvgnd_1
XTAP_TAPCELL_ROW_209_4527 VSS VDD sky130_fd_sc_hd__tapvpwrvgnd_1
XTAP_TAPCELL_ROW_209_4528 VSS VDD sky130_fd_sc_hd__tapvpwrvgnd_1
XTAP_TAPCELL_ROW_209_4529 VSS VDD sky130_fd_sc_hd__tapvpwrvgnd_1
XTAP_TAPCELL_ROW_209_4530 VSS VDD sky130_fd_sc_hd__tapvpwrvgnd_1
XTAP_TAPCELL_ROW_209_4531 VSS VDD sky130_fd_sc_hd__tapvpwrvgnd_1
XTAP_TAPCELL_ROW_209_4532 VSS VDD sky130_fd_sc_hd__tapvpwrvgnd_1
XTAP_TAPCELL_ROW_209_4533 VSS VDD sky130_fd_sc_hd__tapvpwrvgnd_1
XTAP_TAPCELL_ROW_209_4534 VSS VDD sky130_fd_sc_hd__tapvpwrvgnd_1
XTAP_TAPCELL_ROW_209_4535 VSS VDD sky130_fd_sc_hd__tapvpwrvgnd_1
XTAP_TAPCELL_ROW_210_4536 VSS VDD sky130_fd_sc_hd__tapvpwrvgnd_1
XTAP_TAPCELL_ROW_210_4537 VSS VDD sky130_fd_sc_hd__tapvpwrvgnd_1
XTAP_TAPCELL_ROW_210_4538 VSS VDD sky130_fd_sc_hd__tapvpwrvgnd_1
XTAP_TAPCELL_ROW_210_4539 VSS VDD sky130_fd_sc_hd__tapvpwrvgnd_1
XTAP_TAPCELL_ROW_210_4540 VSS VDD sky130_fd_sc_hd__tapvpwrvgnd_1
XTAP_TAPCELL_ROW_210_4541 VSS VDD sky130_fd_sc_hd__tapvpwrvgnd_1
XTAP_TAPCELL_ROW_210_4542 VSS VDD sky130_fd_sc_hd__tapvpwrvgnd_1
XTAP_TAPCELL_ROW_210_4543 VSS VDD sky130_fd_sc_hd__tapvpwrvgnd_1
XTAP_TAPCELL_ROW_210_4544 VSS VDD sky130_fd_sc_hd__tapvpwrvgnd_1
XTAP_TAPCELL_ROW_210_4545 VSS VDD sky130_fd_sc_hd__tapvpwrvgnd_1
XTAP_TAPCELL_ROW_210_4546 VSS VDD sky130_fd_sc_hd__tapvpwrvgnd_1
XTAP_TAPCELL_ROW_210_4547 VSS VDD sky130_fd_sc_hd__tapvpwrvgnd_1
XTAP_TAPCELL_ROW_210_4548 VSS VDD sky130_fd_sc_hd__tapvpwrvgnd_1
XTAP_TAPCELL_ROW_210_4549 VSS VDD sky130_fd_sc_hd__tapvpwrvgnd_1
XTAP_TAPCELL_ROW_210_4550 VSS VDD sky130_fd_sc_hd__tapvpwrvgnd_1
XTAP_TAPCELL_ROW_210_4551 VSS VDD sky130_fd_sc_hd__tapvpwrvgnd_1
XTAP_TAPCELL_ROW_210_4552 VSS VDD sky130_fd_sc_hd__tapvpwrvgnd_1
XTAP_TAPCELL_ROW_210_4553 VSS VDD sky130_fd_sc_hd__tapvpwrvgnd_1
XTAP_TAPCELL_ROW_210_4554 VSS VDD sky130_fd_sc_hd__tapvpwrvgnd_1
XTAP_TAPCELL_ROW_210_4555 VSS VDD sky130_fd_sc_hd__tapvpwrvgnd_1
XTAP_TAPCELL_ROW_210_4556 VSS VDD sky130_fd_sc_hd__tapvpwrvgnd_1
XTAP_TAPCELL_ROW_210_4557 VSS VDD sky130_fd_sc_hd__tapvpwrvgnd_1
XTAP_TAPCELL_ROW_211_4558 VSS VDD sky130_fd_sc_hd__tapvpwrvgnd_1
XTAP_TAPCELL_ROW_211_4559 VSS VDD sky130_fd_sc_hd__tapvpwrvgnd_1
XTAP_TAPCELL_ROW_211_4560 VSS VDD sky130_fd_sc_hd__tapvpwrvgnd_1
XTAP_TAPCELL_ROW_211_4561 VSS VDD sky130_fd_sc_hd__tapvpwrvgnd_1
XTAP_TAPCELL_ROW_211_4562 VSS VDD sky130_fd_sc_hd__tapvpwrvgnd_1
XTAP_TAPCELL_ROW_211_4563 VSS VDD sky130_fd_sc_hd__tapvpwrvgnd_1
XTAP_TAPCELL_ROW_211_4564 VSS VDD sky130_fd_sc_hd__tapvpwrvgnd_1
XTAP_TAPCELL_ROW_211_4565 VSS VDD sky130_fd_sc_hd__tapvpwrvgnd_1
XTAP_TAPCELL_ROW_211_4566 VSS VDD sky130_fd_sc_hd__tapvpwrvgnd_1
XTAP_TAPCELL_ROW_211_4567 VSS VDD sky130_fd_sc_hd__tapvpwrvgnd_1
XTAP_TAPCELL_ROW_211_4568 VSS VDD sky130_fd_sc_hd__tapvpwrvgnd_1
XTAP_TAPCELL_ROW_211_4569 VSS VDD sky130_fd_sc_hd__tapvpwrvgnd_1
XTAP_TAPCELL_ROW_211_4570 VSS VDD sky130_fd_sc_hd__tapvpwrvgnd_1
XTAP_TAPCELL_ROW_211_4571 VSS VDD sky130_fd_sc_hd__tapvpwrvgnd_1
XTAP_TAPCELL_ROW_211_4572 VSS VDD sky130_fd_sc_hd__tapvpwrvgnd_1
XTAP_TAPCELL_ROW_211_4573 VSS VDD sky130_fd_sc_hd__tapvpwrvgnd_1
XTAP_TAPCELL_ROW_211_4574 VSS VDD sky130_fd_sc_hd__tapvpwrvgnd_1
XTAP_TAPCELL_ROW_211_4575 VSS VDD sky130_fd_sc_hd__tapvpwrvgnd_1
XTAP_TAPCELL_ROW_211_4576 VSS VDD sky130_fd_sc_hd__tapvpwrvgnd_1
XTAP_TAPCELL_ROW_211_4577 VSS VDD sky130_fd_sc_hd__tapvpwrvgnd_1
XTAP_TAPCELL_ROW_211_4578 VSS VDD sky130_fd_sc_hd__tapvpwrvgnd_1
XTAP_TAPCELL_ROW_212_4579 VSS VDD sky130_fd_sc_hd__tapvpwrvgnd_1
XTAP_TAPCELL_ROW_212_4580 VSS VDD sky130_fd_sc_hd__tapvpwrvgnd_1
XTAP_TAPCELL_ROW_212_4581 VSS VDD sky130_fd_sc_hd__tapvpwrvgnd_1
XTAP_TAPCELL_ROW_212_4582 VSS VDD sky130_fd_sc_hd__tapvpwrvgnd_1
XTAP_TAPCELL_ROW_212_4583 VSS VDD sky130_fd_sc_hd__tapvpwrvgnd_1
XTAP_TAPCELL_ROW_212_4584 VSS VDD sky130_fd_sc_hd__tapvpwrvgnd_1
XTAP_TAPCELL_ROW_212_4585 VSS VDD sky130_fd_sc_hd__tapvpwrvgnd_1
XTAP_TAPCELL_ROW_212_4586 VSS VDD sky130_fd_sc_hd__tapvpwrvgnd_1
XTAP_TAPCELL_ROW_212_4587 VSS VDD sky130_fd_sc_hd__tapvpwrvgnd_1
XTAP_TAPCELL_ROW_212_4588 VSS VDD sky130_fd_sc_hd__tapvpwrvgnd_1
XTAP_TAPCELL_ROW_212_4589 VSS VDD sky130_fd_sc_hd__tapvpwrvgnd_1
XTAP_TAPCELL_ROW_212_4590 VSS VDD sky130_fd_sc_hd__tapvpwrvgnd_1
XTAP_TAPCELL_ROW_212_4591 VSS VDD sky130_fd_sc_hd__tapvpwrvgnd_1
XTAP_TAPCELL_ROW_212_4592 VSS VDD sky130_fd_sc_hd__tapvpwrvgnd_1
XTAP_TAPCELL_ROW_212_4593 VSS VDD sky130_fd_sc_hd__tapvpwrvgnd_1
XTAP_TAPCELL_ROW_212_4594 VSS VDD sky130_fd_sc_hd__tapvpwrvgnd_1
XTAP_TAPCELL_ROW_212_4595 VSS VDD sky130_fd_sc_hd__tapvpwrvgnd_1
XTAP_TAPCELL_ROW_212_4596 VSS VDD sky130_fd_sc_hd__tapvpwrvgnd_1
XTAP_TAPCELL_ROW_212_4597 VSS VDD sky130_fd_sc_hd__tapvpwrvgnd_1
XTAP_TAPCELL_ROW_212_4598 VSS VDD sky130_fd_sc_hd__tapvpwrvgnd_1
XTAP_TAPCELL_ROW_212_4599 VSS VDD sky130_fd_sc_hd__tapvpwrvgnd_1
XTAP_TAPCELL_ROW_212_4600 VSS VDD sky130_fd_sc_hd__tapvpwrvgnd_1
XTAP_TAPCELL_ROW_213_4601 VSS VDD sky130_fd_sc_hd__tapvpwrvgnd_1
XTAP_TAPCELL_ROW_213_4602 VSS VDD sky130_fd_sc_hd__tapvpwrvgnd_1
XTAP_TAPCELL_ROW_213_4603 VSS VDD sky130_fd_sc_hd__tapvpwrvgnd_1
XTAP_TAPCELL_ROW_213_4604 VSS VDD sky130_fd_sc_hd__tapvpwrvgnd_1
XTAP_TAPCELL_ROW_213_4605 VSS VDD sky130_fd_sc_hd__tapvpwrvgnd_1
XTAP_TAPCELL_ROW_213_4606 VSS VDD sky130_fd_sc_hd__tapvpwrvgnd_1
XTAP_TAPCELL_ROW_213_4607 VSS VDD sky130_fd_sc_hd__tapvpwrvgnd_1
XTAP_TAPCELL_ROW_213_4608 VSS VDD sky130_fd_sc_hd__tapvpwrvgnd_1
XTAP_TAPCELL_ROW_213_4609 VSS VDD sky130_fd_sc_hd__tapvpwrvgnd_1
XTAP_TAPCELL_ROW_213_4610 VSS VDD sky130_fd_sc_hd__tapvpwrvgnd_1
XTAP_TAPCELL_ROW_213_4611 VSS VDD sky130_fd_sc_hd__tapvpwrvgnd_1
XTAP_TAPCELL_ROW_213_4612 VSS VDD sky130_fd_sc_hd__tapvpwrvgnd_1
XTAP_TAPCELL_ROW_213_4613 VSS VDD sky130_fd_sc_hd__tapvpwrvgnd_1
XTAP_TAPCELL_ROW_213_4614 VSS VDD sky130_fd_sc_hd__tapvpwrvgnd_1
XTAP_TAPCELL_ROW_213_4615 VSS VDD sky130_fd_sc_hd__tapvpwrvgnd_1
XTAP_TAPCELL_ROW_213_4616 VSS VDD sky130_fd_sc_hd__tapvpwrvgnd_1
XTAP_TAPCELL_ROW_213_4617 VSS VDD sky130_fd_sc_hd__tapvpwrvgnd_1
XTAP_TAPCELL_ROW_213_4618 VSS VDD sky130_fd_sc_hd__tapvpwrvgnd_1
XTAP_TAPCELL_ROW_213_4619 VSS VDD sky130_fd_sc_hd__tapvpwrvgnd_1
XTAP_TAPCELL_ROW_213_4620 VSS VDD sky130_fd_sc_hd__tapvpwrvgnd_1
XTAP_TAPCELL_ROW_213_4621 VSS VDD sky130_fd_sc_hd__tapvpwrvgnd_1
XTAP_TAPCELL_ROW_214_4622 VSS VDD sky130_fd_sc_hd__tapvpwrvgnd_1
XTAP_TAPCELL_ROW_214_4623 VSS VDD sky130_fd_sc_hd__tapvpwrvgnd_1
XTAP_TAPCELL_ROW_214_4624 VSS VDD sky130_fd_sc_hd__tapvpwrvgnd_1
XTAP_TAPCELL_ROW_214_4625 VSS VDD sky130_fd_sc_hd__tapvpwrvgnd_1
XTAP_TAPCELL_ROW_214_4626 VSS VDD sky130_fd_sc_hd__tapvpwrvgnd_1
XTAP_TAPCELL_ROW_214_4627 VSS VDD sky130_fd_sc_hd__tapvpwrvgnd_1
XTAP_TAPCELL_ROW_214_4628 VSS VDD sky130_fd_sc_hd__tapvpwrvgnd_1
XTAP_TAPCELL_ROW_214_4629 VSS VDD sky130_fd_sc_hd__tapvpwrvgnd_1
XTAP_TAPCELL_ROW_214_4630 VSS VDD sky130_fd_sc_hd__tapvpwrvgnd_1
XTAP_TAPCELL_ROW_214_4631 VSS VDD sky130_fd_sc_hd__tapvpwrvgnd_1
XTAP_TAPCELL_ROW_214_4632 VSS VDD sky130_fd_sc_hd__tapvpwrvgnd_1
XTAP_TAPCELL_ROW_214_4633 VSS VDD sky130_fd_sc_hd__tapvpwrvgnd_1
XTAP_TAPCELL_ROW_214_4634 VSS VDD sky130_fd_sc_hd__tapvpwrvgnd_1
XTAP_TAPCELL_ROW_214_4635 VSS VDD sky130_fd_sc_hd__tapvpwrvgnd_1
XTAP_TAPCELL_ROW_214_4636 VSS VDD sky130_fd_sc_hd__tapvpwrvgnd_1
XTAP_TAPCELL_ROW_214_4637 VSS VDD sky130_fd_sc_hd__tapvpwrvgnd_1
XTAP_TAPCELL_ROW_214_4638 VSS VDD sky130_fd_sc_hd__tapvpwrvgnd_1
XTAP_TAPCELL_ROW_214_4639 VSS VDD sky130_fd_sc_hd__tapvpwrvgnd_1
XTAP_TAPCELL_ROW_214_4640 VSS VDD sky130_fd_sc_hd__tapvpwrvgnd_1
XTAP_TAPCELL_ROW_214_4641 VSS VDD sky130_fd_sc_hd__tapvpwrvgnd_1
XTAP_TAPCELL_ROW_214_4642 VSS VDD sky130_fd_sc_hd__tapvpwrvgnd_1
XTAP_TAPCELL_ROW_214_4643 VSS VDD sky130_fd_sc_hd__tapvpwrvgnd_1
XTAP_TAPCELL_ROW_215_4644 VSS VDD sky130_fd_sc_hd__tapvpwrvgnd_1
XTAP_TAPCELL_ROW_215_4645 VSS VDD sky130_fd_sc_hd__tapvpwrvgnd_1
XTAP_TAPCELL_ROW_215_4646 VSS VDD sky130_fd_sc_hd__tapvpwrvgnd_1
XTAP_TAPCELL_ROW_215_4647 VSS VDD sky130_fd_sc_hd__tapvpwrvgnd_1
XTAP_TAPCELL_ROW_215_4648 VSS VDD sky130_fd_sc_hd__tapvpwrvgnd_1
XTAP_TAPCELL_ROW_215_4649 VSS VDD sky130_fd_sc_hd__tapvpwrvgnd_1
XTAP_TAPCELL_ROW_215_4650 VSS VDD sky130_fd_sc_hd__tapvpwrvgnd_1
XTAP_TAPCELL_ROW_215_4651 VSS VDD sky130_fd_sc_hd__tapvpwrvgnd_1
XTAP_TAPCELL_ROW_215_4652 VSS VDD sky130_fd_sc_hd__tapvpwrvgnd_1
XTAP_TAPCELL_ROW_215_4653 VSS VDD sky130_fd_sc_hd__tapvpwrvgnd_1
XTAP_TAPCELL_ROW_215_4654 VSS VDD sky130_fd_sc_hd__tapvpwrvgnd_1
XTAP_TAPCELL_ROW_215_4655 VSS VDD sky130_fd_sc_hd__tapvpwrvgnd_1
XTAP_TAPCELL_ROW_215_4656 VSS VDD sky130_fd_sc_hd__tapvpwrvgnd_1
XTAP_TAPCELL_ROW_215_4657 VSS VDD sky130_fd_sc_hd__tapvpwrvgnd_1
XTAP_TAPCELL_ROW_215_4658 VSS VDD sky130_fd_sc_hd__tapvpwrvgnd_1
XTAP_TAPCELL_ROW_215_4659 VSS VDD sky130_fd_sc_hd__tapvpwrvgnd_1
XTAP_TAPCELL_ROW_215_4660 VSS VDD sky130_fd_sc_hd__tapvpwrvgnd_1
XTAP_TAPCELL_ROW_215_4661 VSS VDD sky130_fd_sc_hd__tapvpwrvgnd_1
XTAP_TAPCELL_ROW_215_4662 VSS VDD sky130_fd_sc_hd__tapvpwrvgnd_1
XTAP_TAPCELL_ROW_215_4663 VSS VDD sky130_fd_sc_hd__tapvpwrvgnd_1
XTAP_TAPCELL_ROW_215_4664 VSS VDD sky130_fd_sc_hd__tapvpwrvgnd_1
XTAP_TAPCELL_ROW_216_4665 VSS VDD sky130_fd_sc_hd__tapvpwrvgnd_1
XTAP_TAPCELL_ROW_216_4666 VSS VDD sky130_fd_sc_hd__tapvpwrvgnd_1
XTAP_TAPCELL_ROW_216_4667 VSS VDD sky130_fd_sc_hd__tapvpwrvgnd_1
XTAP_TAPCELL_ROW_216_4668 VSS VDD sky130_fd_sc_hd__tapvpwrvgnd_1
XTAP_TAPCELL_ROW_216_4669 VSS VDD sky130_fd_sc_hd__tapvpwrvgnd_1
XTAP_TAPCELL_ROW_216_4670 VSS VDD sky130_fd_sc_hd__tapvpwrvgnd_1
XTAP_TAPCELL_ROW_216_4671 VSS VDD sky130_fd_sc_hd__tapvpwrvgnd_1
XTAP_TAPCELL_ROW_216_4672 VSS VDD sky130_fd_sc_hd__tapvpwrvgnd_1
XTAP_TAPCELL_ROW_216_4673 VSS VDD sky130_fd_sc_hd__tapvpwrvgnd_1
XTAP_TAPCELL_ROW_216_4674 VSS VDD sky130_fd_sc_hd__tapvpwrvgnd_1
XTAP_TAPCELL_ROW_216_4675 VSS VDD sky130_fd_sc_hd__tapvpwrvgnd_1
XTAP_TAPCELL_ROW_216_4676 VSS VDD sky130_fd_sc_hd__tapvpwrvgnd_1
XTAP_TAPCELL_ROW_216_4677 VSS VDD sky130_fd_sc_hd__tapvpwrvgnd_1
XTAP_TAPCELL_ROW_216_4678 VSS VDD sky130_fd_sc_hd__tapvpwrvgnd_1
XTAP_TAPCELL_ROW_216_4679 VSS VDD sky130_fd_sc_hd__tapvpwrvgnd_1
XTAP_TAPCELL_ROW_216_4680 VSS VDD sky130_fd_sc_hd__tapvpwrvgnd_1
XTAP_TAPCELL_ROW_216_4681 VSS VDD sky130_fd_sc_hd__tapvpwrvgnd_1
XTAP_TAPCELL_ROW_216_4682 VSS VDD sky130_fd_sc_hd__tapvpwrvgnd_1
XTAP_TAPCELL_ROW_216_4683 VSS VDD sky130_fd_sc_hd__tapvpwrvgnd_1
XTAP_TAPCELL_ROW_216_4684 VSS VDD sky130_fd_sc_hd__tapvpwrvgnd_1
XTAP_TAPCELL_ROW_216_4685 VSS VDD sky130_fd_sc_hd__tapvpwrvgnd_1
XTAP_TAPCELL_ROW_216_4686 VSS VDD sky130_fd_sc_hd__tapvpwrvgnd_1
XTAP_TAPCELL_ROW_217_4687 VSS VDD sky130_fd_sc_hd__tapvpwrvgnd_1
XTAP_TAPCELL_ROW_217_4688 VSS VDD sky130_fd_sc_hd__tapvpwrvgnd_1
XTAP_TAPCELL_ROW_217_4689 VSS VDD sky130_fd_sc_hd__tapvpwrvgnd_1
XTAP_TAPCELL_ROW_217_4690 VSS VDD sky130_fd_sc_hd__tapvpwrvgnd_1
XTAP_TAPCELL_ROW_217_4691 VSS VDD sky130_fd_sc_hd__tapvpwrvgnd_1
XTAP_TAPCELL_ROW_217_4692 VSS VDD sky130_fd_sc_hd__tapvpwrvgnd_1
XTAP_TAPCELL_ROW_217_4693 VSS VDD sky130_fd_sc_hd__tapvpwrvgnd_1
XTAP_TAPCELL_ROW_217_4694 VSS VDD sky130_fd_sc_hd__tapvpwrvgnd_1
XTAP_TAPCELL_ROW_217_4695 VSS VDD sky130_fd_sc_hd__tapvpwrvgnd_1
XTAP_TAPCELL_ROW_217_4696 VSS VDD sky130_fd_sc_hd__tapvpwrvgnd_1
XTAP_TAPCELL_ROW_217_4697 VSS VDD sky130_fd_sc_hd__tapvpwrvgnd_1
XTAP_TAPCELL_ROW_217_4698 VSS VDD sky130_fd_sc_hd__tapvpwrvgnd_1
XTAP_TAPCELL_ROW_217_4699 VSS VDD sky130_fd_sc_hd__tapvpwrvgnd_1
XTAP_TAPCELL_ROW_217_4700 VSS VDD sky130_fd_sc_hd__tapvpwrvgnd_1
XTAP_TAPCELL_ROW_217_4701 VSS VDD sky130_fd_sc_hd__tapvpwrvgnd_1
XTAP_TAPCELL_ROW_217_4702 VSS VDD sky130_fd_sc_hd__tapvpwrvgnd_1
XTAP_TAPCELL_ROW_217_4703 VSS VDD sky130_fd_sc_hd__tapvpwrvgnd_1
XTAP_TAPCELL_ROW_217_4704 VSS VDD sky130_fd_sc_hd__tapvpwrvgnd_1
XTAP_TAPCELL_ROW_217_4705 VSS VDD sky130_fd_sc_hd__tapvpwrvgnd_1
XTAP_TAPCELL_ROW_217_4706 VSS VDD sky130_fd_sc_hd__tapvpwrvgnd_1
XTAP_TAPCELL_ROW_217_4707 VSS VDD sky130_fd_sc_hd__tapvpwrvgnd_1
XTAP_TAPCELL_ROW_217_4708 VSS VDD sky130_fd_sc_hd__tapvpwrvgnd_1
XTAP_TAPCELL_ROW_217_4709 VSS VDD sky130_fd_sc_hd__tapvpwrvgnd_1
XTAP_TAPCELL_ROW_217_4710 VSS VDD sky130_fd_sc_hd__tapvpwrvgnd_1
XTAP_TAPCELL_ROW_217_4711 VSS VDD sky130_fd_sc_hd__tapvpwrvgnd_1
XTAP_TAPCELL_ROW_217_4712 VSS VDD sky130_fd_sc_hd__tapvpwrvgnd_1
XTAP_TAPCELL_ROW_217_4713 VSS VDD sky130_fd_sc_hd__tapvpwrvgnd_1
XTAP_TAPCELL_ROW_217_4714 VSS VDD sky130_fd_sc_hd__tapvpwrvgnd_1
XTAP_TAPCELL_ROW_217_4715 VSS VDD sky130_fd_sc_hd__tapvpwrvgnd_1
XTAP_TAPCELL_ROW_217_4716 VSS VDD sky130_fd_sc_hd__tapvpwrvgnd_1
XTAP_TAPCELL_ROW_217_4717 VSS VDD sky130_fd_sc_hd__tapvpwrvgnd_1
XTAP_TAPCELL_ROW_217_4718 VSS VDD sky130_fd_sc_hd__tapvpwrvgnd_1
XTAP_TAPCELL_ROW_217_4719 VSS VDD sky130_fd_sc_hd__tapvpwrvgnd_1
XTAP_TAPCELL_ROW_217_4720 VSS VDD sky130_fd_sc_hd__tapvpwrvgnd_1
XTAP_TAPCELL_ROW_217_4721 VSS VDD sky130_fd_sc_hd__tapvpwrvgnd_1
XTAP_TAPCELL_ROW_217_4722 VSS VDD sky130_fd_sc_hd__tapvpwrvgnd_1
XTAP_TAPCELL_ROW_217_4723 VSS VDD sky130_fd_sc_hd__tapvpwrvgnd_1
XTAP_TAPCELL_ROW_217_4724 VSS VDD sky130_fd_sc_hd__tapvpwrvgnd_1
XTAP_TAPCELL_ROW_217_4725 VSS VDD sky130_fd_sc_hd__tapvpwrvgnd_1
XTAP_TAPCELL_ROW_217_4726 VSS VDD sky130_fd_sc_hd__tapvpwrvgnd_1
XTAP_TAPCELL_ROW_217_4727 VSS VDD sky130_fd_sc_hd__tapvpwrvgnd_1
XTAP_TAPCELL_ROW_217_4728 VSS VDD sky130_fd_sc_hd__tapvpwrvgnd_1
XTAP_TAPCELL_ROW_217_4729 VSS VDD sky130_fd_sc_hd__tapvpwrvgnd_1
Xclkload37 clknet_leaf_176_clk_net VSS VSS VDD VDD _unconnected_55
+ sky130_fd_sc_hd__clkbuf_8
Xclkload38 clknet_leaf_179_clk_net VSS VSS VDD VDD _unconnected_56
+ sky130_fd_sc_hd__clkbuf_1
Xclkload39 clknet_leaf_4_clk_net VSS VSS VDD VDD _unconnected_57
+ sky130_fd_sc_hd__clkbuf_8
Xclkload40 clknet_leaf_5_clk_net VSS VSS VDD VDD _unconnected_58
+ sky130_fd_sc_hd__clkinv_1
Xclkload41 clknet_leaf_6_clk_net VSS VSS VDD VDD _unconnected_59
+ sky130_fd_sc_hd__clkbuf_1
Xclkload42 clknet_leaf_7_clk_net VSS VSS VDD VDD _unconnected_60
+ sky130_fd_sc_hd__clkinv_2
Xclkload43 clknet_leaf_8_clk_net VSS VSS VDD VDD _unconnected_61
+ sky130_fd_sc_hd__clkbuf_1
Xclkload44 clknet_leaf_9_clk_net VSS VSS VDD VDD _unconnected_62
+ sky130_fd_sc_hd__clkbuf_8
Xclkload45 clknet_leaf_10_clk_net VSS VSS VDD VDD _unconnected_63
+ sky130_fd_sc_hd__clkbuf_8
Xclkload46 clknet_leaf_12_clk_net VSS VSS VDD VDD _unconnected_64
+ sky130_fd_sc_hd__clkbuf_1
Xclkload47 clknet_leaf_13_clk_net VSS VSS VDD VDD _unconnected_65
+ sky130_fd_sc_hd__clkbuf_8
Xclkload48 clknet_leaf_14_clk_net VSS VSS VDD VDD _unconnected_66
+ sky130_fd_sc_hd__clkbuf_8
Xclkload49 clknet_leaf_15_clk_net VSS VSS VDD VDD _unconnected_67
+ sky130_fd_sc_hd__clkinv_2
Xclkload50 clknet_leaf_16_clk_net VSS VSS VDD VDD _unconnected_68
+ sky130_fd_sc_hd__clkbuf_8
Xclkload51 clknet_leaf_18_clk_net VSS VSS VDD VDD _unconnected_69
+ sky130_fd_sc_hd__clkbuf_1
Xclkload52 clknet_leaf_19_clk_net VSS VSS VDD VDD _unconnected_70
+ sky130_fd_sc_hd__clkbuf_8
Xclkload53 clknet_leaf_21_clk_net VSS VSS VDD VDD _unconnected_71
+ sky130_fd_sc_hd__clkbuf_8
Xclkload54 clknet_leaf_22_clk_net VSS VSS VDD VDD _unconnected_72
+ sky130_fd_sc_hd__clkinv_2
Xclkload55 clknet_leaf_157_clk_net VSS VSS VDD VDD _unconnected_73
+ sky130_fd_sc_hd__clkbuf_8
Xclkload56 clknet_leaf_160_clk_net VSS VSS VDD VDD _unconnected_74
+ sky130_fd_sc_hd__clkbuf_1
Xclkload57 clknet_leaf_161_clk_net VSS VSS VDD VDD _unconnected_75
+ sky130_fd_sc_hd__clkbuf_1
Xclkload58 clknet_leaf_162_clk_net VSS VSS VDD VDD _unconnected_76
+ sky130_fd_sc_hd__clkbuf_1
Xclkload59 clknet_leaf_163_clk_net VSS VSS VDD VDD _unconnected_77
+ sky130_fd_sc_hd__clkbuf_16
Xclkload60 clknet_leaf_164_clk_net VSS VSS VDD VDD _unconnected_78
+ sky130_fd_sc_hd__clkbuf_8
Xclkload61 clknet_leaf_165_clk_net VSS VSS VDD VDD _unconnected_79
+ sky130_fd_sc_hd__clkbuf_8
Xclkload62 clknet_leaf_166_clk_net VSS VSS VDD VDD _unconnected_80
+ sky130_fd_sc_hd__clkbuf_16
Xclkload63 clknet_leaf_139_clk_net VSS VSS VDD VDD _unconnected_81
+ sky130_fd_sc_hd__clkbuf_16
Xclkload64 clknet_leaf_141_clk_net VSS VSS VDD VDD _unconnected_82
+ sky130_fd_sc_hd__clkinv_2
Xclkload65 clknet_leaf_142_clk_net VSS VSS VDD VDD _unconnected_83
+ sky130_fd_sc_hd__clkbuf_1
Xclkload66 clknet_leaf_144_clk_net VSS VSS VDD VDD _unconnected_84
+ sky130_fd_sc_hd__clkbuf_16
Xclkload67 clknet_leaf_145_clk_net VSS VSS VDD VDD _unconnected_85
+ sky130_fd_sc_hd__clkinv_2
Xclkload68 clknet_leaf_146_clk_net VSS VSS VDD VDD _unconnected_86
+ sky130_fd_sc_hd__clkbuf_16
Xclkload69 clknet_leaf_147_clk_net VSS VSS VDD VDD _unconnected_87
+ sky130_fd_sc_hd__clkbuf_8
Xclkload70 clknet_leaf_149_clk_net VSS VSS VDD VDD _unconnected_88
+ sky130_fd_sc_hd__clkbuf_8
Xclkload71 clknet_leaf_151_clk_net VSS VSS VDD VDD _unconnected_89
+ sky130_fd_sc_hd__inv_4
Xclkload72 clknet_leaf_152_clk_net VSS VSS VDD VDD _unconnected_90
+ sky130_fd_sc_hd__clkbuf_16
Xclkload73 clknet_leaf_153_clk_net VSS VSS VDD VDD _unconnected_91
+ sky130_fd_sc_hd__clkbuf_8
Xclkload74 clknet_leaf_127_clk_net VSS VSS VDD VDD _unconnected_92
+ sky130_fd_sc_hd__clkbuf_16
Xclkload75 clknet_leaf_128_clk_net VSS VSS VDD VDD _unconnected_93
+ sky130_fd_sc_hd__clkbuf_16
Xclkload76 clknet_leaf_129_clk_net VSS VSS VDD VDD _unconnected_94
+ sky130_fd_sc_hd__clkinv_2
Xclkload77 clknet_leaf_130_clk_net VSS VSS VDD VDD _unconnected_95
+ sky130_fd_sc_hd__clkbuf_16
Xclkload78 clknet_leaf_131_clk_net VSS VSS VDD VDD _unconnected_96
+ sky130_fd_sc_hd__clkinv_2
Xclkload79 clknet_leaf_132_clk_net VSS VSS VDD VDD _unconnected_97
+ sky130_fd_sc_hd__clkbuf_8
Xclkload80 clknet_leaf_133_clk_net VSS VSS VDD VDD _unconnected_98
+ sky130_fd_sc_hd__clkinv_2
Xclkload81 clknet_leaf_135_clk_net VSS VSS VDD VDD _unconnected_99
+ sky130_fd_sc_hd__clkbuf_8
Xclkload82 clknet_leaf_136_clk_net VSS VSS VDD VDD _unconnected_100
+ sky130_fd_sc_hd__clkbuf_1
Xclkload83 clknet_leaf_137_clk_net VSS VSS VDD VDD _unconnected_101
+ sky130_fd_sc_hd__clkbuf_8
Xclkload84 clknet_leaf_138_clk_net VSS VSS VDD VDD _unconnected_102
+ sky130_fd_sc_hd__inv_4
Xclkload85 clknet_leaf_140_clk_net VSS VSS VDD VDD _unconnected_103
+ sky130_fd_sc_hd__clkbuf_8
Xclkload86 clknet_leaf_107_clk_net VSS VSS VDD VDD _unconnected_104
+ sky130_fd_sc_hd__clkbuf_1
Xclkload87 clknet_leaf_108_clk_net VSS VSS VDD VDD _unconnected_105
+ sky130_fd_sc_hd__clkinv_1
Xclkload88 clknet_leaf_109_clk_net VSS VSS VDD VDD _unconnected_106
+ sky130_fd_sc_hd__clkbuf_1
Xclkload89 clknet_leaf_110_clk_net VSS VSS VDD VDD _unconnected_107
+ sky130_fd_sc_hd__clkinv_1
Xclkload90 clknet_leaf_112_clk_net VSS VSS VDD VDD _unconnected_108
+ sky130_fd_sc_hd__clkinv_1
Xclkload91 clknet_leaf_154_clk_net VSS VSS VDD VDD _unconnected_109
+ sky130_fd_sc_hd__clkinv_1
Xclkload92 clknet_leaf_155_clk_net VSS VSS VDD VDD _unconnected_110
+ sky130_fd_sc_hd__clkinv_1
Xclkload93 clknet_leaf_156_clk_net VSS VSS VDD VDD _unconnected_111
+ sky130_fd_sc_hd__clkinv_2
Xclkload94 clknet_leaf_158_clk_net VSS VSS VDD VDD _unconnected_112
+ sky130_fd_sc_hd__clkbuf_1
Xclkload95 clknet_leaf_159_clk_net VSS VSS VDD VDD _unconnected_113
+ sky130_fd_sc_hd__clkinv_2
Xclkload96 clknet_leaf_98_clk_net VSS VSS VDD VDD _unconnected_114
+ sky130_fd_sc_hd__clkbuf_1
Xclkload97 clknet_leaf_113_clk_net VSS VSS VDD VDD _unconnected_115
+ sky130_fd_sc_hd__clkinv_2
Xclkload98 clknet_leaf_114_clk_net VSS VSS VDD VDD _unconnected_116
+ sky130_fd_sc_hd__clkbuf_16
Xclkload99 clknet_leaf_115_clk_net VSS VSS VDD VDD _unconnected_117
+ sky130_fd_sc_hd__clkbuf_8
Xclkload100 clknet_leaf_116_clk_net VSS VSS VDD VDD _unconnected_118
+ sky130_fd_sc_hd__clkbuf_8
Xclkload101 clknet_leaf_117_clk_net VSS VSS VDD VDD _unconnected_119
+ sky130_fd_sc_hd__clkbuf_1
Xclkload102 clknet_leaf_118_clk_net VSS VSS VDD VDD _unconnected_120
+ sky130_fd_sc_hd__clkbuf_8
Xclkload103 clknet_leaf_119_clk_net VSS VSS VDD VDD _unconnected_121
+ sky130_fd_sc_hd__clkbuf_8
Xclkload104 clknet_leaf_120_clk_net VSS VSS VDD VDD _unconnected_122
+ sky130_fd_sc_hd__clkbuf_1
Xclkload105 clknet_leaf_122_clk_net VSS VSS VDD VDD _unconnected_123
+ sky130_fd_sc_hd__clkbuf_8
Xclkload106 clknet_leaf_123_clk_net VSS VSS VDD VDD _unconnected_124
+ sky130_fd_sc_hd__clkbuf_8
Xclkload107 clknet_leaf_124_clk_net VSS VSS VDD VDD _unconnected_125
+ sky130_fd_sc_hd__clkbuf_8
Xclkload108 clknet_leaf_125_clk_net VSS VSS VDD VDD _unconnected_126
+ sky130_fd_sc_hd__clkbuf_8
Xclkload109 clknet_leaf_126_clk_net VSS VSS VDD VDD _unconnected_127
+ sky130_fd_sc_hd__clkbuf_16
Xclkload110 clknet_leaf_11_clk_net VSS VSS VDD VDD _unconnected_128
+ sky130_fd_sc_hd__clkinv_2
Xclkload111 clknet_leaf_32_clk_net VSS VSS VDD VDD _unconnected_129
+ sky130_fd_sc_hd__clkbuf_1
Xclkload112 clknet_leaf_33_clk_net VSS VSS VDD VDD _unconnected_130
+ sky130_fd_sc_hd__clkbuf_8
Xclkload113 clknet_leaf_35_clk_net VSS VSS VDD VDD _unconnected_131
+ sky130_fd_sc_hd__clkinv_2
Xclkload114 clknet_leaf_36_clk_net VSS VSS VDD VDD _unconnected_132
+ sky130_fd_sc_hd__clkbuf_1
Xclkload115 clknet_leaf_37_clk_net VSS VSS VDD VDD _unconnected_133
+ sky130_fd_sc_hd__clkinv_1
Xclkload116 clknet_leaf_39_clk_net VSS VSS VDD VDD _unconnected_134
+ sky130_fd_sc_hd__clkbuf_1
Xclkload117 clknet_leaf_40_clk_net VSS VSS VDD VDD _unconnected_135
+ sky130_fd_sc_hd__clkbuf_1
Xclkload118 clknet_leaf_43_clk_net VSS VSS VDD VDD _unconnected_136
+ sky130_fd_sc_hd__clkbuf_1
Xclkload119 clknet_leaf_23_clk_net VSS VSS VDD VDD _unconnected_137
+ sky130_fd_sc_hd__clkbuf_8
Xclkload120 clknet_leaf_24_clk_net VSS VSS VDD VDD _unconnected_138
+ sky130_fd_sc_hd__clkbuf_1
Xclkload121 clknet_leaf_25_clk_net VSS VSS VDD VDD _unconnected_139
+ sky130_fd_sc_hd__clkinv_1
Xclkload122 clknet_leaf_26_clk_net VSS VSS VDD VDD _unconnected_140
+ sky130_fd_sc_hd__clkbuf_1
Xclkload123 clknet_leaf_27_clk_net VSS VSS VDD VDD _unconnected_141
+ sky130_fd_sc_hd__clkinv_1
Xclkload124 clknet_leaf_28_clk_net VSS VSS VDD VDD _unconnected_142
+ sky130_fd_sc_hd__clkbuf_8
Xclkload125 clknet_leaf_29_clk_net VSS VSS VDD VDD _unconnected_143
+ sky130_fd_sc_hd__clkbuf_1
Xclkload126 clknet_leaf_34_clk_net VSS VSS VDD VDD _unconnected_144
+ sky130_fd_sc_hd__clkinv_1
Xclkload127 clknet_leaf_30_clk_net VSS VSS VDD VDD _unconnected_145
+ sky130_fd_sc_hd__inv_4
Xclkload128 clknet_leaf_31_clk_net VSS VSS VDD VDD _unconnected_146
+ sky130_fd_sc_hd__clkinv_4
Xclkload129 clknet_leaf_41_clk_net VSS VSS VDD VDD _unconnected_147
+ sky130_fd_sc_hd__clkbuf_16
Xclkload130 clknet_leaf_42_clk_net VSS VSS VDD VDD _unconnected_148
+ sky130_fd_sc_hd__inv_4
Xclkload131 clknet_leaf_44_clk_net VSS VSS VDD VDD _unconnected_149
+ sky130_fd_sc_hd__clkinv_2
Xclkload132 clknet_leaf_45_clk_net VSS VSS VDD VDD _unconnected_150
+ sky130_fd_sc_hd__clkbuf_16
Xclkload133 clknet_leaf_46_clk_net VSS VSS VDD VDD _unconnected_151
+ sky130_fd_sc_hd__inv_4
Xclkload134 clknet_leaf_47_clk_net VSS VSS VDD VDD _unconnected_152
+ sky130_fd_sc_hd__inv_6
Xclkload135 clknet_leaf_48_clk_net VSS VSS VDD VDD _unconnected_153
+ sky130_fd_sc_hd__clkinv_2
Xclkload136 clknet_leaf_49_clk_net VSS VSS VDD VDD _unconnected_154
+ sky130_fd_sc_hd__clkinv_2
Xclkload137 clknet_leaf_50_clk_net VSS VSS VDD VDD _unconnected_155
+ sky130_fd_sc_hd__clkbuf_1
Xclkload138 clknet_leaf_51_clk_net VSS VSS VDD VDD _unconnected_156
+ sky130_fd_sc_hd__clkbuf_8
Xclkload139 clknet_leaf_53_clk_net VSS VSS VDD VDD _unconnected_157
+ sky130_fd_sc_hd__clkbuf_1
Xclkload140 clknet_leaf_54_clk_net VSS VSS VDD VDD _unconnected_158
+ sky130_fd_sc_hd__clkbuf_1
Xclkload141 clknet_leaf_55_clk_net VSS VSS VDD VDD _unconnected_159
+ sky130_fd_sc_hd__clkbuf_8
Xclkload142 clknet_leaf_60_clk_net VSS VSS VDD VDD _unconnected_160
+ sky130_fd_sc_hd__clkbuf_1
Xclkload143 clknet_leaf_61_clk_net VSS VSS VDD VDD _unconnected_161
+ sky130_fd_sc_hd__clkbuf_1
Xclkload144 clknet_leaf_63_clk_net VSS VSS VDD VDD _unconnected_162
+ sky130_fd_sc_hd__clkbuf_1
Xclkload145 clknet_leaf_64_clk_net VSS VSS VDD VDD _unconnected_163
+ sky130_fd_sc_hd__clkbuf_1
Xclkload146 clknet_leaf_65_clk_net VSS VSS VDD VDD _unconnected_164
+ sky130_fd_sc_hd__clkbuf_8
Xclkload147 clknet_leaf_66_clk_net VSS VSS VDD VDD _unconnected_165
+ sky130_fd_sc_hd__clkbuf_1
Xclkload148 clknet_leaf_69_clk_net VSS VSS VDD VDD _unconnected_166
+ sky130_fd_sc_hd__clkinv_2
Xclkload149 clknet_leaf_70_clk_net VSS VSS VDD VDD _unconnected_167
+ sky130_fd_sc_hd__clkbuf_8
Xclkload150 clknet_leaf_71_clk_net VSS VSS VDD VDD _unconnected_168
+ sky130_fd_sc_hd__clkbuf_1
Xclkload151 clknet_leaf_72_clk_net VSS VSS VDD VDD _unconnected_169
+ sky130_fd_sc_hd__clkbuf_1
Xclkload152 clknet_leaf_73_clk_net VSS VSS VDD VDD _unconnected_170
+ sky130_fd_sc_hd__clkbuf_8
Xclkload153 clknet_leaf_74_clk_net VSS VSS VDD VDD _unconnected_171
+ sky130_fd_sc_hd__clkinv_2
Xclkload154 clknet_leaf_75_clk_net VSS VSS VDD VDD _unconnected_172
+ sky130_fd_sc_hd__clkbuf_1
Xclkload155 clknet_leaf_104_clk_net VSS VSS VDD VDD _unconnected_173
+ sky130_fd_sc_hd__clkbuf_1
Xclkload156 clknet_leaf_105_clk_net VSS VSS VDD VDD _unconnected_174
+ sky130_fd_sc_hd__clkbuf_1
Xclkload157 clknet_leaf_106_clk_net VSS VSS VDD VDD _unconnected_175
+ sky130_fd_sc_hd__clkinv_2
Xclkload158 clknet_leaf_92_clk_net VSS VSS VDD VDD _unconnected_176
+ sky130_fd_sc_hd__clkbuf_1
Xclkload159 clknet_leaf_93_clk_net VSS VSS VDD VDD _unconnected_177
+ sky130_fd_sc_hd__clkbuf_1
Xclkload160 clknet_leaf_95_clk_net VSS VSS VDD VDD _unconnected_178
+ sky130_fd_sc_hd__clkbuf_1
Xclkload161 clknet_leaf_96_clk_net VSS VSS VDD VDD _unconnected_179
+ sky130_fd_sc_hd__clkbuf_8
Xclkload162 clknet_leaf_99_clk_net VSS VSS VDD VDD _unconnected_180
+ sky130_fd_sc_hd__clkbuf_8
Xclkload163 clknet_leaf_100_clk_net VSS VSS VDD VDD _unconnected_181
+ sky130_fd_sc_hd__inv_4
Xclkload164 clknet_leaf_101_clk_net VSS VSS VDD VDD _unconnected_182
+ sky130_fd_sc_hd__clkbuf_1
Xclkload165 clknet_leaf_102_clk_net VSS VSS VDD VDD _unconnected_183
+ sky130_fd_sc_hd__inv_4
Xclkload166 clknet_leaf_103_clk_net VSS VSS VDD VDD _unconnected_184
+ sky130_fd_sc_hd__clkbuf_1
Xclkload167 clknet_leaf_56_clk_net VSS VSS VDD VDD _unconnected_185
+ sky130_fd_sc_hd__clkinv_2
Xclkload168 clknet_leaf_57_clk_net VSS VSS VDD VDD _unconnected_186
+ sky130_fd_sc_hd__clkinv_2
Xclkload169 clknet_leaf_58_clk_net VSS VSS VDD VDD _unconnected_187
+ sky130_fd_sc_hd__clkbuf_8
Xclkload170 clknet_leaf_59_clk_net VSS VSS VDD VDD _unconnected_188
+ sky130_fd_sc_hd__clkinv_2
Xclkload171 clknet_leaf_77_clk_net VSS VSS VDD VDD _unconnected_189
+ sky130_fd_sc_hd__clkbuf_8
Xclkload172 clknet_leaf_78_clk_net VSS VSS VDD VDD _unconnected_190
+ sky130_fd_sc_hd__clkbuf_8
Xclkload173 clknet_leaf_79_clk_net VSS VSS VDD VDD _unconnected_191
+ sky130_fd_sc_hd__clkbuf_8
Xclkload174 clknet_leaf_80_clk_net VSS VSS VDD VDD _unconnected_192
+ sky130_fd_sc_hd__clkbuf_1
Xclkload175 clknet_leaf_82_clk_net VSS VSS VDD VDD _unconnected_193
+ sky130_fd_sc_hd__clkinv_2
Xclkload176 clknet_leaf_76_clk_net VSS VSS VDD VDD _unconnected_194
+ sky130_fd_sc_hd__clkbuf_16
Xclkload177 clknet_leaf_83_clk_net VSS VSS VDD VDD _unconnected_195
+ sky130_fd_sc_hd__clkinv_2
Xclkload178 clknet_leaf_84_clk_net VSS VSS VDD VDD _unconnected_196
+ sky130_fd_sc_hd__clkbuf_16
Xclkload179 clknet_leaf_85_clk_net VSS VSS VDD VDD _unconnected_197
+ sky130_fd_sc_hd__clkbuf_16
Xclkload180 clknet_leaf_86_clk_net VSS VSS VDD VDD _unconnected_198
+ sky130_fd_sc_hd__inv_4
Xclkload181 clknet_leaf_87_clk_net VSS VSS VDD VDD _unconnected_199
+ sky130_fd_sc_hd__clkinv_4
Xclkload182 clknet_leaf_88_clk_net VSS VSS VDD VDD _unconnected_200
+ sky130_fd_sc_hd__clkbuf_8
Xclkload183 clknet_leaf_89_clk_net VSS VSS VDD VDD _unconnected_201
+ sky130_fd_sc_hd__bufinv_16
Xclkload184 clknet_leaf_91_clk_net VSS VSS VDD VDD _unconnected_202
+ sky130_fd_sc_hd__clkbuf_8
Xclkbuf_leaf_0_clk_load clknet_4_0__leaf_clk_load VSS VSS
+ VDD VDD clknet_leaf_0_clk_load sky130_fd_sc_hd__clkbuf_16
Xclkbuf_leaf_1_clk_load clknet_4_0__leaf_clk_load VSS VSS
+ VDD VDD clknet_leaf_1_clk_load sky130_fd_sc_hd__clkbuf_16
Xclkbuf_leaf_2_clk_load clknet_4_0__leaf_clk_load VSS VSS
+ VDD VDD clknet_leaf_2_clk_load sky130_fd_sc_hd__clkbuf_16
Xclkbuf_leaf_3_clk_load clknet_4_0__leaf_clk_load VSS VSS
+ VDD VDD clknet_leaf_3_clk_load sky130_fd_sc_hd__clkbuf_16
Xclkbuf_leaf_4_clk_load clknet_4_2__leaf_clk_load VSS VSS
+ VDD VDD clknet_leaf_4_clk_load sky130_fd_sc_hd__clkbuf_16
Xclkbuf_leaf_5_clk_load clknet_4_2__leaf_clk_load VSS VSS
+ VDD VDD clknet_leaf_5_clk_load sky130_fd_sc_hd__clkbuf_16
Xclkbuf_leaf_6_clk_load clknet_4_2__leaf_clk_load VSS VSS
+ VDD VDD clknet_leaf_6_clk_load sky130_fd_sc_hd__clkbuf_16
Xclkbuf_leaf_7_clk_load clknet_4_2__leaf_clk_load VSS VSS
+ VDD VDD clknet_leaf_7_clk_load sky130_fd_sc_hd__clkbuf_16
Xclkbuf_leaf_8_clk_load clknet_4_2__leaf_clk_load VSS VSS
+ VDD VDD clknet_leaf_8_clk_load sky130_fd_sc_hd__clkbuf_16
Xclkbuf_leaf_9_clk_load clknet_4_2__leaf_clk_load VSS VSS
+ VDD VDD clknet_leaf_9_clk_load sky130_fd_sc_hd__clkbuf_16
Xclkbuf_leaf_10_clk_load clknet_4_9__leaf_clk_load VSS VSS
+ VDD VDD clknet_leaf_10_clk_load sky130_fd_sc_hd__clkbuf_16
Xclkbuf_leaf_11_clk_load clknet_4_2__leaf_clk_load VSS VSS
+ VDD VDD clknet_leaf_11_clk_load sky130_fd_sc_hd__clkbuf_16
Xclkbuf_leaf_12_clk_load clknet_4_2__leaf_clk_load VSS VSS
+ VDD VDD clknet_leaf_12_clk_load sky130_fd_sc_hd__clkbuf_16
Xclkbuf_leaf_13_clk_load clknet_4_3__leaf_clk_load VSS VSS
+ VDD VDD clknet_leaf_13_clk_load sky130_fd_sc_hd__clkbuf_16
Xclkbuf_leaf_14_clk_load clknet_4_3__leaf_clk_load VSS VSS
+ VDD VDD clknet_leaf_14_clk_load sky130_fd_sc_hd__clkbuf_16
Xclkbuf_leaf_15_clk_load clknet_4_3__leaf_clk_load VSS VSS
+ VDD VDD clknet_leaf_15_clk_load sky130_fd_sc_hd__clkbuf_16
Xclkbuf_leaf_16_clk_load clknet_4_3__leaf_clk_load VSS VSS
+ VDD VDD clknet_leaf_16_clk_load sky130_fd_sc_hd__clkbuf_16
Xclkbuf_leaf_17_clk_load clknet_4_9__leaf_clk_load VSS VSS
+ VDD VDD clknet_leaf_17_clk_load sky130_fd_sc_hd__clkbuf_16
Xclkbuf_leaf_18_clk_load clknet_4_9__leaf_clk_load VSS VSS
+ VDD VDD clknet_leaf_18_clk_load sky130_fd_sc_hd__clkbuf_16
Xclkbuf_leaf_19_clk_load clknet_4_9__leaf_clk_load VSS VSS
+ VDD VDD clknet_leaf_19_clk_load sky130_fd_sc_hd__clkbuf_16
Xclkbuf_leaf_20_clk_load clknet_4_9__leaf_clk_load VSS VSS
+ VDD VDD clknet_leaf_20_clk_load sky130_fd_sc_hd__clkbuf_16
Xclkbuf_leaf_21_clk_load clknet_4_9__leaf_clk_load VSS VSS
+ VDD VDD clknet_leaf_21_clk_load sky130_fd_sc_hd__clkbuf_16
Xclkbuf_leaf_22_clk_load clknet_4_11__leaf_clk_load VSS VSS
+ VDD VDD clknet_leaf_22_clk_load sky130_fd_sc_hd__clkbuf_16
Xclkbuf_leaf_23_clk_load clknet_4_8__leaf_clk_load VSS VSS
+ VDD VDD clknet_leaf_23_clk_load sky130_fd_sc_hd__clkbuf_16
Xclkbuf_leaf_24_clk_load clknet_4_9__leaf_clk_load VSS VSS
+ VDD VDD clknet_leaf_24_clk_load sky130_fd_sc_hd__clkbuf_16
Xclkbuf_leaf_25_clk_load clknet_4_8__leaf_clk_load VSS VSS
+ VDD VDD clknet_leaf_25_clk_load sky130_fd_sc_hd__clkbuf_16
Xclkbuf_leaf_26_clk_load clknet_4_8__leaf_clk_load VSS VSS
+ VDD VDD clknet_leaf_26_clk_load sky130_fd_sc_hd__clkbuf_16
Xclkbuf_leaf_27_clk_load clknet_4_8__leaf_clk_load VSS VSS
+ VDD VDD clknet_leaf_27_clk_load sky130_fd_sc_hd__clkbuf_16
Xclkbuf_leaf_28_clk_load clknet_4_8__leaf_clk_load VSS VSS
+ VDD VDD clknet_leaf_28_clk_load sky130_fd_sc_hd__clkbuf_16
Xclkbuf_leaf_29_clk_load clknet_4_8__leaf_clk_load VSS VSS
+ VDD VDD clknet_leaf_29_clk_load sky130_fd_sc_hd__clkbuf_16
Xclkbuf_leaf_30_clk_load clknet_4_10__leaf_clk_load VSS VSS
+ VDD VDD clknet_leaf_30_clk_load sky130_fd_sc_hd__clkbuf_16
Xclkbuf_leaf_31_clk_load clknet_4_10__leaf_clk_load VSS VSS
+ VDD VDD clknet_leaf_31_clk_load sky130_fd_sc_hd__clkbuf_16
Xclkbuf_leaf_32_clk_load clknet_4_10__leaf_clk_load VSS VSS
+ VDD VDD clknet_leaf_32_clk_load sky130_fd_sc_hd__clkbuf_16
Xclkbuf_leaf_33_clk_load clknet_4_10__leaf_clk_load VSS VSS
+ VDD VDD clknet_leaf_33_clk_load sky130_fd_sc_hd__clkbuf_16
Xclkbuf_leaf_34_clk_load clknet_4_10__leaf_clk_load VSS VSS
+ VDD VDD clknet_leaf_34_clk_load sky130_fd_sc_hd__clkbuf_16
Xclkbuf_leaf_35_clk_load clknet_4_10__leaf_clk_load VSS VSS
+ VDD VDD clknet_leaf_35_clk_load sky130_fd_sc_hd__clkbuf_16
Xclkbuf_leaf_36_clk_load clknet_4_11__leaf_clk_load VSS VSS
+ VDD VDD clknet_leaf_36_clk_load sky130_fd_sc_hd__clkbuf_16
Xclkbuf_leaf_37_clk_load clknet_4_11__leaf_clk_load VSS VSS
+ VDD VDD clknet_leaf_37_clk_load sky130_fd_sc_hd__clkbuf_16
Xclkbuf_leaf_38_clk_load clknet_4_11__leaf_clk_load VSS VSS
+ VDD VDD clknet_leaf_38_clk_load sky130_fd_sc_hd__clkbuf_16
Xclkbuf_leaf_39_clk_load clknet_4_14__leaf_clk_load VSS VSS
+ VDD VDD clknet_leaf_39_clk_load sky130_fd_sc_hd__clkbuf_16
Xclkbuf_leaf_40_clk_load clknet_4_14__leaf_clk_load VSS VSS
+ VDD VDD clknet_leaf_40_clk_load sky130_fd_sc_hd__clkbuf_16
Xclkbuf_leaf_41_clk_load clknet_4_14__leaf_clk_load VSS VSS
+ VDD VDD clknet_leaf_41_clk_load sky130_fd_sc_hd__clkbuf_16
Xclkbuf_leaf_42_clk_load clknet_4_14__leaf_clk_load VSS VSS
+ VDD VDD clknet_leaf_42_clk_load sky130_fd_sc_hd__clkbuf_16
Xclkbuf_leaf_43_clk_load clknet_4_14__leaf_clk_load VSS VSS
+ VDD VDD clknet_leaf_43_clk_load sky130_fd_sc_hd__clkbuf_16
Xclkbuf_leaf_44_clk_load clknet_4_11__leaf_clk_load VSS VSS
+ VDD VDD clknet_leaf_44_clk_load sky130_fd_sc_hd__clkbuf_16
Xclkbuf_leaf_45_clk_load clknet_4_11__leaf_clk_load VSS VSS
+ VDD VDD clknet_leaf_45_clk_load sky130_fd_sc_hd__clkbuf_16
Xclkbuf_leaf_46_clk_load clknet_4_12__leaf_clk_load VSS VSS
+ VDD VDD clknet_leaf_46_clk_load sky130_fd_sc_hd__clkbuf_16
Xclkbuf_leaf_47_clk_load clknet_4_12__leaf_clk_load VSS VSS
+ VDD VDD clknet_leaf_47_clk_load sky130_fd_sc_hd__clkbuf_16
Xclkbuf_leaf_48_clk_load clknet_4_12__leaf_clk_load VSS VSS
+ VDD VDD clknet_leaf_48_clk_load sky130_fd_sc_hd__clkbuf_16
Xclkbuf_leaf_49_clk_load clknet_4_12__leaf_clk_load VSS VSS
+ VDD VDD clknet_leaf_49_clk_load sky130_fd_sc_hd__clkbuf_16
Xclkbuf_leaf_50_clk_load clknet_4_12__leaf_clk_load VSS VSS
+ VDD VDD clknet_leaf_50_clk_load sky130_fd_sc_hd__clkbuf_16
Xclkbuf_leaf_51_clk_load clknet_4_13__leaf_clk_load VSS VSS
+ VDD VDD clknet_leaf_51_clk_load sky130_fd_sc_hd__clkbuf_16
Xclkbuf_leaf_52_clk_load clknet_4_15__leaf_clk_load VSS VSS
+ VDD VDD clknet_leaf_52_clk_load sky130_fd_sc_hd__clkbuf_16
Xclkbuf_leaf_53_clk_load clknet_4_14__leaf_clk_load VSS VSS
+ VDD VDD clknet_leaf_53_clk_load sky130_fd_sc_hd__clkbuf_16
Xclkbuf_leaf_54_clk_load clknet_4_14__leaf_clk_load VSS VSS
+ VDD VDD clknet_leaf_54_clk_load sky130_fd_sc_hd__clkbuf_16
Xclkbuf_leaf_55_clk_load clknet_4_14__leaf_clk_load VSS VSS
+ VDD VDD clknet_leaf_55_clk_load sky130_fd_sc_hd__clkbuf_16
Xclkbuf_leaf_56_clk_load clknet_4_14__leaf_clk_load VSS VSS
+ VDD VDD clknet_leaf_56_clk_load sky130_fd_sc_hd__clkbuf_16
Xclkbuf_leaf_57_clk_load clknet_4_15__leaf_clk_load VSS VSS
+ VDD VDD clknet_leaf_57_clk_load sky130_fd_sc_hd__clkbuf_16
Xclkbuf_leaf_58_clk_load clknet_4_15__leaf_clk_load VSS VSS
+ VDD VDD clknet_leaf_58_clk_load sky130_fd_sc_hd__clkbuf_16
Xclkbuf_leaf_59_clk_load clknet_4_15__leaf_clk_load VSS VSS
+ VDD VDD clknet_leaf_59_clk_load sky130_fd_sc_hd__clkbuf_16
Xclkbuf_leaf_60_clk_load clknet_4_15__leaf_clk_load VSS VSS
+ VDD VDD clknet_leaf_60_clk_load sky130_fd_sc_hd__clkbuf_16
Xclkbuf_leaf_61_clk_load clknet_4_15__leaf_clk_load VSS VSS
+ VDD VDD clknet_leaf_61_clk_load sky130_fd_sc_hd__clkbuf_16
Xclkbuf_leaf_62_clk_load clknet_4_15__leaf_clk_load VSS VSS
+ VDD VDD clknet_leaf_62_clk_load sky130_fd_sc_hd__clkbuf_16
Xclkbuf_leaf_63_clk_load clknet_4_13__leaf_clk_load VSS VSS
+ VDD VDD clknet_leaf_63_clk_load sky130_fd_sc_hd__clkbuf_16
Xclkbuf_leaf_64_clk_load clknet_4_13__leaf_clk_load VSS VSS
+ VDD VDD clknet_leaf_64_clk_load sky130_fd_sc_hd__clkbuf_16
Xclkbuf_leaf_65_clk_load clknet_4_13__leaf_clk_load VSS VSS
+ VDD VDD clknet_leaf_65_clk_load sky130_fd_sc_hd__clkbuf_16
Xclkbuf_leaf_66_clk_load clknet_4_13__leaf_clk_load VSS VSS
+ VDD VDD clknet_leaf_66_clk_load sky130_fd_sc_hd__clkbuf_16
Xclkbuf_leaf_67_clk_load clknet_4_13__leaf_clk_load VSS VSS
+ VDD VDD clknet_leaf_67_clk_load sky130_fd_sc_hd__clkbuf_16
Xclkbuf_leaf_68_clk_load clknet_4_13__leaf_clk_load VSS VSS
+ VDD VDD clknet_leaf_68_clk_load sky130_fd_sc_hd__clkbuf_16
Xclkbuf_leaf_69_clk_load clknet_4_13__leaf_clk_load VSS VSS
+ VDD VDD clknet_leaf_69_clk_load sky130_fd_sc_hd__clkbuf_16
Xclkbuf_leaf_70_clk_load clknet_4_13__leaf_clk_load VSS VSS
+ VDD VDD clknet_leaf_70_clk_load sky130_fd_sc_hd__clkbuf_16
Xclkbuf_leaf_71_clk_load clknet_4_12__leaf_clk_load VSS VSS
+ VDD VDD clknet_leaf_71_clk_load sky130_fd_sc_hd__clkbuf_16
Xclkbuf_leaf_72_clk_load clknet_4_6__leaf_clk_load VSS VSS
+ VDD VDD clknet_leaf_72_clk_load sky130_fd_sc_hd__clkbuf_16
Xclkbuf_leaf_73_clk_load clknet_4_6__leaf_clk_load VSS VSS
+ VDD VDD clknet_leaf_73_clk_load sky130_fd_sc_hd__clkbuf_16
Xclkbuf_leaf_74_clk_load clknet_4_6__leaf_clk_load VSS VSS
+ VDD VDD clknet_leaf_74_clk_load sky130_fd_sc_hd__clkbuf_16
Xclkbuf_leaf_75_clk_load clknet_4_6__leaf_clk_load VSS VSS
+ VDD VDD clknet_leaf_75_clk_load sky130_fd_sc_hd__clkbuf_16
Xclkbuf_leaf_76_clk_load clknet_4_7__leaf_clk_load VSS VSS
+ VDD VDD clknet_leaf_76_clk_load sky130_fd_sc_hd__clkbuf_16
Xclkbuf_leaf_77_clk_load clknet_4_7__leaf_clk_load VSS VSS
+ VDD VDD clknet_leaf_77_clk_load sky130_fd_sc_hd__clkbuf_16
Xclkbuf_leaf_78_clk_load clknet_4_7__leaf_clk_load VSS VSS
+ VDD VDD clknet_leaf_78_clk_load sky130_fd_sc_hd__clkbuf_16
Xclkbuf_leaf_79_clk_load clknet_4_7__leaf_clk_load VSS VSS
+ VDD VDD clknet_leaf_79_clk_load sky130_fd_sc_hd__clkbuf_16
Xclkbuf_leaf_80_clk_load clknet_4_7__leaf_clk_load VSS VSS
+ VDD VDD clknet_leaf_80_clk_load sky130_fd_sc_hd__clkbuf_16
Xclkbuf_leaf_81_clk_load clknet_4_7__leaf_clk_load VSS VSS
+ VDD VDD clknet_leaf_81_clk_load sky130_fd_sc_hd__clkbuf_16
Xclkbuf_leaf_82_clk_load clknet_4_7__leaf_clk_load VSS VSS
+ VDD VDD clknet_leaf_82_clk_load sky130_fd_sc_hd__clkbuf_16
Xclkbuf_leaf_83_clk_load clknet_4_7__leaf_clk_load VSS VSS
+ VDD VDD clknet_leaf_83_clk_load sky130_fd_sc_hd__clkbuf_16
Xclkbuf_leaf_84_clk_load clknet_4_7__leaf_clk_load VSS VSS
+ VDD VDD clknet_leaf_84_clk_load sky130_fd_sc_hd__clkbuf_16
Xclkbuf_leaf_85_clk_load clknet_4_5__leaf_clk_load VSS VSS
+ VDD VDD clknet_leaf_85_clk_load sky130_fd_sc_hd__clkbuf_16
Xclkbuf_leaf_86_clk_load clknet_4_5__leaf_clk_load VSS VSS
+ VDD VDD clknet_leaf_86_clk_load sky130_fd_sc_hd__clkbuf_16
Xclkbuf_leaf_87_clk_load clknet_4_5__leaf_clk_load VSS VSS
+ VDD VDD clknet_leaf_87_clk_load sky130_fd_sc_hd__clkbuf_16
Xclkbuf_leaf_88_clk_load clknet_4_5__leaf_clk_load VSS VSS
+ VDD VDD clknet_leaf_88_clk_load sky130_fd_sc_hd__clkbuf_16
Xclkbuf_leaf_89_clk_load clknet_4_5__leaf_clk_load VSS VSS
+ VDD VDD clknet_leaf_89_clk_load sky130_fd_sc_hd__clkbuf_16
Xclkbuf_leaf_90_clk_load clknet_4_5__leaf_clk_load VSS VSS
+ VDD VDD clknet_leaf_90_clk_load sky130_fd_sc_hd__clkbuf_16
Xclkbuf_leaf_91_clk_load clknet_4_5__leaf_clk_load VSS VSS
+ VDD VDD clknet_leaf_91_clk_load sky130_fd_sc_hd__clkbuf_16
Xclkbuf_leaf_92_clk_load clknet_4_4__leaf_clk_load VSS VSS
+ VDD VDD clknet_leaf_92_clk_load sky130_fd_sc_hd__clkbuf_16
Xclkbuf_leaf_93_clk_load clknet_4_4__leaf_clk_load VSS VSS
+ VDD VDD clknet_leaf_93_clk_load sky130_fd_sc_hd__clkbuf_16
Xclkbuf_leaf_94_clk_load clknet_4_4__leaf_clk_load VSS VSS
+ VDD VDD clknet_leaf_94_clk_load sky130_fd_sc_hd__clkbuf_16
Xclkbuf_leaf_95_clk_load clknet_4_4__leaf_clk_load VSS VSS
+ VDD VDD clknet_leaf_95_clk_load sky130_fd_sc_hd__clkbuf_16
Xclkbuf_leaf_96_clk_load clknet_4_4__leaf_clk_load VSS VSS
+ VDD VDD clknet_leaf_96_clk_load sky130_fd_sc_hd__clkbuf_16
Xclkbuf_leaf_97_clk_load clknet_4_4__leaf_clk_load VSS VSS
+ VDD VDD clknet_leaf_97_clk_load sky130_fd_sc_hd__clkbuf_16
Xclkbuf_leaf_98_clk_load clknet_4_4__leaf_clk_load VSS VSS
+ VDD VDD clknet_leaf_98_clk_load sky130_fd_sc_hd__clkbuf_16
Xclkbuf_leaf_99_clk_load clknet_4_4__leaf_clk_load VSS VSS
+ VDD VDD clknet_leaf_99_clk_load sky130_fd_sc_hd__clkbuf_16
Xclkbuf_leaf_100_clk_load clknet_4_4__leaf_clk_load VSS VSS
+ VDD VDD clknet_leaf_100_clk_load sky130_fd_sc_hd__clkbuf_16
Xclkbuf_leaf_101_clk_load clknet_4_6__leaf_clk_load VSS VSS
+ VDD VDD clknet_leaf_101_clk_load sky130_fd_sc_hd__clkbuf_16
Xclkbuf_leaf_102_clk_load clknet_4_6__leaf_clk_load VSS VSS
+ VDD VDD clknet_leaf_102_clk_load sky130_fd_sc_hd__clkbuf_16
Xclkbuf_leaf_103_clk_load clknet_4_6__leaf_clk_load VSS VSS
+ VDD VDD clknet_leaf_103_clk_load sky130_fd_sc_hd__clkbuf_16
Xclkbuf_leaf_104_clk_load clknet_4_6__leaf_clk_load VSS VSS
+ VDD VDD clknet_leaf_104_clk_load sky130_fd_sc_hd__clkbuf_16
Xclkbuf_leaf_105_clk_load clknet_4_3__leaf_clk_load VSS VSS
+ VDD VDD clknet_leaf_105_clk_load sky130_fd_sc_hd__clkbuf_16
Xclkbuf_leaf_106_clk_load clknet_4_3__leaf_clk_load VSS VSS
+ VDD VDD clknet_leaf_106_clk_load sky130_fd_sc_hd__clkbuf_16
Xclkbuf_leaf_107_clk_load clknet_4_3__leaf_clk_load VSS VSS
+ VDD VDD clknet_leaf_107_clk_load sky130_fd_sc_hd__clkbuf_16
Xclkbuf_leaf_108_clk_load clknet_4_3__leaf_clk_load VSS VSS
+ VDD VDD clknet_leaf_108_clk_load sky130_fd_sc_hd__clkbuf_16
Xclkbuf_leaf_109_clk_load clknet_4_3__leaf_clk_load VSS VSS
+ VDD VDD clknet_leaf_109_clk_load sky130_fd_sc_hd__clkbuf_16
Xclkbuf_leaf_110_clk_load clknet_4_1__leaf_clk_load VSS VSS
+ VDD VDD clknet_leaf_110_clk_load sky130_fd_sc_hd__clkbuf_16
Xclkbuf_leaf_111_clk_load clknet_4_1__leaf_clk_load VSS VSS
+ VDD VDD clknet_leaf_111_clk_load sky130_fd_sc_hd__clkbuf_16
Xclkbuf_leaf_112_clk_load clknet_4_1__leaf_clk_load VSS VSS
+ VDD VDD clknet_leaf_112_clk_load sky130_fd_sc_hd__clkbuf_16
Xclkbuf_leaf_113_clk_load clknet_4_1__leaf_clk_load VSS VSS
+ VDD VDD clknet_leaf_113_clk_load sky130_fd_sc_hd__clkbuf_16
Xclkbuf_leaf_114_clk_load clknet_4_1__leaf_clk_load VSS VSS
+ VDD VDD clknet_leaf_114_clk_load sky130_fd_sc_hd__clkbuf_16
Xclkbuf_leaf_115_clk_load clknet_4_1__leaf_clk_load VSS VSS
+ VDD VDD clknet_leaf_115_clk_load sky130_fd_sc_hd__clkbuf_16
Xclkbuf_leaf_116_clk_load clknet_4_1__leaf_clk_load VSS VSS
+ VDD VDD clknet_leaf_116_clk_load sky130_fd_sc_hd__clkbuf_16
Xclkbuf_leaf_117_clk_load clknet_4_1__leaf_clk_load VSS VSS
+ VDD VDD clknet_leaf_117_clk_load sky130_fd_sc_hd__clkbuf_16
Xclkbuf_leaf_118_clk_load clknet_4_0__leaf_clk_load VSS VSS
+ VDD VDD clknet_leaf_118_clk_load sky130_fd_sc_hd__clkbuf_16
Xclkbuf_leaf_119_clk_load clknet_4_0__leaf_clk_load VSS VSS
+ VDD VDD clknet_leaf_119_clk_load sky130_fd_sc_hd__clkbuf_16
Xclkbuf_leaf_120_clk_load clknet_4_0__leaf_clk_load VSS VSS
+ VDD VDD clknet_leaf_120_clk_load sky130_fd_sc_hd__clkbuf_16
Xclkbuf_leaf_121_clk_load clknet_4_0__leaf_clk_load VSS VSS
+ VDD VDD clknet_leaf_121_clk_load sky130_fd_sc_hd__clkbuf_16
Xclkbuf_leaf_122_clk_load clknet_4_0__leaf_clk_load VSS VSS
+ VDD VDD clknet_leaf_122_clk_load sky130_fd_sc_hd__clkbuf_16
Xclkbuf_0_clk_load clk_load VSS VSS VDD VDD clknet_0_clk_load
+ sky130_fd_sc_hd__clkbuf_16
Xclkbuf_2_0_0_clk_load clknet_0_clk_load VSS VSS VDD VDD clknet_2_0_0_clk_load
+ sky130_fd_sc_hd__clkbuf_16
Xclkbuf_2_1_0_clk_load clknet_0_clk_load VSS VSS VDD VDD clknet_2_1_0_clk_load
+ sky130_fd_sc_hd__clkbuf_16
Xclkbuf_2_2_0_clk_load clknet_0_clk_load VSS VSS VDD VDD clknet_2_2_0_clk_load
+ sky130_fd_sc_hd__clkbuf_16
Xclkbuf_2_3_0_clk_load clknet_0_clk_load VSS VSS VDD VDD clknet_2_3_0_clk_load
+ sky130_fd_sc_hd__clkbuf_16
Xclkbuf_4_0__f_clk_load clknet_2_0_0_clk_load VSS VSS VDD
+ VDD clknet_4_0__leaf_clk_load sky130_fd_sc_hd__clkbuf_16
Xclkbuf_4_1__f_clk_load clknet_2_0_0_clk_load VSS VSS VDD
+ VDD clknet_4_1__leaf_clk_load sky130_fd_sc_hd__clkbuf_16
Xclkbuf_4_2__f_clk_load clknet_2_0_0_clk_load VSS VSS VDD
+ VDD clknet_4_2__leaf_clk_load sky130_fd_sc_hd__clkbuf_16
Xclkbuf_4_3__f_clk_load clknet_2_0_0_clk_load VSS VSS VDD
+ VDD clknet_4_3__leaf_clk_load sky130_fd_sc_hd__clkbuf_16
Xclkbuf_4_4__f_clk_load clknet_2_1_0_clk_load VSS VSS VDD
+ VDD clknet_4_4__leaf_clk_load sky130_fd_sc_hd__clkbuf_16
Xclkbuf_4_5__f_clk_load clknet_2_1_0_clk_load VSS VSS VDD
+ VDD clknet_4_5__leaf_clk_load sky130_fd_sc_hd__clkbuf_16
Xclkbuf_4_6__f_clk_load clknet_2_1_0_clk_load VSS VSS VDD
+ VDD clknet_4_6__leaf_clk_load sky130_fd_sc_hd__clkbuf_16
Xclkbuf_4_7__f_clk_load clknet_2_1_0_clk_load VSS VSS VDD
+ VDD clknet_4_7__leaf_clk_load sky130_fd_sc_hd__clkbuf_16
Xclkbuf_4_8__f_clk_load clknet_2_2_0_clk_load VSS VSS VDD
+ VDD clknet_4_8__leaf_clk_load sky130_fd_sc_hd__clkbuf_16
Xclkbuf_4_9__f_clk_load clknet_2_2_0_clk_load VSS VSS VDD
+ VDD clknet_4_9__leaf_clk_load sky130_fd_sc_hd__clkbuf_16
Xclkbuf_4_10__f_clk_load clknet_2_2_0_clk_load VSS VSS VDD
+ VDD clknet_4_10__leaf_clk_load sky130_fd_sc_hd__clkbuf_16
Xclkbuf_4_11__f_clk_load clknet_2_2_0_clk_load VSS VSS VDD
+ VDD clknet_4_11__leaf_clk_load sky130_fd_sc_hd__clkbuf_16
Xclkbuf_4_12__f_clk_load clknet_2_3_0_clk_load VSS VSS VDD
+ VDD clknet_4_12__leaf_clk_load sky130_fd_sc_hd__clkbuf_16
Xclkbuf_4_13__f_clk_load clknet_2_3_0_clk_load VSS VSS VDD
+ VDD clknet_4_13__leaf_clk_load sky130_fd_sc_hd__clkbuf_16
Xclkbuf_4_14__f_clk_load clknet_2_3_0_clk_load VSS VSS VDD
+ VDD clknet_4_14__leaf_clk_load sky130_fd_sc_hd__clkbuf_16
Xclkbuf_4_15__f_clk_load clknet_2_3_0_clk_load VSS VSS VDD
+ VDD clknet_4_15__leaf_clk_load sky130_fd_sc_hd__clkbuf_16
Xclkload185 clknet_4_1__leaf_clk_load VSS VSS VDD VDD _unconnected_203
+ sky130_fd_sc_hd__clkbuf_16
Xclkload186 clknet_4_2__leaf_clk_load VSS VSS VDD VDD _unconnected_204
+ sky130_fd_sc_hd__clkbuf_16
Xclkload187 clknet_4_5__leaf_clk_load VSS VSS VDD VDD _unconnected_205
+ sky130_fd_sc_hd__inv_6
Xclkload188 clknet_4_6__leaf_clk_load VSS VSS VDD VDD _unconnected_206
+ sky130_fd_sc_hd__clkbuf_16
Xclkload189 clknet_4_8__leaf_clk_load VSS VSS VDD VDD _unconnected_207
+ sky130_fd_sc_hd__clkbuf_16
Xclkload190 clknet_4_10__leaf_clk_load VSS VSS VDD VDD _unconnected_208
+ sky130_fd_sc_hd__clkbuf_16
Xclkload191 clknet_4_11__leaf_clk_load VSS VSS VDD VDD _unconnected_209
+ sky130_fd_sc_hd__clkbuf_16
Xclkload192 clknet_4_12__leaf_clk_load VSS VSS VDD VDD _unconnected_210
+ sky130_fd_sc_hd__clkinv_8
Xclkload193 clknet_4_15__leaf_clk_load VSS VSS VDD VDD _unconnected_211
+ sky130_fd_sc_hd__inv_6
Xclkload194 clknet_leaf_0_clk_load VSS VSS VDD VDD _unconnected_212
+ sky130_fd_sc_hd__clkinv_1
Xclkload195 clknet_leaf_1_clk_load VSS VSS VDD VDD _unconnected_213
+ sky130_fd_sc_hd__clkinv_1
Xclkload196 clknet_leaf_2_clk_load VSS VSS VDD VDD _unconnected_214
+ sky130_fd_sc_hd__clkinv_2
Xclkload197 clknet_leaf_3_clk_load VSS VSS VDD VDD _unconnected_215
+ sky130_fd_sc_hd__clkinv_2
Xclkload198 clknet_leaf_118_clk_load VSS VSS VDD VDD _unconnected_216
+ sky130_fd_sc_hd__bufinv_16
Xclkload199 clknet_leaf_119_clk_load VSS VSS VDD VDD _unconnected_217
+ sky130_fd_sc_hd__clkinv_1
Xclkload200 clknet_leaf_120_clk_load VSS VSS VDD VDD _unconnected_218
+ sky130_fd_sc_hd__clkinv_1
Xclkload201 clknet_leaf_122_clk_load VSS VSS VDD VDD _unconnected_219
+ sky130_fd_sc_hd__clkinv_2
Xclkload202 clknet_leaf_110_clk_load VSS VSS VDD VDD _unconnected_220
+ sky130_fd_sc_hd__clkinv_2
Xclkload203 clknet_leaf_111_clk_load VSS VSS VDD VDD _unconnected_221
+ sky130_fd_sc_hd__bufinv_16
Xclkload204 clknet_leaf_112_clk_load VSS VSS VDD VDD _unconnected_222
+ sky130_fd_sc_hd__clkinv_1
Xclkload205 clknet_leaf_113_clk_load VSS VSS VDD VDD _unconnected_223
+ sky130_fd_sc_hd__clkbuf_1
Xclkload206 clknet_leaf_114_clk_load VSS VSS VDD VDD _unconnected_224
+ sky130_fd_sc_hd__clkbuf_1
Xclkload207 clknet_leaf_115_clk_load VSS VSS VDD VDD _unconnected_225
+ sky130_fd_sc_hd__clkinv_1
Xclkload208 clknet_leaf_117_clk_load VSS VSS VDD VDD _unconnected_226
+ sky130_fd_sc_hd__clkbuf_1
Xclkload209 clknet_leaf_4_clk_load VSS VSS VDD VDD _unconnected_227
+ sky130_fd_sc_hd__clkinv_1
Xclkload210 clknet_leaf_5_clk_load VSS VSS VDD VDD _unconnected_228
+ sky130_fd_sc_hd__clkinv_1
Xclkload211 clknet_leaf_6_clk_load VSS VSS VDD VDD _unconnected_229
+ sky130_fd_sc_hd__clkbuf_1
Xclkload212 clknet_leaf_7_clk_load VSS VSS VDD VDD _unconnected_230
+ sky130_fd_sc_hd__clkinv_2
Xclkload213 clknet_leaf_9_clk_load VSS VSS VDD VDD _unconnected_231
+ sky130_fd_sc_hd__clkinv_1
Xclkload214 clknet_leaf_12_clk_load VSS VSS VDD VDD _unconnected_232
+ sky130_fd_sc_hd__clkinv_1
Xclkload215 clknet_leaf_13_clk_load VSS VSS VDD VDD _unconnected_233
+ sky130_fd_sc_hd__bufinv_16
Xclkload216 clknet_leaf_14_clk_load VSS VSS VDD VDD _unconnected_234
+ sky130_fd_sc_hd__clkinv_1
Xclkload217 clknet_leaf_15_clk_load VSS VSS VDD VDD _unconnected_235
+ sky130_fd_sc_hd__bufinv_16
Xclkload218 clknet_leaf_16_clk_load VSS VSS VDD VDD _unconnected_236
+ sky130_fd_sc_hd__bufinv_16
Xclkload219 clknet_leaf_105_clk_load VSS VSS VDD VDD _unconnected_237
+ sky130_fd_sc_hd__clkbuf_1
Xclkload220 clknet_leaf_106_clk_load VSS VSS VDD VDD _unconnected_238
+ sky130_fd_sc_hd__clkbuf_1
Xclkload221 clknet_leaf_107_clk_load VSS VSS VDD VDD _unconnected_239
+ sky130_fd_sc_hd__clkinv_2
Xclkload222 clknet_leaf_109_clk_load VSS VSS VDD VDD _unconnected_240
+ sky130_fd_sc_hd__clkinv_1
Xclkload223 clknet_leaf_92_clk_load VSS VSS VDD VDD _unconnected_241
+ sky130_fd_sc_hd__clkinv_2
Xclkload224 clknet_leaf_93_clk_load VSS VSS VDD VDD _unconnected_242
+ sky130_fd_sc_hd__clkinv_1
Xclkload225 clknet_leaf_94_clk_load VSS VSS VDD VDD _unconnected_243
+ sky130_fd_sc_hd__clkbuf_1
Xclkload226 clknet_leaf_95_clk_load VSS VSS VDD VDD _unconnected_244
+ sky130_fd_sc_hd__clkbuf_1
Xclkload227 clknet_leaf_96_clk_load VSS VSS VDD VDD _unconnected_245
+ sky130_fd_sc_hd__clkinv_1
Xclkload228 clknet_leaf_98_clk_load VSS VSS VDD VDD _unconnected_246
+ sky130_fd_sc_hd__clkinv_1
Xclkload229 clknet_leaf_99_clk_load VSS VSS VDD VDD _unconnected_247
+ sky130_fd_sc_hd__clkinv_1
Xclkload230 clknet_leaf_100_clk_load VSS VSS VDD VDD _unconnected_248
+ sky130_fd_sc_hd__clkinv_2
Xclkload231 clknet_leaf_85_clk_load VSS VSS VDD VDD _unconnected_249
+ sky130_fd_sc_hd__clkinv_2
Xclkload232 clknet_leaf_86_clk_load VSS VSS VDD VDD _unconnected_250
+ sky130_fd_sc_hd__clkbuf_1
Xclkload233 clknet_leaf_87_clk_load VSS VSS VDD VDD _unconnected_251
+ sky130_fd_sc_hd__clkinv_2
Xclkload234 clknet_leaf_88_clk_load VSS VSS VDD VDD _unconnected_252
+ sky130_fd_sc_hd__clkbuf_1
Xclkload235 clknet_leaf_89_clk_load VSS VSS VDD VDD _unconnected_253
+ sky130_fd_sc_hd__clkinv_2
Xclkload236 clknet_leaf_90_clk_load VSS VSS VDD VDD _unconnected_254
+ sky130_fd_sc_hd__bufinv_16
Xclkload237 clknet_leaf_72_clk_load VSS VSS VDD VDD _unconnected_255
+ sky130_fd_sc_hd__clkbuf_1
Xclkload238 clknet_leaf_73_clk_load VSS VSS VDD VDD _unconnected_256
+ sky130_fd_sc_hd__clkinv_1
Xclkload239 clknet_leaf_74_clk_load VSS VSS VDD VDD _unconnected_257
+ sky130_fd_sc_hd__clkinv_1
Xclkload240 clknet_leaf_101_clk_load VSS VSS VDD VDD _unconnected_258
+ sky130_fd_sc_hd__clkbuf_1
Xclkload241 clknet_leaf_102_clk_load VSS VSS VDD VDD _unconnected_259
+ sky130_fd_sc_hd__clkbuf_1
Xclkload242 clknet_leaf_103_clk_load VSS VSS VDD VDD _unconnected_260
+ sky130_fd_sc_hd__clkbuf_1
Xclkload243 clknet_leaf_104_clk_load VSS VSS VDD VDD _unconnected_261
+ sky130_fd_sc_hd__bufinv_16
Xclkload244 clknet_leaf_76_clk_load VSS VSS VDD VDD _unconnected_262
+ sky130_fd_sc_hd__clkinv_2
Xclkload245 clknet_leaf_77_clk_load VSS VSS VDD VDD _unconnected_263
+ sky130_fd_sc_hd__clkinv_1
Xclkload246 clknet_leaf_78_clk_load VSS VSS VDD VDD _unconnected_264
+ sky130_fd_sc_hd__clkinvlp_4
Xclkload247 clknet_leaf_80_clk_load VSS VSS VDD VDD _unconnected_265
+ sky130_fd_sc_hd__clkinv_2
Xclkload248 clknet_leaf_81_clk_load VSS VSS VDD VDD _unconnected_266
+ sky130_fd_sc_hd__clkbuf_1
Xclkload249 clknet_leaf_82_clk_load VSS VSS VDD VDD _unconnected_267
+ sky130_fd_sc_hd__clkinv_2
Xclkload250 clknet_leaf_83_clk_load VSS VSS VDD VDD _unconnected_268
+ sky130_fd_sc_hd__clkinvlp_4
Xclkload251 clknet_leaf_84_clk_load VSS VSS VDD VDD _unconnected_269
+ sky130_fd_sc_hd__clkinv_2
Xclkload252 clknet_leaf_23_clk_load VSS VSS VDD VDD _unconnected_270
+ sky130_fd_sc_hd__clkinv_1
Xclkload253 clknet_leaf_25_clk_load VSS VSS VDD VDD _unconnected_271
+ sky130_fd_sc_hd__clkbuf_1
Xclkload254 clknet_leaf_26_clk_load VSS VSS VDD VDD _unconnected_272
+ sky130_fd_sc_hd__clkinv_1
Xclkload255 clknet_leaf_27_clk_load VSS VSS VDD VDD _unconnected_273
+ sky130_fd_sc_hd__clkbuf_1
Xclkload256 clknet_leaf_28_clk_load VSS VSS VDD VDD _unconnected_274
+ sky130_fd_sc_hd__clkinv_2
Xclkload257 clknet_leaf_10_clk_load VSS VSS VDD VDD _unconnected_275
+ sky130_fd_sc_hd__clkbuf_1
Xclkload258 clknet_leaf_17_clk_load VSS VSS VDD VDD _unconnected_276
+ sky130_fd_sc_hd__clkbuf_1
Xclkload259 clknet_leaf_18_clk_load VSS VSS VDD VDD _unconnected_277
+ sky130_fd_sc_hd__clkinv_2
Xclkload260 clknet_leaf_19_clk_load VSS VSS VDD VDD _unconnected_278
+ sky130_fd_sc_hd__clkinv_2
Xclkload261 clknet_leaf_20_clk_load VSS VSS VDD VDD _unconnected_279
+ sky130_fd_sc_hd__clkinv_2
Xclkload262 clknet_leaf_24_clk_load VSS VSS VDD VDD _unconnected_280
+ sky130_fd_sc_hd__clkbuf_1
Xclkload263 clknet_leaf_30_clk_load VSS VSS VDD VDD _unconnected_281
+ sky130_fd_sc_hd__clkinv_1
Xclkload264 clknet_leaf_31_clk_load VSS VSS VDD VDD _unconnected_282
+ sky130_fd_sc_hd__clkbuf_1
Xclkload265 clknet_leaf_32_clk_load VSS VSS VDD VDD _unconnected_283
+ sky130_fd_sc_hd__inv_6
Xclkload266 clknet_leaf_33_clk_load VSS VSS VDD VDD _unconnected_284
+ sky130_fd_sc_hd__clkinv_2
Xclkload267 clknet_leaf_34_clk_load VSS VSS VDD VDD _unconnected_285
+ sky130_fd_sc_hd__clkbuf_1
Xclkload268 clknet_leaf_37_clk_load VSS VSS VDD VDD _unconnected_286
+ sky130_fd_sc_hd__clkinv_1
Xclkload269 clknet_leaf_38_clk_load VSS VSS VDD VDD _unconnected_287
+ sky130_fd_sc_hd__clkinv_1
Xclkload270 clknet_leaf_44_clk_load VSS VSS VDD VDD _unconnected_288
+ sky130_fd_sc_hd__clkinv_2
Xclkload271 clknet_leaf_46_clk_load VSS VSS VDD VDD _unconnected_289
+ sky130_fd_sc_hd__clkinv_2
Xclkload272 clknet_leaf_47_clk_load VSS VSS VDD VDD _unconnected_290
+ sky130_fd_sc_hd__clkbuf_1
Xclkload273 clknet_leaf_49_clk_load VSS VSS VDD VDD _unconnected_291
+ sky130_fd_sc_hd__clkinv_2
Xclkload274 clknet_leaf_50_clk_load VSS VSS VDD VDD _unconnected_292
+ sky130_fd_sc_hd__clkbuf_1
Xclkload275 clknet_leaf_71_clk_load VSS VSS VDD VDD _unconnected_293
+ sky130_fd_sc_hd__bufinv_16
Xclkload276 clknet_leaf_51_clk_load VSS VSS VDD VDD _unconnected_294
+ sky130_fd_sc_hd__clkinv_1
Xclkload277 clknet_leaf_63_clk_load VSS VSS VDD VDD _unconnected_295
+ sky130_fd_sc_hd__inv_6
Xclkload278 clknet_leaf_64_clk_load VSS VSS VDD VDD _unconnected_296
+ sky130_fd_sc_hd__clkbuf_1
Xclkload279 clknet_leaf_65_clk_load VSS VSS VDD VDD _unconnected_297
+ sky130_fd_sc_hd__clkbuf_1
Xclkload280 clknet_leaf_66_clk_load VSS VSS VDD VDD _unconnected_298
+ sky130_fd_sc_hd__bufinv_16
Xclkload281 clknet_leaf_68_clk_load VSS VSS VDD VDD _unconnected_299
+ sky130_fd_sc_hd__clkbuf_1
Xclkload282 clknet_leaf_69_clk_load VSS VSS VDD VDD _unconnected_300
+ sky130_fd_sc_hd__clkbuf_1
Xclkload283 clknet_leaf_70_clk_load VSS VSS VDD VDD _unconnected_301
+ sky130_fd_sc_hd__clkbuf_1
Xclkload284 clknet_leaf_39_clk_load VSS VSS VDD VDD _unconnected_302
+ sky130_fd_sc_hd__clkinv_1
Xclkload285 clknet_leaf_40_clk_load VSS VSS VDD VDD _unconnected_303
+ sky130_fd_sc_hd__clkinv_1
Xclkload286 clknet_leaf_41_clk_load VSS VSS VDD VDD _unconnected_304
+ sky130_fd_sc_hd__clkbuf_1
Xclkload287 clknet_leaf_42_clk_load VSS VSS VDD VDD _unconnected_305
+ sky130_fd_sc_hd__clkinv_2
Xclkload288 clknet_leaf_43_clk_load VSS VSS VDD VDD _unconnected_306
+ sky130_fd_sc_hd__bufinv_16
Xclkload289 clknet_leaf_53_clk_load VSS VSS VDD VDD _unconnected_307
+ sky130_fd_sc_hd__clkbuf_1
Xclkload290 clknet_leaf_54_clk_load VSS VSS VDD VDD _unconnected_308
+ sky130_fd_sc_hd__clkinv_1
Xclkload291 clknet_leaf_55_clk_load VSS VSS VDD VDD _unconnected_309
+ sky130_fd_sc_hd__clkinv_2
Xclkload292 clknet_leaf_57_clk_load VSS VSS VDD VDD _unconnected_310
+ sky130_fd_sc_hd__clkinv_1
Xclkload293 clknet_leaf_58_clk_load VSS VSS VDD VDD _unconnected_311
+ sky130_fd_sc_hd__clkinv_1
Xclkload294 clknet_leaf_59_clk_load VSS VSS VDD VDD _unconnected_312
+ sky130_fd_sc_hd__clkinv_2
Xclkload295 clknet_leaf_60_clk_load VSS VSS VDD VDD _unconnected_313
+ sky130_fd_sc_hd__clkinv_1
Xclkload296 clknet_leaf_61_clk_load VSS VSS VDD VDD _unconnected_314
+ sky130_fd_sc_hd__clkinv_2
Xclkload297 clknet_leaf_62_clk_load VSS VSS VDD VDD _unconnected_315
+ sky130_fd_sc_hd__clkinv_2
Xdelaybuf_0_core_clk clknet_0_clk VSS VSS VDD VDD delaynet_0_core_clk
+ sky130_fd_sc_hd__clkbuf_16
Xdelaybuf_1_core_clk clk VSS VSS VDD VDD delaynet_1_core_clk
+ sky130_fd_sc_hd__clkbuf_16
Xdelaybuf_2_core_clk delaynet_1_core_clk VSS VSS VDD VDD delaynet_2_core_clk
+ sky130_fd_sc_hd__clkbuf_1
Xdelaybuf_3_core_clk delaynet_2_core_clk VSS VSS VDD VDD delaynet_3_core_clk
+ sky130_fd_sc_hd__clkbuf_1
Xdelaybuf_4_core_clk delaynet_3_core_clk VSS VSS VDD VDD delaynet_4_core_clk
+ sky130_fd_sc_hd__clkdlybuf4s50_2
Xhold483 reset VSS VSS VDD VDD net482 sky130_fd_sc_hd__dlygate4sd3_1
Xhold484 net23 VSS VSS VDD VDD net483 sky130_fd_sc_hd__dlygate4sd3_1
Xhold485 _01571_ VSS VSS VDD VDD net484 sky130_fd_sc_hd__dlygate4sd3_1
Xhold486 load_valid VSS VSS VDD VDD net485 sky130_fd_sc_hd__dlygate4sd3_1
Xhold487 start VSS VSS VDD VDD net486 sky130_fd_sc_hd__dlygate4sd3_1
Xhold488 load_data[0] VSS VSS VDD VDD net487 sky130_fd_sc_hd__dlygate4sd3_1
Xhold489 load_data[3] VSS VSS VDD VDD net488 sky130_fd_sc_hd__dlygate4sd3_1
Xhold490 load_data[2] VSS VSS VDD VDD net489 sky130_fd_sc_hd__dlygate4sd3_1
Xhold491 load_data[1] VSS VSS VDD VDD net490 sky130_fd_sc_hd__dlygate4sd3_1
XANTENNA_1 _04111_ VSS VSS VDD VDD sky130_fd_sc_hd__diode_2
XANTENNA_2 _04131_ VSS VSS VDD VDD sky130_fd_sc_hd__diode_2
XANTENNA_3 net331 VSS VSS VDD VDD sky130_fd_sc_hd__diode_2
XANTENNA_4 net362 VSS VSS VDD VDD sky130_fd_sc_hd__diode_2
XANTENNA_5 _09329_ VSS VSS VDD VDD sky130_fd_sc_hd__diode_2
XANTENNA_6 _09363_ VSS VSS VDD VDD sky130_fd_sc_hd__diode_2
XANTENNA_7 icg_load.en VSS VSS VDD VDD sky130_fd_sc_hd__diode_2
.ENDS ecg_snn_core
